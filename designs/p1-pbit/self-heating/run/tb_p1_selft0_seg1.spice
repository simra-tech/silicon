* Paired Segment 1 Arm selft0 (Seed 1001)
.lib run/cornerHBT_isothermal.lib hbt_typ
.lib $PDK_ROOT/ihp-sg13g2/libs.tech/ngspice/models/cornerMOSlv.lib mos_tt

.subckt p1_noise_gen RAW_NOISE_P RAW_NOISE_N VCC VSS
XQ1 RAW_NOISE_N b1_q1 e VSS npn13G2 Nx=1
XQ2 RAW_NOISE_P b2_q2 e VSS npn13G2 Nx=1
RC1 VCC RAW_NOISE_N 1.0k m=1
RC2 VCC RAW_NOISE_P 1.0k m=1
R_TAIL e VSS 316

VBM b_cm VSS DC 0.872

* 1,000-Tone Physical Noise Source (10 MHz - 2.5 GHz)
V_NOISE_P b2_src b_cm DC 0 PWL ( 0.0000n 0.001153 0.0100n 0.001041 0.0200n 0.000918 0.0300n 0.000787 0.0400n 0.000651 0.0500n 0.000511 0.0600n 0.000370 0.0700n 0.000230 0.0800n 0.000094 0.0900n -0.000036 0.1000n -0.000157 0.1100n -0.000269 0.1200n -0.000368 0.1300n -0.000453 0.1400n -0.000523
+ 0.1500n -0.000577 0.1600n -0.000614 0.1700n -0.000634 0.1800n -0.000636 0.1900n -0.000622 0.2000n -0.000591 0.2100n -0.000546 0.2200n -0.000487 0.2300n -0.000415 0.2400n -0.000334 0.2500n -0.000245 0.2600n -0.000150 0.2700n -0.000051 0.2800n 0.000048 0.2900n 0.000145
+ 0.3000n 0.000239 0.3100n 0.000326 0.3200n 0.000404 0.3300n 0.000472 0.3400n 0.000529 0.3500n 0.000572 0.3600n 0.000601 0.3700n 0.000615 0.3800n 0.000614 0.3900n 0.000598 0.4000n 0.000568 0.4100n 0.000524 0.4200n 0.000469 0.4300n 0.000403 0.4400n 0.000329
+ 0.4500n 0.000248 0.4600n 0.000163 0.4700n 0.000077 0.4800n -0.000009 0.4900n -0.000091 0.5000n -0.000167 0.5100n -0.000234 0.5200n -0.000291 0.5300n -0.000336 0.5400n -0.000366 0.5500n -0.000381 0.5600n -0.000380 0.5700n -0.000362 0.5800n -0.000327 0.5900n -0.000275
+ 0.6000n -0.000208 0.6100n -0.000127 0.6200n -0.000033 0.6300n 0.000072 0.6400n 0.000184 0.6500n 0.000302 0.6600n 0.000423 0.6700n 0.000543 0.6800n 0.000659 0.6900n 0.000767 0.7000n 0.000866 0.7100n 0.000951 0.7200n 0.001020 0.7300n 0.001071 0.7400n 0.001100
+ 0.7500n 0.001108 0.7600n 0.001091 0.7700n 0.001049 0.7800n 0.000983 0.7900n 0.000892 0.8000n 0.000777 0.8100n 0.000640 0.8200n 0.000482 0.8300n 0.000307 0.8400n 0.000116 0.8500n -0.000086 0.8600n -0.000296 0.8700n -0.000510 0.8800n -0.000724 0.8900n -0.000934
+ 0.9000n -0.001135 0.9100n -0.001324 0.9200n -0.001495 0.9300n -0.001646 0.9400n -0.001773 0.9500n -0.001873 0.9600n -0.001943 0.9700n -0.001982 0.9800n -0.001988 0.9900n -0.001961 1.0000n -0.001901 1.0100n -0.001807 1.0200n -0.001683 1.0300n -0.001528 1.0400n -0.001347
+ 1.0500n -0.001142 1.0600n -0.000916 1.0700n -0.000675 1.0800n -0.000422 1.0900n -0.000162 1.1000n 0.000100 1.1100n 0.000359 1.1200n 0.000611 1.1300n 0.000850 1.1400n 0.001072 1.1500n 0.001274 1.1600n 0.001450 1.1700n 0.001598 1.1800n 0.001716 1.1900n 0.001801
+ 1.2000n 0.001852 1.2100n 0.001867 1.2200n 0.001849 1.2300n 0.001796 1.2400n 0.001711 1.2500n 0.001595 1.2600n 0.001452 1.2700n 0.001284 1.2800n 0.001096 1.2900n 0.000892 1.3000n 0.000676 1.3100n 0.000453 1.3200n 0.000228 1.3300n 0.000006 1.3400n -0.000208
+ 1.3500n -0.000411 1.3600n -0.000596 1.3700n -0.000762 1.3800n -0.000903 1.3900n -0.001018 1.4000n -0.001104 1.4100n -0.001158 1.4200n -0.001181 1.4300n -0.001172 1.4400n -0.001131 1.4500n -0.001059 1.4600n -0.000958 1.4700n -0.000830 1.4800n -0.000679 1.4900n -0.000508
+ 1.5000n -0.000319 1.5100n -0.000119 1.5200n 0.000089 1.5300n 0.000301 1.5400n 0.000512 1.5500n 0.000717 1.5600n 0.000912 1.5700n 0.001093 1.5800n 0.001256 1.5900n 0.001397 1.6000n 0.001514 1.6100n 0.001605 1.6200n 0.001668 1.6300n 0.001700 1.6400n 0.001703
+ 1.6500n 0.001676 1.6600n 0.001620 1.6700n 0.001536 1.6800n 0.001427 1.6900n 0.001294 1.7000n 0.001140 1.7100n 0.000970 1.7200n 0.000786 1.7300n 0.000593 1.7400n 0.000394 1.7500n 0.000193 1.7600n -0.000004 1.7700n -0.000196 1.7800n -0.000376 1.7900n -0.000543
+ 1.8000n -0.000693 1.8100n -0.000824 1.8200n -0.000932 1.8300n -0.001017 1.8400n -0.001076 1.8500n -0.001109 1.8600n -0.001117 1.8700n -0.001098 1.8800n -0.001055 1.8900n -0.000988 1.9000n -0.000898 1.9100n -0.000789 1.9200n -0.000662 1.9300n -0.000520 1.9400n -0.000367
+ 1.9500n -0.000203 1.9600n -0.000034 1.9700n 0.000138 1.9800n 0.000311 1.9900n 0.000482 2.0000n 0.000648 2.0100n 0.000806 2.0200n 0.000956 2.0300n 0.001096 2.0400n 0.001223 2.0500n 0.001339 2.0600n 0.001441 2.0700n 0.001530 2.0800n 0.001607 2.0900n 0.001672
+ 2.1000n 0.001725 2.1100n 0.001769 2.1200n 0.001804 2.1300n 0.001833 2.1400n 0.001856 2.1500n 0.001876 2.1600n 0.001894 2.1700n 0.001912 2.1800n 0.001931 2.1900n 0.001953 2.2000n 0.001979 2.2100n 0.002011 2.2200n 0.002047 2.2300n 0.002090 2.2400n 0.002139
+ 2.2500n 0.002193 2.2600n 0.002253 2.2700n 0.002317 2.2800n 0.002384 2.2900n 0.002453 2.3000n 0.002523 2.3100n 0.002591 2.3200n 0.002656 2.3300n 0.002716 2.3400n 0.002769 2.3500n 0.002814 2.3600n 0.002847 2.3700n 0.002869 2.3800n 0.002878 2.3900n 0.002872
+ 2.4000n 0.002851 2.4100n 0.002813 2.4200n 0.002760 2.4300n 0.002691 2.4400n 0.002606 2.4500n 0.002506 2.4600n 0.002392 2.4700n 0.002266 2.4800n 0.002129 2.4900n 0.001983 2.5000n 0.001831 2.5100n 0.001674 2.5200n 0.001514 2.5300n 0.001355 2.5400n 0.001198
+ 2.5500n 0.001045 2.5600n 0.000900 2.5700n 0.000762 2.5800n 0.000636 2.5900n 0.000521 2.6000n 0.000418 2.6100n 0.000330 2.6200n 0.000256 2.6300n 0.000196 2.6400n 0.000150 2.6500n 0.000118 2.6600n 0.000098 2.6700n 0.000090 2.6800n 0.000092 2.6900n 0.000101
+ 2.7000n 0.000117 2.7100n 0.000137 2.7200n 0.000160 2.7300n 0.000182 2.7400n 0.000201 2.7500n 0.000216 2.7600n 0.000225 2.7700n 0.000226 2.7800n 0.000217 2.7900n 0.000196 2.8000n 0.000164 2.8100n 0.000119 2.8200n 0.000061 2.8300n -0.000010 2.8400n -0.000094
+ 2.8500n -0.000190 2.8600n -0.000297 2.8700n -0.000413 2.8800n -0.000538 2.8900n -0.000669 2.9000n -0.000804 2.9100n -0.000941 2.9200n -0.001078 2.9300n -0.001213 2.9400n -0.001343 2.9500n -0.001466 2.9600n -0.001580 2.9700n -0.001684 2.9800n -0.001776 2.9900n -0.001853
+ 3.0000n -0.001916 3.0100n -0.001964 3.0200n -0.001995 3.0300n -0.002010 3.0400n -0.002010 3.0500n -0.001994 3.0600n -0.001963 3.0700n -0.001919 3.0800n -0.001863 3.0900n -0.001796 3.1000n -0.001721 3.1100n -0.001639 3.1200n -0.001552 3.1300n -0.001462 3.1400n -0.001371
+ 3.1500n -0.001281 3.1600n -0.001194 3.1700n -0.001111 3.1800n -0.001033 3.1900n -0.000963 3.2000n -0.000899 3.2100n -0.000844 3.2200n -0.000798 3.2300n -0.000759 3.2400n -0.000729 3.2500n -0.000706 3.2600n -0.000690 3.2700n -0.000679 3.2800n -0.000673 3.2900n -0.000669
+ 3.3000n -0.000666 3.3100n -0.000663 3.3200n -0.000657 3.3300n -0.000648 3.3400n -0.000634 3.3500n -0.000613 3.3600n -0.000583 3.3700n -0.000545 3.3800n -0.000497 3.3900n -0.000439 3.4000n -0.000370 3.4100n -0.000291 3.4200n -0.000202 3.4300n -0.000104 3.4400n 0.000003
+ 3.4500n 0.000116 3.4600n 0.000235 3.4700n 0.000357 3.4800n 0.000481 3.4900n 0.000604 3.5000n 0.000724 3.5100n 0.000840 3.5200n 0.000947 3.5300n 0.001046 3.5400n 0.001133 3.5500n 0.001207 3.5600n 0.001265 3.5700n 0.001308 3.5800n 0.001333 3.5900n 0.001340
+ 3.6000n 0.001328 3.6100n 0.001298 3.6200n 0.001250 3.6300n 0.001184 3.6400n 0.001102 3.6500n 0.001005 3.6600n 0.000894 3.6700n 0.000771 3.6800n 0.000640 3.6900n 0.000501 3.7000n 0.000357 3.7100n 0.000212 3.7200n 0.000066 3.7300n -0.000076 3.7400n -0.000214
+ 3.7500n -0.000344 3.7600n -0.000465 3.7700n -0.000575 3.7800n -0.000673 3.7900n -0.000757 3.8000n -0.000827 3.8100n -0.000883 3.8200n -0.000923 3.8300n -0.000949 3.8400n -0.000962 3.8500n -0.000961 3.8600n -0.000949 3.8700n -0.000926 3.8800n -0.000896 3.8900n -0.000858
+ 3.9000n -0.000816 3.9100n -0.000772 3.9200n -0.000727 3.9300n -0.000683 3.9400n -0.000643 3.9500n -0.000608 3.9600n -0.000580 3.9700n -0.000560 3.9800n -0.000549 3.9900n -0.000548 4.0000n -0.000557 4.0100n -0.000576 4.0200n -0.000605 4.0300n -0.000644 4.0400n -0.000691
+ 4.0500n -0.000745 4.0600n -0.000805 4.0700n -0.000869 4.0800n -0.000935 4.0900n -0.001002 4.1000n -0.001067 4.1100n -0.001127 4.1200n -0.001182 4.1300n -0.001229 4.1400n -0.001265 4.1500n -0.001291 4.1600n -0.001303 4.1700n -0.001301 4.1800n -0.001284 4.1900n -0.001251
+ 4.2000n -0.001203 4.2100n -0.001140 4.2200n -0.001062 4.2300n -0.000969 4.2400n -0.000864 4.2500n -0.000748 4.2600n -0.000622 4.2700n -0.000489 4.2800n -0.000351 4.2900n -0.000210 4.3000n -0.000069 4.3100n 0.000070 4.3200n 0.000204 4.3300n 0.000332 4.3400n 0.000451
+ 4.3500n 0.000559 4.3600n 0.000654 4.3700n 0.000735 4.3800n 0.000802 4.3900n 0.000852 4.4000n 0.000886 4.4100n 0.000904 4.4200n 0.000906 4.4300n 0.000893 4.4400n 0.000866 4.4500n 0.000826 4.4600n 0.000775 4.4700n 0.000715 4.4800n 0.000649 4.4900n 0.000577
+ 4.5000n 0.000503 4.5100n 0.000430 4.5200n 0.000358 4.5300n 0.000291 4.5400n 0.000230 4.5500n 0.000177 4.5600n 0.000135 4.5700n 0.000104 4.5800n 0.000085 4.5900n 0.000078 4.6000n 0.000085 4.6100n 0.000105 4.6200n 0.000138 4.6300n 0.000182 4.6400n 0.000237
+ 4.6500n 0.000301 4.6600n 0.000373 4.6700n 0.000450 4.6800n 0.000531 4.6900n 0.000613 4.7000n 0.000694 4.7100n 0.000772 4.7200n 0.000845 4.7300n 0.000909 4.7400n 0.000965 4.7500n 0.001009 4.7600n 0.001041 4.7700n 0.001059 4.7800n 0.001062 4.7900n 0.001051
+ 4.8000n 0.001025 4.8100n 0.000984 4.8200n 0.000930 4.8300n 0.000864 4.8400n 0.000786 4.8500n 0.000699 4.8600n 0.000605 4.8700n 0.000506 4.8800n 0.000404 4.8900n 0.000302 4.9000n 0.000202 4.9100n 0.000108 4.9200n 0.000021 4.9300n -0.000056 4.9400n -0.000121
+ 4.9500n -0.000172 4.9600n -0.000208 4.9700n -0.000227 4.9800n -0.000229 4.9900n -0.000212 5.0000n -0.000177 5.0100n -0.000125 5.0200n -0.000056 5.0300n 0.000029 5.0400n 0.000128 5.0500n 0.000239 5.0600n 0.000361 5.0700n 0.000490 5.0800n 0.000625 5.0900n 0.000762
+ 5.1000n 0.000899 5.1100n 0.001033 5.1200n 0.001161 5.1300n 0.001281 5.1400n 0.001390 5.1500n 0.001486 5.1600n 0.001569 5.1700n 0.001635 5.1800n 0.001684 5.1900n 0.001717 5.2000n 0.001731 5.2100n 0.001728 5.2200n 0.001709 5.2300n 0.001674 5.2400n 0.001625
+ 5.2500n 0.001564 5.2600n 0.001493 5.2700n 0.001414 5.2800n 0.001331 5.2900n 0.001245 5.3000n 0.001160 5.3100n 0.001079 5.3200n 0.001003 5.3300n 0.000937 5.3400n 0.000882 5.3500n 0.000840 5.3600n 0.000814 5.3700n 0.000804 5.3800n 0.000812 5.3900n 0.000838
+ 5.4000n 0.000883 5.4100n 0.000947 5.4200n 0.001028 5.4300n 0.001125 5.4400n 0.001237 5.4500n 0.001362 5.4600n 0.001497 5.4700n 0.001640 5.4800n 0.001788 5.4900n 0.001938 5.5000n 0.002087 5.5100n 0.002231 5.5200n 0.002368 5.5300n 0.002494 5.5400n 0.002607
+ 5.5500n 0.002704 5.5600n 0.002783 5.5700n 0.002843 5.5800n 0.002880 5.5900n 0.002896 5.6000n 0.002888 5.6100n 0.002857 5.6200n 0.002804 5.6300n 0.002729 5.6400n 0.002633 5.6500n 0.002518 5.6600n 0.002387 5.6700n 0.002241 5.6800n 0.002084 5.6900n 0.001918
+ 5.7000n 0.001746 5.7100n 0.001572 5.7200n 0.001399 5.7300n 0.001229 5.7400n 0.001065 5.7500n 0.000911 5.7600n 0.000768 5.7700n 0.000639 5.7800n 0.000525 5.7900n 0.000428 5.8000n 0.000349 5.8100n 0.000287 5.8200n 0.000244 5.8300n 0.000218 5.8400n 0.000208
+ 5.8500n 0.000213 5.8600n 0.000232 5.8700n 0.000262 5.8800n 0.000300 5.8900n 0.000346 5.9000n 0.000394 5.9100n 0.000444 5.9200n 0.000492 5.9300n 0.000535 5.9400n 0.000570 5.9500n 0.000596 5.9600n 0.000610 5.9700n 0.000611 5.9800n 0.000596 5.9900n 0.000564
+ 6.0000n 0.000516 6.0100n 0.000450 6.0200n 0.000368 6.0300n 0.000269 6.0400n 0.000156 6.0500n 0.000029 6.0600n -0.000110 6.0700n -0.000257 6.0800n -0.000411 6.0900n -0.000569 6.1000n -0.000726 6.1100n -0.000881 6.1200n -0.001030 6.1300n -0.001170 6.1400n -0.001298
+ 6.1500n -0.001410 6.1600n -0.001504 6.1700n -0.001578 6.1800n -0.001630 6.1900n -0.001657 6.2000n -0.001660 6.2100n -0.001636 6.2200n -0.001586 6.2300n -0.001510 6.2400n -0.001409 6.2500n -0.001283 6.2600n -0.001135 6.2700n -0.000966 6.2800n -0.000779 6.2900n -0.000576
+ 6.3000n -0.000361 6.3100n -0.000137 6.3200n 0.000094 6.3300n 0.000328 6.3400n 0.000561 6.3500n 0.000790 6.3600n 0.001012 6.3700n 0.001224 6.3800n 0.001424 6.3900n 0.001608 6.4000n 0.001775 6.4100n 0.001923 6.4200n 0.002050 6.4300n 0.002156 6.4400n 0.002241
+ 6.4500n 0.002304 6.4600n 0.002345 6.4700n 0.002365 6.4800n 0.002365 6.4900n 0.002347 6.5000n 0.002312 6.5100n 0.002261 6.5200n 0.002198 6.5300n 0.002124 6.5400n 0.002041 6.5500n 0.001952 6.5600n 0.001858 6.5700n 0.001762 6.5800n 0.001667 6.5900n 0.001572
+ 6.6000n 0.001481 6.6100n 0.001395 6.6200n 0.001314 6.6300n 0.001239 6.6400n 0.001172 6.6500n 0.001112 6.6600n 0.001059 6.6700n 0.001014 6.6800n 0.000975 6.6900n 0.000942 6.7000n 0.000914 6.7100n 0.000890 6.7200n 0.000869 6.7300n 0.000851 6.7400n 0.000833
+ 6.7500n 0.000815 6.7600n 0.000796 6.7700n 0.000775 6.7800n 0.000751 6.7900n 0.000724 6.8000n 0.000693 6.8100n 0.000659 6.8200n 0.000620 6.8300n 0.000579 6.8400n 0.000534 6.8500n 0.000487 6.8600n 0.000439 6.8700n 0.000391 6.8800n 0.000344 6.8900n 0.000299
+ 6.9000n 0.000259 6.9100n 0.000223 6.9200n 0.000195 6.9300n 0.000175 6.9400n 0.000164 6.9500n 0.000165 6.9600n 0.000177 6.9700n 0.000201 6.9800n 0.000239 6.9900n 0.000291 7.0000n 0.000356 7.0100n 0.000434 7.0200n 0.000526 7.0300n 0.000629 7.0400n 0.000744
+ 7.0500n 0.000867 7.0600n 0.000999 7.0700n 0.001137 7.0800n 0.001278 7.0900n 0.001421 7.1000n 0.001564 7.1100n 0.001704 7.1200n 0.001838 7.1300n 0.001965 7.1400n 0.002081 7.1500n 0.002185 7.1600n 0.002275 7.1700n 0.002348 7.1800n 0.002404 7.1900n 0.002441
+ 7.2000n 0.002458 7.2100n 0.002454 7.2200n 0.002429 7.2300n 0.002383 7.2400n 0.002316 7.2500n 0.002230 7.2600n 0.002124 7.2700n 0.002000 7.2800n 0.001861 7.2900n 0.001707 7.3000n 0.001541 7.3100n 0.001365 7.3200n 0.001181 7.3300n 0.000992 7.3400n 0.000799
+ 7.3500n 0.000607 7.3600n 0.000417 7.3700n 0.000231 7.3800n 0.000052 7.3900n -0.000119 7.4000n -0.000279 7.4100n -0.000427 7.4200n -0.000561 7.4300n -0.000681 7.4400n -0.000785 7.4500n -0.000873 7.4600n -0.000944 7.4700n -0.000999 7.4800n -0.001037 7.4900n -0.001059
+ 7.5000n -0.001066 7.5100n -0.001058 7.5200n -0.001037 7.5300n -0.001003 7.5400n -0.000957 7.5500n -0.000902 7.5600n -0.000839 7.5700n -0.000768 7.5800n -0.000692 7.5900n -0.000611 7.6000n -0.000527 7.6100n -0.000442 7.6200n -0.000356 7.6300n -0.000270 7.6400n -0.000186
+ 7.6500n -0.000105 7.6600n -0.000026 7.6700n 0.000049 7.6800n 0.000120 7.6900n 0.000187 7.7000n 0.000248 7.7100n 0.000305 7.7200n 0.000357 7.7300n 0.000403 7.7400n 0.000444 7.7500n 0.000480 7.7600n 0.000511 7.7700n 0.000537 7.7800n 0.000558 7.7900n 0.000574
+ 7.8000n 0.000585 7.8100n 0.000592 7.8200n 0.000594 7.8300n 0.000591 7.8400n 0.000583 7.8500n 0.000571 7.8600n 0.000554 7.8700n 0.000532 7.8800n 0.000505 7.8900n 0.000474 7.9000n 0.000438 7.9100n 0.000397 7.9200n 0.000351 7.9300n 0.000301 7.9400n 0.000247
+ 7.9500n 0.000188 7.9600n 0.000127 7.9700n 0.000062 7.9800n -0.000006 7.9900n -0.000075 8.0000n -0.000146 8.0100n -0.000217 8.0200n -0.000289 8.0300n -0.000359 8.0400n -0.000427 8.0500n -0.000493 8.0600n -0.000555 8.0700n -0.000613 8.0800n -0.000665 8.0900n -0.000711
+ 8.1000n -0.000751 8.1100n -0.000783 8.1200n -0.000807 8.1300n -0.000823 8.1400n -0.000831 8.1500n -0.000829 8.1600n -0.000819 8.1700n -0.000800 8.1800n -0.000772 8.1900n -0.000736 8.2000n -0.000692 8.2100n -0.000642 8.2200n -0.000584 8.2300n -0.000522 8.2400n -0.000454
+ 8.2500n -0.000383 8.2600n -0.000309 8.2700n -0.000233 8.2800n -0.000156 8.2900n -0.000080 8.3000n -0.000004 8.3100n 0.000069 8.3200n 0.000139 8.3300n 0.000205 8.3400n 0.000266 8.3500n 0.000323 8.3600n 0.000373 8.3700n 0.000418 8.3800n 0.000456 8.3900n 0.000487
+ 8.4000n 0.000512 8.4100n 0.000530 8.4200n 0.000541 8.4300n 0.000546 8.4400n 0.000545 8.4500n 0.000538 8.4600n 0.000526 8.4700n 0.000509 8.4800n 0.000487 8.4900n 0.000460 8.5000n 0.000431 8.5100n 0.000398 8.5200n 0.000362 8.5300n 0.000323 8.5400n 0.000282
+ 8.5500n 0.000240 8.5600n 0.000196 8.5700n 0.000151 8.5800n 0.000104 8.5900n 0.000057 8.6000n 0.000009 8.6100n -0.000040 8.6200n -0.000089 8.6300n -0.000138 8.6400n -0.000188 8.6500n -0.000237 8.6600n -0.000287 8.6700n -0.000336 8.6800n -0.000384 8.6900n -0.000432
+ 8.7000n -0.000478 8.7100n -0.000522 8.7200n -0.000565 8.7300n -0.000605 8.7400n -0.000641 8.7500n -0.000675 8.7600n -0.000704 8.7700n -0.000728 8.7800n -0.000748 8.7900n -0.000762 8.8000n -0.000771 8.8100n -0.000773 8.8200n -0.000769 8.8300n -0.000759 8.8400n -0.000743
+ 8.8500n -0.000721 8.8600n -0.000692 8.8700n -0.000659 8.8800n -0.000621 8.8900n -0.000579 8.9000n -0.000534 8.9100n -0.000487 8.9200n -0.000439 8.9300n -0.000392 8.9400n -0.000346 8.9500n -0.000304 8.9600n -0.000267 8.9700n -0.000236 8.9800n -0.000213 8.9900n -0.000199
+ 9.0000n -0.000195 9.0100n -0.000203 9.0200n -0.000223 9.0300n -0.000256 9.0400n -0.000302 9.0500n -0.000363 9.0600n -0.000438 9.0700n -0.000527 9.0800n -0.000628 9.0900n -0.000742 9.1000n -0.000867 9.1100n -0.001001 9.1200n -0.001144 9.1300n -0.001292 9.1400n -0.001444
+ 9.1500n -0.001597 9.1600n -0.001748 9.1700n -0.001896 9.1800n -0.002037 9.1900n -0.002168 9.2000n -0.002287 9.2100n -0.002390 9.2200n -0.002477 9.2300n -0.002544 9.2400n -0.002589 9.2500n -0.002611 9.2600n -0.002608 9.2700n -0.002579 9.2800n -0.002524 9.2900n -0.002442
+ 9.3000n -0.002333 9.3100n -0.002199 9.3200n -0.002040 9.3300n -0.001858 9.3400n -0.001655 9.3500n -0.001432 9.3600n -0.001193 9.3700n -0.000941 9.3800n -0.000678 9.3900n -0.000408 9.4000n -0.000135 9.4100n 0.000139 9.4200n 0.000409 9.4300n 0.000672 9.4400n 0.000925
+ 9.4500n 0.001165 9.4600n 0.001389 9.4700n 0.001593 9.4800n 0.001777 9.4900n 0.001937 9.5000n 0.002072 9.5100n 0.002182 9.5200n 0.002266 9.5300n 0.002322 9.5400n 0.002353 9.5500n 0.002357 9.5600n 0.002336 9.5700n 0.002292 9.5800n 0.002227 9.5900n 0.002141
+ 9.6000n 0.002038 9.6100n 0.001920 9.6200n 0.001789 9.6300n 0.001648 9.6400n 0.001500 9.6500n 0.001346 9.6600n 0.001191 9.6700n 0.001035 9.6800n 0.000881 9.6900n 0.000731 9.7000n 0.000586 9.7100n 0.000448 9.7200n 0.000318 9.7300n 0.000195 9.7400n 0.000082
+ 9.7500n -0.000023 9.7600n -0.000119 9.7700n -0.000208 9.7800n -0.000289 9.7900n -0.000365 9.8000n -0.000435 9.8100n -0.000502 9.8200n -0.000567 9.8300n -0.000631 9.8400n -0.000695 9.8500n -0.000760 9.8600n -0.000829 9.8700n -0.000901 9.8800n -0.000978 9.8900n -0.001059
+ 9.9000n -0.001146 9.9100n -0.001238 9.9200n -0.001335 9.9300n -0.001436 9.9400n -0.001541 9.9500n -0.001647 9.9600n -0.001755 9.9700n -0.001861 9.9800n -0.001965 9.9900n -0.002065 10.0000n -0.002158 10.0100n -0.002243 10.0200n -0.002317 10.0300n -0.002379 10.0400n -0.002426
+ 10.0500n -0.002458 10.0600n -0.002472 10.0700n -0.002468 10.0800n -0.002445 10.0900n -0.002403 10.1000n -0.002340 10.1100n -0.002259 10.1200n -0.002158 10.1300n -0.002039 10.1400n -0.001904 10.1500n -0.001754 10.1600n -0.001591 10.1700n -0.001418 10.1800n -0.001236 10.1900n -0.001049
+ 10.2000n -0.000860 10.2100n -0.000670 10.2200n -0.000483 10.2300n -0.000301 10.2400n -0.000127 10.2500n 0.000037 10.2600n 0.000188 10.2700n 0.000325 10.2800n 0.000447 10.2900n 0.000553 10.3000n 0.000641 10.3100n 0.000713 10.3200n 0.000767 10.3300n 0.000805 10.3400n 0.000828
+ 10.3500n 0.000838 10.3600n 0.000836 10.3700n 0.000824 10.3800n 0.000805 10.3900n 0.000782 10.4000n 0.000757 10.4100n 0.000733 10.4200n 0.000714 10.4300n 0.000701 10.4400n 0.000697 10.4500n 0.000706 10.4600n 0.000728 10.4700n 0.000766 10.4800n 0.000821 10.4900n 0.000893
+ 10.5000n 0.000985 10.5100n 0.001094 10.5200n 0.001222 10.5300n 0.001366 10.5400n 0.001525 10.5500n 0.001697 10.5600n 0.001880 10.5700n 0.002071 10.5800n 0.002267 10.5900n 0.002464 10.6000n 0.002658 10.6100n 0.002846 10.6200n 0.003024 10.6300n 0.003188 10.6400n 0.003335
+ 10.6500n 0.003460 10.6600n 0.003561 10.6700n 0.003635 10.6800n 0.003680 10.6900n 0.003694 10.7000n 0.003674 10.7100n 0.003622 10.7200n 0.003535 10.7300n 0.003415 10.7400n 0.003263 10.7500n 0.003080 10.7600n 0.002868 10.7700n 0.002631 10.7800n 0.002371 10.7900n 0.002091
+ 10.8000n 0.001797 10.8100n 0.001491 10.8200n 0.001179 10.8300n 0.000865 10.8400n 0.000553 10.8500n 0.000249 10.8600n -0.000044 10.8700n -0.000322 10.8800n -0.000580 10.8900n -0.000816 10.9000n -0.001026 10.9100n -0.001208 10.9200n -0.001360 10.9300n -0.001480 10.9400n -0.001569
+ 10.9500n -0.001625 10.9600n -0.001649 10.9700n -0.001643 10.9800n -0.001608 10.9900n -0.001546 11.0000n -0.001459 11.0100n -0.001351 11.0200n -0.001224 11.0300n -0.001083 11.0400n -0.000931 11.0500n -0.000771 11.0600n -0.000608 11.0700n -0.000446 11.0800n -0.000287 11.0900n -0.000135
+ 11.1000n 0.000007 11.1100n 0.000135 11.1200n 0.000248 11.1300n 0.000343 11.1400n 0.000420 11.1500n 0.000476 11.1600n 0.000512 11.1700n 0.000527 11.1800n 0.000522 11.1900n 0.000498 11.2000n 0.000454 11.2100n 0.000394 11.2200n 0.000319 11.2300n 0.000231 11.2400n 0.000131
+ 11.2500n 0.000024 11.2600n -0.000090 11.2700n -0.000208 11.2800n -0.000327 11.2900n -0.000445 11.3000n -0.000560 11.3100n -0.000671 11.3200n -0.000775 11.3300n -0.000871 11.3400n -0.000959 11.3500n -0.001037 11.3600n -0.001105 11.3700n -0.001164 11.3800n -0.001213 11.3900n -0.001253
+ 11.4000n -0.001284 11.4100n -0.001308 11.4200n -0.001326 11.4300n -0.001338 11.4400n -0.001347 11.4500n -0.001353 11.4600n -0.001359 11.4700n -0.001364 11.4800n -0.001371 11.4900n -0.001380 11.5000n -0.001393 11.5100n -0.001409 11.5200n -0.001429 11.5300n -0.001453 11.5400n -0.001482
+ 11.5500n -0.001513 11.5600n -0.001548 11.5700n -0.001585 11.5800n -0.001622 11.5900n -0.001659 11.6000n -0.001693 11.6100n -0.001725 11.6200n -0.001751 11.6300n -0.001770 11.6400n -0.001781 11.6500n -0.001782 11.6600n -0.001772 11.6700n -0.001751 11.6800n -0.001716 11.6900n -0.001667
+ 11.7000n -0.001604 11.7100n -0.001528 11.7200n -0.001438 11.7300n -0.001335 11.7400n -0.001220 11.7500n -0.001094 11.7600n -0.000959 11.7700n -0.000817 11.7800n -0.000670 11.7900n -0.000520 11.8000n -0.000370 11.8100n -0.000222 11.8200n -0.000079 11.8300n 0.000057 11.8400n 0.000183
+ 11.8500n 0.000297 11.8600n 0.000397 11.8700n 0.000481 11.8800n 0.000547 11.8900n 0.000595 11.9000n 0.000624 11.9100n 0.000633 11.9200n 0.000622 11.9300n 0.000592 11.9400n 0.000543 11.9500n 0.000477 11.9600n 0.000396 11.9700n 0.000301 11.9800n 0.000195 11.9900n 0.000080
+ 12.0000n -0.000041 12.0100n -0.000166 12.0200n -0.000290 12.0300n -0.000411 12.0400n -0.000527 12.0500n -0.000634 12.0600n -0.000729 12.0700n -0.000811 12.0800n -0.000877 12.0900n -0.000925 12.1000n -0.000955 12.1100n -0.000964 12.1200n -0.000953 12.1300n -0.000920 12.1400n -0.000868
+ 12.1500n -0.000796 12.1600n -0.000705 12.1700n -0.000597 12.1800n -0.000474 12.1900n -0.000338 12.2000n -0.000192 12.2100n -0.000038 12.2200n 0.000121 12.2300n 0.000282 12.2400n 0.000443 12.2500n 0.000600 12.2600n 0.000750 12.2700n 0.000892 12.2800n 0.001023 12.2900n 0.001141
+ 12.3000n 0.001244 12.3100n 0.001331 12.3200n 0.001401 12.3300n 0.001454 12.3400n 0.001489 12.3500n 0.001507 12.3600n 0.001507 12.3700n 0.001492 12.3800n 0.001463 12.3900n 0.001420 12.4000n 0.001367 12.4100n 0.001304 12.4200n 0.001235 12.4300n 0.001160 12.4400n 0.001084
+ 12.4500n 0.001006 12.4600n 0.000931 12.4700n 0.000859 12.4800n 0.000793 12.4900n 0.000733 12.5000n 0.000682 12.5100n 0.000639 12.5200n 0.000606 12.5300n 0.000583 12.5400n 0.000569 12.5500n 0.000564 12.5600n 0.000568 12.5700n 0.000579 12.5800n 0.000596 12.5900n 0.000618
+ 12.6000n 0.000642 12.6100n 0.000668 12.6200n 0.000693 12.6300n 0.000715 12.6400n 0.000733 12.6500n 0.000745 12.6600n 0.000749 12.6700n 0.000745 12.6800n 0.000731 12.6900n 0.000705 12.7000n 0.000669 12.7100n 0.000622 12.7200n 0.000563 12.7300n 0.000495 12.7400n 0.000416
+ 12.7500n 0.000330 12.7600n 0.000236 12.7700n 0.000138 12.7800n 0.000037 12.7900n -0.000065 12.8000n -0.000165 12.8100n -0.000261 12.8200n -0.000351 12.8300n -0.000432 12.8400n -0.000502 12.8500n -0.000560 12.8600n -0.000603 12.8700n -0.000630 12.8800n -0.000640 12.8900n -0.000633
+ 12.9000n -0.000607 12.9100n -0.000563 12.9200n -0.000501 12.9300n -0.000423 12.9400n -0.000329 12.9500n -0.000222 12.9600n -0.000103 12.9700n 0.000024 12.9800n 0.000159 12.9900n 0.000297 13.0000n 0.000435 13.0100n 0.000572 13.0200n 0.000703 13.0300n 0.000825 13.0400n 0.000936
+ 13.0500n 0.001033 13.0600n 0.001114 13.0700n 0.001177 13.0800n 0.001219 13.0900n 0.001241 13.1000n 0.001240 13.1100n 0.001218 13.1200n 0.001173 13.1300n 0.001107 13.1400n 0.001020 13.1500n 0.000915 13.1600n 0.000794 13.1700n 0.000659 13.1800n 0.000512 13.1900n 0.000357
+ 13.2000n 0.000197 13.2100n 0.000036 13.2200n -0.000124 13.2300n -0.000278 13.2400n -0.000424 13.2500n -0.000558 13.2600n -0.000678 13.2700n -0.000782 13.2800n -0.000866 13.2900n -0.000930 13.3000n -0.000972 13.3100n -0.000991 13.3200n -0.000988 13.3300n -0.000963 13.3400n -0.000916
+ 13.3500n -0.000850 13.3600n -0.000766 13.3700n -0.000666 13.3800n -0.000554 13.3900n -0.000432 13.4000n -0.000305 13.4100n -0.000174 13.4200n -0.000046 13.4300n 0.000078 13.4400n 0.000194 13.4500n 0.000296 13.4600n 0.000384 13.4700n 0.000452 13.4800n 0.000500 13.4900n 0.000523
+ 13.5000n 0.000522 13.5100n 0.000493 13.5200n 0.000437 13.5300n 0.000354 13.5400n 0.000244 13.5500n 0.000107 13.5600n -0.000054 13.5700n -0.000238 13.5800n -0.000441 13.5900n -0.000662 13.6000n -0.000896 13.6100n -0.001140 13.6200n -0.001390 13.6300n -0.001642 13.6400n -0.001892
+ 13.6500n -0.002136 13.6600n -0.002370 13.6700n -0.002591 13.6800n -0.002794 13.6900n -0.002977 13.7000n -0.003137 13.7100n -0.003272 13.7200n -0.003379 13.7300n -0.003459 13.7400n -0.003508 13.7500n -0.003529 13.7600n -0.003520 13.7700n -0.003483 13.7800n -0.003418 13.7900n -0.003329
+ 13.8000n -0.003216 13.8100n -0.003083 13.8200n -0.002932 13.8300n -0.002766 13.8400n -0.002589 13.8500n -0.002403 13.8600n -0.002212 13.8700n -0.002019 13.8800n -0.001828 13.8900n -0.001640 13.9000n -0.001459 13.9100n -0.001287 13.9200n -0.001125 13.9300n -0.000976 13.9400n -0.000841
+ 13.9500n -0.000720 13.9600n -0.000613 13.9700n -0.000521 13.9800n -0.000443 13.9900n -0.000379 14.0000n -0.000326 14.0100n -0.000285 14.0200n -0.000252 14.0300n -0.000227 14.0400n -0.000207 14.0500n -0.000191 14.0600n -0.000176 14.0700n -0.000161 14.0800n -0.000144 14.0900n -0.000124
+ 14.1000n -0.000098 14.1100n -0.000067 14.1200n -0.000028 14.1300n 0.000017 14.1400n 0.000071 14.1500n 0.000131 14.1600n 0.000198 14.1700n 0.000271 14.1800n 0.000349 14.1900n 0.000431 14.2000n 0.000515 14.2100n 0.000598 14.2200n 0.000680 14.2300n 0.000759 14.2400n 0.000832
+ 14.2500n 0.000898 14.2600n 0.000954 14.2700n 0.001000 14.2800n 0.001033 14.2900n 0.001053 14.3000n 0.001059 14.3100n 0.001050 14.3200n 0.001026 14.3300n 0.000987 14.3400n 0.000934 14.3500n 0.000868 14.3600n 0.000789 14.3700n 0.000701 14.3800n 0.000604 14.3900n 0.000500
+ 14.4000n 0.000393 14.4100n 0.000285 14.4200n 0.000178 14.4300n 0.000075 14.4400n -0.000020 14.4500n -0.000106 14.4600n -0.000179 14.4700n -0.000238 14.4800n -0.000281 14.4900n -0.000305 14.5000n -0.000309 14.5100n -0.000292 14.5200n -0.000254 14.5300n -0.000194 14.5400n -0.000113
+ 14.5500n -0.000012 14.5600n 0.000108 14.5700n 0.000246 14.5800n 0.000399 14.5900n 0.000565 14.6000n 0.000741 14.6100n 0.000924 14.6200n 0.001111 14.6300n 0.001299 14.6400n 0.001483 14.6500n 0.001662 14.6600n 0.001830 14.6700n 0.001986 14.6800n 0.002125 14.6900n 0.002246
+ 14.7000n 0.002345 14.7100n 0.002422 14.7200n 0.002473 14.7300n 0.002498 14.7400n 0.002496 14.7500n 0.002467 14.7600n 0.002412 14.7700n 0.002330 14.7800n 0.002223 14.7900n 0.002093 14.8000n 0.001942 14.8100n 0.001773 14.8200n 0.001587 14.8300n 0.001389 14.8400n 0.001181
+ 14.8500n 0.000967 14.8600n 0.000750 14.8700n 0.000534 14.8800n 0.000322 14.8900n 0.000117 14.9000n -0.000077 14.9100n -0.000258 14.9200n -0.000423 14.9300n -0.000570 14.9400n -0.000698 14.9500n -0.000804 14.9600n -0.000888 14.9700n -0.000950 14.9800n -0.000989 14.9900n -0.001005
+ 15.0000n -0.001000 15.0100n -0.000975 15.0200n -0.000931 15.0300n -0.000869 15.0400n -0.000793 15.0500n -0.000705 15.0600n -0.000606 15.0700n -0.000500 15.0800n -0.000390 15.0900n -0.000278 15.1000n -0.000167 15.1100n -0.000059 15.1200n 0.000042 15.1300n 0.000135 15.1400n 0.000218
+ 15.1500n 0.000289 15.1600n 0.000345 15.1700n 0.000387 15.1800n 0.000413 15.1900n 0.000423 15.2000n 0.000416 15.2100n 0.000393 15.2200n 0.000354 15.2300n 0.000300 15.2400n 0.000231 15.2500n 0.000150 15.2600n 0.000057 15.2700n -0.000046 15.2800n -0.000156 15.2900n -0.000273
+ 15.3000n -0.000394 15.3100n -0.000517 15.3200n -0.000640 15.3300n -0.000761 15.3400n -0.000878 15.3500n -0.000990 15.3600n -0.001094 15.3700n -0.001191 15.3800n -0.001277 15.3900n -0.001352 15.4000n -0.001416 15.4100n -0.001467 15.4200n -0.001506 15.4300n -0.001531 15.4400n -0.001542
+ 15.4500n -0.001541 15.4600n -0.001527 15.4700n -0.001501 15.4800n -0.001463 15.4900n -0.001414 15.5000n -0.001355 15.5100n -0.001287 15.5200n -0.001211 15.5300n -0.001128 15.5400n -0.001039 15.5500n -0.000945 15.5600n -0.000849 15.5700n -0.000749 15.5800n -0.000649 15.5900n -0.000549
+ 15.6000n -0.000449 15.6100n -0.000351 15.6200n -0.000257 15.6300n -0.000166 15.6400n -0.000079 15.6500n 0.000002 15.6600n 0.000078 15.6700n 0.000147 15.6800n 0.000209 15.6900n 0.000264 15.7000n 0.000312 15.7100n 0.000351 15.7200n 0.000383 15.7300n 0.000406 15.7400n 0.000421
+ 15.7500n 0.000428 15.7600n 0.000427 15.7700n 0.000418 15.7800n 0.000401 15.7900n 0.000377 15.8000n 0.000346 15.8100n 0.000309 15.8200n 0.000266 15.8300n 0.000218 15.8400n 0.000166 15.8500n 0.000109 15.8600n 0.000050 15.8700n -0.000012 15.8800n -0.000075 15.8900n -0.000139
+ 15.9000n -0.000203 15.9100n -0.000265 15.9200n -0.000326 15.9300n -0.000384 15.9400n -0.000438 15.9500n -0.000488 15.9600n -0.000533 15.9700n -0.000572 15.9800n -0.000606 15.9900n -0.000633 16.0000n -0.000653 16.0100n -0.000667 16.0200n -0.000674 16.0300n -0.000674 16.0400n -0.000667
+ 16.0500n -0.000655 16.0600n -0.000636 16.0700n -0.000612 16.0800n -0.000584 16.0900n -0.000551 16.1000n -0.000515 16.1100n -0.000477 16.1200n -0.000437 16.1300n -0.000397 16.1400n -0.000357 16.1500n -0.000318 16.1600n -0.000281 16.1700n -0.000246 16.1800n -0.000215 16.1900n -0.000188
+ 16.2000n -0.000164 16.2100n -0.000145 16.2200n -0.000131 16.2300n -0.000122 16.2400n -0.000117 16.2500n -0.000117 16.2600n -0.000121 16.2700n -0.000129 16.2800n -0.000139 16.2900n -0.000152 16.3000n -0.000167 16.3100n -0.000182 16.3200n -0.000198 16.3300n -0.000213 16.3400n -0.000226
+ 16.3500n -0.000236 16.3600n -0.000244 16.3700n -0.000248 16.3800n -0.000248 16.3900n -0.000243 16.4000n -0.000233 16.4100n -0.000219 16.4200n -0.000200 16.4300n -0.000176 16.4400n -0.000148 16.4500n -0.000116 16.4600n -0.000082 16.4700n -0.000045 16.4800n -0.000007 16.4900n 0.000031
+ 16.5000n 0.000068 16.5100n 0.000102 16.5200n 0.000134 16.5300n 0.000161 16.5400n 0.000183 16.5500n 0.000198 16.5600n 0.000206 16.5700n 0.000207 16.5800n 0.000198 16.5900n 0.000182 16.6000n 0.000156 16.6100n 0.000122 16.6200n 0.000080 16.6300n 0.000031 16.6400n -0.000025
+ 16.6500n -0.000087 16.6600n -0.000152 16.6700n -0.000221 16.6800n -0.000290 16.6900n -0.000358 16.7000n -0.000423 16.7100n -0.000484 16.7200n -0.000537 16.7300n -0.000582 16.7400n -0.000616 16.7500n -0.000637 16.7600n -0.000644 16.7700n -0.000636 16.7800n -0.000611 16.7900n -0.000569
+ 16.8000n -0.000508 16.8100n -0.000430 16.8200n -0.000333 16.8300n -0.000219 16.8400n -0.000088 16.8500n 0.000058 16.8600n 0.000218 16.8700n 0.000390 16.8800n 0.000571 16.8900n 0.000760 16.9000n 0.000953 16.9100n 0.001148 16.9200n 0.001341 16.9300n 0.001531 16.9400n 0.001713
+ 16.9500n 0.001885 16.9600n 0.002044 16.9700n 0.002187 16.9800n 0.002312 16.9900n 0.002418 17.0000n 0.002501 17.0100n 0.002561 17.0200n 0.002598 17.0300n 0.002609 17.0400n 0.002596 17.0500n 0.002558 17.0600n 0.002496 17.0700n 0.002413 17.0800n 0.002308 17.0900n 0.002185
+ 17.1000n 0.002045 17.1100n 0.001892 17.1200n 0.001728 17.1300n 0.001557 17.1400n 0.001381 17.1500n 0.001204 17.1600n 0.001029 17.1700n 0.000859 17.1800n 0.000698 17.1900n 0.000548 17.2000n 0.000412 17.2100n 0.000292 17.2200n 0.000190 17.2300n 0.000108 17.2400n 0.000046
+ 17.2500n 0.000006 17.2600n -0.000013 17.2700n -0.000010 17.2800n 0.000013 17.2900n 0.000055 17.3000n 0.000116 17.3100n 0.000193 17.3200n 0.000283 17.3300n 0.000385 17.3400n 0.000496 17.3500n 0.000612 17.3600n 0.000732 17.3700n 0.000851 17.3800n 0.000967 17.3900n 0.001077
+ 17.4000n 0.001179 17.4100n 0.001270 17.4200n 0.001348 17.4300n 0.001410 17.4400n 0.001456 17.4500n 0.001484 17.4600n 0.001494 17.4700n 0.001485 17.4800n 0.001457 17.4900n 0.001411 17.5000n 0.001347 17.5100n 0.001267 17.5200n 0.001172 17.5300n 0.001064 17.5400n 0.000945
+ 17.5500n 0.000817 17.5600n 0.000682 17.5700n 0.000543 17.5800n 0.000402 17.5900n 0.000262 17.6000n 0.000125 17.6100n -0.000007 17.6200n -0.000132 17.6300n -0.000248 17.6400n -0.000354 17.6500n -0.000449 17.6600n -0.000532 17.6700n -0.000602 17.6800n -0.000659 17.6900n -0.000704
+ 17.7000n -0.000736 17.7100n -0.000757 17.7200n -0.000767 17.7300n -0.000768 17.7400n -0.000761 17.7500n -0.000748 17.7600n -0.000729 17.7700n -0.000708 17.7800n -0.000685 17.7900n -0.000663 17.8000n -0.000642 17.8100n -0.000624 17.8200n -0.000610 17.8300n -0.000602 17.8400n -0.000600
+ 17.8500n -0.000604 17.8600n -0.000615 17.8700n -0.000633 17.8800n -0.000657 17.8900n -0.000686 17.9000n -0.000720 17.9100n -0.000758 17.9200n -0.000798 17.9300n -0.000839 17.9400n -0.000879 17.9500n -0.000917 17.9600n -0.000950 17.9700n -0.000978 17.9800n -0.000999 17.9900n -0.001010
+ 18.0000n -0.001011 18.0100n -0.001001 18.0200n -0.000979 18.0300n -0.000943 18.0400n -0.000894 18.0500n -0.000832 18.0600n -0.000757 18.0700n -0.000670 18.0800n -0.000570 18.0900n -0.000461 18.1000n -0.000342 18.1100n -0.000216 18.1200n -0.000084 18.1300n 0.000051 18.1400n 0.000187
+ 18.1500n 0.000322 18.1600n 0.000454 18.1700n 0.000580 18.1800n 0.000699 18.1900n 0.000808 18.2000n 0.000906 18.2100n 0.000990 18.2200n 0.001060 18.2300n 0.001114 18.2400n 0.001152 18.2500n 0.001174 18.2600n 0.001178 18.2700n 0.001166 18.2800n 0.001139 18.2900n 0.001096
+ 18.3000n 0.001039 18.3100n 0.000970 18.3200n 0.000891 18.3300n 0.000803 18.3400n 0.000708 18.3500n 0.000609 18.3600n 0.000508 18.3700n 0.000407 18.3800n 0.000308 18.3900n 0.000213 18.4000n 0.000125 18.4100n 0.000044 18.4200n -0.000027 18.4300n -0.000088 18.4400n -0.000137
+ 18.4500n -0.000175 18.4600n -0.000200 18.4700n -0.000213 18.4800n -0.000213 18.4900n -0.000202 18.5000n -0.000181 18.5100n -0.000151 18.5200n -0.000112 18.5300n -0.000067 18.5400n -0.000017 18.5500n 0.000037 18.5600n 0.000091 18.5700n 0.000145 18.5800n 0.000198 18.5900n 0.000247
+ 18.6000n 0.000291 18.6100n 0.000329 18.6200n 0.000360 18.6300n 0.000383 18.6400n 0.000398 18.6500n 0.000406 18.6600n 0.000405 18.6700n 0.000397 18.6800n 0.000382 18.6900n 0.000362 18.7000n 0.000338 18.7100n 0.000311 18.7200n 0.000283 18.7300n 0.000256 18.7400n 0.000232
+ 18.7500n 0.000213 18.7600n 0.000200 18.7700n 0.000195 18.7800n 0.000200 18.7900n 0.000217 18.8000n 0.000247 18.8100n 0.000291 18.8200n 0.000348 18.8300n 0.000421 18.8400n 0.000508 18.8500n 0.000610 18.8600n 0.000725 18.8700n 0.000853 18.8800n 0.000991 18.8900n 0.001138
+ 18.9000n 0.001292 18.9100n 0.001451 18.9200n 0.001611 18.9300n 0.001770 18.9400n 0.001925 18.9500n 0.002072 18.9600n 0.002210 18.9700n 0.002334 18.9800n 0.002443 18.9900n 0.002533 19.0000n 0.002601 19.0100n 0.002647 19.0200n 0.002667 19.0300n 0.002661 19.0400n 0.002628
+ 19.0500n 0.002566 19.0600n 0.002476 19.0700n 0.002358 19.0800n 0.002212 19.0900n 0.002040 19.1000n 0.001844 19.1100n 0.001625 19.1200n 0.001385 19.1300n 0.001128 19.1400n 0.000856 19.1500n 0.000572 19.1600n 0.000279 19.1700n -0.000019 19.1800n -0.000319 19.1900n -0.000617
+ 19.2000n -0.000911 19.2100n -0.001198 19.2200n -0.001473 19.2300n -0.001735 19.2400n -0.001981 19.2500n -0.002209 19.2600n -0.002418 19.2700n -0.002605 19.2800n -0.002769 19.2900n -0.002910 19.3000n -0.003026 19.3100n -0.003119 19.3200n -0.003188 19.3300n -0.003234 19.3400n -0.003256
+ 19.3500n -0.003257 19.3600n -0.003238 19.3700n -0.003198 19.3800n -0.003141 19.3900n -0.003068 19.4000n -0.002979 19.4100n -0.002877 19.4200n -0.002763 19.4300n -0.002639 19.4400n -0.002505 19.4500n -0.002364 19.4600n -0.002217 19.4700n -0.002064 19.4800n -0.001906 19.4900n -0.001746
+ 19.5000n -0.001582 19.5100n -0.001416 19.5200n -0.001249 19.5300n -0.001081 19.5400n -0.000913 19.5500n -0.000745 19.5600n -0.000577 19.5700n -0.000411 19.5800n -0.000246 19.5900n -0.000083 19.6000n 0.000077 19.6100n 0.000232 19.6200n 0.000384 19.6300n 0.000529 19.6400n 0.000668
+ 19.6500n 0.000799 19.6600n 0.000921 19.6700n 0.001032 19.6800n 0.001132 19.6900n 0.001218 19.7000n 0.001290 19.7100n 0.001346 19.7200n 0.001385 19.7300n 0.001406 19.7400n 0.001407 19.7500n 0.001389 19.7600n 0.001350 19.7700n 0.001291 19.7800n 0.001211 19.7900n 0.001110
+ 19.8000n 0.000990 19.8100n 0.000850 19.8200n 0.000693 19.8300n 0.000519 19.8400n 0.000330 19.8500n 0.000129 19.8600n -0.000083 19.8700n -0.000302 19.8800n -0.000526 19.8900n -0.000753 19.9000n -0.000979 19.9100n -0.001201 19.9200n -0.001417 19.9300n -0.001624 19.9400n -0.001818
+ 19.9500n -0.001998 19.9600n -0.002162 19.9700n -0.002306 19.9800n -0.002430 19.9900n -0.002533 20.0000n -0.002613 20.0100n -0.002669 20.0200n -0.002702 20.0300n -0.002713 20.0400n -0.002701 20.0500n -0.002667 20.0600n -0.002614 20.0700n -0.002543 20.0800n -0.002457 20.0900n -0.002357
+ 20.1000n -0.002246 20.1100n -0.002126 20.1200n -0.002001 20.1300n -0.001874 20.1400n -0.001746 20.1500n -0.001621 20.1600n -0.001501 20.1700n -0.001388 20.1800n -0.001284 20.1900n -0.001191 20.2000n -0.001110 20.2100n -0.001042 20.2200n -0.000987 20.2300n -0.000946 20.2400n -0.000918
+ 20.2500n -0.000902 20.2600n -0.000898 20.2700n -0.000904 20.2800n -0.000919 20.2900n -0.000940 20.3000n -0.000966 20.3100n -0.000993 20.3200n -0.001021 20.3300n -0.001046 20.3400n -0.001066 20.3500n -0.001079 20.3600n -0.001083 20.3700n -0.001076 20.3800n -0.001057 20.3900n -0.001025
+ 20.4000n -0.000979 20.4100n -0.000919 20.4200n -0.000844 20.4300n -0.000755 20.4400n -0.000653 20.4500n -0.000539 20.4600n -0.000415 20.4700n -0.000283 20.4800n -0.000145 20.4900n -0.000005 20.5000n 0.000137 20.5100n 0.000276 20.5200n 0.000409 20.5300n 0.000535 20.5400n 0.000649
+ 20.5500n 0.000749 20.5600n 0.000833 20.5700n 0.000899 20.5800n 0.000944 20.5900n 0.000968 20.6000n 0.000969 20.6100n 0.000947 20.6200n 0.000902 20.6300n 0.000834 20.6400n 0.000744 20.6500n 0.000634 20.6600n 0.000506 20.6700n 0.000362 20.6800n 0.000204 20.6900n 0.000036
+ 20.7000n -0.000138 20.7100n -0.000316 20.7200n -0.000494 20.7300n -0.000667 20.7400n -0.000834 20.7500n -0.000989 20.7600n -0.001130 20.7700n -0.001253 20.7800n -0.001357 20.7900n -0.001439 20.8000n -0.001496 20.8100n -0.001529 20.8200n -0.001536 20.8300n -0.001516 20.8400n -0.001471
+ 20.8500n -0.001401 20.8600n -0.001308 20.8700n -0.001194 20.8800n -0.001061 20.8900n -0.000912 20.9000n -0.000750 20.9100n -0.000579 20.9200n -0.000402 20.9300n -0.000223 20.9400n -0.000046 20.9500n 0.000126 20.9600n 0.000288 20.9700n 0.000438 20.9800n 0.000573 20.9900n 0.000689
+ 21.0000n 0.000785 21.0100n 0.000859 21.0200n 0.000910 21.0300n 0.000937 21.0400n 0.000940 21.0500n 0.000919 21.0600n 0.000876 21.0700n 0.000813 21.0800n 0.000730 21.0900n 0.000632 21.1000n 0.000520 21.1100n 0.000399 21.1200n 0.000271 21.1300n 0.000141 21.1400n 0.000012
+ 21.1500n -0.000113 21.1600n -0.000229 21.1700n -0.000332 21.1800n -0.000421 21.1900n -0.000492 21.2000n -0.000543 21.2100n -0.000571 21.2200n -0.000576 21.2300n -0.000556 21.2400n -0.000512 21.2500n -0.000443 21.2600n -0.000350 21.2700n -0.000236 21.2800n -0.000101 21.2900n 0.000050
+ 21.3000n 0.000216 21.3100n 0.000393 21.3200n 0.000577 21.3300n 0.000765 21.3400n 0.000952 21.3500n 0.001134 21.3600n 0.001308 21.3700n 0.001468 21.3800n 0.001613 21.3900n 0.001737 21.4000n 0.001840 21.4100n 0.001917 21.4200n 0.001967 21.4300n 0.001988 21.4400n 0.001980
+ 21.4500n 0.001943 21.4600n 0.001876 21.4700n 0.001782 21.4800n 0.001661 21.4900n 0.001516 21.5000n 0.001349 21.5100n 0.001165 21.5200n 0.000966 21.5300n 0.000756 21.5400n 0.000539 21.5500n 0.000320 21.5600n 0.000104 21.5700n -0.000107 21.5800n -0.000306 21.5900n -0.000492
+ 21.6000n -0.000659 21.6100n -0.000805 21.6200n -0.000928 21.6300n -0.001024 21.6400n -0.001092 21.6500n -0.001131 21.6600n -0.001140 21.6700n -0.001121 21.6800n -0.001073 21.6900n -0.000998 21.7000n -0.000898 21.7100n -0.000775 21.7200n -0.000633 21.7300n -0.000475 21.7400n -0.000305
+ 21.7500n -0.000126 21.7600n 0.000058 21.7700n 0.000241 21.7800n 0.000420 21.7900n 0.000591 21.8000n 0.000750 21.8100n 0.000892 21.8200n 0.001016 21.8300n 0.001118 21.8400n 0.001195 21.8500n 0.001245 21.8600n 0.001268 21.8700n 0.001263 21.8800n 0.001229 21.8900n 0.001166
+ 21.9000n 0.001076 21.9100n 0.000960 21.9200n 0.000821 21.9300n 0.000660 21.9400n 0.000482 21.9500n 0.000288 21.9600n 0.000082 21.9700n -0.000131 21.9800n -0.000349 21.9900n -0.000566 22.0000n -0.000779 22.0100n -0.000985 22.0200n -0.001180 22.0300n -0.001360 22.0400n -0.001523
+ 22.0500n -0.001666 22.0600n -0.001787 22.0700n -0.001883 22.0800n -0.001955 22.0900n -0.002000 22.1000n -0.002019 22.1100n -0.002012 22.1200n -0.001980 22.1300n -0.001923 22.1400n -0.001843 22.1500n -0.001742 22.1600n -0.001623 22.1700n -0.001487 22.1800n -0.001337 22.1900n -0.001177
+ 22.2000n -0.001009 22.2100n -0.000835 22.2200n -0.000660 22.2300n -0.000485 22.2400n -0.000314 22.2500n -0.000148 22.2600n 0.000009 22.2700n 0.000156 22.2800n 0.000292 22.2900n 0.000414 22.3000n 0.000523 22.3100n 0.000616 22.3200n 0.000694 22.3300n 0.000757 22.3400n 0.000804
+ 22.3500n 0.000837 22.3600n 0.000856 22.3700n 0.000862 22.3800n 0.000857 22.3900n 0.000841 22.4000n 0.000815 22.4100n 0.000782 22.4200n 0.000743 22.4300n 0.000699 22.4400n 0.000652 22.4500n 0.000604 22.4600n 0.000554 22.4700n 0.000505 22.4800n 0.000458 22.4900n 0.000413
+ 22.5000n 0.000371 22.5100n 0.000332 22.5200n 0.000298 22.5300n 0.000268 22.5400n 0.000242 22.5500n 0.000220 22.5600n 0.000202 22.5700n 0.000188 22.5800n 0.000178 22.5900n 0.000170 22.6000n 0.000165 22.6100n 0.000162 22.6200n 0.000161 22.6300n 0.000161 22.6400n 0.000162
+ 22.6500n 0.000164 22.6600n 0.000166 22.6700n 0.000168 22.6800n 0.000170 22.6900n 0.000173 22.7000n 0.000176 22.7100n 0.000179 22.7200n 0.000182 22.7300n 0.000187 22.7400n 0.000192 22.7500n 0.000198 22.7600n 0.000206 22.7700n 0.000216 22.7800n 0.000227 22.7900n 0.000241
+ 22.8000n 0.000257 22.8100n 0.000274 22.8200n 0.000295 22.8300n 0.000317 22.8400n 0.000340 22.8500n 0.000366 22.8600n 0.000392 22.8700n 0.000419 22.8800n 0.000446 22.8900n 0.000472 22.9000n 0.000497 22.9100n 0.000520 22.9200n 0.000540 22.9300n 0.000557 22.9400n 0.000570
+ 22.9500n 0.000579 22.9600n 0.000582 22.9700n 0.000581 22.9800n 0.000573 22.9900n 0.000559 23.0000n 0.000540 23.0100n 0.000514 23.0200n 0.000483 23.0300n 0.000446 23.0400n 0.000404 23.0500n 0.000359 23.0600n 0.000310 23.0700n 0.000258 23.0800n 0.000205 23.0900n 0.000151
+ 23.1000n 0.000098 23.1100n 0.000046 23.1200n -0.000003 23.1300n -0.000048 23.1400n -0.000088 23.1500n -0.000122 23.1600n -0.000149 23.1700n -0.000170 23.1800n -0.000182 23.1900n -0.000185 23.2000n -0.000180 23.2100n -0.000167 23.2200n -0.000144 23.2300n -0.000113 23.2400n -0.000074
+ 23.2500n -0.000028 23.2600n 0.000026 23.2700n 0.000085 23.2800n 0.000149 23.2900n 0.000217 23.3000n 0.000288 23.3100n 0.000361 23.3200n 0.000435 23.3300n 0.000509 23.3400n 0.000581 23.3500n 0.000651 23.3600n 0.000718 23.3700n 0.000781 23.3800n 0.000841 23.3900n 0.000896
+ 23.4000n 0.000946 23.4100n 0.000991 23.4200n 0.001033 23.4300n 0.001070 23.4400n 0.001103 23.4500n 0.001134 23.4600n 0.001162 23.4700n 0.001189 23.4800n 0.001215 23.4900n 0.001242 23.5000n 0.001271 23.5100n 0.001301 23.5200n 0.001335 23.5300n 0.001374 23.5400n 0.001416
+ 23.5500n 0.001464 23.5600n 0.001518 23.5700n 0.001577 23.5800n 0.001642 23.5900n 0.001712 23.6000n 0.001787 23.6100n 0.001866 23.6200n 0.001948 23.6300n 0.002032 23.6400n 0.002117 23.6500n 0.002201 23.6600n 0.002281 23.6700n 0.002358 23.6800n 0.002428 23.6900n 0.002490
+ 23.7000n 0.002541 23.7100n 0.002581 23.7200n 0.002607 23.7300n 0.002618 23.7400n 0.002612 23.7500n 0.002588 23.7600n 0.002545 23.7700n 0.002482 23.7800n 0.002400 23.7900n 0.002297 23.8000n 0.002175 23.8100n 0.002033 23.8200n 0.001873 23.8300n 0.001697 23.8400n 0.001505
+ 23.8500n 0.001299 23.8600n 0.001082 23.8700n 0.000856 23.8800n 0.000623 23.8900n 0.000387 23.9000n 0.000149 23.9100n -0.000086 23.9200n -0.000317 23.9300n -0.000541 23.9400n -0.000754 23.9500n -0.000955 23.9600n -0.001140 23.9700n -0.001309 23.9800n -0.001458 23.9900n -0.001587
+ 24.0000n -0.001695 24.0100n -0.001779 24.0200n -0.001841 24.0300n -0.001879 24.0400n -0.001894 24.0500n -0.001886 24.0600n -0.001857 24.0700n -0.001807 24.0800n -0.001737 24.0900n -0.001651 24.1000n -0.001548 24.1100n -0.001432 24.1200n -0.001304 24.1300n -0.001167 24.1400n -0.001023
+ 24.1500n -0.000875 24.1600n -0.000724 24.1700n -0.000573 24.1800n -0.000423 24.1900n -0.000278 24.2000n -0.000137 24.2100n -0.000004 24.2200n 0.000121 24.2300n 0.000237 24.2400n 0.000343 24.2500n 0.000439 24.2600n 0.000523 24.2700n 0.000596 24.2800n 0.000658 24.2900n 0.000709
+ 24.3000n 0.000749 24.3100n 0.000779 24.3200n 0.000800 24.3300n 0.000813 24.3400n 0.000817 24.3500n 0.000815 24.3600n 0.000806 24.3700n 0.000792 24.3800n 0.000773 24.3900n 0.000750 24.4000n 0.000724 24.4100n 0.000696 24.4200n 0.000665 24.4300n 0.000632 24.4400n 0.000598
+ 24.4500n 0.000563 24.4600n 0.000526 24.4700n 0.000489 24.4800n 0.000450 24.4900n 0.000411 24.5000n 0.000370 24.5100n 0.000329 24.5200n 0.000287 24.5300n 0.000244 24.5400n 0.000201 24.5500n 0.000157 24.5600n 0.000113 24.5700n 0.000069 24.5800n 0.000025 24.5900n -0.000017
+ 24.6000n -0.000057 24.6100n -0.000095 24.6200n -0.000129 24.6300n -0.000159 24.6400n -0.000185 24.6500n -0.000204 24.6600n -0.000217 24.6700n -0.000222 24.6800n -0.000218 24.6900n -0.000206 24.7000n -0.000184 24.7100n -0.000153 24.7200n -0.000111 24.7300n -0.000059 24.7400n 0.000003
+ 24.7500n 0.000075 24.7600n 0.000155 24.7700n 0.000244 24.7800n 0.000340 24.7900n 0.000441 24.8000n 0.000547 24.8100n 0.000655 24.8200n 0.000763 24.8300n 0.000870 24.8400n 0.000973 24.8500n 0.001071 24.8600n 0.001161 24.8700n 0.001240 24.8800n 0.001307 24.8900n 0.001360
+ 24.9000n 0.001397 24.9100n 0.001416 24.9200n 0.001415 24.9300n 0.001395 24.9400n 0.001353 24.9500n 0.001289 24.9600n 0.001204 24.9700n 0.001098 24.9800n 0.000971 24.9900n 0.000823 25.0000n 0.000658 25.0100n 0.000475 25.0200n 0.000278 25.0300n 0.000069 25.0400n -0.000150
+ 25.0500n -0.000376 25.0600n -0.000606 25.0700n -0.000837 25.0800n -0.001066 25.0900n -0.001288 25.1000n -0.001503 25.1100n -0.001705 25.1200n -0.001893 25.1300n -0.002064 25.1400n -0.002216 25.1500n -0.002346 25.1600n -0.002452 25.1700n -0.002534 25.1800n -0.002591 25.1900n -0.002622
+ 25.2000n -0.002627 25.2100n -0.002606 25.2200n -0.002560 25.2300n -0.002491 25.2400n -0.002399 25.2500n -0.002287 25.2600n -0.002158 25.2700n -0.002013 25.2800n -0.001855 25.2900n -0.001687 25.3000n -0.001512 25.3100n -0.001334 25.3200n -0.001154 25.3300n -0.000977 25.3400n -0.000805
+ 25.3500n -0.000641 25.3600n -0.000488 25.3700n -0.000347 25.3800n -0.000220 25.3900n -0.000110 25.4000n -0.000018 25.4100n 0.000055 25.4200n 0.000109 25.4300n 0.000143 25.4400n 0.000157 25.4500n 0.000151 25.4600n 0.000127 25.4700n 0.000085 25.4800n 0.000027 25.4900n -0.000047
+ 25.5000n -0.000134 25.5100n -0.000232 25.5200n -0.000340 25.5300n -0.000456 25.5400n -0.000577 25.5500n -0.000702 25.5600n -0.000829 25.5700n -0.000955 25.5800n -0.001079 25.5900n -0.001198 25.6000n -0.001313 25.6100n -0.001420 25.6200n -0.001520 25.6300n -0.001610 25.6400n -0.001691
+ 25.6500n -0.001761 25.6600n -0.001821 25.6700n -0.001869 25.6800n -0.001907 25.6900n -0.001933 25.7000n -0.001949 25.7100n -0.001955 25.7200n -0.001951 25.7300n -0.001938 25.7400n -0.001916 25.7500n -0.001887 25.7600n -0.001850 25.7700n -0.001806 25.7800n -0.001757 25.7900n -0.001703
+ 25.8000n -0.001644 25.8100n -0.001582 25.8200n -0.001516 25.8300n -0.001448 25.8400n -0.001377 25.8500n -0.001305 25.8600n -0.001232 25.8700n -0.001158 25.8800n -0.001083 25.8900n -0.001009 25.9000n -0.000935 25.9100n -0.000862 25.9200n -0.000791 25.9300n -0.000721 25.9400n -0.000653
+ 25.9500n -0.000588 25.9600n -0.000526 25.9700n -0.000468 25.9800n -0.000413 25.9900n -0.000363 26.0000n -0.000318 26.0100n -0.000279 26.0200n -0.000245 26.0300n -0.000217 26.0400n -0.000196 26.0500n -0.000180 26.0600n -0.000172 26.0700n -0.000170 26.0800n -0.000174 26.0900n -0.000184
+ 26.1000n -0.000200 26.1100n -0.000221 26.1200n -0.000247 26.1300n -0.000276 26.1400n -0.000307 26.1500n -0.000341 26.1600n -0.000375 26.1700n -0.000408 26.1800n -0.000440 26.1900n -0.000469 26.2000n -0.000494 26.2100n -0.000513 26.2200n -0.000526 26.2300n -0.000532 26.2400n -0.000530
+ 26.2500n -0.000520 26.2600n -0.000500 26.2700n -0.000472 26.2800n -0.000434 26.2900n -0.000387 26.3000n -0.000332 26.3100n -0.000270 26.3200n -0.000202 26.3300n -0.000129 26.3400n -0.000052 26.3500n 0.000025 26.3600n 0.000103 26.3700n 0.000177 26.3800n 0.000247 26.3900n 0.000309
+ 26.4000n 0.000362 26.4100n 0.000403 26.4200n 0.000430 26.4300n 0.000441 26.4400n 0.000435 26.4500n 0.000409 26.4600n 0.000362 26.4700n 0.000294 26.4800n 0.000204 26.4900n 0.000093 26.5000n -0.000040 26.5100n -0.000194 26.5200n -0.000367 26.5300n -0.000558 26.5400n -0.000764
+ 26.5500n -0.000984 26.5600n -0.001212 26.5700n -0.001448 26.5800n -0.001686 26.5900n -0.001924 26.6000n -0.002157 26.6100n -0.002381 26.6200n -0.002593 26.6300n -0.002788 26.6400n -0.002962 26.6500n -0.003113 26.6600n -0.003237 26.6700n -0.003332 26.6800n -0.003394 26.6900n -0.003422
+ 26.7000n -0.003416 26.7100n -0.003374 26.7200n -0.003296 26.7300n -0.003184 26.7400n -0.003037 26.7500n -0.002859 26.7600n -0.002652 26.7700n -0.002418 26.7800n -0.002162 26.7900n -0.001888 26.8000n -0.001599 26.8100n -0.001301 26.8200n -0.000998 26.8300n -0.000696 26.8400n -0.000399
+ 26.8500n -0.000113 26.8600n 0.000159 26.8700n 0.000410 26.8800n 0.000638 26.8900n 0.000839 26.9000n 0.001009 26.9100n 0.001146 26.9200n 0.001248 26.9300n 0.001315 26.9400n 0.001344 26.9500n 0.001338 26.9600n 0.001297 26.9700n 0.001222 26.9800n 0.001115 26.9900n 0.000981
+ 27.0000n 0.000822 27.0100n 0.000643 27.0200n 0.000448 27.0300n 0.000241 27.0400n 0.000028 27.0500n -0.000186 27.0600n -0.000396 27.0700n -0.000598 27.0800n -0.000786 27.0900n -0.000956 27.1000n -0.001103 27.1100n -0.001226 27.1200n -0.001319 27.1300n -0.001382 27.1400n -0.001412
+ 27.1500n -0.001408 27.1600n -0.001371 27.1700n -0.001300 27.1800n -0.001198 27.1900n -0.001065 27.2000n -0.000905 27.2100n -0.000720 27.2200n -0.000516 27.2300n -0.000294 27.2400n -0.000061 27.2500n 0.000179 27.2600n 0.000421 27.2700n 0.000660 27.2800n 0.000891 27.2900n 0.001109
+ 27.3000n 0.001310 27.3100n 0.001489 27.3200n 0.001643 27.3300n 0.001768 27.3400n 0.001863 27.3500n 0.001924 27.3600n 0.001951 27.3700n 0.001943 27.3800n 0.001901 27.3900n 0.001824 27.4000n 0.001715 27.4100n 0.001576 27.4200n 0.001410 27.4300n 0.001220 27.4400n 0.001009
+ 27.4500n 0.000783 27.4600n 0.000545 27.4700n 0.000300 27.4800n 0.000053 27.4900n -0.000192 27.5000n -0.000429 27.5100n -0.000655 27.5200n -0.000865 27.5300n -0.001055 27.5400n -0.001223 27.5500n -0.001365 27.5600n -0.001480 27.5700n -0.001565 27.5800n -0.001621 27.5900n -0.001646
+ 27.6000n -0.001640 27.6100n -0.001606 27.6200n -0.001545 27.6300n -0.001458 27.6400n -0.001348 27.6500n -0.001219 27.6600n -0.001074 27.6700n -0.000916 27.6800n -0.000749 27.6900n -0.000578 27.7000n -0.000406 27.7100n -0.000236 27.7200n -0.000074 27.7300n 0.000079 27.7400n 0.000218
+ 27.7500n 0.000341 27.7600n 0.000446 27.7700n 0.000531 27.7800n 0.000595 27.7900n 0.000636 27.8000n 0.000655 27.8100n 0.000651 27.8200n 0.000626 27.8300n 0.000581 27.8400n 0.000518 27.8500n 0.000438 27.8600n 0.000344 27.8700n 0.000239 27.8800n 0.000125 27.8900n 0.000006
+ 27.9000n -0.000116 27.9100n -0.000238 27.9200n -0.000356 27.9300n -0.000468 27.9400n -0.000571 27.9500n -0.000664 27.9600n -0.000744 27.9700n -0.000811 27.9800n -0.000862 27.9900n -0.000897 28.0000n -0.000916 28.0100n -0.000918 28.0200n -0.000906 28.0300n -0.000878 28.0400n -0.000838
+ 28.0500n -0.000785 28.0600n -0.000722 28.0700n -0.000651 28.0800n -0.000574 28.0900n -0.000492 28.1000n -0.000409 28.1100n -0.000326 28.1200n -0.000246 28.1300n -0.000169 28.1400n -0.000098 28.1500n -0.000034 28.1600n 0.000021 28.1700n 0.000067 28.1800n 0.000104 28.1900n 0.000131
+ 28.2000n 0.000149 28.2100n 0.000158 28.2200n 0.000158 28.2300n 0.000152 28.2400n 0.000139 28.2500n 0.000122 28.2600n 0.000103 28.2700n 0.000082 28.2800n 0.000062 28.2900n 0.000044 28.3000n 0.000030 28.3100n 0.000022 28.3200n 0.000020 28.3300n 0.000027 28.3400n 0.000042
+ 28.3500n 0.000067 28.3600n 0.000102 28.3700n 0.000146 28.3800n 0.000199 28.3900n 0.000260 28.4000n 0.000329 28.4100n 0.000404 28.4200n 0.000483 28.4300n 0.000565 28.4400n 0.000647 28.4500n 0.000728 28.4600n 0.000805 28.4700n 0.000876 28.4800n 0.000938 28.4900n 0.000991
+ 28.5000n 0.001031 28.5100n 0.001057 28.5200n 0.001068 28.5300n 0.001062 28.5400n 0.001039 28.5500n 0.000998 28.5600n 0.000940 28.5700n 0.000864 28.5800n 0.000771 28.5900n 0.000663 28.6000n 0.000542 28.6100n 0.000408 28.6200n 0.000264 28.6300n 0.000114 28.6400n -0.000042
+ 28.6500n -0.000199 28.6600n -0.000355 28.6700n -0.000507 28.6800n -0.000652 28.6900n -0.000788 28.7000n -0.000911 28.7100n -0.001019 28.7200n -0.001111 28.7300n -0.001185 28.7400n -0.001238 28.7500n -0.001271 28.7600n -0.001283 28.7700n -0.001273 28.7800n -0.001243 28.7900n -0.001193
+ 28.8000n -0.001124 28.8100n -0.001038 28.8200n -0.000938 28.8300n -0.000825 28.8400n -0.000702 28.8500n -0.000572 28.8600n -0.000439 28.8700n -0.000305 28.8800n -0.000173 28.8900n -0.000046 28.9000n 0.000073 28.9100n 0.000181 28.9200n 0.000276 28.9300n 0.000356 28.9400n 0.000419
+ 28.9500n 0.000464 28.9600n 0.000490 28.9700n 0.000497 28.9800n 0.000485 28.9900n 0.000454 29.0000n 0.000406 29.0100n 0.000341 29.0200n 0.000262 29.0300n 0.000171 29.0400n 0.000069 29.0500n -0.000039 29.0600n -0.000152 29.0700n -0.000266 29.0800n -0.000379 29.0900n -0.000488
+ 29.1000n -0.000589 29.1100n -0.000681 29.1200n -0.000761 29.1300n -0.000827 29.1400n -0.000877 29.1500n -0.000910 29.1600n -0.000926 29.1700n -0.000923 29.1800n -0.000903 29.1900n -0.000865 29.2000n -0.000810 29.2100n -0.000741 29.2200n -0.000658 29.2300n -0.000564 29.2400n -0.000462
+ 29.2500n -0.000354 29.2600n -0.000242 29.2700n -0.000131 29.2800n -0.000023 29.2900n 0.000078 29.3000n 0.000171 29.3100n 0.000252 29.3200n 0.000318 29.3300n 0.000368 29.3400n 0.000400 29.3500n 0.000411 29.3600n 0.000402 29.3700n 0.000371 29.3800n 0.000319 29.3900n 0.000246
+ 29.4000n 0.000152 29.4100n 0.000039 29.4200n -0.000090 29.4300n -0.000235 29.4400n -0.000392 29.4500n -0.000558 29.4600n -0.000731 29.4700n -0.000907 29.4800n -0.001084 29.4900n -0.001256 29.5000n -0.001422 29.5100n -0.001578 29.5200n -0.001722 29.5300n -0.001849 29.5400n -0.001958
+ 29.5500n -0.002047 29.5600n -0.002113 29.5700n -0.002157 29.5800n -0.002176 29.5900n -0.002170 29.6000n -0.002140 29.6100n -0.002087 29.6200n -0.002010 29.6300n -0.001912 29.6400n -0.001794 29.6500n -0.001658 29.6600n -0.001507 29.6700n -0.001344 29.6800n -0.001170 29.6900n -0.000990
+ 29.7000n -0.000806 29.7100n -0.000620 29.7200n -0.000435 29.7300n -0.000255 29.7400n -0.000081 29.7500n 0.000085 29.7600n 0.000240 29.7700n 0.000384 29.7800n 0.000516 29.7900n 0.000634 29.8000n 0.000739 29.8100n 0.000831 29.8200n 0.000910 29.8300n 0.000977 29.8400n 0.001033
+ 29.8500n 0.001080 29.8600n 0.001120 29.8700n 0.001154 29.8800n 0.001185 29.8900n 0.001214 29.9000n 0.001244 29.9100n 0.001276 29.9200n 0.001313 29.9300n 0.001356 29.9400n 0.001407 29.9500n 0.001468 29.9600n 0.001538 29.9700n 0.001618 29.9800n 0.001709 29.9900n 0.001811
+ 30.0000n 0.001922 30.0100n 0.002042 30.0200n 0.002169 30.0300n 0.002301 30.0400n 0.002437 30.0500n 0.002574 30.0600n 0.002710 30.0700n 0.002840 30.0800n 0.002963 30.0900n 0.003076 30.1000n 0.003175 30.1100n 0.003257 30.1200n 0.003319 30.1300n 0.003359 30.1400n 0.003374
+ 30.1500n 0.003362 30.1600n 0.003321 30.1700n 0.003251 30.1800n 0.003149 30.1900n 0.003015 30.2000n 0.002850 30.2100n 0.002654 30.2200n 0.002427 30.2300n 0.002173 30.2400n 0.001891 30.2500n 0.001586 30.2600n 0.001260 30.2700n 0.000916 30.2800n 0.000557 30.2900n 0.000188
+ 30.3000n -0.000187 30.3100n -0.000565 30.3200n -0.000940 30.3300n -0.001308 30.3400n -0.001666 30.3500n -0.002008 30.3600n -0.002331 30.3700n -0.002632 30.3800n -0.002906 30.3900n -0.003150 30.4000n -0.003362 30.4100n -0.003539 30.4200n -0.003679 30.4300n -0.003782 30.4400n -0.003846
+ 30.4500n -0.003870 30.4600n -0.003855 30.4700n -0.003801 30.4800n -0.003710 30.4900n -0.003583 30.5000n -0.003421 30.5100n -0.003228 30.5200n -0.003005 30.5300n -0.002756 30.5400n -0.002485 30.5500n -0.002194 30.5600n -0.001887 30.5700n -0.001568 30.5800n -0.001242 30.5900n -0.000911
+ 30.6000n -0.000581 30.6100n -0.000254 30.6200n 0.000066 30.6300n 0.000375 30.6400n 0.000669 30.6500n 0.000946 30.6600n 0.001203 30.6700n 0.001437 30.6800n 0.001645 30.6900n 0.001826 30.7000n 0.001979 30.7100n 0.002101 30.7200n 0.002192 30.7300n 0.002251 30.7400n 0.002278
+ 30.7500n 0.002273 30.7600n 0.002237 30.7700n 0.002171 30.7800n 0.002074 30.7900n 0.001950 30.8000n 0.001799 30.8100n 0.001623 30.8200n 0.001425 30.8300n 0.001207 30.8400n 0.000972 30.8500n 0.000722 30.8600n 0.000460 30.8700n 0.000189 30.8800n -0.000088 30.8900n -0.000367
+ 30.9000n -0.000647 30.9100n -0.000923 30.9200n -0.001193 30.9300n -0.001454 30.9400n -0.001704 30.9500n -0.001940 30.9600n -0.002160 30.9700n -0.002361 30.9800n -0.002542 30.9900n -0.002701 31.0000n -0.002837 31.0100n -0.002950 31.0200n -0.003038 31.0300n -0.003102 31.0400n -0.003140
+ 31.0500n -0.003155 31.0600n -0.003146 31.0700n -0.003114 31.0800n -0.003062 31.0900n -0.002989 31.1000n -0.002899 31.1100n -0.002794 31.1200n -0.002675 31.1300n -0.002545 31.1400n -0.002407 31.1500n -0.002262 31.1600n -0.002115 31.1700n -0.001967 31.1800n -0.001821 31.1900n -0.001679
+ 31.2000n -0.001544 31.2100n -0.001418 31.2200n -0.001302 31.2300n -0.001198 31.2400n -0.001108 31.2500n -0.001032 31.2600n -0.000971 31.2700n -0.000925 31.2800n -0.000895 31.2900n -0.000879 31.3000n -0.000878 31.3100n -0.000890 31.3200n -0.000914 31.3300n -0.000948 31.3400n -0.000990
+ 31.3500n -0.001039 31.3600n -0.001092 31.3700n -0.001147 31.3800n -0.001202 31.3900n -0.001254 31.4000n -0.001301 31.4100n -0.001341 31.4200n -0.001372 31.4300n -0.001392 31.4400n -0.001400 31.4500n -0.001393 31.4600n -0.001371 31.4700n -0.001334 31.4800n -0.001280 31.4900n -0.001211
+ 31.5000n -0.001125 31.5100n -0.001024 31.5200n -0.000909 31.5300n -0.000781 31.5400n -0.000641 31.5500n -0.000493 31.5600n -0.000337 31.5700n -0.000176 31.5800n -0.000012 31.5900n 0.000152 31.6000n 0.000314 31.6100n 0.000470 31.6200n 0.000620 31.6300n 0.000759 31.6400n 0.000887
+ 31.6500n 0.001002 31.6600n 0.001101 31.6700n 0.001184 31.6800n 0.001249 31.6900n 0.001295 31.7000n 0.001323 31.7100n 0.001332 31.7200n 0.001322 31.7300n 0.001295 31.7400n 0.001251 31.7500n 0.001191 31.7600n 0.001118 31.7700n 0.001032 31.7800n 0.000935 31.7900n 0.000831
+ 31.8000n 0.000720 31.8100n 0.000606 31.8200n 0.000490 31.8300n 0.000374 31.8400n 0.000261 31.8500n 0.000153 31.8600n 0.000050 31.8700n -0.000045 31.8800n -0.000131 31.8900n -0.000207 31.9000n -0.000273 31.9100n -0.000328 31.9200n -0.000373 31.9300n -0.000406 31.9400n -0.000429
+ 31.9500n -0.000443 31.9600n -0.000447 31.9700n -0.000445 31.9800n -0.000436 31.9900n -0.000421 32.0000n -0.000404 32.0100n -0.000384 32.0200n -0.000363 32.0300n -0.000343 32.0400n -0.000324 32.0500n -0.000309 32.0600n -0.000297 32.0700n -0.000290 32.0800n -0.000287 32.0900n -0.000289
+ 32.1000n -0.000297 32.1100n -0.000309 32.1200n -0.000325 32.1300n -0.000345 32.1400n -0.000366 32.1500n -0.000389 32.1600n -0.000412 32.1700n -0.000433 32.1800n -0.000451 32.1900n -0.000464 32.2000n -0.000471 32.2100n -0.000470 32.2200n -0.000460 32.2300n -0.000440 32.2400n -0.000409
+ 32.2500n -0.000366 32.2600n -0.000311 32.2700n -0.000243 32.2800n -0.000163 32.2900n -0.000072 32.3000n 0.000031 32.3100n 0.000143 32.3200n 0.000263 32.3300n 0.000390 32.3400n 0.000521 32.3500n 0.000654 32.3600n 0.000787 32.3700n 0.000917 32.3800n 0.001041 32.3900n 0.001156
+ 32.4000n 0.001261 32.4100n 0.001352 32.4200n 0.001428 32.4300n 0.001485 32.4400n 0.001522 32.4500n 0.001538 32.4600n 0.001531 32.4700n 0.001501 32.4800n 0.001446 32.4900n 0.001368 32.5000n 0.001265 32.5100n 0.001141 32.5200n 0.000995 32.5300n 0.000829 32.5400n 0.000646
+ 32.5500n 0.000448 32.5600n 0.000238 32.5700n 0.000019 32.5800n -0.000206 32.5900n -0.000434 32.6000n -0.000661 32.6100n -0.000883 32.6200n -0.001099 32.6300n -0.001303 32.6400n -0.001494 32.6500n -0.001668 32.6600n -0.001824 32.6700n -0.001959 32.6800n -0.002072 32.6900n -0.002161
+ 32.7000n -0.002226 32.7100n -0.002266 32.7200n -0.002282 32.7300n -0.002274 32.7400n -0.002244 32.7500n -0.002191 32.7600n -0.002120 32.7700n -0.002031 32.7800n -0.001926 32.7900n -0.001810 32.8000n -0.001683 32.8100n -0.001549 32.8200n -0.001411 32.8300n -0.001272 32.8400n -0.001133
+ 32.8500n -0.000999 32.8600n -0.000870 32.8700n -0.000749 32.8800n -0.000638 32.8900n -0.000538 32.9000n -0.000450 32.9100n -0.000375 32.9200n -0.000313 32.9300n -0.000263 32.9400n -0.000226 32.9500n -0.000201 32.9600n -0.000187 32.9700n -0.000182 32.9800n -0.000185 32.9900n -0.000194
+ 33.0000n -0.000208 33.0100n -0.000225 33.0200n -0.000242 33.0300n -0.000259 33.0400n -0.000274 33.0500n -0.000285 33.0600n -0.000291 33.0700n -0.000292 33.0800n -0.000286 33.0900n -0.000273 33.1000n -0.000253 33.1100n -0.000227 33.1200n -0.000195 33.1300n -0.000158 33.1400n -0.000117
+ 33.1500n -0.000074 33.1600n -0.000030 33.1700n 0.000012 33.1800n 0.000051 33.1900n 0.000085 33.2000n 0.000112 33.2100n 0.000129 33.2200n 0.000135 33.2300n 0.000129 33.2400n 0.000108 33.2500n 0.000072 33.2600n 0.000019 33.2700n -0.000050 33.2800n -0.000136 33.2900n -0.000239
+ 33.3000n -0.000357 33.3100n -0.000490 33.3200n -0.000637 33.3300n -0.000794 33.3400n -0.000960 33.3500n -0.001133 33.3600n -0.001309 33.3700n -0.001486 33.3800n -0.001659 33.3900n -0.001827 33.4000n -0.001985 33.4100n -0.002131 33.4200n -0.002262 33.4300n -0.002374 33.4400n -0.002465
+ 33.4500n -0.002533 33.4600n -0.002577 33.4700n -0.002594 33.4800n -0.002585 33.4900n -0.002548 33.5000n -0.002484 33.5100n -0.002393 33.5200n -0.002278 33.5300n -0.002139 33.5400n -0.001980 33.5500n -0.001802 33.5600n -0.001609 33.5700n -0.001404 33.5800n -0.001192 33.5900n -0.000975
+ 33.6000n -0.000759 33.6100n -0.000546 33.6200n -0.000342 33.6300n -0.000150 33.6400n 0.000026 33.6500n 0.000184 33.6600n 0.000319 33.6700n 0.000429 33.6800n 0.000512 33.6900n 0.000567 33.7000n 0.000592 33.7100n 0.000587 33.7200n 0.000552 33.7300n 0.000487 33.7400n 0.000394
+ 33.7500n 0.000275 33.7600n 0.000131 33.7700n -0.000034 33.7800n -0.000217 33.7900n -0.000415 33.8000n -0.000625 33.8100n -0.000842 33.8200n -0.001062 33.8300n -0.001282 33.8400n -0.001496 33.8500n -0.001703 33.8600n -0.001897 33.8700n -0.002076 33.8800n -0.002236 33.8900n -0.002375
+ 33.9000n -0.002491 33.9100n -0.002582 33.9200n -0.002647 33.9300n -0.002685 33.9400n -0.002696 33.9500n -0.002681 33.9600n -0.002639 33.9700n -0.002573 33.9800n -0.002484 33.9900n -0.002374 34.0000n -0.002246 34.0100n -0.002102 34.0200n -0.001944 34.0300n -0.001777 34.0400n -0.001603
+ 34.0500n -0.001424 34.0600n -0.001244 34.0700n -0.001066 34.0800n -0.000892 34.0900n -0.000724 34.1000n -0.000566 34.1100n -0.000418 34.1200n -0.000281 34.1300n -0.000158 34.1400n -0.000049 34.1500n 0.000046 34.1600n 0.000127 34.1700n 0.000193 34.1800n 0.000246 34.1900n 0.000287
+ 34.2000n 0.000315 34.2100n 0.000334 34.2200n 0.000343 34.2300n 0.000344 34.2400n 0.000340 34.2500n 0.000331 34.2600n 0.000319 34.2700n 0.000304 34.2800n 0.000290 34.2900n 0.000276 34.3000n 0.000263 34.3100n 0.000252 34.3200n 0.000243 34.3300n 0.000237 34.3400n 0.000234
+ 34.3500n 0.000233 34.3600n 0.000234 34.3700n 0.000237 34.3800n 0.000240 34.3900n 0.000244 34.4000n 0.000246 34.4100n 0.000246 34.4200n 0.000243 34.4300n 0.000236 34.4400n 0.000225 34.4500n 0.000208 34.4600n 0.000186 34.4700n 0.000157 34.4800n 0.000121 34.4900n 0.000080
+ 34.5000n 0.000032 34.5100n -0.000022 34.5200n -0.000080 34.5300n -0.000142 34.5400n -0.000206 34.5500n -0.000272 34.5600n -0.000338 34.5700n -0.000402 34.5800n -0.000462 34.5900n -0.000517 34.6000n -0.000565 34.6100n -0.000604 34.6200n -0.000634 34.6300n -0.000652 34.6400n -0.000657
+ 34.6500n -0.000649 34.6600n -0.000627 34.6700n -0.000591 34.6800n -0.000540 34.6900n -0.000475 34.7000n -0.000397 34.7100n -0.000306 34.7200n -0.000204 34.7300n -0.000093 34.7400n 0.000027 34.7500n 0.000151 34.7600n 0.000279 34.7700n 0.000408 34.7800n 0.000535 34.7900n 0.000657
+ 34.8000n 0.000773 34.8100n 0.000880 34.8200n 0.000975 34.8300n 0.001056 34.8400n 0.001121 34.8500n 0.001170 34.8600n 0.001200 34.8700n 0.001211 34.8800n 0.001202 34.8900n 0.001174 34.9000n 0.001127 34.9100n 0.001061 34.9200n 0.000977 34.9300n 0.000879 34.9400n 0.000767
+ 34.9500n 0.000643 34.9600n 0.000511 34.9700n 0.000373 34.9800n 0.000232 34.9900n 0.000092 35.0000n -0.000046 35.0100n -0.000177 35.0200n -0.000298 35.0300n -0.000408 35.0400n -0.000502 35.0500n -0.000580 35.0600n -0.000639 35.0700n -0.000677 35.0800n -0.000693 35.0900n -0.000687
+ 35.1000n -0.000659 35.1100n -0.000607 35.1200n -0.000535 35.1300n -0.000441 35.1400n -0.000328 35.1500n -0.000199 35.1600n -0.000054 35.1700n 0.000103 35.1800n 0.000270 35.1900n 0.000443 35.2000n 0.000619 35.2100n 0.000795 35.2200n 0.000969 35.2300n 0.001137 35.2400n 0.001295
+ 35.2500n 0.001442 35.2600n 0.001576 35.2700n 0.001693 35.2800n 0.001792 35.2900n 0.001872 35.3000n 0.001932 35.3100n 0.001972 35.3200n 0.001991 35.3300n 0.001990 35.3400n 0.001969 35.3500n 0.001931 35.3600n 0.001876 35.3700n 0.001806 35.3800n 0.001724 35.3900n 0.001631
+ 35.4000n 0.001531 35.4100n 0.001425 35.4200n 0.001317 35.4300n 0.001209 35.4400n 0.001103 35.4500n 0.001002 35.4600n 0.000908 35.4700n 0.000822 35.4800n 0.000746 35.4900n 0.000682 35.5000n 0.000629 35.5100n 0.000589 35.5200n 0.000561 35.5300n 0.000545 35.5400n 0.000540
+ 35.5500n 0.000545 35.5600n 0.000559 35.5700n 0.000580 35.5800n 0.000606 35.5900n 0.000634 35.6000n 0.000663 35.6100n 0.000690 35.6200n 0.000712 35.6300n 0.000728 35.6400n 0.000735 35.6500n 0.000731 35.6600n 0.000715 35.6700n 0.000684 35.6800n 0.000638 35.6900n 0.000575
+ 35.7000n 0.000495 35.7100n 0.000398 35.7200n 0.000284 35.7300n 0.000154 35.7400n 0.000008 35.7500n -0.000151 35.7600n -0.000322 35.7700n -0.000503 35.7800n -0.000691 35.7900n -0.000885 35.8000n -0.001080 35.8100n -0.001275 35.8200n -0.001465 35.8300n -0.001649 35.8400n -0.001824
+ 35.8500n -0.001985 35.8600n -0.002132 35.8700n -0.002261 35.8800n -0.002370 35.8900n -0.002457 35.9000n -0.002522 35.9100n -0.002561 35.9200n -0.002576 35.9300n -0.002565 35.9400n -0.002528 35.9500n -0.002467 35.9600n -0.002380 35.9700n -0.002270 35.9800n -0.002139 35.9900n -0.001987
+ 36.0000n -0.001817 36.0100n -0.001631 36.0200n -0.001432 36.0300n -0.001221 36.0400n -0.001002 36.0500n -0.000777 36.0600n -0.000549 36.0700n -0.000320 36.0800n -0.000093 36.0900n 0.000129 36.1000n 0.000345 36.1100n 0.000553 36.1200n 0.000750 36.1300n 0.000935 36.1400n 0.001107
+ 36.1500n 0.001264 36.1600n 0.001406 36.1700n 0.001533 36.1800n 0.001642 36.1900n 0.001736 36.2000n 0.001812 36.2100n 0.001872 36.2200n 0.001916 36.2300n 0.001943 36.2400n 0.001956 36.2500n 0.001954 36.2600n 0.001938 36.2700n 0.001908 36.2800n 0.001867 36.2900n 0.001813
+ 36.3000n 0.001749 36.3100n 0.001675 36.3200n 0.001591 36.3300n 0.001499 36.3400n 0.001400 36.3500n 0.001294 36.3600n 0.001181 36.3700n 0.001064 36.3800n 0.000941 36.3900n 0.000816 36.4000n 0.000687 36.4100n 0.000557 36.4200n 0.000426 36.4300n 0.000295 36.4400n 0.000166
+ 36.4500n 0.000038 36.4600n -0.000086 36.4700n -0.000205 36.4800n -0.000319 36.4900n -0.000425 36.5000n -0.000523 36.5100n -0.000612 36.5200n -0.000690 36.5300n -0.000756 36.5400n -0.000809 36.5500n -0.000849 36.5600n -0.000874 36.5700n -0.000885 36.5800n -0.000880 36.5900n -0.000860
+ 36.6000n -0.000824 36.6100n -0.000774 36.6200n -0.000709 36.6300n -0.000631 36.6400n -0.000541 36.6500n -0.000439 36.6600n -0.000329 36.6700n -0.000211 36.6800n -0.000088 36.6900n 0.000038 36.7000n 0.000165 36.7100n 0.000290 36.7200n 0.000411 36.7300n 0.000525 36.7400n 0.000629
+ 36.7500n 0.000722 36.7600n 0.000801 36.7700n 0.000865 36.7800n 0.000911 36.7900n 0.000938 36.8000n 0.000945 36.8100n 0.000932 36.8200n 0.000898 36.8300n 0.000843 36.8400n 0.000768 36.8500n 0.000674 36.8600n 0.000563 36.8700n 0.000435 36.8800n 0.000293 36.8900n 0.000141
+ 36.9000n -0.000020 36.9100n -0.000186 36.9200n -0.000355 36.9300n -0.000522 36.9400n -0.000684 36.9500n -0.000838 36.9600n -0.000980 36.9700n -0.001109 36.9800n -0.001219 36.9900n -0.001310 37.0000n -0.001378 37.0100n -0.001421 37.0200n -0.001440 37.0300n -0.001432 37.0400n -0.001396
+ 37.0500n -0.001335 37.0600n -0.001247 37.0700n -0.001134 37.0800n -0.000999 37.0900n -0.000842 37.1000n -0.000668 37.1100n -0.000479 37.1200n -0.000278 37.1300n -0.000070 37.1400n 0.000143 37.1500n 0.000355 37.1600n 0.000564 37.1700n 0.000764 37.1800n 0.000953 37.1900n 0.001126
+ 37.2000n 0.001280 37.2100n 0.001413 37.2200n 0.001522 37.2300n 0.001604 37.2400n 0.001659 37.2500n 0.001686 37.2600n 0.001683 37.2700n 0.001652 37.2800n 0.001594 37.2900n 0.001510 37.3000n 0.001402 37.3100n 0.001272 37.3200n 0.001124 37.3300n 0.000961 37.3400n 0.000787
+ 37.3500n 0.000606 37.3600n 0.000421 37.3700n 0.000238 37.3800n 0.000060 37.3900n -0.000110 37.4000n -0.000266 37.4100n -0.000405 37.4200n -0.000526 37.4300n -0.000624 37.4400n -0.000697 37.4500n -0.000744 37.4600n -0.000765 37.4700n -0.000758 37.4800n -0.000723 37.4900n -0.000663
+ 37.5000n -0.000577 37.5100n -0.000469 37.5200n -0.000340 37.5300n -0.000195 37.5400n -0.000035 37.5500n 0.000134 37.5600n 0.000309 37.5700n 0.000485 37.5800n 0.000658 37.5900n 0.000824 37.6000n 0.000978 37.6100n 0.001117 37.6200n 0.001237 37.6300n 0.001334 37.6400n 0.001406
+ 37.6500n 0.001450 37.6600n 0.001465 37.6700n 0.001448 37.6800n 0.001401 37.6900n 0.001322 37.7000n 0.001212 37.7100n 0.001074 37.7200n 0.000908 37.7300n 0.000718 37.7400n 0.000506 37.7500n 0.000276 37.7600n 0.000033 37.7700n -0.000221 37.7800n -0.000480 37.7900n -0.000741
+ 37.8000n -0.000997 37.8100n -0.001246 37.8200n -0.001482 37.8300n -0.001703 37.8400n -0.001903 37.8500n -0.002079 37.8600n -0.002230 37.8700n -0.002351 37.8800n -0.002443 37.8900n -0.002503 37.9000n -0.002531 37.9100n -0.002527 37.9200n -0.002491 37.9300n -0.002426 37.9400n -0.002332
+ 37.9500n -0.002213 37.9600n -0.002070 37.9700n -0.001907 37.9800n -0.001728 37.9900n -0.001536 38.0000n -0.001335 38.0100n -0.001129 38.0200n -0.000922 38.0300n -0.000718 38.0400n -0.000520 38.0500n -0.000332 38.0600n -0.000157 38.0700n 0.000003 38.0800n 0.000144 38.0900n 0.000266
+ 38.1000n 0.000366 38.1100n 0.000444 38.1200n 0.000499 38.1300n 0.000532 38.1400n 0.000543 38.1500n 0.000533 38.1600n 0.000503 38.1700n 0.000455 38.1800n 0.000392 38.1900n 0.000315 38.2000n 0.000227 38.2100n 0.000131 38.2200n 0.000030 38.2300n -0.000074 38.2400n -0.000178
+ 38.2500n -0.000280 38.2600n -0.000377 38.2700n -0.000467 38.2800n -0.000548 38.2900n -0.000619 38.3000n -0.000679 38.3100n -0.000726 38.3200n -0.000760 38.3300n -0.000781 38.3400n -0.000789 38.3500n -0.000785 38.3600n -0.000768 38.3700n -0.000741 38.3800n -0.000705 38.3900n -0.000660
+ 38.4000n -0.000609 38.4100n -0.000552 38.4200n -0.000493 38.4300n -0.000431 38.4400n -0.000368 38.4500n -0.000307 38.4600n -0.000247 38.4700n -0.000191 38.4800n -0.000139 38.4900n -0.000091 38.5000n -0.000048 38.5100n -0.000010 38.5200n 0.000024 38.5300n 0.000053 38.5400n 0.000078
+ 38.5500n 0.000100 38.5600n 0.000120 38.5700n 0.000140 38.5800n 0.000159 38.5900n 0.000180 38.6000n 0.000204 38.6100n 0.000231 38.6200n 0.000262 38.6300n 0.000300 38.6400n 0.000343 38.6500n 0.000394 38.6600n 0.000451 38.6700n 0.000515 38.6800n 0.000586 38.6900n 0.000663
+ 38.7000n 0.000745 38.7100n 0.000831 38.7200n 0.000920 38.7300n 0.001010 38.7400n 0.001098 38.7500n 0.001185 38.7600n 0.001266 38.7700n 0.001340 38.7800n 0.001404 38.7900n 0.001457 38.8000n 0.001497 38.8100n 0.001521 38.8200n 0.001527 38.8300n 0.001515 38.8400n 0.001483
+ 38.8500n 0.001431 38.8600n 0.001357 38.8700n 0.001261 38.8800n 0.001145 38.8900n 0.001008 38.9000n 0.000852 38.9100n 0.000679 38.9200n 0.000490 38.9300n 0.000287 38.9400n 0.000074 38.9500n -0.000146 38.9600n -0.000372 38.9700n -0.000598 38.9800n -0.000823 38.9900n -0.001041
+ 39.0000n -0.001251 39.0100n -0.001448 39.0200n -0.001628 39.0300n -0.001790 39.0400n -0.001930 39.0500n -0.002046 39.0600n -0.002136 39.0700n -0.002198 39.0800n -0.002230 39.0900n -0.002232 39.1000n -0.002204 39.1100n -0.002146 39.1200n -0.002059 39.1300n -0.001943 39.1400n -0.001801
+ 39.1500n -0.001634 39.1600n -0.001446 39.1700n -0.001238 39.1800n -0.001014 39.1900n -0.000777 39.2000n -0.000531 39.2100n -0.000279 39.2200n -0.000026 39.2300n 0.000226 39.2400n 0.000473 39.2500n 0.000711 39.2600n 0.000937 39.2700n 0.001149 39.2800n 0.001342 39.2900n 0.001516
+ 39.3000n 0.001668 39.3100n 0.001797 39.3200n 0.001901 39.3300n 0.001979 39.3400n 0.002032 39.3500n 0.002058 39.3600n 0.002060 39.3700n 0.002036 39.3800n 0.001990 39.3900n 0.001921 39.4000n 0.001832 39.4100n 0.001724 39.4200n 0.001600 39.4300n 0.001463 39.4400n 0.001313
+ 39.4500n 0.001154 39.4600n 0.000988 39.4700n 0.000818 39.4800n 0.000645 39.4900n 0.000471 39.5000n 0.000300 39.5100n 0.000132 39.5200n -0.000031 39.5300n -0.000188 39.5400n -0.000337 39.5500n -0.000477 39.5600n -0.000608 39.5700n -0.000729 39.5800n -0.000840 39.5900n -0.000941
+ 39.6000n -0.001031 39.6100n -0.001111 39.6200n -0.001181 39.6300n -0.001242 39.6400n -0.001294 39.6500n -0.001338 39.6600n -0.001374 39.6700n -0.001403 39.6800n -0.001426 39.6900n -0.001443 39.7000n -0.001454 39.7100n -0.001461 39.7200n -0.001463 39.7300n -0.001462 39.7400n -0.001457
+ 39.7500n -0.001448 39.7600n -0.001437 39.7700n -0.001422 39.7800n -0.001405 39.7900n -0.001385 39.8000n -0.001363 39.8100n -0.001338 39.8200n -0.001310 39.8300n -0.001280 39.8400n -0.001247 39.8500n -0.001212 39.8600n -0.001176 39.8700n -0.001137 39.8800n -0.001096 39.8900n -0.001054
+ 39.9000n -0.001011 39.9100n -0.000968 39.9200n -0.000925 39.9300n -0.000881 39.9400n -0.000839 39.9500n -0.000798 39.9600n -0.000760 39.9700n -0.000723 39.9800n -0.000690 39.9900n -0.000660 40.0000n -0.000634 40.0100n -0.000612 40.0200n -0.000595 40.0300n -0.000582 40.0400n -0.000574
+ 40.0500n -0.000570 40.0600n -0.000572 40.0700n -0.000577 40.0800n -0.000587 40.0900n -0.000600 40.1000n -0.000616 40.1100n -0.000635 40.1200n -0.000655 40.1300n -0.000676 40.1400n -0.000698 40.1500n -0.000719 40.1600n -0.000738 40.1700n -0.000756 40.1800n -0.000770 40.1900n -0.000780
+ 40.2000n -0.000786 40.2100n -0.000787 40.2200n -0.000783 40.2300n -0.000773 40.2400n -0.000756 40.2500n -0.000734 40.2600n -0.000705 40.2700n -0.000670 40.2800n -0.000629 40.2900n -0.000583 40.3000n -0.000532 40.3100n -0.000476 40.3200n -0.000416 40.3300n -0.000353 40.3400n -0.000288
+ 40.3500n -0.000221 40.3600n -0.000154 40.3700n -0.000087 40.3800n -0.000021 40.3900n 0.000044 40.4000n 0.000106 40.4100n 0.000164 40.4200n 0.000219 40.4300n 0.000269 40.4400n 0.000315 40.4500n 0.000355 40.4600n 0.000390 40.4700n 0.000419 40.4800n 0.000443 40.4900n 0.000462
+ 40.5000n 0.000475 40.5100n 0.000483 40.5200n 0.000486 40.5300n 0.000485 40.5400n 0.000479 40.5500n 0.000470 40.5600n 0.000458 40.5700n 0.000442 40.5800n 0.000425 40.5900n 0.000405 40.6000n 0.000384 40.6100n 0.000361 40.6200n 0.000337 40.6300n 0.000312 40.6400n 0.000286
+ 40.6500n 0.000260 40.6600n 0.000234 40.6700n 0.000206 40.6800n 0.000179 40.6900n 0.000150 40.7000n 0.000121 40.7100n 0.000092 40.7200n 0.000062 40.7300n 0.000031 40.7400n -0.000001 40.7500n -0.000034 40.7600n -0.000066 40.7700n -0.000100 40.7800n -0.000133 40.7900n -0.000167
+ 40.8000n -0.000200 40.8100n -0.000232 40.8200n -0.000263 40.8300n -0.000292 40.8400n -0.000319 40.8500n -0.000343 40.8600n -0.000363 40.8700n -0.000379 40.8800n -0.000391 40.8900n -0.000397 40.9000n -0.000398 40.9100n -0.000392 40.9200n -0.000381 40.9300n -0.000363 40.9400n -0.000339
+ 40.9500n -0.000309 40.9600n -0.000273 40.9700n -0.000231 40.9800n -0.000185 40.9900n -0.000135 41.0000n -0.000082 41.0100n -0.000027 41.0200n 0.000028 41.0300n 0.000083 41.0400n 0.000135 41.0500n 0.000184 41.0600n 0.000227 41.0700n 0.000264 41.0800n 0.000292 41.0900n 0.000311
+ 41.1000n 0.000318 41.1100n 0.000314 41.1200n 0.000296 41.1300n 0.000264 41.1400n 0.000217 41.1500n 0.000156 41.1600n 0.000080 41.1700n -0.000010 41.1800n -0.000115 41.1900n -0.000232 41.2000n -0.000361 41.2100n -0.000500 41.2200n -0.000647 41.2300n -0.000801 41.2400n -0.000959
+ 41.2500n -0.001118 41.2600n -0.001276 41.2700n -0.001431 41.2800n -0.001578 41.2900n -0.001717 41.3000n -0.001843 41.3100n -0.001954 41.3200n -0.002049 41.3300n -0.002123 41.3400n -0.002176 41.3500n -0.002206 41.3600n -0.002211 41.3700n -0.002190 41.3800n -0.002143 41.3900n -0.002068
+ 41.4000n -0.001968 41.4100n -0.001841 41.4200n -0.001689 41.4300n -0.001513 41.4400n -0.001316 41.4500n -0.001098 41.4600n -0.000863 41.4700n -0.000613 41.4800n -0.000351 41.4900n -0.000080 41.5000n 0.000197 41.5100n 0.000477 41.5200n 0.000756 41.5300n 0.001032 41.5400n 0.001301
+ 41.5500n 0.001561 41.5600n 0.001809 41.5700n 0.002043 41.5800n 0.002261 41.5900n 0.002461 41.6000n 0.002642 41.6100n 0.002803 41.6200n 0.002944 41.6300n 0.003063 41.6400n 0.003163 41.6500n 0.003242 41.6600n 0.003303 41.6700n 0.003346 41.6800n 0.003373 41.6900n 0.003385
+ 41.7000n 0.003384 41.7100n 0.003373 41.7200n 0.003353 41.7300n 0.003327 41.7400n 0.003295 41.7500n 0.003261 41.7600n 0.003226 41.7700n 0.003192 41.7800n 0.003159 41.7900n 0.003130 41.8000n 0.003104 41.8100n 0.003083 41.8200n 0.003066 41.8300n 0.003053 41.8400n 0.003045
+ 41.8500n 0.003040 41.8600n 0.003038 41.8700n 0.003037 41.8800n 0.003037 41.8900n 0.003035 41.9000n 0.003029 41.9100n 0.003020 41.9200n 0.003004 41.9300n 0.002980 41.9400n 0.002946 41.9500n 0.002902 41.9600n 0.002846 41.9700n 0.002777 41.9800n 0.002694 41.9900n 0.002597
+ 42.0000n 0.002486 42.0100n 0.002361 42.0200n 0.002223 42.0300n 0.002072 42.0400n 0.001909 42.0500n 0.001737 42.0600n 0.001557 42.0700n 0.001370 42.0800n 0.001180 42.0900n 0.000988 42.1000n 0.000797 42.1100n 0.000609 42.1200n 0.000427 42.1300n 0.000253 42.1400n 0.000090
+ 42.1500n -0.000061 42.1600n -0.000196 42.1700n -0.000316 42.1800n -0.000418 42.1900n -0.000501 42.2000n -0.000564 42.2100n -0.000608 42.2200n -0.000632 42.2300n -0.000637 42.2400n -0.000623 42.2500n -0.000592 42.2600n -0.000545 42.2700n -0.000484 42.2800n -0.000412 42.2900n -0.000330
+ 42.3000n -0.000240 42.3100n -0.000146 42.3200n -0.000050 42.3300n 0.000045 42.3400n 0.000138 42.3500n 0.000224 42.3600n 0.000303 42.3700n 0.000373 42.3800n 0.000430 42.3900n 0.000475 42.4000n 0.000506 42.4100n 0.000521 42.4200n 0.000522 42.4300n 0.000506 42.4400n 0.000476
+ 42.4500n 0.000432 42.4600n 0.000374 42.4700n 0.000305 42.4800n 0.000225 42.4900n 0.000137 42.5000n 0.000043 42.5100n -0.000056 42.5200n -0.000156 42.5300n -0.000256 42.5400n -0.000353 42.5500n -0.000446 42.5600n -0.000531 42.5700n -0.000607 42.5800n -0.000672 42.5900n -0.000726
+ 42.6000n -0.000766 42.6100n -0.000792 42.6200n -0.000804 42.6300n -0.000802 42.6400n -0.000785 42.6500n -0.000754 42.6600n -0.000711 42.6700n -0.000656 42.6800n -0.000591 42.6900n -0.000518 42.7000n -0.000437 42.7100n -0.000353 42.7200n -0.000266 42.7300n -0.000178 42.7400n -0.000093
+ 42.7500n -0.000011 42.7600n 0.000065 42.7700n 0.000133 42.7800n 0.000193 42.7900n 0.000241 42.8000n 0.000278 42.8100n 0.000303 42.8200n 0.000315 42.8300n 0.000315 42.8400n 0.000301 42.8500n 0.000276 42.8600n 0.000239 42.8700n 0.000192 42.8800n 0.000135 42.8900n 0.000072
+ 42.9000n 0.000003 42.9100n -0.000070 42.9200n -0.000144 42.9300n -0.000219 42.9400n -0.000291 42.9500n -0.000360 42.9600n -0.000422 42.9700n -0.000478 42.9800n -0.000525 42.9900n -0.000562 43.0000n -0.000588 43.0100n -0.000602 43.0200n -0.000606 43.0300n -0.000597 43.0400n -0.000577
+ 43.0500n -0.000547 43.0600n -0.000506 43.0700n -0.000457 43.0800n -0.000401 43.0900n -0.000340 43.1000n -0.000274 43.1100n -0.000207 43.1200n -0.000140 43.1300n -0.000074 43.1400n -0.000013 43.1500n 0.000043 43.1600n 0.000091 43.1700n 0.000130 43.1800n 0.000159 43.1900n 0.000176
+ 43.2000n 0.000181 43.2100n 0.000173 43.2200n 0.000153 43.2300n 0.000119 43.2400n 0.000074 43.2500n 0.000016 43.2600n -0.000051 43.2700n -0.000128 43.2800n -0.000212 43.2900n -0.000301 43.3000n -0.000394 43.3100n -0.000489 43.3200n -0.000582 43.3300n -0.000672 43.3400n -0.000756
+ 43.3500n -0.000833 43.3600n -0.000900 43.3700n -0.000955 43.3800n -0.000996 43.3900n -0.001023 43.4000n -0.001034 43.4100n -0.001027 43.4200n -0.001004 43.4300n -0.000962 43.4400n -0.000903 43.4500n -0.000827 43.4600n -0.000735 43.4700n -0.000629 43.4800n -0.000508 43.4900n -0.000377
+ 43.5000n -0.000235 43.5100n -0.000087 43.5200n 0.000067 43.5300n 0.000223 43.5400n 0.000379 43.5500n 0.000532 43.5600n 0.000680 43.5700n 0.000821 43.5800n 0.000952 43.5900n 0.001070 43.6000n 0.001175 43.6100n 0.001264 43.6200n 0.001336 43.6300n 0.001390 43.6400n 0.001425
+ 43.6500n 0.001440 43.6600n 0.001436 43.6700n 0.001413 43.6800n 0.001371 43.6900n 0.001311 43.7000n 0.001234 43.7100n 0.001142 43.7200n 0.001035 43.7300n 0.000916 43.7400n 0.000787 43.7500n 0.000649 43.7600n 0.000504 43.7700n 0.000355 43.7800n 0.000204 43.7900n 0.000053
+ 43.8000n -0.000097 43.8100n -0.000243 43.8200n -0.000383 43.8300n -0.000516 43.8400n -0.000641 43.8500n -0.000757 43.8600n -0.000861 43.8700n -0.000953 43.8800n -0.001034 43.8900n -0.001101 43.9000n -0.001155 43.9100n -0.001195 43.9200n -0.001223 43.9300n -0.001237 43.9400n -0.001239
+ 43.9500n -0.001228 43.9600n -0.001206 43.9700n -0.001172 43.9800n -0.001129 43.9900n -0.001075 44.0000n -0.001013 44.0100n -0.000943 44.0200n -0.000866 44.0300n -0.000783 44.0400n -0.000695 44.0500n -0.000603 44.0600n -0.000507 44.0700n -0.000408 44.0800n -0.000308 44.0900n -0.000207
+ 44.1000n -0.000106 44.1100n -0.000005 44.1200n 0.000093 44.1300n 0.000189 44.1400n 0.000281 44.1500n 0.000369 44.1600n 0.000452 44.1700n 0.000528 44.1800n 0.000597 44.1900n 0.000659 44.2000n 0.000711 44.2100n 0.000753 44.2200n 0.000785 44.2300n 0.000805 44.2400n 0.000813
+ 44.2500n 0.000808 44.2600n 0.000790 44.2700n 0.000758 44.2800n 0.000711 44.2900n 0.000651 44.3000n 0.000576 44.3100n 0.000487 44.3200n 0.000385 44.3300n 0.000270 44.3400n 0.000142 44.3500n 0.000003 44.3600n -0.000146 44.3700n -0.000304 44.3800n -0.000469 44.3900n -0.000639
+ 44.4000n -0.000814 44.4100n -0.000989 44.4200n -0.001165 44.4300n -0.001337 44.4400n -0.001505 44.4500n -0.001667 44.4600n -0.001819 44.4700n -0.001960 44.4800n -0.002088 44.4900n -0.002202 44.5000n -0.002300 44.5100n -0.002380 44.5200n -0.002441 44.5300n -0.002483 44.5400n -0.002505
+ 44.5500n -0.002506 44.5600n -0.002487 44.5700n -0.002448 44.5800n -0.002389 44.5900n -0.002312 44.6000n -0.002217 44.6100n -0.002106 44.6200n -0.001980 44.6300n -0.001842 44.6400n -0.001692 44.6500n -0.001534 44.6600n -0.001369 44.6700n -0.001199 44.6800n -0.001026 44.6900n -0.000853
+ 44.7000n -0.000681 44.7100n -0.000513 44.7200n -0.000348 44.7300n -0.000190 44.7400n -0.000040 44.7500n 0.000103 44.7600n 0.000237 44.7700n 0.000361 44.7800n 0.000476 44.7900n 0.000582 44.8000n 0.000679 44.8100n 0.000767 44.8200n 0.000848 44.8300n 0.000922 44.8400n 0.000990
+ 44.8500n 0.001054 44.8600n 0.001115 44.8700n 0.001174 44.8800n 0.001232 44.8900n 0.001290 44.9000n 0.001350 44.9100n 0.001413 44.9200n 0.001479 44.9300n 0.001549 44.9400n 0.001623 44.9500n 0.001701 44.9600n 0.001784 44.9700n 0.001870 44.9800n 0.001959 44.9900n 0.002051
+ 45.0000n 0.002143 45.0100n 0.002236 45.0200n 0.002327 45.0300n 0.002414 45.0400n 0.002497 45.0500n 0.002573 45.0600n 0.002640 45.0700n 0.002697 45.0800n 0.002741 45.0900n 0.002773 45.1000n 0.002789 45.1100n 0.002789 45.1200n 0.002772 45.1300n 0.002737 45.1400n 0.002684
+ 45.1500n 0.002612 45.1600n 0.002522 45.1700n 0.002415 45.1800n 0.002292 45.1900n 0.002152 45.2000n 0.001999 45.2100n 0.001834 45.2200n 0.001658 45.2300n 0.001474 45.2400n 0.001284 45.2500n 0.001091 45.2600n 0.000897 45.2700n 0.000705 45.2800n 0.000516 45.2900n 0.000333
+ 45.3000n 0.000158 45.3100n -0.000006 45.3200n -0.000159 45.3300n -0.000299 45.3400n -0.000424 45.3500n -0.000535 45.3600n -0.000630 45.3700n -0.000710 45.3800n -0.000775 45.3900n -0.000825 45.4000n -0.000862 45.4100n -0.000887 45.4200n -0.000901 45.4300n -0.000905 45.4400n -0.000903
+ 45.4500n -0.000896 45.4600n -0.000885 45.4700n -0.000873 45.4800n -0.000863 45.4900n -0.000855 45.5000n -0.000852 45.5100n -0.000856 45.5200n -0.000867 45.5300n -0.000886 45.5400n -0.000915 45.5500n -0.000954 45.5600n -0.001003 45.5700n -0.001061 45.5800n -0.001127 45.5900n -0.001202
+ 45.6000n -0.001282 45.6100n -0.001368 45.6200n -0.001456 45.6300n -0.001545 45.6400n -0.001631 45.6500n -0.001714 45.6600n -0.001790 45.6700n -0.001857 45.6800n -0.001912 45.6900n -0.001953 45.7000n -0.001978 45.7100n -0.001985 45.7200n -0.001973 45.7300n -0.001940 45.7400n -0.001886
+ 45.7500n -0.001809 45.7600n -0.001711 45.7700n -0.001591 45.7800n -0.001451 45.7900n -0.001291 45.8000n -0.001113 45.8100n -0.000920 45.8200n -0.000714 45.8300n -0.000498 45.8400n -0.000274 45.8500n -0.000046 45.8600n 0.000183 45.8700n 0.000409 45.8800n 0.000629 45.8900n 0.000841
+ 45.9000n 0.001040 45.9100n 0.001223 45.9200n 0.001389 45.9300n 0.001534 45.9400n 0.001657 45.9500n 0.001756 45.9600n 0.001831 45.9700n 0.001879 45.9800n 0.001902 45.9900n 0.001900 46.0000n 0.001873 46.0100n 0.001823 46.0200n 0.001751 46.0300n 0.001659 46.0400n 0.001550
+ 46.0500n 0.001427 46.0600n 0.001292 46.0700n 0.001148 46.0800n 0.001000 46.0900n 0.000849 46.1000n 0.000699 46.1100n 0.000554 46.1200n 0.000415 46.1300n 0.000286 46.1400n 0.000169 46.1500n 0.000067 46.1600n -0.000020 46.1700n -0.000090 46.1800n -0.000142 46.1900n -0.000175
+ 46.2000n -0.000191 46.2100n -0.000188 46.2200n -0.000169 46.2300n -0.000135 46.2400n -0.000086 46.2500n -0.000026 46.2600n 0.000044 46.2700n 0.000120 46.2800n 0.000201 46.2900n 0.000284 46.3000n 0.000366 46.3100n 0.000443 46.3200n 0.000515 46.3300n 0.000577 46.3400n 0.000628
+ 46.3500n 0.000666 46.3600n 0.000688 46.3700n 0.000694 46.3800n 0.000682 46.3900n 0.000652 46.4000n 0.000603 46.4100n 0.000536 46.4200n 0.000450 46.4300n 0.000347 46.4400n 0.000228 46.4500n 0.000094 46.4600n -0.000052 46.4700n -0.000210 46.4800n -0.000376 46.4900n -0.000548
+ 46.5000n -0.000725 46.5100n -0.000903 46.5200n -0.001080 46.5300n -0.001253 46.5400n -0.001420 46.5500n -0.001580 46.5600n -0.001729 46.5700n -0.001867 46.5800n -0.001992 46.5900n -0.002102 46.6000n -0.002196 46.6100n -0.002274 46.6200n -0.002336 46.6300n -0.002380 46.6400n -0.002408
+ 46.6500n -0.002419 46.6600n -0.002415 46.6700n -0.002395 46.6800n -0.002362 46.6900n -0.002315 46.7000n -0.002256 46.7100n -0.002187 46.7200n -0.002109 46.7300n -0.002023 46.7400n -0.001930 46.7500n -0.001831 46.7600n -0.001728 46.7700n -0.001622 46.7800n -0.001513 46.7900n -0.001402
+ 46.8000n -0.001291 46.8100n -0.001179 46.8200n -0.001067 46.8300n -0.000956 46.8400n -0.000845 46.8500n -0.000735 46.8600n -0.000625 46.8700n -0.000516 46.8800n -0.000408 46.8900n -0.000301 46.9000n -0.000194 46.9100n -0.000088 46.9200n 0.000017 46.9300n 0.000122 46.9400n 0.000225
+ 46.9500n 0.000327 46.9600n 0.000427 46.9700n 0.000525 46.9800n 0.000619 46.9900n 0.000711 47.0000n 0.000797 47.0100n 0.000878 47.0200n 0.000954 47.0300n 0.001022 47.0400n 0.001082 47.0500n 0.001134 47.0600n 0.001176 47.0700n 0.001208 47.0800n 0.001229 47.0900n 0.001239
+ 47.1000n 0.001237 47.1100n 0.001223 47.1200n 0.001197 47.1300n 0.001160 47.1400n 0.001112 47.1500n 0.001053 47.1600n 0.000984 47.1700n 0.000907 47.1800n 0.000823 47.1900n 0.000732 47.2000n 0.000637 47.2100n 0.000539 47.2200n 0.000439 47.2300n 0.000339 47.2400n 0.000242
+ 47.2500n 0.000148 47.2600n 0.000060 47.2700n -0.000021 47.2800n -0.000095 47.2900n -0.000159 47.3000n -0.000212 47.3100n -0.000254 47.3200n -0.000284 47.3300n -0.000303 47.3400n -0.000308 47.3500n -0.000302 47.3600n -0.000285 47.3700n -0.000256 47.3800n -0.000217 47.3900n -0.000170
+ 47.4000n -0.000115 47.4100n -0.000053 47.4200n 0.000013 47.4300n 0.000081 47.4400n 0.000151 47.4500n 0.000221 47.4600n 0.000288 47.4700n 0.000352 47.4800n 0.000411 47.4900n 0.000463 47.5000n 0.000507 47.5100n 0.000542 47.5200n 0.000568 47.5300n 0.000584 47.5400n 0.000589
+ 47.5500n 0.000584 47.5600n 0.000568 47.5700n 0.000542 47.5800n 0.000506 47.5900n 0.000461 47.6000n 0.000408 47.6100n 0.000347 47.6200n 0.000281 47.6300n 0.000209 47.6400n 0.000133 47.6500n 0.000055 47.6600n -0.000025 47.6700n -0.000106 47.6800n -0.000187 47.6900n -0.000267
+ 47.7000n -0.000345 47.7100n -0.000421 47.7200n -0.000494 47.7300n -0.000565 47.7400n -0.000633 47.7500n -0.000698 47.7600n -0.000760 47.7700n -0.000821 47.7800n -0.000880 47.7900n -0.000938 47.8000n -0.000995 47.8100n -0.001052 47.8200n -0.001110 47.8300n -0.001168 47.8400n -0.001228
+ 47.8500n -0.001289 47.8600n -0.001351 47.8700n -0.001415 47.8800n -0.001479 47.8900n -0.001544 47.9000n -0.001608 47.9100n -0.001670 47.9200n -0.001729 47.9300n -0.001785 47.9400n -0.001834 47.9500n -0.001876 47.9600n -0.001909 47.9700n -0.001930 47.9800n -0.001939 47.9900n -0.001932
+ 48.0000n -0.001909 48.0100n -0.001868 48.0200n -0.001807 48.0300n -0.001726 48.0400n -0.001624 48.0500n -0.001500 48.0600n -0.001354 48.0700n -0.001187 48.0800n -0.001000 48.0900n -0.000794 48.1000n -0.000570 48.1100n -0.000331 48.1200n -0.000080 48.1300n 0.000181 48.1400n 0.000448
+ 48.1500n 0.000717 48.1600n 0.000985 48.1700n 0.001247 48.1800n 0.001500 48.1900n 0.001740 48.2000n 0.001962 48.2100n 0.002162 48.2200n 0.002337 48.2300n 0.002484 48.2400n 0.002600 48.2500n 0.002682 48.2600n 0.002730 48.2700n 0.002741 48.2800n 0.002716 48.2900n 0.002654
+ 48.3000n 0.002557 48.3100n 0.002426 48.3200n 0.002264 48.3300n 0.002073 48.3400n 0.001857 48.3500n 0.001621 48.3600n 0.001370 48.3700n 0.001107 48.3800n 0.000839 48.3900n 0.000572 48.4000n 0.000310 48.4100n 0.000060 48.4200n -0.000174 48.4300n -0.000385 48.4400n -0.000569
+ 48.4500n -0.000721 48.4600n -0.000839 48.4700n -0.000918 48.4800n -0.000957 48.4900n -0.000954 48.5000n -0.000909 48.5100n -0.000821 48.5200n -0.000693 48.5300n -0.000526 48.5400n -0.000323 48.5500n -0.000088 48.5600n 0.000174 48.5700n 0.000458 48.5800n 0.000758 48.5900n 0.001069
+ 48.6000n 0.001382 48.6100n 0.001692 48.6200n 0.001991 48.6300n 0.002272 48.6400n 0.002530 48.6500n 0.002757 48.6600n 0.002948 48.6700n 0.003098 48.6800n 0.003202 48.6900n 0.003257 48.7000n 0.003260 48.7100n 0.003209 48.7200n 0.003104 48.7300n 0.002945 48.7400n 0.002734
+ 48.7500n 0.002472 48.7600n 0.002165 48.7700n 0.001815 48.7800n 0.001428 48.7900n 0.001011 48.8000n 0.000570 48.8100n 0.000112 48.8200n -0.000356 48.8300n -0.000825 48.8400n -0.001288 48.8500n -0.001737 48.8600n -0.002165 48.8700n -0.002564 48.8800n -0.002928 48.8900n -0.003252
+ 48.9000n -0.003530 48.9100n -0.003759 48.9200n -0.003934 48.9300n -0.004055 48.9400n -0.004119 48.9500n -0.004127 48.9600n -0.004081 48.9700n -0.003982 48.9800n -0.003833 48.9900n -0.003640 49.0000n -0.003406 49.0100n -0.003138 49.0200n -0.002841 49.0300n -0.002523 49.0400n -0.002191
+ 49.0500n -0.001852 49.0600n -0.001513 49.0700n -0.001182 49.0800n -0.000866 49.0900n -0.000570 49.1000n -0.000301 49.1100n -0.000063 49.1200n 0.000138 49.1300n 0.000299 49.1400n 0.000417 49.1500n 0.000492 49.1600n 0.000523 49.1700n 0.000509 49.1800n 0.000453 49.1900n 0.000357
+ 49.2000n 0.000224 49.2100n 0.000058 49.2200n -0.000135 49.2300n -0.000351 49.2400n -0.000583 49.2500n -0.000826 49.2600n -0.001073 49.2700n -0.001317 49.2800n -0.001552 49.2900n -0.001773 49.3000n -0.001973 49.3100n -0.002147 49.3200n -0.002291 49.3300n -0.002400 49.3400n -0.002473
+ 49.3500n -0.002506 49.3600n -0.002499 49.3700n -0.002450 49.3800n -0.002361 49.3900n -0.002233 49.4000n -0.002069 49.4100n -0.001871 49.4200n -0.001643 49.4300n -0.001390 49.4400n -0.001117 49.4500n -0.000829 49.4600n -0.000532 49.4700n -0.000232 49.4800n 0.000065 49.4900n 0.000354
+ 49.5000n 0.000629 49.5100n 0.000885 49.5200n 0.001117 49.5300n 0.001321 49.5400n 0.001494 49.5500n 0.001633 49.5600n 0.001736 49.5700n 0.001802 49.5800n 0.001830 49.5900n 0.001821 49.6000n 0.001777 49.6100n 0.001698 49.6200n 0.001589 49.6300n 0.001451 49.6400n 0.001290
+ 49.6500n 0.001109 49.6600n 0.000913 49.6700n 0.000707 49.6800n 0.000495 49.6900n 0.000282 49.7000n 0.000074 49.7100n -0.000126 49.7200n -0.000314 49.7300n -0.000485 49.7400n -0.000637 49.7500n -0.000767 49.7600n -0.000874 49.7700n -0.000956 49.7800n -0.001012 49.7900n -0.001043
+ 49.8000n -0.001050 49.8100n -0.001034 49.8200n -0.000997 49.8300n -0.000942 49.8400n -0.000871 49.8500n -0.000789 49.8600n -0.000698 49.8700n -0.000603 49.8800n -0.000507 49.8900n -0.000414 49.9000n -0.000327 49.9100n -0.000251 49.9200n -0.000188 49.9300n -0.000141 49.9400n -0.000112
+ 49.9500n -0.000102 49.9600n -0.000113 49.9700n -0.000144 49.9800n -0.000196 49.9900n -0.000268 50.0000n -0.000357 50.0100n -0.000463 50.0200n -0.000583 50.0300n -0.000713 50.0400n -0.000851 50.0500n -0.000992 50.0600n -0.001133 50.0700n -0.001270 50.0800n -0.001399 50.0900n -0.001517
+ 50.1000n -0.001619 50.1100n -0.001702 50.1200n -0.001764 50.1300n -0.001802 50.1400n -0.001815 50.1500n -0.001801 50.1600n -0.001759 50.1700n -0.001690 50.1800n -0.001594 50.1900n -0.001473 50.2000n -0.001329 50.2100n -0.001165 50.2200n -0.000983 50.2300n -0.000787 50.2400n -0.000582
+ 50.2500n -0.000371 50.2600n -0.000159 50.2700n 0.000048 50.2800n 0.000247 50.2900n 0.000433 50.3000n 0.000602 50.3100n 0.000749 50.3200n 0.000871 50.3300n 0.000965 50.3400n 0.001028 50.3500n 0.001059 50.3600n 0.001056 50.3700n 0.001019 50.3800n 0.000948 50.3900n 0.000844
+ 50.4000n 0.000709 50.4100n 0.000545 50.4200n 0.000355 50.4300n 0.000143 50.4400n -0.000088 50.4500n -0.000332 50.4600n -0.000585 50.4700n -0.000842 50.4800n -0.001098 50.4900n -0.001348 50.5000n -0.001586 50.5100n -0.001809 50.5200n -0.002011 50.5300n -0.002188 50.5400n -0.002338
+ 50.5500n -0.002456 50.5600n -0.002541 50.5700n -0.002592 50.5800n -0.002606 50.5900n -0.002584 50.6000n -0.002527 50.6100n -0.002435 50.6200n -0.002310 50.6300n -0.002155 50.6400n -0.001973 50.6500n -0.001768 50.6600n -0.001542 50.6700n -0.001301 50.6800n -0.001049 50.6900n -0.000790
+ 50.7000n -0.000529 50.7100n -0.000270 50.7200n -0.000019 50.7300n 0.000222 50.7400n 0.000449 50.7500n 0.000658 50.7600n 0.000846 50.7700n 0.001012 50.7800n 0.001153 50.7900n 0.001268 50.8000n 0.001358 50.8100n 0.001422 50.8200n 0.001460 50.8300n 0.001474 50.8400n 0.001466
+ 50.8500n 0.001438 50.8600n 0.001392 50.8700n 0.001331 50.8800n 0.001258 50.8900n 0.001176 50.9000n 0.001089 50.9100n 0.000998 50.9200n 0.000909 50.9300n 0.000822 50.9400n 0.000741 50.9500n 0.000669 50.9600n 0.000605 50.9700n 0.000553 50.9800n 0.000513 50.9900n 0.000485
+ 51.0000n 0.000470 51.0100n 0.000466 51.0200n 0.000473 51.0300n 0.000490 51.0400n 0.000514 51.0500n 0.000543 51.0600n 0.000575 51.0700n 0.000608 51.0800n 0.000638 51.0900n 0.000663 51.1000n 0.000680 51.1100n 0.000686 51.1200n 0.000680 51.1300n 0.000658 51.1400n 0.000619
+ 51.1500n 0.000561 51.1600n 0.000484 51.1700n 0.000386 51.1800n 0.000268 51.1900n 0.000130 51.2000n -0.000028 51.2100n -0.000204 51.2200n -0.000396 51.2300n -0.000602 51.2400n -0.000819 51.2500n -0.001044 51.2600n -0.001274 51.2700n -0.001506 51.2800n -0.001736 51.2900n -0.001960
+ 51.3000n -0.002175 51.3100n -0.002377 51.3200n -0.002564 51.3300n -0.002731 51.3400n -0.002876 51.3500n -0.002997 51.3600n -0.003092 51.3700n -0.003159 51.3800n -0.003198 51.3900n -0.003209 51.4000n -0.003191 51.4100n -0.003145 51.4200n -0.003072 51.4300n -0.002974 51.4400n -0.002854
+ 51.4500n -0.002714 51.4600n -0.002556 51.4700n -0.002384 51.4800n -0.002202 51.4900n -0.002012 51.5000n -0.001819 51.5100n -0.001626 51.5200n -0.001437 51.5300n -0.001254 51.5400n -0.001082 51.5500n -0.000922 51.5600n -0.000777 51.5700n -0.000649 51.5800n -0.000540 51.5900n -0.000451
+ 51.6000n -0.000382 51.6100n -0.000334 51.6200n -0.000305 51.6300n -0.000297 51.6400n -0.000306 51.6500n -0.000331 51.6600n -0.000371 51.6700n -0.000423 51.6800n -0.000484 51.6900n -0.000551 51.7000n -0.000622 51.7100n -0.000694 51.7200n -0.000763 51.7300n -0.000827 51.7400n -0.000883
+ 51.7500n -0.000929 51.7600n -0.000962 51.7700n -0.000980 51.7800n -0.000981 51.7900n -0.000965 51.8000n -0.000931 51.8100n -0.000878 51.8200n -0.000806 51.8300n -0.000716 51.8400n -0.000608 51.8500n -0.000484 51.8600n -0.000346 51.8700n -0.000194 51.8800n -0.000031 51.8900n 0.000140
+ 51.9000n 0.000317 51.9100n 0.000498 51.9200n 0.000680 51.9300n 0.000860 51.9400n 0.001036 51.9500n 0.001205 51.9600n 0.001366 51.9700n 0.001516 51.9800n 0.001653 51.9900n 0.001776 52.0000n 0.001884 52.0100n 0.001975 52.0200n 0.002050 52.0300n 0.002108 52.0400n 0.002149
+ 52.0500n 0.002173 52.0600n 0.002181 52.0700n 0.002175 52.0800n 0.002154 52.0900n 0.002121 52.1000n 0.002076 52.1100n 0.002022 52.1200n 0.001959 52.1300n 0.001891 52.1400n 0.001817 52.1500n 0.001741 52.1600n 0.001662 52.1700n 0.001584 52.1800n 0.001506 52.1900n 0.001430
+ 52.2000n 0.001356 52.2100n 0.001286 52.2200n 0.001220 52.2300n 0.001157 52.2400n 0.001098 52.2500n 0.001044 52.2600n 0.000992 52.2700n 0.000944 52.2800n 0.000897 52.2900n 0.000853 52.3000n 0.000808 52.3100n 0.000764 52.3200n 0.000718 52.3300n 0.000670 52.3400n 0.000619
+ 52.3500n 0.000565 52.3600n 0.000506 52.3700n 0.000442 52.3800n 0.000372 52.3900n 0.000296 52.4000n 0.000215 52.4100n 0.000127 52.4200n 0.000033 52.4300n -0.000066 52.4400n -0.000170 52.4500n -0.000279 52.4600n -0.000392 52.4700n -0.000507 52.4800n -0.000625 52.4900n -0.000743
+ 52.5000n -0.000861 52.5100n -0.000979 52.5200n -0.001093 52.5300n -0.001205 52.5400n -0.001312 52.5500n -0.001413 52.5600n -0.001509 52.5700n -0.001597 52.5800n -0.001677 52.5900n -0.001748 52.6000n -0.001811 52.6100n -0.001864 52.6200n -0.001908 52.6300n -0.001942 52.6400n -0.001966
+ 52.6500n -0.001980 52.6600n -0.001985 52.6700n -0.001980 52.6800n -0.001967 52.6900n -0.001945 52.7000n -0.001915 52.7100n -0.001877 52.7200n -0.001833 52.7300n -0.001782 52.7400n -0.001725 52.7500n -0.001662 52.7600n -0.001595 52.7700n -0.001524 52.7800n -0.001449 52.7900n -0.001371
+ 52.8000n -0.001290 52.8100n -0.001206 52.8200n -0.001122 52.8300n -0.001036 52.8400n -0.000949 52.8500n -0.000862 52.8600n -0.000775 52.8700n -0.000689 52.8800n -0.000604 52.8900n -0.000522 52.9000n -0.000442 52.9100n -0.000365 52.9200n -0.000293 52.9300n -0.000225 52.9400n -0.000162
+ 52.9500n -0.000106 52.9600n -0.000056 52.9700n -0.000014 52.9800n 0.000020 52.9900n 0.000045 53.0000n 0.000061 53.0100n 0.000067 53.0200n 0.000063 53.0300n 0.000049 53.0400n 0.000024 53.0500n -0.000011 53.0600n -0.000057 53.0700n -0.000112 53.0800n -0.000177 53.0900n -0.000250
+ 53.1000n -0.000330 53.1100n -0.000417 53.1200n -0.000509 53.1300n -0.000605 53.1400n -0.000703 53.1500n -0.000801 53.1600n -0.000898 53.1700n -0.000991 53.1800n -0.001079 53.1900n -0.001160 53.2000n -0.001232 53.2100n -0.001294 53.2200n -0.001342 53.2300n -0.001377 53.2400n -0.001397
+ 53.2500n -0.001400 53.2600n -0.001386 53.2700n -0.001354 53.2800n -0.001303 53.2900n -0.001235 53.3000n -0.001148 53.3100n -0.001044 53.3200n -0.000924 53.3300n -0.000789 53.3400n -0.000640 53.3500n -0.000480 53.3600n -0.000310 53.3700n -0.000133 53.3800n 0.000049 53.3900n 0.000233
+ 53.4000n 0.000417 53.4100n 0.000597 53.4200n 0.000772 53.4300n 0.000937 53.4400n 0.001091 53.4500n 0.001232 53.4600n 0.001357 53.4700n 0.001463 53.4800n 0.001551 53.4900n 0.001617 53.5000n 0.001662 53.5100n 0.001683 53.5200n 0.001683 53.5300n 0.001659 53.5400n 0.001614
+ 53.5500n 0.001547 53.5600n 0.001460 53.5700n 0.001355 53.5800n 0.001234 53.5900n 0.001098 53.6000n 0.000950 53.6100n 0.000794 53.6200n 0.000630 53.6300n 0.000463 53.6400n 0.000295 53.6500n 0.000130 53.6600n -0.000032 53.6700n -0.000185 53.6800n -0.000330 53.6900n -0.000462
+ 53.7000n -0.000580 53.7100n -0.000683 53.7200n -0.000769 53.7300n -0.000837 53.7400n -0.000886 53.7500n -0.000917 53.7600n -0.000929 53.7700n -0.000923 53.7800n -0.000900 53.7900n -0.000860 53.8000n -0.000806 53.8100n -0.000738 53.8200n -0.000659 53.8300n -0.000570 53.8400n -0.000475
+ 53.8500n -0.000374 53.8600n -0.000271 53.8700n -0.000167 53.8800n -0.000065 53.8900n 0.000033 53.9000n 0.000125 53.9100n 0.000209 53.9200n 0.000285 53.9300n 0.000349 53.9400n 0.000403 53.9500n 0.000444 53.9600n 0.000472 53.9700n 0.000487 53.9800n 0.000490 53.9900n 0.000480
+ 54.0000n 0.000458 54.0100n 0.000424 54.0200n 0.000381 54.0300n 0.000329 54.0400n 0.000269 54.0500n 0.000204 54.0600n 0.000134 54.0700n 0.000062 54.0800n -0.000012 54.0900n -0.000085 54.1000n -0.000156 54.1100n -0.000223 54.1200n -0.000286 54.1300n -0.000343 54.1400n -0.000392
+ 54.1500n -0.000433 54.1600n -0.000466 54.1700n -0.000490 54.1800n -0.000505 54.1900n -0.000510 54.2000n -0.000505 54.2100n -0.000492 54.2200n -0.000470 54.2300n -0.000439 54.2400n -0.000402 54.2500n -0.000357 54.2600n -0.000307 54.2700n -0.000252 54.2800n -0.000193 54.2900n -0.000132
+ 54.3000n -0.000068 54.3100n -0.000003 54.3200n 0.000063 54.3300n 0.000127 54.3400n 0.000191 54.3500n 0.000253 54.3600n 0.000313 54.3700n 0.000370 54.3800n 0.000424 54.3900n 0.000474 54.4000n 0.000522 54.4100n 0.000566 54.4200n 0.000606 54.4300n 0.000643 54.4400n 0.000677
+ 54.4500n 0.000708 54.4600n 0.000736 54.4700n 0.000761 54.4800n 0.000783 54.4900n 0.000803 54.5000n 0.000821 54.5100n 0.000837 54.5200n 0.000851 54.5300n 0.000862 54.5400n 0.000871 54.5500n 0.000879 54.5600n 0.000883 54.5700n 0.000886 54.5800n 0.000886 54.5900n 0.000884
+ 54.6000n 0.000879 54.6100n 0.000871 54.6200n 0.000860 54.6300n 0.000846 54.6400n 0.000829 54.6500n 0.000809 54.6600n 0.000786 54.6700n 0.000761 54.6800n 0.000733 54.6900n 0.000703 54.7000n 0.000671 54.7100n 0.000638 54.7200n 0.000605 54.7300n 0.000571 54.7400n 0.000538
+ 54.7500n 0.000507 54.7600n 0.000478 54.7700n 0.000451 54.7800n 0.000428 54.7900n 0.000410 54.8000n 0.000397 54.8100n 0.000389 54.8200n 0.000387 54.8300n 0.000392 54.8400n 0.000404 54.8500n 0.000422 54.8600n 0.000448 54.8700n 0.000481 54.8800n 0.000520 54.8900n 0.000565
+ 54.9000n 0.000616 54.9100n 0.000672 54.9200n 0.000732 54.9300n 0.000795 54.9400n 0.000860 54.9500n 0.000925 54.9600n 0.000991 54.9700n 0.001054 54.9800n 0.001115 54.9900n 0.001172 55.0000n 0.001223 55.0100n 0.001268 55.0200n 0.001305 55.0300n 0.001335 55.0400n 0.001355
+ 55.0500n 0.001365 55.0600n 0.001366 55.0700n 0.001357 55.0800n 0.001337 55.0900n 0.001308 55.1000n 0.001269 55.1100n 0.001222 55.1200n 0.001167 55.1300n 0.001105 55.1400n 0.001037 55.1500n 0.000965 55.1600n 0.000890 55.1700n 0.000813 55.1800n 0.000737 55.1900n 0.000662
+ 55.2000n 0.000590 55.2100n 0.000522 55.2200n 0.000461 55.2300n 0.000407 55.2400n 0.000362 55.2500n 0.000326 55.2600n 0.000300 55.2700n 0.000285 55.2800n 0.000280 55.2900n 0.000287 55.3000n 0.000306 55.3100n 0.000334 55.3200n 0.000373 55.3300n 0.000421 55.3400n 0.000477
+ 55.3500n 0.000541 55.3600n 0.000610 55.3700n 0.000683 55.3800n 0.000759 55.3900n 0.000835 55.4000n 0.000911 55.4100n 0.000984 55.4200n 0.001053 55.4300n 0.001116 55.4400n 0.001172 55.4500n 0.001220 55.4600n 0.001257 55.4700n 0.001283 55.4800n 0.001297 55.4900n 0.001299
+ 55.5000n 0.001288 55.5100n 0.001264 55.5200n 0.001227 55.5300n 0.001177 55.5400n 0.001115 55.5500n 0.001041 55.5600n 0.000956 55.5700n 0.000862 55.5800n 0.000759 55.5900n 0.000649 55.6000n 0.000533 55.6100n 0.000413 55.6200n 0.000291 55.6300n 0.000167 55.6400n 0.000044
+ 55.6500n -0.000077 55.6600n -0.000194 55.6700n -0.000307 55.6800n -0.000414 55.6900n -0.000513 55.7000n -0.000604 55.7100n -0.000687 55.7200n -0.000759 55.7300n -0.000821 55.7400n -0.000872 55.7500n -0.000912 55.7600n -0.000941 55.7700n -0.000959 55.7800n -0.000965 55.7900n -0.000961
+ 55.8000n -0.000946 55.8100n -0.000921 55.8200n -0.000886 55.8300n -0.000842 55.8400n -0.000789 55.8500n -0.000728 55.8600n -0.000659 55.8700n -0.000584 55.8800n -0.000502 55.8900n -0.000414 55.9000n -0.000321 55.9100n -0.000224 55.9200n -0.000122 55.9300n -0.000017 55.9400n 0.000092
+ 55.9500n 0.000203 55.9600n 0.000316 55.9700n 0.000430 55.9800n 0.000545 55.9900n 0.000661 56.0000n 0.000776 56.0100n 0.000889 56.0200n 0.001001 56.0300n 0.001110 56.0400n 0.001216 56.0500n 0.001317 56.0600n 0.001412 56.0700n 0.001501 56.0800n 0.001583 56.0900n 0.001657
+ 56.1000n 0.001721 56.1100n 0.001776 56.1200n 0.001819 56.1300n 0.001850 56.1400n 0.001868 56.1500n 0.001873 56.1600n 0.001863 56.1700n 0.001840 56.1800n 0.001801 56.1900n 0.001748 56.2000n 0.001681 56.2100n 0.001598 56.2200n 0.001502 56.2300n 0.001392 56.2400n 0.001270
+ 56.2500n 0.001137 56.2600n 0.000993 56.2700n 0.000840 56.2800n 0.000680 56.2900n 0.000513 56.3000n 0.000343 56.3100n 0.000170 56.3200n -0.000003 56.3300n -0.000176 56.3400n -0.000346 56.3500n -0.000511 56.3600n -0.000670 56.3700n -0.000822 56.3800n -0.000965 56.3900n -0.001098
+ 56.4000n -0.001221 56.4100n -0.001333 56.4200n -0.001433 56.4300n -0.001521 56.4400n -0.001597 56.4500n -0.001662 56.4600n -0.001716 56.4700n -0.001760 56.4800n -0.001795 56.4900n -0.001821 56.5000n -0.001841 56.5100n -0.001855 56.5200n -0.001865 56.5300n -0.001873 56.5400n -0.001879
+ 56.5500n -0.001885 56.5600n -0.001892 56.5700n -0.001901 56.5800n -0.001914 56.5900n -0.001931 56.6000n -0.001953 56.6100n -0.001979 56.6200n -0.002010 56.6300n -0.002045 56.6400n -0.002084 56.6500n -0.002126 56.6600n -0.002170 56.6700n -0.002215 56.6800n -0.002259 56.6900n -0.002301
+ 56.7000n -0.002338 56.7100n -0.002368 56.7200n -0.002390 56.7300n -0.002402 56.7400n -0.002402 56.7500n -0.002388 56.7600n -0.002358 56.7700n -0.002310 56.7800n -0.002245 56.7900n -0.002160 56.8000n -0.002055 56.8100n -0.001930 56.8200n -0.001785 56.8300n -0.001621 56.8400n -0.001439
+ 56.8500n -0.001240 56.8600n -0.001026 56.8700n -0.000798 56.8800n -0.000561 56.8900n -0.000316 56.9000n -0.000066 56.9100n 0.000185 56.9200n 0.000434 56.9300n 0.000677 56.9400n 0.000911 56.9500n 0.001133 56.9600n 0.001338 56.9700n 0.001524 56.9800n 0.001688 56.9900n 0.001828
+ 57.0000n 0.001941 57.0100n 0.002025 57.0200n 0.002080 57.0300n 0.002104 57.0400n 0.002096 57.0500n 0.002059 57.0600n 0.001991 57.0700n 0.001895 57.0800n 0.001773 57.0900n 0.001626 57.1000n 0.001458 57.1100n 0.001272 57.1200n 0.001071 57.1300n 0.000860 57.1400n 0.000642
+ 57.1500n 0.000422 57.1600n 0.000204 57.1700n -0.000008 57.1800n -0.000210 57.1900n -0.000397 57.2000n -0.000567 57.2100n -0.000715 57.2200n -0.000840 57.2300n -0.000937 57.2400n -0.001006 57.2500n -0.001045 57.2600n -0.001054 57.2700n -0.001030 57.2800n -0.000977 57.2900n -0.000893
+ 57.3000n -0.000781 57.3100n -0.000642 57.3200n -0.000480 57.3300n -0.000297 57.3400n -0.000096 57.3500n 0.000118 57.3600n 0.000343 57.3700n 0.000573 57.3800n 0.000804 57.3900n 0.001033 57.4000n 0.001255 57.4100n 0.001465 57.4200n 0.001661 57.4300n 0.001839 57.4400n 0.001996
+ 57.4500n 0.002128 57.4600n 0.002234 57.4700n 0.002311 57.4800n 0.002360 57.4900n 0.002378 57.5000n 0.002367 57.5100n 0.002326 57.5200n 0.002256 57.5300n 0.002159 57.5400n 0.002037 57.5500n 0.001893 57.5600n 0.001728 57.5700n 0.001548 57.5800n 0.001354 57.5900n 0.001150
+ 57.6000n 0.000941 57.6100n 0.000730 57.6200n 0.000521 57.6300n 0.000318 57.6400n 0.000123 57.6500n -0.000058 57.6600n -0.000224 57.6700n -0.000372 57.6800n -0.000498 57.6900n -0.000602 57.7000n -0.000682 57.7100n -0.000736 57.7200n -0.000765 57.7300n -0.000766 57.7400n -0.000742
+ 57.7500n -0.000693 57.7600n -0.000619 57.7700n -0.000523 57.7800n -0.000406 57.7900n -0.000270 57.8000n -0.000118 57.8100n 0.000048 57.8200n 0.000226 57.8300n 0.000411 57.8400n 0.000602 57.8500n 0.000796 57.8600n 0.000990 57.8700n 0.001181 57.8800n 0.001366 57.8900n 0.001544
+ 57.9000n 0.001712 57.9100n 0.001869 57.9200n 0.002012 57.9300n 0.002141 57.9400n 0.002255 57.9500n 0.002352 57.9600n 0.002432 57.9700n 0.002496 57.9800n 0.002543 57.9900n 0.002574 58.0000n 0.002589 58.0100n 0.002588 58.0200n 0.002574 58.0300n 0.002547 58.0400n 0.002508
+ 58.0500n 0.002459 58.0600n 0.002400 58.0700n 0.002334 58.0800n 0.002262 58.0900n 0.002184 58.1000n 0.002103 58.1100n 0.002020 58.1200n 0.001935 58.1300n 0.001850 58.1400n 0.001765 58.1500n 0.001682 58.1600n 0.001601 58.1700n 0.001522 58.1800n 0.001446 58.1900n 0.001374
+ 58.2000n 0.001304 58.2100n 0.001239 58.2200n 0.001176 58.2300n 0.001116 58.2400n 0.001060 58.2500n 0.001005 58.2600n 0.000953 58.2700n 0.000902 58.2800n 0.000852 58.2900n 0.000803 58.3000n 0.000754 58.3100n 0.000705 58.3200n 0.000654 58.3300n 0.000602 58.3400n 0.000548
+ 58.3500n 0.000492 58.3600n 0.000433 58.3700n 0.000371 58.3800n 0.000306 58.3900n 0.000238 58.4000n 0.000165 58.4100n 0.000090 58.4200n 0.000010 58.4300n -0.000072 58.4400n -0.000158 58.4500n -0.000246 58.4600n -0.000337 58.4700n -0.000430 58.4800n -0.000525 58.4900n -0.000619
+ 58.5000n -0.000714 58.5100n -0.000807 58.5200n -0.000899 58.5300n -0.000987 58.5400n -0.001072 58.5500n -0.001151 58.5600n -0.001223 58.5700n -0.001288 58.5800n -0.001344 58.5900n -0.001389 58.6000n -0.001424 58.6100n -0.001446 58.6200n -0.001454 58.6300n -0.001448 58.6400n -0.001427
+ 58.6500n -0.001390 58.6600n -0.001337 58.6700n -0.001267 58.6800n -0.001180 58.6900n -0.001076 58.7000n -0.000955 58.7100n -0.000820 58.7200n -0.000669 58.7300n -0.000504 58.7400n -0.000327 58.7500n -0.000139 58.7600n 0.000058 58.7700n 0.000261 58.7800n 0.000469 58.7900n 0.000679
+ 58.8000n 0.000889 58.8100n 0.001095 58.8200n 0.001296 58.8300n 0.001487 58.8400n 0.001668 58.8500n 0.001834 58.8600n 0.001984 58.8700n 0.002115 58.8800n 0.002226 58.8900n 0.002313 58.9000n 0.002377 58.9100n 0.002415 58.9200n 0.002428 58.9300n 0.002414 58.9400n 0.002374
+ 58.9500n 0.002309 58.9600n 0.002220 58.9700n 0.002107 58.9800n 0.001974 58.9900n 0.001822 59.0000n 0.001654 59.0100n 0.001472 59.0200n 0.001282 59.0300n 0.001084 59.0400n 0.000885 59.0500n 0.000686 59.0600n 0.000493 59.0700n 0.000308 59.0800n 0.000135 59.0900n -0.000022
+ 59.1000n -0.000160 59.1100n -0.000276 59.1200n -0.000369 59.1300n -0.000435 59.1400n -0.000474 59.1500n -0.000485 59.1600n -0.000467 59.1700n -0.000420 59.1800n -0.000346 59.1900n -0.000246 59.2000n -0.000121 59.2100n 0.000025 59.2200n 0.000191 59.2300n 0.000371 59.2400n 0.000564
+ 59.2500n 0.000764 59.2600n 0.000968 59.2700n 0.001171 59.2800n 0.001368 59.2900n 0.001555 59.3000n 0.001729 59.3100n 0.001884 59.3200n 0.002018 59.3300n 0.002127 59.3400n 0.002207 59.3500n 0.002258 59.3600n 0.002277 59.3700n 0.002263 59.3800n 0.002216 59.3900n 0.002135
+ 59.4000n 0.002023 59.4100n 0.001880 59.4200n 0.001709 59.4300n 0.001512 59.4400n 0.001294 59.4500n 0.001057 59.4600n 0.000807 59.4700n 0.000547 59.4800n 0.000283 59.4900n 0.000019 59.5000n -0.000239 59.5100n -0.000487 59.5200n -0.000720 59.5300n -0.000933 59.5400n -0.001124
+ 59.5500n -0.001287 59.5600n -0.001421 59.5700n -0.001523 59.5800n -0.001591 59.5900n -0.001623 59.6000n -0.001621 59.6100n -0.001584 59.6200n -0.001513 59.6300n -0.001411 59.6400n -0.001280 59.6500n -0.001123 59.6600n -0.000943 59.6700n -0.000746 59.6800n -0.000535 59.6900n -0.000315
+ 59.7000n -0.000091 59.7100n 0.000131 59.7200n 0.000346 59.7300n 0.000551 59.7400n 0.000740 59.7500n 0.000908 59.7600n 0.001053 59.7700n 0.001170 59.7800n 0.001258 59.7900n 0.001315 59.8000n 0.001338 59.8100n 0.001328 59.8200n 0.001284 59.8300n 0.001208 59.8400n 0.001102
+ 59.8500n 0.000968 59.8600n 0.000809 59.8700n 0.000628 59.8800n 0.000430 59.8900n 0.000220 59.9000n 0.000001 59.9100n -0.000220 59.9200n -0.000440 59.9300n -0.000652 59.9400n -0.000852 59.9500n -0.001036 59.9600n -0.001199 59.9700n -0.001336 59.9800n -0.001446 59.9900n -0.001525
+ 60.0000n -0.001571 60.0100n -0.001583 60.0200n -0.001560 60.0300n -0.001503 60.0400n -0.001413 60.0500n -0.001291 60.0600n -0.001141 60.0700n -0.000964 60.0800n -0.000766 60.0900n -0.000550 60.1000n -0.000320 60.1100n -0.000082 60.1200n 0.000159 60.1300n 0.000398 60.1400n 0.000629
+ 60.1500n 0.000848 60.1600n 0.001049 60.1700n 0.001228 60.1800n 0.001381 60.1900n 0.001505 60.2000n 0.001596 60.2100n 0.001651 60.2200n 0.001671 60.2300n 0.001653 60.2400n 0.001597 60.2500n 0.001505 60.2600n 0.001378 60.2700n 0.001217 60.2800n 0.001026 60.2900n 0.000808
+ 60.3000n 0.000568 60.3100n 0.000308 60.3200n 0.000035 60.3300n -0.000247 60.3400n -0.000533 60.3500n -0.000817 60.3600n -0.001096 60.3700n -0.001363 60.3800n -0.001614 60.3900n -0.001846 60.4000n -0.002054 60.4100n -0.002235 60.4200n -0.002386 60.4300n -0.002507 60.4400n -0.002594
+ 60.4500n -0.002648 60.4600n -0.002670 60.4700n -0.002658 60.4800n -0.002616 60.4900n -0.002544 60.5000n -0.002445 60.5100n -0.002323 60.5200n -0.002181 60.5300n -0.002021 60.5400n -0.001849 60.5500n -0.001667 60.5600n -0.001481 60.5700n -0.001293 60.5800n -0.001108 60.5900n -0.000929
+ 60.6000n -0.000760 60.6100n -0.000603 60.6200n -0.000460 60.6300n -0.000334 60.6400n -0.000226 60.6500n -0.000137 60.6600n -0.000066 60.6700n -0.000015 60.6800n 0.000019 60.6900n 0.000036 60.7000n 0.000038 60.7100n 0.000027 60.7200n 0.000005 60.7300n -0.000025 60.7400n -0.000060
+ 60.7500n -0.000098 60.7600n -0.000135 60.7700n -0.000169 60.7800n -0.000197 60.7900n -0.000218 60.8000n -0.000228 60.8100n -0.000226 60.8200n -0.000211 60.8300n -0.000181 60.8400n -0.000137 60.8500n -0.000079 60.8600n -0.000006 60.8700n 0.000079 60.8800n 0.000176 60.8900n 0.000283
+ 60.9000n 0.000397 60.9100n 0.000517 60.9200n 0.000638 60.9300n 0.000759 60.9400n 0.000875 60.9500n 0.000985 60.9600n 0.001085 60.9700n 0.001171 60.9800n 0.001243 60.9900n 0.001296 61.0000n 0.001328 61.0100n 0.001339 61.0200n 0.001327 61.0300n 0.001291 61.0400n 0.001230
+ 61.0500n 0.001146 61.0600n 0.001038 61.0700n 0.000908 61.0800n 0.000757 61.0900n 0.000588 61.1000n 0.000404 61.1100n 0.000206 61.1200n -0.000001 61.1300n -0.000215 61.1400n -0.000432 61.1500n -0.000648 61.1600n -0.000860 61.1700n -0.001065 61.1800n -0.001258 61.1900n -0.001438
+ 61.2000n -0.001601 61.2100n -0.001745 61.2200n -0.001868 61.2300n -0.001968 61.2400n -0.002045 61.2500n -0.002098 61.2600n -0.002127 61.2700n -0.002132 61.2800n -0.002115 61.2900n -0.002076 61.3000n -0.002018 61.3100n -0.001943 61.3200n -0.001853 61.3300n -0.001751 61.3400n -0.001639
+ 61.3500n -0.001522 61.3600n -0.001401 61.3700n -0.001280 61.3800n -0.001162 61.3900n -0.001050 61.4000n -0.000945 61.4100n -0.000851 61.4200n -0.000769 61.4300n -0.000701 61.4400n -0.000647 61.4500n -0.000609 61.4600n -0.000587 61.4700n -0.000580 61.4800n -0.000588 61.4900n -0.000611
+ 61.5000n -0.000645 61.5100n -0.000691 61.5200n -0.000746 61.5300n -0.000808 61.5400n -0.000874 61.5500n -0.000942 61.5600n -0.001011 61.5700n -0.001076 61.5800n -0.001137 61.5900n -0.001190 61.6000n -0.001235 61.6100n -0.001268 61.6200n -0.001289 61.6300n -0.001297 61.6400n -0.001290
+ 61.6500n -0.001269 61.6600n -0.001234 61.6700n -0.001184 61.6800n -0.001120 61.6900n -0.001045 61.7000n -0.000958 61.7100n -0.000861 61.7200n -0.000757 61.7300n -0.000647 61.7400n -0.000534 61.7500n -0.000420 61.7600n -0.000306 61.7700n -0.000196 61.7800n -0.000091 61.7900n 0.000006
+ 61.8000n 0.000094 61.8100n 0.000172 61.8200n 0.000238 61.8300n 0.000291 61.8400n 0.000330 61.8500n 0.000356 61.8600n 0.000368 61.8700n 0.000367 61.8800n 0.000353 61.8900n 0.000328 61.9000n 0.000292 61.9100n 0.000247 61.9200n 0.000195 61.9300n 0.000138 61.9400n 0.000078
+ 61.9500n 0.000016 61.9600n -0.000045 61.9700n -0.000103 61.9800n -0.000156 61.9900n -0.000202 62.0000n -0.000241 62.0100n -0.000270 62.0200n -0.000288 62.0300n -0.000294 62.0400n -0.000288 62.0500n -0.000269 62.0600n -0.000237 62.0700n -0.000193 62.0800n -0.000137 62.0900n -0.000069
+ 62.1000n 0.000009 62.1100n 0.000096 62.1200n 0.000191 62.1300n 0.000292 62.1400n 0.000398 62.1500n 0.000508 62.1600n 0.000619 62.1700n 0.000731 62.1800n 0.000841 62.1900n 0.000949 62.2000n 0.001053 62.2100n 0.001151 62.2200n 0.001245 62.2300n 0.001331 62.2400n 0.001411
+ 62.2500n 0.001483 62.2600n 0.001548 62.2700n 0.001605 62.2800n 0.001656 62.2900n 0.001700 62.3000n 0.001738 62.3100n 0.001770 62.3200n 0.001798 62.3300n 0.001822 62.3400n 0.001842 62.3500n 0.001859 62.3600n 0.001874 62.3700n 0.001887 62.3800n 0.001899 62.3900n 0.001909
+ 62.4000n 0.001918 62.4100n 0.001926 62.4200n 0.001932 62.4300n 0.001935 62.4400n 0.001936 62.4500n 0.001933 62.4600n 0.001925 62.4700n 0.001911 62.4800n 0.001890 62.4900n 0.001861 62.5000n 0.001824 62.5100n 0.001776 62.5200n 0.001716 62.5300n 0.001645 62.5400n 0.001561
+ 62.5500n 0.001464 62.5600n 0.001354 62.5700n 0.001230 62.5800n 0.001093 62.5900n 0.000944 62.6000n 0.000784 62.6100n 0.000613 62.6200n 0.000433 62.6300n 0.000247 62.6400n 0.000056 62.6500n -0.000138 62.6600n -0.000332 62.6700n -0.000523 62.6800n -0.000709 62.6900n -0.000887
+ 62.7000n -0.001054 62.7100n -0.001208 62.7200n -0.001346 62.7300n -0.001466 62.7400n -0.001565 62.7500n -0.001643 62.7600n -0.001698 62.7700n -0.001728 62.7800n -0.001734 62.7900n -0.001714 62.8000n -0.001670 62.8100n -0.001603 62.8200n -0.001512 62.8300n -0.001401 62.8400n -0.001270
+ 62.8500n -0.001124 62.8600n -0.000963 62.8700n -0.000792 62.8800n -0.000613 62.8900n -0.000430 62.9000n -0.000247 62.9100n -0.000066 62.9200n 0.000108 62.9300n 0.000273 62.9400n 0.000425 62.9500n 0.000562 62.9600n 0.000681 62.9700n 0.000779 62.9800n 0.000857 62.9900n 0.000911
+ 63.0000n 0.000941 63.0100n 0.000948 63.0200n 0.000930 63.0300n 0.000890 63.0400n 0.000827 63.0500n 0.000745 63.0600n 0.000644 63.0700n 0.000527 63.0800n 0.000397 63.0900n 0.000257 63.1000n 0.000110 63.1100n -0.000042 63.1200n -0.000195 63.1300n -0.000345 63.1400n -0.000490
+ 63.1500n -0.000627 63.1600n -0.000753 63.1700n -0.000866 63.1800n -0.000964 63.1900n -0.001046 63.2000n -0.001110 63.2100n -0.001156 63.2200n -0.001184 63.2300n -0.001193 63.2400n -0.001184 63.2500n -0.001159 63.2600n -0.001119 63.2700n -0.001065 63.2800n -0.001000 63.2900n -0.000926
+ 63.3000n -0.000845 63.3100n -0.000760 63.3200n -0.000673 63.3300n -0.000587 63.3400n -0.000505 63.3500n -0.000428 63.3600n -0.000359 63.3700n -0.000299 63.3800n -0.000249 63.3900n -0.000212 63.4000n -0.000187 63.4100n -0.000174 63.4200n -0.000174 63.4300n -0.000186 63.4400n -0.000208
+ 63.4500n -0.000241 63.4600n -0.000281 63.4700n -0.000327 63.4800n -0.000377 63.4900n -0.000429 63.5000n -0.000480 63.5100n -0.000528 63.5200n -0.000570 63.5300n -0.000604 63.5400n -0.000628 63.5500n -0.000641 63.5600n -0.000640 63.5700n -0.000624 63.5800n -0.000593 63.5900n -0.000546
+ 63.6000n -0.000483 63.6100n -0.000404 63.6200n -0.000311 63.6300n -0.000205 63.6400n -0.000087 63.6500n 0.000040 63.6600n 0.000173 63.6700n 0.000310 63.6800n 0.000449 63.6900n 0.000585 63.7000n 0.000716 63.7100n 0.000838 63.7200n 0.000948 63.7300n 0.001044 63.7400n 0.001123
+ 63.7500n 0.001182 63.7600n 0.001219 63.7700n 0.001233 63.7800n 0.001223 63.7900n 0.001188 63.8000n 0.001129 63.8100n 0.001045 63.8200n 0.000938 63.8300n 0.000811 63.8400n 0.000664 63.8500n 0.000501 63.8600n 0.000325 63.8700n 0.000140 63.8800n -0.000052 63.8900n -0.000244
+ 63.9000n -0.000434 63.9100n -0.000617 63.9200n -0.000789 63.9300n -0.000945 63.9400n -0.001083 63.9500n -0.001198 63.9600n -0.001287 63.9700n -0.001347 63.9800n -0.001377 63.9900n -0.001375 64.0000n -0.001341 64.0100n -0.001273 64.0200n -0.001172 64.0300n -0.001040 64.0400n -0.000879
+ 64.0500n -0.000690 64.0600n -0.000476 64.0700n -0.000243 64.0800n 0.000008 64.0900n 0.000271 64.1000n 0.000541 64.1100n 0.000814 64.1200n 0.001085 64.1300n 0.001349 64.1400n 0.001601 64.1500n 0.001836 64.1600n 0.002051 64.1700n 0.002240 64.1800n 0.002401 64.1900n 0.002531
+ 64.2000n 0.002627 64.2100n 0.002688 64.2200n 0.002713 64.2300n 0.002701 64.2400n 0.002653 64.2500n 0.002570 64.2600n 0.002454 64.2700n 0.002307 64.2800n 0.002133 64.2900n 0.001934 64.3000n 0.001715 64.3100n 0.001480 64.3200n 0.001233 64.3300n 0.000980 64.3400n 0.000724
+ 64.3500n 0.000471 64.3600n 0.000224 64.3700n -0.000011 64.3800n -0.000231 64.3900n -0.000432 64.4000n -0.000611 64.4100n -0.000765 64.4200n -0.000893 64.4300n -0.000993 64.4400n -0.001064 64.4500n -0.001106 64.4600n -0.001121 64.4700n -0.001107 64.4800n -0.001068 64.4900n -0.001006
+ 64.5000n -0.000922 64.5100n -0.000821 64.5200n -0.000705 64.5300n -0.000577 64.5400n -0.000442 64.5500n -0.000303 64.5600n -0.000164 64.5700n -0.000027 64.5800n 0.000103 64.5900n 0.000224 64.6000n 0.000333 64.6100n 0.000428 64.6200n 0.000507 64.6300n 0.000569 64.6400n 0.000614
+ 64.6500n 0.000640 64.6600n 0.000649 64.6700n 0.000642 64.6800n 0.000619 64.6900n 0.000583 64.7000n 0.000536 64.7100n 0.000480 64.7200n 0.000418 64.7300n 0.000353 64.7400n 0.000289 64.7500n 0.000228 64.7600n 0.000174 64.7700n 0.000129 64.7800n 0.000097 64.7900n 0.000080
+ 64.8000n 0.000079 64.8100n 0.000097 64.8200n 0.000135 64.8300n 0.000194 64.8400n 0.000274 64.8500n 0.000374 64.8600n 0.000495 64.8700n 0.000633 64.8800n 0.000789 64.8900n 0.000959 64.9000n 0.001141 64.9100n 0.001331 64.9200n 0.001527 64.9300n 0.001724 64.9400n 0.001920
+ 64.9500n 0.002109 64.9600n 0.002288 64.9700n 0.002454 64.9800n 0.002603 64.9900n 0.002731 65.0000n 0.002837 65.0100n 0.002916 65.0200n 0.002967 65.0300n 0.002988 65.0400n 0.002978 65.0500n 0.002937 65.0600n 0.002864 65.0700n 0.002760 65.0800n 0.002626 65.0900n 0.002464
+ 65.1000n 0.002275 65.1100n 0.002064 65.1200n 0.001832 65.1300n 0.001582 65.1400n 0.001320 65.1500n 0.001047 65.1600n 0.000770 65.1700n 0.000491 65.1800n 0.000214 65.1900n -0.000055 65.2000n -0.000314 65.2100n -0.000559 65.2200n -0.000787 65.2300n -0.000995 65.2400n -0.001179
+ 65.2500n -0.001339 65.2600n -0.001472 65.2700n -0.001578 65.2800n -0.001656 65.2900n -0.001705 65.3000n -0.001727 65.3100n -0.001722 65.3200n -0.001691 65.3300n -0.001637 65.3400n -0.001561 65.3500n -0.001465 65.3600n -0.001353 65.3700n -0.001228 65.3800n -0.001092 65.3900n -0.000949
+ 65.4000n -0.000801 65.4100n -0.000652 65.4200n -0.000505 65.4300n -0.000363 65.4400n -0.000228 65.4500n -0.000102 65.4600n 0.000012 65.4700n 0.000112 65.4800n 0.000197 65.4900n 0.000267 65.5000n 0.000320 65.5100n 0.000356 65.5200n 0.000375 65.5300n 0.000377 65.5400n 0.000364
+ 65.5500n 0.000336 65.5600n 0.000294 65.5700n 0.000240 65.5800n 0.000175 65.5900n 0.000102 65.6000n 0.000021 65.6100n -0.000064 65.6200n -0.000151 65.6300n -0.000240 65.6400n -0.000328 65.6500n -0.000413 65.6600n -0.000494 65.6700n -0.000569 65.6800n -0.000636 65.6900n -0.000696
+ 65.7000n -0.000746 65.7100n -0.000786 65.7200n -0.000816 65.7300n -0.000835 65.7400n -0.000843 65.7500n -0.000842 65.7600n -0.000830 65.7700n -0.000809 65.7800n -0.000779 65.7900n -0.000741 65.8000n -0.000697 65.8100n -0.000647 65.8200n -0.000592 65.8300n -0.000534 65.8400n -0.000474
+ 65.8500n -0.000413 65.8600n -0.000352 65.8700n -0.000292 65.8800n -0.000235 65.8900n -0.000181 65.9000n -0.000132 65.9100n -0.000087 65.9200n -0.000048 65.9300n -0.000015 65.9400n 0.000011 65.9500n 0.000030 65.9600n 0.000043 65.9700n 0.000049 65.9800n 0.000048 65.9900n 0.000040
+ 66.0000n 0.000027 66.0100n 0.000007 66.0200n -0.000017 66.0300n -0.000045 66.0400n -0.000078 66.0500n -0.000113 66.0600n -0.000149 66.0700n -0.000187 66.0800n -0.000225 66.0900n -0.000262 66.1000n -0.000298 66.1100n -0.000330 66.1200n -0.000359 66.1300n -0.000383 66.1400n -0.000402
+ 66.1500n -0.000414 66.1600n -0.000420 66.1700n -0.000418 66.1800n -0.000408 66.1900n -0.000389 66.2000n -0.000362 66.2100n -0.000325 66.2200n -0.000280 66.2300n -0.000225 66.2400n -0.000162 66.2500n -0.000090 66.2600n -0.000011 66.2700n 0.000076 66.2800n 0.000169 66.2900n 0.000267
+ 66.3000n 0.000369 66.3100n 0.000475 66.3200n 0.000581 66.3300n 0.000688 66.3400n 0.000793 66.3500n 0.000895 66.3600n 0.000991 66.3700n 0.001081 66.3800n 0.001163 66.3900n 0.001235 66.4000n 0.001294 66.4100n 0.001341 66.4200n 0.001372 66.4300n 0.001388 66.4400n 0.001386
+ 66.4500n 0.001367 66.4600n 0.001328 66.4700n 0.001270 66.4800n 0.001193 66.4900n 0.001096 66.5000n 0.000979 66.5100n 0.000844 66.5200n 0.000692 66.5300n 0.000522 66.5400n 0.000337 66.5500n 0.000139 66.5600n -0.000072 66.5700n -0.000292 66.5800n -0.000520 66.5900n -0.000752
+ 66.6000n -0.000988 66.6100n -0.001224 66.6200n -0.001457 66.6300n -0.001686 66.6400n -0.001907 66.6500n -0.002118 66.6600n -0.002318 66.6700n -0.002503 66.6800n -0.002672 66.6900n -0.002824 66.7000n -0.002957 66.7100n -0.003070 66.7200n -0.003162 66.7300n -0.003233 66.7400n -0.003283
+ 66.7500n -0.003312 66.7600n -0.003321 66.7700n -0.003310 66.7800n -0.003280 66.7900n -0.003233 66.8000n -0.003171 66.8100n -0.003095 66.8200n -0.003007 66.8300n -0.002909 66.8400n -0.002803 66.8500n -0.002692 66.8600n -0.002578 66.8700n -0.002461 66.8800n -0.002345 66.8900n -0.002232
+ 66.9000n -0.002122 66.9100n -0.002018 66.9200n -0.001920 66.9300n -0.001830 66.9400n -0.001748 66.9500n -0.001674 66.9600n -0.001610 66.9700n -0.001554 66.9800n -0.001507 66.9900n -0.001469 67.0000n -0.001437 67.0100n -0.001413 67.0200n -0.001394 67.0300n -0.001380 67.0400n -0.001369
+ 67.0500n -0.001360 67.0600n -0.001353 67.0700n -0.001346 67.0800n -0.001339 67.0900n -0.001329 67.1000n -0.001318 67.1100n -0.001303 67.1200n -0.001285 67.1300n -0.001264 67.1400n -0.001240 67.1500n -0.001212 67.1600n -0.001182 67.1700n -0.001150 67.1800n -0.001116 67.1900n -0.001083
+ 67.2000n -0.001050 67.2100n -0.001020 67.2200n -0.000993 67.2300n -0.000970 67.2400n -0.000953 67.2500n -0.000943 67.2600n -0.000941 67.2700n -0.000947 67.2800n -0.000963 67.2900n -0.000988 67.3000n -0.001024 67.3100n -0.001069 67.3200n -0.001124 67.3300n -0.001188 67.3400n -0.001261
+ 67.3500n -0.001340 67.3600n -0.001425 67.3700n -0.001514 67.3800n -0.001606 67.3900n -0.001697 67.4000n -0.001787 67.4100n -0.001873 67.4200n -0.001952 67.4300n -0.002023 67.4400n -0.002084 67.4500n -0.002132 67.4600n -0.002166 67.4700n -0.002184 67.4800n -0.002185 67.4900n -0.002168
+ 67.5000n -0.002133 67.5100n -0.002079 67.5200n -0.002006 67.5300n -0.001916 67.5400n -0.001808 67.5500n -0.001685 67.5600n -0.001547 67.5700n -0.001398 67.5800n -0.001240 67.5900n -0.001074 67.6000n -0.000905 67.6100n -0.000735 67.6200n -0.000567 67.6300n -0.000404 67.6400n -0.000249
+ 67.6500n -0.000106 67.6600n 0.000023 67.6700n 0.000135 67.6800n 0.000229 67.6900n 0.000302 67.7000n 0.000352 67.7100n 0.000380 67.7200n 0.000384 67.7300n 0.000365 67.7400n 0.000322 67.7500n 0.000257 67.7600n 0.000172 67.7700n 0.000068 67.7800n -0.000052 67.7900n -0.000186
+ 67.8000n -0.000329 67.8100n -0.000480 67.8200n -0.000634 67.8300n -0.000788 67.8400n -0.000937 67.8500n -0.001078 67.8600n -0.001208 67.8700n -0.001322 67.8800n -0.001419 67.8900n -0.001494 67.9000n -0.001546 67.9100n -0.001572 67.9200n -0.001572 67.9300n -0.001544 67.9400n -0.001487
+ 67.9500n -0.001403 67.9600n -0.001292 67.9700n -0.001155 67.9800n -0.000995 67.9900n -0.000813 68.0000n -0.000613 68.0100n -0.000398 68.0200n -0.000172 68.0300n 0.000062 68.0400n 0.000299 68.0500n 0.000535 68.0600n 0.000766 68.0700n 0.000987 68.0800n 0.001195 68.0900n 0.001387
+ 68.1000n 0.001558 68.1100n 0.001705 68.1200n 0.001827 68.1300n 0.001920 68.1400n 0.001985 68.1500n 0.002019 68.1600n 0.002022 68.1700n 0.001995 68.1800n 0.001938 68.1900n 0.001853 68.2000n 0.001743 68.2100n 0.001608 68.2200n 0.001453 68.2300n 0.001281 68.2400n 0.001094
+ 68.2500n 0.000898 68.2600n 0.000695 68.2700n 0.000490 68.2800n 0.000287 68.2900n 0.000090 68.3000n -0.000099 68.3100n -0.000275 68.3200n -0.000435 68.3300n -0.000578 68.3400n -0.000701 68.3500n -0.000801 68.3600n -0.000879 68.3700n -0.000934 68.3800n -0.000965 68.3900n -0.000974
+ 68.4000n -0.000960 68.4100n -0.000926 68.4200n -0.000874 68.4300n -0.000805 68.4400n -0.000723 68.4500n -0.000630 68.4600n -0.000530 68.4700n -0.000425 68.4800n -0.000318 68.4900n -0.000214 68.5000n -0.000114 68.5100n -0.000021 68.5200n 0.000061 68.5300n 0.000132 68.5400n 0.000188
+ 68.5500n 0.000230 68.5600n 0.000256 68.5700n 0.000265 68.5800n 0.000258 68.5900n 0.000235 68.6000n 0.000198 68.6100n 0.000148 68.6200n 0.000087 68.6300n 0.000016 68.6400n -0.000060 68.6500n -0.000141 68.6600n -0.000222 68.6700n -0.000301 68.6800n -0.000374 68.6900n -0.000440
+ 68.7000n -0.000494 68.7100n -0.000534 68.7200n -0.000559 68.7300n -0.000565 68.7400n -0.000552 68.7500n -0.000518 68.7600n -0.000462 68.7700n -0.000385 68.7800n -0.000286 68.7900n -0.000167 68.8000n -0.000028 68.8100n 0.000128 68.8200n 0.000300 68.8300n 0.000484 68.8400n 0.000679
+ 68.8500n 0.000880 68.8600n 0.001084 68.8700n 0.001288 68.8800n 0.001488 68.8900n 0.001680 68.9000n 0.001861 68.9100n 0.002028 68.9200n 0.002177 68.9300n 0.002306 68.9400n 0.002411 68.9500n 0.002491 68.9600n 0.002545 68.9700n 0.002570 68.9800n 0.002567 68.9900n 0.002535
+ 69.0000n 0.002475 69.0100n 0.002387 69.0200n 0.002273 69.0300n 0.002134 69.0400n 0.001973 69.0500n 0.001792 69.0600n 0.001595 69.0700n 0.001384 69.0800n 0.001162 69.0900n 0.000933 69.1000n 0.000701 69.1100n 0.000469 69.1200n 0.000240 69.1300n 0.000017 69.1400n -0.000195
+ 69.1500n -0.000396 69.1600n -0.000582 69.1700n -0.000750 69.1800n -0.000901 69.1900n -0.001031 69.2000n -0.001140 69.2100n -0.001228 69.2200n -0.001295 69.2300n -0.001340 69.2400n -0.001365 69.2500n -0.001370 69.2600n -0.001356 69.2700n -0.001326 69.2800n -0.001280 69.2900n -0.001222
+ 69.3000n -0.001151 69.3100n -0.001072 69.3200n -0.000985 69.3300n -0.000893 69.3400n -0.000798 69.3500n -0.000702 69.3600n -0.000605 69.3700n -0.000511 69.3800n -0.000419 69.3900n -0.000331 69.4000n -0.000247 69.4100n -0.000169 69.4200n -0.000096 69.4300n -0.000029 69.4400n 0.000033
+ 69.4500n 0.000089 69.4600n 0.000142 69.4700n 0.000190 69.4800n 0.000235 69.4900n 0.000278 69.5000n 0.000319 69.5100n 0.000359 69.5200n 0.000399 69.5300n 0.000440 69.5400n 0.000482 69.5500n 0.000526 69.5600n 0.000572 69.5700n 0.000620 69.5800n 0.000670 69.5900n 0.000722
+ 69.6000n 0.000776 69.6100n 0.000830 69.6200n 0.000885 69.6300n 0.000939 69.6400n 0.000992 69.6500n 0.001042 69.6600n 0.001088 69.6700n 0.001130 69.6800n 0.001166 69.6900n 0.001194 69.7000n 0.001215 69.7100n 0.001227 69.7200n 0.001229 69.7300n 0.001220 69.7400n 0.001200
+ 69.7500n 0.001170 69.7600n 0.001127 69.7700n 0.001074 69.7800n 0.001009 69.7900n 0.000934 69.8000n 0.000850 69.8100n 0.000756 69.8200n 0.000655 69.8300n 0.000547 69.8400n 0.000433 69.8500n 0.000316 69.8600n 0.000196 69.8700n 0.000075 69.8800n -0.000046 69.8900n -0.000165
+ 69.9000n -0.000282 69.9100n -0.000394 69.9200n -0.000501 69.9300n -0.000601 69.9400n -0.000695 69.9500n -0.000781 69.9600n -0.000860 69.9700n -0.000931 69.9800n -0.000994 69.9900n -0.001049 70.0000n -0.001097 70.0100n -0.001138 70.0200n -0.001174 70.0300n -0.001204 70.0400n -0.001230
+ 70.0500n -0.001253 70.0600n -0.001273 70.0700n -0.001292 70.0800n -0.001310 70.0900n -0.001329 70.1000n -0.001349 70.1100n -0.001371 70.1200n -0.001395 70.1300n -0.001422 70.1400n -0.001452 70.1500n -0.001484 70.1600n -0.001520 70.1700n -0.001557 70.1800n -0.001597 70.1900n -0.001638
+ 70.2000n -0.001679 70.2100n -0.001719 70.2200n -0.001758 70.2300n -0.001794 70.2400n -0.001827 70.2500n -0.001854 70.2600n -0.001876 70.2700n -0.001891 70.2800n -0.001899 70.2900n -0.001898 70.3000n -0.001888 70.3100n -0.001868 70.3200n -0.001838 70.3300n -0.001799 70.3400n -0.001750
+ 70.3500n -0.001692 70.3600n -0.001626 70.3700n -0.001551 70.3800n -0.001470 70.3900n -0.001383 70.4000n -0.001291 70.4100n -0.001197 70.4200n -0.001101 70.4300n -0.001004 70.4400n -0.000910 70.4500n -0.000818 70.4600n -0.000731 70.4700n -0.000650 70.4800n -0.000575 70.4900n -0.000509
+ 70.5000n -0.000452 70.5100n -0.000404 70.5200n -0.000366 70.5300n -0.000339 70.5400n -0.000322 70.5500n -0.000315 70.5600n -0.000317 70.5700n -0.000328 70.5800n -0.000346 70.5900n -0.000371 70.6000n -0.000401 70.6100n -0.000434 70.6200n -0.000470 70.6300n -0.000506 70.6400n -0.000541
+ 70.6500n -0.000573 70.6600n -0.000600 70.6700n -0.000622 70.6800n -0.000637 70.6900n -0.000643 70.7000n -0.000640 70.7100n -0.000626 70.7200n -0.000602 70.7300n -0.000567 70.7400n -0.000521 70.7500n -0.000464 70.7600n -0.000396 70.7700n -0.000318 70.7800n -0.000232 70.7900n -0.000137
+ 70.8000n -0.000036 70.8100n 0.000071 70.8200n 0.000181 70.8300n 0.000294 70.8400n 0.000407 70.8500n 0.000520 70.8600n 0.000630 70.8700n 0.000736 70.8800n 0.000838 70.8900n 0.000933 70.9000n 0.001021 70.9100n 0.001100 70.9200n 0.001171 70.9300n 0.001232 70.9400n 0.001285
+ 70.9500n 0.001327 70.9600n 0.001361 70.9700n 0.001386 70.9800n 0.001403 70.9900n 0.001412 71.0000n 0.001415 71.0100n 0.001411 71.0200n 0.001404 71.0300n 0.001392 71.0400n 0.001379 71.0500n 0.001363 71.0600n 0.001347 71.0700n 0.001330 71.0800n 0.001315 71.0900n 0.001300
+ 71.1000n 0.001288 71.1100n 0.001277 71.1200n 0.001267 71.1300n 0.001259 71.1400n 0.001252 71.1500n 0.001245 71.1600n 0.001239 71.1700n 0.001230 71.1800n 0.001220 71.1900n 0.001206 71.2000n 0.001188 71.2100n 0.001165 71.2200n 0.001135 71.2300n 0.001097 71.2400n 0.001052
+ 71.2500n 0.000997 71.2600n 0.000932 71.2700n 0.000858 71.2800n 0.000774 71.2900n 0.000680 71.3000n 0.000576 71.3100n 0.000464 71.3200n 0.000345 71.3300n 0.000219 71.3400n 0.000089 71.3500n -0.000044 71.3600n -0.000178 71.3700n -0.000310 71.3800n -0.000440 71.3900n -0.000563
+ 71.4000n -0.000678 71.4100n -0.000782 71.4200n -0.000874 71.4300n -0.000950 71.4400n -0.001010 71.4500n -0.001051 71.4600n -0.001072 71.4700n -0.001072 71.4800n -0.001050 71.4900n -0.001005 71.5000n -0.000939 71.5100n -0.000851 71.5200n -0.000742 71.5300n -0.000614 71.5400n -0.000468
+ 71.5500n -0.000306 71.5600n -0.000131 71.5700n 0.000055 71.5800n 0.000248 71.5900n 0.000446 71.6000n 0.000645 71.6100n 0.000841 71.6200n 0.001032 71.6300n 0.001215 71.6400n 0.001385 71.6500n 0.001540 71.6600n 0.001677 71.6700n 0.001795 71.6800n 0.001890 71.6900n 0.001961
+ 71.7000n 0.002008 71.7100n 0.002028 71.7200n 0.002023 71.7300n 0.001992 71.7400n 0.001935 71.7500n 0.001855 71.7600n 0.001753 71.7700n 0.001630 71.7800n 0.001490 71.7900n 0.001334 71.8000n 0.001166 71.8100n 0.000989 71.8200n 0.000806 71.8300n 0.000620 71.8400n 0.000435
+ 71.8500n 0.000254 71.8600n 0.000080 71.8700n -0.000085 71.8800n -0.000237 71.8900n -0.000376 71.9000n -0.000498 71.9100n -0.000602 71.9200n -0.000688 71.9300n -0.000754 71.9400n -0.000802 71.9500n -0.000830 71.9600n -0.000841 71.9700n -0.000835 71.9800n -0.000813 71.9900n -0.000779
+ 72.0000n -0.000733 72.0100n -0.000679 72.0200n -0.000619 72.0300n -0.000556 72.0400n -0.000493 72.0500n -0.000431 72.0600n -0.000375 72.0700n -0.000326 72.0800n -0.000286 72.0900n -0.000258 72.1000n -0.000244 72.1100n -0.000244 72.1200n -0.000259 72.1300n -0.000290 72.1400n -0.000337
+ 72.1500n -0.000399 72.1600n -0.000476 72.1700n -0.000567 72.1800n -0.000669 72.1900n -0.000782 72.2000n -0.000902 72.2100n -0.001028 72.2200n -0.001156 72.2300n -0.001285 72.2400n -0.001410 72.2500n -0.001530 72.2600n -0.001642 72.2700n -0.001742 72.2800n -0.001829 72.2900n -0.001900
+ 72.3000n -0.001954 72.3100n -0.001988 72.3200n -0.002002 72.3300n -0.001994 72.3400n -0.001965 72.3500n -0.001914 72.3600n -0.001842 72.3700n -0.001750 72.3800n -0.001638 72.3900n -0.001508 72.4000n -0.001363 72.4100n -0.001203 72.4200n -0.001033 72.4300n -0.000853 72.4400n -0.000668
+ 72.4500n -0.000479 72.4600n -0.000290 72.4700n -0.000102 72.4800n 0.000081 72.4900n 0.000256 72.5000n 0.000422 72.5100n 0.000577 72.5200n 0.000719 72.5300n 0.000846 72.5400n 0.000958 72.5500n 0.001053 72.5600n 0.001131 72.5700n 0.001193 72.5800n 0.001238 72.5900n 0.001266
+ 72.6000n 0.001280 72.6100n 0.001279 72.6200n 0.001265 72.6300n 0.001239 72.6400n 0.001204 72.6500n 0.001160 72.6600n 0.001109 72.6700n 0.001053 72.6800n 0.000993 72.6900n 0.000932 72.7000n 0.000869 72.7100n 0.000807 72.7200n 0.000746 72.7300n 0.000688 72.7400n 0.000632
+ 72.7500n 0.000579 72.7600n 0.000529 72.7700n 0.000482 72.7800n 0.000437 72.7900n 0.000394 72.8000n 0.000353 72.8100n 0.000312 72.8200n 0.000270 72.8300n 0.000227 72.8400n 0.000181 72.8500n 0.000132 72.8600n 0.000077 72.8700n 0.000018 72.8800n -0.000048 72.8900n -0.000121
+ 72.9000n -0.000201 72.9100n -0.000289 72.9200n -0.000385 72.9300n -0.000487 72.9400n -0.000596 72.9500n -0.000712 72.9600n -0.000832 72.9700n -0.000957 72.9800n -0.001083 72.9900n -0.001211 73.0000n -0.001338 73.0100n -0.001462 73.0200n -0.001582 73.0300n -0.001696 73.0400n -0.001801
+ 73.0500n -0.001897 73.0600n -0.001981 73.0700n -0.002051 73.0800n -0.002106 73.0900n -0.002146 73.1000n -0.002168 73.1100n -0.002173 73.1200n -0.002159 73.1300n -0.002127 73.1400n -0.002076 73.1500n -0.002008 73.1600n -0.001922 73.1700n -0.001820 73.1800n -0.001703 73.1900n -0.001572
+ 73.2000n -0.001429 73.2100n -0.001275 73.2200n -0.001113 73.2300n -0.000944 73.2400n -0.000771 73.2500n -0.000595 73.2600n -0.000419 73.2700n -0.000244 73.2800n -0.000072 73.2900n 0.000095 73.3000n 0.000256 73.3100n 0.000409 73.3200n 0.000553 73.3300n 0.000688 73.3400n 0.000811
+ 73.3500n 0.000924 73.3600n 0.001026 73.3700n 0.001116 73.3800n 0.001195 73.3900n 0.001263 73.4000n 0.001321 73.4100n 0.001369 73.4200n 0.001408 73.4300n 0.001438 73.4400n 0.001462 73.4500n 0.001478 73.4600n 0.001489 73.4700n 0.001496 73.4800n 0.001498 73.4900n 0.001497
+ 73.5000n 0.001493 73.5100n 0.001487 73.5200n 0.001479 73.5300n 0.001469 73.5400n 0.001459 73.5500n 0.001446 73.5600n 0.001433 73.5700n 0.001418 73.5800n 0.001401 73.5900n 0.001383 73.6000n 0.001362 73.6100n 0.001338 73.6200n 0.001311 73.6300n 0.001281 73.6400n 0.001247
+ 73.6500n 0.001210 73.6600n 0.001168 73.6700n 0.001122 73.6800n 0.001072 73.6900n 0.001019 73.7000n 0.000962 73.7100n 0.000901 73.7200n 0.000838 73.7300n 0.000773 73.7400n 0.000706 73.7500n 0.000639 73.7600n 0.000572 73.7700n 0.000505 73.7800n 0.000441 73.7900n 0.000378
+ 73.8000n 0.000320 73.8100n 0.000265 73.8200n 0.000215 73.8300n 0.000170 73.8400n 0.000130 73.8500n 0.000096 73.8600n 0.000068 73.8700n 0.000046 73.8800n 0.000029 73.8900n 0.000017 73.9000n 0.000010 73.9100n 0.000007 73.9200n 0.000007 73.9300n 0.000009 73.9400n 0.000013
+ 73.9500n 0.000017 73.9600n 0.000020 73.9700n 0.000022 73.9800n 0.000021 73.9900n 0.000018 74.0000n 0.000010 74.0100n -0.000002 74.0200n -0.000018 74.0300n -0.000039 74.0400n -0.000065 74.0500n -0.000095 74.0600n -0.000128 74.0700n -0.000164 74.0800n -0.000201 74.0900n -0.000239
+ 74.1000n -0.000275 74.1100n -0.000307 74.1200n -0.000335 74.1300n -0.000355 74.1400n -0.000367 74.1500n -0.000367 74.1600n -0.000355 74.1700n -0.000327 74.1800n -0.000283 74.1900n -0.000221 74.2000n -0.000139 74.2100n -0.000038 74.2200n 0.000085 74.2300n 0.000228 74.2400n 0.000392
+ 74.2500n 0.000576 74.2600n 0.000779 74.2700n 0.000999 74.2800n 0.001235 74.2900n 0.001483 74.3000n 0.001741 74.3100n 0.002005 74.3200n 0.002272 74.3300n 0.002539 74.3400n 0.002801 74.3500n 0.003055 74.3600n 0.003295 74.3700n 0.003518 74.3800n 0.003721 74.3900n 0.003898
+ 74.4000n 0.004047 74.4100n 0.004165 74.4200n 0.004248 74.4300n 0.004295 74.4400n 0.004304 74.4500n 0.004273 74.4600n 0.004203 74.4700n 0.004093 74.4800n 0.003944 74.4900n 0.003759 74.5000n 0.003538 74.5100n 0.003284 74.5200n 0.003002 74.5300n 0.002695 74.5400n 0.002366
+ 74.5500n 0.002022 74.5600n 0.001666 74.5700n 0.001305 74.5800n 0.000943 74.5900n 0.000585 74.6000n 0.000238 74.6100n -0.000095 74.6200n -0.000408 74.6300n -0.000696 74.6400n -0.000957 74.6500n -0.001185 74.6600n -0.001380 74.6700n -0.001537 74.6800n -0.001657 74.6900n -0.001737
+ 74.7000n -0.001779 74.7100n -0.001782 74.7200n -0.001748 74.7300n -0.001679 74.7400n -0.001578 74.7500n -0.001448 74.7600n -0.001293 74.7700n -0.001116 74.7800n -0.000923 74.7900n -0.000718 74.8000n -0.000506 74.8100n -0.000292 74.8200n -0.000081 74.8300n 0.000122 74.8400n 0.000313
+ 74.8500n 0.000488 74.8600n 0.000644 74.8700n 0.000776 74.8800n 0.000883 74.8900n 0.000962 74.9000n 0.001013 74.9100n 0.001034 74.9200n 0.001025 74.9300n 0.000988 74.9400n 0.000923 74.9500n 0.000833 74.9600n 0.000719 74.9700n 0.000586 74.9800n 0.000437 74.9900n 0.000275
+ 75.0000n 0.000104 75.0100n -0.000070 75.0200n -0.000245 75.0300n -0.000415 75.0400n -0.000576 75.0500n -0.000724 75.0600n -0.000856 75.0700n -0.000968 75.0800n -0.001057 75.0900n -0.001121 75.1000n -0.001158 75.1100n -0.001166 75.1200n -0.001145 75.1300n -0.001095 75.1400n -0.001016
+ 75.1500n -0.000909 75.1600n -0.000777 75.1700n -0.000622 75.1800n -0.000445 75.1900n -0.000251 75.2000n -0.000042 75.2100n 0.000177 75.2200n 0.000402 75.2300n 0.000630 75.2400n 0.000856 75.2500n 0.001077 75.2600n 0.001288 75.2700n 0.001487 75.2800n 0.001669 75.2900n 0.001832
+ 75.3000n 0.001974 75.3100n 0.002093 75.3200n 0.002187 75.3300n 0.002255 75.3400n 0.002297 75.3500n 0.002313 75.3600n 0.002304 75.3700n 0.002271 75.3800n 0.002215 75.3900n 0.002140 75.4000n 0.002047 75.4100n 0.001939 75.4200n 0.001820 75.4300n 0.001692 75.4400n 0.001559
+ 75.4500n 0.001424 75.4600n 0.001291 75.4700n 0.001163 75.4800n 0.001043 75.4900n 0.000933 75.5000n 0.000837 75.5100n 0.000756 75.5200n 0.000693 75.5300n 0.000648 75.5400n 0.000622 75.5500n 0.000616 75.5600n 0.000631 75.5700n 0.000665 75.5800n 0.000718 75.5900n 0.000789
+ 75.6000n 0.000876 75.6100n 0.000978 75.6200n 0.001092 75.6300n 0.001216 75.6400n 0.001347 75.6500n 0.001484 75.6600n 0.001623 75.6700n 0.001763 75.6800n 0.001900 75.6900n 0.002033 75.7000n 0.002159 75.7100n 0.002277 75.7200n 0.002384 75.7300n 0.002479 75.7400n 0.002562
+ 75.7500n 0.002632 75.7600n 0.002688 75.7700n 0.002729 75.7800n 0.002757 75.7900n 0.002771 75.8000n 0.002772 75.8100n 0.002762 75.8200n 0.002740 75.8300n 0.002709 75.8400n 0.002669 75.8500n 0.002623 75.8600n 0.002571 75.8700n 0.002515 75.8800n 0.002456 75.8900n 0.002395
+ 75.9000n 0.002334 75.9100n 0.002274 75.9200n 0.002216 75.9300n 0.002159 75.9400n 0.002105 75.9500n 0.002054 75.9600n 0.002006 75.9700n 0.001961 75.9800n 0.001918 75.9900n 0.001876 76.0000n 0.001837 76.0100n 0.001797 76.0200n 0.001758 76.0300n 0.001718 76.0400n 0.001675
+ 76.0500n 0.001630 76.0600n 0.001581 76.0700n 0.001528 76.0800n 0.001470 76.0900n 0.001407 76.1000n 0.001337 76.1100n 0.001262 76.1200n 0.001180 76.1300n 0.001093 76.1400n 0.000999 76.1500n 0.000901 76.1600n 0.000799 76.1700n 0.000693 76.1800n 0.000585 76.1900n 0.000475
+ 76.2000n 0.000366 76.2100n 0.000258 76.2200n 0.000152 76.2300n 0.000050 76.2400n -0.000046 76.2500n -0.000135 76.2600n -0.000217 76.2700n -0.000290 76.2800n -0.000352 76.2900n -0.000404 76.3000n -0.000444 76.3100n -0.000473 76.3200n -0.000489 76.3300n -0.000492 76.3400n -0.000484
+ 76.3500n -0.000463 76.3600n -0.000431 76.3700n -0.000387 76.3800n -0.000334 76.3900n -0.000271 76.4000n -0.000200 76.4100n -0.000122 76.4200n -0.000037 76.4300n 0.000052 76.4400n 0.000145 76.4500n 0.000240 76.4600n 0.000337 76.4700n 0.000434 76.4800n 0.000530 76.4900n 0.000625
+ 76.5000n 0.000717 76.5100n 0.000806 76.5200n 0.000892 76.5300n 0.000973 76.5400n 0.001050 76.5500n 0.001123 76.5600n 0.001190 76.5700n 0.001253 76.5800n 0.001311 76.5900n 0.001364 76.6000n 0.001413 76.6100n 0.001457 76.6200n 0.001497 76.6300n 0.001532 76.6400n 0.001564
+ 76.6500n 0.001591 76.6600n 0.001615 76.6700n 0.001634 76.6800n 0.001649 76.6900n 0.001659 76.7000n 0.001665 76.7100n 0.001665 76.7200n 0.001659 76.7300n 0.001647 76.7400n 0.001629 76.7500n 0.001603 76.7600n 0.001569 76.7700n 0.001527 76.7800n 0.001476 76.7900n 0.001416
+ 76.8000n 0.001346 76.8100n 0.001267 76.8200n 0.001177 76.8300n 0.001078 76.8400n 0.000969 76.8500n 0.000851 76.8600n 0.000724 76.8700n 0.000590 76.8800n 0.000449 76.8900n 0.000302 76.9000n 0.000150 76.9100n -0.000004 76.9200n -0.000159 76.9300n -0.000314 76.9400n -0.000467
+ 76.9500n -0.000615 76.9600n -0.000758 76.9700n -0.000893 76.9800n -0.001019 76.9900n -0.001133 77.0000n -0.001235 77.0100n -0.001322 77.0200n -0.001394 77.0300n -0.001450 77.0400n -0.001489 77.0500n -0.001510 77.0600n -0.001513 77.0700n -0.001498 77.0800n -0.001466 77.0900n -0.001418
+ 77.1000n -0.001353 77.1100n -0.001274 77.1200n -0.001181 77.1300n -0.001077 77.1400n -0.000963 77.1500n -0.000841 77.1600n -0.000714 77.1700n -0.000582 77.1800n -0.000450 77.1900n -0.000318 77.2000n -0.000189 77.2100n -0.000064 77.2200n 0.000053 77.2300n 0.000162 77.2400n 0.000261
+ 77.2500n 0.000348 77.2600n 0.000424 77.2700n 0.000486 77.2800n 0.000534 77.2900n 0.000569 77.3000n 0.000590 77.3100n 0.000597 77.3200n 0.000592 77.3300n 0.000575 77.3400n 0.000546 77.3500n 0.000509 77.3600n 0.000463 77.3700n 0.000411 77.3800n 0.000354 77.3900n 0.000293
+ 77.4000n 0.000231 77.4100n 0.000170 77.4200n 0.000110 77.4300n 0.000053 77.4400n 0.000001 77.4500n -0.000045 77.4600n -0.000085 77.4700n -0.000117 77.4800n -0.000141 77.4900n -0.000156 77.5000n -0.000163 77.5100n -0.000162 77.5200n -0.000152 77.5300n -0.000135 77.5400n -0.000112
+ 77.5500n -0.000083 77.5600n -0.000049 77.5700n -0.000012 77.5800n 0.000027 77.5900n 0.000067 77.6000n 0.000107 77.6100n 0.000145 77.6200n 0.000180 77.6300n 0.000210 77.6400n 0.000236 77.6500n 0.000256 77.6600n 0.000268 77.6700n 0.000274 77.6800n 0.000272 77.6900n 0.000263
+ 77.7000n 0.000246 77.7100n 0.000222 77.7200n 0.000191 77.7300n 0.000155 77.7400n 0.000113 77.7500n 0.000067 77.7600n 0.000018 77.7700n -0.000033 77.7800n -0.000085 77.7900n -0.000136 77.8000n -0.000185 77.8100n -0.000231 77.8200n -0.000273 77.8300n -0.000309 77.8400n -0.000339
+ 77.8500n -0.000362 77.8600n -0.000378 77.8700n -0.000386 77.8800n -0.000386 77.8900n -0.000377 77.9000n -0.000361 77.9100n -0.000337 77.9200n -0.000306 77.9300n -0.000269 77.9400n -0.000226 77.9500n -0.000180 77.9600n -0.000131 77.9700n -0.000080 77.9800n -0.000029 77.9900n 0.000021
+ 78.0000n 0.000069 78.0100n 0.000113 78.0200n 0.000152 78.0300n 0.000184 78.0400n 0.000210 78.0500n 0.000226 78.0600n 0.000234 78.0700n 0.000232 78.0800n 0.000220 78.0900n 0.000198 78.1000n 0.000165 78.1100n 0.000122 78.1200n 0.000069 78.1300n 0.000007 78.1400n -0.000064
+ 78.1500n -0.000143 78.1600n -0.000229 78.1700n -0.000320 78.1800n -0.000416 78.1900n -0.000515 78.2000n -0.000616 78.2100n -0.000718 78.2200n -0.000819 78.2300n -0.000918 78.2400n -0.001014 78.2500n -0.001106 78.2600n -0.001192 78.2700n -0.001272 78.2800n -0.001344 78.2900n -0.001409
+ 78.3000n -0.001465 78.3100n -0.001512 78.3200n -0.001549 78.3300n -0.001577 78.3400n -0.001595 78.3500n -0.001603 78.3600n -0.001601 78.3700n -0.001591 78.3800n -0.001571 78.3900n -0.001542 78.4000n -0.001504 78.4100n -0.001459 78.4200n -0.001406 78.4300n -0.001346 78.4400n -0.001280
+ 78.4500n -0.001207 78.4600n -0.001129 78.4700n -0.001046 78.4800n -0.000958 78.4900n -0.000866 78.5000n -0.000771 78.5100n -0.000672 78.5200n -0.000570 78.5300n -0.000466 78.5400n -0.000360 78.5500n -0.000252 78.5600n -0.000144 78.5700n -0.000035 78.5800n 0.000074 78.5900n 0.000182
+ 78.6000n 0.000289 78.6100n 0.000394 78.6200n 0.000496 78.6300n 0.000596 78.6400n 0.000691 78.6500n 0.000781 78.6600n 0.000866 78.6700n 0.000944 78.6800n 0.001016 78.6900n 0.001079 78.7000n 0.001134 78.7100n 0.001180 78.7200n 0.001216 78.7300n 0.001242 78.7400n 0.001258
+ 78.7500n 0.001262 78.7600n 0.001256 78.7700n 0.001239 78.7800n 0.001212 78.7900n 0.001174 78.8000n 0.001127 78.8100n 0.001070 78.8200n 0.001005 78.8300n 0.000933 78.8400n 0.000854 78.8500n 0.000770 78.8600n 0.000682 78.8700n 0.000592 78.8800n 0.000501 78.8900n 0.000410
+ 78.9000n 0.000321 78.9100n 0.000235 78.9200n 0.000153 78.9300n 0.000077 78.9400n 0.000008 78.9500n -0.000053 78.9600n -0.000106 78.9700n -0.000149 78.9800n -0.000183 78.9900n -0.000206 79.0000n -0.000220 79.0100n -0.000224 79.0200n -0.000218 79.0300n -0.000203 79.0400n -0.000180
+ 79.0500n -0.000150 79.0600n -0.000113 79.0700n -0.000072 79.0800n -0.000026 79.0900n 0.000021 79.1000n 0.000070 79.1100n 0.000118 79.1200n 0.000164 79.1300n 0.000208 79.1400n 0.000246 79.1500n 0.000280 79.1600n 0.000307 79.1700n 0.000327 79.1800n 0.000339 79.1900n 0.000342
+ 79.2000n 0.000338 79.2100n 0.000325 79.2200n 0.000304 79.2300n 0.000276 79.2400n 0.000240 79.2500n 0.000199 79.2600n 0.000152 79.2700n 0.000101 79.2800n 0.000048 79.2900n -0.000007 79.3000n -0.000062 79.3100n -0.000116 79.3200n -0.000167 79.3300n -0.000215 79.3400n -0.000257
+ 79.3500n -0.000294 79.3600n -0.000324 79.3700n -0.000347 79.3800n -0.000362 79.3900n -0.000368 79.4000n -0.000367 79.4100n -0.000357 79.4200n -0.000340 79.4300n -0.000316 79.4400n -0.000285 79.4500n -0.000249 79.4600n -0.000209 79.4700n -0.000166 79.4800n -0.000122 79.4900n -0.000077
+ 79.5000n -0.000033 79.5100n 0.000008 79.5200n 0.000045 79.5300n 0.000078 79.5400n 0.000104 79.5500n 0.000123 79.5600n 0.000134 79.5700n 0.000137 79.5800n 0.000131 79.5900n 0.000116 79.6000n 0.000093 79.6100n 0.000061 79.6200n 0.000021 79.6300n -0.000025 79.6400n -0.000077
+ 79.6500n -0.000134 79.6600n -0.000194 79.6700n -0.000256 79.6800n -0.000318 79.6900n -0.000379 79.7000n -0.000437 79.7100n -0.000491 79.7200n -0.000540 79.7300n -0.000582 79.7400n -0.000616 79.7500n -0.000642 79.7600n -0.000658 79.7700n -0.000665 79.7800n -0.000662 79.7900n -0.000649
+ 79.8000n -0.000627 79.8100n -0.000597 79.8200n -0.000560 79.8300n -0.000516 79.8400n -0.000467 79.8500n -0.000416 79.8600n -0.000363 79.8700n -0.000310 79.8800n -0.000260 79.8900n -0.000214 79.9000n -0.000174 79.9100n -0.000142 79.9200n -0.000119 79.9300n -0.000107 79.9400n -0.000107
+ 79.9500n -0.000119 79.9600n -0.000145 79.9700n -0.000184 79.9800n -0.000237 79.9900n -0.000302 80.0000n -0.000380 80.0100n -0.000469 80.0200n -0.000568 80.0300n -0.000675 80.0400n -0.000787 80.0500n -0.000903 80.0600n -0.001021 80.0700n -0.001137 80.0800n -0.001250 80.0900n -0.001356
+ 80.1000n -0.001454 80.1100n -0.001541 80.1200n -0.001615 80.1300n -0.001674 80.1400n -0.001716 80.1500n -0.001741 80.1600n -0.001747 80.1700n -0.001734 80.1800n -0.001702 80.1900n -0.001651 80.2000n -0.001582 80.2100n -0.001497 80.2200n -0.001397 80.2300n -0.001284 80.2400n -0.001160
+ 80.2500n -0.001029 80.2600n -0.000893 80.2700n -0.000755 80.2800n -0.000618 80.2900n -0.000486 80.3000n -0.000361 80.3100n -0.000247 80.3200n -0.000146 80.3300n -0.000060 80.3400n 0.000007 80.3500n 0.000056 80.3600n 0.000083 80.3700n 0.000089 80.3800n 0.000073 80.3900n 0.000036
+ 80.4000n -0.000023 80.4100n -0.000101 80.4200n -0.000196 80.4300n -0.000307 80.4400n -0.000431 80.4500n -0.000565 80.4600n -0.000704 80.4700n -0.000846 80.4800n -0.000988 80.4900n -0.001124 80.5000n -0.001251 80.5100n -0.001365 80.5200n -0.001464 80.5300n -0.001543 80.5400n -0.001600
+ 80.5500n -0.001632 80.5600n -0.001638 80.5700n -0.001616 80.5800n -0.001566 80.5900n -0.001486 80.6000n -0.001379 80.6100n -0.001244 80.6200n -0.001084 80.6300n -0.000901 80.6400n -0.000699 80.6500n -0.000480 80.6600n -0.000249 80.6700n -0.000009 80.6800n 0.000233 80.6900n 0.000475
+ 80.7000n 0.000710 80.7100n 0.000933 80.7200n 0.001141 80.7300n 0.001329 80.7400n 0.001491 80.7500n 0.001626 80.7600n 0.001728 80.7700n 0.001796 80.7800n 0.001827 80.7900n 0.001821 80.8000n 0.001775 80.8100n 0.001692 80.8200n 0.001570 80.8300n 0.001413 80.8400n 0.001222
+ 80.8500n 0.001000 80.8600n 0.000752 80.8700n 0.000480 80.8800n 0.000191 80.8900n -0.000112 80.9000n -0.000422 80.9100n -0.000734 80.9200n -0.001042 80.9300n -0.001342 80.9400n -0.001626 80.9500n -0.001891 80.9600n -0.002132 80.9700n -0.002343 80.9800n -0.002522 80.9900n -0.002665
+ 81.0000n -0.002769 81.0100n -0.002833 81.0200n -0.002856 81.0300n -0.002837 81.0400n -0.002777 81.0500n -0.002678 81.0600n -0.002540 81.0700n -0.002368 81.0800n -0.002163 81.0900n -0.001931 81.1000n -0.001674 81.1100n -0.001398 81.1200n -0.001108 81.1300n -0.000808 81.1400n -0.000505
+ 81.1500n -0.000202 81.1600n 0.000095 81.1700n 0.000381 81.1800n 0.000653 81.1900n 0.000906 81.2000n 0.001136 81.2100n 0.001341 81.2200n 0.001519 81.2300n 0.001667 81.2400n 0.001784 81.2500n 0.001871 81.2600n 0.001927 81.2700n 0.001952 81.2800n 0.001949 81.2900n 0.001919
+ 81.3000n 0.001864 81.3100n 0.001788 81.3200n 0.001692 81.3300n 0.001581 81.3400n 0.001457 81.3500n 0.001324 81.3600n 0.001186 81.3700n 0.001045 81.3800n 0.000906 81.3900n 0.000770 81.4000n 0.000641 81.4100n 0.000521 81.4200n 0.000411 81.4300n 0.000314 81.4400n 0.000229
+ 81.4500n 0.000159 81.4600n 0.000102 81.4700n 0.000058 81.4800n 0.000028 81.4900n 0.000009 81.5000n 0.000001 81.5100n 0.000002 81.5200n 0.000010 81.5300n 0.000023 81.5400n 0.000040 81.5500n 0.000058 81.5600n 0.000076 81.5700n 0.000091 81.5800n 0.000102 81.5900n 0.000108
+ 81.6000n 0.000108 81.6100n 0.000100 81.6200n 0.000085 81.6300n 0.000063 81.6400n 0.000032 81.6500n -0.000004 81.6600n -0.000047 81.6700n -0.000095 81.6800n -0.000145 81.6900n -0.000198 81.7000n -0.000250 81.7100n -0.000300 81.7200n -0.000346 81.7300n -0.000386 81.7400n -0.000418
+ 81.7500n -0.000440 81.7600n -0.000451 81.7700n -0.000450 81.7800n -0.000435 81.7900n -0.000407 81.8000n -0.000364 81.8100n -0.000307 81.8200n -0.000236 81.8300n -0.000153 81.8400n -0.000058 81.8500n 0.000046 81.8600n 0.000158 81.8700n 0.000276 81.8800n 0.000396 81.8900n 0.000517
+ 81.9000n 0.000635 81.9100n 0.000748 81.9200n 0.000852 81.9300n 0.000945 81.9400n 0.001025 81.9500n 0.001090 81.9600n 0.001136 81.9700n 0.001163 81.9800n 0.001170 81.9900n 0.001155 82.0000n 0.001119 82.0100n 0.001062 82.0200n 0.000983 82.0300n 0.000886 82.0400n 0.000771
+ 82.0500n 0.000640 82.0600n 0.000497 82.0700n 0.000344 82.0800n 0.000184 82.0900n 0.000021 82.1000n -0.000141 82.1100n -0.000300 82.1200n -0.000450 82.1300n -0.000590 82.1400n -0.000714 82.1500n -0.000821 82.1600n -0.000908 82.1700n -0.000971 82.1800n -0.001010 82.1900n -0.001023
+ 82.2000n -0.001008 82.2100n -0.000967 82.2200n -0.000899 82.2300n -0.000806 82.2400n -0.000688 82.2500n -0.000549 82.2600n -0.000390 82.2700n -0.000216 82.2800n -0.000028 82.2900n 0.000168 82.3000n 0.000369 82.3100n 0.000570 82.3200n 0.000768 82.3300n 0.000958 82.3400n 0.001135
+ 82.3500n 0.001297 82.3600n 0.001440 82.3700n 0.001560 82.3800n 0.001654 82.3900n 0.001721 82.4000n 0.001759 82.4100n 0.001767 82.4200n 0.001744 82.4300n 0.001691 82.4400n 0.001608 82.4500n 0.001498 82.4600n 0.001362 82.4700n 0.001202 82.4800n 0.001023 82.4900n 0.000827
+ 82.5000n 0.000618 82.5100n 0.000400 82.5200n 0.000178 82.5300n -0.000044 82.5400n -0.000263 82.5500n -0.000473 82.5600n -0.000671 82.5700n -0.000854 82.5800n -0.001018 82.5900n -0.001161 82.6000n -0.001279 82.6100n -0.001372 82.6200n -0.001439 82.6300n -0.001478 82.6400n -0.001490
+ 82.6500n -0.001476 82.6600n -0.001436 82.6700n -0.001372 82.6800n -0.001287 82.6900n -0.001183 82.7000n -0.001064 82.7100n -0.000931 82.7200n -0.000790 82.7300n -0.000642 82.7400n -0.000493 82.7500n -0.000344 82.7600n -0.000200 82.7700n -0.000063 82.7800n 0.000063 82.7900n 0.000177
+ 82.8000n 0.000277 82.8100n 0.000360 82.8200n 0.000427 82.8300n 0.000476 82.8400n 0.000507 82.8500n 0.000522 82.8600n 0.000521 82.8700n 0.000506 82.8800n 0.000478 82.8900n 0.000439 82.9000n 0.000393 82.9100n 0.000341 82.9200n 0.000286 82.9300n 0.000232 82.9400n 0.000181
+ 82.9500n 0.000135 82.9600n 0.000097 82.9700n 0.000069 82.9800n 0.000053 82.9900n 0.000049 83.0000n 0.000060 83.0100n 0.000085 83.0200n 0.000124 83.0300n 0.000177 83.0400n 0.000242 83.0500n 0.000319 83.0600n 0.000404 83.0700n 0.000495 83.0800n 0.000590 83.0900n 0.000685
+ 83.1000n 0.000777 83.1100n 0.000863 83.1200n 0.000939 83.1300n 0.001002 83.1400n 0.001048 83.1500n 0.001074 83.1600n 0.001078 83.1700n 0.001058 83.1800n 0.001010 83.1900n 0.000935 83.2000n 0.000831 83.2100n 0.000698 83.2200n 0.000537 83.2300n 0.000349 83.2400n 0.000135
+ 83.2500n -0.000101 83.2600n -0.000358 83.2700n -0.000631 83.2800n -0.000917 83.2900n -0.001210 83.3000n -0.001507 83.3100n -0.001803 83.3200n -0.002091 83.3300n -0.002368 83.3400n -0.002629 83.3500n -0.002868 83.3600n -0.003081 83.3700n -0.003264 83.3800n -0.003413 83.3900n -0.003526
+ 83.4000n -0.003601 83.4100n -0.003634 83.4200n -0.003626 83.4300n -0.003577 83.4400n -0.003486 83.4500n -0.003355 83.4600n -0.003186 83.4700n -0.002982 83.4800n -0.002747 83.4900n -0.002483 83.5000n -0.002196 83.5100n -0.001890 83.5200n -0.001571 83.5300n -0.001244 83.5400n -0.000914
+ 83.5500n -0.000587 83.5600n -0.000268 83.5700n 0.000038 83.5800n 0.000326 83.5900n 0.000592 83.6000n 0.000831 83.6100n 0.001042 83.6200n 0.001220 83.6300n 0.001364 83.6400n 0.001473 83.6500n 0.001546 83.6600n 0.001583 83.6700n 0.001585 83.6800n 0.001554 83.6900n 0.001491
+ 83.7000n 0.001399 83.7100n 0.001281 83.7200n 0.001142 83.7300n 0.000983 83.7400n 0.000811 83.7500n 0.000627 83.7600n 0.000438 83.7700n 0.000247 83.7800n 0.000057 83.7900n -0.000126 83.8000n -0.000301 83.8100n -0.000464 83.8200n -0.000613 83.8300n -0.000745 83.8400n -0.000859
+ 83.8500n -0.000953 83.8600n -0.001029 83.8700n -0.001085 83.8800n -0.001122 83.8900n -0.001142 83.9000n -0.001145 83.9100n -0.001135 83.9200n -0.001113 83.9300n -0.001081 83.9400n -0.001042 83.9500n -0.000999 83.9600n -0.000955 83.9700n -0.000912 83.9800n -0.000873 83.9900n -0.000840
+ 84.0000n -0.000814 84.0100n -0.000798 84.0200n -0.000792 84.0300n -0.000798 84.0400n -0.000815 84.0500n -0.000843 84.0600n -0.000882 84.0700n -0.000930 84.0800n -0.000987 84.0900n -0.001048 84.1000n -0.001114 84.1100n -0.001180 84.1200n -0.001244 84.1300n -0.001303 84.1400n -0.001353
+ 84.1500n -0.001393 84.1600n -0.001419 84.1700n -0.001428 84.1800n -0.001417 84.1900n -0.001385 84.2000n -0.001330 84.2100n -0.001250 84.2200n -0.001145 84.2300n -0.001014 84.2400n -0.000858 84.2500n -0.000678 84.2600n -0.000474 84.2700n -0.000250 84.2800n -0.000007 84.2900n 0.000252
+ 84.3000n 0.000523 84.3100n 0.000803 84.3200n 0.001087 84.3300n 0.001371 84.3400n 0.001652 84.3500n 0.001923 84.3600n 0.002182 84.3700n 0.002424 84.3800n 0.002645 84.3900n 0.002841 84.4000n 0.003009 84.4100n 0.003147 84.4200n 0.003251 84.4300n 0.003321 84.4400n 0.003356
+ 84.4500n 0.003354 84.4600n 0.003316 84.4700n 0.003243 84.4800n 0.003135 84.4900n 0.002997 84.5000n 0.002828 84.5100n 0.002634 84.5200n 0.002416 84.5300n 0.002179 84.5400n 0.001928 84.5500n 0.001665 84.5600n 0.001396 84.5700n 0.001124 84.5800n 0.000855 84.5900n 0.000592
+ 84.6000n 0.000339 84.6100n 0.000100 84.6200n -0.000122 84.6300n -0.000325 84.6400n -0.000506 84.6500n -0.000663 84.6600n -0.000795 84.6700n -0.000902 84.6800n -0.000982 84.6900n -0.001038 84.7000n -0.001068 84.7100n -0.001076 84.7200n -0.001062 84.7300n -0.001029 84.7400n -0.000979
+ 84.7500n -0.000915 84.7600n -0.000840 84.7700n -0.000756 84.7800n -0.000666 84.7900n -0.000574 84.8000n -0.000483 84.8100n -0.000393 84.8200n -0.000309 84.8300n -0.000232 84.8400n -0.000163 84.8500n -0.000104 84.8600n -0.000056 84.8700n -0.000020 84.8800n 0.000006 84.8900n 0.000021
+ 84.9000n 0.000026 84.9100n 0.000022 84.9200n 0.000010 84.9300n -0.000007 84.9400n -0.000028 84.9500n -0.000051 84.9600n -0.000073 84.9700n -0.000093 84.9800n -0.000107 84.9900n -0.000114 85.0000n -0.000112 85.0100n -0.000099 85.0200n -0.000074 85.0300n -0.000035 85.0400n 0.000018
+ 85.0500n 0.000086 85.0600n 0.000169 85.0700n 0.000267 85.0800n 0.000378 85.0900n 0.000502 85.1000n 0.000637 85.1100n 0.000782 85.1200n 0.000933 85.1300n 0.001090 85.1400n 0.001248 85.1500n 0.001405 85.1600n 0.001558 85.1700n 0.001705 85.1800n 0.001842 85.1900n 0.001967
+ 85.2000n 0.002077 85.2100n 0.002169 85.2200n 0.002242 85.2300n 0.002294 85.2400n 0.002323 85.2500n 0.002328 85.2600n 0.002310 85.2700n 0.002267 85.2800n 0.002200 85.2900n 0.002111 85.3000n 0.002000 85.3100n 0.001870 85.3200n 0.001722 85.3300n 0.001558 85.3400n 0.001383
+ 85.3500n 0.001198 85.3600n 0.001007 85.3700n 0.000814 85.3800n 0.000621 85.3900n 0.000433 85.4000n 0.000252 85.4100n 0.000083 85.4200n -0.000073 85.4300n -0.000212 85.4400n -0.000331 85.4500n -0.000429 85.4600n -0.000503 85.4700n -0.000553 85.4800n -0.000577 85.4900n -0.000576
+ 85.5000n -0.000548 85.5100n -0.000495 85.5200n -0.000418 85.5300n -0.000318 85.5400n -0.000197 85.5500n -0.000056 85.5600n 0.000101 85.5700n 0.000271 85.5800n 0.000453 85.5900n 0.000642 85.6000n 0.000835 85.6100n 0.001030 85.6200n 0.001222 85.6300n 0.001408 85.6400n 0.001586
+ 85.6500n 0.001752 85.6600n 0.001904 85.6700n 0.002039 85.6800n 0.002155 85.6900n 0.002250 85.7000n 0.002323 85.7100n 0.002372 85.7200n 0.002397 85.7300n 0.002397 85.7400n 0.002373 85.7500n 0.002325 85.7600n 0.002254 85.7700n 0.002160 85.7800n 0.002046 85.7900n 0.001913
+ 85.8000n 0.001762 85.8100n 0.001596 85.8200n 0.001418 85.8300n 0.001229 85.8400n 0.001033 85.8500n 0.000831 85.8600n 0.000627 85.8700n 0.000422 85.8800n 0.000220 85.8900n 0.000022 85.9000n -0.000169 85.9100n -0.000351 85.9200n -0.000523 85.9300n -0.000682 85.9400n -0.000827
+ 85.9500n -0.000958 85.9600n -0.001073 85.9700n -0.001171 85.9800n -0.001252 85.9900n -0.001316 86.0000n -0.001362 86.0100n -0.001391 86.0200n -0.001403 86.0300n -0.001399 86.0400n -0.001379 86.0500n -0.001344 86.0600n -0.001296 86.0700n -0.001235 86.0800n -0.001163 86.0900n -0.001080
+ 86.1000n -0.000988 86.1100n -0.000889 86.1200n -0.000783 86.1300n -0.000672 86.1400n -0.000558 86.1500n -0.000441 86.1600n -0.000322 86.1700n -0.000204 86.1800n -0.000087 86.1900n 0.000028 86.2000n 0.000140 86.2100n 0.000248 86.2200n 0.000351 86.2300n 0.000449 86.2400n 0.000541
+ 86.2500n 0.000626 86.2600n 0.000705 86.2700n 0.000777 86.2800n 0.000841 86.2900n 0.000898 86.3000n 0.000947 86.3100n 0.000989 86.3200n 0.001024 86.3300n 0.001051 86.3400n 0.001071 86.3500n 0.001085 86.3600n 0.001092 86.3700n 0.001094 86.3800n 0.001089 86.3900n 0.001080
+ 86.4000n 0.001065 86.4100n 0.001047 86.4200n 0.001024 86.4300n 0.000997 86.4400n 0.000968 86.4500n 0.000935 86.4600n 0.000900 86.4700n 0.000863 86.4800n 0.000823 86.4900n 0.000782 86.5000n 0.000739 86.5100n 0.000694 86.5200n 0.000648 86.5300n 0.000600 86.5400n 0.000550
+ 86.5500n 0.000499 86.5600n 0.000446 86.5700n 0.000391 86.5800n 0.000335 86.5900n 0.000276 86.6000n 0.000214 86.6100n 0.000151 86.6200n 0.000085 86.6300n 0.000016 86.6400n -0.000055 86.6500n -0.000128 86.6600n -0.000204 86.6700n -0.000282 86.6800n -0.000363 86.6900n -0.000445
+ 86.7000n -0.000528 86.7100n -0.000612 86.7200n -0.000696 86.7300n -0.000781 86.7400n -0.000864 86.7500n -0.000946 86.7600n -0.001025 86.7700n -0.001101 86.7800n -0.001172 86.7900n -0.001239 86.8000n -0.001300 86.8100n -0.001355 86.8200n -0.001402 86.8300n -0.001440 86.8400n -0.001471
+ 86.8500n -0.001491 86.8600n -0.001502 86.8700n -0.001502 86.8800n -0.001493 86.8900n -0.001472 86.9000n -0.001441 86.9100n -0.001399 86.9200n -0.001348 86.9300n -0.001287 86.9400n -0.001216 86.9500n -0.001138 86.9600n -0.001052 86.9700n -0.000960 86.9800n -0.000862 86.9900n -0.000760
+ 87.0000n -0.000654 87.0100n -0.000547 87.0200n -0.000439 87.0300n -0.000332 87.0400n -0.000227 87.0500n -0.000124 87.0600n -0.000026 87.0700n 0.000067 87.0800n 0.000153 87.0900n 0.000233 87.1000n 0.000306 87.1100n 0.000370 87.1200n 0.000425 87.1300n 0.000471 87.1400n 0.000508
+ 87.1500n 0.000536 87.1600n 0.000555 87.1700n 0.000565 87.1800n 0.000567 87.1900n 0.000561 87.2000n 0.000547 87.2100n 0.000527 87.2200n 0.000500 87.2300n 0.000467 87.2400n 0.000430 87.2500n 0.000389 87.2600n 0.000344 87.2700n 0.000296 87.2800n 0.000246 87.2900n 0.000195
+ 87.3000n 0.000142 87.3100n 0.000089 87.3200n 0.000035 87.3300n -0.000019 87.3400n -0.000072 87.3500n -0.000126 87.3600n -0.000179 87.3700n -0.000231 87.3800n -0.000283 87.3900n -0.000335 87.4000n -0.000386 87.4100n -0.000436 87.4200n -0.000486 87.4300n -0.000534 87.4400n -0.000581
+ 87.4500n -0.000627 87.4600n -0.000671 87.4700n -0.000713 87.4800n -0.000752 87.4900n -0.000788 87.5000n -0.000819 87.5100n -0.000845 87.5200n -0.000865 87.5300n -0.000878 87.5400n -0.000883 87.5500n -0.000880 87.5600n -0.000866 87.5700n -0.000842 87.5800n -0.000805 87.5900n -0.000756
+ 87.6000n -0.000694 87.6100n -0.000618 87.6200n -0.000527 87.6300n -0.000422 87.6400n -0.000303 87.6500n -0.000170 87.6600n -0.000024 87.6700n 0.000136 87.6800n 0.000306 87.6900n 0.000487 87.7000n 0.000677 87.7100n 0.000873 87.7200n 0.001074 87.7300n 0.001277 87.7400n 0.001481
+ 87.7500n 0.001682 87.7600n 0.001877 87.7700n 0.002065 87.7800n 0.002243 87.7900n 0.002408 87.8000n 0.002557 87.8100n 0.002689 87.8200n 0.002801 87.8300n 0.002892 87.8400n 0.002961 87.8500n 0.003005 87.8600n 0.003025 87.8700n 0.003019 87.8800n 0.002989 87.8900n 0.002935
+ 87.9000n 0.002857 87.9100n 0.002758 87.9200n 0.002639 87.9300n 0.002502 87.9400n 0.002349 87.9500n 0.002184 87.9600n 0.002010 87.9700n 0.001830 87.9800n 0.001647 87.9900n 0.001466 88.0000n 0.001289 88.0100n 0.001120 88.0200n 0.000962 88.0300n 0.000819 88.0400n 0.000693
+ 88.0500n 0.000587 88.0600n 0.000502 88.0700n 0.000442 88.0800n 0.000406 88.0900n 0.000396 88.1000n 0.000412 88.1100n 0.000454 88.1200n 0.000520 88.1300n 0.000609 88.1400n 0.000720 88.1500n 0.000850 88.1600n 0.000996 88.1700n 0.001156 88.1800n 0.001325 88.1900n 0.001501
+ 88.2000n 0.001678 88.2100n 0.001855 88.2200n 0.002026 88.2300n 0.002188 88.2400n 0.002337 88.2500n 0.002470 88.2600n 0.002583 88.2700n 0.002675 88.2800n 0.002743 88.2900n 0.002784 88.3000n 0.002799 88.3100n 0.002785 88.3200n 0.002744 88.3300n 0.002675 88.3400n 0.002579
+ 88.3500n 0.002459 88.3600n 0.002316 88.3700n 0.002152 88.3800n 0.001971 88.3900n 0.001776 88.4000n 0.001571 88.4100n 0.001359 88.4200n 0.001145 88.4300n 0.000932 88.4400n 0.000724 88.4500n 0.000526 88.4600n 0.000340 88.4700n 0.000171 88.4800n 0.000020 88.4900n -0.000109
+ 88.5000n -0.000214 88.5100n -0.000294 88.5200n -0.000348 88.5300n -0.000376 88.5400n -0.000378 88.5500n -0.000354 88.5600n -0.000306 88.5700n -0.000236 88.5800n -0.000146 88.5900n -0.000039 88.6000n 0.000081 88.6100n 0.000212 88.6200n 0.000350 88.6300n 0.000490 88.6400n 0.000629
+ 88.6500n 0.000764 88.6600n 0.000889 88.6700n 0.001003 88.6800n 0.001101 88.6900n 0.001180 88.7000n 0.001239 88.7100n 0.001276 88.7200n 0.001288 88.7300n 0.001275 88.7400n 0.001237 88.7500n 0.001174 88.7600n 0.001087 88.7700n 0.000977 88.7800n 0.000846 88.7900n 0.000698
+ 88.8000n 0.000534 88.8100n 0.000358 88.8200n 0.000173 88.8300n -0.000016 88.8400n -0.000206 88.8500n -0.000393 88.8600n -0.000573 88.8700n -0.000742 88.8800n -0.000897 88.8900n -0.001033 88.9000n -0.001150 88.9100n -0.001242 88.9200n -0.001310 88.9300n -0.001351 88.9400n -0.001365
+ 88.9500n -0.001350 88.9600n -0.001309 88.9700n -0.001240 88.9800n -0.001146 88.9900n -0.001028 89.0000n -0.000890 89.0100n -0.000734 89.0200n -0.000563 89.0300n -0.000381 89.0400n -0.000192 89.0500n -0.000000 89.0600n 0.000191 89.0700n 0.000377 89.0800n 0.000555 89.0900n 0.000720
+ 89.1000n 0.000868 89.1100n 0.000997 89.1200n 0.001104 89.1300n 0.001187 89.1400n 0.001243 89.1500n 0.001272 89.1600n 0.001273 89.1700n 0.001245 89.1800n 0.001189 89.1900n 0.001107 89.2000n 0.000999 89.2100n 0.000868 89.2200n 0.000716 89.2300n 0.000546 89.2400n 0.000361
+ 89.2500n 0.000166 89.2600n -0.000038 89.2700n -0.000245 89.2800n -0.000452 89.2900n -0.000655 89.3000n -0.000850 89.3100n -0.001034 89.3200n -0.001204 89.3300n -0.001357 89.3400n -0.001489 89.3500n -0.001600 89.3600n -0.001686 89.3700n -0.001748 89.3800n -0.001783 89.3900n -0.001792
+ 89.4000n -0.001776 89.4100n -0.001734 89.4200n -0.001667 89.4300n -0.001578 89.4400n -0.001468 89.4500n -0.001340 89.4600n -0.001195 89.4700n -0.001036 89.4800n -0.000867 89.4900n -0.000689 89.5000n -0.000507 89.5100n -0.000323 89.5200n -0.000139 89.5300n 0.000041 89.5400n 0.000215
+ 89.5500n 0.000380 89.5600n 0.000535 89.5700n 0.000677 89.5800n 0.000806 89.5900n 0.000919 89.6000n 0.001017 89.6100n 0.001097 89.6200n 0.001161 89.6300n 0.001207 89.6400n 0.001236 89.6500n 0.001249 89.6600n 0.001246 89.6700n 0.001228 89.6800n 0.001195 89.6900n 0.001149
+ 89.7000n 0.001090 89.7100n 0.001020 89.7200n 0.000940 89.7300n 0.000851 89.7400n 0.000754 89.7500n 0.000650 89.7600n 0.000539 89.7700n 0.000423 89.7800n 0.000302 89.7900n 0.000176 89.8000n 0.000047 89.8100n -0.000086 89.8200n -0.000221 89.8300n -0.000360 89.8400n -0.000501
+ 89.8500n -0.000645 89.8600n -0.000790 89.8700n -0.000938 89.8800n -0.001086 89.8900n -0.001236 89.9000n -0.001385 89.9100n -0.001535 89.9200n -0.001683 89.9300n -0.001830 89.9400n -0.001973 89.9500n -0.002112 89.9600n -0.002246 89.9700n -0.002374 89.9800n -0.002493 89.9900n -0.002603
+ 90.0000n -0.002702 90.0100n -0.002789 90.0200n -0.002861 90.0300n -0.002919 90.0400n -0.002960 90.0500n -0.002984 90.0600n -0.002990 90.0700n -0.002976 90.0800n -0.002944 90.0900n -0.002891 90.1000n -0.002819 90.1100n -0.002729 90.1200n -0.002620 90.1300n -0.002493 90.1400n -0.002351
+ 90.1500n -0.002195 90.1600n -0.002026 90.1700n -0.001847 90.1800n -0.001661 90.1900n -0.001469 90.2000n -0.001275 90.2100n -0.001081 90.2200n -0.000890 90.2300n -0.000705 90.2400n -0.000530 90.2500n -0.000365 90.2600n -0.000214 90.2700n -0.000080 90.2800n 0.000036 90.2900n 0.000133
+ 90.3000n 0.000208 90.3100n 0.000260 90.3200n 0.000290 90.3300n 0.000297 90.3400n 0.000280 90.3500n 0.000242 90.3600n 0.000181 90.3700n 0.000101 90.3800n 0.000002 90.3900n -0.000114 90.4000n -0.000244 90.4100n -0.000386 90.4200n -0.000536 90.4300n -0.000694 90.4400n -0.000855
+ 90.4500n -0.001016 90.4600n -0.001175 90.4700n -0.001329 90.4800n -0.001476 90.4900n -0.001613 90.5000n -0.001737 90.5100n -0.001847 90.5200n -0.001942 90.5300n -0.002019 90.5400n -0.002078 90.5500n -0.002118 90.5600n -0.002140 90.5700n -0.002143 90.5800n -0.002127 90.5900n -0.002093
+ 90.6000n -0.002042 90.6100n -0.001976 90.6200n -0.001896 90.6300n -0.001804 90.6400n -0.001701 90.6500n -0.001589 90.6600n -0.001470 90.6700n -0.001347 90.6800n -0.001221 90.6900n -0.001095 90.7000n -0.000968 90.7100n -0.000845 90.7200n -0.000725 90.7300n -0.000611 90.7400n -0.000503
+ 90.7500n -0.000402 90.7600n -0.000309 90.7700n -0.000225 90.7800n -0.000148 90.7900n -0.000081 90.8000n -0.000022 90.8100n 0.000029 90.8200n 0.000072 90.8300n 0.000108 90.8400n 0.000136 90.8500n 0.000159 90.8600n 0.000176 90.8700n 0.000188 90.8800n 0.000196 90.8900n 0.000200
+ 90.9000n 0.000201 90.9100n 0.000198 90.9200n 0.000192 90.9300n 0.000184 90.9400n 0.000173 90.9500n 0.000159 90.9600n 0.000142 90.9700n 0.000121 90.9800n 0.000097 90.9900n 0.000068 91.0000n 0.000035 91.0100n -0.000004 91.0200n -0.000048 91.0300n -0.000098 91.0400n -0.000154
+ 91.0500n -0.000217 91.0600n -0.000287 91.0700n -0.000364 91.0800n -0.000447 91.0900n -0.000536 91.1000n -0.000630 91.1100n -0.000730 91.1200n -0.000833 91.1300n -0.000940 91.1400n -0.001048 91.1500n -0.001157 91.1600n -0.001265 91.1700n -0.001370 91.1800n -0.001471 91.1900n -0.001567
+ 91.2000n -0.001656 91.2100n -0.001736 91.2200n -0.001806 91.2300n -0.001864 91.2400n -0.001911 91.2500n -0.001944 91.2600n -0.001964 91.2700n -0.001969 91.2800n -0.001960 91.2900n -0.001937 91.3000n -0.001899 91.3100n -0.001849 91.3200n -0.001787 91.3300n -0.001713 91.3400n -0.001630
+ 91.3500n -0.001539 91.3600n -0.001442 91.3700n -0.001341 91.3800n -0.001238 91.3900n -0.001135 91.4000n -0.001034 91.4100n -0.000938 91.4200n -0.000848 91.4300n -0.000765 91.4400n -0.000692 91.4500n -0.000631 91.4600n -0.000581 91.4700n -0.000545 91.4800n -0.000522 91.4900n -0.000514
+ 91.5000n -0.000519 91.5100n -0.000537 91.5200n -0.000569 91.5300n -0.000612 91.5400n -0.000665 91.5500n -0.000727 91.5600n -0.000797 91.5700n -0.000871 91.5800n -0.000948 91.5900n -0.001026 91.6000n -0.001103 91.6100n -0.001176 91.6200n -0.001243 91.6300n -0.001303 91.6400n -0.001353
+ 91.6500n -0.001393 91.6600n -0.001419 91.6700n -0.001433 91.6800n -0.001432 91.6900n -0.001416 91.7000n -0.001386 91.7100n -0.001341 91.7200n -0.001282 91.7300n -0.001210 91.7400n -0.001126 91.7500n -0.001031 91.7600n -0.000928 91.7700n -0.000818 91.7800n -0.000703 91.7900n -0.000584
+ 91.8000n -0.000465 91.8100n -0.000347 91.8200n -0.000233 91.8300n -0.000123 91.8400n -0.000020 91.8500n 0.000074 91.8600n 0.000159 91.8700n 0.000234 91.8800n 0.000297 91.8900n 0.000348 91.9000n 0.000388 91.9100n 0.000416 91.9200n 0.000434 91.9300n 0.000441 91.9400n 0.000440
+ 91.9500n 0.000430 91.9600n 0.000415 91.9700n 0.000396 91.9800n 0.000373 91.9900n 0.000350 92.0000n 0.000327 92.0100n 0.000308 92.0200n 0.000292 92.0300n 0.000282 92.0400n 0.000278 92.0500n 0.000283 92.0600n 0.000295 92.0700n 0.000317 92.0800n 0.000347 92.0900n 0.000386
+ 92.1000n 0.000432 92.1100n 0.000486 92.1200n 0.000545 92.1300n 0.000609 92.1400n 0.000675 92.1500n 0.000742 92.1600n 0.000807 92.1700n 0.000869 92.1800n 0.000925 92.1900n 0.000974 92.2000n 0.001013 92.2100n 0.001041 92.2200n 0.001056 92.2300n 0.001057 92.2400n 0.001043
+ 92.2500n 0.001013 92.2600n 0.000968 92.2700n 0.000907 92.2800n 0.000832 92.2900n 0.000743 92.3000n 0.000642 92.3100n 0.000530 92.3200n 0.000412 92.3300n 0.000288 92.3400n 0.000162 92.3500n 0.000037 92.3600n -0.000084 92.3700n -0.000198 92.3800n -0.000300 92.3900n -0.000389
+ 92.4000n -0.000460 92.4100n -0.000512 92.4200n -0.000541 92.4300n -0.000547 92.4400n -0.000526 92.4500n -0.000479 92.4600n -0.000405 92.4700n -0.000304 92.4800n -0.000177 92.4900n -0.000025 92.5000n 0.000150 92.5100n 0.000345 92.5200n 0.000558 92.5300n 0.000784 92.5400n 0.001020
+ 92.5500n 0.001261 92.5600n 0.001502 92.5700n 0.001740 92.5800n 0.001969 92.5900n 0.002184 92.6000n 0.002381 92.6100n 0.002556 92.6200n 0.002704 92.6300n 0.002821 92.6400n 0.002906 92.6500n 0.002955 92.6600n 0.002966 92.6700n 0.002939 92.6800n 0.002873 92.6900n 0.002769
+ 92.7000n 0.002629 92.7100n 0.002453 92.7200n 0.002245 92.7300n 0.002008 92.7400n 0.001747 92.7500n 0.001466 92.7600n 0.001170 92.7700n 0.000865 92.7800n 0.000557 92.7900n 0.000250 92.8000n -0.000049 92.8100n -0.000333 92.8200n -0.000599 92.8300n -0.000840 92.8400n -0.001053
+ 92.8500n -0.001232 92.8600n -0.001375 92.8700n -0.001479 92.8800n -0.001542 92.8900n -0.001563 92.9000n -0.001542 92.9100n -0.001480 92.9200n -0.001378 92.9300n -0.001239 92.9400n -0.001067 92.9500n -0.000864 92.9600n -0.000636 92.9700n -0.000389 92.9800n -0.000127 92.9900n 0.000143
+ 93.0000n 0.000416 93.0100n 0.000684 93.0200n 0.000942 93.0300n 0.001183 93.0400n 0.001403 93.0500n 0.001595 93.0600n 0.001755 93.0700n 0.001880 93.0800n 0.001966 93.0900n 0.002010 93.1000n 0.002011 93.1100n 0.001969 93.1200n 0.001883 93.1300n 0.001755 93.1400n 0.001588
+ 93.1500n 0.001383 93.1600n 0.001145 93.1700n 0.000878 93.1800n 0.000587 93.1900n 0.000279 93.2000n -0.000042 93.2100n -0.000369 93.2200n -0.000695 93.2300n -0.001015 93.2400n -0.001322 93.2500n -0.001609 93.2600n -0.001872 93.2700n -0.002106 93.2800n -0.002306 93.2900n -0.002468
+ 93.3000n -0.002589 93.3100n -0.002668 93.3200n -0.002703 93.3300n -0.002694 93.3400n -0.002642 93.3500n -0.002548 93.3600n -0.002413 93.3700n -0.002243 93.3800n -0.002040 93.3900n -0.001808 93.4000n -0.001553 93.4100n -0.001281 93.4200n -0.000996 93.4300n -0.000706 93.4400n -0.000414
+ 93.4500n -0.000129 93.4600n 0.000146 93.4700n 0.000404 93.4800n 0.000640 93.4900n 0.000852 93.5000n 0.001034 93.5100n 0.001183 93.5200n 0.001299 93.5300n 0.001378 93.5400n 0.001421 93.5500n 0.001428 93.5600n 0.001400 93.5700n 0.001338 93.5800n 0.001245 93.5900n 0.001125
+ 93.6000n 0.000980 93.6100n 0.000816 93.6200n 0.000636 93.6300n 0.000446 93.6400n 0.000251 93.6500n 0.000055 93.6600n -0.000136 93.6700n -0.000318 93.6800n -0.000486 93.6900n -0.000635 93.7000n -0.000763 93.7100n -0.000866 93.7200n -0.000942 93.7300n -0.000988 93.7400n -0.001004
+ 93.7500n -0.000990 93.7600n -0.000945 93.7700n -0.000871 93.7800n -0.000769 93.7900n -0.000641 93.8000n -0.000491 93.8100n -0.000321 93.8200n -0.000136 93.8300n 0.000061 93.8400n 0.000266 93.8500n 0.000473 93.8600n 0.000680 93.8700n 0.000881 93.8800n 0.001072 93.8900n 0.001251
+ 93.9000n 0.001412 93.9100n 0.001554 93.9200n 0.001673 93.9300n 0.001768 93.9400n 0.001837 93.9500n 0.001880 93.9600n 0.001896 93.9700n 0.001885 93.9800n 0.001848 93.9900n 0.001787 94.0000n 0.001703 94.0100n 0.001600 94.0200n 0.001479 94.0300n 0.001344 94.0400n 0.001197
+ 94.0500n 0.001043 94.0600n 0.000884 94.0700n 0.000724 94.0800n 0.000567 94.0900n 0.000414 94.1000n 0.000269 94.1100n 0.000134 94.1200n 0.000012 94.1300n -0.000097 94.1400n -0.000190 94.1500n -0.000267 94.1600n -0.000327 94.1700n -0.000372 94.1800n -0.000400 94.1900n -0.000415
+ 94.2000n -0.000415 94.2100n -0.000405 94.2200n -0.000384 94.2300n -0.000356 94.2400n -0.000322 94.2500n -0.000285 94.2600n -0.000246 94.2700n -0.000209 94.2800n -0.000175 94.2900n -0.000146 94.3000n -0.000123 94.3100n -0.000108 94.3200n -0.000100 94.3300n -0.000102 94.3400n -0.000112
+ 94.3500n -0.000130 94.3600n -0.000156 94.3700n -0.000188 94.3800n -0.000225 94.3900n -0.000265 94.4000n -0.000305 94.4100n -0.000345 94.4200n -0.000380 94.4300n -0.000408 94.4400n -0.000428 94.4500n -0.000436 94.4600n -0.000431 94.4700n -0.000409 94.4800n -0.000370 94.4900n -0.000312
+ 94.5000n -0.000233 94.5100n -0.000134 94.5200n -0.000013 94.5300n 0.000128 94.5400n 0.000288 94.5500n 0.000467 94.5600n 0.000663 94.5700n 0.000872 94.5800n 0.001093 94.5900n 0.001322 94.6000n 0.001555 94.6100n 0.001789 94.6200n 0.002019 94.6300n 0.002243 94.6400n 0.002454
+ 94.6500n 0.002649 94.6600n 0.002825 94.6700n 0.002978 94.6800n 0.003103 94.6900n 0.003198 94.7000n 0.003261 94.7100n 0.003288 94.7200n 0.003280 94.7300n 0.003234 94.7400n 0.003150 94.7500n 0.003029 94.7600n 0.002872 94.7700n 0.002680 94.7800n 0.002456 94.7900n 0.002202
+ 94.8000n 0.001921 94.8100n 0.001618 94.8200n 0.001297 94.8300n 0.000961 94.8400n 0.000617 94.8500n 0.000268 94.8600n -0.000080 94.8700n -0.000423 94.8800n -0.000755 94.8900n -0.001071 94.9000n -0.001369 94.9100n -0.001642 94.9200n -0.001888 94.9300n -0.002104 94.9400n -0.002288
+ 94.9500n -0.002436 94.9600n -0.002548 94.9700n -0.002623 94.9800n -0.002661 94.9900n -0.002662 95.0000n -0.002627 95.0100n -0.002559 95.0200n -0.002458 95.0300n -0.002328 95.0400n -0.002171 95.0500n -0.001992 95.0600n -0.001793 95.0700n -0.001578 95.0800n -0.001352 95.0900n -0.001118
+ 95.1000n -0.000881 95.1100n -0.000644 95.1200n -0.000412 95.1300n -0.000187 95.1400n 0.000027 95.1500n 0.000226 95.1600n 0.000409 95.1700n 0.000574 95.1800n 0.000717 95.1900n 0.000839 95.2000n 0.000937 95.2100n 0.001012 95.2200n 0.001064 95.2300n 0.001092 95.2400n 0.001098
+ 95.2500n 0.001083 95.2600n 0.001048 95.2700n 0.000994 95.2800n 0.000924 95.2900n 0.000839 95.3000n 0.000743 95.3100n 0.000636 95.3200n 0.000522 95.3300n 0.000403 95.3400n 0.000281 95.3500n 0.000158 95.3600n 0.000037 95.3700n -0.000081 95.3800n -0.000194 95.3900n -0.000300
+ 95.4000n -0.000398 95.4100n -0.000486 95.4200n -0.000564 95.4300n -0.000630 95.4400n -0.000685 95.4500n -0.000727 95.4600n -0.000757 95.4700n -0.000774 95.4800n -0.000779 95.4900n -0.000771 95.5000n -0.000752 95.5100n -0.000722 95.5200n -0.000681 95.5300n -0.000631 95.5400n -0.000571
+ 95.5500n -0.000502 95.5600n -0.000426 95.5700n -0.000343 95.5800n -0.000255 95.5900n -0.000162 95.6000n -0.000064 95.6100n 0.000037 95.6200n 0.000139 95.6300n 0.000243 95.6400n 0.000348 95.6500n 0.000451 95.6600n 0.000553 95.6700n 0.000653 95.6800n 0.000749 95.6900n 0.000841
+ 95.7000n 0.000928 95.7100n 0.001008 95.7200n 0.001081 95.7300n 0.001147 95.7400n 0.001203 95.7500n 0.001251 95.7600n 0.001288 95.7700n 0.001314 95.7800n 0.001329 95.7900n 0.001332 95.8000n 0.001323 95.8100n 0.001303 95.8200n 0.001270 95.8300n 0.001225 95.8400n 0.001169
+ 95.8500n 0.001102 95.8600n 0.001025 95.8700n 0.000939 95.8800n 0.000844 95.8900n 0.000743 95.9000n 0.000636 95.9100n 0.000525 95.9200n 0.000412 95.9300n 0.000298 95.9400n 0.000185 95.9500n 0.000075 95.9600n -0.000029 95.9700n -0.000127 95.9800n -0.000217 95.9900n -0.000296
+ 96.0000n -0.000363 96.0100n -0.000417 96.0200n -0.000457 96.0300n -0.000481 96.0400n -0.000490 96.0500n -0.000482 96.0600n -0.000457 96.0700n -0.000415 96.0800n -0.000357 96.0900n -0.000283 96.1000n -0.000195 96.1100n -0.000093 96.1200n 0.000021 96.1300n 0.000146 96.1400n 0.000278
+ 96.1500n 0.000418 96.1600n 0.000561 96.1700n 0.000707 96.1800n 0.000852 96.1900n 0.000995 96.2000n 0.001133 96.2100n 0.001264 96.2200n 0.001387 96.2300n 0.001498 96.2400n 0.001597 96.2500n 0.001682 96.2600n 0.001751 96.2700n 0.001805 96.2800n 0.001843 96.2900n 0.001863
+ 96.3000n 0.001867 96.3100n 0.001854 96.3200n 0.001825 96.3300n 0.001781 96.3400n 0.001723 96.3500n 0.001653 96.3600n 0.001572 96.3700n 0.001481 96.3800n 0.001383 96.3900n 0.001279 96.4000n 0.001172 96.4100n 0.001062 96.4200n 0.000953 96.4300n 0.000845 96.4400n 0.000740
+ 96.4500n 0.000640 96.4600n 0.000546 96.4700n 0.000459 96.4800n 0.000379 96.4900n 0.000308 96.5000n 0.000246 96.5100n 0.000191 96.5200n 0.000146 96.5300n 0.000108 96.5400n 0.000078 96.5500n 0.000055 96.5600n 0.000037 96.5700n 0.000023 96.5800n 0.000013 96.5900n 0.000006
+ 96.6000n -0.000000 96.6100n -0.000007 96.6200n -0.000015 96.6300n -0.000025 96.6400n -0.000037 96.6500n -0.000054 96.6600n -0.000075 96.6700n -0.000100 96.6800n -0.000131 96.6900n -0.000165 96.7000n -0.000204 96.7100n -0.000247 96.7200n -0.000293 96.7300n -0.000341 96.7400n -0.000390
+ 96.7500n -0.000439 96.7600n -0.000486 96.7700n -0.000531 96.7800n -0.000572 96.7900n -0.000608 96.8000n -0.000637 96.8100n -0.000658 96.8200n -0.000671 96.8300n -0.000674 96.8400n -0.000667 96.8500n -0.000649 96.8600n -0.000620 96.8700n -0.000581 96.8800n -0.000531 96.8900n -0.000471
+ 96.9000n -0.000402 96.9100n -0.000325 96.9200n -0.000241 96.9300n -0.000152 96.9400n -0.000059 96.9500n 0.000035 96.9600n 0.000130 96.9700n 0.000223 96.9800n 0.000312 96.9900n 0.000396 97.0000n 0.000473 97.0100n 0.000541 97.0200n 0.000599 97.0300n 0.000646 97.0400n 0.000681
+ 97.0500n 0.000704 97.0600n 0.000713 97.0700n 0.000710 97.0800n 0.000694 97.0900n 0.000666 97.1000n 0.000628 97.1100n 0.000580 97.1200n 0.000525 97.1300n 0.000463 97.1400n 0.000397 97.1500n 0.000329 97.1600n 0.000261 97.1700n 0.000196 97.1800n 0.000136 97.1900n 0.000083
+ 97.2000n 0.000038 97.2100n 0.000005 97.2200n -0.000015 97.2300n -0.000021 97.2400n -0.000012 97.2500n 0.000013 97.2600n 0.000055 97.2700n 0.000112 97.2800n 0.000186 97.2900n 0.000275 97.3000n 0.000377 97.3100n 0.000491 97.3200n 0.000615 97.3300n 0.000747 97.3400n 0.000884
+ 97.3500n 0.001023 97.3600n 0.001161 97.3700n 0.001295 97.3800n 0.001422 97.3900n 0.001538 97.4000n 0.001641 97.4100n 0.001727 97.4200n 0.001794 97.4300n 0.001839 97.4400n 0.001861 97.4500n 0.001857 97.4600n 0.001827 97.4700n 0.001770 97.4800n 0.001684 97.4900n 0.001572
+ 97.5000n 0.001433 97.5100n 0.001269 97.5200n 0.001081 97.5300n 0.000873 97.5400n 0.000646 97.5500n 0.000404 97.5600n 0.000150 97.5700n -0.000111 97.5800n -0.000377 97.5900n -0.000642 97.6000n -0.000904 97.6100n -0.001157 97.6200n -0.001397 97.6300n -0.001621 97.6400n -0.001825
+ 97.6500n -0.002006 97.6600n -0.002161 97.6700n -0.002287 97.6800n -0.002383 97.6900n -0.002446 97.7000n -0.002476 97.7100n -0.002473 97.7200n -0.002436 97.7300n -0.002367 97.7400n -0.002266 97.7500n -0.002136 97.7600n -0.001979 97.7700n -0.001797 97.7800n -0.001594 97.7900n -0.001373
+ 97.8000n -0.001137 97.8100n -0.000891 97.8200n -0.000639 97.8300n -0.000385 97.8400n -0.000132 97.8500n 0.000115 97.8600n 0.000353 97.8700n 0.000578 97.8800n 0.000788 97.8900n 0.000978 97.9000n 0.001148 97.9100n 0.001295 97.9200n 0.001418 97.9300n 0.001516 97.9400n 0.001587
+ 97.9500n 0.001633 97.9600n 0.001654 97.9700n 0.001651 97.9800n 0.001625 97.9900n 0.001579 98.0000n 0.001513 98.0100n 0.001432 98.0200n 0.001336 98.0300n 0.001230 98.0400n 0.001117 98.0500n 0.000999 98.0600n 0.000879 98.0700n 0.000761 98.0800n 0.000648 98.0900n 0.000541
+ 98.1000n 0.000444 98.1100n 0.000358 98.1200n 0.000286 98.1300n 0.000229 98.1400n 0.000188 98.1500n 0.000164 98.1600n 0.000158 98.1700n 0.000168 98.1800n 0.000196 98.1900n 0.000239 98.2000n 0.000298 98.2100n 0.000370 98.2200n 0.000454 98.2300n 0.000547 98.2400n 0.000649
+ 98.2500n 0.000756 98.2600n 0.000866 98.2700n 0.000977 98.2800n 0.001087 98.2900n 0.001192 98.3000n 0.001291 98.3100n 0.001382 98.3200n 0.001463 98.3300n 0.001532 98.3400n 0.001587 98.3500n 0.001628 98.3600n 0.001653 98.3700n 0.001662 98.3800n 0.001654 98.3900n 0.001630
+ 98.4000n 0.001590 98.4100n 0.001534 98.4200n 0.001463 98.4300n 0.001378 98.4400n 0.001282 98.4500n 0.001174 98.4600n 0.001057 98.4700n 0.000933 98.4800n 0.000803 98.4900n 0.000670 98.5000n 0.000536 98.5100n 0.000402 98.5200n 0.000270 98.5300n 0.000144 98.5400n 0.000023
+ 98.5500n -0.000090 98.5600n -0.000194 98.5700n -0.000287 98.5800n -0.000368 98.5900n -0.000437 98.6000n -0.000493 98.6100n -0.000535 98.6200n -0.000563 98.6300n -0.000577 98.6400n -0.000578 98.6500n -0.000567 98.6600n -0.000542 98.6700n -0.000507 98.6800n -0.000461 98.6900n -0.000407
+ 98.7000n -0.000344 98.7100n -0.000276 98.7200n -0.000202 98.7300n -0.000126 98.7400n -0.000049 98.7500n 0.000028 98.7600n 0.000104 98.7700n 0.000175 98.7800n 0.000242 98.7900n 0.000302 98.8000n 0.000354 98.8100n 0.000397 98.8200n 0.000429 98.8300n 0.000450 98.8400n 0.000460
+ 98.8500n 0.000457 98.8600n 0.000440 98.8700n 0.000411 98.8800n 0.000369 98.8900n 0.000314 98.9000n 0.000246 98.9100n 0.000167 98.9200n 0.000076 98.9300n -0.000024 98.9400n -0.000134 98.9500n -0.000252 98.9600n -0.000376 98.9700n -0.000505 98.9800n -0.000638 98.9900n -0.000772
+ 99.0000n -0.000907 99.0100n -0.001040 99.0200n -0.001170 99.0300n -0.001295 99.0400n -0.001414 99.0500n -0.001526 99.0600n -0.001628 99.0700n -0.001721 99.0800n -0.001802 99.0900n -0.001871 99.1000n -0.001927 99.1100n -0.001970 99.1200n -0.001999 99.1300n -0.002014 99.1400n -0.002016
+ 99.1500n -0.002005 99.1600n -0.001981 99.1700n -0.001945 99.1800n -0.001898 99.1900n -0.001841 99.2000n -0.001776 99.2100n -0.001703 99.2200n -0.001624 99.2300n -0.001542 99.2400n -0.001456 99.2500n -0.001369 99.2600n -0.001283 99.2700n -0.001199 99.2800n -0.001118 99.2900n -0.001043
+ 99.3000n -0.000974 99.3100n -0.000912 99.3200n -0.000858 99.3300n -0.000813 99.3400n -0.000778 99.3500n -0.000753 99.3600n -0.000738 99.3700n -0.000734 99.3800n -0.000739 99.3900n -0.000753 99.4000n -0.000776 99.4100n -0.000806 99.4200n -0.000844 99.4300n -0.000886 99.4400n -0.000934
+ 99.4500n -0.000984 99.4600n -0.001036 99.4700n -0.001088 99.4800n -0.001139 99.4900n -0.001188 99.5000n -0.001233 99.5100n -0.001273 99.5200n -0.001308 99.5300n -0.001336 99.5400n -0.001357 99.5500n -0.001371 99.5600n -0.001377 99.5700n -0.001375 99.5800n -0.001366 99.5900n -0.001349
+ 99.6000n -0.001326 99.6100n -0.001297 99.6200n -0.001263 99.6300n -0.001226 99.6400n -0.001186 99.6500n -0.001144 99.6600n -0.001102 99.6700n -0.001061 99.6800n -0.001023 99.6900n -0.000988 99.7000n -0.000958 99.7100n -0.000934 99.7200n -0.000916 99.7300n -0.000905 99.7400n -0.000902
+ 99.7500n -0.000906 99.7600n -0.000917 99.7700n -0.000936 99.7800n -0.000961 99.7900n -0.000992 99.8000n -0.001028 99.8100n -0.001068 99.8200n -0.001109 99.8300n -0.001152 99.8400n -0.001193 99.8500n -0.001231 99.8600n -0.001265 99.8700n -0.001292 99.8800n -0.001311 99.8900n -0.001320
+ 99.9000n -0.001317 99.9100n -0.001302 99.9200n -0.001272 99.9300n -0.001228 99.9400n -0.001168 99.9500n -0.001091 99.9600n -0.000999 99.9700n -0.000891 99.9800n -0.000767 99.9900n -0.000630 100.0000n -0.000478 100.0100n -0.000315 100.0200n -0.000142 100.0300n 0.000039 100.0400n 0.000226
+ 100.0500n 0.000417 100.0600n 0.000609 100.0700n 0.000800 100.0800n 0.000988 100.0900n 0.001169 100.1000n 0.001342 100.1100n 0.001505 100.1200n 0.001655 100.1300n 0.001791 100.1400n 0.001912 100.1500n 0.002015 100.1600n 0.002101 100.1700n 0.002169 100.1800n 0.002218 100.1900n 0.002249
+ 100.2000n 0.002262 100.2100n 0.002258 100.2200n 0.002238 100.2300n 0.002203 100.2400n 0.002156 100.2500n 0.002097 100.2600n 0.002028 100.2700n 0.001953 100.2800n 0.001871 100.2900n 0.001787 100.3000n 0.001700 100.3100n 0.001614 100.3200n 0.001530 100.3300n 0.001450 100.3400n 0.001373
+ 100.3500n 0.001302 100.3600n 0.001238 100.3700n 0.001179 100.3800n 0.001127 100.3900n 0.001081 100.4000n 0.001041 100.4100n 0.001005 100.4200n 0.000972 100.4300n 0.000941 100.4400n 0.000911 100.4500n 0.000880 100.4600n 0.000846 100.4700n 0.000807 100.4800n 0.000762 100.4900n 0.000709
+ 100.5000n 0.000646 100.5100n 0.000573 100.5200n 0.000489 100.5300n 0.000392 100.5400n 0.000283 100.5500n 0.000161 100.5600n 0.000027 100.5700n -0.000117 100.5800n -0.000272 100.5900n -0.000435 100.6000n -0.000605 100.6100n -0.000778 100.6200n -0.000953 100.6300n -0.001127 100.6400n -0.001295
+ 100.6500n -0.001456 100.6600n -0.001607 100.6700n -0.001743 100.6800n -0.001861 100.6900n -0.001960 100.7000n -0.002036 100.7100n -0.002087 100.7200n -0.002111 100.7300n -0.002107 100.7400n -0.002073 100.7500n -0.002010 100.7600n -0.001917 100.7700n -0.001796 100.7800n -0.001647 100.7900n -0.001472
+ 100.8000n -0.001275 100.8100n -0.001058 100.8200n -0.000824 100.8300n -0.000579 100.8400n -0.000325 100.8500n -0.000068 100.8600n 0.000188 100.8700n 0.000437 100.8800n 0.000676 100.8900n 0.000898 100.9000n 0.001101 100.9100n 0.001279 100.9200n 0.001428 100.9300n 0.001546 100.9400n 0.001630
+ 100.9500n 0.001678 100.9600n 0.001688 100.9700n 0.001661 100.9800n 0.001595 100.9900n 0.001492 101.0000n 0.001353 101.0100n 0.001182 101.0200n 0.000981 101.0300n 0.000754 101.0400n 0.000506 101.0500n 0.000241 101.0600n -0.000036 101.0700n -0.000318 101.0800n -0.000600 101.0900n -0.000876
+ 101.1000n -0.001141 101.1100n -0.001388 101.1200n -0.001613 101.1300n -0.001811 101.1400n -0.001976 101.1500n -0.002106 101.1600n -0.002197 101.1700n -0.002246 101.1800n -0.002253 101.1900n -0.002216 101.2000n -0.002137 101.2100n -0.002014 101.2200n -0.001852 101.2300n -0.001652 101.2400n -0.001418
+ 101.2500n -0.001154 101.2600n -0.000865 101.2700n -0.000556 101.2800n -0.000234 101.2900n 0.000097 101.3000n 0.000429 101.3100n 0.000757 101.3200n 0.001074 101.3300n 0.001374 101.3400n 0.001652 101.3500n 0.001902 101.3600n 0.002120 101.3700n 0.002303 101.3800n 0.002446 101.3900n 0.002547
+ 101.4000n 0.002605 101.4100n 0.002620 101.4200n 0.002591 101.4300n 0.002519 101.4400n 0.002407 101.4500n 0.002257 101.4600n 0.002073 101.4700n 0.001859 101.4800n 0.001620 101.4900n 0.001362 101.5000n 0.001089 101.5100n 0.000807 101.5200n 0.000524 101.5300n 0.000244 101.5400n -0.000027
+ 101.5500n -0.000282 101.5600n -0.000516 101.5700n -0.000726 101.5800n -0.000906 101.5900n -0.001053 101.6000n -0.001164 101.6100n -0.001237 101.6200n -0.001272 101.6300n -0.001267 101.6400n -0.001223 101.6500n -0.001141 101.6600n -0.001023 101.6700n -0.000872 101.6800n -0.000692 101.6900n -0.000486
+ 101.7000n -0.000258 101.7100n -0.000013 101.7200n 0.000243 101.7300n 0.000506 101.7400n 0.000771 101.7500n 0.001032 101.7600n 0.001285 101.7700n 0.001526 101.7800n 0.001749 101.7900n 0.001952 101.8000n 0.002132 101.8100n 0.002285 101.8200n 0.002411 101.8300n 0.002508 101.8400n 0.002576
+ 101.8500n 0.002616 101.8600n 0.002627 101.8700n 0.002612 101.8800n 0.002573 101.8900n 0.002513 101.9000n 0.002435 101.9100n 0.002342 101.9200n 0.002239 101.9300n 0.002128 101.9400n 0.002014 101.9500n 0.001901 101.9600n 0.001792 101.9700n 0.001691 101.9800n 0.001602 101.9900n 0.001526
+ 102.0000n 0.001466 102.0100n 0.001423 102.0200n 0.001399 102.0300n 0.001395 102.0400n 0.001409 102.0500n 0.001441 102.0600n 0.001490 102.0700n 0.001554 102.0800n 0.001631 102.0900n 0.001717 102.1000n 0.001809 102.1100n 0.001904 102.1200n 0.001998 102.1300n 0.002086 102.1400n 0.002167
+ 102.1500n 0.002234 102.1600n 0.002286 102.1700n 0.002318 102.1800n 0.002327 102.1900n 0.002312 102.2000n 0.002271 102.2100n 0.002201 102.2200n 0.002102 102.2300n 0.001974 102.2400n 0.001818 102.2500n 0.001635 102.2600n 0.001426 102.2700n 0.001194 102.2800n 0.000942 102.2900n 0.000673
+ 102.3000n 0.000391 102.3100n 0.000101 102.3200n -0.000193 102.3300n -0.000487 102.3400n -0.000776 102.3500n -0.001055 102.3600n -0.001321 102.3700n -0.001568 102.3800n -0.001793 102.3900n -0.001993 102.4000n -0.002165 102.4100n -0.002306 102.4200n -0.002414 102.4300n -0.002490 102.4400n -0.002531
+ 102.4500n -0.002539 102.4600n -0.002515 102.4700n -0.002459 102.4800n -0.002374 102.4900n -0.002264 102.5000n -0.002130 102.5100n -0.001977 102.5200n -0.001808 102.5300n -0.001628 102.5400n -0.001441 102.5500n -0.001252 102.5600n -0.001064 102.5700n -0.000882 102.5800n -0.000710 102.5900n -0.000551
+ 102.6000n -0.000409 102.6100n -0.000286 102.6200n -0.000184 102.6300n -0.000106 102.6400n -0.000052 102.6500n -0.000023 102.6600n -0.000018 102.6700n -0.000038 102.6800n -0.000080 102.6900n -0.000143 102.7000n -0.000225 102.7100n -0.000323 102.7200n -0.000433 102.7300n -0.000554 102.7400n -0.000681
+ 102.7500n -0.000812 102.7600n -0.000942 102.7700n -0.001068 102.7800n -0.001187 102.7900n -0.001296 102.8000n -0.001392 102.8100n -0.001474 102.8200n -0.001539 102.8300n -0.001586 102.8400n -0.001615 102.8500n -0.001624 102.8600n -0.001615 102.8700n -0.001588 102.8800n -0.001544 102.8900n -0.001485
+ 102.9000n -0.001412 102.9100n -0.001329 102.9200n -0.001238 102.9300n -0.001142 102.9400n -0.001043 102.9500n -0.000946 102.9600n -0.000852 102.9700n -0.000765 102.9800n -0.000687 102.9900n -0.000621 103.0000n -0.000570 103.0100n -0.000533 103.0200n -0.000514 103.0300n -0.000512 103.0400n -0.000528
+ 103.0500n -0.000562 103.0600n -0.000613 103.0700n -0.000679 103.0800n -0.000760 103.0900n -0.000853 103.1000n -0.000955 103.1100n -0.001063 103.1200n -0.001176 103.1300n -0.001288 103.1400n -0.001398 103.1500n -0.001501 103.1600n -0.001594 103.1700n -0.001674 103.1800n -0.001738 103.1900n -0.001784
+ 103.2000n -0.001809 103.2100n -0.001812 103.2200n -0.001790 103.2300n -0.001743 103.2400n -0.001672 103.2500n -0.001575 103.2600n -0.001454 103.2700n -0.001309 103.2800n -0.001144 103.2900n -0.000961 103.3000n -0.000761 103.3100n -0.000548 103.3200n -0.000327 103.3300n -0.000099 103.3400n 0.000129
+ 103.3500n 0.000356 103.3600n 0.000576 103.3700n 0.000786 103.3800n 0.000983 103.3900n 0.001161 103.4000n 0.001320 103.4100n 0.001455 103.4200n 0.001565 103.4300n 0.001648 103.4400n 0.001703 103.4500n 0.001729 103.4600n 0.001726 103.4700n 0.001695 103.4800n 0.001637 103.4900n 0.001553
+ 103.5000n 0.001446 103.5100n 0.001319 103.5200n 0.001174 103.5300n 0.001016 103.5400n 0.000847 103.5500n 0.000672 103.5600n 0.000494 103.5700n 0.000318 103.5800n 0.000148 103.5900n -0.000013 103.6000n -0.000161 103.6100n -0.000292 103.6200n -0.000404 103.6300n -0.000495 103.6400n -0.000562
+ 103.6500n -0.000604 103.6600n -0.000620 103.6700n -0.000609 103.6800n -0.000572 103.6900n -0.000510 103.7000n -0.000424 103.7100n -0.000315 103.7200n -0.000187 103.7300n -0.000042 103.7400n 0.000117 103.7500n 0.000287 103.7600n 0.000463 103.7700n 0.000643 103.7800n 0.000821 103.7900n 0.000995
+ 103.8000n 0.001160 103.8100n 0.001312 103.8200n 0.001448 103.8300n 0.001566 103.8400n 0.001661 103.8500n 0.001732 103.8600n 0.001776 103.8700n 0.001792 103.8800n 0.001780 103.8900n 0.001737 103.9000n 0.001665 103.9100n 0.001563 103.9200n 0.001433 103.9300n 0.001277 103.9400n 0.001095
+ 103.9500n 0.000890 103.9600n 0.000666 103.9700n 0.000424 103.9800n 0.000168 103.9900n -0.000099 104.0000n -0.000373 104.0100n -0.000651 104.0200n -0.000928 104.0300n -0.001203 104.0400n -0.001470 104.0500n -0.001728 104.0600n -0.001972 104.0700n -0.002200 104.0800n -0.002409 104.0900n -0.002598
+ 104.1000n -0.002763 104.1100n -0.002904 104.1200n -0.003018 104.1300n -0.003106 104.1400n -0.003166 104.1500n -0.003199 104.1600n -0.003203 104.1700n -0.003180 104.1800n -0.003129 104.1900n -0.003053 104.2000n -0.002951 104.2100n -0.002826 104.2200n -0.002678 104.2300n -0.002509 104.2400n -0.002322
+ 104.2500n -0.002117 104.2600n -0.001898 104.2700n -0.001665 104.2800n -0.001421 104.2900n -0.001168 104.3000n -0.000908 104.3100n -0.000643 104.3200n -0.000376 104.3300n -0.000108 104.3400n 0.000159 104.3500n 0.000423 104.3600n 0.000681 104.3700n 0.000933 104.3800n 0.001175 104.3900n 0.001406
+ 104.4000n 0.001625 104.4100n 0.001830 104.4200n 0.002019 104.4300n 0.002190 104.4400n 0.002343 104.4500n 0.002476 104.4600n 0.002587 104.4700n 0.002677 104.4800n 0.002743 104.4900n 0.002785 104.5000n 0.002803 104.5100n 0.002796 104.5200n 0.002763 104.5300n 0.002706 104.5400n 0.002625
+ 104.5500n 0.002519 104.5600n 0.002390 104.5700n 0.002239 104.5800n 0.002067 104.5900n 0.001876 104.6000n 0.001667 104.6100n 0.001443 104.6200n 0.001205 104.6300n 0.000957 104.6400n 0.000702 104.6500n 0.000441 104.6600n 0.000177 104.6700n -0.000085 104.6800n -0.000343 104.6900n -0.000595
+ 104.7000n -0.000836 104.7100n -0.001065 104.7200n -0.001278 104.7300n -0.001472 104.7400n -0.001646 104.7500n -0.001796 104.7600n -0.001922 104.7700n -0.002021 104.7800n -0.002093 104.7900n -0.002136 104.8000n -0.002150 104.8100n -0.002134 104.8200n -0.002090 104.8300n -0.002017 104.8400n -0.001917
+ 104.8500n -0.001792 104.8600n -0.001642 104.8700n -0.001471 104.8800n -0.001280 104.8900n -0.001072 104.9000n -0.000850 104.9100n -0.000617 104.9200n -0.000377 104.9300n -0.000132 104.9400n 0.000115 104.9500n 0.000359 104.9600n 0.000599 104.9700n 0.000830 104.9800n 0.001050 104.9900n 0.001256
+ 105.0000n 0.001446 105.0100n 0.001618 105.0200n 0.001769 105.0300n 0.001898 105.0400n 0.002004 105.0500n 0.002085 105.0600n 0.002142 105.0700n 0.002173 105.0800n 0.002179 105.0900n 0.002161 105.1000n 0.002118 105.1100n 0.002052 105.1200n 0.001964 105.1300n 0.001855 105.1400n 0.001728
+ 105.1500n 0.001583 105.1600n 0.001423 105.1700n 0.001250 105.1800n 0.001065 105.1900n 0.000872 105.2000n 0.000671 105.2100n 0.000466 105.2200n 0.000258 105.2300n 0.000049 105.2400n -0.000158 105.2500n -0.000363 105.2600n -0.000563 105.2700n -0.000757 105.2800n -0.000944 105.2900n -0.001121
+ 105.3000n -0.001289 105.3100n -0.001446 105.3200n -0.001591 105.3300n -0.001724 105.3400n -0.001844 105.3500n -0.001950 105.3600n -0.002044 105.3700n -0.002123 105.3800n -0.002189 105.3900n -0.002242 105.4000n -0.002281 105.4100n -0.002307 105.4200n -0.002320 105.4300n -0.002321 105.4400n -0.002310
+ 105.4500n -0.002288 105.4600n -0.002255 105.4700n -0.002212 105.4800n -0.002160 105.4900n -0.002100 105.5000n -0.002033 105.5100n -0.001958 105.5200n -0.001879 105.5300n -0.001794 105.5400n -0.001707 105.5500n -0.001617 105.5600n -0.001525 105.5700n -0.001434 105.5800n -0.001343 105.5900n -0.001254
+ 105.6000n -0.001169 105.6100n -0.001088 105.6200n -0.001011 105.6300n -0.000941 105.6400n -0.000878 105.6500n -0.000823 105.6600n -0.000776 105.6700n -0.000738 105.6800n -0.000709 105.6900n -0.000690 105.7000n -0.000680 105.7100n -0.000680 105.7200n -0.000689 105.7300n -0.000707 105.7400n -0.000733
+ 105.7500n -0.000767 105.7600n -0.000808 105.7700n -0.000854 105.7800n -0.000906 105.7900n -0.000960 105.8000n -0.001016 105.8100n -0.001074 105.8200n -0.001130 105.8300n -0.001184 105.8400n -0.001235 105.8500n -0.001281 105.8600n -0.001320 105.8700n -0.001352 105.8800n -0.001375 105.8900n -0.001389
+ 105.9000n -0.001393 105.9100n -0.001386 105.9200n -0.001368 105.9300n -0.001339 105.9400n -0.001298 105.9500n -0.001247 105.9600n -0.001185 105.9700n -0.001113 105.9800n -0.001032 105.9900n -0.000944 106.0000n -0.000849 106.0100n -0.000749 106.0200n -0.000645 106.0300n -0.000538 106.0400n -0.000431
+ 106.0500n -0.000325 106.0600n -0.000222 106.0700n -0.000122 106.0800n -0.000028 106.0900n 0.000059 106.1000n 0.000138 106.1100n 0.000208 106.1200n 0.000268 106.1300n 0.000317 106.1400n 0.000355 106.1500n 0.000382 106.1600n 0.000397 106.1700n 0.000402 106.1800n 0.000395 106.1900n 0.000378
+ 106.2000n 0.000352 106.2100n 0.000317 106.2200n 0.000275 106.2300n 0.000227 106.2400n 0.000173 106.2500n 0.000116 106.2600n 0.000057 106.2700n -0.000004 106.2800n -0.000064 106.2900n -0.000122 106.3000n -0.000178 106.3100n -0.000230 106.3200n -0.000278 106.3300n -0.000320 106.3400n -0.000356
+ 106.3500n -0.000385 106.3600n -0.000408 106.3700n -0.000423 106.3800n -0.000432 106.3900n -0.000434 106.4000n -0.000430 106.4100n -0.000420 106.4200n -0.000404 106.4300n -0.000384 106.4400n -0.000359 106.4500n -0.000330 106.4600n -0.000299 106.4700n -0.000265 106.4800n -0.000229 106.4900n -0.000192
+ 106.5000n -0.000155 106.5100n -0.000116 106.5200n -0.000077 106.5300n -0.000037 106.5400n 0.000003 106.5500n 0.000043 106.5600n 0.000085 106.5700n 0.000128 106.5800n 0.000173 106.5900n 0.000220 106.6000n 0.000270 106.6100n 0.000324 106.6200n 0.000382 106.6300n 0.000444 106.6400n 0.000512
+ 106.6500n 0.000585 106.6600n 0.000664 106.6700n 0.000749 106.6800n 0.000840 106.6900n 0.000936 106.7000n 0.001037 106.7100n 0.001142 106.7200n 0.001251 106.7300n 0.001363 106.7400n 0.001475 106.7500n 0.001587 106.7600n 0.001698 106.7700n 0.001804 106.7800n 0.001906 106.7900n 0.001999
+ 106.8000n 0.002084 106.8100n 0.002158 106.8200n 0.002218 106.8300n 0.002264 106.8400n 0.002294 106.8500n 0.002306 106.8600n 0.002300 106.8700n 0.002274 106.8800n 0.002228 106.8900n 0.002162 106.9000n 0.002077 106.9100n 0.001971 106.9200n 0.001847 106.9300n 0.001706 106.9400n 0.001550
+ 106.9500n 0.001379 106.9600n 0.001198 106.9700n 0.001007 106.9800n 0.000810 106.9900n 0.000610 107.0000n 0.000410 107.0100n 0.000213 107.0200n 0.000022 107.0300n -0.000160 107.0400n -0.000329 107.0500n -0.000484 107.0600n -0.000621 107.0700n -0.000739 107.0800n -0.000835 107.0900n -0.000908
+ 107.1000n -0.000957 107.1100n -0.000982 107.1200n -0.000982 107.1300n -0.000957 107.1400n -0.000909 107.1500n -0.000839 107.1600n -0.000748 107.1700n -0.000639 107.1800n -0.000514 107.1900n -0.000377 107.2000n -0.000230 107.2100n -0.000077 107.2200n 0.000079 107.2300n 0.000234 107.2400n 0.000385
+ 107.2500n 0.000527 107.2600n 0.000659 107.2700n 0.000776 107.2800n 0.000875 107.2900n 0.000955 107.3000n 0.001014 107.3100n 0.001048 107.3200n 0.001059 107.3300n 0.001044 107.3400n 0.001003 107.3500n 0.000938 107.3600n 0.000849 107.3700n 0.000737 107.3800n 0.000605 107.3900n 0.000454
+ 107.4000n 0.000288 107.4100n 0.000109 107.4200n -0.000079 107.4300n -0.000273 107.4400n -0.000468 107.4500n -0.000662 107.4600n -0.000851 107.4700n -0.001031 107.4800n -0.001199 107.4900n -0.001351 107.5000n -0.001484 107.5100n -0.001597 107.5200n -0.001687 107.5300n -0.001752 107.5400n -0.001792
+ 107.5500n -0.001805 107.5600n -0.001791 107.5700n -0.001751 107.5800n -0.001686 107.5900n -0.001596 107.6000n -0.001483 107.6100n -0.001350 107.6200n -0.001198 107.6300n -0.001030 107.6400n -0.000849 107.6500n -0.000659 107.6600n -0.000461 107.6700n -0.000260 107.6800n -0.000058 107.6900n 0.000142
+ 107.7000n 0.000338 107.7100n 0.000526 107.7200n 0.000705 107.7300n 0.000873 107.7400n 0.001028 107.7500n 0.001169 107.7600n 0.001295 107.7700n 0.001406 107.7800n 0.001502 107.7900n 0.001582 107.8000n 0.001648 107.8100n 0.001701 107.8200n 0.001742 107.8300n 0.001771 107.8400n 0.001792
+ 107.8500n 0.001804 107.8600n 0.001810 107.8700n 0.001812 107.8800n 0.001811 107.8900n 0.001809 107.9000n 0.001807 107.9100n 0.001807 107.9200n 0.001808 107.9300n 0.001812 107.9400n 0.001820 107.9500n 0.001831 107.9600n 0.001845 107.9700n 0.001861 107.9800n 0.001880 107.9900n 0.001899
+ 108.0000n 0.001918 108.0100n 0.001935 108.0200n 0.001949 108.0300n 0.001957 108.0400n 0.001959 108.0500n 0.001952 108.0600n 0.001936 108.0700n 0.001907 108.0800n 0.001866 108.0900n 0.001810 108.1000n 0.001740 108.1100n 0.001654 108.1200n 0.001552 108.1300n 0.001434 108.1400n 0.001300
+ 108.1500n 0.001152 108.1600n 0.000990 108.1700n 0.000815 108.1800n 0.000630 108.1900n 0.000436 108.2000n 0.000236 108.2100n 0.000031 108.2200n -0.000175 108.2300n -0.000380 108.2400n -0.000581 108.2500n -0.000777 108.2600n -0.000963 108.2700n -0.001138 108.2800n -0.001300 108.2900n -0.001447
+ 108.3000n -0.001577 108.3100n -0.001689 108.3200n -0.001782 108.3300n -0.001856 108.3400n -0.001910 108.3500n -0.001945 108.3600n -0.001961 108.3700n -0.001959 108.3800n -0.001942 108.3900n -0.001910 108.4000n -0.001866 108.4100n -0.001811 108.4200n -0.001749 108.4300n -0.001681 108.4400n -0.001610
+ 108.4500n -0.001539 108.4600n -0.001470 108.4700n -0.001405 108.4800n -0.001347 108.4900n -0.001298 108.5000n -0.001258 108.5100n -0.001229 108.5200n -0.001213 108.5300n -0.001209 108.5400n -0.001218 108.5500n -0.001239 108.5600n -0.001272 108.5700n -0.001315 108.5800n -0.001367 108.5900n -0.001427
+ 108.6000n -0.001493 108.6100n -0.001562 108.6200n -0.001632 108.6300n -0.001700 108.6400n -0.001765 108.6500n -0.001823 108.6600n -0.001873 108.6700n -0.001912 108.6800n -0.001938 108.6900n -0.001950 108.7000n -0.001946 108.7100n -0.001926 108.7200n -0.001888 108.7300n -0.001832 108.7400n -0.001759
+ 108.7500n -0.001669 108.7600n -0.001564 108.7700n -0.001444 108.7800n -0.001312 108.7900n -0.001170 108.8000n -0.001020 108.8100n -0.000864 108.8200n -0.000706 108.8300n -0.000548 108.8400n -0.000393 108.8500n -0.000245 108.8600n -0.000105 108.8700n 0.000023 108.8800n 0.000138 108.8900n 0.000237
+ 108.9000n 0.000318 108.9100n 0.000380 108.9200n 0.000423 108.9300n 0.000445 108.9400n 0.000447 108.9500n 0.000429 108.9600n 0.000392 108.9700n 0.000337 108.9800n 0.000265 108.9900n 0.000179 109.0000n 0.000081 109.0100n -0.000027 109.0200n -0.000142 109.0300n -0.000261 109.0400n -0.000382
+ 109.0500n -0.000502 109.0600n -0.000618 109.0700n -0.000728 109.0800n -0.000829 109.0900n -0.000920 109.1000n -0.000998 109.1100n -0.001063 109.1200n -0.001113 109.1300n -0.001149 109.1400n -0.001169 109.1500n -0.001174 109.1600n -0.001166 109.1700n -0.001144 109.1800n -0.001112 109.1900n -0.001069
+ 109.2000n -0.001020 109.2100n -0.000965 109.2200n -0.000907 109.2300n -0.000849 109.2400n -0.000794 109.2500n -0.000742 109.2600n -0.000698 109.2700n -0.000663 109.2800n -0.000638 109.2900n -0.000625 109.3000n -0.000626 109.3100n -0.000641 109.3200n -0.000670 109.3300n -0.000714 109.3400n -0.000771
+ 109.3500n -0.000841 109.3600n -0.000921 109.3700n -0.001011 109.3800n -0.001108 109.3900n -0.001210 109.4000n -0.001314 109.4100n -0.001416 109.4200n -0.001515 109.4300n -0.001607 109.4400n -0.001689 109.4500n -0.001758 109.4600n -0.001811 109.4700n -0.001847 109.4800n -0.001864 109.4900n -0.001859
+ 109.5000n -0.001832 109.5100n -0.001781 109.5200n -0.001708 109.5300n -0.001612 109.5400n -0.001495 109.5500n -0.001357 109.5600n -0.001202 109.5700n -0.001031 109.5800n -0.000847 109.5900n -0.000653 109.6000n -0.000454 109.6100n -0.000253 109.6200n -0.000054 109.6300n 0.000140 109.6400n 0.000323
+ 109.6500n 0.000493 109.6600n 0.000646 109.6700n 0.000779 109.6800n 0.000888 109.6900n 0.000972 109.7000n 0.001028 109.7100n 0.001056 109.7200n 0.001053 109.7300n 0.001022 109.7400n 0.000960 109.7500n 0.000871 109.7600n 0.000756 109.7700n 0.000617 109.7800n 0.000456 109.7900n 0.000278
+ 109.8000n 0.000087 109.8100n -0.000115 109.8200n -0.000322 109.8300n -0.000530 109.8400n -0.000735 109.8500n -0.000931 109.8600n -0.001116 109.8700n -0.001285 109.8800n -0.001434 109.8900n -0.001560 109.9000n -0.001661 109.9100n -0.001733 109.9200n -0.001777 109.9300n -0.001791 109.9400n -0.001775
+ 109.9500n -0.001729 109.9600n -0.001654 109.9700n -0.001553 109.9800n -0.001428 109.9900n -0.001282 110.0000n -0.001118 110.0100n -0.000941 110.0200n -0.000754 110.0300n -0.000563 110.0400n -0.000371 110.0500n -0.000183 110.0600n -0.000005 110.0700n 0.000160 110.0800n 0.000308 110.0900n 0.000435
+ 110.1000n 0.000538 110.1100n 0.000614 110.1200n 0.000660 110.1300n 0.000676 110.1400n 0.000661 110.1500n 0.000614 110.1600n 0.000537 110.1700n 0.000430 110.1800n 0.000296 110.1900n 0.000137 110.2000n -0.000043 110.2100n -0.000241 110.2200n -0.000453 110.2300n -0.000674 110.2400n -0.000900
+ 110.2500n -0.001125 110.2600n -0.001345 110.2700n -0.001556 110.2800n -0.001752 110.2900n -0.001929 110.3000n -0.002083 110.3100n -0.002211 110.3200n -0.002309 110.3300n -0.002376 110.3400n -0.002410 110.3500n -0.002409 110.3600n -0.002374 110.3700n -0.002303 110.3800n -0.002200 110.3900n -0.002064
+ 110.4000n -0.001898 110.4100n -0.001706 110.4200n -0.001490 110.4300n -0.001254 110.4400n -0.001002 110.4500n -0.000739 110.4600n -0.000468 110.4700n -0.000195 110.4800n 0.000075 110.4900n 0.000340 110.5000n 0.000594 110.5100n 0.000833 110.5200n 0.001055 110.5300n 0.001255 110.5400n 0.001432
+ 110.5500n 0.001583 110.5600n 0.001707 110.5700n 0.001803 110.5800n 0.001870 110.5900n 0.001908 110.6000n 0.001919 110.6100n 0.001904 110.6200n 0.001863 110.6300n 0.001800 110.6400n 0.001716 110.6500n 0.001615 110.6600n 0.001498 110.6700n 0.001370 110.6800n 0.001232 110.6900n 0.001088
+ 110.7000n 0.000941 110.7100n 0.000793 110.7200n 0.000647 110.7300n 0.000505 110.7400n 0.000369 110.7500n 0.000240 110.7600n 0.000120 110.7700n 0.000008 110.7800n -0.000094 110.7900n -0.000186 110.8000n -0.000269 110.8100n -0.000344 110.8200n -0.000411 110.8300n -0.000472 110.8400n -0.000528
+ 110.8500n -0.000580 110.8600n -0.000631 110.8700n -0.000681 110.8800n -0.000732 110.8900n -0.000785 110.9000n -0.000841 110.9100n -0.000902 110.9200n -0.000969 110.9300n -0.001040 110.9400n -0.001118 110.9500n -0.001200 110.9600n -0.001288 110.9700n -0.001379 110.9800n -0.001474 110.9900n -0.001569
+ 111.0000n -0.001665 111.0100n -0.001758 111.0200n -0.001847 111.0300n -0.001930 111.0400n -0.002005 111.0500n -0.002069 111.0600n -0.002120 111.0700n -0.002158 111.0800n -0.002179 111.0900n -0.002183 111.1000n -0.002169 111.1100n -0.002136 111.1200n -0.002084 111.1300n -0.002012 111.1400n -0.001922
+ 111.1500n -0.001814 111.1600n -0.001690 111.1700n -0.001550 111.1800n -0.001399 111.1900n -0.001237 111.2000n -0.001067 111.2100n -0.000893 111.2200n -0.000716 111.2300n -0.000541 111.2400n -0.000371 111.2500n -0.000207 111.2600n -0.000053 111.2700n 0.000088 111.2800n 0.000214 111.2900n 0.000323
+ 111.3000n 0.000414 111.3100n 0.000486 111.3200n 0.000537 111.3300n 0.000568 111.3400n 0.000579 111.3500n 0.000571 111.3600n 0.000545 111.3700n 0.000502 111.3800n 0.000446 111.3900n 0.000379 111.4000n 0.000303 111.4100n 0.000222 111.4200n 0.000139 111.4300n 0.000056 111.4400n -0.000021
+ 111.4500n -0.000091 111.4600n -0.000149 111.4700n -0.000194 111.4800n -0.000223 111.4900n -0.000233 111.5000n -0.000223 111.5100n -0.000191 111.5200n -0.000138 111.5300n -0.000062 111.5400n 0.000036 111.5500n 0.000154 111.5600n 0.000291 111.5700n 0.000446 111.5800n 0.000615 111.5900n 0.000795
+ 111.6000n 0.000983 111.6100n 0.001175 111.6200n 0.001368 111.6300n 0.001556 111.6400n 0.001738 111.6500n 0.001907 111.6600n 0.002060 111.6700n 0.002195 111.6800n 0.002306 111.6900n 0.002393 111.7000n 0.002451 111.7100n 0.002480 111.7200n 0.002479 111.7300n 0.002445 111.7400n 0.002381
+ 111.7500n 0.002286 111.7600n 0.002161 111.7700n 0.002009 111.7800n 0.001832 111.7900n 0.001634 111.8000n 0.001417 111.8100n 0.001187 111.8200n 0.000946 111.8300n 0.000701 111.8400n 0.000454 111.8500n 0.000212 111.8600n -0.000022 111.8700n -0.000243 111.8800n -0.000446 111.8900n -0.000629
+ 111.9000n -0.000788 111.9100n -0.000920 111.9200n -0.001023 111.9300n -0.001095 111.9400n -0.001135 111.9500n -0.001144 111.9600n -0.001121 111.9700n -0.001068 111.9800n -0.000986 111.9900n -0.000879 112.0000n -0.000748 112.0100n -0.000598 112.0200n -0.000431 112.0300n -0.000253 112.0400n -0.000068
+ 112.0500n 0.000120 112.0600n 0.000307 112.0700n 0.000488 112.0800n 0.000659 112.0900n 0.000816 112.1000n 0.000956 112.1100n 0.001074 112.1200n 0.001170 112.1300n 0.001240 112.1400n 0.001284 112.1500n 0.001301 112.1600n 0.001290 112.1700n 0.001253 112.1800n 0.001190 112.1900n 0.001104
+ 112.2000n 0.000997 112.2100n 0.000871 112.2200n 0.000731 112.2300n 0.000579 112.2400n 0.000421 112.2500n 0.000260 112.2600n 0.000100 112.2700n -0.000055 112.2800n -0.000200 112.2900n -0.000332 112.3000n -0.000447 112.3100n -0.000542 112.3200n -0.000615 112.3300n -0.000664 112.3400n -0.000686
+ 112.3500n -0.000682 112.3600n -0.000651 112.3700n -0.000593 112.3800n -0.000510 112.3900n -0.000404 112.4000n -0.000276 112.4100n -0.000131 112.4200n 0.000030 112.4300n 0.000202 112.4400n 0.000381 112.4500n 0.000563 112.4600n 0.000744 112.4700n 0.000919 112.4800n 0.001084 112.4900n 0.001234
+ 112.5000n 0.001367 112.5100n 0.001478 112.5200n 0.001565 112.5300n 0.001625 112.5400n 0.001656 112.5500n 0.001657 112.5600n 0.001628 112.5700n 0.001567 112.5800n 0.001477 112.5900n 0.001358 112.6000n 0.001212 112.6100n 0.001042 112.6200n 0.000851 112.6300n 0.000642 112.6400n 0.000420
+ 112.6500n 0.000188 112.6600n -0.000049 112.6700n -0.000286 112.6800n -0.000520 112.6900n -0.000744 112.7000n -0.000956 112.7100n -0.001151 112.7200n -0.001325 112.7300n -0.001476 112.7400n -0.001600 112.7500n -0.001694 112.7600n -0.001759 112.7700n -0.001791 112.7800n -0.001792 112.7900n -0.001761
+ 112.8000n -0.001698 112.8100n -0.001606 112.8200n -0.001486 112.8300n -0.001341 112.8400n -0.001174 112.8500n -0.000987 112.8600n -0.000784 112.8700n -0.000570 112.8800n -0.000347 112.8900n -0.000120 112.9000n 0.000107 112.9100n 0.000331 112.9200n 0.000548 112.9300n 0.000754 112.9400n 0.000948
+ 112.9500n 0.001126 112.9600n 0.001286 112.9700n 0.001427 112.9800n 0.001547 112.9900n 0.001646 113.0000n 0.001724 113.0100n 0.001781 113.0200n 0.001817 113.0300n 0.001834 113.0400n 0.001833 113.0500n 0.001817 113.0600n 0.001787 113.0700n 0.001745 113.0800n 0.001694 113.0900n 0.001637
+ 113.1000n 0.001576 113.1100n 0.001512 113.1200n 0.001450 113.1300n 0.001389 113.1400n 0.001333 113.1500n 0.001283 113.1600n 0.001240 113.1700n 0.001204 113.1800n 0.001177 113.1900n 0.001158 113.2000n 0.001147 113.2100n 0.001143 113.2200n 0.001146 113.2300n 0.001155 113.2400n 0.001167
+ 113.2500n 0.001182 113.2600n 0.001198 113.2700n 0.001212 113.2800n 0.001223 113.2900n 0.001230 113.3000n 0.001230 113.3100n 0.001222 113.3200n 0.001204 113.3300n 0.001176 113.3400n 0.001137 113.3500n 0.001086 113.3600n 0.001023 113.3700n 0.000949 113.3800n 0.000864 113.3900n 0.000768
+ 113.4000n 0.000664 113.4100n 0.000553 113.4200n 0.000437 113.4300n 0.000318 113.4400n 0.000198 113.4500n 0.000081 113.4600n -0.000033 113.4700n -0.000139 113.4800n -0.000235 113.4900n -0.000320 113.5000n -0.000389 113.5100n -0.000443 113.5200n -0.000478 113.5300n -0.000493 113.5400n -0.000487
+ 113.5500n -0.000460 113.5600n -0.000411 113.5700n -0.000340 113.5800n -0.000249 113.5900n -0.000137 113.6000n -0.000006 113.6100n 0.000141 113.6200n 0.000303 113.6300n 0.000477 113.6400n 0.000660 113.6500n 0.000849 113.6600n 0.001042 113.6700n 0.001235 113.6800n 0.001424 113.6900n 0.001607
+ 113.7000n 0.001781 113.7100n 0.001942 113.7200n 0.002088 113.7300n 0.002217 113.7400n 0.002327 113.7500n 0.002416 113.7600n 0.002483 113.7700n 0.002528 113.7800n 0.002550 113.7900n 0.002548 113.8000n 0.002525 113.8100n 0.002481 113.8200n 0.002416 113.8300n 0.002334 113.8400n 0.002237
+ 113.8500n 0.002125 113.8600n 0.002003 113.8700n 0.001873 113.8800n 0.001738 113.8900n 0.001600 113.9000n 0.001462 113.9100n 0.001327 113.9200n 0.001198 113.9300n 0.001077 113.9400n 0.000965 113.9500n 0.000866 113.9600n 0.000779 113.9700n 0.000706 113.9800n 0.000647 113.9900n 0.000603
+ 114.0000n 0.000574 114.0100n 0.000559 114.0200n 0.000557 114.0300n 0.000567 114.0400n 0.000587 114.0500n 0.000615 114.0600n 0.000651 114.0700n 0.000690 114.0800n 0.000731 114.0900n 0.000773 114.1000n 0.000812 114.1100n 0.000846 114.1200n 0.000873 114.1300n 0.000892 114.1400n 0.000901
+ 114.1500n 0.000899 114.1600n 0.000884 114.1700n 0.000856 114.1800n 0.000815 114.1900n 0.000760 114.2000n 0.000692 114.2100n 0.000612 114.2200n 0.000521 114.2300n 0.000420 114.2400n 0.000311 114.2500n 0.000196 114.2600n 0.000078 114.2700n -0.000043 114.2800n -0.000162 114.2900n -0.000278
+ 114.3000n -0.000388 114.3100n -0.000490 114.3200n -0.000582 114.3300n -0.000662 114.3400n -0.000728 114.3500n -0.000778 114.3600n -0.000812 114.3700n -0.000827 114.3800n -0.000825 114.3900n -0.000805 114.4000n -0.000767 114.4100n -0.000711 114.4200n -0.000640 114.4300n -0.000553 114.4400n -0.000454
+ 114.4500n -0.000343 114.4600n -0.000223 114.4700n -0.000097 114.4800n 0.000034 114.4900n 0.000165 114.5000n 0.000296 114.5100n 0.000423 114.5200n 0.000543 114.5300n 0.000655 114.5400n 0.000756 114.5500n 0.000844 114.5600n 0.000917 114.5700n 0.000975 114.5800n 0.001016 114.5900n 0.001040
+ 114.6000n 0.001046 114.6100n 0.001035 114.6200n 0.001008 114.6300n 0.000965 114.6400n 0.000907 114.6500n 0.000837 114.6600n 0.000756 114.6700n 0.000667 114.6800n 0.000572 114.6900n 0.000474 114.7000n 0.000375 114.7100n 0.000278 114.7200n 0.000187 114.7300n 0.000103 114.7400n 0.000030
+ 114.7500n -0.000030 114.7600n -0.000076 114.7700n -0.000105 114.7800n -0.000116 114.7900n -0.000107 114.8000n -0.000078 114.8100n -0.000028 114.8200n 0.000043 114.8300n 0.000133 114.8400n 0.000243 114.8500n 0.000371 114.8600n 0.000515 114.8700n 0.000673 114.8800n 0.000844 114.8900n 0.001023
+ 114.9000n 0.001209 114.9100n 0.001398 114.9200n 0.001587 114.9300n 0.001772 114.9400n 0.001951 114.9500n 0.002121 114.9600n 0.002277 114.9700n 0.002418 114.9800n 0.002540 114.9900n 0.002640 115.0000n 0.002718 115.0100n 0.002771 115.0200n 0.002797 115.0300n 0.002797 115.0400n 0.002768
+ 115.0500n 0.002711 115.0600n 0.002628 115.0700n 0.002517 115.0800n 0.002382 115.0900n 0.002222 115.1000n 0.002042 115.1100n 0.001842 115.1200n 0.001627 115.1300n 0.001398 115.1400n 0.001160 115.1500n 0.000915 115.1600n 0.000668 115.1700n 0.000422 115.1800n 0.000180 115.1900n -0.000053
+ 115.2000n -0.000275 115.2100n -0.000482 115.2200n -0.000671 115.2300n -0.000840 115.2400n -0.000986 115.2500n -0.001106 115.2600n -0.001201 115.2700n -0.001267 115.2800n -0.001306 115.2900n -0.001315 115.3000n -0.001296 115.3100n -0.001250 115.3200n -0.001177 115.3300n -0.001078 115.3400n -0.000957
+ 115.3500n -0.000815 115.3600n -0.000655 115.3700n -0.000480 115.3800n -0.000294 115.3900n -0.000099 115.4000n 0.000102 115.4100n 0.000303 115.4200n 0.000502 115.4300n 0.000695 115.4400n 0.000879 115.4500n 0.001051 115.4600n 0.001206 115.4700n 0.001344 115.4800n 0.001461 115.4900n 0.001555
+ 115.5000n 0.001624 115.5100n 0.001667 115.5200n 0.001684 115.5300n 0.001675 115.5400n 0.001638 115.5500n 0.001575 115.5600n 0.001488 115.5700n 0.001377 115.5800n 0.001244 115.5900n 0.001092 115.6000n 0.000924 115.6100n 0.000742 115.6200n 0.000551 115.6300n 0.000352 115.6400n 0.000150
+ 115.6500n -0.000052 115.6600n -0.000250 115.6700n -0.000440 115.6800n -0.000619 115.6900n -0.000783 115.7000n -0.000930 115.7100n -0.001057 115.7200n -0.001162 115.7300n -0.001241 115.7400n -0.001295 115.7500n -0.001321 115.7600n -0.001319 115.7700n -0.001289 115.7800n -0.001230 115.7900n -0.001145
+ 115.8000n -0.001034 115.8100n -0.000899 115.8200n -0.000741 115.8300n -0.000565 115.8400n -0.000372 115.8500n -0.000165 115.8600n 0.000051 115.8700n 0.000273 115.8800n 0.000498 115.8900n 0.000721 115.9000n 0.000939 115.9100n 0.001149 115.9200n 0.001346 115.9300n 0.001527 115.9400n 0.001690
+ 115.9500n 0.001831 115.9600n 0.001949 115.9700n 0.002040 115.9800n 0.002105 115.9900n 0.002142 116.0000n 0.002150 116.0100n 0.002130 116.0200n 0.002082 116.0300n 0.002007 116.0400n 0.001906 116.0500n 0.001782 116.0600n 0.001637 116.0700n 0.001473 116.0800n 0.001294 116.0900n 0.001103
+ 116.1000n 0.000903 116.1100n 0.000698 116.1200n 0.000492 116.1300n 0.000287 116.1400n 0.000088 116.1500n -0.000102 116.1600n -0.000280 116.1700n -0.000442 116.1800n -0.000587 116.1900n -0.000713 116.2000n -0.000816 116.2100n -0.000896 116.2200n -0.000952 116.2300n -0.000984 116.2400n -0.000991
+ 116.2500n -0.000973 116.2600n -0.000932 116.2700n -0.000868 116.2800n -0.000784 116.2900n -0.000681 116.3000n -0.000562 116.3100n -0.000429 116.3200n -0.000285 116.3300n -0.000132 116.3400n 0.000027 116.3500n 0.000188 116.3600n 0.000349 116.3700n 0.000507 116.3800n 0.000659 116.3900n 0.000804
+ 116.4000n 0.000938 116.4100n 0.001061 116.4200n 0.001171 116.4300n 0.001266 116.4400n 0.001346 116.4500n 0.001410 116.4600n 0.001459 116.4700n 0.001492 116.4800n 0.001510 116.4900n 0.001514 116.5000n 0.001504 116.5100n 0.001484 116.5200n 0.001453 116.5300n 0.001414 116.5400n 0.001369
+ 116.5500n 0.001319 116.5600n 0.001267 116.5700n 0.001213 116.5800n 0.001160 116.5900n 0.001109 116.6000n 0.001061 116.6100n 0.001018 116.6200n 0.000980 116.6300n 0.000949 116.6400n 0.000923 116.6500n 0.000904 116.6600n 0.000891 116.6700n 0.000883 116.6800n 0.000880 116.6900n 0.000880
+ 116.7000n 0.000883 116.7100n 0.000886 116.7200n 0.000889 116.7300n 0.000890 116.7400n 0.000887 116.7500n 0.000879 116.7600n 0.000863 116.7700n 0.000839 116.7800n 0.000806 116.7900n 0.000761 116.8000n 0.000706 116.8100n 0.000638 116.8200n 0.000557 116.8300n 0.000465 116.8400n 0.000360
+ 116.8500n 0.000244 116.8600n 0.000118 116.8700n -0.000016 116.8800n -0.000158 116.8900n -0.000305 116.9000n -0.000456 116.9100n -0.000607 116.9200n -0.000757 116.9300n -0.000903 116.9400n -0.001042 116.9500n -0.001172 116.9600n -0.001291 116.9700n -0.001396 116.9800n -0.001485 116.9900n -0.001556
+ 117.0000n -0.001608 117.0100n -0.001640 117.0200n -0.001650 117.0300n -0.001637 117.0400n -0.001602 117.0500n -0.001546 117.0600n -0.001468 117.0700n -0.001369 117.0800n -0.001251 117.0900n -0.001116 117.1000n -0.000966 117.1100n -0.000803 117.1200n -0.000629 117.1300n -0.000447 117.1400n -0.000261
+ 117.1500n -0.000072 117.1600n 0.000116 117.1700n 0.000300 117.1800n 0.000478 117.1900n 0.000647 117.2000n 0.000805 117.2100n 0.000949 117.2200n 0.001079 117.2300n 0.001192 117.2400n 0.001288 117.2500n 0.001366 117.2600n 0.001425 117.2700n 0.001465 117.2800n 0.001488 117.2900n 0.001493
+ 117.3000n 0.001483 117.3100n 0.001457 117.3200n 0.001419 117.3300n 0.001369 117.3400n 0.001310 117.3500n 0.001244 117.3600n 0.001174 117.3700n 0.001101 117.3800n 0.001027 117.3900n 0.000955 117.4000n 0.000886 117.4100n 0.000823 117.4200n 0.000766 117.4300n 0.000717 117.4400n 0.000676
+ 117.4500n 0.000645 117.4600n 0.000623 117.4700n 0.000610 117.4800n 0.000606 117.4900n 0.000610 117.5000n 0.000622 117.5100n 0.000639 117.5200n 0.000660 117.5300n 0.000684 117.5400n 0.000708 117.5500n 0.000732 117.5600n 0.000752 117.5700n 0.000767 117.5800n 0.000776 117.5900n 0.000776
+ 117.6000n 0.000766 117.6100n 0.000745 117.6200n 0.000711 117.6300n 0.000664 117.6400n 0.000604 117.6500n 0.000529 117.6600n 0.000441 117.6700n 0.000340 117.6800n 0.000227 117.6900n 0.000103 117.7000n -0.000030 117.7100n -0.000171 117.7200n -0.000317 117.7300n -0.000466 117.7400n -0.000616
+ 117.7500n -0.000764 117.7600n -0.000908 117.7700n -0.001045 117.7800n -0.001171 117.7900n -0.001286 117.8000n -0.001387 117.8100n -0.001471 117.8200n -0.001537 117.8300n -0.001584 117.8400n -0.001609 117.8500n -0.001613 117.8600n -0.001595 117.8700n -0.001555 117.8800n -0.001492 117.8900n -0.001409
+ 117.9000n -0.001305 117.9100n -0.001183 117.9200n -0.001044 117.9300n -0.000890 117.9400n -0.000723 117.9500n -0.000545 117.9600n -0.000360 117.9700n -0.000171 117.9800n 0.000021 117.9900n 0.000213 118.0000n 0.000401 118.0100n 0.000583 118.0200n 0.000756 118.0300n 0.000919 118.0400n 0.001069
+ 118.0500n 0.001205 118.0600n 0.001324 118.0700n 0.001426 118.0800n 0.001509 118.0900n 0.001574 118.1000n 0.001620 118.1100n 0.001647 118.1200n 0.001655 118.1300n 0.001645 118.1400n 0.001619 118.1500n 0.001576 118.1600n 0.001519 118.1700n 0.001449 118.1800n 0.001368 118.1900n 0.001278
+ 118.2000n 0.001180 118.2100n 0.001076 118.2200n 0.000968 118.2300n 0.000858 118.2400n 0.000747 118.2500n 0.000638 118.2600n 0.000531 118.2700n 0.000428 118.2800n 0.000330 118.2900n 0.000238 118.3000n 0.000153 118.3100n 0.000075 118.3200n 0.000005 118.3300n -0.000058 118.3400n -0.000112
+ 118.3500n -0.000158 118.3600n -0.000197 118.3700n -0.000228 118.3800n -0.000252 118.3900n -0.000270 118.4000n -0.000282 118.4100n -0.000288 118.4200n -0.000290 118.4300n -0.000288 118.4400n -0.000283 118.4500n -0.000275 118.4600n -0.000265 118.4700n -0.000253 118.4800n -0.000241 118.4900n -0.000228
+ 118.5000n -0.000214 118.5100n -0.000201 118.5200n -0.000189 118.5300n -0.000177 118.5400n -0.000167 118.5500n -0.000158 118.5600n -0.000151 118.5700n -0.000146 118.5800n -0.000143 118.5900n -0.000142 118.6000n -0.000144 118.6100n -0.000149 118.6200n -0.000157 118.6300n -0.000169 118.6400n -0.000184
+ 118.6500n -0.000203 118.6600n -0.000225 118.6700n -0.000252 118.6800n -0.000284 118.6900n -0.000319 118.7000n -0.000359 118.7100n -0.000403 118.7200n -0.000452 118.7300n -0.000504 118.7400n -0.000559 118.7500n -0.000617 118.7600n -0.000678 118.7700n -0.000740 118.7800n -0.000803 118.7900n -0.000865
+ 118.8000n -0.000926 118.8100n -0.000984 118.8200n -0.001038 118.8300n -0.001087 118.8400n -0.001129 118.8500n -0.001163 118.8600n -0.001188 118.8700n -0.001203 118.8800n -0.001206 118.8900n -0.001196 118.9000n -0.001173 118.9100n -0.001135 118.9200n -0.001083 118.9300n -0.001017 118.9400n -0.000935
+ 118.9500n -0.000840 118.9600n -0.000731 118.9700n -0.000610 118.9800n -0.000478 118.9900n -0.000336 119.0000n -0.000187 119.0100n -0.000033 119.0200n 0.000124 119.0300n 0.000281 119.0400n 0.000435 119.0500n 0.000583 119.0600n 0.000723 119.0700n 0.000851 119.0800n 0.000965 119.0900n 0.001061
+ 119.1000n 0.001137 119.1100n 0.001191 119.1200n 0.001220 119.1300n 0.001223 119.1400n 0.001198 119.1500n 0.001145 119.1600n 0.001062 119.1700n 0.000951 119.1800n 0.000811 119.1900n 0.000644 119.2000n 0.000452 119.2100n 0.000236 119.2200n -0.000001 119.2300n -0.000256 119.2400n -0.000525
+ 119.2500n -0.000804 119.2600n -0.001089 119.2700n -0.001377 119.2800n -0.001662 119.2900n -0.001940 119.3000n -0.002206 119.3100n -0.002456 119.3200n -0.002686 119.3300n -0.002891 119.3400n -0.003068 119.3500n -0.003214 119.3600n -0.003325 119.3700n -0.003400 119.3800n -0.003437 119.3900n -0.003435
+ 119.4000n -0.003393 119.4100n -0.003311 119.4200n -0.003191 119.4300n -0.003034 119.4400n -0.002842 119.4500n -0.002617 119.4600n -0.002364 119.4700n -0.002085 119.4800n -0.001785 119.4900n -0.001467 119.5000n -0.001138 119.5100n -0.000801 119.5200n -0.000461 119.5300n -0.000123 119.5400n 0.000208
+ 119.5500n 0.000528 119.5600n 0.000831 119.5700n 0.001116 119.5800n 0.001377 119.5900n 0.001613 119.6000n 0.001820 119.6100n 0.001997 119.6200n 0.002142 119.6300n 0.002255 119.6400n 0.002335 119.6500n 0.002382 119.6600n 0.002399 119.6700n 0.002386 119.6800n 0.002345 119.6900n 0.002278
+ 119.7000n 0.002189 119.7100n 0.002080 119.7200n 0.001954 119.7300n 0.001815 119.7400n 0.001665 119.7500n 0.001509 119.7600n 0.001348 119.7700n 0.001187 119.7800n 0.001028 119.7900n 0.000874 119.8000n 0.000726 119.8100n 0.000586 119.8200n 0.000456 119.8300n 0.000336 119.8400n 0.000227
+ 119.8500n 0.000129 119.8600n 0.000041 119.8700n -0.000036 119.8800n -0.000105 119.8900n -0.000166 119.9000n -0.000221 119.9100n -0.000272 119.9200n -0.000321 119.9300n -0.000368 119.9400n -0.000417 119.9500n -0.000469 119.9600n -0.000525 119.9700n -0.000586 119.9800n -0.000654 119.9900n -0.000730
+ 120.0000n -0.000813 120.0100n -0.000904 120.0200n -0.001002 120.0300n -0.001107 120.0400n -0.001216 120.0500n -0.001330 120.0600n -0.001445 120.0700n -0.001559 120.0800n -0.001670 120.0900n -0.001775 120.1000n -0.001871 120.1100n -0.001956 120.1200n -0.002026 120.1300n -0.002079 120.1400n -0.002112
+ 120.1500n -0.002123 120.1600n -0.002110 120.1700n -0.002070 120.1800n -0.002003 120.1900n -0.001909 120.2000n -0.001786 120.2100n -0.001635 120.2200n -0.001457 120.2300n -0.001254 120.2400n -0.001027 120.2500n -0.000780 120.2600n -0.000515 120.2700n -0.000235 120.2800n 0.000054 120.2900n 0.000349
+ 120.3000n 0.000645 120.3100n 0.000937 120.3200n 0.001221 120.3300n 0.001492 120.3400n 0.001745 120.3500n 0.001976 120.3600n 0.002180 120.3700n 0.002353 120.3800n 0.002493 120.3900n 0.002596 120.4000n 0.002660 120.4100n 0.002684 120.4200n 0.002666 120.4300n 0.002607 120.4400n 0.002507
+ 120.4500n 0.002367 120.4600n 0.002189 120.4700n 0.001975 120.4800n 0.001730 120.4900n 0.001456 120.5000n 0.001158 120.5100n 0.000840 120.5200n 0.000508 120.5300n 0.000166 120.5400n -0.000179 120.5500n -0.000524 120.5600n -0.000862 120.5700n -0.001189 120.5800n -0.001500 120.5900n -0.001790
+ 120.6000n -0.002056 120.6100n -0.002293 120.6200n -0.002499 120.6300n -0.002673 120.6400n -0.002811 120.6500n -0.002913 120.6600n -0.002979 120.6700n -0.003009 120.6800n -0.003004 120.6900n -0.002966 120.7000n -0.002897 120.7100n -0.002799 120.7200n -0.002676 120.7300n -0.002530 120.7400n -0.002367
+ 120.7500n -0.002189 120.7600n -0.002000 120.7700n -0.001805 120.7800n -0.001608 120.7900n -0.001413 120.8000n -0.001222 120.8100n -0.001040 120.8200n -0.000869 120.8300n -0.000712 120.8400n -0.000570 120.8500n -0.000446 120.8600n -0.000341 120.8700n -0.000254 120.8800n -0.000186 120.8900n -0.000137
+ 120.9000n -0.000106 120.9100n -0.000090 120.9200n -0.000090 120.9300n -0.000102 120.9400n -0.000124 120.9500n -0.000154 120.9600n -0.000189 120.9700n -0.000227 120.9800n -0.000264 120.9900n -0.000299 121.0000n -0.000329 121.0100n -0.000351 121.0200n -0.000365 121.0300n -0.000367 121.0400n -0.000358
+ 121.0500n -0.000336 121.0600n -0.000300 121.0700n -0.000252 121.0800n -0.000190 121.0900n -0.000116 121.1000n -0.000031 121.1100n 0.000063 121.1200n 0.000166 121.1300n 0.000274 121.1400n 0.000386 121.1500n 0.000499 121.1600n 0.000611 121.1700n 0.000719 121.1800n 0.000821 121.1900n 0.000915
+ 121.2000n 0.000998 121.2100n 0.001068 121.2200n 0.001124 121.2300n 0.001163 121.2400n 0.001186 121.2500n 0.001192 121.2600n 0.001179 121.2700n 0.001148 121.2800n 0.001100 121.2900n 0.001034 121.3000n 0.000953 121.3100n 0.000858 121.3200n 0.000751 121.3300n 0.000633 121.3400n 0.000507
+ 121.3500n 0.000376 121.3600n 0.000242 121.3700n 0.000108 121.3800n -0.000023 121.3900n -0.000150 121.4000n -0.000268 121.4100n -0.000376 121.4200n -0.000472 121.4300n -0.000553 121.4400n -0.000618 121.4500n -0.000664 121.4600n -0.000691 121.4700n -0.000699 121.4800n -0.000685 121.4900n -0.000651
+ 121.5000n -0.000596 121.5100n -0.000521 121.5200n -0.000426 121.5300n -0.000313 121.5400n -0.000183 121.5500n -0.000037 121.5600n 0.000123 121.5700n 0.000295 121.5800n 0.000478 121.5900n 0.000668 121.6000n 0.000864 121.6100n 0.001064 121.6200n 0.001265 121.6300n 0.001465 121.6400n 0.001663
+ 121.6500n 0.001856 121.6600n 0.002043 121.6700n 0.002221 121.6800n 0.002390 121.6900n 0.002548 121.7000n 0.002693 121.7100n 0.002824 121.7200n 0.002941 121.7300n 0.003042 121.7400n 0.003127 121.7500n 0.003195 121.7600n 0.003247 121.7700n 0.003280 121.7800n 0.003296 121.7900n 0.003294
+ 121.8000n 0.003274 121.8100n 0.003236 121.8200n 0.003180 121.8300n 0.003107 121.8400n 0.003016 121.8500n 0.002909 121.8600n 0.002785 121.8700n 0.002645 121.8800n 0.002490 121.8900n 0.002320 121.9000n 0.002137 121.9100n 0.001941 121.9200n 0.001733 121.9300n 0.001516 121.9400n 0.001289
+ 121.9500n 0.001056 121.9600n 0.000817 121.9700n 0.000574 121.9800n 0.000329 121.9900n 0.000085 122.0000n -0.000156 122.0100n -0.000393 122.0200n -0.000623 122.0300n -0.000843 122.0400n -0.001052 122.0500n -0.001246 122.0600n -0.001424 122.0700n -0.001584 122.0800n -0.001724 122.0900n -0.001842
+ 122.1000n -0.001937 122.1100n -0.002007 122.1200n -0.002052 122.1300n -0.002071 122.1400n -0.002064 122.1500n -0.002031 122.1600n -0.001973 122.1700n -0.001891 122.1800n -0.001786 122.1900n -0.001660 122.2000n -0.001515 122.2100n -0.001354 122.2200n -0.001180 122.2300n -0.000995 122.2400n -0.000804
+ 122.2500n -0.000609 122.2600n -0.000414 122.2700n -0.000224 122.2800n -0.000041 122.2900n 0.000131 122.3000n 0.000288 122.3100n 0.000427 122.3200n 0.000545 122.3300n 0.000640 122.3400n 0.000708 122.3500n 0.000748 122.3600n 0.000759 122.3700n 0.000740 122.3800n 0.000690 122.3900n 0.000610
+ 122.4000n 0.000499 122.4100n 0.000360 122.4200n 0.000194 122.4300n 0.000003 122.4400n -0.000210 122.4500n -0.000442 122.4600n -0.000691 122.4700n -0.000951 122.4800n -0.001220 122.4900n -0.001494 122.5000n -0.001768 122.5100n -0.002039 122.5200n -0.002301 122.5300n -0.002553 122.5400n -0.002790
+ 122.5500n -0.003008 122.5600n -0.003205 122.5700n -0.003378 122.5800n -0.003525 122.5900n -0.003645 122.6000n -0.003735 122.6100n -0.003796 122.6200n -0.003827 122.6300n -0.003829 122.6400n -0.003803 122.6500n -0.003748 122.6600n -0.003668 122.6700n -0.003565 122.6800n -0.003440 122.6900n -0.003296
+ 122.7000n -0.003136 122.7100n -0.002963 122.7200n -0.002780 122.7300n -0.002590 122.7400n -0.002395 122.7500n -0.002200 122.7600n -0.002006 122.7700n -0.001816 122.7800n -0.001631 122.7900n -0.001455 122.8000n -0.001288 122.8100n -0.001131 122.8200n -0.000985 122.8300n -0.000852 122.8400n -0.000730
+ 122.8500n -0.000620 122.8600n -0.000521 122.8700n -0.000432 122.8800n -0.000352 122.8900n -0.000280 122.9000n -0.000215 122.9100n -0.000156 122.9200n -0.000099 122.9300n -0.000046 122.9400n 0.000007 122.9500n 0.000061 122.9600n 0.000116 122.9700n 0.000173 122.9800n 0.000233 122.9900n 0.000297
+ 123.0000n 0.000364 123.0100n 0.000434 123.0200n 0.000507 123.0300n 0.000583 123.0400n 0.000659 123.0500n 0.000735 123.0600n 0.000810 123.0700n 0.000881 123.0800n 0.000947 123.0900n 0.001006 123.1000n 0.001056 123.1100n 0.001095 123.1200n 0.001122 123.1300n 0.001135 123.1400n 0.001132
+ 123.1500n 0.001112 123.1600n 0.001074 123.1700n 0.001018 123.1800n 0.000943 123.1900n 0.000849 123.2000n 0.000736 123.2100n 0.000606 123.2200n 0.000460 123.2300n 0.000298 123.2400n 0.000124 123.2500n -0.000062 123.2600n -0.000256 123.2700n -0.000456 123.2800n -0.000659 123.2900n -0.000862
+ 123.3000n -0.001062 123.3100n -0.001256 123.3200n -0.001440 123.3300n -0.001613 123.3400n -0.001772 123.3500n -0.001913 123.3600n -0.002035 123.3700n -0.002136 123.3800n -0.002214 123.3900n -0.002269 123.4000n -0.002298 123.4100n -0.002303 123.4200n -0.002284 123.4300n -0.002240 123.4400n -0.002173
+ 123.4500n -0.002083 123.4600n -0.001974 123.4700n -0.001846 123.4800n -0.001702 123.4900n -0.001544 123.5000n -0.001375 123.5100n -0.001198 123.5200n -0.001015 123.5300n -0.000829 123.5400n -0.000643 123.5500n -0.000459 123.5600n -0.000281 123.5700n -0.000109 123.5800n 0.000053 123.5900n 0.000204
+ 123.6000n 0.000343 123.6100n 0.000468 123.6200n 0.000579 123.6300n 0.000675 123.6400n 0.000755 123.6500n 0.000821 123.6600n 0.000871 123.6700n 0.000907 123.6800n 0.000929 123.6900n 0.000939 123.7000n 0.000937 123.7100n 0.000925 123.7200n 0.000904 123.7300n 0.000875 123.7400n 0.000840
+ 123.7500n 0.000799 123.7600n 0.000754 123.7700n 0.000706 123.7800n 0.000655 123.7900n 0.000604 123.8000n 0.000551 123.8100n 0.000497 123.8200n 0.000443 123.8300n 0.000389 123.8400n 0.000335 123.8500n 0.000281 123.8600n 0.000225 123.8700n 0.000169 123.8800n 0.000111 123.8900n 0.000052
+ 123.9000n -0.000010 123.9100n -0.000074 123.9200n -0.000141 123.9300n -0.000211 123.9400n -0.000283 123.9500n -0.000358 123.9600n -0.000435 123.9700n -0.000514 123.9800n -0.000594 123.9900n -0.000674 124.0000n -0.000753 124.0100n -0.000830 124.0200n -0.000904 124.0300n -0.000972 124.0400n -0.001035
+ 124.0500n -0.001089 124.0600n -0.001134 124.0700n -0.001169 124.0800n -0.001191 124.0900n -0.001200 124.1000n -0.001194 124.1100n -0.001174 124.1200n -0.001137 124.1300n -0.001085 124.1400n -0.001017 124.1500n -0.000933 124.1600n -0.000835 124.1700n -0.000723 124.1800n -0.000599 124.1900n -0.000464
+ 124.2000n -0.000321 124.2100n -0.000172 124.2200n -0.000019 124.2300n 0.000136 124.2400n 0.000289 124.2500n 0.000437 124.2600n 0.000578 124.2700n 0.000709 124.2800n 0.000828 124.2900n 0.000932 124.3000n 0.001018 124.3100n 0.001086 124.3200n 0.001133 124.3300n 0.001159 124.3400n 0.001163
+ 124.3500n 0.001144 124.3600n 0.001103 124.3700n 0.001041 124.3800n 0.000960 124.3900n 0.000860 124.4000n 0.000744 124.4100n 0.000615 124.4200n 0.000475 124.4300n 0.000328 124.4400n 0.000177 124.4500n 0.000026 124.4600n -0.000122 124.4700n -0.000263 124.4800n -0.000393 124.4900n -0.000508
+ 124.5000n -0.000607 124.5100n -0.000685 124.5200n -0.000740 124.5300n -0.000771 124.5400n -0.000775 124.5500n -0.000752 124.5600n -0.000701 124.5700n -0.000622 124.5800n -0.000517 124.5900n -0.000385 124.6000n -0.000230 124.6100n -0.000053 124.6200n 0.000143 124.6300n 0.000354 124.6400n 0.000577
+ 124.6500n 0.000807 124.6600n 0.001041 124.6700n 0.001275 124.6800n 0.001503 124.6900n 0.001722 124.7000n 0.001928 124.7100n 0.002117 124.7200n 0.002285 124.7300n 0.002429 124.7400n 0.002547 124.7500n 0.002635 124.7600n 0.002693 124.7700n 0.002720 124.7800n 0.002715 124.7900n 0.002678
+ 124.8000n 0.002610 124.8100n 0.002512 124.8200n 0.002386 124.8300n 0.002235 124.8400n 0.002061 124.8500n 0.001868 124.8600n 0.001659 124.8700n 0.001439 124.8800n 0.001210 124.8900n 0.000977 124.9000n 0.000744 124.9100n 0.000514 124.9200n 0.000292 124.9300n 0.000080 124.9400n -0.000118
+ 124.9500n -0.000300 124.9600n -0.000464 124.9700n -0.000608 124.9800n -0.000731 124.9900n -0.000832 125.0000n -0.000912 125.0100n -0.000971 125.0200n -0.001009 125.0300n -0.001029 125.0400n -0.001031 125.0500n -0.001019 125.0600n -0.000994 125.0700n -0.000959 125.0800n -0.000917 125.0900n -0.000871
+ 125.1000n -0.000823 125.1100n -0.000776 125.1200n -0.000732 125.1300n -0.000694 125.1400n -0.000664 125.1500n -0.000642 125.1600n -0.000630 125.1700n -0.000629 125.1800n -0.000638 125.1900n -0.000657 125.2000n -0.000685 125.2100n -0.000722 125.2200n -0.000764 125.2300n -0.000811 125.2400n -0.000860
+ 125.2500n -0.000908 125.2600n -0.000952 125.2700n -0.000990 125.2800n -0.001019 125.2900n -0.001035 125.3000n -0.001037 125.3100n -0.001021 125.3200n -0.000986 125.3300n -0.000931 125.3400n -0.000853 125.3500n -0.000752 125.3600n -0.000628 125.3700n -0.000481 125.3800n -0.000313 125.3900n -0.000124
+ 125.4000n 0.000082 125.4100n 0.000304 125.4200n 0.000538 125.4300n 0.000781 125.4400n 0.001028 125.4500n 0.001275 125.4600n 0.001519 125.4700n 0.001753 125.4800n 0.001974 125.4900n 0.002178 125.5000n 0.002360 125.5100n 0.002515 125.5200n 0.002641 125.5300n 0.002734 125.5400n 0.002793
+ 125.5500n 0.002814 125.5600n 0.002797 125.5700n 0.002741 125.5800n 0.002646 125.5900n 0.002514 125.6000n 0.002346 125.6100n 0.002145 125.6200n 0.001913 125.6300n 0.001654 125.6400n 0.001373 125.6500n 0.001075 125.6600n 0.000764 125.6700n 0.000445 125.6800n 0.000125 125.6900n -0.000191
+ 125.7000n -0.000498 125.7100n -0.000791 125.7200n -0.001064 125.7300n -0.001313 125.7400n -0.001533 125.7500n -0.001722 125.7600n -0.001877 125.7700n -0.001995 125.7800n -0.002075 125.7900n -0.002117 125.8000n -0.002120 125.8100n -0.002086 125.8200n -0.002017 125.8300n -0.001915 125.8400n -0.001783
+ 125.8500n -0.001624 125.8600n -0.001445 125.8700n -0.001247 125.8800n -0.001038 125.8900n -0.000822 125.9000n -0.000604 125.9100n -0.000389 125.9200n -0.000182 125.9300n 0.000011 125.9400n 0.000187 125.9500n 0.000342 125.9600n 0.000472 125.9700n 0.000574 125.9800n 0.000647 125.9900n 0.000689
+ 126.0000n 0.000700 126.0100n 0.000679 126.0200n 0.000628 126.0300n 0.000548 126.0400n 0.000442 126.0500n 0.000312 126.0600n 0.000162 126.0700n -0.000004 126.0800n -0.000183 126.0900n -0.000369 126.1000n -0.000557 126.1100n -0.000744 126.1200n -0.000924 126.1300n -0.001093 126.1400n -0.001246
+ 126.1500n -0.001380 126.1600n -0.001492 126.1700n -0.001578 126.1800n -0.001636 126.1900n -0.001665 126.2000n -0.001663 126.2100n -0.001630 126.2200n -0.001567 126.2300n -0.001475 126.2400n -0.001355 126.2500n -0.001209 126.2600n -0.001041 126.2700n -0.000853 126.2800n -0.000650 126.2900n -0.000435
+ 126.3000n -0.000212 126.3100n 0.000014 126.3200n 0.000239 126.3300n 0.000460 126.3400n 0.000672 126.3500n 0.000871 126.3600n 0.001054 126.3700n 0.001219 126.3800n 0.001363 126.3900n 0.001485 126.4000n 0.001583 126.4100n 0.001656 126.4200n 0.001705 126.4300n 0.001730 126.4400n 0.001733
+ 126.4500n 0.001714 126.4600n 0.001677 126.4700n 0.001623 126.4800n 0.001556 126.4900n 0.001478 126.5000n 0.001393 126.5100n 0.001305 126.5200n 0.001216 126.5300n 0.001129 126.5400n 0.001048 126.5500n 0.000975 126.5600n 0.000913 126.5700n 0.000863 126.5800n 0.000827 126.5900n 0.000805
+ 126.6000n 0.000798 126.6100n 0.000806 126.6200n 0.000827 126.6300n 0.000861 126.6400n 0.000906 126.6500n 0.000959 126.6600n 0.001018 126.6700n 0.001079 126.6800n 0.001139 126.6900n 0.001196 126.7000n 0.001244 126.7100n 0.001282 126.7200n 0.001305 126.7300n 0.001310 126.7400n 0.001295
+ 126.7500n 0.001257 126.7600n 0.001193 126.7700n 0.001104 126.7800n 0.000986 126.7900n 0.000841 126.8000n 0.000669 126.8100n 0.000471 126.8200n 0.000248 126.8300n 0.000003 126.8400n -0.000261 126.8500n -0.000541 126.8600n -0.000832 126.8700n -0.001130 126.8800n -0.001431 126.8900n -0.001729
+ 126.9000n -0.002020 126.9100n -0.002297 126.9200n -0.002557 126.9300n -0.002794 126.9400n -0.003003 126.9500n -0.003180 126.9600n -0.003322 126.9700n -0.003425 126.9800n -0.003488 126.9900n -0.003507 127.0000n -0.003482 127.0100n -0.003413 127.0200n -0.003301 127.0300n -0.003145 127.0400n -0.002949
+ 127.0500n -0.002716 127.0600n -0.002447 127.0700n -0.002149 127.0800n -0.001825 127.0900n -0.001480 127.1000n -0.001119 127.1100n -0.000749 127.1200n -0.000375 127.1300n -0.000002 127.1400n 0.000363 127.1500n 0.000716 127.1600n 0.001050 127.1700n 0.001362 127.1800n 0.001647 127.1900n 0.001901
+ 127.2000n 0.002121 127.2100n 0.002304 127.2200n 0.002449 127.2300n 0.002555 127.2400n 0.002621 127.2500n 0.002648 127.2600n 0.002636 127.2700n 0.002587 127.2800n 0.002504 127.2900n 0.002390 127.3000n 0.002247 127.3100n 0.002080 127.3200n 0.001891 127.3300n 0.001686 127.3400n 0.001468
+ 127.3500n 0.001242 127.3600n 0.001012 127.3700n 0.000782 127.3800n 0.000554 127.3900n 0.000334 127.4000n 0.000124 127.4100n -0.000075 127.4200n -0.000259 127.4300n -0.000427 127.4400n -0.000578 127.4500n -0.000712 127.4600n -0.000829 127.4700n -0.000928 127.4800n -0.001012 127.4900n -0.001081
+ 127.5000n -0.001138 127.5100n -0.001183 127.5200n -0.001220 127.5300n -0.001250 127.5400n -0.001277 127.5500n -0.001302 127.5600n -0.001328 127.5700n -0.001357 127.5800n -0.001391 127.5900n -0.001432 127.6000n -0.001481 127.6100n -0.001538 127.6200n -0.001606 127.6300n -0.001683 127.6400n -0.001770
+ 127.6500n -0.001866 127.6600n -0.001969 127.6700n -0.002079 127.6800n -0.002193 127.6900n -0.002310 127.7000n -0.002426 127.7100n -0.002539 127.7200n -0.002647 127.7300n -0.002746 127.7400n -0.002833 127.7500n -0.002907 127.7600n -0.002964 127.7700n -0.003001 127.7800n -0.003017 127.7900n -0.003010
+ 127.8000n -0.002978 127.8100n -0.002920 127.8200n -0.002835 127.8300n -0.002725 127.8400n -0.002588 127.8500n -0.002425 127.8600n -0.002239 127.8700n -0.002031 127.8800n -0.001802 127.8900n -0.001556 127.9000n -0.001295 127.9100n -0.001024 127.9200n -0.000744 127.9300n -0.000460 127.9400n -0.000175
+ 127.9500n 0.000106 127.9600n 0.000381 127.9700n 0.000645 127.9800n 0.000895 127.9900n 0.001128 128.0000n 0.001342 128.0100n 0.001533 128.0200n 0.001700 128.0300n 0.001841 128.0400n 0.001954 128.0500n 0.002040 128.0600n 0.002096 128.0700n 0.002125 128.0800n 0.002125 128.0900n 0.002099
+ 128.1000n 0.002047 128.1100n 0.001972 128.1200n 0.001875 128.1300n 0.001758 128.1400n 0.001625 128.1500n 0.001479 128.1600n 0.001321 128.1700n 0.001155 128.1800n 0.000984 128.1900n 0.000810 128.2000n 0.000637 128.2100n 0.000468 128.2200n 0.000303 128.2300n 0.000147 128.2400n 0.000000
+ 128.2500n -0.000134 128.2600n -0.000256 128.2700n -0.000364 128.2800n -0.000457 128.2900n -0.000534 128.3000n -0.000595 128.3100n -0.000640 128.3200n -0.000670 128.3300n -0.000685 128.3400n -0.000685 128.3500n -0.000672 128.3600n -0.000646 128.3700n -0.000609 128.3800n -0.000561 128.3900n -0.000505
+ 128.4000n -0.000441 128.4100n -0.000370 128.4200n -0.000295 128.4300n -0.000216 128.4400n -0.000134 128.4500n -0.000050 128.4600n 0.000034 128.4700n 0.000118 128.4800n 0.000201 128.4900n 0.000282 128.5000n 0.000360 128.5100n 0.000435 128.5200n 0.000507 128.5300n 0.000575 128.5400n 0.000639
+ 128.5500n 0.000698 128.5600n 0.000753 128.5700n 0.000803 128.5800n 0.000847 128.5900n 0.000887 128.6000n 0.000920 128.6100n 0.000948 128.6200n 0.000970 128.6300n 0.000986 128.6400n 0.000995 128.6500n 0.000997 128.6600n 0.000993 128.6700n 0.000981 128.6800n 0.000962 128.6900n 0.000936
+ 128.7000n 0.000901 128.7100n 0.000859 128.7200n 0.000809 128.7300n 0.000751 128.7400n 0.000685 128.7500n 0.000612 128.7600n 0.000531 128.7700n 0.000443 128.7800n 0.000349 128.7900n 0.000249 128.8000n 0.000143 128.8100n 0.000034 128.8200n -0.000080 128.8300n -0.000196 128.8400n -0.000315
+ 128.8500n -0.000434 128.8600n -0.000552 128.8700n -0.000670 128.8800n -0.000785 128.8900n -0.000898 128.9000n -0.001006 128.9100n -0.001109 128.9200n -0.001206 128.9300n -0.001297 128.9400n -0.001381 128.9500n -0.001457 128.9600n -0.001526 128.9700n -0.001586 128.9800n -0.001638 128.9900n -0.001682
+ 129.0000n -0.001718 129.0100n -0.001747 129.0200n -0.001768 129.0300n -0.001782 129.0400n -0.001790 129.0500n -0.001792 129.0600n -0.001789 129.0700n -0.001780 129.0800n -0.001768 129.0900n -0.001752 129.1000n -0.001732 129.1100n -0.001710 129.1200n -0.001684 129.1300n -0.001656 129.1400n -0.001626
+ 129.1500n -0.001593 129.1600n -0.001557 129.1700n -0.001517 129.1800n -0.001474 129.1900n -0.001427 129.2000n -0.001374 129.2100n -0.001316 129.2200n -0.001252 129.2300n -0.001180 129.2400n -0.001100 129.2500n -0.001011 129.2600n -0.000912 129.2700n -0.000803 129.2800n -0.000683 129.2900n -0.000552
+ 129.3000n -0.000409 129.3100n -0.000254 129.3200n -0.000089 129.3300n 0.000089 129.3400n 0.000276 129.3500n 0.000473 129.3600n 0.000679 129.3700n 0.000893 129.3800n 0.001112 129.3900n 0.001336 129.4000n 0.001561 129.4100n 0.001787 129.4200n 0.002011 129.4300n 0.002231 129.4400n 0.002444
+ 129.4500n 0.002649 129.4600n 0.002842 129.4700n 0.003021 129.4800n 0.003186 129.4900n 0.003332 129.5000n 0.003459 129.5100n 0.003564 129.5200n 0.003648 129.5300n 0.003707 129.5400n 0.003742 129.5500n 0.003752 129.5600n 0.003737 129.5700n 0.003698 129.5800n 0.003633 129.5900n 0.003545
+ 129.6000n 0.003435 129.6100n 0.003303 129.6200n 0.003152 129.6300n 0.002984 129.6400n 0.002800 129.6500n 0.002603 129.6600n 0.002396 129.6700n 0.002180 129.6800n 0.001959 129.6900n 0.001735 129.7000n 0.001510 129.7100n 0.001288 129.7200n 0.001070 129.7300n 0.000858 129.7400n 0.000656
+ 129.7500n 0.000464 129.7600n 0.000284 129.7700n 0.000118 129.7800n -0.000034 129.7900n -0.000169 129.8000n -0.000289 129.8100n -0.000392 129.8200n -0.000478 129.8300n -0.000548 129.8400n -0.000601 129.8500n -0.000639 129.8600n -0.000662 129.8700n -0.000670 129.8800n -0.000665 129.8900n -0.000648
+ 129.9000n -0.000621 129.9100n -0.000583 129.9200n -0.000537 129.9300n -0.000484 129.9400n -0.000424 129.9500n -0.000360 129.9600n -0.000292 129.9700n -0.000221 129.9800n -0.000149 129.9900n -0.000076 130.0000n -0.000003 130.0100n 0.000068 130.0200n 0.000138 130.0300n 0.000206 130.0400n 0.000270
+ 130.0500n 0.000331 130.0600n 0.000387 130.0700n 0.000438 130.0800n 0.000484 130.0900n 0.000525 130.1000n 0.000558 130.1100n 0.000585 130.1200n 0.000604 130.1300n 0.000616 130.1400n 0.000619 130.1500n 0.000612 130.1600n 0.000596 130.1700n 0.000571 130.1800n 0.000534 130.1900n 0.000487
+ 130.2000n 0.000429 130.2100n 0.000359 130.2200n 0.000278 130.2300n 0.000186 130.2400n 0.000083 130.2500n -0.000031 130.2600n -0.000154 130.2700n -0.000287 130.2800n -0.000428 130.2900n -0.000576 130.3000n -0.000729 130.3100n -0.000886 130.3200n -0.001044 130.3300n -0.001203 130.3400n -0.001358
+ 130.3500n -0.001509 130.3600n -0.001652 130.3700n -0.001786 130.3800n -0.001907 130.3900n -0.002012 130.4000n -0.002100 130.4100n -0.002169 130.4200n -0.002215 130.4300n -0.002237 130.4400n -0.002233 130.4500n -0.002202 130.4600n -0.002142 130.4700n -0.002054 130.4800n -0.001937 130.4900n -0.001790
+ 130.5000n -0.001616 130.5100n -0.001414 130.5200n -0.001187 130.5300n -0.000937 130.5400n -0.000665 130.5500n -0.000376 130.5600n -0.000072 130.5700n 0.000242 130.5800n 0.000563 130.5900n 0.000887 130.6000n 0.001210 130.6100n 0.001526 130.6200n 0.001831 130.6300n 0.002121 130.6400n 0.002392
+ 130.6500n 0.002639 130.6600n 0.002859 130.6700n 0.003048 130.6800n 0.003203 130.6900n 0.003321 130.7000n 0.003401 130.7100n 0.003441 130.7200n 0.003440 130.7300n 0.003397 130.7400n 0.003313 130.7500n 0.003189 130.7600n 0.003027 130.7700n 0.002828 130.7800n 0.002595 130.7900n 0.002332
+ 130.8000n 0.002043 130.8100n 0.001730 130.8200n 0.001399 130.8300n 0.001054 130.8400n 0.000701 130.8500n 0.000343 130.8600n -0.000013 130.8700n -0.000364 130.8800n -0.000704 130.8900n -0.001030 130.9000n -0.001336 130.9100n -0.001619 130.9200n -0.001876 130.9300n -0.002105 130.9400n -0.002301
+ 130.9500n -0.002465 130.9600n -0.002595 130.9700n -0.002689 130.9800n -0.002749 130.9900n -0.002775 131.0000n -0.002767 131.0100n -0.002728 131.0200n -0.002660 131.0300n -0.002565 131.0400n -0.002445 131.0500n -0.002305 131.0600n -0.002148 131.0700n -0.001977 131.0800n -0.001795 131.0900n -0.001607
+ 131.1000n -0.001417 131.1100n -0.001227 131.1200n -0.001041 131.1300n -0.000862 131.1400n -0.000694 131.1500n -0.000538 131.1600n -0.000396 131.1700n -0.000270 131.1800n -0.000163 131.1900n -0.000073 131.2000n -0.000003 131.2100n 0.000049 131.2200n 0.000082 131.2300n 0.000096 131.2400n 0.000094
+ 131.2500n 0.000077 131.2600n 0.000045 131.2700n 0.000001 131.2800n -0.000053 131.2900n -0.000116 131.3000n -0.000184 131.3100n -0.000257 131.3200n -0.000332 131.3300n -0.000407 131.3400n -0.000480 131.3500n -0.000550 131.3600n -0.000615 131.3700n -0.000674 131.3800n -0.000725 131.3900n -0.000769
+ 131.4000n -0.000804 131.4100n -0.000831 131.4200n -0.000848 131.4300n -0.000857 131.4400n -0.000858 131.4500n -0.000852 131.4600n -0.000838 131.4700n -0.000819 131.4800n -0.000794 131.4900n -0.000766 131.5000n -0.000735 131.5100n -0.000701 131.5200n -0.000667 131.5300n -0.000633 131.5400n -0.000600
+ 131.5500n -0.000569 131.5600n -0.000540 131.5700n -0.000514 131.5800n -0.000491 131.5900n -0.000472 131.6000n -0.000456 131.6100n -0.000443 131.6200n -0.000434 131.6300n -0.000427 131.6400n -0.000423 131.6500n -0.000420 131.6600n -0.000419 131.6700n -0.000418 131.6800n -0.000418 131.6900n -0.000417
+ 131.7000n -0.000414 131.7100n -0.000410 131.7200n -0.000404 131.7300n -0.000395 131.7400n -0.000384 131.7500n -0.000370 131.7600n -0.000353 131.7700n -0.000333 131.7800n -0.000310 131.7900n -0.000286 131.8000n -0.000260 131.8100n -0.000232 131.8200n -0.000205 131.8300n -0.000177 131.8400n -0.000151
+ 131.8500n -0.000126 131.8600n -0.000103 131.8700n -0.000084 131.8800n -0.000069 131.8900n -0.000058 131.9000n -0.000052 131.9100n -0.000051 131.9200n -0.000055 131.9300n -0.000065 131.9400n -0.000080 131.9500n -0.000100 131.9600n -0.000125 131.9700n -0.000154 131.9800n -0.000187 131.9900n -0.000223
+ 132.0000n -0.000260 132.0100n -0.000298 132.0200n -0.000336 132.0300n -0.000373 132.0400n -0.000407 132.0500n -0.000438 132.0600n -0.000464 132.0700n -0.000485 132.0800n -0.000500 132.0900n -0.000507 132.1000n -0.000506 132.1100n -0.000497 132.1200n -0.000480 132.1300n -0.000454 132.1400n -0.000420
+ 132.1500n -0.000377 132.1600n -0.000327 132.1700n -0.000270 132.1800n -0.000206 132.1900n -0.000138 132.2000n -0.000065 132.2100n 0.000010 132.2200n 0.000087 132.2300n 0.000164 132.2400n 0.000240 132.2500n 0.000313 132.2600n 0.000381 132.2700n 0.000445 132.2800n 0.000501 132.2900n 0.000550
+ 132.3000n 0.000590 132.3100n 0.000621 132.3200n 0.000642 132.3300n 0.000652 132.3400n 0.000652 132.3500n 0.000641 132.3600n 0.000620 132.3700n 0.000589 132.3800n 0.000548 132.3900n 0.000500 132.4000n 0.000444 132.4100n 0.000382 132.4200n 0.000315 132.4300n 0.000244 132.4400n 0.000172
+ 132.4500n 0.000099 132.4600n 0.000026 132.4700n -0.000044 132.4800n -0.000111 132.4900n -0.000172 132.5000n -0.000228 132.5100n -0.000277 132.5200n -0.000318 132.5300n -0.000351 132.5400n -0.000374 132.5500n -0.000388 132.5600n -0.000393 132.5700n -0.000389 132.5800n -0.000376 132.5900n -0.000354
+ 132.6000n -0.000325 132.6100n -0.000289 132.6200n -0.000247 132.6300n -0.000200 132.6400n -0.000149 132.6500n -0.000095 132.6600n -0.000041 132.6700n 0.000014 132.6800n 0.000067 132.6900n 0.000118 132.7000n 0.000166 132.7100n 0.000208 132.7200n 0.000246 132.7300n 0.000277 132.7400n 0.000301
+ 132.7500n 0.000317 132.7600n 0.000326 132.7700n 0.000326 132.7800n 0.000318 132.7900n 0.000302 132.8000n 0.000278 132.8100n 0.000247 132.8200n 0.000208 132.8300n 0.000163 132.8400n 0.000112 132.8500n 0.000056 132.8600n -0.000004 132.8700n -0.000068 132.8800n -0.000135 132.8900n -0.000204
+ 132.9000n -0.000273 132.9100n -0.000343 132.9200n -0.000413 132.9300n -0.000482 132.9400n -0.000549 132.9500n -0.000614 132.9600n -0.000676 132.9700n -0.000735 132.9800n -0.000792 132.9900n -0.000844 133.0000n -0.000894 133.0100n -0.000939 133.0200n -0.000981 133.0300n -0.001020 133.0400n -0.001055
+ 133.0500n -0.001087 133.0600n -0.001116 133.0700n -0.001142 133.0800n -0.001165 133.0900n -0.001185 133.1000n -0.001204 133.1100n -0.001220 133.1200n -0.001234 133.1300n -0.001246 133.1400n -0.001256 133.1500n -0.001265 133.1600n -0.001272 133.1700n -0.001278 133.1800n -0.001282 133.1900n -0.001285
+ 133.2000n -0.001287 133.2100n -0.001287 133.2200n -0.001286 133.2300n -0.001284 133.2400n -0.001281 133.2500n -0.001277 133.2600n -0.001272 133.2700n -0.001266 133.2800n -0.001260 133.2900n -0.001253 133.3000n -0.001246 133.3100n -0.001239 133.3200n -0.001232 133.3300n -0.001225 133.3400n -0.001218
+ 133.3500n -0.001212 133.3600n -0.001207 133.3700n -0.001203 133.3800n -0.001199 133.3900n -0.001196 133.4000n -0.001194 133.4100n -0.001193 133.4200n -0.001193 133.4300n -0.001193 133.4400n -0.001193 133.4500n -0.001193 133.4600n -0.001192 133.4700n -0.001191 133.4800n -0.001189 133.4900n -0.001184
+ 133.5000n -0.001178 133.5100n -0.001169 133.5200n -0.001158 133.5300n -0.001143 133.5400n -0.001124 133.5500n -0.001101 133.5600n -0.001075 133.5700n -0.001044 133.5800n -0.001010 133.5900n -0.000971 133.6000n -0.000930 133.6100n -0.000885 133.6200n -0.000837 133.6300n -0.000788 133.6400n -0.000738
+ 133.6500n -0.000689 133.6600n -0.000640 133.6700n -0.000593 133.6800n -0.000551 133.6900n -0.000512 133.7000n -0.000480 133.7100n -0.000455 133.7200n -0.000438 133.7300n -0.000430 133.7400n -0.000433 133.7500n -0.000447 133.7600n -0.000473 133.7700n -0.000510 133.7800n -0.000561 133.7900n -0.000624
+ 133.8000n -0.000699 133.8100n -0.000785 133.8200n -0.000882 133.8300n -0.000989 133.8400n -0.001104 133.8500n -0.001226 133.8600n -0.001352 133.8700n -0.001481 133.8800n -0.001611 133.8900n -0.001739 133.9000n -0.001863 133.9100n -0.001980 133.9200n -0.002088 133.9300n -0.002185 133.9400n -0.002268
+ 133.9500n -0.002335 133.9600n -0.002384 133.9700n -0.002415 133.9800n -0.002424 133.9900n -0.002412 134.0000n -0.002379 134.0100n -0.002323 134.0200n -0.002245 134.0300n -0.002146 134.0400n -0.002027 134.0500n -0.001890 134.0600n -0.001736 134.0700n -0.001568 134.0800n -0.001390 134.0900n -0.001202
+ 134.1000n -0.001011 134.1100n -0.000817 134.1200n -0.000626 134.1300n -0.000441 134.1400n -0.000266 134.1500n -0.000103 134.1600n 0.000042 134.1700n 0.000168 134.1800n 0.000271 134.1900n 0.000349 134.2000n 0.000399 134.2100n 0.000421 134.2200n 0.000412 134.2300n 0.000372 134.2400n 0.000301
+ 134.2500n 0.000200 134.2600n 0.000070 134.2700n -0.000088 134.2800n -0.000271 134.2900n -0.000477 134.3000n -0.000702 134.3100n -0.000943 134.3200n -0.001196 134.3300n -0.001456 134.3400n -0.001720 134.3500n -0.001982 134.3600n -0.002239 134.3700n -0.002486 134.3800n -0.002718 134.3900n -0.002932
+ 134.4000n -0.003124 134.4100n -0.003291 134.4200n -0.003429 134.4300n -0.003537 134.4400n -0.003612 134.4500n -0.003655 134.4600n -0.003663 134.4700n -0.003637 134.4800n -0.003578 134.4900n -0.003488 134.5000n -0.003367 134.5100n -0.003220 134.5200n -0.003047 134.5300n -0.002854 134.5400n -0.002644
+ 134.5500n -0.002420 134.5600n -0.002188 134.5700n -0.001951 134.5800n -0.001714 134.5900n -0.001481 134.6000n -0.001256 134.6100n -0.001043 134.6200n -0.000846 134.6300n -0.000668 134.6400n -0.000511 134.6500n -0.000378 134.6600n -0.000271 134.6700n -0.000190 134.6800n -0.000136 134.6900n -0.000109
+ 134.7000n -0.000108 134.7100n -0.000133 134.7200n -0.000180 134.7300n -0.000248 134.7400n -0.000335 134.7500n -0.000437 134.7600n -0.000551 134.7700n -0.000673 134.7800n -0.000801 134.7900n -0.000929 134.8000n -0.001055 134.8100n -0.001174 134.8200n -0.001285 134.8300n -0.001383 134.8400n -0.001466
+ 134.8500n -0.001532 134.8600n -0.001579 134.8700n -0.001606 134.8800n -0.001612 134.8900n -0.001596 134.9000n -0.001559 134.9100n -0.001502 134.9200n -0.001425 134.9300n -0.001332 134.9400n -0.001222 134.9500n -0.001100 134.9600n -0.000968 134.9700n -0.000829 134.9800n -0.000685 134.9900n -0.000541
+ 135.0000n -0.000398 135.0100n -0.000261 135.0200n -0.000131 135.0300n -0.000012 135.0400n 0.000094 135.0500n 0.000186 135.0600n 0.000261 135.0700n 0.000319 135.0800n 0.000359 135.0900n 0.000381 135.1000n 0.000385 135.1100n 0.000373 135.1200n 0.000345 135.1300n 0.000303 135.1400n 0.000249
+ 135.1500n 0.000186 135.1600n 0.000117 135.1700n 0.000043 135.1800n -0.000032 135.1900n -0.000104 135.2000n -0.000172 135.2100n -0.000231 135.2200n -0.000281 135.2300n -0.000317 135.2400n -0.000339 135.2500n -0.000344 135.2600n -0.000331 135.2700n -0.000299 135.2800n -0.000249 135.2900n -0.000180
+ 135.3000n -0.000094 135.3100n 0.000009 135.3200n 0.000127 135.3300n 0.000258 135.3400n 0.000399 135.3500n 0.000547 135.3600n 0.000699 135.3700n 0.000852 135.3800n 0.001001 135.3900n 0.001144 135.4000n 0.001277 135.4100n 0.001396 135.4200n 0.001498 135.4300n 0.001581 135.4400n 0.001640
+ 135.4500n 0.001675 135.4600n 0.001684 135.4700n 0.001664 135.4800n 0.001616 135.4900n 0.001538 135.5000n 0.001432 135.5100n 0.001299 135.5200n 0.001139 135.5300n 0.000956 135.5400n 0.000750 135.5500n 0.000527 135.5600n 0.000288 135.5700n 0.000037 135.5800n -0.000221 135.5900n -0.000484
+ 135.6000n -0.000745 135.6100n -0.001002 135.6200n -0.001251 135.6300n -0.001487 135.6400n -0.001706 135.6500n -0.001907 135.6600n -0.002085 135.6700n -0.002239 135.6800n -0.002366 135.6900n -0.002465 135.7000n -0.002535 135.7100n -0.002575 135.7200n -0.002587 135.7300n -0.002570 135.7400n -0.002526
+ 135.7500n -0.002457 135.7600n -0.002364 135.7700n -0.002251 135.7800n -0.002121 135.7900n -0.001976 135.8000n -0.001819 135.8100n -0.001655 135.8200n -0.001486 135.8300n -0.001316 135.8400n -0.001148 135.8500n -0.000986 135.8600n -0.000831 135.8700n -0.000686 135.8800n -0.000554 135.8900n -0.000435
+ 135.9000n -0.000332 135.9100n -0.000245 135.9200n -0.000174 135.9300n -0.000119 135.9400n -0.000079 135.9500n -0.000054 135.9600n -0.000042 135.9700n -0.000041 135.9800n -0.000050 135.9900n -0.000066 136.0000n -0.000087 136.0100n -0.000110 136.0200n -0.000134 136.0300n -0.000155 136.0400n -0.000171
+ 136.0500n -0.000181 136.0600n -0.000182 136.0700n -0.000172 136.0800n -0.000152 136.0900n -0.000118 136.1000n -0.000072 136.1100n -0.000012 136.1200n 0.000060 136.1300n 0.000144 136.1400n 0.000240 136.1500n 0.000345 136.1600n 0.000459 136.1700n 0.000578 136.1800n 0.000701 136.1900n 0.000825
+ 136.2000n 0.000948 136.2100n 0.001068 136.2200n 0.001181 136.2300n 0.001285 136.2400n 0.001377 136.2500n 0.001456 136.2600n 0.001520 136.2700n 0.001567 136.2800n 0.001596 136.2900n 0.001605 136.3000n 0.001594 136.3100n 0.001564 136.3200n 0.001514 136.3300n 0.001445 136.3400n 0.001358
+ 136.3500n 0.001255 136.3600n 0.001137 136.3700n 0.001007 136.3800n 0.000868 136.3900n 0.000721 136.4000n 0.000569 136.4100n 0.000415 136.4200n 0.000263 136.4300n 0.000114 136.4400n -0.000028 136.4500n -0.000161 136.4600n -0.000283 136.4700n -0.000391 136.4800n -0.000484 136.4900n -0.000560
+ 136.5000n -0.000619 136.5100n -0.000660 136.5200n -0.000682 136.5300n -0.000686 136.5400n -0.000672 136.5500n -0.000642 136.5600n -0.000597 136.5700n -0.000537 136.5800n -0.000467 136.5900n -0.000386 136.6000n -0.000298 136.6100n -0.000206 136.6200n -0.000112 136.6300n -0.000018 136.6400n 0.000073
+ 136.6500n 0.000159 136.6600n 0.000237 136.6700n 0.000305 136.6800n 0.000362 136.6900n 0.000406 136.7000n 0.000436 136.7100n 0.000451 136.7200n 0.000450 136.7300n 0.000434 136.7400n 0.000403 136.7500n 0.000357 136.7600n 0.000298 136.7700n 0.000226 136.7800n 0.000143 136.7900n 0.000051
+ 136.8000n -0.000047 136.8100n -0.000151 136.8200n -0.000257 136.8300n -0.000364 136.8400n -0.000469 136.8500n -0.000569 136.8600n -0.000664 136.8700n -0.000750 136.8800n -0.000826 136.8900n -0.000891 136.9000n -0.000942 136.9100n -0.000980 136.9200n -0.001004 136.9300n -0.001013 136.9400n -0.001007
+ 136.9500n -0.000986 136.9600n -0.000951 136.9700n -0.000904 136.9800n -0.000844 136.9900n -0.000774 137.0000n -0.000695 137.0100n -0.000608 137.0200n -0.000517 137.0300n -0.000421 137.0400n -0.000325 137.0500n -0.000229 137.0600n -0.000135 137.0700n -0.000045 137.0800n 0.000039 137.0900n 0.000116
+ 137.1000n 0.000184 137.1100n 0.000243 137.1200n 0.000292 137.1300n 0.000330 137.1400n 0.000357 137.1500n 0.000373 137.1600n 0.000379 137.1700n 0.000374 137.1800n 0.000360 137.1900n 0.000339 137.2000n 0.000310 137.2100n 0.000276 137.2200n 0.000238 137.2300n 0.000198 137.2400n 0.000158
+ 137.2500n 0.000118 137.2600n 0.000082 137.2700n 0.000050 137.2800n 0.000025 137.2900n 0.000007 137.3000n -0.000002 137.3100n -0.000001 137.3200n 0.000012 137.3300n 0.000036 137.3400n 0.000072 137.3500n 0.000122 137.3600n 0.000184 137.3700n 0.000258 137.3800n 0.000345 137.3900n 0.000442
+ 137.4000n 0.000551 137.4100n 0.000669 137.4200n 0.000795 137.4300n 0.000928 137.4400n 0.001067 137.4500n 0.001209 137.4600n 0.001353 137.4700n 0.001498 137.4800n 0.001641 137.4900n 0.001781 137.5000n 0.001916 137.5100n 0.002045 137.5200n 0.002166 137.5300n 0.002277 137.5400n 0.002377
+ 137.5500n 0.002466 137.5600n 0.002541 137.5700n 0.002602 137.5800n 0.002648 137.5900n 0.002679 137.6000n 0.002694 137.6100n 0.002693 137.6200n 0.002675 137.6300n 0.002642 137.6400n 0.002594 137.6500n 0.002530 137.6600n 0.002451 137.6700n 0.002359 137.6800n 0.002254 137.6900n 0.002137
+ 137.7000n 0.002010 137.7100n 0.001874 137.7200n 0.001730 137.7300n 0.001579 137.7400n 0.001424 137.7500n 0.001265 137.7600n 0.001106 137.7700n 0.000947 137.7800n 0.000789 137.7900n 0.000636 137.8000n 0.000489 137.8100n 0.000349 137.8200n 0.000218 137.8300n 0.000098 137.8400n -0.000011
+ 137.8500n -0.000105 137.8600n -0.000185 137.8700n -0.000248 137.8800n -0.000295 137.8900n -0.000323 137.9000n -0.000334 137.9100n -0.000326 137.9200n -0.000299 137.9300n -0.000253 137.9400n -0.000189 137.9500n -0.000108 137.9600n -0.000009 137.9700n 0.000104 137.9800n 0.000232 137.9900n 0.000372
+ 138.0000n 0.000523 138.0100n 0.000682 138.0200n 0.000848 138.0300n 0.001017 138.0400n 0.001186 138.0500n 0.001355 138.0600n 0.001518 138.0700n 0.001675 138.0800n 0.001821 138.0900n 0.001955 138.1000n 0.002073 138.1100n 0.002173 138.1200n 0.002253 138.1300n 0.002312 138.1400n 0.002346
+ 138.1500n 0.002355 138.1600n 0.002338 138.1700n 0.002293 138.1800n 0.002222 138.1900n 0.002122 138.2000n 0.001996 138.2100n 0.001845 138.2200n 0.001668 138.2300n 0.001468 138.2400n 0.001248 138.2500n 0.001009 138.2600n 0.000754 138.2700n 0.000486 138.2800n 0.000209 138.2900n -0.000074
+ 138.3000n -0.000360 138.3100n -0.000645 138.3200n -0.000925 138.3300n -0.001197 138.3400n -0.001457 138.3500n -0.001702 138.3600n -0.001929 138.3700n -0.002134 138.3800n -0.002316 138.3900n -0.002472 138.4000n -0.002601 138.4100n -0.002700 138.4200n -0.002770 138.4300n -0.002808 138.4400n -0.002816
+ 138.4500n -0.002794 138.4600n -0.002742 138.4700n -0.002661 138.4800n -0.002554 138.4900n -0.002422 138.5000n -0.002268 138.5100n -0.002093 138.5200n -0.001901 138.5300n -0.001695 138.5400n -0.001478 138.5500n -0.001252 138.5600n -0.001021 138.5700n -0.000789 138.5800n -0.000557 138.5900n -0.000329
+ 138.6000n -0.000108 138.6100n 0.000104 138.6200n 0.000304 138.6300n 0.000492 138.6400n 0.000665 138.6500n 0.000821 138.6600n 0.000961 138.6700n 0.001083 138.6800n 0.001187 138.6900n 0.001272 138.7000n 0.001340 138.7100n 0.001391 138.7200n 0.001424 138.7300n 0.001443 138.7400n 0.001447
+ 138.7500n 0.001437 138.7600n 0.001416 138.7700n 0.001385 138.7800n 0.001344 138.7900n 0.001296 138.8000n 0.001242 138.8100n 0.001183 138.8200n 0.001121 138.8300n 0.001057 138.8400n 0.000991 138.8500n 0.000925 138.8600n 0.000859 138.8700n 0.000794 138.8800n 0.000731 138.8900n 0.000669
+ 138.9000n 0.000609 138.9100n 0.000551 138.9200n 0.000496 138.9300n 0.000442 138.9400n 0.000390 138.9500n 0.000340 138.9600n 0.000292 138.9700n 0.000245 138.9800n 0.000199 138.9900n 0.000155 139.0000n 0.000112 139.0100n 0.000070 139.0200n 0.000031 139.0300n -0.000007 139.0400n -0.000043
+ 139.0500n -0.000076 139.0600n -0.000105 139.0700n -0.000132 139.0800n -0.000153 139.0900n -0.000170 139.1000n -0.000182 139.1100n -0.000187 139.1200n -0.000186 139.1300n -0.000178 139.1400n -0.000162 139.1500n -0.000139 139.1600n -0.000108 139.1700n -0.000069 139.1800n -0.000022 139.1900n 0.000031
+ 139.2000n 0.000092 139.2100n 0.000158 139.2200n 0.000230 139.2300n 0.000305 139.2400n 0.000384 139.2500n 0.000465 139.2600n 0.000546 139.2700n 0.000626 139.2800n 0.000703 139.2900n 0.000777 139.3000n 0.000845 139.3100n 0.000906 139.3200n 0.000960 139.3300n 0.001004 139.3400n 0.001038
+ 139.3500n 0.001062 139.3600n 0.001074 139.3700n 0.001074 139.3800n 0.001062 139.3900n 0.001039 139.4000n 0.001005 139.4100n 0.000960 139.4200n 0.000906 139.4300n 0.000843 139.4400n 0.000774 139.4500n 0.000699 139.4600n 0.000621 139.4700n 0.000541 139.4800n 0.000460 139.4900n 0.000382
+ 139.5000n 0.000308 139.5100n 0.000239 139.5200n 0.000177 139.5300n 0.000123 139.5400n 0.000080 139.5500n 0.000048 139.5600n 0.000027 139.5700n 0.000018 139.5800n 0.000022 139.5900n 0.000037 139.6000n 0.000063 139.6100n 0.000100 139.6200n 0.000147 139.6300n 0.000200 139.6400n 0.000260
+ 139.6500n 0.000323 139.6600n 0.000388 139.6700n 0.000452 139.6800n 0.000513 139.6900n 0.000568 139.7000n 0.000614 139.7100n 0.000650 139.7200n 0.000673 139.7300n 0.000682 139.7400n 0.000673 139.7500n 0.000646 139.7600n 0.000600 139.7700n 0.000534 139.7800n 0.000448 139.7900n 0.000342
+ 139.8000n 0.000216 139.8100n 0.000073 139.8200n -0.000088 139.8300n -0.000264 139.8400n -0.000452 139.8500n -0.000650 139.8600n -0.000856 139.8700n -0.001064 139.8800n -0.001274 139.8900n -0.001480 139.9000n -0.001679 139.9100n -0.001867 139.9200n -0.002042 139.9300n -0.002200 139.9400n -0.002338
+ 139.9500n -0.002454 139.9600n -0.002544 139.9700n -0.002607 139.9800n -0.002642 139.9900n -0.002648 140.0000n -0.002624 140.0100n -0.002571 140.0200n -0.002489 140.0300n -0.002381 140.0400n -0.002246 140.0500n -0.002089 140.0600n -0.001911 140.0700n -0.001717 140.0800n -0.001508 140.0900n -0.001290
+ 140.1000n -0.001067 140.1100n -0.000842 140.1200n -0.000619 140.1300n -0.000403 140.1400n -0.000198 140.1500n -0.000008 140.1600n 0.000164 140.1700n 0.000315 140.1800n 0.000442 140.1900n 0.000543 140.2000n 0.000615 140.2100n 0.000658 140.2200n 0.000671 140.2300n 0.000654 140.2400n 0.000606
+ 140.2500n 0.000530 140.2600n 0.000427 140.2700n 0.000298 140.2800n 0.000146 140.2900n -0.000025 140.3000n -0.000214 140.3100n -0.000415 140.3200n -0.000627 140.3300n -0.000844 140.3400n -0.001064 140.3500n -0.001282 140.3600n -0.001495 140.3700n -0.001699 140.3800n -0.001892 140.3900n -0.002069
+ 140.4000n -0.002230 140.4100n -0.002371 140.4200n -0.002491 140.4300n -0.002588 140.4400n -0.002663 140.4500n -0.002714 140.4600n -0.002741 140.4700n -0.002746 140.4800n -0.002730 140.4900n -0.002692 140.5000n -0.002637 140.5100n -0.002564 140.5200n -0.002477 140.5300n -0.002377 140.5400n -0.002268
+ 140.5500n -0.002151 140.5600n -0.002029 140.5700n -0.001905 140.5800n -0.001780 140.5900n -0.001657 140.6000n -0.001537 140.6100n -0.001423 140.6200n -0.001314 140.6300n -0.001213 140.6400n -0.001120 140.6500n -0.001035 140.6600n -0.000959 140.6700n -0.000890 140.6800n -0.000830 140.6900n -0.000776
+ 140.7000n -0.000728 140.7100n -0.000685 140.7200n -0.000646 140.7300n -0.000610 140.7400n -0.000575 140.7500n -0.000540 140.7600n -0.000504 140.7700n -0.000466 140.7800n -0.000426 140.7900n -0.000382 140.8000n -0.000334 140.8100n -0.000282 140.8200n -0.000226 140.8300n -0.000166 140.8400n -0.000104
+ 140.8500n -0.000039 140.8600n 0.000027 140.8700n 0.000094 140.8800n 0.000159 140.8900n 0.000222 140.9000n 0.000281 140.9100n 0.000334 140.9200n 0.000380 140.9300n 0.000418 140.9400n 0.000446 140.9500n 0.000464 140.9600n 0.000470 140.9700n 0.000463 140.9800n 0.000444 140.9900n 0.000413
+ 141.0000n 0.000369 141.0100n 0.000314 141.0200n 0.000248 141.0300n 0.000173 141.0400n 0.000089 141.0500n 0.000000 141.0600n -0.000093 141.0700n -0.000187 141.0800n -0.000281 141.0900n -0.000371 141.1000n -0.000456 141.1100n -0.000532 141.1200n -0.000597 141.1300n -0.000649 141.1400n -0.000686
+ 141.1500n -0.000706 141.1600n -0.000707 141.1700n -0.000689 141.1800n -0.000650 141.1900n -0.000590 141.2000n -0.000510 141.2100n -0.000410 141.2200n -0.000290 141.2300n -0.000154 141.2400n -0.000001 141.2500n 0.000165 141.2600n 0.000341 141.2700n 0.000526 141.2800n 0.000715 141.2900n 0.000905
+ 141.3000n 0.001094 141.3100n 0.001276 141.3200n 0.001450 141.3300n 0.001612 141.3400n 0.001759 141.3500n 0.001887 141.3600n 0.001994 141.3700n 0.002079 141.3800n 0.002139 141.3900n 0.002173 141.4000n 0.002180 141.4100n 0.002160 141.4200n 0.002113 141.4300n 0.002041 141.4400n 0.001943
+ 141.4500n 0.001823 141.4600n 0.001682 141.4700n 0.001523 141.4800n 0.001348 141.4900n 0.001162 141.5000n 0.000967 141.5100n 0.000767 141.5200n 0.000566 141.5300n 0.000367 141.5400n 0.000174 141.5500n -0.000009 141.5600n -0.000180 141.5700n -0.000335 141.5800n -0.000471 141.5900n -0.000588
+ 141.6000n -0.000682 141.6100n -0.000753 141.6200n -0.000800 141.6300n -0.000822 141.6400n -0.000819 141.6500n -0.000793 141.6600n -0.000745 141.6700n -0.000675 141.6800n -0.000586 141.6900n -0.000480 141.7000n -0.000360 141.7100n -0.000228 141.7200n -0.000087 141.7300n 0.000059 141.7400n 0.000209
+ 141.7500n 0.000359 141.7600n 0.000506 141.7700n 0.000647 141.7800n 0.000781 141.7900n 0.000906 141.8000n 0.001018 141.8100n 0.001118 141.8200n 0.001204 141.8300n 0.001275 141.8400n 0.001331 141.8500n 0.001372 141.8600n 0.001399 141.8700n 0.001412 141.8800n 0.001412 141.8900n 0.001400
+ 141.9000n 0.001379 141.9100n 0.001349 141.9200n 0.001313 141.9300n 0.001271 141.9400n 0.001227 141.9500n 0.001181 141.9600n 0.001135 141.9700n 0.001091 141.9800n 0.001049 141.9900n 0.001012 142.0000n 0.000978 142.0100n 0.000950 142.0200n 0.000926 142.0300n 0.000907 142.0400n 0.000893
+ 142.0500n 0.000883 142.0600n 0.000875 142.0700n 0.000868 142.0800n 0.000862 142.0900n 0.000855 142.1000n 0.000846 142.1100n 0.000832 142.1200n 0.000812 142.1300n 0.000785 142.1400n 0.000750 142.1500n 0.000705 142.1600n 0.000650 142.1700n 0.000584 142.1800n 0.000507 142.1900n 0.000418
+ 142.2000n 0.000318 142.2100n 0.000208 142.2200n 0.000089 142.2300n -0.000038 142.2400n -0.000172 142.2500n -0.000310 142.2600n -0.000450 142.2700n -0.000591 142.2800n -0.000728 142.2900n -0.000861 142.3000n -0.000986 142.3100n -0.001100 142.3200n -0.001202 142.3300n -0.001289 142.3400n -0.001359
+ 142.3500n -0.001410 142.3600n -0.001441 142.3700n -0.001451 142.3800n -0.001438 142.3900n -0.001404 142.4000n -0.001347 142.4100n -0.001269 142.4200n -0.001171 142.4300n -0.001054 142.4400n -0.000920 142.4500n -0.000772 142.4600n -0.000612 142.4700n -0.000443 142.4800n -0.000268 142.4900n -0.000090
+ 142.5000n 0.000086 142.5100n 0.000259 142.5200n 0.000424 142.5300n 0.000578 142.5400n 0.000719 142.5500n 0.000843 142.5600n 0.000949 142.5700n 0.001034 142.5800n 0.001097 142.5900n 0.001137 142.6000n 0.001153 142.6100n 0.001145 142.6200n 0.001113 142.6300n 0.001058 142.6400n 0.000982
+ 142.6500n 0.000886 142.6600n 0.000772 142.6700n 0.000644 142.6800n 0.000503 142.6900n 0.000352 142.7000n 0.000196 142.7100n 0.000036 142.7200n -0.000122 142.7300n -0.000278 142.7400n -0.000426 142.7500n -0.000565 142.7600n -0.000691 142.7700n -0.000803 142.7800n -0.000898 142.7900n -0.000975
+ 142.8000n -0.001032 142.8100n -0.001069 142.8200n -0.001086 142.8300n -0.001082 142.8400n -0.001058 142.8500n -0.001016 142.8600n -0.000956 142.8700n -0.000881 142.8800n -0.000792 142.8900n -0.000691 142.9000n -0.000582 142.9100n -0.000466 142.9200n -0.000346 142.9300n -0.000225 142.9400n -0.000105
+ 142.9500n 0.000012 142.9600n 0.000123 142.9700n 0.000226 142.9800n 0.000320 142.9900n 0.000403 143.0000n 0.000475 143.0100n 0.000535 143.0200n 0.000582 143.0300n 0.000618 143.0400n 0.000641 143.0500n 0.000653 143.0600n 0.000655 143.0700n 0.000649 143.0800n 0.000636 143.0900n 0.000617
+ 143.1000n 0.000595 143.1100n 0.000571 143.1200n 0.000547 143.1300n 0.000525 143.1400n 0.000507 143.1500n 0.000494 143.1600n 0.000488 143.1700n 0.000490 143.1800n 0.000500 143.1900n 0.000519 143.2000n 0.000548 143.2100n 0.000586 143.2200n 0.000633 143.2300n 0.000689 143.2400n 0.000751
+ 143.2500n 0.000820 143.2600n 0.000893 143.2700n 0.000969 143.2800n 0.001046 143.2900n 0.001123 143.3000n 0.001198 143.3100n 0.001268 143.3200n 0.001333 143.3300n 0.001390 143.3400n 0.001438 143.3500n 0.001476 143.3600n 0.001502 143.3700n 0.001517 143.3800n 0.001520 143.3900n 0.001510
+ 143.4000n 0.001489 143.4100n 0.001456 143.4200n 0.001412 143.4300n 0.001358 143.4400n 0.001296 143.4500n 0.001227 143.4600n 0.001153 143.4700n 0.001076 143.4800n 0.000996 143.4900n 0.000916 143.5000n 0.000838 143.5100n 0.000763 143.5200n 0.000692 143.5300n 0.000627 143.5400n 0.000568
+ 143.5500n 0.000516 143.5600n 0.000471 143.5700n 0.000432 143.5800n 0.000400 143.5900n 0.000373 143.6000n 0.000350 143.6100n 0.000330 143.6200n 0.000311 143.6300n 0.000291 143.6400n 0.000268 143.6500n 0.000239 143.6600n 0.000202 143.6700n 0.000155 143.6800n 0.000095 143.6900n 0.000022
+ 143.7000n -0.000069 143.7100n -0.000176 143.7200n -0.000303 143.7300n -0.000449 143.7400n -0.000615 143.7500n -0.000800 143.7600n -0.001003 143.7700n -0.001223 143.7800n -0.001459 143.7900n -0.001707 143.8000n -0.001964 143.8100n -0.002228 143.8200n -0.002493 143.8300n -0.002757 143.8400n -0.003014
+ 143.8500n -0.003260 143.8600n -0.003490 143.8700n -0.003700 143.8800n -0.003884 143.8900n -0.004039 143.9000n -0.004161 143.9100n -0.004245 143.9200n -0.004290 143.9300n -0.004293 143.9400n -0.004251 143.9500n -0.004165 143.9600n -0.004033 143.9700n -0.003857 143.9800n -0.003638 143.9900n -0.003379
+ 144.0000n -0.003082 144.0100n -0.002751 144.0200n -0.002391 144.0300n -0.002008 144.0400n -0.001607 144.0500n -0.001194 144.0600n -0.000775 144.0700n -0.000358 144.0800n 0.000051 144.0900n 0.000445 144.1000n 0.000818 144.1100n 0.001163 144.1200n 0.001476 144.1300n 0.001750 144.1400n 0.001982
+ 144.1500n 0.002167 144.1600n 0.002304 144.1700n 0.002390 144.1800n 0.002425 144.1900n 0.002409 144.2000n 0.002343 144.2100n 0.002229 144.2200n 0.002070 144.2300n 0.001870 144.2400n 0.001635 144.2500n 0.001369 144.2600n 0.001079 144.2700n 0.000772 144.2800n 0.000454 144.2900n 0.000132
+ 144.3000n -0.000186 144.3100n -0.000493 144.3200n -0.000783 144.3300n -0.001048 144.3400n -0.001284 144.3500n -0.001485 144.3600n -0.001647 144.3700n -0.001765 144.3800n -0.001838 144.3900n -0.001864 144.4000n -0.001841 144.4100n -0.001771 144.4200n -0.001655 144.4300n -0.001495 144.4400n -0.001295
+ 144.4500n -0.001059 144.4600n -0.000792 144.4700n -0.000499 144.4800n -0.000188 144.4900n 0.000136 144.5000n 0.000466 144.5100n 0.000795 144.5200n 0.001115 144.5300n 0.001420 144.5400n 0.001704 144.5500n 0.001961 144.5600n 0.002185 144.5700n 0.002373 144.5800n 0.002519 144.5900n 0.002622
+ 144.6000n 0.002679 144.6100n 0.002691 144.6200n 0.002656 144.6300n 0.002576 144.6400n 0.002453 144.6500n 0.002291 144.6600n 0.002093 144.6700n 0.001865 144.6800n 0.001611 144.6900n 0.001337 144.7000n 0.001050 144.7100n 0.000756 144.7200n 0.000463 144.7300n 0.000176 144.7400n -0.000097
+ 144.7500n -0.000351 144.7600n -0.000579 144.7700n -0.000777 144.7800n -0.000940 144.7900n -0.001064 144.8000n -0.001146 144.8100n -0.001186 144.8200n -0.001180 144.8300n -0.001131 144.8400n -0.001038 144.8500n -0.000903 144.8600n -0.000731 144.8700n -0.000523 144.8800n -0.000285 144.8900n -0.000021
+ 144.9000n 0.000262 144.9100n 0.000559 144.9200n 0.000864 144.9300n 0.001170 144.9400n 0.001471 144.9500n 0.001761 144.9600n 0.002034 144.9700n 0.002284 144.9800n 0.002507 144.9900n 0.002697 145.0000n 0.002852 145.0100n 0.002969 145.0200n 0.003047 145.0300n 0.003082 145.0400n 0.003077
+ 145.0500n 0.003031 145.0600n 0.002947 145.0700n 0.002826 145.0800n 0.002672 145.0900n 0.002488 145.1000n 0.002280 145.1100n 0.002051 145.1200n 0.001809 145.1300n 0.001557 145.1400n 0.001301 145.1500n 0.001047 145.1600n 0.000801 145.1700n 0.000568 145.1800n 0.000352 145.1900n 0.000158
+ 145.2000n -0.000011 145.2100n -0.000152 145.2200n -0.000261 145.2300n -0.000338 145.2400n -0.000382 145.2500n -0.000392 145.2600n -0.000370 145.2700n -0.000317 145.2800n -0.000234 145.2900n -0.000126 145.3000n 0.000006 145.3100n 0.000157 145.3200n 0.000322 145.3300n 0.000499 145.3400n 0.000681
+ 145.3500n 0.000865 145.3600n 0.001045 145.3700n 0.001219 145.3800n 0.001381 145.3900n 0.001528 145.4000n 0.001657 145.4100n 0.001766 145.4200n 0.001851 145.4300n 0.001912 145.4400n 0.001949 145.4500n 0.001960 145.4600n 0.001948 145.4700n 0.001912 145.4800n 0.001854 145.4900n 0.001778
+ 145.5000n 0.001686 145.5100n 0.001581 145.5200n 0.001467 145.5300n 0.001347 145.5400n 0.001226 145.5500n 0.001106 145.5600n 0.000993 145.5700n 0.000889 145.5800n 0.000799 145.5900n 0.000723 145.6000n 0.000666 145.6100n 0.000630 145.6200n 0.000614 145.6300n 0.000621 145.6400n 0.000651
+ 145.6500n 0.000702 145.6600n 0.000774 145.6700n 0.000865 145.6800n 0.000973 145.6900n 0.001094 145.7000n 0.001226 145.7100n 0.001366 145.7200n 0.001508 145.7300n 0.001650 145.7400n 0.001787 145.7500n 0.001914 145.7600n 0.002029 145.7700n 0.002126 145.7800n 0.002203 145.7900n 0.002256
+ 145.8000n 0.002284 145.8100n 0.002283 145.8200n 0.002253 145.8300n 0.002193 145.8400n 0.002102 145.8500n 0.001981 145.8600n 0.001832 145.8700n 0.001656 145.8800n 0.001456 145.8900n 0.001235 145.9000n 0.000997 145.9100n 0.000746 145.9200n 0.000486 145.9300n 0.000221 145.9400n -0.000042
+ 145.9500n -0.000300 145.9600n -0.000548 145.9700n -0.000781 145.9800n -0.000994 145.9900n -0.001183 146.0000n -0.001345 146.0100n -0.001477 146.0200n -0.001576 146.0300n -0.001640 146.0400n -0.001668 146.0500n -0.001659 146.0600n -0.001614 146.0700n -0.001533 146.0800n -0.001419 146.0900n -0.001273
+ 146.1000n -0.001098 146.1100n -0.000898 146.1200n -0.000676 146.1300n -0.000437 146.1400n -0.000186 146.1500n 0.000073 146.1600n 0.000335 146.1700n 0.000595 146.1800n 0.000848 146.1900n 0.001089 146.2000n 0.001314 146.2100n 0.001519 146.2200n 0.001700 146.2300n 0.001854 146.2400n 0.001978
+ 146.2500n 0.002071 146.2600n 0.002131 146.2700n 0.002158 146.2800n 0.002151 146.2900n 0.002111 146.3000n 0.002039 146.3100n 0.001937 146.3200n 0.001807 146.3300n 0.001652 146.3400n 0.001475 146.3500n 0.001280 146.3600n 0.001070 146.3700n 0.000849 146.3800n 0.000621 146.3900n 0.000390
+ 146.4000n 0.000160 146.4100n -0.000065 146.4200n -0.000282 146.4300n -0.000488 146.4400n -0.000679 146.4500n -0.000854 146.4600n -0.001010 146.4700n -0.001146 146.4800n -0.001260 146.4900n -0.001353 146.5000n -0.001424 146.5100n -0.001473 146.5200n -0.001502 146.5300n -0.001511 146.5400n -0.001503
+ 146.5500n -0.001478 146.5600n -0.001440 146.5700n -0.001391 146.5800n -0.001333 146.5900n -0.001270 146.6000n -0.001203 146.6100n -0.001135 146.6200n -0.001069 146.6300n -0.001007 146.6400n -0.000952 146.6500n -0.000905 146.6600n -0.000869 146.6700n -0.000843 146.6800n -0.000831 146.6900n -0.000831
+ 146.7000n -0.000845 146.7100n -0.000872 146.7200n -0.000913 146.7300n -0.000966 146.7400n -0.001031 146.7500n -0.001107 146.7600n -0.001192 146.7700n -0.001284 146.7800n -0.001382 146.7900n -0.001485 146.8000n -0.001589 146.8100n -0.001694 146.8200n -0.001796 146.8300n -0.001896 146.8400n -0.001989
+ 146.8500n -0.002076 146.8600n -0.002155 146.8700n -0.002223 146.8800n -0.002280 146.8900n -0.002326 146.9000n -0.002358 146.9100n -0.002377 146.9200n -0.002383 146.9300n -0.002375 146.9400n -0.002353 146.9500n -0.002318 146.9600n -0.002269 146.9700n -0.002209 146.9800n -0.002136 146.9900n -0.002053
+ 147.0000n -0.001959 147.0100n -0.001856 147.0200n -0.001745 147.0300n -0.001628 147.0400n -0.001504 147.0500n -0.001376 147.0600n -0.001244 147.0700n -0.001109 147.0800n -0.000973 147.0900n -0.000837 147.1000n -0.000701 147.1100n -0.000567 147.1200n -0.000436 147.1300n -0.000308 147.1400n -0.000185
+ 147.1500n -0.000068 147.1600n 0.000043 147.1700n 0.000147 147.1800n 0.000243 147.1900n 0.000329 147.2000n 0.000406 147.2100n 0.000471 147.2200n 0.000526 147.2300n 0.000567 147.2400n 0.000596 147.2500n 0.000612 147.2600n 0.000613 147.2700n 0.000599 147.2800n 0.000571 147.2900n 0.000527
+ 147.3000n 0.000468 147.3100n 0.000393 147.3200n 0.000303 147.3300n 0.000199 147.3400n 0.000080 147.3500n -0.000052 147.3600n -0.000197 147.3700n -0.000352 147.3800n -0.000518 147.3900n -0.000692 147.4000n -0.000873 147.4100n -0.001059 147.4200n -0.001247 147.4300n -0.001435 147.4400n -0.001622
+ 147.4500n -0.001805 147.4600n -0.001982 147.4700n -0.002150 147.4800n -0.002307 147.4900n -0.002450 147.5000n -0.002579 147.5100n -0.002691 147.5200n -0.002784 147.5300n -0.002858 147.5400n -0.002910 147.5500n -0.002940 147.5600n -0.002948 147.5700n -0.002933 147.5800n -0.002896 147.5900n -0.002838
+ 147.6000n -0.002758 147.6100n -0.002658 147.6200n -0.002540 147.6300n -0.002406 147.6400n -0.002258 147.6500n -0.002098 147.6600n -0.001929 147.6700n -0.001754 147.6800n -0.001574 147.6900n -0.001394 147.7000n -0.001216 147.7100n -0.001043 147.7200n -0.000877 147.7300n -0.000721 147.7400n -0.000578
+ 147.7500n -0.000449 147.7600n -0.000336 147.7700n -0.000240 147.7800n -0.000163 147.7900n -0.000106 147.8000n -0.000068 147.8100n -0.000050 147.8200n -0.000051 147.8300n -0.000069 147.8400n -0.000105 147.8500n -0.000155 147.8600n -0.000219 147.8700n -0.000294 147.8800n -0.000378 147.8900n -0.000467
+ 147.9000n -0.000560 147.9100n -0.000653 147.9200n -0.000744 147.9300n -0.000830 147.9400n -0.000908 147.9500n -0.000976 147.9600n -0.001032 147.9700n -0.001073 147.9800n -0.001097 147.9900n -0.001104 148.0000n -0.001093 148.0100n -0.001062 148.0200n -0.001013 148.0300n -0.000944 148.0400n -0.000856
+ 148.0500n -0.000751 148.0600n -0.000630 148.0700n -0.000494 148.0800n -0.000347 148.0900n -0.000189 148.1000n -0.000025 148.1100n 0.000144 148.1200n 0.000315 148.1300n 0.000484 148.1400n 0.000648 148.1500n 0.000805 148.1600n 0.000952 148.1700n 0.001085 148.1800n 0.001203 148.1900n 0.001303
+ 148.2000n 0.001382 148.2100n 0.001440 148.2200n 0.001474 148.2300n 0.001485 148.2400n 0.001471 148.2500n 0.001432 148.2600n 0.001368 148.2700n 0.001280 148.2800n 0.001170 148.2900n 0.001038 148.3000n 0.000886 148.3100n 0.000716 148.3200n 0.000531 148.3300n 0.000333 148.3400n 0.000124
+ 148.3500n -0.000092 148.3600n -0.000313 148.3700n -0.000535 148.3800n -0.000756 148.3900n -0.000973 148.4000n -0.001183 148.4100n -0.001384 148.4200n -0.001572 148.4300n -0.001747 148.4400n -0.001906 148.4500n -0.002047 148.4600n -0.002169 148.4700n -0.002272 148.4800n -0.002354 148.4900n -0.002415
+ 148.5000n -0.002455 148.5100n -0.002474 148.5200n -0.002474 148.5300n -0.002455 148.5400n -0.002417 148.5500n -0.002364 148.5600n -0.002295 148.5700n -0.002213 148.5800n -0.002120 148.5900n -0.002017 148.6000n -0.001907 148.6100n -0.001792 148.6200n -0.001674 148.6300n -0.001555 148.6400n -0.001436
+ 148.6500n -0.001320 148.6600n -0.001209 148.6700n -0.001103 148.6800n -0.001004 148.6900n -0.000914 148.7000n -0.000833 148.7100n -0.000761 148.7200n -0.000700 148.7300n -0.000649 148.7400n -0.000609 148.7500n -0.000579 148.7600n -0.000558 148.7700n -0.000546 148.7800n -0.000542 148.7900n -0.000545
+ 148.8000n -0.000554 148.8100n -0.000567 148.8200n -0.000583 148.8300n -0.000600 148.8400n -0.000616 148.8500n -0.000630 148.8600n -0.000641 148.8700n -0.000646 148.8800n -0.000644 148.8900n -0.000634 148.9000n -0.000614 148.9100n -0.000583 148.9200n -0.000540 148.9300n -0.000485 148.9400n -0.000415
+ 148.9500n -0.000332 148.9600n -0.000235 148.9700n -0.000124 148.9800n 0.000001 148.9900n 0.000139 149.0000n 0.000289 149.0100n 0.000450 149.0200n 0.000621 149.0300n 0.000800 149.0400n 0.000985 149.0500n 0.001175 149.0600n 0.001367 149.0700n 0.001559 149.0800n 0.001748 149.0900n 0.001933
+ 149.1000n 0.002109 149.1100n 0.002276 149.1200n 0.002430 149.1300n 0.002570 149.1400n 0.002692 149.1500n 0.002795 149.1600n 0.002877 149.1700n 0.002935 149.1800n 0.002970 149.1900n 0.002979 149.2000n 0.002963 149.2100n 0.002920 149.2200n 0.002851 149.2300n 0.002755 149.2400n 0.002635
+ 149.2500n 0.002491 149.2600n 0.002324 149.2700n 0.002137 149.2800n 0.001932 149.2900n 0.001712 149.3000n 0.001480 149.3100n 0.001238 149.3200n 0.000990 149.3300n 0.000741 149.3400n 0.000493 149.3500n 0.000250 149.3600n 0.000016 149.3700n -0.000205 149.3800n -0.000410 149.3900n -0.000595
+ 149.4000n -0.000757 149.4100n -0.000894 149.4200n -0.001003 149.4300n -0.001083 149.4400n -0.001131 149.4500n -0.001147 149.4600n -0.001129 149.4700n -0.001079 149.4800n -0.000996 149.4900n -0.000882 149.5000n -0.000739 149.5100n -0.000567 149.5200n -0.000371 149.5300n -0.000153 149.5400n 0.000084
+ 149.5500n 0.000336 149.5600n 0.000599 149.5700n 0.000868 149.5800n 0.001140 149.5900n 0.001409 149.6000n 0.001671 149.6100n 0.001923 149.6200n 0.002158 149.6300n 0.002375 149.6400n 0.002569 149.6500n 0.002736 149.6600n 0.002875 149.6700n 0.002981 149.6800n 0.003055 149.6900n 0.003093
+ 149.7000n 0.003096 149.7100n 0.003064 149.7200n 0.002995 149.7300n 0.002893 149.7400n 0.002758 149.7500n 0.002591 149.7600n 0.002397 149.7700n 0.002177 149.7800n 0.001934 149.7900n 0.001674 149.8000n 0.001398 149.8100n 0.001113 149.8200n 0.000820 149.8300n 0.000526 149.8400n 0.000233
+ 149.8500n -0.000054 149.8600n -0.000332 149.8700n -0.000596 149.8800n -0.000845 149.8900n -0.001075 149.9000n -0.001283 149.9100n -0.001469 149.9200n -0.001630 149.9300n -0.001765 149.9400n -0.001875 149.9500n -0.001958 149.9600n -0.002016 149.9700n -0.002050 149.9800n -0.002061 149.9900n -0.002050
+ 150.0000n -0.002021 150.0100n -0.001973 150.0200n -0.001912 150.0300n -0.001838 150.0400n -0.001755 150.0500n -0.001665 150.0600n -0.001571 150.0700n -0.001476 150.0800n -0.001380 150.0900n -0.001288 150.1000n -0.001200 150.1100n -0.001117 150.1200n -0.001042 150.1300n -0.000974 150.1400n -0.000915
+ 150.1500n -0.000864 150.1600n -0.000820 150.1700n -0.000784 150.1800n -0.000754 150.1900n -0.000729 150.2000n -0.000708 150.2100n -0.000689 150.2200n -0.000670 150.2300n -0.000649 150.2400n -0.000625 150.2500n -0.000596 150.2600n -0.000560 150.2700n -0.000516 150.2800n -0.000462 150.2900n -0.000397
+ 150.3000n -0.000321 150.3100n -0.000232 150.3200n -0.000131 150.3300n -0.000018 150.3400n 0.000106 150.3500n 0.000241 150.3600n 0.000386 150.3700n 0.000538 150.3800n 0.000696 150.3900n 0.000859 150.4000n 0.001023 150.4100n 0.001186 150.4200n 0.001346 150.4300n 0.001500 150.4400n 0.001645
+ 150.4500n 0.001780 150.4600n 0.001901 150.4700n 0.002007 150.4800n 0.002095 150.4900n 0.002165 150.5000n 0.002215 150.5100n 0.002244 150.5200n 0.002251 150.5300n 0.002237 150.5400n 0.002202 150.5500n 0.002147 150.5600n 0.002072 150.5700n 0.001980 150.5800n 0.001872 150.5900n 0.001750
+ 150.6000n 0.001617 150.6100n 0.001476 150.6200n 0.001329 150.6300n 0.001180 150.6400n 0.001030 150.6500n 0.000884 150.6600n 0.000743 150.6700n 0.000611 150.6800n 0.000490 150.6900n 0.000381 150.7000n 0.000287 150.7100n 0.000209 150.7200n 0.000148 150.7300n 0.000105 150.7400n 0.000079
+ 150.7500n 0.000070 150.7600n 0.000078 150.7700n 0.000101 150.7800n 0.000138 150.7900n 0.000187 150.8000n 0.000246 150.8100n 0.000312 150.8200n 0.000383 150.8300n 0.000455 150.8400n 0.000527 150.8500n 0.000595 150.8600n 0.000656 150.8700n 0.000708 150.8800n 0.000749 150.8900n 0.000776
+ 150.9000n 0.000788 150.9100n 0.000783 150.9200n 0.000760 150.9300n 0.000718 150.9400n 0.000658 150.9500n 0.000580 150.9600n 0.000484 150.9700n 0.000372 150.9800n 0.000245 150.9900n 0.000106 151.0000n -0.000042 151.0100n -0.000198 151.0200n -0.000358 151.0300n -0.000518 151.0400n -0.000676
+ 151.0500n -0.000828 151.0600n -0.000970 151.0700n -0.001099 151.0800n -0.001213 151.0900n -0.001307 151.1000n -0.001379 151.1100n -0.001428 151.1200n -0.001450 151.1300n -0.001446 151.1400n -0.001412 151.1500n -0.001350 151.1600n -0.001258 151.1700n -0.001138 151.1800n -0.000991 151.1900n -0.000817
+ 151.2000n -0.000619 151.2100n -0.000400 151.2200n -0.000162 151.2300n 0.000092 151.2400n 0.000358 151.2500n 0.000633 151.2600n 0.000913 151.2700n 0.001194 151.2800n 0.001473 151.2900n 0.001745 151.3000n 0.002007 151.3100n 0.002255 151.3200n 0.002487 151.3300n 0.002699 151.3400n 0.002888
+ 151.3500n 0.003054 151.3600n 0.003193 151.3700n 0.003304 151.3800n 0.003388 151.3900n 0.003443 151.4000n 0.003469 151.4100n 0.003466 151.4200n 0.003437 151.4300n 0.003381 151.4400n 0.003301 151.4500n 0.003199 151.4600n 0.003076 151.4700n 0.002935 151.4800n 0.002779 151.4900n 0.002611
+ 151.5000n 0.002432 151.5100n 0.002246 151.5200n 0.002056 151.5300n 0.001864 151.5400n 0.001672 151.5500n 0.001483 151.5600n 0.001300 151.5700n 0.001123 151.5800n 0.000955 151.5900n 0.000797 151.6000n 0.000651 151.6100n 0.000516 151.6200n 0.000395 151.6300n 0.000286 151.6400n 0.000191
+ 151.6500n 0.000110 151.6600n 0.000042 151.6700n -0.000013 151.6800n -0.000055 151.6900n -0.000086 151.7000n -0.000105 151.7100n -0.000113 151.7200n -0.000111 151.7300n -0.000100 151.7400n -0.000080 151.7500n -0.000052 151.7600n -0.000016 151.7700n 0.000026 151.7800n 0.000075 151.7900n 0.000130
+ 151.8000n 0.000191 151.8100n 0.000257 151.8200n 0.000328 151.8300n 0.000405 151.8400n 0.000486 151.8500n 0.000571 151.8600n 0.000661 151.8700n 0.000755 151.8800n 0.000852 151.8900n 0.000952 151.9000n 0.001055 151.9100n 0.001160 151.9200n 0.001267 151.9300n 0.001374 151.9400n 0.001481
+ 151.9500n 0.001586 151.9600n 0.001689 151.9700n 0.001788 151.9800n 0.001882 151.9900n 0.001970 152.0000n 0.002050 152.0100n 0.002120 152.0200n 0.002181 152.0300n 0.002229 152.0400n 0.002265 152.0500n 0.002286 152.0600n 0.002292 152.0700n 0.002282 152.0800n 0.002255 152.0900n 0.002212
+ 152.1000n 0.002151 152.1100n 0.002073 152.1200n 0.001978 152.1300n 0.001867 152.1400n 0.001740 152.1500n 0.001599 152.1600n 0.001444 152.1700n 0.001279 152.1800n 0.001103 152.1900n 0.000920 152.2000n 0.000731 152.2100n 0.000538 152.2200n 0.000344 152.2300n 0.000152 152.2400n -0.000037
+ 152.2500n -0.000220 152.2600n -0.000395 152.2700n -0.000560 152.2800n -0.000712 152.2900n -0.000851 152.3000n -0.000974 152.3100n -0.001080 152.3200n -0.001168 152.3300n -0.001237 152.3400n -0.001287 152.3500n -0.001318 152.3600n -0.001330 152.3700n -0.001322 152.3800n -0.001297 152.3900n -0.001254
+ 152.4000n -0.001196 152.4100n -0.001123 152.4200n -0.001037 152.4300n -0.000940 152.4400n -0.000834 152.4500n -0.000721 152.4600n -0.000603 152.4700n -0.000481 152.4800n -0.000359 152.4900n -0.000238 152.5000n -0.000119 152.5100n -0.000006 152.5200n 0.000102 152.5300n 0.000201 152.5400n 0.000292
+ 152.5500n 0.000373 152.5600n 0.000442 152.5700n 0.000501 152.5800n 0.000547 152.5900n 0.000580 152.6000n 0.000602 152.6100n 0.000612 152.6200n 0.000609 152.6300n 0.000596 152.6400n 0.000571 152.6500n 0.000537 152.6600n 0.000494 152.6700n 0.000442 152.6800n 0.000383 152.6900n 0.000318
+ 152.7000n 0.000247 152.7100n 0.000171 152.7200n 0.000092 152.7300n 0.000010 152.7400n -0.000074 152.7500n -0.000159 152.7600n -0.000245 152.7700n -0.000331 152.7800n -0.000417 152.7900n -0.000502 152.8000n -0.000586 152.8100n -0.000668 152.8200n -0.000748 152.8300n -0.000825 152.8400n -0.000901
+ 152.8500n -0.000974 152.8600n -0.001043 152.8700n -0.001110 152.8800n -0.001173 152.8900n -0.001233 152.9000n -0.001288 152.9100n -0.001339 152.9200n -0.001385 152.9300n -0.001426 152.9400n -0.001461 152.9500n -0.001490 152.9600n -0.001513 152.9700n -0.001528 152.9800n -0.001537 152.9900n -0.001537
+ 153.0000n -0.001530 153.0100n -0.001514 153.0200n -0.001490 153.0300n -0.001458 153.0400n -0.001418 153.0500n -0.001369 153.0600n -0.001313 153.0700n -0.001249 153.0800n -0.001179 153.0900n -0.001103 153.1000n -0.001022 153.1100n -0.000938 153.1200n -0.000850 153.1300n -0.000762 153.1400n -0.000673
+ 153.1500n -0.000586 153.1600n -0.000501 153.1700n -0.000421 153.1800n -0.000347 153.1900n -0.000280 153.2000n -0.000221 153.2100n -0.000172 153.2200n -0.000134 153.2300n -0.000107 153.2400n -0.000092 153.2500n -0.000089 153.2600n -0.000100 153.2700n -0.000123 153.2800n -0.000158 153.2900n -0.000206
+ 153.3000n -0.000264 153.3100n -0.000332 153.3200n -0.000408 153.3300n -0.000492 153.3400n -0.000580 153.3500n -0.000672 153.3600n -0.000765 153.3700n -0.000857 153.3800n -0.000945 153.3900n -0.001028 153.4000n -0.001104 153.4100n -0.001169 153.4200n -0.001223 153.4300n -0.001262 153.4400n -0.001287
+ 153.4500n -0.001294 153.4600n -0.001284 153.4700n -0.001255 153.4800n -0.001207 153.4900n -0.001139 153.5000n -0.001052 153.5100n -0.000946 153.5200n -0.000822 153.5300n -0.000682 153.5400n -0.000527 153.5500n -0.000359 153.5600n -0.000180 153.5700n 0.000008 153.5800n 0.000202 153.5900n 0.000398
+ 153.6000n 0.000596 153.6100n 0.000790 153.6200n 0.000979 153.6300n 0.001160 153.6400n 0.001330 153.6500n 0.001486 153.6600n 0.001625 153.6700n 0.001746 153.6800n 0.001847 153.6900n 0.001925 153.7000n 0.001980 153.7100n 0.002011 153.7200n 0.002017 153.7300n 0.001998 153.7400n 0.001954
+ 153.7500n 0.001885 153.7600n 0.001794 153.7700n 0.001680 153.7800n 0.001546 153.7900n 0.001394 153.8000n 0.001225 153.8100n 0.001042 153.8200n 0.000848 153.8300n 0.000646 153.8400n 0.000438 153.8500n 0.000227 153.8600n 0.000016 153.8700n -0.000192 153.8800n -0.000394 153.8900n -0.000587
+ 153.9000n -0.000770 153.9100n -0.000940 153.9200n -0.001095 153.9300n -0.001233 153.9400n -0.001352 153.9500n -0.001452 153.9600n -0.001531 153.9700n -0.001589 153.9800n -0.001626 153.9900n -0.001640 154.0000n -0.001634 154.0100n -0.001606 154.0200n -0.001559 154.0300n -0.001492 154.0400n -0.001407
+ 154.0500n -0.001306 154.0600n -0.001190 154.0700n -0.001061 154.0800n -0.000920 154.0900n -0.000769 154.1000n -0.000611 154.1100n -0.000446 154.1200n -0.000278 154.1300n -0.000107 154.1400n 0.000064 154.1500n 0.000233 154.1600n 0.000400 154.1700n 0.000562 154.1800n 0.000717 154.1900n 0.000865
+ 154.2000n 0.001005 154.2100n 0.001134 154.2200n 0.001253 154.2300n 0.001360 154.2400n 0.001455 154.2500n 0.001537 154.2600n 0.001605 154.2700n 0.001660 154.2800n 0.001701 154.2900n 0.001729 154.3000n 0.001742 154.3100n 0.001742 154.3200n 0.001728 154.3300n 0.001702 154.3400n 0.001663
+ 154.3500n 0.001612 154.3600n 0.001551 154.3700n 0.001479 154.3800n 0.001397 154.3900n 0.001307 154.4000n 0.001209 154.4100n 0.001105 154.4200n 0.000996 154.4300n 0.000882 154.4400n 0.000765 154.4500n 0.000647 154.4600n 0.000528 154.4700n 0.000410 154.4800n 0.000294 154.4900n 0.000181
+ 154.5000n 0.000072 154.5100n -0.000032 154.5200n -0.000129 154.5300n -0.000219 154.5400n -0.000301 154.5500n -0.000374 154.5600n -0.000438 154.5700n -0.000493 154.5800n -0.000537 154.5900n -0.000572 154.6000n -0.000596 154.6100n -0.000611 154.6200n -0.000616 154.6300n -0.000612 154.6400n -0.000600
+ 154.6500n -0.000579 154.6600n -0.000552 154.6700n -0.000519 154.6800n -0.000481 154.6900n -0.000439 154.7000n -0.000393 154.7100n -0.000346 154.7200n -0.000299 154.7300n -0.000251 154.7400n -0.000204 154.7500n -0.000160 154.7600n -0.000118 154.7700n -0.000079 154.7800n -0.000044 154.7900n -0.000013
+ 154.8000n 0.000013 154.8100n 0.000036 154.8200n 0.000054 154.8300n 0.000068 154.8400n 0.000079 154.8500n 0.000087 154.8600n 0.000093 154.8700n 0.000098 154.8800n 0.000102 154.8900n 0.000107 154.9000n 0.000114 154.9100n 0.000123 154.9200n 0.000135 154.9300n 0.000152 154.9400n 0.000174
+ 154.9500n 0.000202 154.9600n 0.000235 154.9700n 0.000275 154.9800n 0.000322 154.9900n 0.000376 155.0000n 0.000435 155.0100n 0.000501 155.0200n 0.000571 155.0300n 0.000646 155.0400n 0.000724 155.0500n 0.000804 155.0600n 0.000884 155.0700n 0.000963 155.0800n 0.001039 155.0900n 0.001111
+ 155.1000n 0.001177 155.1100n 0.001234 155.1200n 0.001282 155.1300n 0.001319 155.1400n 0.001344 155.1500n 0.001354 155.1600n 0.001350 155.1700n 0.001330 155.1800n 0.001295 155.1900n 0.001242 155.2000n 0.001174 155.2100n 0.001089 155.2200n 0.000989 155.2300n 0.000875 155.2400n 0.000748
+ 155.2500n 0.000610 155.2600n 0.000462 155.2700n 0.000306 155.2800n 0.000145 155.2900n -0.000019 155.3000n -0.000184 155.3100n -0.000347 155.3200n -0.000506 155.3300n -0.000658 155.3400n -0.000802 155.3500n -0.000935 155.3600n -0.001055 155.3700n -0.001160 155.3800n -0.001250 155.3900n -0.001323
+ 155.4000n -0.001379 155.4100n -0.001417 155.4200n -0.001437 155.4300n -0.001440 155.4400n -0.001427 155.4500n -0.001398 155.4600n -0.001355 155.4700n -0.001300 155.4800n -0.001235 155.4900n -0.001161 155.5000n -0.001081 155.5100n -0.000997 155.5200n -0.000911 155.5300n -0.000827 155.5400n -0.000745
+ 155.5500n -0.000669 155.5600n -0.000599 155.5700n -0.000538 155.5800n -0.000487 155.5900n -0.000447 155.6000n -0.000418 155.6100n -0.000400 155.6200n -0.000394 155.6300n -0.000400 155.6400n -0.000415 155.6500n -0.000438 155.6600n -0.000469 155.6700n -0.000506 155.6800n -0.000545 155.6900n -0.000585
+ 155.7000n -0.000624 155.7100n -0.000659 155.7200n -0.000687 155.7300n -0.000705 155.7400n -0.000713 155.7500n -0.000707 155.7600n -0.000685 155.7700n -0.000647 155.7800n -0.000591 155.7900n -0.000516 155.8000n -0.000423 155.8100n -0.000311 155.8200n -0.000181 155.8300n -0.000034 155.8400n 0.000128
+ 155.8500n 0.000302 155.8600n 0.000487 155.8700n 0.000678 155.8800n 0.000873 155.8900n 0.001069 155.9000n 0.001261 155.9100n 0.001446 155.9200n 0.001619 155.9300n 0.001777 155.9400n 0.001915 155.9500n 0.002032 155.9600n 0.002123 155.9700n 0.002185 155.9800n 0.002217 155.9900n 0.002217
+ 156.0000n 0.002182 156.0100n 0.002114 156.0200n 0.002011 156.0300n 0.001876 156.0400n 0.001708 156.0500n 0.001511 156.0600n 0.001286 156.0700n 0.001038 156.0800n 0.000770 156.0900n 0.000487 156.1000n 0.000192 156.1100n -0.000108 156.1200n -0.000409 156.1300n -0.000705 156.1400n -0.000991
+ 156.1500n -0.001262 156.1600n -0.001513 156.1700n -0.001740 156.1800n -0.001937 156.1900n -0.002101 156.2000n -0.002230 156.2100n -0.002320 156.2200n -0.002369 156.2300n -0.002378 156.2400n -0.002345 156.2500n -0.002271 156.2600n -0.002157 156.2700n -0.002005 156.2800n -0.001819 156.2900n -0.001600
+ 156.3000n -0.001355 156.3100n -0.001086 156.3200n -0.000799 156.3300n -0.000500 156.3400n -0.000193 156.3500n 0.000115 156.3600n 0.000419 156.3700n 0.000714 156.3800n 0.000993 156.3900n 0.001253 156.4000n 0.001488 156.4100n 0.001695 156.4200n 0.001870 156.4300n 0.002010 156.4400n 0.002113
+ 156.4500n 0.002178 156.4600n 0.002205 156.4700n 0.002193 156.4800n 0.002144 156.4900n 0.002059 156.5000n 0.001941 156.5100n 0.001793 156.5200n 0.001618 156.5300n 0.001421 156.5400n 0.001207 156.5500n 0.000979 156.5600n 0.000743 156.5700n 0.000504 156.5800n 0.000267 156.5900n 0.000037
+ 156.6000n -0.000181 156.6100n -0.000383 156.6200n -0.000566 156.6300n -0.000725 156.6400n -0.000859 156.6500n -0.000964 156.6600n -0.001038 156.6700n -0.001083 156.6800n -0.001095 156.6900n -0.001078 156.7000n -0.001031 156.7100n -0.000955 156.7200n -0.000855 156.7300n -0.000732 156.7400n -0.000589
+ 156.7500n -0.000430 156.7600n -0.000259 156.7700n -0.000080 156.7800n 0.000103 156.7900n 0.000285 156.8000n 0.000463 156.8100n 0.000634 156.8200n 0.000792 156.8300n 0.000936 156.8400n 0.001062 156.8500n 0.001169 156.8600n 0.001253 156.8700n 0.001315 156.8800n 0.001353 156.8900n 0.001367
+ 156.9000n 0.001358 156.9100n 0.001327 156.9200n 0.001274 156.9300n 0.001203 156.9400n 0.001115 156.9500n 0.001013 156.9600n 0.000900 156.9700n 0.000778 156.9800n 0.000652 156.9900n 0.000525 157.0000n 0.000399 157.0100n 0.000278 157.0200n 0.000165 157.0300n 0.000062 157.0400n -0.000029
+ 157.0500n -0.000105 157.0600n -0.000164 157.0700n -0.000207 157.0800n -0.000232 157.0900n -0.000239 157.1000n -0.000228 157.1100n -0.000200 157.1200n -0.000156 157.1300n -0.000097 157.1400n -0.000026 157.1500n 0.000056 157.1600n 0.000146 157.1700n 0.000241 157.1800n 0.000340 157.1900n 0.000440
+ 157.2000n 0.000538 157.2100n 0.000631 157.2200n 0.000718 157.2300n 0.000797 157.2400n 0.000866 157.2500n 0.000922 157.2600n 0.000966 157.2700n 0.000997 157.2800n 0.001013 157.2900n 0.001016 157.3000n 0.001005 157.3100n 0.000982 157.3200n 0.000946 157.3300n 0.000900 157.3400n 0.000846
+ 157.3500n 0.000784 157.3600n 0.000717 157.3700n 0.000646 157.3800n 0.000574 157.3900n 0.000503 157.4000n 0.000435 157.4100n 0.000370 157.4200n 0.000312 157.4300n 0.000260 157.4400n 0.000217 157.4500n 0.000182 157.4600n 0.000157 157.4700n 0.000141 157.4800n 0.000134 157.4900n 0.000135
+ 157.5000n 0.000145 157.5100n 0.000160 157.5200n 0.000181 157.5300n 0.000205 157.5400n 0.000231 157.5500n 0.000257 157.5600n 0.000280 157.5700n 0.000300 157.5800n 0.000314 157.5900n 0.000320 157.6000n 0.000316 157.6100n 0.000302 157.6200n 0.000277 157.6300n 0.000238 157.6400n 0.000187
+ 157.6500n 0.000122 157.6600n 0.000045 157.6700n -0.000045 157.6800n -0.000147 157.6900n -0.000259 157.7000n -0.000379 157.7100n -0.000506 157.7200n -0.000639 157.7300n -0.000773 157.7400n -0.000908 157.7500n -0.001040 157.7600n -0.001167 157.7700n -0.001286 157.7800n -0.001396 157.7900n -0.001494
+ 157.8000n -0.001578 157.8100n -0.001646 157.8200n -0.001697 157.8300n -0.001730 157.8400n -0.001745 157.8500n -0.001740 157.8600n -0.001716 157.8700n -0.001674 157.8800n -0.001615 157.8900n -0.001540 157.9000n -0.001451 157.9100n -0.001350 157.9200n -0.001239 157.9300n -0.001120 157.9400n -0.000998
+ 157.9500n -0.000873 157.9600n -0.000750 157.9700n -0.000631 157.9800n -0.000519 157.9900n -0.000417 158.0000n -0.000327 158.0100n -0.000250 158.0200n -0.000190 158.0300n -0.000147 158.0400n -0.000122 158.0500n -0.000117 158.0600n -0.000131 158.0700n -0.000164 158.0800n -0.000216 158.0900n -0.000285
+ 158.1000n -0.000371 158.1100n -0.000471 158.1200n -0.000583 158.1300n -0.000705 158.1400n -0.000835 158.1500n -0.000970 158.1600n -0.001107 158.1700n -0.001243 158.1800n -0.001376 158.1900n -0.001503 158.2000n -0.001622 158.2100n -0.001730 158.2200n -0.001826 158.2300n -0.001908 158.2400n -0.001974
+ 158.2500n -0.002024 158.2600n -0.002057 158.2700n -0.002073 158.2800n -0.002073 158.2900n -0.002056 158.3000n -0.002024 158.3100n -0.001979 158.3200n -0.001921 158.3300n -0.001852 158.3400n -0.001775 158.3500n -0.001691 158.3600n -0.001603 158.3700n -0.001513 158.3800n -0.001422 158.3900n -0.001333
+ 158.4000n -0.001248 158.4100n -0.001168 158.4200n -0.001094 158.4300n -0.001028 158.4400n -0.000971 158.4500n -0.000922 158.4600n -0.000883 158.4700n -0.000852 158.4800n -0.000830 158.4900n -0.000815 158.5000n -0.000807 158.5100n -0.000804 158.5200n -0.000804 158.5300n -0.000806 158.5400n -0.000808
+ 158.5500n -0.000808 158.5600n -0.000805 158.5700n -0.000796 158.5800n -0.000780 158.5900n -0.000755 158.6000n -0.000720 158.6100n -0.000674 158.6200n -0.000617 158.6300n -0.000548 158.6400n -0.000466 158.6500n -0.000373 158.6600n -0.000268 158.6700n -0.000153 158.6800n -0.000030 158.6900n 0.000102
+ 158.7000n 0.000239 158.7100n 0.000379 158.7200n 0.000521 158.7300n 0.000661 158.7400n 0.000798 158.7500n 0.000930 158.7600n 0.001053 158.7700n 0.001166 158.7800n 0.001267 158.7900n 0.001353 158.8000n 0.001424 158.8100n 0.001478 158.8200n 0.001515 158.8300n 0.001534 158.8400n 0.001535
+ 158.8500n 0.001518 158.8600n 0.001485 158.8700n 0.001437 158.8800n 0.001374 158.8900n 0.001300 158.9000n 0.001215 158.9100n 0.001124 158.9200n 0.001028 158.9300n 0.000930 158.9400n 0.000833 158.9500n 0.000740 158.9600n 0.000653 158.9700n 0.000575 158.9800n 0.000510 158.9900n 0.000457
+ 159.0000n 0.000421 159.0100n 0.000401 159.0200n 0.000400 159.0300n 0.000417 159.0400n 0.000453 159.0500n 0.000508 159.0600n 0.000580 159.0700n 0.000670 159.0800n 0.000774 159.0900n 0.000891 159.1000n 0.001019 159.1100n 0.001155 159.1200n 0.001296 159.1300n 0.001440 159.1400n 0.001582
+ 159.1500n 0.001720 159.1600n 0.001851 159.1700n 0.001972 159.1800n 0.002080 159.1900n 0.002172 159.2000n 0.002246 159.2100n 0.002300 159.2200n 0.002333 159.2300n 0.002344 159.2400n 0.002331 159.2500n 0.002296 159.2600n 0.002238 159.2700n 0.002157 159.2800n 0.002057 159.2900n 0.001937
+ 159.3000n 0.001800 159.3100n 0.001649 159.3200n 0.001487 159.3300n 0.001315 159.3400n 0.001137 159.3500n 0.000957 159.3600n 0.000777 159.3700n 0.000601 159.3800n 0.000431 159.3900n 0.000269 159.4000n 0.000120 159.4100n -0.000016 159.4200n -0.000136 159.4300n -0.000240 159.4400n -0.000326
+ 159.4500n -0.000393 159.4600n -0.000441 159.4700n -0.000472 159.4800n -0.000485 159.4900n -0.000481 159.5000n -0.000462 159.5100n -0.000430 159.5200n -0.000387 159.5300n -0.000334 159.5400n -0.000275 159.5500n -0.000211 159.5600n -0.000145 159.5700n -0.000079 159.5800n -0.000016 159.5900n 0.000042
+ 159.6000n 0.000095 159.6100n 0.000140 159.6200n 0.000176 159.6300n 0.000202 159.6400n 0.000218 159.6500n 0.000224 159.6600n 0.000220 159.6700n 0.000207 159.6800n 0.000187 159.6900n 0.000159 159.7000n 0.000126 159.7100n 0.000091 159.7200n 0.000054 159.7300n 0.000018 159.7400n -0.000014
+ 159.7500n -0.000041 159.7600n -0.000060 159.7700n -0.000070 159.7800n -0.000068 159.7900n -0.000053 159.8000n -0.000024 159.8100n 0.000020 159.8200n 0.000080 159.8300n 0.000155 159.8400n 0.000245 159.8500n 0.000351 159.8600n 0.000469 159.8700n 0.000600 159.8800n 0.000740 159.8900n 0.000887
+ 159.9000n 0.001040 159.9100n 0.001195 159.9200n 0.001350 159.9300n 0.001500 159.9400n 0.001644 159.9500n 0.001778 159.9600n 0.001900 159.9700n 0.002006 159.9800n 0.002094 159.9900n 0.002162 160.0000n 0.002208 160.0100n 0.002231 160.0200n 0.002229 160.0300n 0.002203 160.0400n 0.002153
+ 160.0500n 0.002079 160.0600n 0.001982 160.0700n 0.001863 160.0800n 0.001725 160.0900n 0.001569 160.1000n 0.001399 160.1100n 0.001218 160.1200n 0.001028 160.1300n 0.000833 160.1400n 0.000636 160.1500n 0.000441 160.1600n 0.000251 160.1700n 0.000070 160.1800n -0.000100 160.1900n -0.000257
+ 160.2000n -0.000397 160.2100n -0.000519 160.2200n -0.000622 160.2300n -0.000704 160.2400n -0.000765 160.2500n -0.000805 160.2600n -0.000824 160.2700n -0.000823 160.2800n -0.000805 160.2900n -0.000769 160.3000n -0.000720 160.3100n -0.000658 160.3200n -0.000587 160.3300n -0.000509 160.3400n -0.000428
+ 160.3500n -0.000347 160.3600n -0.000267 160.3700n -0.000193 160.3800n -0.000126 160.3900n -0.000069 160.4000n -0.000024 160.4100n 0.000009 160.4200n 0.000027 160.4300n 0.000030 160.4400n 0.000018 160.4500n -0.000009 160.4600n -0.000050 160.4700n -0.000104 160.4800n -0.000169 160.4900n -0.000244
+ 160.5000n -0.000325 160.5100n -0.000410 160.5200n -0.000497 160.5300n -0.000582 160.5400n -0.000663 160.5500n -0.000736 160.5600n -0.000799 160.5700n -0.000849 160.5800n -0.000883 160.5900n -0.000900 160.6000n -0.000898 160.6100n -0.000875 160.6200n -0.000830 160.6300n -0.000764 160.6400n -0.000677
+ 160.6500n -0.000568 160.6600n -0.000441 160.6700n -0.000296 160.6800n -0.000135 160.6900n 0.000038 160.7000n 0.000221 160.7100n 0.000410 160.7200n 0.000601 160.7300n 0.000792 160.7400n 0.000978 160.7500n 0.001155 160.7600n 0.001319 160.7700n 0.001468 160.7800n 0.001597 160.7900n 0.001704
+ 160.8000n 0.001787 160.8100n 0.001843 160.8200n 0.001870 160.8300n 0.001869 160.8400n 0.001838 160.8500n 0.001777 160.8600n 0.001688 160.8700n 0.001572 160.8800n 0.001431 160.8900n 0.001267 160.9000n 0.001083 160.9100n 0.000883 160.9200n 0.000669 160.9300n 0.000447 160.9400n 0.000220
+ 160.9500n -0.000008 160.9600n -0.000233 160.9700n -0.000450 160.9800n -0.000656 160.9900n -0.000847 161.0000n -0.001020 161.0100n -0.001171 161.0200n -0.001299 161.0300n -0.001401 161.0400n -0.001477 161.0500n -0.001524 161.0600n -0.001544 161.0700n -0.001536 161.0800n -0.001501 161.0900n -0.001441
+ 161.1000n -0.001358 161.1100n -0.001253 161.1200n -0.001129 161.1300n -0.000991 161.1400n -0.000840 161.1500n -0.000680 161.1600n -0.000515 161.1700n -0.000348 161.1800n -0.000183 161.1900n -0.000022 161.2000n 0.000130 161.2100n 0.000272 161.2200n 0.000400 161.2300n 0.000514 161.2400n 0.000610
+ 161.2500n 0.000689 161.2600n 0.000749 161.2700n 0.000791 161.2800n 0.000814 161.2900n 0.000819 161.3000n 0.000808 161.3100n 0.000781 161.3200n 0.000741 161.3300n 0.000689 161.3400n 0.000628 161.3500n 0.000560 161.3600n 0.000488 161.3700n 0.000414 161.3800n 0.000339 161.3900n 0.000268
+ 161.4000n 0.000201 161.4100n 0.000140 161.4200n 0.000087 161.4300n 0.000043 161.4400n 0.000008 161.4500n -0.000016 161.4600n -0.000030 161.4700n -0.000035 161.4800n -0.000030 161.4900n -0.000017 161.5000n 0.000002 161.5100n 0.000027 161.5200n 0.000055 161.5300n 0.000084 161.5400n 0.000113
+ 161.5500n 0.000139 161.5600n 0.000161 161.5700n 0.000176 161.5800n 0.000183 161.5900n 0.000180 161.6000n 0.000165 161.6100n 0.000139 161.6200n 0.000101 161.6300n 0.000050 161.6400n -0.000014 161.6500n -0.000090 161.6600n -0.000177 161.6700n -0.000273 161.6800n -0.000377 161.6900n -0.000487
+ 161.7000n -0.000600 161.7100n -0.000714 161.7200n -0.000826 161.7300n -0.000933 161.7400n -0.001033 161.7500n -0.001122 161.7600n -0.001199 161.7700n -0.001259 161.7800n -0.001302 161.7900n -0.001326 161.8000n -0.001328 161.8100n -0.001307 161.8200n -0.001263 161.8300n -0.001196 161.8400n -0.001106
+ 161.8500n -0.000993 161.8600n -0.000860 161.8700n -0.000707 161.8800n -0.000537 161.8900n -0.000353 161.9000n -0.000158 161.9100n 0.000045 161.9200n 0.000252 161.9300n 0.000460 161.9400n 0.000665 161.9500n 0.000862 161.9600n 0.001049 161.9700n 0.001221 161.9800n 0.001375 161.9900n 0.001508
+ 162.0000n 0.001617 162.0100n 0.001700 162.0200n 0.001755 162.0300n 0.001781 162.0400n 0.001776 162.0500n 0.001741 162.0600n 0.001675 162.0700n 0.001580 162.0800n 0.001457 162.0900n 0.001308 162.1000n 0.001135 162.1100n 0.000941 162.1200n 0.000729 162.1300n 0.000502 162.1400n 0.000264
+ 162.1500n 0.000019 162.1600n -0.000230 162.1700n -0.000479 162.1800n -0.000724 162.1900n -0.000962 162.2000n -0.001190 162.2100n -0.001404 162.2200n -0.001602 162.2300n -0.001783 162.2400n -0.001943 162.2500n -0.002082 162.2600n -0.002199 162.2700n -0.002294 162.2800n -0.002366 162.2900n -0.002417
+ 162.3000n -0.002446 162.3100n -0.002456 162.3200n -0.002447 162.3300n -0.002422 162.3400n -0.002383 162.3500n -0.002332 162.3600n -0.002270 162.3700n -0.002201 162.3800n -0.002127 162.3900n -0.002049 162.4000n -0.001969 162.4100n -0.001890 162.4200n -0.001812 162.4300n -0.001737 162.4400n -0.001665
+ 162.4500n -0.001597 162.4600n -0.001533 162.4700n -0.001473 162.4800n -0.001416 162.4900n -0.001362 162.5000n -0.001309 162.5100n -0.001256 162.5200n -0.001202 162.5300n -0.001145 162.5400n -0.001083 162.5500n -0.001016 162.5600n -0.000940 162.5700n -0.000855 162.5800n -0.000760 162.5900n -0.000653
+ 162.6000n -0.000534 162.6100n -0.000403 162.6200n -0.000259 162.6300n -0.000102 162.6400n 0.000066 162.6500n 0.000245 162.6600n 0.000433 162.6700n 0.000628 162.6800n 0.000828 162.6900n 0.001030 162.7000n 0.001233 162.7100n 0.001431 162.7200n 0.001624 162.7300n 0.001807 162.7400n 0.001978
+ 162.7500n 0.002132 162.7600n 0.002268 162.7700n 0.002383 162.7800n 0.002473 162.7900n 0.002537 162.8000n 0.002574 162.8100n 0.002582 162.8200n 0.002560 162.8300n 0.002508 162.8400n 0.002426 162.8500n 0.002316 162.8600n 0.002178 162.8700n 0.002015 162.8800n 0.001828 162.8900n 0.001622
+ 162.9000n 0.001398 162.9100n 0.001162 162.9200n 0.000916 162.9300n 0.000665 162.9400n 0.000412 162.9500n 0.000163 162.9600n -0.000078 162.9700n -0.000309 162.9800n -0.000523 162.9900n -0.000720 163.0000n -0.000894 163.0100n -0.001043 163.0200n -0.001165 163.0300n -0.001259 163.0400n -0.001322
+ 163.0500n -0.001356 163.0600n -0.001359 163.0700n -0.001332 163.0800n -0.001277 163.0900n -0.001195 163.1000n -0.001089 163.1100n -0.000961 163.1200n -0.000815 163.1300n -0.000655 163.1400n -0.000483 163.1500n -0.000305 163.1600n -0.000123 163.1700n 0.000057 163.1800n 0.000231 163.1900n 0.000397
+ 163.2000n 0.000550 163.2100n 0.000687 163.2200n 0.000804 163.2300n 0.000901 163.2400n 0.000974 163.2500n 0.001022 163.2600n 0.001045 163.2700n 0.001041 163.2800n 0.001012 163.2900n 0.000958 163.3000n 0.000881 163.3100n 0.000782 163.3200n 0.000665 163.3300n 0.000531 163.3400n 0.000384
+ 163.3500n 0.000228 163.3600n 0.000066 163.3700n -0.000098 163.3800n -0.000260 163.3900n -0.000416 163.4000n -0.000563 163.4100n -0.000696 163.4200n -0.000814 163.4300n -0.000912 163.4400n -0.000988 163.4500n -0.001040 163.4600n -0.001067 163.4700n -0.001067 163.4800n -0.001040 163.4900n -0.000986
+ 163.5000n -0.000906 163.5100n -0.000799 163.5200n -0.000670 163.5300n -0.000518 163.5400n -0.000347 163.5500n -0.000160 163.5600n 0.000040 163.5700n 0.000250 163.5800n 0.000465 163.5900n 0.000682 163.6000n 0.000896 163.6100n 0.001105 163.6200n 0.001304 163.6300n 0.001489 163.6400n 0.001657
+ 163.6500n 0.001805 163.6600n 0.001930 163.6700n 0.002030 163.6800n 0.002103 163.6900n 0.002146 163.7000n 0.002159 163.7100n 0.002142 163.7200n 0.002095 163.7300n 0.002017 163.7400n 0.001909 163.7500n 0.001774 163.7600n 0.001613 163.7700n 0.001428 163.7800n 0.001222 163.7900n 0.000997
+ 163.8000n 0.000757 163.8100n 0.000504 163.8200n 0.000243 163.8300n -0.000022 163.8400n -0.000289 163.8500n -0.000554 163.8600n -0.000813 163.8700n -0.001063 163.8800n -0.001300 163.8900n -0.001522 163.9000n -0.001725 163.9100n -0.001908 163.9200n -0.002067 163.9300n -0.002201 163.9400n -0.002309
+ 163.9500n -0.002389 163.9600n -0.002441 163.9700n -0.002463 163.9800n -0.002457 163.9900n -0.002421 164.0000n -0.002358 164.0100n -0.002267 164.0200n -0.002150 164.0300n -0.002008 164.0400n -0.001844 164.0500n -0.001659 164.0600n -0.001456 164.0700n -0.001237 164.0800n -0.001004 164.0900n -0.000760
+ 164.1000n -0.000509 164.1100n -0.000252 164.1200n 0.000007 164.1300n 0.000265 164.1400n 0.000520 164.1500n 0.000769 164.1600n 0.001010 164.1700n 0.001239 164.1800n 0.001454 164.1900n 0.001654 164.2000n 0.001836 164.2100n 0.001998 164.2200n 0.002139 164.2300n 0.002258 164.2400n 0.002353
+ 164.2500n 0.002423 164.2600n 0.002469 164.2700n 0.002490 164.2800n 0.002486 164.2900n 0.002457 164.3000n 0.002404 164.3100n 0.002328 164.3200n 0.002231 164.3300n 0.002113 164.3400n 0.001977 164.3500n 0.001824 164.3600n 0.001656 164.3700n 0.001476 164.3800n 0.001287 164.3900n 0.001090
+ 164.4000n 0.000888 164.4100n 0.000684 164.4200n 0.000480 164.4300n 0.000280 164.4400n 0.000084 164.4500n -0.000103 164.4600n -0.000281 164.4700n -0.000447 164.4800n -0.000600 164.4900n -0.000738 164.5000n -0.000860 164.5100n -0.000965 164.5200n -0.001052 164.5300n -0.001122 164.5400n -0.001174
+ 164.5500n -0.001209 164.5600n -0.001228 164.5700n -0.001232 164.5800n -0.001222 164.5900n -0.001199 164.6000n -0.001166 164.6100n -0.001124 164.6200n -0.001076 164.6300n -0.001023 164.6400n -0.000968 164.6500n -0.000913 164.6600n -0.000861 164.6700n -0.000813 164.6800n -0.000771 164.6900n -0.000737
+ 164.7000n -0.000713 164.7100n -0.000699 164.7200n -0.000696 164.7300n -0.000706 164.7400n -0.000727 164.7500n -0.000761 164.7600n -0.000806 164.7700n -0.000862 164.7800n -0.000927 164.7900n -0.001001 164.8000n -0.001080 164.8100n -0.001163 164.8200n -0.001249 164.8300n -0.001334 164.8400n -0.001415
+ 164.8500n -0.001492 164.8600n -0.001560 164.8700n -0.001618 164.8800n -0.001662 164.8900n -0.001692 164.9000n -0.001706 164.9100n -0.001700 164.9200n -0.001675 164.9300n -0.001630 164.9400n -0.001564 164.9500n -0.001476 164.9600n -0.001368 164.9700n -0.001240 164.9800n -0.001093 164.9900n -0.000929
+ 165.0000n -0.000751 165.0100n -0.000559 165.0200n -0.000358 165.0300n -0.000150 165.0400n 0.000063 165.0500n 0.000275 165.0600n 0.000486 165.0700n 0.000690 165.0800n 0.000885 165.0900n 0.001067 165.1000n 0.001235 165.1100n 0.001384 165.1200n 0.001513 165.1300n 0.001620 165.1400n 0.001704
+ 165.1500n 0.001762 165.1600n 0.001795 165.1700n 0.001803 165.1800n 0.001786 165.1900n 0.001744 165.2000n 0.001679 165.2100n 0.001594 165.2200n 0.001489 165.2300n 0.001367 165.2400n 0.001232 165.2500n 0.001086 165.2600n 0.000933 165.2700n 0.000775 165.2800n 0.000617 165.2900n 0.000460
+ 165.3000n 0.000309 165.3100n 0.000167 165.3200n 0.000035 165.3300n -0.000083 165.3400n -0.000186 165.3500n -0.000272 165.3600n -0.000341 165.3700n -0.000391 165.3800n -0.000422 165.3900n -0.000435 165.4000n -0.000431 165.4100n -0.000411 165.4200n -0.000377 165.4300n -0.000331 165.4400n -0.000275
+ 165.4500n -0.000212 165.4600n -0.000145 165.4700n -0.000078 165.4800n -0.000012 165.4900n 0.000048 165.5000n 0.000100 165.5100n 0.000140 165.5200n 0.000168 165.5300n 0.000179 165.5400n 0.000172 165.5500n 0.000146 165.5600n 0.000101 165.5700n 0.000034 165.5800n -0.000053 165.5900n -0.000161
+ 165.6000n -0.000287 165.6100n -0.000430 165.6200n -0.000589 165.6300n -0.000761 165.6400n -0.000943 165.6500n -0.001132 165.6600n -0.001324 165.6700n -0.001516 165.6800n -0.001704 165.6900n -0.001884 165.7000n -0.002053 165.7100n -0.002207 165.7200n -0.002343 165.7300n -0.002458 165.7400n -0.002549
+ 165.7500n -0.002614 165.7600n -0.002652 165.7700n -0.002661 165.7800n -0.002640 165.7900n -0.002590 165.8000n -0.002511 165.8100n -0.002404 165.8200n -0.002270 165.8300n -0.002113 165.8400n -0.001934 165.8500n -0.001736 165.8600n -0.001523 165.8700n -0.001298 165.8800n -0.001065 165.8900n -0.000828
+ 165.9000n -0.000591 165.9100n -0.000358 165.9200n -0.000132 165.9300n 0.000083 165.9400n 0.000284 165.9500n 0.000469 165.9600n 0.000633 165.9700n 0.000777 165.9800n 0.000898 165.9900n 0.000996 166.0000n 0.001070 166.0100n 0.001120 166.0200n 0.001148 166.0300n 0.001154 166.0400n 0.001140
+ 166.0500n 0.001109 166.0600n 0.001063 166.0700n 0.001005 166.0800n 0.000938 166.0900n 0.000864 166.1000n 0.000789 166.1100n 0.000714 166.1200n 0.000643 166.1300n 0.000579 166.1400n 0.000525 166.1500n 0.000482 166.1600n 0.000454 166.1700n 0.000442 166.1800n 0.000447 166.1900n 0.000469
+ 166.2000n 0.000508 166.2100n 0.000565 166.2200n 0.000638 166.2300n 0.000725 166.2400n 0.000826 166.2500n 0.000936 166.2600n 0.001054 166.2700n 0.001177 166.2800n 0.001301 166.2900n 0.001422 166.3000n 0.001538 166.3100n 0.001644 166.3200n 0.001738 166.3300n 0.001816 166.3400n 0.001875
+ 166.3500n 0.001912 166.3600n 0.001925 166.3700n 0.001913 166.3800n 0.001874 166.3900n 0.001808 166.4000n 0.001713 166.4100n 0.001592 166.4200n 0.001444 166.4300n 0.001271 166.4400n 0.001075 166.4500n 0.000860 166.4600n 0.000627 166.4700n 0.000382 166.4800n 0.000126 166.4900n -0.000135
+ 166.5000n -0.000398 166.5100n -0.000658 166.5200n -0.000910 166.5300n -0.001152 166.5400n -0.001378 166.5500n -0.001585 166.5600n -0.001770 166.5700n -0.001930 166.5800n -0.002062 166.5900n -0.002164 166.6000n -0.002235 166.6100n -0.002273 166.6200n -0.002280 166.6300n -0.002254 166.6400n -0.002198
+ 166.6500n -0.002112 166.6600n -0.001999 166.6700n -0.001861 166.6800n -0.001700 166.6900n -0.001521 166.7000n -0.001327 166.7100n -0.001121 166.7200n -0.000907 166.7300n -0.000690 166.7400n -0.000473 166.7500n -0.000260 166.7600n -0.000055 166.7700n 0.000140 166.7800n 0.000321 166.7900n 0.000485
+ 166.8000n 0.000631 166.8100n 0.000757 166.8200n 0.000862 166.8300n 0.000944 166.8400n 0.001005 166.8500n 0.001044 166.8600n 0.001061 166.8700n 0.001060 166.8800n 0.001040 166.8900n 0.001004 166.9000n 0.000955 166.9100n 0.000895 166.9200n 0.000826 166.9300n 0.000752 166.9400n 0.000676
+ 166.9500n 0.000600 166.9600n 0.000527 166.9700n 0.000461 166.9800n 0.000402 166.9900n 0.000354 167.0000n 0.000318 167.0100n 0.000295 167.0200n 0.000287 167.0300n 0.000295 167.0400n 0.000318 167.0500n 0.000357 167.0600n 0.000411 167.0700n 0.000479 167.0800n 0.000560 167.0900n 0.000652
+ 167.1000n 0.000755 167.1100n 0.000864 167.1200n 0.000980 167.1300n 0.001098 167.1400n 0.001218 167.1500n 0.001336 167.1600n 0.001451 167.1700n 0.001560 167.1800n 0.001661 167.1900n 0.001752 167.2000n 0.001832 167.2100n 0.001900 167.2200n 0.001954 167.2300n 0.001994 167.2400n 0.002019
+ 167.2500n 0.002028 167.2600n 0.002023 167.2700n 0.002004 167.2800n 0.001970 167.2900n 0.001924 167.3000n 0.001865 167.3100n 0.001796 167.3200n 0.001717 167.3300n 0.001629 167.3400n 0.001535 167.3500n 0.001436 167.3600n 0.001333 167.3700n 0.001226 167.3800n 0.001118 167.3900n 0.001009
+ 167.4000n 0.000900 167.4100n 0.000792 167.4200n 0.000685 167.4300n 0.000579 167.4400n 0.000475 167.4500n 0.000373 167.4600n 0.000271 167.4700n 0.000171 167.4800n 0.000071 167.4900n -0.000029 167.5000n -0.000130 167.5100n -0.000232 167.5200n -0.000335 167.5300n -0.000441 167.5400n -0.000549
+ 167.5500n -0.000659 167.5600n -0.000773 167.5700n -0.000889 167.5800n -0.001006 167.5900n -0.001126 167.6000n -0.001246 167.6100n -0.001365 167.6200n -0.001483 167.6300n -0.001597 167.6400n -0.001707 167.6500n -0.001810 167.6600n -0.001904 167.6700n -0.001987 167.6800n -0.002058 167.6900n -0.002114
+ 167.7000n -0.002153 167.7100n -0.002174 167.7200n -0.002175 167.7300n -0.002154 167.7400n -0.002110 167.7500n -0.002043 167.7600n -0.001952 167.7700n -0.001838 167.7800n -0.001699 167.7900n -0.001537 167.8000n -0.001354 167.8100n -0.001151 167.8200n -0.000930 167.8300n -0.000693 167.8400n -0.000443
+ 167.8500n -0.000184 167.8600n 0.000082 167.8700n 0.000349 167.8800n 0.000616 167.8900n 0.000877 167.9000n 0.001129 167.9100n 0.001368 167.9200n 0.001589 167.9300n 0.001790 167.9400n 0.001967 167.9500n 0.002116 167.9600n 0.002234 167.9700n 0.002321 167.9800n 0.002373 167.9900n 0.002389
+ 168.0000n 0.002369 168.0100n 0.002312 168.0200n 0.002218 168.0300n 0.002089 168.0400n 0.001926 168.0500n 0.001731 168.0600n 0.001506 168.0700n 0.001255 168.0800n 0.000980 168.0900n 0.000686 168.1000n 0.000376 168.1100n 0.000054 168.1200n -0.000274 168.1300n -0.000605 168.1400n -0.000934
+ 168.1500n -0.001257 168.1600n -0.001569 168.1700n -0.001867 168.1800n -0.002148 168.1900n -0.002407 168.2000n -0.002642 168.2100n -0.002850 168.2200n -0.003030 168.2300n -0.003181 168.2400n -0.003300 168.2500n -0.003389 168.2600n -0.003447 168.2700n -0.003474 168.2800n -0.003473 168.2900n -0.003444
+ 168.3000n -0.003390 168.3100n -0.003313 168.3200n -0.003215 168.3300n -0.003100 168.3400n -0.002971 168.3500n -0.002831 168.3600n -0.002684 168.3700n -0.002531 168.3800n -0.002378 168.3900n -0.002226 168.4000n -0.002079 168.4100n -0.001939 168.4200n -0.001809 168.4300n -0.001690 168.4400n -0.001584
+ 168.4500n -0.001493 168.4600n -0.001416 168.4700n -0.001355 168.4800n -0.001309 168.4900n -0.001279 168.5000n -0.001263 168.5100n -0.001260 168.5200n -0.001269 168.5300n -0.001288 168.5400n -0.001316 168.5500n -0.001349 168.5600n -0.001387 168.5700n -0.001427 168.5800n -0.001466 168.5900n -0.001502
+ 168.6000n -0.001534 168.6100n -0.001558 168.6200n -0.001574 168.6300n -0.001579 168.6400n -0.001572 168.6500n -0.001552 168.6600n -0.001518 168.6700n -0.001469 168.6800n -0.001406 168.6900n -0.001328 168.7000n -0.001236 168.7100n -0.001130 168.7200n -0.001012 168.7300n -0.000883 168.7400n -0.000744
+ 168.7500n -0.000597 168.7600n -0.000445 168.7700n -0.000288 168.7800n -0.000130 168.7900n 0.000027 168.8000n 0.000181 168.8100n 0.000330 168.8200n 0.000471 168.8300n 0.000603 168.8400n 0.000723 168.8500n 0.000830 168.8600n 0.000922 168.8700n 0.000998 168.8800n 0.001056 168.8900n 0.001095
+ 168.9000n 0.001116 168.9100n 0.001117 168.9200n 0.001099 168.9300n 0.001062 168.9400n 0.001007 168.9500n 0.000934 168.9600n 0.000845 168.9700n 0.000740 168.9800n 0.000623 168.9900n 0.000493 169.0000n 0.000353 169.0100n 0.000206 169.0200n 0.000054 169.0300n -0.000102 169.0400n -0.000258
+ 169.0500n -0.000413 169.0600n -0.000564 169.0700n -0.000709 169.0800n -0.000846 169.0900n -0.000972 169.1000n -0.001085 169.1100n -0.001184 169.1200n -0.001266 169.1300n -0.001332 169.1400n -0.001378 169.1500n -0.001405 169.1600n -0.001411 169.1700n -0.001396 169.1800n -0.001359 169.1900n -0.001301
+ 169.2000n -0.001223 169.2100n -0.001123 169.2200n -0.001004 169.2300n -0.000866 169.2400n -0.000711 169.2500n -0.000540 169.2600n -0.000355 169.2700n -0.000157 169.2800n 0.000051 169.2900n 0.000267 169.3000n 0.000490 169.3100n 0.000716 169.3200n 0.000942 169.3300n 0.001168 169.3400n 0.001390
+ 169.3500n 0.001606 169.3600n 0.001813 169.3700n 0.002009 169.3800n 0.002192 169.3900n 0.002361 169.4000n 0.002512 169.4100n 0.002645 169.4200n 0.002758 169.4300n 0.002850 169.4400n 0.002920 169.4500n 0.002967 169.4600n 0.002991 169.4700n 0.002991 169.4800n 0.002968 169.4900n 0.002922
+ 169.5000n 0.002853 169.5100n 0.002763 169.5200n 0.002652 169.5300n 0.002523 169.5400n 0.002376 169.5500n 0.002213 169.5600n 0.002037 169.5700n 0.001849 169.5800n 0.001651 169.5900n 0.001446 169.6000n 0.001236 169.6100n 0.001024 169.6200n 0.000811 169.6300n 0.000600 169.6400n 0.000394
+ 169.6500n 0.000194 169.6600n 0.000002 169.6700n -0.000179 169.6800n -0.000349 169.6900n -0.000505 169.7000n -0.000646 169.7100n -0.000771 169.7200n -0.000880 169.7300n -0.000971 169.7400n -0.001044 169.7500n -0.001099 169.7600n -0.001136 169.7700n -0.001155 169.7800n -0.001157 169.7900n -0.001141
+ 169.8000n -0.001110 169.8100n -0.001064 169.8200n -0.001003 169.8300n -0.000929 169.8400n -0.000844 169.8500n -0.000749 169.8600n -0.000644 169.8700n -0.000532 169.8800n -0.000414 169.8900n -0.000292 169.9000n -0.000167 169.9100n -0.000040 169.9200n 0.000087 169.9300n 0.000212 169.9400n 0.000335
+ 169.9500n 0.000454 169.9600n 0.000568 169.9700n 0.000676 169.9800n 0.000777 169.9900n 0.000869 170.0000n 0.000952 170.0100n 0.001025 170.0200n 0.001087 170.0300n 0.001138 170.0400n 0.001177 170.0500n 0.001203 170.0600n 0.001216 170.0700n 0.001215 170.0800n 0.001201 170.0900n 0.001172
+ 170.1000n 0.001130 170.1100n 0.001073 170.1200n 0.001002 170.1300n 0.000917 170.1400n 0.000818 170.1500n 0.000706 170.1600n 0.000581 170.1700n 0.000445 170.1800n 0.000296 170.1900n 0.000138 170.2000n -0.000030 170.2100n -0.000205 170.2200n -0.000388 170.2300n -0.000575 170.2400n -0.000766
+ 170.2500n -0.000959 170.2600n -0.001151 170.2700n -0.001341 170.2800n -0.001526 170.2900n -0.001706 170.3000n -0.001877 170.3100n -0.002037 170.3200n -0.002184 170.3300n -0.002317 170.3400n -0.002433 170.3500n -0.002531 170.3600n -0.002609 170.3700n -0.002666 170.3800n -0.002700 170.3900n -0.002710
+ 170.4000n -0.002697 170.4100n -0.002659 170.4200n -0.002597 170.4300n -0.002510 170.4400n -0.002401 170.4500n -0.002269 170.4600n -0.002116 170.4700n -0.001943 170.4800n -0.001753 170.4900n -0.001548 170.5000n -0.001330 170.5100n -0.001102 170.5200n -0.000866 170.5300n -0.000627 170.5400n -0.000386
+ 170.5500n -0.000146 170.5600n 0.000088 170.5700n 0.000315 170.5800n 0.000532 170.5900n 0.000736 170.6000n 0.000924 170.6100n 0.001095 170.6200n 0.001247 170.6300n 0.001378 170.6400n 0.001488 170.6500n 0.001576 170.6600n 0.001642 170.6700n 0.001686 170.6800n 0.001709 170.6900n 0.001712
+ 170.7000n 0.001697 170.7100n 0.001665 170.7200n 0.001619 170.7300n 0.001561 170.7400n 0.001494 170.7500n 0.001420 170.7600n 0.001344 170.7700n 0.001268 170.7800n 0.001194 170.7900n 0.001127 170.8000n 0.001068 170.8100n 0.001021 170.8200n 0.000988 170.8300n 0.000971 170.8400n 0.000971
+ 170.8500n 0.000990 170.8600n 0.001029 170.8700n 0.001088 170.8800n 0.001166 170.8900n 0.001265 170.9000n 0.001381 170.9100n 0.001514 170.9200n 0.001662 170.9300n 0.001822 170.9400n 0.001992 170.9500n 0.002169 170.9600n 0.002348 170.9700n 0.002528 170.9800n 0.002704 170.9900n 0.002872
+ 171.0000n 0.003030 171.0100n 0.003172 171.0200n 0.003297 171.0300n 0.003402 171.0400n 0.003482 171.0500n 0.003536 171.0600n 0.003563 171.0700n 0.003559 171.0800n 0.003526 171.0900n 0.003461 171.1000n 0.003365 171.1100n 0.003238 171.1200n 0.003083 171.1300n 0.002899 171.1400n 0.002690
+ 171.1500n 0.002458 171.1600n 0.002206 171.1700n 0.001937 171.1800n 0.001655 171.1900n 0.001363 171.2000n 0.001066 171.2100n 0.000768 171.2200n 0.000472 171.2300n 0.000182 171.2400n -0.000097 171.2500n -0.000363 171.2600n -0.000611 171.2700n -0.000840 171.2800n -0.001046 171.2900n -0.001228
+ 171.3000n -0.001383 171.3100n -0.001511 171.3200n -0.001610 171.3300n -0.001682 171.3400n -0.001726 171.3500n -0.001742 171.3600n -0.001733 171.3700n -0.001699 171.3800n -0.001643 171.3900n -0.001567 171.4000n -0.001474 171.4100n -0.001366 171.4200n -0.001246 171.4300n -0.001118 171.4400n -0.000983
+ 171.4500n -0.000846 171.4600n -0.000708 171.4700n -0.000572 171.4800n -0.000442 171.4900n -0.000318 171.5000n -0.000202 171.5100n -0.000097 171.5200n -0.000003 171.5300n 0.000079 171.5400n 0.000148 171.5500n 0.000205 171.5600n 0.000249 171.5700n 0.000282 171.5800n 0.000304 171.5900n 0.000316
+ 171.6000n 0.000320 171.6100n 0.000316 171.6200n 0.000307 171.6300n 0.000293 171.6400n 0.000277 171.6500n 0.000260 171.6600n 0.000244 171.6700n 0.000229 171.6800n 0.000218 171.6900n 0.000210 171.7000n 0.000207 171.7100n 0.000209 171.7200n 0.000216 171.7300n 0.000229 171.7400n 0.000246
+ 171.7500n 0.000268 171.7600n 0.000293 171.7700n 0.000321 171.7800n 0.000350 171.7900n 0.000380 171.8000n 0.000408 171.8100n 0.000433 171.8200n 0.000454 171.8300n 0.000469 171.8400n 0.000477 171.8500n 0.000477 171.8600n 0.000467 171.8700n 0.000447 171.8800n 0.000415 171.8900n 0.000372
+ 171.9000n 0.000318 171.9100n 0.000252 171.9200n 0.000175 171.9300n 0.000088 171.9400n -0.000009 171.9500n -0.000114 171.9600n -0.000225 171.9700n -0.000341 171.9800n -0.000461 171.9900n -0.000581 172.0000n -0.000701 172.0100n -0.000817 172.0200n -0.000929 172.0300n -0.001033 172.0400n -0.001127
+ 172.0500n -0.001211 172.0600n -0.001283 172.0700n -0.001340 172.0800n -0.001383 172.0900n -0.001410 172.1000n -0.001420 172.1100n -0.001415 172.1200n -0.001393 172.1300n -0.001355 172.1400n -0.001303 172.1500n -0.001237 172.1600n -0.001160 172.1700n -0.001071 172.1800n -0.000975 172.1900n -0.000871
+ 172.2000n -0.000764 172.2100n -0.000655 172.2200n -0.000547 172.2300n -0.000441 172.2400n -0.000341 172.2500n -0.000248 172.2600n -0.000164 172.2700n -0.000091 172.2800n -0.000030 172.2900n 0.000016 172.3000n 0.000048 172.3100n 0.000064 172.3200n 0.000064 172.3300n 0.000049 172.3400n 0.000018
+ 172.3500n -0.000028 172.3600n -0.000088 172.3700n -0.000160 172.3800n -0.000243 172.3900n -0.000336 172.4000n -0.000436 172.4100n -0.000542 172.4200n -0.000651 172.4300n -0.000762 172.4400n -0.000872 172.4500n -0.000979 172.4600n -0.001082 172.4700n -0.001178 172.4800n -0.001266 172.4900n -0.001344
+ 172.5000n -0.001412 172.5100n -0.001468 172.5200n -0.001511 172.5300n -0.001541 172.5400n -0.001558 172.5500n -0.001562 172.5600n -0.001552 172.5700n -0.001530 172.5800n -0.001497 172.5900n -0.001453 172.6000n -0.001398 172.6100n -0.001336 172.6200n -0.001265 172.6300n -0.001188 172.6400n -0.001107
+ 172.6500n -0.001021 172.6600n -0.000933 172.6700n -0.000843 172.6800n -0.000752 172.6900n -0.000662 172.7000n -0.000572 172.7100n -0.000483 172.7200n -0.000396 172.7300n -0.000311 172.7400n -0.000228 172.7500n -0.000146 172.7600n -0.000066 172.7700n 0.000014 172.7800n 0.000093 172.7900n 0.000172
+ 172.8000n 0.000251 172.8100n 0.000332 172.8200n 0.000414 172.8300n 0.000498 172.8400n 0.000585 172.8500n 0.000674 172.8600n 0.000766 172.8700n 0.000861 172.8800n 0.000958 172.8900n 0.001058 172.9000n 0.001158 172.9100n 0.001260 172.9200n 0.001362 172.9300n 0.001462 172.9400n 0.001560
+ 172.9500n 0.001654 172.9600n 0.001743 172.9700n 0.001825 172.9800n 0.001900 172.9900n 0.001964 173.0000n 0.002018 173.0100n 0.002059 173.0200n 0.002087 173.0300n 0.002100 173.0400n 0.002098 173.0500n 0.002080 173.0600n 0.002045 173.0700n 0.001995 173.0800n 0.001928 173.0900n 0.001846
+ 173.1000n 0.001749 173.1100n 0.001638 173.1200n 0.001515 173.1300n 0.001382 173.1400n 0.001239 173.1500n 0.001090 173.1600n 0.000936 173.1700n 0.000780 173.1800n 0.000625 173.1900n 0.000471 173.2000n 0.000322 173.2100n 0.000181 173.2200n 0.000048 173.2300n -0.000073 173.2400n -0.000182
+ 173.2500n -0.000276 173.2600n -0.000354 173.2700n -0.000416 173.2800n -0.000461 173.2900n -0.000488 173.3000n -0.000499 173.3100n -0.000492 173.3200n -0.000470 173.3300n -0.000433 173.3400n -0.000383 173.3500n -0.000321 173.3600n -0.000250 173.3700n -0.000171 173.3800n -0.000086 173.3900n 0.000001
+ 173.4000n 0.000089 173.4100n 0.000175 173.4200n 0.000257 173.4300n 0.000333 173.4400n 0.000400 173.4500n 0.000457 173.4600n 0.000503 173.4700n 0.000536 173.4800n 0.000555 173.4900n 0.000560 173.5000n 0.000550 173.5100n 0.000525 173.5200n 0.000487 173.5300n 0.000435 173.5400n 0.000371
+ 173.5500n 0.000296 173.5600n 0.000212 173.5700n 0.000121 173.5800n 0.000025 173.5900n -0.000074 173.6000n -0.000174 173.6100n -0.000272 173.6200n -0.000366 173.6300n -0.000453 173.6400n -0.000532 173.6500n -0.000600 173.6600n -0.000657 173.6700n -0.000699 173.6800n -0.000727 173.6900n -0.000738
+ 173.7000n -0.000733 173.7100n -0.000711 173.7200n -0.000672 173.7300n -0.000616 173.7400n -0.000545 173.7500n -0.000459 173.7600n -0.000359 173.7700n -0.000247 173.7800n -0.000126 173.7900n 0.000004 173.8000n 0.000141 173.8100n 0.000281 173.8200n 0.000422 173.8300n 0.000564 173.8400n 0.000702
+ 173.8500n 0.000836 173.8600n 0.000963 173.8700n 0.001081 173.8800n 0.001189 173.8900n 0.001285 173.9000n 0.001368 173.9100n 0.001436 173.9200n 0.001490 173.9300n 0.001529 173.9400n 0.001553 173.9500n 0.001562 173.9600n 0.001555 173.9700n 0.001534 173.9800n 0.001500 173.9900n 0.001453
+ 174.0000n 0.001394 174.0100n 0.001325 174.0200n 0.001247 174.0300n 0.001161 174.0400n 0.001068 174.0500n 0.000971 174.0600n 0.000869 174.0700n 0.000765 174.0800n 0.000659 174.0900n 0.000553 174.1000n 0.000447 174.1100n 0.000343 174.1200n 0.000241 174.1300n 0.000141 174.1400n 0.000045
+ 174.1500n -0.000049 174.1600n -0.000139 174.1700n -0.000225 174.1800n -0.000307 174.1900n -0.000386 174.2000n -0.000462 174.2100n -0.000533 174.2200n -0.000602 174.2300n -0.000667 174.2400n -0.000728 174.2500n -0.000786 174.2600n -0.000841 174.2700n -0.000893 174.2800n -0.000940 174.2900n -0.000983
+ 174.3000n -0.001022 174.3100n -0.001056 174.3200n -0.001084 174.3300n -0.001106 174.3400n -0.001122 174.3500n -0.001131 174.3600n -0.001132 174.3700n -0.001124 174.3800n -0.001108 174.3900n -0.001083 174.4000n -0.001048 174.4100n -0.001004 174.4200n -0.000950 174.4300n -0.000887 174.4400n -0.000814
+ 174.4500n -0.000733 174.4600n -0.000643 174.4700n -0.000546 174.4800n -0.000443 174.4900n -0.000334 174.5000n -0.000221 174.5100n -0.000106 174.5200n 0.000011 174.5300n 0.000127 174.5400n 0.000241 174.5500n 0.000351 174.5600n 0.000456 174.5700n 0.000554 174.5800n 0.000643 174.5900n 0.000723
+ 174.6000n 0.000792 174.6100n 0.000849 174.6200n 0.000893 174.6300n 0.000924 174.6400n 0.000942 174.6500n 0.000946 174.6600n 0.000936 174.6700n 0.000914 174.6800n 0.000880 174.6900n 0.000835 174.7000n 0.000780 174.7100n 0.000716 174.7200n 0.000646 174.7300n 0.000572 174.7400n 0.000494
+ 174.7500n 0.000416 174.7600n 0.000339 174.7700n 0.000265 174.7800n 0.000196 174.7900n 0.000135 174.8000n 0.000083 174.8100n 0.000041 174.8200n 0.000012 174.8300n -0.000004 174.8400n -0.000007 174.8500n 0.000006 174.8600n 0.000033 174.8700n 0.000076 174.8800n 0.000133 174.8900n 0.000205
+ 174.9000n 0.000289 174.9100n 0.000386 174.9200n 0.000493 174.9300n 0.000610 174.9400n 0.000733 174.9500n 0.000862 174.9600n 0.000993 174.9700n 0.001126 174.9800n 0.001256 174.9900n 0.001383 175.0000n 0.001504 175.0100n 0.001617 175.0200n 0.001720 175.0300n 0.001810 175.0400n 0.001887
+ 175.0500n 0.001949 175.0600n 0.001995 175.0700n 0.002023 175.0800n 0.002034 175.0900n 0.002026 175.1000n 0.001999 175.1100n 0.001955 175.1200n 0.001892 175.1300n 0.001811 175.1400n 0.001714 175.1500n 0.001601 175.1600n 0.001474 175.1700n 0.001334 175.1800n 0.001182 175.1900n 0.001019
+ 175.2000n 0.000848 175.2100n 0.000670 175.2200n 0.000487 175.2300n 0.000300 175.2400n 0.000110 175.2500n -0.000080 175.2600n -0.000269 175.2700n -0.000455 175.2800n -0.000639 175.2900n -0.000817 175.3000n -0.000989 175.3100n -0.001155 175.3200n -0.001312 175.3300n -0.001461 175.3400n -0.001599
+ 175.3500n -0.001728 175.3600n -0.001845 175.3700n -0.001950 175.3800n -0.002043 175.3900n -0.002122 175.4000n -0.002188 175.4100n -0.002239 175.4200n -0.002276 175.4300n -0.002298 175.4400n -0.002304 175.4500n -0.002294 175.4600n -0.002268 175.4700n -0.002225 175.4800n -0.002166 175.4900n -0.002090
+ 175.5000n -0.001998 175.5100n -0.001890 175.5200n -0.001766 175.5300n -0.001627 175.5400n -0.001475 175.5500n -0.001309 175.5600n -0.001132 175.5700n -0.000946 175.5800n -0.000751 175.5900n -0.000550 175.6000n -0.000345 175.6100n -0.000140 175.6200n 0.000065 175.6300n 0.000265 175.6400n 0.000458
+ 175.6500n 0.000641 175.6600n 0.000812 175.6700n 0.000966 175.6800n 0.001103 175.6900n 0.001218 175.7000n 0.001310 175.7100n 0.001376 175.7200n 0.001414 175.7300n 0.001424 175.7400n 0.001404 175.7500n 0.001354 175.7600n 0.001274 175.7700n 0.001164 175.7800n 0.001025 175.7900n 0.000859
+ 175.8000n 0.000667 175.8100n 0.000454 175.8200n 0.000221 175.8300n -0.000028 175.8400n -0.000288 175.8500n -0.000556 175.8600n -0.000827 175.8700n -0.001096 175.8800n -0.001359 175.8900n -0.001610 175.9000n -0.001844 175.9100n -0.002057 175.9200n -0.002245 175.9300n -0.002404 175.9400n -0.002530
+ 175.9500n -0.002620 175.9600n -0.002672 175.9700n -0.002684 175.9800n -0.002654 175.9900n -0.002584 176.0000n -0.002472 176.0100n -0.002321 176.0200n -0.002132 176.0300n -0.001908 176.0400n -0.001652 176.0500n -0.001369 176.0600n -0.001063 176.0700n -0.000740 176.0800n -0.000404 176.0900n -0.000061
+ 176.1000n 0.000281 176.1100n 0.000618 176.1200n 0.000944 176.1300n 0.001252 176.1400n 0.001538 176.1500n 0.001796 176.1600n 0.002022 176.1700n 0.002212 176.1800n 0.002363 176.1900n 0.002472 176.2000n 0.002538 176.2100n 0.002561 176.2200n 0.002540 176.2300n 0.002478 176.2400n 0.002375
+ 176.2500n 0.002235 176.2600n 0.002061 176.2700n 0.001859 176.2800n 0.001633 176.2900n 0.001389 176.3000n 0.001132 176.3100n 0.000869 176.3200n 0.000607 176.3300n 0.000352 176.3400n 0.000110 176.3500n -0.000112 176.3600n -0.000310 176.3700n -0.000477 176.3800n -0.000610 176.3900n -0.000704
+ 176.4000n -0.000757 176.4100n -0.000766 176.4200n -0.000731 176.4300n -0.000652 176.4400n -0.000529 176.4500n -0.000364 176.4600n -0.000160 176.4700n 0.000078 176.4800n 0.000347 176.4900n 0.000641 176.5000n 0.000955 176.5100n 0.001281 176.5200n 0.001612 176.5300n 0.001943 176.5400n 0.002265
+ 176.5500n 0.002573 176.5600n 0.002857 176.5700n 0.003114 176.5800n 0.003336 176.5900n 0.003518 176.6000n 0.003655 176.6100n 0.003745 176.6200n 0.003785 176.6300n 0.003772 176.6400n 0.003706 176.6500n 0.003587 176.6600n 0.003417 176.6700n 0.003199 176.6800n 0.002935 176.6900n 0.002631
+ 176.7000n 0.002291 176.7100n 0.001922 176.7200n 0.001529 176.7300n 0.001121 176.7400n 0.000703 176.7500n 0.000284 176.7600n -0.000130 176.7700n -0.000531 176.7800n -0.000912 176.7900n -0.001266 176.8000n -0.001589 176.8100n -0.001875 176.8200n -0.002119 176.8300n -0.002318 176.8400n -0.002471
+ 176.8500n -0.002575 176.8600n -0.002630 176.8700n -0.002638 176.8800n -0.002599 176.8900n -0.002517 176.9000n -0.002396 176.9100n -0.002239 176.9200n -0.002052 176.9300n -0.001841 176.9400n -0.001612 176.9500n -0.001371 176.9600n -0.001126 176.9700n -0.000882 176.9800n -0.000647 176.9900n -0.000427
+ 177.0000n -0.000227 177.0100n -0.000052 177.0200n 0.000092 177.0300n 0.000203 177.0400n 0.000277 177.0500n 0.000313 177.0600n 0.000310 177.0700n 0.000267 177.0800n 0.000186 177.0900n 0.000070 177.1000n -0.000080 177.1100n -0.000258 177.1200n -0.000461 177.1300n -0.000683 177.1400n -0.000917
+ 177.1500n -0.001159 177.1600n -0.001401 177.1700n -0.001638 177.1800n -0.001861 177.1900n -0.002065 177.2000n -0.002245 177.2100n -0.002394 177.2200n -0.002508 177.2300n -0.002583 177.2400n -0.002615 177.2500n -0.002602 177.2600n -0.002544 177.2700n -0.002438 177.2800n -0.002287 177.2900n -0.002092
+ 177.3000n -0.001856 177.3100n -0.001582 177.3200n -0.001275 177.3300n -0.000941 177.3400n -0.000585 177.3500n -0.000213 177.3600n 0.000166 177.3700n 0.000546 177.3800n 0.000920 177.3900n 0.001280 177.4000n 0.001620 177.4100n 0.001932 177.4200n 0.002210 177.4300n 0.002448 177.4400n 0.002642
+ 177.4500n 0.002788 177.4600n 0.002882 177.4700n 0.002923 177.4800n 0.002908 177.4900n 0.002838 177.5000n 0.002714 177.5100n 0.002538 177.5200n 0.002312 177.5300n 0.002041 177.5400n 0.001728 177.5500n 0.001380 177.5600n 0.001002 177.5700n 0.000600 177.5800n 0.000182 177.5900n -0.000245
+ 177.6000n -0.000676 177.6100n -0.001102 177.6200n -0.001517 177.6300n -0.001914 177.6400n -0.002287 177.6500n -0.002632 177.6600n -0.002943 177.6700n -0.003216 177.6800n -0.003448 177.6900n -0.003636 177.7000n -0.003780 177.7100n -0.003879 177.7200n -0.003932 177.7300n -0.003941 177.7400n -0.003908
+ 177.7500n -0.003835 177.7600n -0.003726 177.7700n -0.003584 177.7800n -0.003414 177.7900n -0.003219 177.8000n -0.003006 177.8100n -0.002779 177.8200n -0.002542 177.8300n -0.002301 177.8400n -0.002061 177.8500n -0.001825 177.8600n -0.001597 177.8700n -0.001382 177.8800n -0.001181 177.8900n -0.000998
+ 177.9000n -0.000834 177.9100n -0.000691 177.9200n -0.000569 177.9300n -0.000468 177.9400n -0.000388 177.9500n -0.000327 177.9600n -0.000284 177.9700n -0.000258 177.9800n -0.000245 177.9900n -0.000244 178.0000n -0.000252 178.0100n -0.000266 178.0200n -0.000283 178.0300n -0.000301 178.0400n -0.000317
+ 178.0500n -0.000328 178.0600n -0.000333 178.0700n -0.000330 178.0800n -0.000318 178.0900n -0.000295 178.1000n -0.000261 178.1100n -0.000215 178.1200n -0.000158 178.1300n -0.000091 178.1400n -0.000014 178.1500n 0.000071 178.1600n 0.000163 178.1700n 0.000260 178.1800n 0.000360 178.1900n 0.000462
+ 178.2000n 0.000563 178.2100n 0.000661 178.2200n 0.000754 178.2300n 0.000842 178.2400n 0.000921 178.2500n 0.000992 178.2600n 0.001052 178.2700n 0.001102 178.2800n 0.001141 178.2900n 0.001169 178.3000n 0.001187 178.3100n 0.001194 178.3200n 0.001193 178.3300n 0.001185 178.3400n 0.001170
+ 178.3500n 0.001151 178.3600n 0.001129 178.3700n 0.001107 178.3800n 0.001085 178.3900n 0.001067 178.4000n 0.001053 178.4100n 0.001046 178.4200n 0.001045 178.4300n 0.001054 178.4400n 0.001072 178.4500n 0.001099 178.4600n 0.001136 178.4700n 0.001183 178.4800n 0.001238 178.4900n 0.001300
+ 178.5000n 0.001369 178.5100n 0.001443 178.5200n 0.001518 178.5300n 0.001594 178.5400n 0.001668 178.5500n 0.001738 178.5600n 0.001800 178.5700n 0.001853 178.5800n 0.001894 178.5900n 0.001921 178.6000n 0.001932 178.6100n 0.001926 178.6200n 0.001901 178.6300n 0.001857 178.6400n 0.001792
+ 178.6500n 0.001708 178.6600n 0.001604 178.6700n 0.001483 178.6800n 0.001344 178.6900n 0.001191 178.7000n 0.001026 178.7100n 0.000851 178.7200n 0.000670 178.7300n 0.000485 178.7400n 0.000302 178.7500n 0.000122 178.7600n -0.000050 178.7700n -0.000210 178.7800n -0.000356 178.7900n -0.000484
+ 178.8000n -0.000591 178.8100n -0.000675 178.8200n -0.000733 178.8300n -0.000765 178.8400n -0.000769 178.8500n -0.000746 178.8600n -0.000694 178.8700n -0.000616 178.8800n -0.000513 178.8900n -0.000387 178.9000n -0.000241 178.9100n -0.000077 178.9200n 0.000099 178.9300n 0.000285 178.9400n 0.000477
+ 178.9500n 0.000668 178.9600n 0.000856 178.9700n 0.001035 178.9800n 0.001201 178.9900n 0.001349 179.0000n 0.001477 179.0100n 0.001578 179.0200n 0.001652 179.0300n 0.001695 179.0400n 0.001705 179.0500n 0.001681 179.0600n 0.001623 179.0700n 0.001529 179.0800n 0.001402 179.0900n 0.001242
+ 179.1000n 0.001052 179.1100n 0.000834 179.1200n 0.000592 179.1300n 0.000330 179.1400n 0.000052 179.1500n -0.000237 179.1600n -0.000533 179.1700n -0.000830 179.1800n -0.001124 179.1900n -0.001409 179.2000n -0.001680 179.2100n -0.001934 179.2200n -0.002165 179.2300n -0.002370 179.2400n -0.002547
+ 179.2500n -0.002691 179.2600n -0.002802 179.2700n -0.002877 179.2800n -0.002917 179.2900n -0.002921 179.3000n -0.002891 179.3100n -0.002827 179.3200n -0.002732 179.3300n -0.002608 179.3400n -0.002459 179.3500n -0.002287 179.3600n -0.002098 179.3700n -0.001894 179.3800n -0.001681 179.3900n -0.001463
+ 179.4000n -0.001244 179.4100n -0.001028 179.4200n -0.000819 179.4300n -0.000621 179.4400n -0.000437 179.4500n -0.000270 179.4600n -0.000123 179.4700n 0.000004 179.4800n 0.000109 179.4900n 0.000190 179.5000n 0.000249 179.5100n 0.000285 179.5200n 0.000300 179.5300n 0.000296 179.5400n 0.000274
+ 179.5500n 0.000237 179.5600n 0.000187 179.5700n 0.000128 179.5800n 0.000062 179.5900n -0.000006 179.6000n -0.000075 179.6100n -0.000141 179.6200n -0.000202 179.6300n -0.000253 179.6400n -0.000294 179.6500n -0.000323 179.6600n -0.000338 179.6700n -0.000337 179.6800n -0.000321 179.6900n -0.000290
+ 179.7000n -0.000244 179.7100n -0.000184 179.7200n -0.000112 179.7300n -0.000029 179.7400n 0.000062 179.7500n 0.000159 179.7600n 0.000259 179.7700n 0.000358 179.7800n 0.000454 179.7900n 0.000544 179.8000n 0.000625 179.8100n 0.000694 179.8200n 0.000748 179.8300n 0.000784 179.8400n 0.000802
+ 179.8500n 0.000799 179.8600n 0.000774 179.8700n 0.000726 179.8800n 0.000656 179.8900n 0.000563 179.9000n 0.000449 179.9100n 0.000315 179.9200n 0.000163 179.9300n -0.000005 179.9400n -0.000187 179.9500n -0.000378 179.9600n -0.000578 179.9700n -0.000781 179.9800n -0.000984 179.9900n -0.001184
+ 180.0000n -0.001378 180.0100n -0.001562 180.0200n -0.001733 180.0300n -0.001889 180.0400n -0.002026 180.0500n -0.002143 180.0600n -0.002238 180.0700n -0.002309 180.0800n -0.002357 180.0900n -0.002381 180.1000n -0.002382 180.1100n -0.002359 180.1200n -0.002314 180.1300n -0.002250 180.1400n -0.002167
+ 180.1500n -0.002068 180.1600n -0.001957 180.1700n -0.001835 180.1800n -0.001705 180.1900n -0.001571 180.2000n -0.001436 180.2100n -0.001302 180.2200n -0.001172 180.2300n -0.001048 180.2400n -0.000934 180.2500n -0.000830 180.2600n -0.000738 180.2700n -0.000659 180.2800n -0.000594 180.2900n -0.000544
+ 180.3000n -0.000507 180.3100n -0.000484 180.3200n -0.000474 180.3300n -0.000474 180.3400n -0.000485 180.3500n -0.000503 180.3600n -0.000527 180.3700n -0.000554 180.3800n -0.000583 180.3900n -0.000610 180.4000n -0.000634 180.4100n -0.000653 180.4200n -0.000664 180.4300n -0.000666 180.4400n -0.000657
+ 180.4500n -0.000637 180.4600n -0.000604 180.4700n -0.000558 180.4800n -0.000500 180.4900n -0.000429 180.5000n -0.000346 180.5100n -0.000253 180.5200n -0.000151 180.5300n -0.000041 180.5400n 0.000074 180.5500n 0.000192 180.5600n 0.000311 180.5700n 0.000428 180.5800n 0.000541 180.5900n 0.000648
+ 180.6000n 0.000745 180.6100n 0.000832 180.6200n 0.000905 180.6300n 0.000964 180.6400n 0.001008 180.6500n 0.001034 180.6600n 0.001044 180.6700n 0.001035 180.6800n 0.001010 180.6900n 0.000968 180.7000n 0.000911 180.7100n 0.000840 180.7200n 0.000757 180.7300n 0.000663 180.7400n 0.000562
+ 180.7500n 0.000456 180.7600n 0.000347 180.7700n 0.000239 180.7800n 0.000133 180.7900n 0.000033 180.8000n -0.000060 180.8100n -0.000142 180.8200n -0.000212 180.8300n -0.000268 180.8400n -0.000308 180.8500n -0.000332 180.8600n -0.000340 180.8700n -0.000330 180.8800n -0.000304 180.8900n -0.000262
+ 180.9000n -0.000205 180.9100n -0.000135 180.9200n -0.000054 180.9300n 0.000036 180.9400n 0.000132 180.9500n 0.000233 180.9600n 0.000334 180.9700n 0.000433 180.9800n 0.000528 180.9900n 0.000615 181.0000n 0.000692 181.0100n 0.000756 181.0200n 0.000806 181.0300n 0.000839 181.0400n 0.000854
+ 181.0500n 0.000850 181.0600n 0.000828 181.0700n 0.000785 181.0800n 0.000724 181.0900n 0.000645 181.1000n 0.000548 181.1100n 0.000437 181.1200n 0.000313 181.1300n 0.000179 181.1400n 0.000037 181.1500n -0.000109 181.1600n -0.000256 181.1700n -0.000402 181.1800n -0.000542 181.1900n -0.000673
+ 181.2000n -0.000794 181.2100n -0.000899 181.2200n -0.000988 181.2300n -0.001058 181.2400n -0.001107 181.2500n -0.001133 181.2600n -0.001136 181.2700n -0.001116 181.2800n -0.001072 181.2900n -0.001006 181.3000n -0.000917 181.3100n -0.000809 181.3200n -0.000683 181.3300n -0.000541 181.3400n -0.000387
+ 181.3500n -0.000224 181.3600n -0.000055 181.3700n 0.000117 181.3800n 0.000287 181.3900n 0.000452 181.4000n 0.000609 181.4100n 0.000754 181.4200n 0.000884 181.4300n 0.000996 181.4400n 0.001088 181.4500n 0.001157 181.4600n 0.001202 181.4700n 0.001221 181.4800n 0.001215 181.4900n 0.001183
+ 181.5000n 0.001125 181.5100n 0.001042 181.5200n 0.000937 181.5300n 0.000810 181.5400n 0.000664 181.5500n 0.000503 181.5600n 0.000328 181.5700n 0.000144 181.5800n -0.000047 181.5900n -0.000240 181.6000n -0.000432 181.6100n -0.000619 181.6200n -0.000798 181.6300n -0.000965 181.6400n -0.001117
+ 181.6500n -0.001252 181.6600n -0.001367 181.6700n -0.001461 181.6800n -0.001530 181.6900n -0.001575 181.7000n -0.001595 181.7100n -0.001590 181.7200n -0.001559 181.7300n -0.001504 181.7400n -0.001426 181.7500n -0.001326 181.7600n -0.001207 181.7700n -0.001071 181.7800n -0.000919 181.7900n -0.000756
+ 181.8000n -0.000584 181.8100n -0.000405 181.8200n -0.000223 181.8300n -0.000041 181.8400n 0.000139 181.8500n 0.000314 181.8600n 0.000481 181.8700n 0.000639 181.8800n 0.000785 181.8900n 0.000917 181.9000n 0.001035 181.9100n 0.001138 181.9200n 0.001224 181.9300n 0.001294 181.9400n 0.001348
+ 181.9500n 0.001386 181.9600n 0.001409 181.9700n 0.001417 181.9800n 0.001413 181.9900n 0.001397 182.0000n 0.001370 182.0100n 0.001335 182.0200n 0.001293 182.0300n 0.001246 182.0400n 0.001195 182.0500n 0.001142 182.0600n 0.001089 182.0700n 0.001036 182.0800n 0.000985 182.0900n 0.000937
+ 182.1000n 0.000893 182.1100n 0.000854 182.1200n 0.000819 182.1300n 0.000790 182.1400n 0.000766 182.1500n 0.000748 182.1600n 0.000734 182.1700n 0.000724 182.1800n 0.000719 182.1900n 0.000717 182.2000n 0.000718 182.2100n 0.000721 182.2200n 0.000725 182.2300n 0.000730 182.2400n 0.000735
+ 182.2500n 0.000739 182.2600n 0.000743 182.2700n 0.000744 182.2800n 0.000744 182.2900n 0.000742 182.3000n 0.000737 182.3100n 0.000731 182.3200n 0.000722 182.3300n 0.000711 182.3400n 0.000699 182.3500n 0.000685 182.3600n 0.000671 182.3700n 0.000655 182.3800n 0.000640 182.3900n 0.000625
+ 182.4000n 0.000610 182.4100n 0.000596 182.4200n 0.000583 182.4300n 0.000571 182.4400n 0.000560 182.4500n 0.000550 182.4600n 0.000541 182.4700n 0.000533 182.4800n 0.000524 182.4900n 0.000516 182.5000n 0.000507 182.5100n 0.000497 182.5200n 0.000485 182.5300n 0.000470 182.5400n 0.000452
+ 182.5500n 0.000430 182.5600n 0.000404 182.5700n 0.000374 182.5800n 0.000338 182.5900n 0.000296 182.6000n 0.000249 182.6100n 0.000197 182.6200n 0.000140 182.6300n 0.000078 182.6400n 0.000011 182.6500n -0.000059 182.6600n -0.000131 182.6700n -0.000204 182.6800n -0.000278 182.6900n -0.000351
+ 182.7000n -0.000421 182.7100n -0.000487 182.7200n -0.000547 182.7300n -0.000600 182.7400n -0.000645 182.7500n -0.000680 182.7600n -0.000703 182.7700n -0.000715 182.7800n -0.000713 182.7900n -0.000697 182.8000n -0.000668 182.8100n -0.000623 182.8200n -0.000565 182.8300n -0.000493 182.8400n -0.000407
+ 182.8500n -0.000310 182.8600n -0.000201 182.8700n -0.000084 182.8800n 0.000041 182.8900n 0.000172 182.9000n 0.000306 182.9100n 0.000441 182.9200n 0.000574 182.9300n 0.000704 182.9400n 0.000827 182.9500n 0.000942 182.9600n 0.001046 182.9700n 0.001137 182.9800n 0.001213 182.9900n 0.001272
+ 183.0000n 0.001314 183.0100n 0.001338 183.0200n 0.001341 183.0300n 0.001325 183.0400n 0.001290 183.0500n 0.001235 183.0600n 0.001162 183.0700n 0.001072 183.0800n 0.000966 183.0900n 0.000847 183.1000n 0.000716 183.1100n 0.000577 183.1200n 0.000431 183.1300n 0.000281 183.1400n 0.000131
+ 183.1500n -0.000018 183.1600n -0.000161 183.1700n -0.000297 183.1800n -0.000422 183.1900n -0.000534 183.2000n -0.000632 183.2100n -0.000713 183.2200n -0.000775 183.2300n -0.000818 183.2400n -0.000841 183.2500n -0.000843 183.2600n -0.000824 183.2700n -0.000785 183.2800n -0.000727 183.2900n -0.000650
+ 183.3000n -0.000557 183.3100n -0.000450 183.3200n -0.000330 183.3300n -0.000200 183.3400n -0.000062 183.3500n 0.000080 183.3600n 0.000223 183.3700n 0.000366 183.3800n 0.000505 183.3900n 0.000637 183.4000n 0.000760 183.4100n 0.000872 183.4200n 0.000970 183.4300n 0.001052 183.4400n 0.001118
+ 183.4500n 0.001166 183.4600n 0.001195 183.4700n 0.001205 183.4800n 0.001196 183.4900n 0.001168 183.5000n 0.001122 183.5100n 0.001060 183.5200n 0.000981 183.5300n 0.000889 183.5400n 0.000784 183.5500n 0.000669 183.5600n 0.000547 183.5700n 0.000418 183.5800n 0.000286 183.5900n 0.000152
+ 183.6000n 0.000020 183.6100n -0.000110 183.6200n -0.000235 183.6300n -0.000354 183.6400n -0.000465 183.6500n -0.000568 183.6600n -0.000660 183.6700n -0.000742 183.6800n -0.000814 183.6900n -0.000875 183.7000n -0.000926 183.7100n -0.000967 183.7200n -0.000999 183.7300n -0.001024 183.7400n -0.001042
+ 183.7500n -0.001054 183.7600n -0.001062 183.7700n -0.001069 183.7800n -0.001074 183.7900n -0.001079 183.8000n -0.001086 183.8100n -0.001097 183.8200n -0.001111 183.8300n -0.001129 183.8400n -0.001153 183.8500n -0.001183 183.8600n -0.001218 183.8700n -0.001258 183.8800n -0.001303 183.8900n -0.001352
+ 183.9000n -0.001404 183.9100n -0.001457 183.9200n -0.001510 183.9300n -0.001561 183.9400n -0.001608 183.9500n -0.001649 183.9600n -0.001682 183.9700n -0.001705 183.9800n -0.001716 183.9900n -0.001714 184.0000n -0.001695 184.0100n -0.001660 184.0200n -0.001606 184.0300n -0.001534 184.0400n -0.001441
+ 184.0500n -0.001327 184.0600n -0.001194 184.0700n -0.001041 184.0800n -0.000870 184.0900n -0.000681 184.1000n -0.000476 184.1100n -0.000258 184.1200n -0.000029 184.1300n 0.000208 184.1400n 0.000451 184.1500n 0.000695 184.1600n 0.000938 184.1700n 0.001176 184.1800n 0.001405 184.1900n 0.001622
+ 184.2000n 0.001824 184.2100n 0.002006 184.2200n 0.002165 184.2300n 0.002300 184.2400n 0.002407 184.2500n 0.002483 184.2600n 0.002528 184.2700n 0.002540 184.2800n 0.002517 184.2900n 0.002461 184.3000n 0.002370 184.3100n 0.002246 184.3200n 0.002090 184.3300n 0.001904 184.3400n 0.001690
+ 184.3500n 0.001450 184.3600n 0.001189 184.3700n 0.000909 184.3800n 0.000615 184.3900n 0.000310 184.4000n -0.000001 184.4100n -0.000314 184.4200n -0.000623 184.4300n -0.000925 184.4400n -0.001215 184.4500n -0.001489 184.4600n -0.001742 184.4700n -0.001971 184.4800n -0.002173 184.4900n -0.002343
+ 184.5000n -0.002481 184.5100n -0.002583 184.5200n -0.002648 184.5300n -0.002674 184.5400n -0.002662 184.5500n -0.002611 184.5600n -0.002523 184.5700n -0.002397 184.5800n -0.002236 184.5900n -0.002041 184.6000n -0.001817 184.6100n -0.001565 184.6200n -0.001289 184.6300n -0.000994 184.6400n -0.000682
+ 184.6500n -0.000359 184.6600n -0.000028 184.6700n 0.000306 184.6800n 0.000638 184.6900n 0.000964 184.7000n 0.001280 184.7100n 0.001581 184.7200n 0.001864 184.7300n 0.002126 184.7400n 0.002362 184.7500n 0.002571 184.7600n 0.002750 184.7700n 0.002897 184.7800n 0.003011 184.7900n 0.003091
+ 184.8000n 0.003136 184.8100n 0.003146 184.8200n 0.003123 184.8300n 0.003067 184.8400n 0.002981 184.8500n 0.002865 184.8600n 0.002722 184.8700n 0.002555 184.8800n 0.002368 184.8900n 0.002163 184.9000n 0.001944 184.9100n 0.001714 184.9200n 0.001477 184.9300n 0.001238 184.9400n 0.000998
+ 184.9500n 0.000763 184.9600n 0.000535 184.9700n 0.000318 184.9800n 0.000114 184.9900n -0.000073 185.0000n -0.000242 185.0100n -0.000391 185.0200n -0.000518 185.0300n -0.000622 185.0400n -0.000703 185.0500n -0.000760 185.0600n -0.000793 185.0700n -0.000803 185.0800n -0.000791 185.0900n -0.000759
+ 185.1000n -0.000708 185.1100n -0.000640 185.1200n -0.000557 185.1300n -0.000462 185.1400n -0.000358 185.1500n -0.000247 185.1600n -0.000132 185.1700n -0.000016 185.1800n 0.000098 185.1900n 0.000207 185.2000n 0.000310 185.2100n 0.000403 185.2200n 0.000485 185.2300n 0.000554 185.2400n 0.000608
+ 185.2500n 0.000647 185.2600n 0.000669 185.2700n 0.000674 185.2800n 0.000662 185.2900n 0.000634 185.3000n 0.000589 185.3100n 0.000530 185.3200n 0.000457 185.3300n 0.000372 185.3400n 0.000277 185.3500n 0.000174 185.3600n 0.000066 185.3700n -0.000046 185.3800n -0.000159 185.3900n -0.000271
+ 185.4000n -0.000379 185.4100n -0.000481 185.4200n -0.000575 185.4300n -0.000659 185.4400n -0.000732 185.4500n -0.000793 185.4600n -0.000839 185.4700n -0.000872 185.4800n -0.000890 185.4900n -0.000893 185.5000n -0.000882 185.5100n -0.000859 185.5200n -0.000823 185.5300n -0.000776 185.5400n -0.000721
+ 185.5500n -0.000659 185.5600n -0.000593 185.5700n -0.000525 185.5800n -0.000457 185.5900n -0.000392 185.6000n -0.000332 185.6100n -0.000281 185.6200n -0.000240 185.6300n -0.000211 185.6400n -0.000196 185.6500n -0.000197 185.6600n -0.000215 185.6700n -0.000251 185.6800n -0.000306 185.6900n -0.000378
+ 185.7000n -0.000469 185.7100n -0.000576 185.7200n -0.000699 185.7300n -0.000835 185.7400n -0.000983 185.7500n -0.001141 185.7600n -0.001304 185.7700n -0.001471 185.7800n -0.001638 185.7900n -0.001800 185.8000n -0.001956 185.8100n -0.002101 185.8200n -0.002232 185.8300n -0.002345 185.8400n -0.002438
+ 185.8500n -0.002507 185.8600n -0.002551 185.8700n -0.002567 185.8800n -0.002553 185.8900n -0.002510 185.9000n -0.002435 185.9100n -0.002330 185.9200n -0.002195 185.9300n -0.002031 185.9400n -0.001840 185.9500n -0.001624 185.9600n -0.001387 185.9700n -0.001131 185.9800n -0.000861 185.9900n -0.000580
+ 186.0000n -0.000293 186.0100n -0.000005 186.0200n 0.000281 186.0300n 0.000558 186.0400n 0.000823 186.0500n 0.001071 186.0600n 0.001298 186.0700n 0.001500 186.0800n 0.001673 186.0900n 0.001814 186.1000n 0.001921 186.1100n 0.001991 186.1200n 0.002024 186.1300n 0.002018 186.1400n 0.001974
+ 186.1500n 0.001892 186.1600n 0.001774 186.1700n 0.001621 186.1800n 0.001436 186.1900n 0.001222 186.2000n 0.000983 186.2100n 0.000722 186.2200n 0.000445 186.2300n 0.000155 186.2400n -0.000142 186.2500n -0.000442 186.2600n -0.000739 186.2700n -0.001029 186.2800n -0.001306 186.2900n -0.001567
+ 186.3000n -0.001807 186.3100n -0.002023 186.3200n -0.002211 186.3300n -0.002369 186.3400n -0.002493 186.3500n -0.002584 186.3600n -0.002640 186.3700n -0.002660 186.3800n -0.002646 186.3900n -0.002597 186.4000n -0.002516 186.4100n -0.002404 186.4200n -0.002265 186.4300n -0.002101 186.4400n -0.001916
+ 186.4500n -0.001712 186.4600n -0.001496 186.4700n -0.001269 186.4800n -0.001037 186.4900n -0.000803 186.5000n -0.000572 186.5100n -0.000347 186.5200n -0.000132 186.5300n 0.000070 186.5400n 0.000256 186.5500n 0.000424 186.5600n 0.000571 186.5700n 0.000696 186.5800n 0.000798 186.5900n 0.000877
+ 186.6000n 0.000932 186.6100n 0.000964 186.6200n 0.000973 186.6300n 0.000961 186.6400n 0.000930 186.6500n 0.000882 186.6600n 0.000819 186.6700n 0.000743 186.6800n 0.000658 186.6900n 0.000565 186.7000n 0.000468 186.7100n 0.000370 186.7200n 0.000273 186.7300n 0.000179 186.7400n 0.000092
+ 186.7500n 0.000013 186.7600n -0.000057 186.7700n -0.000114 186.7800n -0.000160 186.7900n -0.000191 186.8000n -0.000209 186.8100n -0.000213 186.8200n -0.000202 186.8300n -0.000179 186.8400n -0.000142 186.8500n -0.000095 186.8600n -0.000037 186.8700n 0.000030 186.8800n 0.000104 186.8900n 0.000183
+ 186.9000n 0.000265 186.9100n 0.000349 186.9200n 0.000434 186.9300n 0.000516 186.9400n 0.000595 186.9500n 0.000669 186.9600n 0.000737 186.9700n 0.000797 186.9800n 0.000849 186.9900n 0.000892 187.0000n 0.000926 187.0100n 0.000950 187.0200n 0.000964 187.0300n 0.000968 187.0400n 0.000963
+ 187.0500n 0.000949 187.0600n 0.000926 187.0700n 0.000896 187.0800n 0.000859 187.0900n 0.000815 187.1000n 0.000766 187.1100n 0.000713 187.1200n 0.000656 187.1300n 0.000597 187.1400n 0.000535 187.1500n 0.000471 187.1600n 0.000407 187.1700n 0.000342 187.1800n 0.000277 187.1900n 0.000211
+ 187.2000n 0.000146 187.2100n 0.000080 187.2200n 0.000014 187.2300n -0.000052 187.2400n -0.000119 187.2500n -0.000186 187.2600n -0.000255 187.2700n -0.000325 187.2800n -0.000396 187.2900n -0.000469 187.3000n -0.000544 187.3100n -0.000620 187.3200n -0.000698 187.3300n -0.000777 187.3400n -0.000857
+ 187.3500n -0.000937 187.3600n -0.001018 187.3700n -0.001097 187.3800n -0.001175 187.3900n -0.001251 187.4000n -0.001323 187.4100n -0.001391 187.4200n -0.001454 187.4300n -0.001510 187.4400n -0.001560 187.4500n -0.001601 187.4600n -0.001634 187.4700n -0.001657 187.4800n -0.001671 187.4900n -0.001675
+ 187.5000n -0.001669 187.5100n -0.001653 187.5200n -0.001627 187.5300n -0.001592 187.5400n -0.001548 187.5500n -0.001496 187.5600n -0.001438 187.5700n -0.001375 187.5800n -0.001308 187.5900n -0.001238 187.6000n -0.001167 187.6100n -0.001096 187.6200n -0.001028 187.6300n -0.000963 187.6400n -0.000904
+ 187.6500n -0.000850 187.6600n -0.000805 187.6700n -0.000768 187.6800n -0.000740 187.6900n -0.000723 187.7000n -0.000715 187.7100n -0.000718 187.7200n -0.000731 187.7300n -0.000753 187.7400n -0.000784 187.7500n -0.000822 187.7600n -0.000867 187.7700n -0.000916 187.7800n -0.000968 187.7900n -0.001022
+ 187.8000n -0.001074 187.8100n -0.001124 187.8200n -0.001168 187.8300n -0.001206 187.8400n -0.001235 187.8500n -0.001254 187.8600n -0.001261 187.8700n -0.001255 187.8800n -0.001234 187.8900n -0.001199 187.9000n -0.001148 187.9100n -0.001082 187.9200n -0.001001 187.9300n -0.000906 187.9400n -0.000798
+ 187.9500n -0.000678 187.9600n -0.000548 187.9700n -0.000411 187.9800n -0.000267 187.9900n -0.000121 188.0000n 0.000026 188.0100n 0.000171 188.0200n 0.000311 188.0300n 0.000442 188.0400n 0.000563 188.0500n 0.000671 188.0600n 0.000763 188.0700n 0.000838 188.0800n 0.000893 188.0900n 0.000927
+ 188.1000n 0.000939 188.1100n 0.000929 188.1200n 0.000895 188.1300n 0.000839 188.1400n 0.000761 188.1500n 0.000662 188.1600n 0.000544 188.1700n 0.000408 188.1800n 0.000257 188.1900n 0.000093 188.2000n -0.000081 188.2100n -0.000261 188.2200n -0.000445 188.2300n -0.000629 188.2400n -0.000811
+ 188.2500n -0.000986 188.2600n -0.001153 188.2700n -0.001307 188.2800n -0.001448 188.2900n -0.001571 188.3000n -0.001676 188.3100n -0.001761 188.3200n -0.001825 188.3300n -0.001867 188.3400n -0.001887 188.3500n -0.001886 188.3600n -0.001864 188.3700n -0.001822 188.3800n -0.001761 188.3900n -0.001684
+ 188.4000n -0.001594 188.4100n -0.001491 188.4200n -0.001379 188.4300n -0.001261 188.4400n -0.001139 188.4500n -0.001017 188.4600n -0.000896 188.4700n -0.000779 188.4800n -0.000669 188.4900n -0.000568 188.5000n -0.000478 188.5100n -0.000399 188.5200n -0.000333 188.5300n -0.000280 188.5400n -0.000241
+ 188.5500n -0.000215 188.5600n -0.000201 188.5700n -0.000199 188.5800n -0.000206 188.5900n -0.000222 188.6000n -0.000243 188.6100n -0.000269 188.6200n -0.000295 188.6300n -0.000320 188.6400n -0.000340 188.6500n -0.000354 188.6600n -0.000359 188.6700n -0.000352 188.6800n -0.000332 188.6900n -0.000296
+ 188.7000n -0.000244 188.7100n -0.000174 188.7200n -0.000085 188.7300n 0.000022 188.7400n 0.000147 188.7500n 0.000290 188.7600n 0.000448 188.7700n 0.000621 188.7800n 0.000806 188.7900n 0.001000 188.8000n 0.001202 188.8100n 0.001406 188.8200n 0.001611 188.8300n 0.001813 188.8400n 0.002008
+ 188.8500n 0.002193 188.8600n 0.002364 188.8700n 0.002518 188.8800n 0.002652 188.8900n 0.002764 188.9000n 0.002850 188.9100n 0.002910 188.9200n 0.002941 188.9300n 0.002944 188.9400n 0.002917 188.9500n 0.002860 188.9600n 0.002776 188.9700n 0.002664 188.9800n 0.002526 188.9900n 0.002366
+ 189.0000n 0.002185 189.0100n 0.001987 189.0200n 0.001776 189.0300n 0.001554 189.0400n 0.001326 189.0500n 0.001096 189.0600n 0.000868 189.0700n 0.000646 189.0800n 0.000433 189.0900n 0.000233 189.1000n 0.000050 189.1100n -0.000114 189.1200n -0.000256 189.1300n -0.000374 189.1400n -0.000467
+ 189.1500n -0.000533 189.1600n -0.000573 189.1700n -0.000585 189.1800n -0.000571 189.1900n -0.000532 189.2000n -0.000470 189.2100n -0.000387 189.2200n -0.000284 189.2300n -0.000166 189.2400n -0.000034 189.2500n 0.000106 189.2600n 0.000253 189.2700n 0.000402 189.2800n 0.000550 189.2900n 0.000694
+ 189.3000n 0.000829 189.3100n 0.000953 189.3200n 0.001064 189.3300n 0.001158 189.3400n 0.001233 189.3500n 0.001288 189.3600n 0.001322 189.3700n 0.001333 189.3800n 0.001321 189.3900n 0.001287 189.4000n 0.001231 189.4100n 0.001153 189.4200n 0.001056 189.4300n 0.000942 189.4400n 0.000811
+ 189.4500n 0.000667 189.4600n 0.000512 189.4700n 0.000349 189.4800n 0.000180 189.4900n 0.000009 189.5000n -0.000161 189.5100n -0.000329 189.5200n -0.000491 189.5300n -0.000644 189.5400n -0.000788 189.5500n -0.000918 189.5600n -0.001035 189.5700n -0.001136 189.5800n -0.001220 189.5900n -0.001287
+ 189.6000n -0.001335 189.6100n -0.001366 189.6200n -0.001378 189.6300n -0.001372 189.6400n -0.001349 189.6500n -0.001310 189.6600n -0.001255 189.6700n -0.001186 189.6800n -0.001104 189.6900n -0.001010 189.7000n -0.000906 189.7100n -0.000792 189.7200n -0.000671 189.7300n -0.000543 189.7400n -0.000410
+ 189.7500n -0.000273 189.7600n -0.000132 189.7700n 0.000010 189.7800n 0.000154 189.7900n 0.000299 189.8000n 0.000444 189.8100n 0.000588 189.8200n 0.000731 189.8300n 0.000873 189.8400n 0.001012 189.8500n 0.001149 189.8600n 0.001283 189.8700n 0.001413 189.8800n 0.001539 189.8900n 0.001661
+ 189.9000n 0.001777 189.9100n 0.001887 189.9200n 0.001989 189.9300n 0.002084 189.9400n 0.002168 189.9500n 0.002243 189.9600n 0.002306 189.9700n 0.002355 189.9800n 0.002391 189.9900n 0.002411 190.0000n 0.002414 190.0100n 0.002400 190.0200n 0.002367 190.0300n 0.002314 190.0400n 0.002242
+ 190.0500n 0.002149 190.0600n 0.002037 190.0700n 0.001904 190.0800n 0.001752 190.0900n 0.001581 190.1000n 0.001393 190.1100n 0.001189 190.1200n 0.000972 190.1300n 0.000744 190.1400n 0.000506 190.1500n 0.000263 190.1600n 0.000017 190.1700n -0.000229 190.1800n -0.000472 190.1900n -0.000707
+ 190.2000n -0.000932 190.2100n -0.001142 190.2200n -0.001336 190.2300n -0.001509 190.2400n -0.001659 190.2500n -0.001783 190.2600n -0.001880 190.2700n -0.001947 190.2800n -0.001984 190.2900n -0.001990 190.3000n -0.001964 190.3100n -0.001907 190.3200n -0.001819 190.3300n -0.001703 190.3400n -0.001561
+ 190.3500n -0.001394 190.3600n -0.001206 190.3700n -0.001000 190.3800n -0.000781 190.3900n -0.000551 190.4000n -0.000316 190.4100n -0.000080 190.4200n 0.000153 190.4300n 0.000379 190.4400n 0.000592 190.4500n 0.000790 190.4600n 0.000968 190.4700n 0.001122 190.4800n 0.001251 190.4900n 0.001350
+ 190.5000n 0.001420 190.5100n 0.001457 190.5200n 0.001462 190.5300n 0.001434 190.5400n 0.001374 190.5500n 0.001283 190.5600n 0.001163 190.5700n 0.001017 190.5800n 0.000847 190.5900n 0.000657 190.6000n 0.000451 190.6100n 0.000233 190.6200n 0.000007 190.6300n -0.000222 190.6400n -0.000449
+ 190.6500n -0.000670 190.6600n -0.000881 190.6700n -0.001077 190.6800n -0.001254 190.6900n -0.001408 190.7000n -0.001537 190.7100n -0.001638 190.7200n -0.001709 190.7300n -0.001748 190.7400n -0.001755 190.7500n -0.001729 190.7600n -0.001671 190.7700n -0.001583 190.7800n -0.001465 190.7900n -0.001321
+ 190.8000n -0.001153 190.8100n -0.000965 190.8200n -0.000759 190.8300n -0.000541 190.8400n -0.000314 190.8500n -0.000083 190.8600n 0.000149 190.8700n 0.000375 190.8800n 0.000593 190.8900n 0.000799 190.9000n 0.000988 190.9100n 0.001157 190.9200n 0.001304 190.9300n 0.001426 190.9400n 0.001521
+ 190.9500n 0.001588 190.9600n 0.001627 190.9700n 0.001637 190.9800n 0.001618 190.9900n 0.001572 191.0000n 0.001501 191.0100n 0.001406 191.0200n 0.001290 191.0300n 0.001156 191.0400n 0.001007 191.0500n 0.000848 191.0600n 0.000680 191.0700n 0.000509 191.0800n 0.000338 191.0900n 0.000170
+ 191.1000n 0.000010 191.1100n -0.000140 191.1200n -0.000275 191.1300n -0.000395 191.1400n -0.000495 191.1500n -0.000575 191.1600n -0.000633 191.1700n -0.000667 191.1800n -0.000678 191.1900n -0.000665 191.2000n -0.000629 191.2100n -0.000571 191.2200n -0.000493 191.2300n -0.000395 191.2400n -0.000280
+ 191.2500n -0.000151 191.2600n -0.000010 191.2700n 0.000140 191.2800n 0.000296 191.2900n 0.000455 191.3000n 0.000615 191.3100n 0.000771 191.3200n 0.000923 191.3300n 0.001066 191.3400n 0.001199 191.3500n 0.001319 191.3600n 0.001426 191.3700n 0.001517 191.3800n 0.001591 191.3900n 0.001648
+ 191.4000n 0.001687 191.4100n 0.001708 191.4200n 0.001712 191.4300n 0.001699 191.4400n 0.001670 191.4500n 0.001627 191.4600n 0.001569 191.4700n 0.001500 191.4800n 0.001420 191.4900n 0.001332 191.5000n 0.001237 191.5100n 0.001138 191.5200n 0.001035 191.5300n 0.000930 191.5400n 0.000826
+ 191.5500n 0.000723 191.5600n 0.000624 191.5700n 0.000528 191.5800n 0.000438 191.5900n 0.000353 191.6000n 0.000275 191.6100n 0.000204 191.6200n 0.000141 191.6300n 0.000085 191.6400n 0.000036 191.6500n -0.000005 191.6600n -0.000039 191.6700n -0.000067 191.6800n -0.000088 191.6900n -0.000102
+ 191.7000n -0.000112 191.7100n -0.000115 191.7200n -0.000114 191.7300n -0.000108 191.7400n -0.000098 191.7500n -0.000083 191.7600n -0.000063 191.7700n -0.000040 191.7800n -0.000012 191.7900n 0.000021 191.8000n 0.000058 191.8100n 0.000100 191.8200n 0.000148 191.8300n 0.000200 191.8400n 0.000259
+ 191.8500n 0.000323 191.8600n 0.000393 191.8700n 0.000469 191.8800n 0.000550 191.8900n 0.000638 191.9000n 0.000730 191.9100n 0.000827 191.9200n 0.000929 191.9300n 0.001034 191.9400n 0.001142 191.9500n 0.001251 191.9600n 0.001360 191.9700n 0.001469 191.9800n 0.001575 191.9900n 0.001678
+ 192.0000n 0.001776 192.0100n 0.001867 192.0200n 0.001950 192.0300n 0.002024 192.0400n 0.002088 192.0500n 0.002140 192.0600n 0.002179 192.0700n 0.002205 192.0800n 0.002218 192.0900n 0.002215 192.1000n 0.002199 192.1100n 0.002168 192.1200n 0.002123 192.1300n 0.002065 192.1400n 0.001995
+ 192.1500n 0.001914 192.1600n 0.001823 192.1700n 0.001724 192.1800n 0.001619 192.1900n 0.001509 192.2000n 0.001396 192.2100n 0.001284 192.2200n 0.001173 192.2300n 0.001066 192.2400n 0.000965 192.2500n 0.000871 192.2600n 0.000787 192.2700n 0.000715 192.2800n 0.000655 192.2900n 0.000609
+ 192.3000n 0.000577 192.3100n 0.000560 192.3200n 0.000559 192.3300n 0.000573 192.3400n 0.000601 192.3500n 0.000644 192.3600n 0.000700 192.3700n 0.000768 192.3800n 0.000846 192.3900n 0.000933 192.4000n 0.001026 192.4100n 0.001123 192.4200n 0.001221 192.4300n 0.001320 192.4400n 0.001415
+ 192.4500n 0.001505 192.4600n 0.001588 192.4700n 0.001660 192.4800n 0.001720 192.4900n 0.001767 192.5000n 0.001797 192.5100n 0.001811 192.5200n 0.001806 192.5300n 0.001782 192.5400n 0.001738 192.5500n 0.001674 192.5600n 0.001590 192.5700n 0.001487 192.5800n 0.001365 192.5900n 0.001225
+ 192.6000n 0.001069 192.6100n 0.000897 192.6200n 0.000713 192.6300n 0.000517 192.6400n 0.000312 192.6500n 0.000101 192.6600n -0.000116 192.6700n -0.000334 192.6800n -0.000551 192.6900n -0.000766 192.7000n -0.000976 192.7100n -0.001178 192.7200n -0.001371 192.7300n -0.001552 192.7400n -0.001720
+ 192.7500n -0.001872 192.7600n -0.002008 192.7700n -0.002127 192.7800n -0.002226 192.7900n -0.002306 192.8000n -0.002365 192.8100n -0.002404 192.8200n -0.002423 192.8300n -0.002421 192.8400n -0.002398 192.8500n -0.002356 192.8600n -0.002295 192.8700n -0.002215 192.8800n -0.002118 192.8900n -0.002005
+ 192.9000n -0.001878 192.9100n -0.001737 192.9200n -0.001584 192.9300n -0.001421 192.9400n -0.001250 192.9500n -0.001072 192.9600n -0.000889 192.9700n -0.000703 192.9800n -0.000516 192.9900n -0.000329 193.0000n -0.000146 193.0100n 0.000033 193.0200n 0.000206 193.0300n 0.000370 193.0400n 0.000524
+ 193.0500n 0.000667 193.0600n 0.000796 193.0700n 0.000909 193.0800n 0.001007 193.0900n 0.001087 193.1000n 0.001148 193.1100n 0.001190 193.1200n 0.001211 193.1300n 0.001212 193.1400n 0.001192 193.1500n 0.001151 193.1600n 0.001090 193.1700n 0.001008 193.1800n 0.000908 193.1900n 0.000790
+ 193.2000n 0.000656 193.2100n 0.000508 193.2200n 0.000346 193.2300n 0.000175 193.2400n -0.000004 193.2500n -0.000188 193.2600n -0.000374 193.2700n -0.000560 193.2800n -0.000741 193.2900n -0.000915 193.3000n -0.001080 193.3100n -0.001231 193.3200n -0.001367 193.3300n -0.001484 193.3400n -0.001580
+ 193.3500n -0.001654 193.3600n -0.001702 193.3700n -0.001724 193.3800n -0.001719 193.3900n -0.001686 193.4000n -0.001626 193.4100n -0.001538 193.4200n -0.001424 193.4300n -0.001285 193.4400n -0.001124 193.4500n -0.000942 193.4600n -0.000743 193.4700n -0.000530 193.4800n -0.000307 193.4900n -0.000077
+ 193.5000n 0.000154 193.5100n 0.000383 193.5200n 0.000605 193.5300n 0.000816 193.5400n 0.001011 193.5500n 0.001187 193.5600n 0.001338 193.5700n 0.001462 193.5800n 0.001556 193.5900n 0.001617 193.6000n 0.001642 193.6100n 0.001631 193.6200n 0.001582 193.6300n 0.001495 193.6400n 0.001372
+ 193.6500n 0.001212 193.6600n 0.001020 193.6700n 0.000796 193.6800n 0.000544 193.6900n 0.000269 193.7000n -0.000026 193.7100n -0.000334 193.7200n -0.000652 193.7300n -0.000973 193.7400n -0.001291 193.7500n -0.001601 193.7600n -0.001897 193.7700n -0.002173 193.7800n -0.002424 193.7900n -0.002645
+ 193.8000n -0.002832 193.8100n -0.002979 193.8200n -0.003085 193.8300n -0.003145 193.8400n -0.003160 193.8500n -0.003127 193.8600n -0.003047 193.8700n -0.002919 193.8800n -0.002747 193.8900n -0.002532 193.9000n -0.002277 193.9100n -0.001988 193.9200n -0.001667 193.9300n -0.001321 193.9400n -0.000956
+ 193.9500n -0.000577 193.9600n -0.000191 193.9700n 0.000194 193.9800n 0.000573 193.9900n 0.000939 194.0000n 0.001285 194.0100n 0.001605 194.0200n 0.001893 194.0300n 0.002145 194.0400n 0.002356 194.0500n 0.002521 194.0600n 0.002639 194.0700n 0.002707 194.0800n 0.002723 194.0900n 0.002689
+ 194.1000n 0.002603 194.1100n 0.002468 194.1200n 0.002286 194.1300n 0.002060 194.1400n 0.001795 194.1500n 0.001494 194.1600n 0.001164 194.1700n 0.000810 194.1800n 0.000438 194.1900n 0.000054 194.2000n -0.000334 194.2100n -0.000721 194.2200n -0.001100 194.2300n -0.001465 194.2400n -0.001809
+ 194.2500n -0.002127 194.2600n -0.002414 194.2700n -0.002666 194.2800n -0.002879 194.2900n -0.003050 194.3000n -0.003176 194.3100n -0.003257 194.3200n -0.003292 194.3300n -0.003280 194.3400n -0.003223 194.3500n -0.003122 194.3600n -0.002980 194.3700n -0.002799 194.3800n -0.002584 194.3900n -0.002338
+ 194.4000n -0.002065 194.4100n -0.001771 194.4200n -0.001460 194.4300n -0.001137 194.4400n -0.000807 194.4500n -0.000475 194.4600n -0.000145 194.4700n 0.000177 194.4800n 0.000487 194.4900n 0.000783 194.5000n 0.001059 194.5100n 0.001315 194.5200n 0.001546 194.5300n 0.001751 194.5400n 0.001929
+ 194.5500n 0.002079 194.5600n 0.002200 194.5700n 0.002293 194.5800n 0.002357 194.5900n 0.002395 194.6000n 0.002406 194.6100n 0.002394 194.6200n 0.002358 194.6300n 0.002302 194.6400n 0.002226 194.6500n 0.002134 194.6600n 0.002028 194.6700n 0.001908 194.6800n 0.001778 194.6900n 0.001639
+ 194.7000n 0.001492 194.7100n 0.001339 194.7200n 0.001182 194.7300n 0.001022 194.7400n 0.000859 194.7500n 0.000694 194.7600n 0.000528 194.7700n 0.000360 194.7800n 0.000193 194.7900n 0.000025 194.8000n -0.000143 194.8100n -0.000311 194.8200n -0.000480 194.8300n -0.000647 194.8400n -0.000815
+ 194.8500n -0.000981 194.8600n -0.001146 194.8700n -0.001309 194.8800n -0.001469 194.8900n -0.001626 194.9000n -0.001778 194.9100n -0.001924 194.9200n -0.002063 194.9300n -0.002193 194.9400n -0.002314 194.9500n -0.002423 194.9600n -0.002519 194.9700n -0.002600 194.9800n -0.002666 194.9900n -0.002715
+ 195.0000n -0.002747 195.0100n -0.002759 195.0200n -0.002753 195.0300n -0.002727 195.0400n -0.002682 195.0500n -0.002618 195.0600n -0.002536 195.0700n -0.002437 195.0800n -0.002323 195.0900n -0.002195 195.1000n -0.002056 195.1100n -0.001908 195.1200n -0.001753 195.1300n -0.001596 195.1400n -0.001438
+ 195.1500n -0.001283 195.1600n -0.001133 195.1700n -0.000993 195.1800n -0.000865 195.1900n -0.000751 195.2000n -0.000654 195.2100n -0.000577 195.2200n -0.000520 195.2300n -0.000487 195.2400n -0.000476 195.2500n -0.000490 195.2600n -0.000527 195.2700n -0.000587 195.2800n -0.000669 195.2900n -0.000771
+ 195.3000n -0.000891 195.3100n -0.001026 195.3200n -0.001173 195.3300n -0.001329 195.3400n -0.001490 195.3500n -0.001651 195.3600n -0.001809 195.3700n -0.001960 195.3800n -0.002099 195.3900n -0.002222 195.4000n -0.002326 195.4100n -0.002407 195.4200n -0.002461 195.4300n -0.002487 195.4400n -0.002482
+ 195.4500n -0.002444 195.4600n -0.002373 195.4700n -0.002268 195.4800n -0.002129 195.4900n -0.001957 195.5000n -0.001755 195.5100n -0.001524 195.5200n -0.001267 195.5300n -0.000988 195.5400n -0.000691 195.5500n -0.000379 195.5600n -0.000059 195.5700n 0.000266 195.5800n 0.000590 195.5900n 0.000908
+ 195.6000n 0.001215 195.6100n 0.001505 195.6200n 0.001775 195.6300n 0.002019 195.6400n 0.002234 195.6500n 0.002416 195.6600n 0.002562 195.6700n 0.002671 195.6800n 0.002739 195.6900n 0.002767 195.7000n 0.002753 195.7100n 0.002699 195.7200n 0.002605 195.7300n 0.002474 195.7400n 0.002307
+ 195.7500n 0.002109 195.7600n 0.001881 195.7700n 0.001629 195.7800n 0.001356 195.7900n 0.001067 195.8000n 0.000767 195.8100n 0.000461 195.8200n 0.000154 195.8300n -0.000150 195.8400n -0.000446 195.8500n -0.000730 195.8600n -0.000997 195.8700n -0.001244 195.8800n -0.001468 195.8900n -0.001666
+ 195.9000n -0.001836 195.9100n -0.001977 195.9200n -0.002088 195.9300n -0.002168 195.9400n -0.002217 195.9500n -0.002237 195.9600n -0.002228 195.9700n -0.002192 195.9800n -0.002132 195.9900n -0.002049 196.0000n -0.001947 196.0100n -0.001828 196.0200n -0.001695 196.0300n -0.001552 196.0400n -0.001401
+ 196.0500n -0.001246 196.0600n -0.001089 196.0700n -0.000933 196.0800n -0.000782 196.0900n -0.000636 196.1000n -0.000498 196.1100n -0.000369 196.1200n -0.000252 196.1300n -0.000146 196.1400n -0.000052 196.1500n 0.000030 196.1600n 0.000099 196.1700n 0.000156 196.1800n 0.000202 196.1900n 0.000237
+ 196.2000n 0.000262 196.2100n 0.000280 196.2200n 0.000289 196.2300n 0.000293 196.2400n 0.000291 196.2500n 0.000286 196.2600n 0.000278 196.2700n 0.000268 196.2800n 0.000257 196.2900n 0.000246 196.3000n 0.000234 196.3100n 0.000223 196.3200n 0.000213 196.3300n 0.000202 196.3400n 0.000192
+ 196.3500n 0.000181 196.3600n 0.000170 196.3700n 0.000157 196.3800n 0.000143 196.3900n 0.000125 196.4000n 0.000105 196.4100n 0.000081 196.4200n 0.000053 196.4300n 0.000021 196.4400n -0.000016 196.4500n -0.000057 196.4600n -0.000102 196.4700n -0.000152 196.4800n -0.000204 196.4900n -0.000259
+ 196.5000n -0.000315 196.5100n -0.000372 196.5200n -0.000427 196.5300n -0.000480 196.5400n -0.000528 196.5500n -0.000571 196.5600n -0.000606 196.5700n -0.000633 196.5800n -0.000649 196.5900n -0.000653 196.6000n -0.000644 196.6100n -0.000622 196.6200n -0.000585 196.6300n -0.000533 196.6400n -0.000466
+ 196.6500n -0.000384 196.6600n -0.000288 196.6700n -0.000179 196.6800n -0.000057 196.6900n 0.000074 196.7000n 0.000215 196.7100n 0.000361 196.7200n 0.000512 196.7300n 0.000664 196.7400n 0.000815 196.7500n 0.000962 196.7600n 0.001101 196.7700n 0.001232 196.7800n 0.001350 196.7900n 0.001453
+ 196.8000n 0.001540 196.8100n 0.001608 196.8200n 0.001655 196.8300n 0.001681 196.8400n 0.001685 196.8500n 0.001666 196.8600n 0.001624 196.8700n 0.001560 196.8800n 0.001476 196.8900n 0.001372 196.9000n 0.001250 196.9100n 0.001113 196.9200n 0.000964 196.9300n 0.000805 196.9400n 0.000640
+ 196.9500n 0.000472 196.9600n 0.000304 196.9700n 0.000140 196.9800n -0.000017 196.9900n -0.000164 197.0000n -0.000297 197.0100n -0.000413 197.0200n -0.000511 197.0300n -0.000588 197.0400n -0.000643 197.0500n -0.000673 197.0600n -0.000680 197.0700n -0.000661 197.0800n -0.000619 197.0900n -0.000553
+ 197.1000n -0.000465 197.1100n -0.000357 197.1200n -0.000232 197.1300n -0.000090 197.1400n 0.000063 197.1500n 0.000226 197.1600n 0.000396 197.1700n 0.000567 197.1800n 0.000738 197.1900n 0.000905 197.2000n 0.001064 197.2100n 0.001213 197.2200n 0.001348 197.2300n 0.001469 197.2400n 0.001571
+ 197.2500n 0.001655 197.2600n 0.001719 197.2700n 0.001762 197.2800n 0.001784 197.2900n 0.001786 197.3000n 0.001769 197.3100n 0.001734 197.3200n 0.001683 197.3300n 0.001618 197.3400n 0.001542 197.3500n 0.001457 197.3600n 0.001367 197.3700n 0.001274 197.3800n 0.001182 197.3900n 0.001094
+ 197.4000n 0.001012 197.4100n 0.000941 197.4200n 0.000881 197.4300n 0.000836 197.4400n 0.000807 197.4500n 0.000796 197.4600n 0.000803 197.4700n 0.000829 197.4800n 0.000874 197.4900n 0.000937 197.5000n 0.001017 197.5100n 0.001114 197.5200n 0.001223 197.5300n 0.001344 197.5400n 0.001474
+ 197.5500n 0.001609 197.5600n 0.001746 197.5700n 0.001883 197.5800n 0.002015 197.5900n 0.002139 197.6000n 0.002252 197.6100n 0.002350 197.6200n 0.002432 197.6300n 0.002493 197.6400n 0.002533 197.6500n 0.002549 197.6600n 0.002541 197.6700n 0.002506 197.6800n 0.002445 197.6900n 0.002359
+ 197.7000n 0.002247 197.7100n 0.002112 197.7200n 0.001954 197.7300n 0.001775 197.7400n 0.001579 197.7500n 0.001368 197.7600n 0.001145 197.7700n 0.000913 197.7800n 0.000675 197.7900n 0.000435 197.8000n 0.000196 197.8100n -0.000039 197.8200n -0.000267 197.8300n -0.000485 197.8400n -0.000692
+ 197.8500n -0.000885 197.8600n -0.001062 197.8700n -0.001223 197.8800n -0.001366 197.8900n -0.001492 197.9000n -0.001601 197.9100n -0.001693 197.9200n -0.001769 197.9300n -0.001832 197.9400n -0.001881 197.9500n -0.001921 197.9600n -0.001952 197.9700n -0.001977 197.9800n -0.001999 197.9900n -0.002019
+ 198.0000n -0.002040 198.0100n -0.002065 198.0200n -0.002095 198.0300n -0.002131 198.0400n -0.002175 198.0500n -0.002228 198.0600n -0.002291 198.0700n -0.002362 198.0800n -0.002443 198.0900n -0.002531 198.1000n -0.002627 198.1100n -0.002727 198.1200n -0.002830 198.1300n -0.002934 198.1400n -0.003036
+ 198.1500n -0.003133 198.1600n -0.003222 198.1700n -0.003299 198.1800n -0.003363 198.1900n -0.003409 198.2000n -0.003436 198.2100n -0.003439 198.2200n -0.003418 198.2300n -0.003370 198.2400n -0.003294 198.2500n -0.003189 198.2600n -0.003055 198.2700n -0.002891 198.2800n -0.002699 198.2900n -0.002479
+ 198.3000n -0.002234 198.3100n -0.001965 198.3200n -0.001676 198.3300n -0.001371 198.3400n -0.001052 198.3500n -0.000723 198.3600n -0.000390 198.3700n -0.000056 198.3800n 0.000274 198.3900n 0.000596 198.4000n 0.000906 198.4100n 0.001198 198.4200n 0.001469 198.4300n 0.001717 198.4400n 0.001937
+ 198.4500n 0.002126 198.4600n 0.002284 198.4700n 0.002407 198.4800n 0.002496 198.4900n 0.002550 198.5000n 0.002569 198.5100n 0.002554 198.5200n 0.002507 198.5300n 0.002429 198.5400n 0.002323 198.5500n 0.002192 198.5600n 0.002040 198.5700n 0.001869 198.5800n 0.001684 198.5900n 0.001489
+ 198.6000n 0.001288 198.6100n 0.001084 198.6200n 0.000882 198.6300n 0.000685 198.6400n 0.000496 198.6500n 0.000319 198.6600n 0.000157 198.6700n 0.000011 198.6800n -0.000117 198.6900n -0.000225 198.7000n -0.000312 198.7100n -0.000379 198.7200n -0.000426 198.7300n -0.000453 198.7400n -0.000462
+ 198.7500n -0.000454 198.7600n -0.000430 198.7700n -0.000394 198.7800n -0.000348 198.7900n -0.000294 198.8000n -0.000234 198.8100n -0.000172 198.8200n -0.000110 198.8300n -0.000050 198.8400n 0.000005 198.8500n 0.000053 198.8600n 0.000094 198.8700n 0.000124 198.8800n 0.000144 198.8900n 0.000153
+ 198.9000n 0.000151 198.9100n 0.000137 198.9200n 0.000113 198.9300n 0.000079 198.9400n 0.000038 198.9500n -0.000011 198.9600n -0.000064 198.9700n -0.000120 198.9800n -0.000176 198.9900n -0.000231 199.0000n -0.000282 199.0100n -0.000326 199.0200n -0.000363 199.0300n -0.000389 199.0400n -0.000404
+ 199.0500n -0.000406 199.0600n -0.000393 199.0700n -0.000366 199.0800n -0.000324 199.0900n -0.000267 199.1000n -0.000195 199.1100n -0.000109 199.1200n -0.000011 199.1300n 0.000098 199.1400n 0.000216 199.1500n 0.000342 199.1600n 0.000472 199.1700n 0.000604 199.1800n 0.000737 199.1900n 0.000866
+ 199.2000n 0.000991 199.2100n 0.001108 199.2200n 0.001216 199.2300n 0.001312 199.2400n 0.001395 199.2500n 0.001463 199.2600n 0.001516 199.2700n 0.001553 199.2800n 0.001574 199.2900n 0.001579 199.3000n 0.001568 199.3100n 0.001544 199.3200n 0.001507 199.3300n 0.001459 199.3400n 0.001402
+ 199.3500n 0.001340 199.3600n 0.001273 199.3700n 0.001206 199.3800n 0.001140 199.3900n 0.001078 199.4000n 0.001024 199.4100n 0.000979 199.4200n 0.000947 199.4300n 0.000928 199.4400n 0.000925 199.4500n 0.000938 199.4600n 0.000970 199.4700n 0.001019 199.4800n 0.001087 199.4900n 0.001172
+ 199.5000n 0.001273 199.5100n 0.001390 199.5200n 0.001519 199.5300n 0.001659 199.5400n 0.001807 199.5500n 0.001959 199.5600n 0.002113 199.5700n 0.002265 199.5800n 0.002412 199.5900n 0.002549 199.6000n 0.002674 199.6100n 0.002783 199.6200n 0.002874 199.6300n 0.002942 199.6400n 0.002986
+ 199.6500n 0.003004 199.6600n 0.002994 199.6700n 0.002955 199.6800n 0.002886 199.6900n 0.002789 199.7000n 0.002662 199.7100n 0.002509 199.7200n 0.002329 199.7300n 0.002127 199.7400n 0.001903 199.7500n 0.001663 199.7600n 0.001409 199.7700n 0.001145 199.7800n 0.000875 199.7900n 0.000604
+ 199.8000n 0.000336 199.8100n 0.000075 199.8200n -0.000175 199.8300n -0.000410 199.8400n -0.000625 199.8500n -0.000819 199.8600n -0.000987 199.8700n -0.001128 199.8800n -0.001240 199.8900n -0.001320 199.9000n -0.001370 199.9100n -0.001388 199.9200n -0.001376 199.9300n -0.001333 199.9400n -0.001263
+ 199.9500n -0.001167 199.9600n -0.001047 199.9700n -0.000909 199.9800n -0.000753 199.9900n -0.000585 200.0000n -0.000409 200.0100n -0.000229 200.0200n -0.000048 200.0300n 0.000128 200.0400n 0.000296 200.0500n 0.000452 200.0600n 0.000592 200.0700n 0.000714 200.0800n 0.000814 200.0900n 0.000889
+ 200.1000n 0.000939 200.1100n 0.000963 200.1200n 0.000958 200.1300n 0.000925 200.1400n 0.000866 200.1500n 0.000780 200.1600n 0.000669 200.1700n 0.000536 200.1800n 0.000382 200.1900n 0.000212 200.2000n 0.000027 200.2100n -0.000167 200.2200n -0.000369 200.2300n -0.000572 200.2400n -0.000775
+ 200.2500n -0.000972 200.2600n -0.001160 200.2700n -0.001335 200.2800n -0.001495 200.2900n -0.001635 200.3000n -0.001754 200.3100n -0.001848 200.3200n -0.001917 200.3300n -0.001959 200.3400n -0.001972 200.3500n -0.001958 200.3600n -0.001916 200.3700n -0.001846 200.3800n -0.001750 200.3900n -0.001631
+ 200.4000n -0.001489 200.4100n -0.001327 200.4200n -0.001149 200.4300n -0.000957 200.4400n -0.000755 200.4500n -0.000545 200.4600n -0.000333 200.4700n -0.000120 200.4800n 0.000088 200.4900n 0.000290 200.5000n 0.000481 200.5100n 0.000659 200.5200n 0.000821 200.5300n 0.000964 200.5400n 0.001087
+ 200.5500n 0.001187 200.5600n 0.001264 200.5700n 0.001316 200.5800n 0.001344 200.5900n 0.001347 200.6000n 0.001326 200.6100n 0.001281 200.6200n 0.001214 200.6300n 0.001126 200.6400n 0.001020 200.6500n 0.000896 200.6600n 0.000759 200.6700n 0.000610 200.6800n 0.000452 200.6900n 0.000287
+ 200.7000n 0.000120 200.7100n -0.000048 200.7200n -0.000213 200.7300n -0.000373 200.7400n -0.000526 200.7500n -0.000668 200.7600n -0.000797 200.7700n -0.000913 200.7800n -0.001012 200.7900n -0.001094 200.8000n -0.001158 200.8100n -0.001202 200.8200n -0.001227 200.8300n -0.001232 200.8400n -0.001217
+ 200.8500n -0.001183 200.8600n -0.001131 200.8700n -0.001062 200.8800n -0.000977 200.8900n -0.000877 200.9000n -0.000766 200.9100n -0.000643 200.9200n -0.000512 200.9300n -0.000375 200.9400n -0.000233 200.9500n -0.000089 200.9600n 0.000054 200.9700n 0.000195 200.9800n 0.000332 200.9900n 0.000462
+ 201.0000n 0.000584 201.0100n 0.000696 201.0200n 0.000797 201.0300n 0.000885 201.0400n 0.000959 201.0500n 0.001019 201.0600n 0.001064 201.0700n 0.001095 201.0800n 0.001110 201.0900n 0.001111 201.1000n 0.001098 201.1100n 0.001072 201.1200n 0.001034 201.1300n 0.000985 201.1400n 0.000927
+ 201.1500n 0.000861 201.1600n 0.000790 201.1700n 0.000715 201.1800n 0.000638 201.1900n 0.000561 201.2000n 0.000486 201.2100n 0.000416 201.2200n 0.000351 201.2300n 0.000295 201.2400n 0.000248 201.2500n 0.000211 201.2600n 0.000187 201.2700n 0.000176 201.2800n 0.000179 201.2900n 0.000196
+ 201.3000n 0.000227 201.3100n 0.000272 201.3200n 0.000331 201.3300n 0.000403 201.3400n 0.000487 201.3500n 0.000580 201.3600n 0.000683 201.3700n 0.000792 201.3800n 0.000905 201.3900n 0.001021 201.4000n 0.001136 201.4100n 0.001249 201.4200n 0.001357 201.4300n 0.001457 201.4400n 0.001547
+ 201.4500n 0.001624 201.4600n 0.001686 201.4700n 0.001732 201.4800n 0.001759 201.4900n 0.001766 201.5000n 0.001752 201.5100n 0.001716 201.5200n 0.001658 201.5300n 0.001578 201.5400n 0.001477 201.5500n 0.001355 201.5600n 0.001215 201.5700n 0.001057 201.5800n 0.000883 201.5900n 0.000697
+ 201.6000n 0.000502 201.6100n 0.000300 201.6200n 0.000094 201.6300n -0.000111 201.6400n -0.000312 201.6500n -0.000506 201.6600n -0.000689 201.6700n -0.000857 201.6800n -0.001008 201.6900n -0.001137 201.7000n -0.001243 201.7100n -0.001322 201.7200n -0.001374 201.7300n -0.001395 201.7400n -0.001386
+ 201.7500n -0.001346 201.7600n -0.001275 201.7700n -0.001173 201.7800n -0.001042 201.7900n -0.000883 201.8000n -0.000699 201.8100n -0.000492 201.8200n -0.000266 201.8300n -0.000025 201.8400n 0.000229 201.8500n 0.000490 201.8600n 0.000754 201.8700n 0.001017 201.8800n 0.001274 201.8900n 0.001520
+ 201.9000n 0.001752 201.9100n 0.001965 201.9200n 0.002155 201.9300n 0.002318 201.9400n 0.002452 201.9500n 0.002555 201.9600n 0.002623 201.9700n 0.002656 201.9800n 0.002652 201.9900n 0.002612 202.0000n 0.002536 202.0100n 0.002424 202.0200n 0.002279 202.0300n 0.002103 202.0400n 0.001898
+ 202.0500n 0.001667 202.0600n 0.001415 202.0700n 0.001144 202.0800n 0.000860 202.0900n 0.000566 202.1000n 0.000268 202.1100n -0.000031 202.1200n -0.000326 202.1300n -0.000613 202.1400n -0.000887 202.1500n -0.001145 202.1600n -0.001384 202.1700n -0.001600 202.1800n -0.001791 202.1900n -0.001955
+ 202.2000n -0.002091 202.2100n -0.002198 202.2200n -0.002275 202.2300n -0.002322 202.2400n -0.002341 202.2500n -0.002333 202.2600n -0.002300 202.2700n -0.002242 202.2800n -0.002164 202.2900n -0.002068 202.3000n -0.001957 202.3100n -0.001834 202.3200n -0.001702 202.3300n -0.001564 202.3400n -0.001425
+ 202.3500n -0.001286 202.3600n -0.001150 202.3700n -0.001021 202.3800n -0.000900 202.3900n -0.000790 202.4000n -0.000691 202.4100n -0.000605 202.4200n -0.000533 202.4300n -0.000475 202.4400n -0.000431 202.4500n -0.000400 202.4600n -0.000381 202.4700n -0.000373 202.4800n -0.000375 202.4900n -0.000385
+ 202.5000n -0.000401 202.5100n -0.000421 202.5200n -0.000443 202.5300n -0.000465 202.5400n -0.000485 202.5500n -0.000502 202.5600n -0.000513 202.5700n -0.000517 202.5800n -0.000514 202.5900n -0.000502 202.6000n -0.000481 202.6100n -0.000450 202.6200n -0.000412 202.6300n -0.000365 202.6400n -0.000311
+ 202.6500n -0.000251 202.6600n -0.000187 202.6700n -0.000121 202.6800n -0.000054 202.6900n 0.000010 202.7000n 0.000070 202.7100n 0.000124 202.7200n 0.000169 202.7300n 0.000202 202.7400n 0.000223 202.7500n 0.000229 202.7600n 0.000219 202.7700n 0.000191 202.7800n 0.000145 202.7900n 0.000081
+ 202.8000n -0.000002 202.8100n -0.000102 202.8200n -0.000220 202.8300n -0.000353 202.8400n -0.000499 202.8500n -0.000657 202.8600n -0.000824 202.8700n -0.000997 202.8800n -0.001173 202.8900n -0.001349 202.9000n -0.001522 202.9100n -0.001687 202.9200n -0.001842 202.9300n -0.001984 202.9400n -0.002109
+ 202.9500n -0.002214 202.9600n -0.002298 202.9700n -0.002359 202.9800n -0.002394 202.9900n -0.002402 203.0000n -0.002384 203.0100n -0.002339 203.0200n -0.002267 203.0300n -0.002170 203.0400n -0.002049 203.0500n -0.001907 203.0600n -0.001745 203.0700n -0.001568 203.0800n -0.001378 203.0900n -0.001179
+ 203.1000n -0.000975 203.1100n -0.000770 203.1200n -0.000569 203.1300n -0.000374 203.1400n -0.000191 203.1500n -0.000023 203.1600n 0.000126 203.1700n 0.000253 203.1800n 0.000356 203.1900n 0.000432 203.2000n 0.000479 203.2100n 0.000497 203.2200n 0.000483 203.2300n 0.000440 203.2400n 0.000366
+ 203.2500n 0.000263 203.2600n 0.000134 203.2700n -0.000021 203.2800n -0.000198 203.2900n -0.000393 203.3000n -0.000604 203.3100n -0.000826 203.3200n -0.001056 203.3300n -0.001289 203.3400n -0.001521 203.3500n -0.001747 203.3600n -0.001964 203.3700n -0.002168 203.3800n -0.002355 203.3900n -0.002521
+ 203.4000n -0.002664 203.4100n -0.002782 203.4200n -0.002872 203.4300n -0.002933 203.4400n -0.002965 203.4500n -0.002967 203.4600n -0.002939 203.4700n -0.002882 203.4800n -0.002797 203.4900n -0.002687 203.5000n -0.002554 203.5100n -0.002400 203.5200n -0.002228 203.5300n -0.002041 203.5400n -0.001843
+ 203.5500n -0.001638 203.5600n -0.001428 203.5700n -0.001217 203.5800n -0.001010 203.5900n -0.000807 203.6000n -0.000614 203.6100n -0.000432 203.6200n -0.000264 203.6300n -0.000111 203.6400n 0.000025 203.6500n 0.000143 203.6600n 0.000242 203.6700n 0.000322 203.6800n 0.000384 203.6900n 0.000427
+ 203.7000n 0.000454 203.7100n 0.000465 203.7200n 0.000461 203.7300n 0.000446 203.7400n 0.000420 203.7500n 0.000387 203.7600n 0.000347 203.7700n 0.000305 203.7800n 0.000260 203.7900n 0.000217 203.8000n 0.000177 203.8100n 0.000140 203.8200n 0.000110 203.8300n 0.000087 203.8400n 0.000073
+ 203.8500n 0.000067 203.8600n 0.000070 203.8700n 0.000082 203.8800n 0.000103 203.8900n 0.000132 203.9000n 0.000168 203.9100n 0.000210 203.9200n 0.000258 203.9300n 0.000308 203.9400n 0.000360 203.9500n 0.000412 203.9600n 0.000463 203.9700n 0.000510 203.9800n 0.000552 203.9900n 0.000587
+ 204.0000n 0.000615 204.0100n 0.000634 204.0200n 0.000642 204.0300n 0.000640 204.0400n 0.000627 204.0500n 0.000602 204.0600n 0.000567 204.0700n 0.000520 204.0800n 0.000463 204.0900n 0.000396 204.1000n 0.000321 204.1100n 0.000239 204.1200n 0.000152 204.1300n 0.000060 204.1400n -0.000035
+ 204.1500n -0.000130 204.1600n -0.000225 204.1700n -0.000318 204.1800n -0.000407 204.1900n -0.000491 204.2000n -0.000568 204.2100n -0.000639 204.2200n -0.000701 204.2300n -0.000755 204.2400n -0.000799 204.2500n -0.000835 204.2600n -0.000862 204.2700n -0.000880 204.2800n -0.000891 204.2900n -0.000895
+ 204.3000n -0.000892 204.3100n -0.000885 204.3200n -0.000874 204.3300n -0.000861 204.3400n -0.000848 204.3500n -0.000834 204.3600n -0.000823 204.3700n -0.000815 204.3800n -0.000810 204.3900n -0.000812 204.4000n -0.000819 204.4100n -0.000832 204.4200n -0.000853 204.4300n -0.000881 204.4400n -0.000915
+ 204.4500n -0.000956 204.4600n -0.001003 204.4700n -0.001054 204.4800n -0.001110 204.4900n -0.001168 204.5000n -0.001227 204.5100n -0.001285 204.5200n -0.001341 204.5300n -0.001392 204.5400n -0.001438 204.5500n -0.001476 204.5600n -0.001505 204.5700n -0.001523 204.5800n -0.001529 204.5900n -0.001522
+ 204.6000n -0.001499 204.6100n -0.001462 204.6200n -0.001409 204.6300n -0.001340 204.6400n -0.001256 204.6500n -0.001156 204.6600n -0.001042 204.6700n -0.000915 204.6800n -0.000775 204.6900n -0.000625 204.7000n -0.000467 204.7100n -0.000302 204.7200n -0.000133 204.7300n 0.000038 204.7400n 0.000209
+ 204.7500n 0.000376 204.7600n 0.000538 204.7700n 0.000693 204.7800n 0.000837 204.7900n 0.000969 204.8000n 0.001087 204.8100n 0.001189 204.8200n 0.001274 204.8300n 0.001339 204.8400n 0.001386 204.8500n 0.001412 204.8600n 0.001417 204.8700n 0.001402 204.8800n 0.001367 204.8900n 0.001313
+ 204.9000n 0.001240 204.9100n 0.001150 204.9200n 0.001044 204.9300n 0.000924 204.9400n 0.000792 204.9500n 0.000650 204.9600n 0.000500 204.9700n 0.000345 204.9800n 0.000186 204.9900n 0.000026 205.0000n -0.000132 205.0100n -0.000287 205.0200n -0.000436 205.0300n -0.000578 205.0400n -0.000711
+ 205.0500n -0.000832 205.0600n -0.000942 205.0700n -0.001038 205.0800n -0.001120 205.0900n -0.001187 205.1000n -0.001238 205.1100n -0.001274 205.1200n -0.001294 205.1300n -0.001299 205.1400n -0.001289 205.1500n -0.001264 205.1600n -0.001226 205.1700n -0.001175 205.1800n -0.001113 205.1900n -0.001040
+ 205.2000n -0.000958 205.2100n -0.000868 205.2200n -0.000771 205.2300n -0.000669 205.2400n -0.000563 205.2500n -0.000455 205.2600n -0.000345 205.2700n -0.000234 205.2800n -0.000125 205.2900n -0.000017 205.3000n 0.000088 205.3100n 0.000189 205.3200n 0.000285 205.3300n 0.000376 205.3400n 0.000462
+ 205.3500n 0.000541 205.3600n 0.000614 205.3700n 0.000680 205.3800n 0.000739 205.3900n 0.000790 205.4000n 0.000835 205.4100n 0.000872 205.4200n 0.000902 205.4300n 0.000926 205.4400n 0.000943 205.4500n 0.000953 205.4600n 0.000957 205.4700n 0.000956 205.4800n 0.000950 205.4900n 0.000938
+ 205.5000n 0.000923 205.5100n 0.000904 205.5200n 0.000881 205.5300n 0.000856 205.5400n 0.000829 205.5500n 0.000800 205.5600n 0.000771 205.5700n 0.000741 205.5800n 0.000711 205.5900n 0.000682 205.6000n 0.000654 205.6100n 0.000628 205.6200n 0.000604 205.6300n 0.000583 205.6400n 0.000565
+ 205.6500n 0.000550 205.6600n 0.000538 205.6700n 0.000529 205.6800n 0.000524 205.6900n 0.000522 205.7000n 0.000524 205.7100n 0.000528 205.7200n 0.000535 205.7300n 0.000545 205.7400n 0.000555 205.7500n 0.000567 205.7600n 0.000580 205.7700n 0.000592 205.7800n 0.000603 205.7900n 0.000612
+ 205.8000n 0.000619 205.8100n 0.000622 205.8200n 0.000622 205.8300n 0.000616 205.8400n 0.000606 205.8500n 0.000590 205.8600n 0.000567 205.8700n 0.000538 205.8800n 0.000502 205.8900n 0.000460 205.9000n 0.000411 205.9100n 0.000355 205.9200n 0.000294 205.9300n 0.000227 205.9400n 0.000155
+ 205.9500n 0.000079 205.9600n 0.000000 205.9700n -0.000080 205.9800n -0.000161 205.9900n -0.000242 206.0000n -0.000321 206.0100n -0.000397 206.0200n -0.000469 206.0300n -0.000535 206.0400n -0.000595 206.0500n -0.000646 206.0600n -0.000689 206.0700n -0.000723 206.0800n -0.000746 206.0900n -0.000758
+ 206.1000n -0.000760 206.1100n -0.000751 206.1200n -0.000731 206.1300n -0.000701 206.1400n -0.000661 206.1500n -0.000613 206.1600n -0.000556 206.1700n -0.000494 206.1800n -0.000426 206.1900n -0.000355 206.2000n -0.000282 206.2100n -0.000210 206.2200n -0.000139 206.2300n -0.000071 206.2400n -0.000009
+ 206.2500n 0.000046 206.2600n 0.000092 206.2700n 0.000128 206.2800n 0.000153 206.2900n 0.000166 206.3000n 0.000166 206.3100n 0.000152 206.3200n 0.000124 206.3300n 0.000083 206.3400n 0.000029 206.3500n -0.000039 206.3600n -0.000117 206.3700n -0.000206 206.3800n -0.000304 206.3900n -0.000408
+ 206.4000n -0.000518 206.4100n -0.000630 206.4200n -0.000742 206.4300n -0.000853 206.4400n -0.000959 206.4500n -0.001058 206.4600n -0.001147 206.4700n -0.001225 206.4800n -0.001289 206.4900n -0.001337 206.5000n -0.001367 206.5100n -0.001378 206.5200n -0.001368 206.5300n -0.001337 206.5400n -0.001284
+ 206.5500n -0.001209 206.5600n -0.001112 206.5700n -0.000994 206.5800n -0.000855 206.5900n -0.000696 206.6000n -0.000521 206.6100n -0.000329 206.6200n -0.000124 206.6300n 0.000092 206.6400n 0.000317 206.6500n 0.000548 206.6600n 0.000781 206.6700n 0.001014 206.6800n 0.001244 206.6900n 0.001468
+ 206.7000n 0.001684 206.7100n 0.001887 206.7200n 0.002077 206.7300n 0.002249 206.7400n 0.002403 206.7500n 0.002537 206.7600n 0.002649 206.7700n 0.002737 206.7800n 0.002801 206.7900n 0.002840 206.8000n 0.002854 206.8100n 0.002844 206.8200n 0.002808 206.8300n 0.002749 206.8400n 0.002667
+ 206.8500n 0.002563 206.8600n 0.002439 206.8700n 0.002297 206.8800n 0.002138 206.8900n 0.001964 206.9000n 0.001778 206.9100n 0.001582 206.9200n 0.001377 206.9300n 0.001167 206.9400n 0.000953 206.9500n 0.000738 206.9600n 0.000524 206.9700n 0.000312 206.9800n 0.000105 206.9900n -0.000095
+ 207.0000n -0.000286 207.0100n -0.000468 207.0200n -0.000638 207.0300n -0.000796 207.0400n -0.000940 207.0500n -0.001068 207.0600n -0.001181 207.0700n -0.001277 207.0800n -0.001356 207.0900n -0.001418 207.1000n -0.001461 207.1100n -0.001486 207.1200n -0.001492 207.1300n -0.001480 207.1400n -0.001450
+ 207.1500n -0.001401 207.1600n -0.001335 207.1700n -0.001251 207.1800n -0.001151 207.1900n -0.001035 207.2000n -0.000903 207.2100n -0.000758 207.2200n -0.000599 207.2300n -0.000429 207.2400n -0.000249 207.2500n -0.000060 207.2600n 0.000136 207.2700n 0.000337 207.2800n 0.000541 207.2900n 0.000747
+ 207.3000n 0.000951 207.3100n 0.001152 207.3200n 0.001347 207.3300n 0.001535 207.3400n 0.001712 207.3500n 0.001877 207.3600n 0.002027 207.3700n 0.002161 207.3800n 0.002275 207.3900n 0.002370 207.4000n 0.002442 207.4100n 0.002491 207.4200n 0.002516 207.4300n 0.002515 207.4400n 0.002489
+ 207.4500n 0.002438 207.4600n 0.002362 207.4700n 0.002262 207.4800n 0.002138 207.4900n 0.001993 207.5000n 0.001827 207.5100n 0.001645 207.5200n 0.001447 207.5300n 0.001237 207.5400n 0.001017 207.5500n 0.000792 207.5600n 0.000564 207.5700n 0.000336 207.5800n 0.000113 207.5900n -0.000102
+ 207.6000n -0.000307 207.6100n -0.000497 207.6200n -0.000670 207.6300n -0.000823 207.6400n -0.000954 207.6500n -0.001061 207.6600n -0.001143 207.6700n -0.001198 207.6800n -0.001226 207.6900n -0.001227 207.7000n -0.001202 207.7100n -0.001151 207.7200n -0.001076 207.7300n -0.000980 207.7400n -0.000864
+ 207.7500n -0.000732 207.7600n -0.000587 207.7700n -0.000432 207.7800n -0.000271 207.7900n -0.000108 207.8000n 0.000052 207.8100n 0.000207 207.8200n 0.000352 207.8300n 0.000483 207.8400n 0.000597 207.8500n 0.000691 207.8600n 0.000761 207.8700n 0.000806 207.8800n 0.000824 207.8900n 0.000812
+ 207.9000n 0.000771 207.9100n 0.000701 207.9200n 0.000601 207.9300n 0.000473 207.9400n 0.000318 207.9500n 0.000138 207.9600n -0.000064 207.9700n -0.000285 207.9800n -0.000522 207.9900n -0.000770 208.0000n -0.001026 208.0100n -0.001286 208.0200n -0.001546 208.0300n -0.001800 208.0400n -0.002046
+ 208.0500n -0.002278 208.0600n -0.002494 208.0700n -0.002689 208.0800n -0.002861 208.0900n -0.003007 208.1000n -0.003126 208.1100n -0.003215 208.1200n -0.003274 208.1300n -0.003303 208.1400n -0.003301 208.1500n -0.003270 208.1600n -0.003211 208.1700n -0.003125 208.1800n -0.003016 208.1900n -0.002886
+ 208.2000n -0.002739 208.2100n -0.002577 208.2200n -0.002405 208.2300n -0.002227 208.2400n -0.002045 208.2500n -0.001865 208.2600n -0.001689 208.2700n -0.001522 208.2800n -0.001366 208.2900n -0.001224 208.3000n -0.001099 208.3100n -0.000993 208.3200n -0.000907 208.3300n -0.000842 208.3400n -0.000800
+ 208.3500n -0.000778 208.3600n -0.000778 208.3700n -0.000797 208.3800n -0.000835 208.3900n -0.000890 208.4000n -0.000958 208.4100n -0.001037 208.4200n -0.001125 208.4300n -0.001217 208.4400n -0.001312 208.4500n -0.001405 208.4600n -0.001494 208.4700n -0.001575 208.4800n -0.001646 208.4900n -0.001704
+ 208.5000n -0.001747 208.5100n -0.001773 208.5200n -0.001781 208.5300n -0.001769 208.5400n -0.001738 208.5500n -0.001687 208.5600n -0.001618 208.5700n -0.001530 208.5800n -0.001426 208.5900n -0.001306 208.6000n -0.001175 208.6100n -0.001033 208.6200n -0.000884 208.6300n -0.000731 208.6400n -0.000576
+ 208.6500n -0.000424 208.6600n -0.000276 208.6700n -0.000136 208.6800n -0.000007 208.6900n 0.000109 208.7000n 0.000210 208.7100n 0.000294 208.7200n 0.000359 208.7300n 0.000404 208.7400n 0.000430 208.7500n 0.000435 208.7600n 0.000420 208.7700n 0.000386 208.7800n 0.000334 208.7900n 0.000266
+ 208.8000n 0.000183 208.8100n 0.000089 208.8200n -0.000015 208.8300n -0.000125 208.8400n -0.000240 208.8500n -0.000355 208.8600n -0.000469 208.8700n -0.000578 208.8800n -0.000679 208.8900n -0.000771 208.9000n -0.000852 208.9100n -0.000918 208.9200n -0.000970 208.9300n -0.001006 208.9400n -0.001025
+ 208.9500n -0.001027 208.9600n -0.001012 208.9700n -0.000982 208.9800n -0.000937 208.9900n -0.000878 209.0000n -0.000808 209.0100n -0.000728 209.0200n -0.000641 209.0300n -0.000549 209.0400n -0.000456 209.0500n -0.000363 209.0600n -0.000273 209.0700n -0.000190 209.0800n -0.000115 209.0900n -0.000050
+ 209.1000n 0.000001 209.1100n 0.000038 209.1200n 0.000059 209.1300n 0.000063 209.1400n 0.000049 209.1500n 0.000018 209.1600n -0.000032 209.1700n -0.000098 209.1800n -0.000182 209.1900n -0.000280 209.2000n -0.000392 209.2100n -0.000516 209.2200n -0.000649 209.2300n -0.000790 209.2400n -0.000937
+ 209.2500n -0.001086 209.2600n -0.001236 209.2700n -0.001384 209.2800n -0.001527 209.2900n -0.001665 209.3000n -0.001795 209.3100n -0.001915 209.3200n -0.002025 209.3300n -0.002122 209.3400n -0.002208 209.3500n -0.002281 209.3600n -0.002341 209.3700n -0.002390 209.3800n -0.002426 209.3900n -0.002453
+ 209.4000n -0.002470 209.4100n -0.002479 209.4200n -0.002482 209.4300n -0.002480 209.4400n -0.002475 209.4500n -0.002469 209.4600n -0.002464 209.4700n -0.002460 209.4800n -0.002460 209.4900n -0.002465 209.5000n -0.002475 209.5100n -0.002491 209.5200n -0.002514 209.5300n -0.002544 209.5400n -0.002579
+ 209.5500n -0.002620 209.5600n -0.002666 209.5700n -0.002716 209.5800n -0.002767 209.5900n -0.002819 209.6000n -0.002869 209.6100n -0.002915 209.6200n -0.002955 209.6300n -0.002987 209.6400n -0.003008 209.6500n -0.003017 209.6600n -0.003012 209.6700n -0.002991 209.6800n -0.002952 209.6900n -0.002895
+ 209.7000n -0.002818 209.7100n -0.002721 209.7200n -0.002604 209.7300n -0.002467 209.7400n -0.002311 209.7500n -0.002138 209.7600n -0.001948 209.7700n -0.001744 209.7800n -0.001528 209.7900n -0.001303 209.8000n -0.001071 209.8100n -0.000836 209.8200n -0.000600 209.8300n -0.000367 209.8400n -0.000140
+ 209.8500n 0.000078 209.8600n 0.000284 209.8700n 0.000474 209.8800n 0.000648 209.8900n 0.000802 209.9000n 0.000934 209.9100n 0.001043 209.9200n 0.001129 209.9300n 0.001190 209.9400n 0.001226 209.9500n 0.001238 209.9600n 0.001226 209.9700n 0.001192 209.9800n 0.001138 209.9900n 0.001066
+ 210.0000n 0.000977 210.0100n 0.000874 210.0200n 0.000761 210.0300n 0.000641 210.0400n 0.000515 210.0500n 0.000389 210.0600n 0.000263 210.0700n 0.000143 210.0800n 0.000029 210.0900n -0.000075 210.1000n -0.000168 210.1100n -0.000246 210.1200n -0.000310 210.1300n -0.000357 210.1400n -0.000386
+ 210.1500n -0.000399 210.1600n -0.000394 210.1700n -0.000373 210.1800n -0.000335 210.1900n -0.000283 210.2000n -0.000217 210.2100n -0.000140 210.2200n -0.000054 210.2300n 0.000040 210.2400n 0.000139 210.2500n 0.000241 210.2600n 0.000344 210.2700n 0.000445 210.2800n 0.000542 210.2900n 0.000635
+ 210.3000n 0.000720 210.3100n 0.000797 210.3200n 0.000864 210.3300n 0.000921 210.3400n 0.000968 210.3500n 0.001004 210.3600n 0.001029 210.3700n 0.001044 210.3800n 0.001050 210.3900n 0.001047 210.4000n 0.001037 210.4100n 0.001022 210.4200n 0.001002 210.4300n 0.000980 210.4400n 0.000956
+ 210.4500n 0.000934 210.4600n 0.000913 210.4700n 0.000895 210.4800n 0.000882 210.4900n 0.000875 210.5000n 0.000874 210.5100n 0.000880 210.5200n 0.000892 210.5300n 0.000911 210.5400n 0.000937 210.5500n 0.000969 210.5600n 0.001005 210.5700n 0.001045 210.5800n 0.001087 210.5900n 0.001129
+ 210.6000n 0.001171 210.6100n 0.001209 210.6200n 0.001243 210.6300n 0.001270 210.6400n 0.001289 210.6500n 0.001298 210.6600n 0.001296 210.6700n 0.001281 210.6800n 0.001253 210.6900n 0.001211 210.7000n 0.001155 210.7100n 0.001084 210.7200n 0.001000 210.7300n 0.000903 210.7400n 0.000795
+ 210.7500n 0.000676 210.7600n 0.000548 210.7700n 0.000414 210.7800n 0.000276 210.7900n 0.000136 210.8000n -0.000003 210.8100n -0.000139 210.8200n -0.000270 210.8300n -0.000391 210.8400n -0.000502 210.8500n -0.000600 210.8600n -0.000683 210.8700n -0.000749 210.8800n -0.000797 210.8900n -0.000827
+ 210.9000n -0.000837 210.9100n -0.000827 210.9200n -0.000798 210.9300n -0.000751 210.9400n -0.000687 210.9500n -0.000607 210.9600n -0.000512 210.9700n -0.000407 210.9800n -0.000292 210.9900n -0.000171 211.0000n -0.000046 211.0100n 0.000080 211.0200n 0.000203 211.0300n 0.000322 211.0400n 0.000433
+ 211.0500n 0.000534 211.0600n 0.000622 211.0700n 0.000697 211.0800n 0.000755 211.0900n 0.000798 211.1000n 0.000822 211.1100n 0.000830 211.1200n 0.000820 211.1300n 0.000794 211.1400n 0.000754 211.1500n 0.000699 211.1600n 0.000634 211.1700n 0.000560 211.1800n 0.000480 211.1900n 0.000396
+ 211.2000n 0.000313 211.2100n 0.000233 211.2200n 0.000159 211.2300n 0.000094 211.2400n 0.000041 211.2500n 0.000003 211.2600n -0.000018 211.2700n -0.000021 211.2800n -0.000003 211.2900n 0.000036 211.3000n 0.000097 211.3100n 0.000179 211.3200n 0.000283 211.3300n 0.000405 211.3400n 0.000546
+ 211.3500n 0.000703 211.3600n 0.000872 211.3700n 0.001051 211.3800n 0.001236 211.3900n 0.001425 211.4000n 0.001611 211.4100n 0.001793 211.4200n 0.001965 211.4300n 0.002125 211.4400n 0.002267 211.4500n 0.002390 211.4600n 0.002489 211.4700n 0.002563 211.4800n 0.002609 211.4900n 0.002625
+ 211.5000n 0.002612 211.5100n 0.002568 211.5200n 0.002495 211.5300n 0.002392 211.5400n 0.002263 211.5500n 0.002110 211.5600n 0.001935 211.5700n 0.001742 211.5800n 0.001535 211.5900n 0.001319 211.6000n 0.001098 211.6100n 0.000877 211.6200n 0.000661 211.6300n 0.000454 211.6400n 0.000262
+ 211.6500n 0.000089 211.6600n -0.000061 211.6700n -0.000185 211.6800n -0.000279 211.6900n -0.000340 211.7000n -0.000368 211.7100n -0.000361 211.7200n -0.000319 211.7300n -0.000242 211.7400n -0.000132 211.7500n 0.000009 211.7600n 0.000178 211.7700n 0.000372 211.7800n 0.000586 211.7900n 0.000816
+ 211.8000n 0.001056 211.8100n 0.001301 211.8200n 0.001544 211.8300n 0.001781 211.8400n 0.002004 211.8500n 0.002209 211.8600n 0.002389 211.8700n 0.002539 211.8800n 0.002656 211.8900n 0.002734 211.9000n 0.002770 211.9100n 0.002761 211.9200n 0.002707 211.9300n 0.002606 211.9400n 0.002457
+ 211.9500n 0.002262 211.9600n 0.002024 211.9700n 0.001743 211.9800n 0.001425 211.9900n 0.001073 212.0000n 0.000693 212.0100n 0.000291 212.0200n -0.000128 212.0300n -0.000556 212.0400n -0.000987 212.0500n -0.001413 212.0600n -0.001828 212.0700n -0.002224 212.0800n -0.002594 212.0900n -0.002933
+ 212.1000n -0.003234 212.1100n -0.003491 212.1200n -0.003701 212.1300n -0.003860 212.1400n -0.003963 212.1500n -0.004010 212.1600n -0.003999 212.1700n -0.003930 212.1800n -0.003803 212.1900n -0.003621 212.2000n -0.003385 212.2100n -0.003100 212.2200n -0.002769 212.2300n -0.002397 212.2400n -0.001989
+ 212.2500n -0.001553 212.2600n -0.001093 212.2700n -0.000617 212.2800n -0.000131 212.2900n 0.000358 212.3000n 0.000843 212.3100n 0.001318 212.3200n 0.001776 212.3300n 0.002213 212.3400n 0.002621 212.3500n 0.002997 212.3600n 0.003337 212.3700n 0.003637 212.3800n 0.003895 212.3900n 0.004108
+ 212.4000n 0.004276 212.4100n 0.004398 212.4200n 0.004473 212.4300n 0.004504 212.4400n 0.004492 212.4500n 0.004439 212.4600n 0.004347 212.4700n 0.004221 212.4800n 0.004063 212.4900n 0.003877 212.5000n 0.003667 212.5100n 0.003439 212.5200n 0.003195 212.5300n 0.002940 212.5400n 0.002678
+ 212.5500n 0.002414 212.5600n 0.002151 212.5700n 0.001892 212.5800n 0.001641 212.5900n 0.001400 212.6000n 0.001173 212.6100n 0.000960 212.6200n 0.000764 212.6300n 0.000586 212.6400n 0.000426 212.6500n 0.000286 212.6600n 0.000165 212.6700n 0.000064 212.6800n -0.000018 212.6900n -0.000082
+ 212.7000n -0.000128 212.7100n -0.000157 212.7200n -0.000171 212.7300n -0.000170 212.7400n -0.000156 212.7500n -0.000129 212.7600n -0.000092 212.7700n -0.000044 212.7800n 0.000013 212.7900n 0.000078 212.8000n 0.000150 212.8100n 0.000229 212.8200n 0.000314 212.8300n 0.000405 212.8400n 0.000501
+ 212.8500n 0.000601 212.8600n 0.000706 212.8700n 0.000815 212.8800n 0.000928 212.8900n 0.001044 212.9000n 0.001163 212.9100n 0.001285 212.9200n 0.001410 212.9300n 0.001536 212.9400n 0.001663 212.9500n 0.001791 212.9600n 0.001918 212.9700n 0.002044 212.9800n 0.002168 212.9900n 0.002288
+ 213.0000n 0.002404 213.0100n 0.002514 213.0200n 0.002617 213.0300n 0.002711 213.0400n 0.002796 213.0500n 0.002870 213.0600n 0.002932 213.0700n 0.002981 213.0800n 0.003016 213.0900n 0.003037 213.1000n 0.003041 213.1100n 0.003030 213.1200n 0.003003 213.1300n 0.002960 213.1400n 0.002901
+ 213.1500n 0.002826 213.1600n 0.002736 213.1700n 0.002632 213.1800n 0.002515 213.1900n 0.002386 213.2000n 0.002246 213.2100n 0.002097 213.2200n 0.001941 213.2300n 0.001779 213.2400n 0.001613 213.2500n 0.001445 213.2600n 0.001276 213.2700n 0.001108 213.2800n 0.000944 213.2900n 0.000784
+ 213.3000n 0.000630 213.3100n 0.000483 213.3200n 0.000345 213.3300n 0.000217 213.3400n 0.000098 213.3500n -0.000009 213.3600n -0.000105 213.3700n -0.000190 213.3800n -0.000263 213.3900n -0.000324 213.4000n -0.000375 213.4100n -0.000414 213.4200n -0.000443 213.4300n -0.000462 213.4400n -0.000473
+ 213.4500n -0.000475 213.4600n -0.000469 213.4700n -0.000457 213.4800n -0.000439 213.4900n -0.000415 213.5000n -0.000388 213.5100n -0.000356 213.5200n -0.000321 213.5300n -0.000283 213.5400n -0.000242 213.5500n -0.000199 213.5600n -0.000154 213.5700n -0.000108 213.5800n -0.000059 213.5900n -0.000009
+ 213.6000n 0.000043 213.6100n 0.000097 213.6200n 0.000153 213.6300n 0.000211 213.6400n 0.000270 213.6500n 0.000332 213.6600n 0.000396 213.6700n 0.000462 213.6800n 0.000529 213.6900n 0.000598 213.7000n 0.000668 213.7100n 0.000738 213.7200n 0.000808 213.7300n 0.000878 213.7400n 0.000947
+ 213.7500n 0.001014 213.7600n 0.001078 213.7700n 0.001138 213.7800n 0.001195 213.7900n 0.001246 213.8000n 0.001291 213.8100n 0.001330 213.8200n 0.001361 213.8300n 0.001384 213.8400n 0.001399 213.8500n 0.001405 213.8600n 0.001403 213.8700n 0.001391 213.8800n 0.001370 213.8900n 0.001341
+ 213.9000n 0.001303 213.9100n 0.001257 213.9200n 0.001203 213.9300n 0.001143 213.9400n 0.001078 213.9500n 0.001007 213.9600n 0.000932 213.9700n 0.000855 213.9800n 0.000775 213.9900n 0.000695 214.0000n 0.000615 214.0100n 0.000536 214.0200n 0.000459 214.0300n 0.000384 214.0400n 0.000313
+ 214.0500n 0.000246 214.0600n 0.000182 214.0700n 0.000123 214.0800n 0.000068 214.0900n 0.000017 214.1000n -0.000029 214.1100n -0.000072 214.1200n -0.000112 214.1300n -0.000149 214.1400n -0.000184 214.1500n -0.000218 214.1600n -0.000251 214.1700n -0.000283 214.1800n -0.000316 214.1900n -0.000350
+ 214.2000n -0.000386 214.2100n -0.000423 214.2200n -0.000463 214.2300n -0.000504 214.2400n -0.000547 214.2500n -0.000591 214.2600n -0.000636 214.2700n -0.000682 214.2800n -0.000727 214.2900n -0.000770 214.3000n -0.000811 214.3100n -0.000847 214.3200n -0.000879 214.3300n -0.000903 214.3400n -0.000920
+ 214.3500n -0.000927 214.3600n -0.000924 214.3700n -0.000909 214.3800n -0.000881 214.3900n -0.000839 214.4000n -0.000784 214.4100n -0.000714 214.4200n -0.000631 214.4300n -0.000533 214.4400n -0.000421 214.4500n -0.000298 214.4600n -0.000163 214.4700n -0.000019 214.4800n 0.000133 214.4900n 0.000290
+ 214.5000n 0.000450 214.5100n 0.000611 214.5200n 0.000769 214.5300n 0.000922 214.5400n 0.001067 214.5500n 0.001201 214.5600n 0.001322 214.5700n 0.001426 214.5800n 0.001512 214.5900n 0.001576 214.6000n 0.001618 214.6100n 0.001636 214.6200n 0.001630 214.6300n 0.001597 214.6400n 0.001539
+ 214.6500n 0.001455 214.6600n 0.001348 214.6700n 0.001217 214.6800n 0.001066 214.6900n 0.000896 214.7000n 0.000710 214.7100n 0.000512 214.7200n 0.000305 214.7300n 0.000092 214.7400n -0.000121 214.7500n -0.000332 214.7600n -0.000535 214.7700n -0.000727 214.7800n -0.000904 214.7900n -0.001063
+ 214.8000n -0.001199 214.8100n -0.001309 214.8200n -0.001392 214.8300n -0.001444 214.8400n -0.001465 214.8500n -0.001453 214.8600n -0.001408 214.8700n -0.001329 214.8800n -0.001219 214.8900n -0.001078 214.9000n -0.000909 214.9100n -0.000713 214.9200n -0.000495 214.9300n -0.000257 214.9400n -0.000004
+ 214.9500n 0.000260 214.9600n 0.000530 214.9700n 0.000802 214.9800n 0.001072 214.9900n 0.001334 215.0000n 0.001585 215.0100n 0.001819 215.0200n 0.002034 215.0300n 0.002225 215.0400n 0.002390 215.0500n 0.002526 215.0600n 0.002632 215.0700n 0.002705 215.0800n 0.002747 215.0900n 0.002755
+ 215.1000n 0.002732 215.1100n 0.002678 215.1200n 0.002596 215.1300n 0.002488 215.1400n 0.002357 215.1500n 0.002206 215.1600n 0.002039 215.1700n 0.001860 215.1800n 0.001673 215.1900n 0.001483 215.2000n 0.001294 215.2100n 0.001109 215.2200n 0.000934 215.2300n 0.000772 215.2400n 0.000626
+ 215.2500n 0.000499 215.2600n 0.000394 215.2700n 0.000312 215.2800n 0.000255 215.2900n 0.000224 215.3000n 0.000219 215.3100n 0.000239 215.3200n 0.000284 215.3300n 0.000352 215.3400n 0.000440 215.3500n 0.000547 215.3600n 0.000669 215.3700n 0.000803 215.3800n 0.000945 215.3900n 0.001093
+ 215.4000n 0.001241 215.4100n 0.001386 215.4200n 0.001525 215.4300n 0.001653 215.4400n 0.001768 215.4500n 0.001867 215.4600n 0.001946 215.4700n 0.002005 215.4800n 0.002041 215.4900n 0.002053 215.5000n 0.002040 215.5100n 0.002002 215.5200n 0.001941 215.5300n 0.001856 215.5400n 0.001749
+ 215.5500n 0.001623 215.5600n 0.001479 215.5700n 0.001320 215.5800n 0.001150 215.5900n 0.000970 215.6000n 0.000785 215.6100n 0.000598 215.6200n 0.000412 215.6300n 0.000231 215.6400n 0.000057 215.6500n -0.000107 215.6600n -0.000257 215.6700n -0.000393 215.6800n -0.000511 215.6900n -0.000612
+ 215.7000n -0.000692 215.7100n -0.000753 215.7200n -0.000793 215.7300n -0.000813 215.7400n -0.000814 215.7500n -0.000797 215.7600n -0.000762 215.7700n -0.000712 215.7800n -0.000649 215.7900n -0.000574 215.8000n -0.000489 215.8100n -0.000398 215.8200n -0.000301 215.8300n -0.000201 215.8400n -0.000100
+ 215.8500n 0.000000 215.8600n 0.000098 215.8700n 0.000193 215.8800n 0.000283 215.8900n 0.000367 215.9000n 0.000446 215.9100n 0.000520 215.9200n 0.000587 215.9300n 0.000650 215.9400n 0.000708 215.9500n 0.000763 215.9600n 0.000816 215.9700n 0.000867 215.9800n 0.000918 215.9900n 0.000971
+ 216.0000n 0.001027 216.0100n 0.001086 216.0200n 0.001149 216.0300n 0.001218 216.0400n 0.001293 216.0500n 0.001374 216.0600n 0.001461 216.0700n 0.001553 216.0800n 0.001650 216.0900n 0.001750 216.1000n 0.001852 216.1100n 0.001955 216.1200n 0.002055 216.1300n 0.002151 216.1400n 0.002240
+ 216.1500n 0.002320 216.1600n 0.002387 216.1700n 0.002440 216.1800n 0.002474 216.1900n 0.002489 216.2000n 0.002481 216.2100n 0.002449 216.2200n 0.002391 216.2300n 0.002305 216.2400n 0.002192 216.2500n 0.002050 216.2600n 0.001880 216.2700n 0.001683 216.2800n 0.001461 216.2900n 0.001215
+ 216.3000n 0.000947 216.3100n 0.000662 216.3200n 0.000362 216.3300n 0.000052 216.3400n -0.000265 216.3500n -0.000583 216.3600n -0.000898 216.3700n -0.001205 216.3800n -0.001499 216.3900n -0.001776 216.4000n -0.002030 216.4100n -0.002258 216.4200n -0.002455 216.4300n -0.002618 216.4400n -0.002745
+ 216.4500n -0.002832 216.4600n -0.002879 216.4700n -0.002884 216.4800n -0.002847 216.4900n -0.002769 216.5000n -0.002652 216.5100n -0.002497 216.5200n -0.002307 216.5300n -0.002085 216.5400n -0.001836 216.5500n -0.001564 216.5600n -0.001274 216.5700n -0.000971 216.5800n -0.000662 216.5900n -0.000351
+ 216.6000n -0.000044 216.6100n 0.000253 216.6200n 0.000534 216.6300n 0.000795 216.6400n 0.001031 216.6500n 0.001238 216.6600n 0.001412 216.6700n 0.001551 216.6800n 0.001651 216.6900n 0.001713 216.7000n 0.001734 216.7100n 0.001715 216.7200n 0.001657 216.7300n 0.001562 216.7400n 0.001431
+ 216.7500n 0.001268 216.7600n 0.001076 216.7700n 0.000860 216.7800n 0.000623 216.7900n 0.000370 216.8000n 0.000107 216.8100n -0.000162 216.8200n -0.000431 216.8300n -0.000696 216.8400n -0.000951 216.8500n -0.001193 216.8600n -0.001417 216.8700n -0.001620 216.8800n -0.001799 216.8900n -0.001950
+ 216.9000n -0.002073 216.9100n -0.002166 216.9200n -0.002229 216.9300n -0.002261 216.9400n -0.002265 216.9500n -0.002240 216.9600n -0.002189 216.9700n -0.002115 216.9800n -0.002020 216.9900n -0.001908 217.0000n -0.001782 217.0100n -0.001645 217.0200n -0.001503 217.0300n -0.001357 217.0400n -0.001213
+ 217.0500n -0.001073 217.0600n -0.000941 217.0700n -0.000820 217.0800n -0.000711 217.0900n -0.000617 217.1000n -0.000540 217.1100n -0.000480 217.1200n -0.000437 217.1300n -0.000412 217.1400n -0.000404 217.1500n -0.000412 217.1600n -0.000433 217.1700n -0.000467 217.1800n -0.000510 217.1900n -0.000560
+ 217.2000n -0.000613 217.2100n -0.000668 217.2200n -0.000721 217.2300n -0.000768 217.2400n -0.000807 217.2500n -0.000836 217.2600n -0.000851 217.2700n -0.000852 217.2800n -0.000835 217.2900n -0.000801 217.3000n -0.000748 217.3100n -0.000676 217.3200n -0.000586 217.3300n -0.000478 217.3400n -0.000354
+ 217.3500n -0.000216 217.3600n -0.000066 217.3700n 0.000094 217.3800n 0.000260 217.3900n 0.000428 217.4000n 0.000597 217.4100n 0.000761 217.4200n 0.000919 217.4300n 0.001065 217.4400n 0.001197 217.4500n 0.001312 217.4600n 0.001406 217.4700n 0.001479 217.4800n 0.001528 217.4900n 0.001551
+ 217.5000n 0.001548 217.5100n 0.001518 217.5200n 0.001462 217.5300n 0.001381 217.5400n 0.001276 217.5500n 0.001150 217.5600n 0.001004 217.5700n 0.000842 217.5800n 0.000668 217.5900n 0.000484 217.6000n 0.000295 217.6100n 0.000105 217.6200n -0.000082 217.6300n -0.000262 217.6400n -0.000432
+ 217.6500n -0.000587 217.6600n -0.000723 217.6700n -0.000839 217.6800n -0.000932 217.6900n -0.000999 217.7000n -0.001039 217.7100n -0.001051 217.7200n -0.001036 217.7300n -0.000993 217.7400n -0.000924 217.7500n -0.000830 217.7600n -0.000714 217.7700n -0.000579 217.7800n -0.000428 217.7900n -0.000265
+ 217.8000n -0.000094 217.8100n 0.000081 217.8200n 0.000255 217.8300n 0.000423 217.8400n 0.000581 217.8500n 0.000724 217.8600n 0.000849 217.8700n 0.000951 217.8800n 0.001026 217.8900n 0.001073 217.9000n 0.001087 217.9100n 0.001069 217.9200n 0.001016 217.9300n 0.000927 217.9400n 0.000804
+ 217.9500n 0.000647 217.9600n 0.000458 217.9700n 0.000239 217.9800n -0.000007 217.9900n -0.000276 218.0000n -0.000564 218.0100n -0.000868 218.0200n -0.001181 218.0300n -0.001499 218.0400n -0.001816 218.0500n -0.002128 218.0600n -0.002428 218.0700n -0.002713 218.0800n -0.002975 218.0900n -0.003212
+ 218.1000n -0.003419 218.1100n -0.003592 218.1200n -0.003728 218.1300n -0.003824 218.1400n -0.003879 218.1500n -0.003891 218.1600n -0.003860 218.1700n -0.003787 218.1800n -0.003671 218.1900n -0.003515 218.2000n -0.003322 218.2100n -0.003093 218.2200n -0.002833 218.2300n -0.002545 218.2400n -0.002234
+ 218.2500n -0.001905 218.2600n -0.001562 218.2700n -0.001210 218.2800n -0.000855 218.2900n -0.000502 218.3000n -0.000156 218.3100n 0.000179 218.3200n 0.000498 218.3300n 0.000798 218.3400n 0.001073 218.3500n 0.001322 218.3600n 0.001541 218.3700n 0.001728 218.3800n 0.001882 218.3900n 0.002003
+ 218.4000n 0.002088 218.4100n 0.002140 218.4200n 0.002159 218.4300n 0.002146 218.4400n 0.002103 218.4500n 0.002032 218.4600n 0.001937 218.4700n 0.001820 218.4800n 0.001684 218.4900n 0.001534 218.5000n 0.001372 218.5100n 0.001203 218.5200n 0.001029 218.5300n 0.000856 218.5400n 0.000685
+ 218.5500n 0.000520 218.5600n 0.000365 218.5700n 0.000221 218.5800n 0.000091 218.5900n -0.000023 218.6000n -0.000120 218.6100n -0.000198 218.6200n -0.000259 218.6300n -0.000300 218.6400n -0.000323 218.6500n -0.000328 218.6600n -0.000316 218.6700n -0.000290 218.6800n -0.000250 218.6900n -0.000198
+ 218.7000n -0.000138 218.7100n -0.000070 218.7200n 0.000002 218.7300n 0.000075 218.7400n 0.000147 218.7500n 0.000217 218.7600n 0.000280 218.7700n 0.000335 218.7800n 0.000380 218.7900n 0.000414 218.8000n 0.000434 218.8100n 0.000439 218.8200n 0.000429 218.8300n 0.000403 218.8400n 0.000360
+ 218.8500n 0.000301 218.8600n 0.000227 218.8700n 0.000138 218.8800n 0.000036 218.8900n -0.000078 218.9000n -0.000202 218.9100n -0.000335 218.9200n -0.000473 218.9300n -0.000614 218.9400n -0.000757 218.9500n -0.000897 218.9600n -0.001032 218.9700n -0.001160 218.9800n -0.001278 218.9900n -0.001383
+ 219.0000n -0.001474 219.0100n -0.001547 219.0200n -0.001601 219.0300n -0.001633 219.0400n -0.001644 219.0500n -0.001631 219.0600n -0.001594 219.0700n -0.001533 219.0800n -0.001447 219.0900n -0.001337 219.1000n -0.001203 219.1100n -0.001048 219.1200n -0.000872 219.1300n -0.000677 219.1400n -0.000466
+ 219.1500n -0.000241 219.1600n -0.000005 219.1700n 0.000239 219.1800n 0.000488 219.1900n 0.000739 219.2000n 0.000989 219.2100n 0.001233 219.2200n 0.001469 219.2300n 0.001693 219.2400n 0.001902 219.2500n 0.002094 219.2600n 0.002265 219.2700n 0.002412 219.2800n 0.002534 219.2900n 0.002629
+ 219.3000n 0.002695 219.3100n 0.002731 219.3200n 0.002737 219.3300n 0.002712 219.3400n 0.002656 219.3500n 0.002571 219.3600n 0.002457 219.3700n 0.002316 219.3800n 0.002149 219.3900n 0.001960 219.4000n 0.001750 219.4100n 0.001523 219.4200n 0.001281 219.4300n 0.001029 219.4400n 0.000769
+ 219.4500n 0.000506 219.4600n 0.000243 219.4700n -0.000017 219.4800n -0.000269 219.4900n -0.000510 219.5000n -0.000738 219.5100n -0.000948 219.5200n -0.001139 219.5300n -0.001308 219.5400n -0.001453 219.5500n -0.001572 219.5600n -0.001664 219.5700n -0.001729 219.5800n -0.001765 219.5900n -0.001774
+ 219.6000n -0.001756 219.6100n -0.001712 219.6200n -0.001642 219.6300n -0.001550 219.6400n -0.001437 219.6500n -0.001306 219.6600n -0.001159 219.6700n -0.000999 219.6800n -0.000829 219.6900n -0.000653 219.7000n -0.000473 219.7100n -0.000293 219.7200n -0.000115 219.7300n 0.000058 219.7400n 0.000222
+ 219.7500n 0.000376 219.7600n 0.000517 219.7700n 0.000644 219.7800n 0.000755 219.7900n 0.000848 219.8000n 0.000924 219.8100n 0.000981 219.8200n 0.001020 219.8300n 0.001041 219.8400n 0.001045 219.8500n 0.001033 219.8600n 0.001005 219.8700n 0.000964 219.8800n 0.000912 219.8900n 0.000850
+ 219.9000n 0.000780 219.9100n 0.000704 219.9200n 0.000626 219.9300n 0.000545 219.9400n 0.000466 219.9500n 0.000388 219.9600n 0.000315 219.9700n 0.000248 219.9800n 0.000187 219.9900n 0.000134 220.0000n 0.000089 220.0100n 0.000053 220.0200n 0.000026 220.0300n 0.000007 220.0400n -0.000004
+ 220.0500n -0.000008 220.0600n -0.000006 220.0700n 0.000001 220.0800n 0.000011 220.0900n 0.000023 220.1000n 0.000035 220.1100n 0.000046 220.1200n 0.000053 220.1300n 0.000056 220.1400n 0.000052 220.1500n 0.000041 220.1600n 0.000021 220.1700n -0.000009 220.1800n -0.000049 220.1900n -0.000100
+ 220.2000n -0.000162 220.2100n -0.000234 220.2200n -0.000315 220.2300n -0.000406 220.2400n -0.000504 220.2500n -0.000607 220.2600n -0.000715 220.2700n -0.000825 220.2800n -0.000935 220.2900n -0.001043 220.3000n -0.001145 220.3100n -0.001239 220.3200n -0.001324 220.3300n -0.001396 220.3400n -0.001453
+ 220.3500n -0.001493 220.3600n -0.001514 220.3700n -0.001515 220.3800n -0.001493 220.3900n -0.001449 220.4000n -0.001382 220.4100n -0.001291 220.4200n -0.001177 220.4300n -0.001040 220.4400n -0.000882 220.4500n -0.000705 220.4600n -0.000509 220.4700n -0.000297 220.4800n -0.000072 220.4900n 0.000163
+ 220.5000n 0.000405 220.5100n 0.000652 220.5200n 0.000899 220.5300n 0.001143 220.5400n 0.001382 220.5500n 0.001610 220.5600n 0.001826 220.5700n 0.002027 220.5800n 0.002209 220.5900n 0.002370 220.6000n 0.002508 220.6100n 0.002622 220.6200n 0.002709 220.6300n 0.002768 220.6400n 0.002800
+ 220.6500n 0.002804 220.6600n 0.002781 220.6700n 0.002730 220.6800n 0.002654 220.6900n 0.002553 220.7000n 0.002430 220.7100n 0.002286 220.7200n 0.002124 220.7300n 0.001946 220.7400n 0.001755 220.7500n 0.001555 220.7600n 0.001346 220.7700n 0.001133 220.7800n 0.000918 220.7900n 0.000704
+ 220.8000n 0.000493 220.8100n 0.000287 220.8200n 0.000089 220.8300n -0.000100 220.8400n -0.000278 220.8500n -0.000444 220.8600n -0.000596 220.8700n -0.000735 220.8800n -0.000859 220.8900n -0.000969 220.9000n -0.001065 220.9100n -0.001146 220.9200n -0.001214 220.9300n -0.001268 220.9400n -0.001311
+ 220.9500n -0.001342 220.9600n -0.001363 220.9700n -0.001374 220.9800n -0.001377 220.9900n -0.001372 221.0000n -0.001361 221.0100n -0.001344 221.0200n -0.001322 221.0300n -0.001295 221.0400n -0.001265 221.0500n -0.001231 221.0600n -0.001193 221.0700n -0.001152 221.0800n -0.001107 221.0900n -0.001059
+ 221.1000n -0.001008 221.1100n -0.000952 221.1200n -0.000892 221.1300n -0.000828 221.1400n -0.000760 221.1500n -0.000686 221.1600n -0.000607 221.1700n -0.000524 221.1800n -0.000435 221.1900n -0.000342 221.2000n -0.000245 221.2100n -0.000143 221.2200n -0.000038 221.2300n 0.000069 221.2400n 0.000177
+ 221.2500n 0.000285 221.2600n 0.000393 221.2700n 0.000498 221.2800n 0.000600 221.2900n 0.000696 221.3000n 0.000786 221.3100n 0.000868 221.3200n 0.000940 221.3300n 0.001000 221.3400n 0.001049 221.3500n 0.001085 221.3600n 0.001106 221.3700n 0.001113 221.3800n 0.001104 221.3900n 0.001079
+ 221.4000n 0.001040 221.4100n 0.000985 221.4200n 0.000915 221.4300n 0.000832 221.4400n 0.000736 221.4500n 0.000629 221.4600n 0.000513 221.4700n 0.000389 221.4800n 0.000259 221.4900n 0.000125 221.5000n -0.000011 221.5100n -0.000145 221.5200n -0.000277 221.5300n -0.000404 221.5400n -0.000524
+ 221.5500n -0.000635 221.5600n -0.000735 221.5700n -0.000823 221.5800n -0.000897 221.5900n -0.000957 221.6000n -0.001001 221.6100n -0.001029 221.6200n -0.001041 221.6300n -0.001037 221.6400n -0.001017 221.6500n -0.000983 221.6600n -0.000936 221.6700n -0.000876 221.6800n -0.000806 221.6900n -0.000727
+ 221.7000n -0.000640 221.7100n -0.000549 221.7200n -0.000455 221.7300n -0.000361 221.7400n -0.000268 221.7500n -0.000178 221.7600n -0.000094 221.7700n -0.000017 221.7800n 0.000051 221.7900n 0.000109 221.8000n 0.000156 221.8100n 0.000190 221.8200n 0.000212 221.8300n 0.000221 221.8400n 0.000217
+ 221.8500n 0.000201 221.8600n 0.000173 221.8700n 0.000133 221.8800n 0.000084 221.8900n 0.000026 221.9000n -0.000038 221.9100n -0.000108 221.9200n -0.000182 221.9300n -0.000257 221.9400n -0.000332 221.9500n -0.000405 221.9600n -0.000475 221.9700n -0.000538 221.9800n -0.000595 221.9900n -0.000643
+ 222.0000n -0.000682 222.0100n -0.000710 222.0200n -0.000728 222.0300n -0.000734 222.0400n -0.000728 222.0500n -0.000711 222.0600n -0.000682 222.0700n -0.000644 222.0800n -0.000595 222.0900n -0.000539 222.1000n -0.000475 222.1100n -0.000406 222.1200n -0.000332 222.1300n -0.000256 222.1400n -0.000180
+ 222.1500n -0.000104 222.1600n -0.000031 222.1700n 0.000037 222.1800n 0.000100 222.1900n 0.000156 222.2000n 0.000203 222.2100n 0.000241 222.2200n 0.000268 222.2300n 0.000285 222.2400n 0.000290 222.2500n 0.000284 222.2600n 0.000266 222.2700n 0.000238 222.2800n 0.000199 222.2900n 0.000151
+ 222.3000n 0.000093 222.3100n 0.000028 222.3200n -0.000043 222.3300n -0.000120 222.3400n -0.000200 222.3500n -0.000283 222.3600n -0.000367 222.3700n -0.000450 222.3800n -0.000531 222.3900n -0.000609 222.4000n -0.000683 222.4100n -0.000752 222.4200n -0.000814 222.4300n -0.000869 222.4400n -0.000916
+ 222.4500n -0.000956 222.4600n -0.000987 222.4700n -0.001011 222.4800n -0.001026 222.4900n -0.001034 222.5000n -0.001034 222.5100n -0.001028 222.5200n -0.001017 222.5300n -0.001000 222.5400n -0.000980 222.5500n -0.000957 222.5600n -0.000932 222.5700n -0.000907 222.5800n -0.000882 222.5900n -0.000859
+ 222.6000n -0.000839 222.6100n -0.000822 222.6200n -0.000810 222.6300n -0.000803 222.6400n -0.000803 222.6500n -0.000809 222.6600n -0.000822 222.6700n -0.000843 222.6800n -0.000872 222.6900n -0.000909 222.7000n -0.000953 222.7100n -0.001005 222.7200n -0.001065 222.7300n -0.001132 222.7400n -0.001205
+ 222.7500n -0.001284 222.7600n -0.001369 222.7700n -0.001458 222.7800n -0.001551 222.7900n -0.001646 222.8000n -0.001744 222.8100n -0.001842 222.8200n -0.001941 222.8300n -0.002038 222.8400n -0.002133 222.8500n -0.002224 222.8600n -0.002311 222.8700n -0.002392 222.8800n -0.002466 222.8900n -0.002533
+ 222.9000n -0.002590 222.9100n -0.002638 222.9200n -0.002675 222.9300n -0.002700 222.9400n -0.002712 222.9500n -0.002711 222.9600n -0.002696 222.9700n -0.002666 222.9800n -0.002622 222.9900n -0.002562 223.0000n -0.002486 223.0100n -0.002395 223.0200n -0.002289 223.0300n -0.002168 223.0400n -0.002033
+ 223.0500n -0.001885 223.0600n -0.001724 223.0700n -0.001552 223.0800n -0.001370 223.0900n -0.001180 223.1000n -0.000983 223.1100n -0.000782 223.1200n -0.000578 223.1300n -0.000374 223.1400n -0.000171 223.1500n 0.000027 223.1600n 0.000218 223.1700n 0.000401 223.1800n 0.000572 223.1900n 0.000730
+ 223.2000n 0.000873 223.2100n 0.000998 223.2200n 0.001104 223.2300n 0.001190 223.2400n 0.001255 223.2500n 0.001298 223.2600n 0.001318 223.2700n 0.001315 223.2800n 0.001290 223.2900n 0.001243 223.3000n 0.001175 223.3100n 0.001089 223.3200n 0.000985 223.3300n 0.000867 223.3400n 0.000736
+ 223.3500n 0.000595 223.3600n 0.000448 223.3700n 0.000297 223.3800n 0.000146 223.3900n -0.000001 223.4000n -0.000142 223.4100n -0.000272 223.4200n -0.000390 223.4300n -0.000491 223.4400n -0.000573 223.4500n -0.000634 223.4600n -0.000671 223.4700n -0.000684 223.4800n -0.000670 223.4900n -0.000630
+ 223.5000n -0.000563 223.5100n -0.000471 223.5200n -0.000353 223.5300n -0.000212 223.5400n -0.000049 223.5500n 0.000132 223.5600n 0.000329 223.5700n 0.000538 223.5800n 0.000756 223.5900n 0.000979 223.6000n 0.001202 223.6100n 0.001421 223.6200n 0.001631 223.6300n 0.001830 223.6400n 0.002013
+ 223.6500n 0.002175 223.6600n 0.002315 223.6700n 0.002428 223.6800n 0.002513 223.6900n 0.002567 223.7000n 0.002590 223.7100n 0.002581 223.7200n 0.002539 223.7300n 0.002466 223.7400n 0.002364 223.7500n 0.002233 223.7600n 0.002078 223.7700n 0.001901 223.7800n 0.001706 223.7900n 0.001497
+ 223.8000n 0.001280 223.8100n 0.001058 223.8200n 0.000837 223.8300n 0.000623 223.8400n 0.000419 223.8500n 0.000232 223.8600n 0.000065 223.8700n -0.000076 223.8800n -0.000190 223.8900n -0.000271 223.9000n -0.000318 223.9100n -0.000328 223.9200n -0.000301 223.9300n -0.000237 223.9400n -0.000136
+ 223.9500n 0.000002 223.9600n 0.000173 223.9700n 0.000374 223.9800n 0.000603 223.9900n 0.000855 224.0000n 0.001124 224.0100n 0.001407 224.0200n 0.001696 224.0300n 0.001986 224.0400n 0.002272 224.0500n 0.002546 224.0600n 0.002804 224.0700n 0.003039 224.0800n 0.003246 224.0900n 0.003421
+ 224.1000n 0.003559 224.1100n 0.003657 224.1200n 0.003712 224.1300n 0.003722 224.1400n 0.003687 224.1500n 0.003607 224.1600n 0.003482 224.1700n 0.003315 224.1800n 0.003108 224.1900n 0.002864 224.2000n 0.002590 224.2100n 0.002288 224.2200n 0.001967 224.2300n 0.001631 224.2400n 0.001287
+ 224.2500n 0.000942 224.2600n 0.000603 224.2700n 0.000277 224.2800n -0.000030 224.2900n -0.000310 224.3000n -0.000559 224.3100n -0.000771 224.3200n -0.000942 224.3300n -0.001067 224.3400n -0.001145 224.3500n -0.001172 224.3600n -0.001149 224.3700n -0.001076 224.3800n -0.000953 224.3900n -0.000784
+ 224.4000n -0.000570 224.4100n -0.000317 224.4200n -0.000029 224.4300n 0.000288 224.4400n 0.000627 224.4500n 0.000983 224.4600n 0.001348 224.4700n 0.001714 224.4800n 0.002074 224.4900n 0.002421 224.5000n 0.002748 224.5100n 0.003047 224.5200n 0.003314 224.5300n 0.003542 224.5400n 0.003726
+ 224.5500n 0.003864 224.5600n 0.003951 224.5700n 0.003985 224.5800n 0.003966 224.5900n 0.003894 224.6000n 0.003770 224.6100n 0.003595 224.6200n 0.003374 224.6300n 0.003109 224.6400n 0.002807 224.6500n 0.002471 224.6600n 0.002108 224.6700n 0.001725 224.6800n 0.001328 224.6900n 0.000925
+ 224.7000n 0.000523 224.7100n 0.000128 224.7200n -0.000253 224.7300n -0.000613 224.7400n -0.000947 224.7500n -0.001249 224.7600n -0.001514 224.7700n -0.001740 224.7800n -0.001923 224.7900n -0.002060 224.8000n -0.002152 224.8100n -0.002197 224.8200n -0.002196 224.8300n -0.002151 224.8400n -0.002065
+ 224.8500n -0.001940 224.8600n -0.001780 224.8700n -0.001590 224.8800n -0.001374 224.8900n -0.001138 224.9000n -0.000888 224.9100n -0.000627 224.9200n -0.000363 224.9300n -0.000101 224.9400n 0.000155 224.9500n 0.000399 224.9600n 0.000628 224.9700n 0.000837 224.9800n 0.001023 224.9900n 0.001183
+ 225.0000n 0.001316 225.0100n 0.001421 225.0200n 0.001497 225.0300n 0.001544 225.0400n 0.001563 225.0500n 0.001555 225.0600n 0.001524 225.0700n 0.001471 225.0800n 0.001399 225.0900n 0.001311 225.1000n 0.001212 225.1100n 0.001104 225.1200n 0.000992 225.1300n 0.000878 225.1400n 0.000767
+ 225.1500n 0.000662 225.1600n 0.000566 225.1700n 0.000481 225.1800n 0.000409 225.1900n 0.000351 225.2000n 0.000310 225.2100n 0.000284 225.2200n 0.000275 225.2300n 0.000282 225.2400n 0.000304 225.2500n 0.000338 225.2600n 0.000384 225.2700n 0.000439 225.2800n 0.000500 225.2900n 0.000565
+ 225.3000n 0.000631 225.3100n 0.000694 225.3200n 0.000753 225.3300n 0.000803 225.3400n 0.000844 225.3500n 0.000872 225.3600n 0.000885 225.3700n 0.000882 225.3800n 0.000862 225.3900n 0.000825 225.4000n 0.000769 225.4100n 0.000696 225.4200n 0.000606 225.4300n 0.000500 225.4400n 0.000381
+ 225.4500n 0.000249 225.4600n 0.000109 225.4700n -0.000038 225.4800n -0.000189 225.4900n -0.000340 225.5000n -0.000488 225.5100n -0.000632 225.5200n -0.000766 225.5300n -0.000889 225.5400n -0.000999 225.5500n -0.001092 225.5600n -0.001167 225.5700n -0.001223 225.5800n -0.001258 225.5900n -0.001273
+ 225.6000n -0.001267 225.6100n -0.001241 225.6200n -0.001195 225.6300n -0.001131 225.6400n -0.001052 225.6500n -0.000958 225.6600n -0.000853 225.6700n -0.000740 225.6800n -0.000621 225.6900n -0.000499 225.7000n -0.000378 225.7100n -0.000261 225.7200n -0.000149 225.7300n -0.000047 225.7400n 0.000043
+ 225.7500n 0.000121 225.7600n 0.000183 225.7700n 0.000229 225.7800n 0.000257 225.7900n 0.000269 225.8000n 0.000263 225.8100n 0.000241 225.8200n 0.000204 225.8300n 0.000153 225.8400n 0.000091 225.8500n 0.000019 225.8600n -0.000059 225.8700n -0.000140 225.8800n -0.000222 225.8900n -0.000301
+ 225.9000n -0.000375 225.9100n -0.000440 225.9200n -0.000493 225.9300n -0.000533 225.9400n -0.000556 225.9500n -0.000561 225.9600n -0.000546 225.9700n -0.000511 225.9800n -0.000454 225.9900n -0.000377 226.0000n -0.000279 226.0100n -0.000162 226.0200n -0.000026 226.0300n 0.000125 226.0400n 0.000289
+ 226.0500n 0.000464 226.0600n 0.000647 226.0700n 0.000834 226.0800n 0.001021 226.0900n 0.001207 226.1000n 0.001386 226.1100n 0.001556 226.1200n 0.001714 226.1300n 0.001856 226.1400n 0.001981 226.1500n 0.002086 226.1600n 0.002169 226.1700n 0.002230 226.1800n 0.002268 226.1900n 0.002283
+ 226.2000n 0.002276 226.2100n 0.002246 226.2200n 0.002197 226.2300n 0.002131 226.2400n 0.002049 226.2500n 0.001954 226.2600n 0.001851 226.2700n 0.001742 226.2800n 0.001631 226.2900n 0.001521 226.3000n 0.001416 226.3100n 0.001320 226.3200n 0.001236 226.3300n 0.001166 226.3400n 0.001114
+ 226.3500n 0.001081 226.3600n 0.001070 226.3700n 0.001081 226.3800n 0.001115 226.3900n 0.001171 226.4000n 0.001250 226.4100n 0.001350 226.4200n 0.001469 226.4300n 0.001604 226.4400n 0.001754 226.4500n 0.001914 226.4600n 0.002081 226.4700n 0.002251 226.4800n 0.002420 226.4900n 0.002584
+ 226.5000n 0.002739 226.5100n 0.002880 226.5200n 0.003004 226.5300n 0.003107 226.5400n 0.003186 226.5500n 0.003238 226.5600n 0.003261 226.5700n 0.003253 226.5800n 0.003213 226.5900n 0.003140 226.6000n 0.003035 226.6100n 0.002898 226.6200n 0.002731 226.6300n 0.002536 226.6400n 0.002316
+ 226.6500n 0.002073 226.6600n 0.001811 226.6700n 0.001535 226.6800n 0.001248 226.6900n 0.000955 226.7000n 0.000659 226.7100n 0.000367 226.7200n 0.000081 226.7300n -0.000193 226.7400n -0.000453 226.7500n -0.000694 226.7600n -0.000913 226.7700n -0.001109 226.7800n -0.001278 226.7900n -0.001419
+ 226.8000n -0.001532 226.8100n -0.001616 226.8200n -0.001672 226.8300n -0.001701 226.8400n -0.001704 226.8500n -0.001683 226.8600n -0.001641 226.8700n -0.001581 226.8800n -0.001506 226.8900n -0.001419 226.9000n -0.001324 226.9100n -0.001225 226.9200n -0.001125 226.9300n -0.001028 226.9400n -0.000936
+ 226.9500n -0.000854 226.9600n -0.000783 226.9700n -0.000725 226.9800n -0.000683 226.9900n -0.000657 227.0000n -0.000648 227.0100n -0.000656 227.0200n -0.000681 227.0300n -0.000722 227.0400n -0.000776 227.0500n -0.000843 227.0600n -0.000920 227.0700n -0.001004 227.0800n -0.001092 227.0900n -0.001180
+ 227.1000n -0.001267 227.1100n -0.001347 227.1200n -0.001419 227.1300n -0.001478 227.1400n -0.001523 227.1500n -0.001549 227.1600n -0.001556 227.1700n -0.001542 227.1800n -0.001505 227.1900n -0.001444 227.2000n -0.001359 227.2100n -0.001251 227.2200n -0.001120 227.2300n -0.000969 227.2400n -0.000799
+ 227.2500n -0.000612 227.2600n -0.000411 227.2700n -0.000201 227.2800n 0.000017 227.2900n 0.000237 227.3000n 0.000456 227.3100n 0.000670 227.3200n 0.000875 227.3300n 0.001067 227.3400n 0.001243 227.3500n 0.001399 227.3600n 0.001532 227.3700n 0.001640 227.3800n 0.001721 227.3900n 0.001773
+ 227.4000n 0.001796 227.4100n 0.001788 227.4200n 0.001751 227.4300n 0.001684 227.4400n 0.001590 227.4500n 0.001471 227.4600n 0.001328 227.4700n 0.001165 227.4800n 0.000984 227.4900n 0.000790 227.5000n 0.000586 227.5100n 0.000376 227.5200n 0.000164 227.5300n -0.000046 227.5400n -0.000251
+ 227.5500n -0.000446 227.5600n -0.000629 227.5700n -0.000796 227.5800n -0.000945 227.5900n -0.001074 227.6000n -0.001181 227.6100n -0.001265 227.6200n -0.001325 227.6300n -0.001361 227.6400n -0.001374 227.6500n -0.001364 227.6600n -0.001334 227.6700n -0.001284 227.6800n -0.001218 227.6900n -0.001137
+ 227.7000n -0.001044 227.7100n -0.000943 227.7200n -0.000837 227.7300n -0.000728 227.7400n -0.000619 227.7500n -0.000515 227.7600n -0.000416 227.7700n -0.000327 227.7800n -0.000248 227.7900n -0.000183 227.8000n -0.000131 227.8100n -0.000095 227.8200n -0.000075 227.8300n -0.000071 227.8400n -0.000082
+ 227.8500n -0.000108 227.8600n -0.000148 227.8700n -0.000200 227.8800n -0.000262 227.8900n -0.000332 227.9000n -0.000408 227.9100n -0.000487 227.9200n -0.000566 227.9300n -0.000643 227.9400n -0.000715 227.9500n -0.000780 227.9600n -0.000834 227.9700n -0.000877 227.9800n -0.000905 227.9900n -0.000918
+ 228.0000n -0.000915 228.0100n -0.000894 228.0200n -0.000855 228.0300n -0.000798 228.0400n -0.000725 228.0500n -0.000634 228.0600n -0.000529 228.0700n -0.000410 228.0800n -0.000280 228.0900n -0.000141 228.1000n 0.000005 228.1100n 0.000155 228.1200n 0.000307 228.1300n 0.000456 228.1400n 0.000601
+ 228.1500n 0.000739 228.1600n 0.000866 228.1700n 0.000981 228.1800n 0.001080 228.1900n 0.001163 228.2000n 0.001227 228.2100n 0.001271 228.2200n 0.001293 228.2300n 0.001294 228.2400n 0.001273 228.2500n 0.001229 228.2600n 0.001165 228.2700n 0.001080 228.2800n 0.000976 228.2900n 0.000854
+ 228.3000n 0.000716 228.3100n 0.000565 228.3200n 0.000402 228.3300n 0.000231 228.3400n 0.000053 228.3500n -0.000129 228.3600n -0.000312 228.3700n -0.000494 228.3800n -0.000672 228.3900n -0.000844 228.4000n -0.001008 228.4100n -0.001161 228.4200n -0.001303 228.4300n -0.001431 228.4400n -0.001545
+ 228.4500n -0.001642 228.4600n -0.001723 228.4700n -0.001788 228.4800n -0.001835 228.4900n -0.001865 228.5000n -0.001879 228.5100n -0.001876 228.5200n -0.001857 228.5300n -0.001824 228.5400n -0.001777 228.5500n -0.001716 228.5600n -0.001644 228.5700n -0.001562 228.5800n -0.001470 228.5900n -0.001369
+ 228.6000n -0.001262 228.6100n -0.001149 228.6200n -0.001031 228.6300n -0.000909 228.6400n -0.000785 228.6500n -0.000658 228.6600n -0.000531 228.6700n -0.000404 228.6800n -0.000277 228.6900n -0.000152 228.7000n -0.000029 228.7100n 0.000091 228.7200n 0.000209 228.7300n 0.000322 228.7400n 0.000430
+ 228.7500n 0.000534 228.7600n 0.000632 228.7700n 0.000723 228.7800n 0.000807 228.7900n 0.000884 228.8000n 0.000953 228.8100n 0.001013 228.8200n 0.001064 228.8300n 0.001104 228.8400n 0.001134 228.8500n 0.001154 228.8600n 0.001162 228.8700n 0.001159 228.8800n 0.001143 228.8900n 0.001117
+ 228.9000n 0.001078 228.9100n 0.001028 228.9200n 0.000967 228.9300n 0.000896 228.9400n 0.000814 228.9500n 0.000724 228.9600n 0.000626 228.9700n 0.000522 228.9800n 0.000412 228.9900n 0.000298 229.0000n 0.000182 229.0100n 0.000065 229.0200n -0.000052 229.0300n -0.000165 229.0400n -0.000275
+ 229.0500n -0.000379 229.0600n -0.000476 229.0700n -0.000564 229.0800n -0.000643 229.0900n -0.000710 229.1000n -0.000767 229.1100n -0.000811 229.1200n -0.000843 229.1300n -0.000863 229.1400n -0.000870 229.1500n -0.000865 229.1600n -0.000850 229.1700n -0.000824 229.1800n -0.000790 229.1900n -0.000749
+ 229.2000n -0.000701 229.2100n -0.000650 229.2200n -0.000597 229.2300n -0.000544 229.2400n -0.000493 229.2500n -0.000446 229.2600n -0.000404 229.2700n -0.000370 229.2800n -0.000345 229.2900n -0.000331 229.3000n -0.000328 229.3100n -0.000338 229.3200n -0.000360 229.3300n -0.000396 229.3400n -0.000445
+ 229.3500n -0.000507 229.3600n -0.000581 229.3700n -0.000666 229.3800n -0.000760 229.3900n -0.000861 229.4000n -0.000969 229.4100n -0.001079 229.4200n -0.001191 229.4300n -0.001302 229.4400n -0.001408 229.4500n -0.001508 229.4600n -0.001598 229.4700n -0.001678 229.4800n -0.001744 229.4900n -0.001794
+ 229.5000n -0.001826 229.5100n -0.001840 229.5200n -0.001834 229.5300n -0.001808 229.5400n -0.001761 229.5500n -0.001693 229.5600n -0.001606 229.5700n -0.001500 229.5800n -0.001377 229.5900n -0.001238 229.6000n -0.001086 229.6100n -0.000924 229.6200n -0.000753 229.6300n -0.000579 229.6400n -0.000402
+ 229.6500n -0.000228 229.6600n -0.000059 229.6700n 0.000102 229.6800n 0.000251 229.6900n 0.000386 229.7000n 0.000503 229.7100n 0.000601 229.7200n 0.000677 229.7300n 0.000731 229.7400n 0.000760 229.7500n 0.000764 229.7600n 0.000743 229.7700n 0.000698 229.7800n 0.000630 229.7900n 0.000539
+ 229.8000n 0.000428 229.8100n 0.000300 229.8200n 0.000157 229.8300n 0.000001 229.8400n -0.000162 229.8500n -0.000330 229.8600n -0.000499 229.8700n -0.000665 229.8800n -0.000824 229.8900n -0.000973 229.9000n -0.001107 229.9100n -0.001224 229.9200n -0.001320 229.9300n -0.001393 229.9400n -0.001440
+ 229.9500n -0.001459 229.9600n -0.001450 229.9700n -0.001412 229.9800n -0.001344 229.9900n -0.001247 230.0000n -0.001121 230.0100n -0.000970 230.0200n -0.000793 230.0300n -0.000595 230.0400n -0.000378 230.0500n -0.000145 230.0600n 0.000100 230.0700n 0.000353 230.0800n 0.000610 230.0900n 0.000867
+ 230.1000n 0.001120 230.1100n 0.001365 230.1200n 0.001599 230.1300n 0.001817 230.1400n 0.002016 230.1500n 0.002193 230.1600n 0.002346 230.1700n 0.002473 230.1800n 0.002572 230.1900n 0.002643 230.2000n 0.002685 230.2100n 0.002697 230.2200n 0.002682 230.2300n 0.002640 230.2400n 0.002572
+ 230.2500n 0.002482 230.2600n 0.002371 230.2700n 0.002243 230.2800n 0.002101 230.2900n 0.001948 230.3000n 0.001789 230.3100n 0.001626 230.3200n 0.001465 230.3300n 0.001308 230.3400n 0.001159 230.3500n 0.001022 230.3600n 0.000899 230.3700n 0.000794 230.3800n 0.000709 230.3900n 0.000646
+ 230.4000n 0.000606 230.4100n 0.000590 230.4200n 0.000600 230.4300n 0.000634 230.4400n 0.000693 230.4500n 0.000776 230.4600n 0.000881 230.4700n 0.001006 230.4800n 0.001150 230.4900n 0.001308 230.5000n 0.001480 230.5100n 0.001661 230.5200n 0.001848 230.5300n 0.002038 230.5400n 0.002227
+ 230.5500n 0.002411 230.5600n 0.002588 230.5700n 0.002754 230.5800n 0.002906 230.5900n 0.003041 230.6000n 0.003157 230.6100n 0.003250 230.6200n 0.003320 230.6300n 0.003365 230.6400n 0.003383 230.6500n 0.003375 230.6600n 0.003339 230.6700n 0.003276 230.6800n 0.003187 230.6900n 0.003072
+ 230.7000n 0.002933 230.7100n 0.002771 230.7200n 0.002589 230.7300n 0.002389 230.7400n 0.002172 230.7500n 0.001943 230.7600n 0.001704 230.7700n 0.001457 230.7800n 0.001206 230.7900n 0.000954 230.8000n 0.000704 230.8100n 0.000458 230.8200n 0.000220 230.8300n -0.000008 230.8400n -0.000223
+ 230.8500n -0.000424 230.8600n -0.000607 230.8700n -0.000772 230.8800n -0.000916 230.8900n -0.001039 230.9000n -0.001140 230.9100n -0.001218 230.9200n -0.001272 230.9300n -0.001304 230.9400n -0.001312 230.9500n -0.001298 230.9600n -0.001262 230.9700n -0.001206 230.9800n -0.001131 230.9900n -0.001039
+ 231.0000n -0.000931 231.0100n -0.000809 231.0200n -0.000675 231.0300n -0.000532 231.0400n -0.000383 231.0500n -0.000228 231.0600n -0.000071 231.0700n 0.000085 231.0800n 0.000239 231.0900n 0.000388 231.1000n 0.000529 231.1100n 0.000660 231.1200n 0.000780 231.1300n 0.000886 231.1400n 0.000976
+ 231.1500n 0.001049 231.1600n 0.001104 231.1700n 0.001139 231.1800n 0.001154 231.1900n 0.001147 231.2000n 0.001120 231.2100n 0.001071 231.2200n 0.001001 231.2300n 0.000910 231.2400n 0.000800 231.2500n 0.000672 231.2600n 0.000527 231.2700n 0.000368 231.2800n 0.000195 231.2900n 0.000011
+ 231.3000n -0.000181 231.3100n -0.000379 231.3200n -0.000579 231.3300n -0.000780 231.3400n -0.000978 231.3500n -0.001171 231.3600n -0.001355 231.3700n -0.001527 231.3800n -0.001686 231.3900n -0.001828 231.4000n -0.001952 231.4100n -0.002054 231.4200n -0.002133 231.4300n -0.002189 231.4400n -0.002219
+ 231.4500n -0.002223 231.4600n -0.002200 231.4700n -0.002151 231.4800n -0.002076 231.4900n -0.001976 231.5000n -0.001851 231.5100n -0.001705 231.5200n -0.001538 231.5300n -0.001352 231.5400n -0.001152 231.5500n -0.000938 231.5600n -0.000715 231.5700n -0.000486 231.5800n -0.000254 231.5900n -0.000023
+ 231.6000n 0.000204 231.6100n 0.000424 231.6200n 0.000634 231.6300n 0.000829 231.6400n 0.001008 231.6500n 0.001168 231.6600n 0.001306 231.6700n 0.001420 231.6800n 0.001510 231.6900n 0.001573 231.7000n 0.001610 231.7100n 0.001620 231.7200n 0.001603 231.7300n 0.001560 231.7400n 0.001492
+ 231.7500n 0.001400 231.7600n 0.001288 231.7700n 0.001156 231.7800n 0.001007 231.7900n 0.000845 231.8000n 0.000672 231.8100n 0.000492 231.8200n 0.000307 231.8300n 0.000122 231.8400n -0.000061 231.8500n -0.000239 231.8600n -0.000407 231.8700n -0.000564 231.8800n -0.000707 231.8900n -0.000834
+ 231.9000n -0.000942 231.9100n -0.001030 231.9200n -0.001097 231.9300n -0.001143 231.9400n -0.001166 231.9500n -0.001168 231.9600n -0.001148 231.9700n -0.001108 231.9800n -0.001048 231.9900n -0.000971 232.0000n -0.000879 232.0100n -0.000773 232.0200n -0.000656 232.0300n -0.000532 232.0400n -0.000402
+ 232.0500n -0.000270 232.0600n -0.000139 232.0700n -0.000010 232.0800n 0.000112 232.0900n 0.000226 232.1000n 0.000330 232.1100n 0.000420 232.1200n 0.000495 232.1300n 0.000555 232.1400n 0.000596 232.1500n 0.000620 232.1600n 0.000625 232.1700n 0.000611 232.1800n 0.000579 232.1900n 0.000528
+ 232.2000n 0.000461 232.2100n 0.000378 232.2200n 0.000280 232.2300n 0.000171 232.2400n 0.000051 232.2500n -0.000078 232.2600n -0.000212 232.2700n -0.000350 232.2800n -0.000490 232.2900n -0.000628 232.3000n -0.000763 232.3100n -0.000893 232.3200n -0.001014 232.3300n -0.001127 232.3400n -0.001227
+ 232.3500n -0.001316 232.3600n -0.001390 232.3700n -0.001449 232.3800n -0.001493 232.3900n -0.001520 232.4000n -0.001531 232.4100n -0.001526 232.4200n -0.001505 232.4300n -0.001469 232.4400n -0.001418 232.4500n -0.001354 232.4600n -0.001277 232.4700n -0.001189 232.4800n -0.001091 232.4900n -0.000985
+ 232.5000n -0.000872 232.5100n -0.000754 232.5200n -0.000632 232.5300n -0.000509 232.5400n -0.000385 232.5500n -0.000262 232.5600n -0.000141 232.5700n -0.000024 232.5800n 0.000089 232.5900n 0.000195 232.6000n 0.000295 232.6100n 0.000388 232.6200n 0.000472 232.6300n 0.000548 232.6400n 0.000614
+ 232.6500n 0.000671 232.6600n 0.000719 232.6700n 0.000756 232.6800n 0.000784 232.6900n 0.000803 232.7000n 0.000812 232.7100n 0.000811 232.7200n 0.000802 232.7300n 0.000783 232.7400n 0.000756 232.7500n 0.000721 232.7600n 0.000679 232.7700n 0.000629 232.7800n 0.000572 232.7900n 0.000508
+ 232.8000n 0.000439 232.8100n 0.000364 232.8200n 0.000283 232.8300n 0.000198 232.8400n 0.000109 232.8500n 0.000016 232.8600n -0.000080 232.8700n -0.000178 232.8800n -0.000279 232.8900n -0.000381 232.9000n -0.000484 232.9100n -0.000587 232.9200n -0.000690 232.9300n -0.000792 232.9400n -0.000892
+ 232.9500n -0.000990 232.9600n -0.001085 232.9700n -0.001177 232.9800n -0.001264 232.9900n -0.001348 233.0000n -0.001426 233.0100n -0.001500 233.0200n -0.001567 233.0300n -0.001629 233.0400n -0.001685 233.0500n -0.001735 233.0600n -0.001779 233.0700n -0.001817 233.0800n -0.001849 233.0900n -0.001876
+ 233.1000n -0.001897 233.1100n -0.001914 233.1200n -0.001927 233.1300n -0.001936 233.1400n -0.001941 233.1500n -0.001944 233.1600n -0.001945 233.1700n -0.001945 233.1800n -0.001944 233.1900n -0.001942 233.2000n -0.001941 233.2100n -0.001941 233.2200n -0.001941 233.2300n -0.001943 233.2400n -0.001946
+ 233.2500n -0.001952 233.2600n -0.001959 233.2700n -0.001967 233.2800n -0.001977 233.2900n -0.001988 233.3000n -0.002000 233.3100n -0.002013 233.3200n -0.002026 233.3300n -0.002038 233.3400n -0.002048 233.3500n -0.002057 233.3600n -0.002064 233.3700n -0.002068 233.3800n -0.002068 233.3900n -0.002064
+ 233.4000n -0.002056 233.4100n -0.002043 233.4200n -0.002024 233.4300n -0.002001 233.4400n -0.001972 233.4500n -0.001938 233.4600n -0.001898 233.4700n -0.001854 233.4800n -0.001806 233.4900n -0.001753 233.5000n -0.001697 233.5100n -0.001639 233.5200n -0.001579 233.5300n -0.001518 233.5400n -0.001457
+ 233.5500n -0.001397 233.5600n -0.001339 233.5700n -0.001283 233.5800n -0.001232 233.5900n -0.001184 233.6000n -0.001142 233.6100n -0.001105 233.6200n -0.001075 233.6300n -0.001051 233.6400n -0.001035 233.6500n -0.001025 233.6600n -0.001023 233.6700n -0.001027 233.6800n -0.001038 233.6900n -0.001055
+ 233.7000n -0.001078 233.7100n -0.001106 233.7200n -0.001138 233.7300n -0.001174 233.7400n -0.001212 233.7500n -0.001251 233.7600n -0.001291 233.7700n -0.001331 233.7800n -0.001369 233.7900n -0.001405 233.8000n -0.001438 233.8100n -0.001467 233.8200n -0.001492 233.8300n -0.001511 233.8400n -0.001525
+ 233.8500n -0.001533 233.8600n -0.001534 233.8700n -0.001529 233.8800n -0.001518 233.8900n -0.001500 233.9000n -0.001476 233.9100n -0.001445 233.9200n -0.001409 233.9300n -0.001368 233.9400n -0.001322 233.9500n -0.001271 233.9600n -0.001216 233.9700n -0.001157 233.9800n -0.001094 233.9900n -0.001028
+ 234.0000n -0.000960 234.0100n -0.000889 234.0200n -0.000815 234.0300n -0.000738 234.0400n -0.000659 234.0500n -0.000578 234.0600n -0.000493 234.0700n -0.000406 234.0800n -0.000315 234.0900n -0.000221 234.1000n -0.000123 234.1100n -0.000022 234.1200n 0.000084 234.1300n 0.000193 234.1400n 0.000307
+ 234.1500n 0.000425 234.1600n 0.000547 234.1700n 0.000672 234.1800n 0.000800 234.1900n 0.000931 234.2000n 0.001063 234.2100n 0.001195 234.2200n 0.001327 234.2300n 0.001457 234.2400n 0.001584 234.2500n 0.001705 234.2600n 0.001821 234.2700n 0.001928 234.2800n 0.002025 234.2900n 0.002110
+ 234.3000n 0.002183 234.3100n 0.002240 234.3200n 0.002281 234.3300n 0.002305 234.3400n 0.002310 234.3500n 0.002295 234.3600n 0.002261 234.3700n 0.002206 234.3800n 0.002130 234.3900n 0.002035 234.4000n 0.001920 234.4100n 0.001787 234.4200n 0.001637 234.4300n 0.001472 234.4400n 0.001295
+ 234.4500n 0.001106 234.4600n 0.000910 234.4700n 0.000708 234.4800n 0.000504 234.4900n 0.000301 234.5000n 0.000102 234.5100n -0.000090 234.5200n -0.000272 234.5300n -0.000441 234.5400n -0.000594 234.5500n -0.000729 234.5600n -0.000842 234.5700n -0.000934 234.5800n -0.001001 234.5900n -0.001044
+ 234.6000n -0.001061 234.6100n -0.001053 234.6200n -0.001019 234.6300n -0.000961 234.6400n -0.000881 234.6500n -0.000779 234.6600n -0.000659 234.6700n -0.000523 234.6800n -0.000374 234.6900n -0.000215 234.7000n -0.000051 234.7100n 0.000116 234.7200n 0.000281 234.7300n 0.000441 234.7400n 0.000592
+ 234.7500n 0.000731 234.7600n 0.000853 234.7700n 0.000956 234.7800n 0.001038 234.7900n 0.001095 234.8000n 0.001126 234.8100n 0.001131 234.8200n 0.001107 234.8300n 0.001055 234.8400n 0.000976 234.8500n 0.000869 234.8600n 0.000737 234.8700n 0.000582 234.8800n 0.000406 234.8900n 0.000212
+ 234.9000n 0.000004 234.9100n -0.000216 234.9200n -0.000442 234.9300n -0.000672 234.9400n -0.000901 234.9500n -0.001125 234.9600n -0.001340 234.9700n -0.001542 234.9800n -0.001728 234.9900n -0.001894 235.0000n -0.002038 235.0100n -0.002157 235.0200n -0.002250 235.0300n -0.002314 235.0400n -0.002350
+ 235.0500n -0.002356 235.0600n -0.002335 235.0700n -0.002285 235.0800n -0.002209 235.0900n -0.002109 235.1000n -0.001987 235.1100n -0.001846 235.1200n -0.001690 235.1300n -0.001521 235.1400n -0.001343 235.1500n -0.001160 235.1600n -0.000976 235.1700n -0.000795 235.1800n -0.000620 235.1900n -0.000455
+ 235.2000n -0.000302 235.2100n -0.000164 235.2200n -0.000045 235.2300n 0.000055 235.2400n 0.000133 235.2500n 0.000189 235.2600n 0.000223 235.2700n 0.000233 235.2800n 0.000222 235.2900n 0.000189 235.3000n 0.000137 235.3100n 0.000068 235.3200n -0.000017 235.3300n -0.000115 235.3400n -0.000222
+ 235.3500n -0.000337 235.3600n -0.000455 235.3700n -0.000575 235.3800n -0.000692 235.3900n -0.000804 235.4000n -0.000908 235.4100n -0.001002 235.4200n -0.001084 235.4300n -0.001151 235.4400n -0.001202 235.4500n -0.001237 235.4600n -0.001254 235.4700n -0.001253 235.4800n -0.001234 235.4900n -0.001198
+ 235.5000n -0.001146 235.5100n -0.001080 235.5200n -0.001000 235.5300n -0.000908 235.5400n -0.000808 235.5500n -0.000699 235.5600n -0.000586 235.5700n -0.000470 235.5800n -0.000352 235.5900n -0.000236 235.6000n -0.000124 235.6100n -0.000016 235.6200n 0.000086 235.6300n 0.000180 235.6400n 0.000266
+ 235.6500n 0.000343 235.6600n 0.000411 235.6700n 0.000471 235.6800n 0.000521 235.6900n 0.000564 235.7000n 0.000600 235.7100n 0.000630 235.7200n 0.000656 235.7300n 0.000678 235.7400n 0.000699 235.7500n 0.000720 235.7600n 0.000742 235.7700n 0.000767 235.7800n 0.000795 235.7900n 0.000828
+ 235.8000n 0.000866 235.8100n 0.000910 235.8200n 0.000960 235.8300n 0.001016 235.8400n 0.001077 235.8500n 0.001142 235.8600n 0.001210 235.8700n 0.001279 235.8800n 0.001348 235.8900n 0.001415 235.9000n 0.001477 235.9100n 0.001533 235.9200n 0.001580 235.9300n 0.001615 235.9400n 0.001637
+ 235.9500n 0.001644 235.9600n 0.001633 235.9700n 0.001603 235.9800n 0.001553 235.9900n 0.001482 236.0000n 0.001391 236.0100n 0.001278 236.0200n 0.001144 236.0300n 0.000992 236.0400n 0.000821 236.0500n 0.000635 236.0600n 0.000436 236.0700n 0.000227 236.0800n 0.000011 236.0900n -0.000208
+ 236.1000n -0.000426 236.1100n -0.000639 236.1200n -0.000843 236.1300n -0.001033 236.1400n -0.001207 236.1500n -0.001360 236.1600n -0.001488 236.1700n -0.001589 236.1800n -0.001661 236.1900n -0.001700 236.2000n -0.001706 236.2100n -0.001678 236.2200n -0.001615 236.2300n -0.001520 236.2400n -0.001392
+ 236.2500n -0.001234 236.2600n -0.001049 236.2700n -0.000840 236.2800n -0.000612 236.2900n -0.000368 236.3000n -0.000114 236.3100n 0.000145 236.3200n 0.000404 236.3300n 0.000657 236.3400n 0.000899 236.3500n 0.001123 236.3600n 0.001325 236.3700n 0.001500 236.3800n 0.001644 236.3900n 0.001753
+ 236.4000n 0.001823 236.4100n 0.001853 236.4200n 0.001841 236.4300n 0.001786 236.4400n 0.001689 236.4500n 0.001550 236.4600n 0.001371 236.4700n 0.001156 236.4800n 0.000908 236.4900n 0.000631 236.5000n 0.000330 236.5100n 0.000012 236.5200n -0.000319 236.5300n -0.000655 236.5400n -0.000990
+ 236.5500n -0.001317 236.5600n -0.001630 236.5700n -0.001922 236.5800n -0.002188 236.5900n -0.002421 236.6000n -0.002617 236.6100n -0.002772 236.6200n -0.002881 236.6300n -0.002942 236.6400n -0.002954 236.6500n -0.002916 236.6600n -0.002827 236.6700n -0.002690 236.6800n -0.002505 236.6900n -0.002277
+ 236.7000n -0.002009 236.7100n -0.001705 236.7200n -0.001372 236.7300n -0.001015 236.7400n -0.000640 236.7500n -0.000253 236.7600n 0.000137 236.7700n 0.000525 236.7800n 0.000903 236.7900n 0.001265 236.8000n 0.001605 236.8100n 0.001918 236.8200n 0.002197 236.8300n 0.002440 236.8400n 0.002641
+ 236.8500n 0.002800 236.8600n 0.002913 236.8700n 0.002980 236.8800n 0.003001 236.8900n 0.002977 236.9000n 0.002910 236.9100n 0.002803 236.9200n 0.002659 236.9300n 0.002482 236.9400n 0.002277 236.9500n 0.002050 236.9600n 0.001805 236.9700n 0.001549 236.9800n 0.001287 236.9900n 0.001025
+ 237.0000n 0.000769 237.0100n 0.000524 237.0200n 0.000295 237.0300n 0.000087 237.0400n -0.000098 237.0500n -0.000255 237.0600n -0.000382 237.0700n -0.000479 237.0800n -0.000543 237.0900n -0.000575 237.1000n -0.000576 237.1100n -0.000548 237.1200n -0.000492 237.1300n -0.000412 237.1400n -0.000311
+ 237.1500n -0.000192 237.1600n -0.000061 237.1700n 0.000078 237.1800n 0.000221 237.1900n 0.000362 237.2000n 0.000498 237.2100n 0.000623 237.2200n 0.000735 237.2300n 0.000828 237.2400n 0.000900 237.2500n 0.000948 237.2600n 0.000970 237.2700n 0.000966 237.2800n 0.000933 237.2900n 0.000873
+ 237.3000n 0.000786 237.3100n 0.000673 237.3200n 0.000537 237.3300n 0.000380 237.3400n 0.000205 237.3500n 0.000016 237.3600n -0.000183 237.3700n -0.000389 237.3800n -0.000596 237.3900n -0.000801 237.4000n -0.000999 237.4100n -0.001187 237.4200n -0.001361 237.4300n -0.001518 237.4400n -0.001654
+ 237.4500n -0.001767 237.4600n -0.001856 237.4700n -0.001918 237.4800n -0.001955 237.4900n -0.001965 237.5000n -0.001950 237.5100n -0.001911 237.5200n -0.001850 237.5300n -0.001769 237.5400n -0.001670 237.5500n -0.001559 237.5600n -0.001437 237.5700n -0.001309 237.5800n -0.001178 237.5900n -0.001049
+ 237.6000n -0.000924 237.6100n -0.000809 237.6200n -0.000706 237.6300n -0.000617 237.6400n -0.000546 237.6500n -0.000495 237.6600n -0.000464 237.6700n -0.000455 237.6800n -0.000468 237.6900n -0.000503 237.7000n -0.000558 237.7100n -0.000632 237.7200n -0.000723 237.7300n -0.000829 237.7400n -0.000945
+ 237.7500n -0.001070 237.7600n -0.001198 237.7700n -0.001327 237.7800n -0.001453 237.7900n -0.001571 237.8000n -0.001678 237.8100n -0.001770 237.8200n -0.001844 237.8300n -0.001897 237.8400n -0.001927 237.8500n -0.001931 237.8600n -0.001909 237.8700n -0.001859 237.8800n -0.001781 237.8900n -0.001676
+ 237.9000n -0.001545 237.9100n -0.001389 237.9200n -0.001211 237.9300n -0.001014 237.9400n -0.000800 237.9500n -0.000574 237.9600n -0.000339 237.9700n -0.000098 237.9800n 0.000142 237.9900n 0.000380 238.0000n 0.000609 238.0100n 0.000828 238.0200n 0.001031 238.0300n 0.001215 238.0400n 0.001379
+ 238.0500n 0.001519 238.0600n 0.001633 238.0700n 0.001721 238.0800n 0.001781 238.0900n 0.001813 238.1000n 0.001819 238.1100n 0.001798 238.1200n 0.001754 238.1300n 0.001687 238.1400n 0.001601 238.1500n 0.001498 238.1600n 0.001383 238.1700n 0.001257 238.1800n 0.001125 238.1900n 0.000992
+ 238.2000n 0.000859 238.2100n 0.000731 238.2200n 0.000611 238.2300n 0.000501 238.2400n 0.000405 238.2500n 0.000325 238.2600n 0.000262 238.2700n 0.000217 238.2800n 0.000191 238.2900n 0.000183 238.3000n 0.000195 238.3100n 0.000223 238.3200n 0.000267 238.3300n 0.000325 238.3400n 0.000395
+ 238.3500n 0.000473 238.3600n 0.000557 238.3700n 0.000643 238.3800n 0.000729 238.3900n 0.000811 238.4000n 0.000885 238.4100n 0.000950 238.4200n 0.001001 238.4300n 0.001037 238.4400n 0.001056 238.4500n 0.001055 238.4600n 0.001034 238.4700n 0.000992 238.4800n 0.000929 238.4900n 0.000845
+ 238.5000n 0.000741 238.5100n 0.000619 238.5200n 0.000480 238.5300n 0.000327 238.5400n 0.000162 238.5500n -0.000011 238.5600n -0.000190 238.5700n -0.000371 238.5800n -0.000550 238.5900n -0.000725 238.6000n -0.000891 238.6100n -0.001047 238.6200n -0.001188 238.6300n -0.001313 238.6400n -0.001419
+ 238.6500n -0.001505 238.6600n -0.001570 238.6700n -0.001613 238.6800n -0.001634 238.6900n -0.001633 238.7000n -0.001611 238.7100n -0.001570 238.7200n -0.001512 238.7300n -0.001439 238.7400n -0.001354 238.7500n -0.001260 238.7600n -0.001160 238.7700n -0.001057 238.7800n -0.000956 238.7900n -0.000859
+ 238.8000n -0.000769 238.8100n -0.000690 238.8200n -0.000625 238.8300n -0.000576 238.8400n -0.000544 238.8500n -0.000533 238.8600n -0.000541 238.8700n -0.000571 238.8800n -0.000622 238.8900n -0.000693 238.9000n -0.000783 238.9100n -0.000891 238.9200n -0.001014 238.9300n -0.001150 238.9400n -0.001296
+ 238.9500n -0.001448 238.9600n -0.001604 238.9700n -0.001759 238.9800n -0.001910 238.9900n -0.002053 239.0000n -0.002184 239.0100n -0.002301 239.0200n -0.002401 239.0300n -0.002480 239.0400n -0.002537 239.0500n -0.002570 239.0600n -0.002578 239.0700n -0.002560 239.0800n -0.002516 239.0900n -0.002447
+ 239.1000n -0.002354 239.1100n -0.002239 239.1200n -0.002103 239.1300n -0.001950 239.1400n -0.001783 239.1500n -0.001605 239.1600n -0.001420 239.1700n -0.001231 239.1800n -0.001043 239.1900n -0.000859 239.2000n -0.000683 239.2100n -0.000520 239.2200n -0.000371 239.2300n -0.000241 239.2400n -0.000131
+ 239.2500n -0.000044 239.2600n 0.000018 239.2700n 0.000056 239.2800n 0.000068 239.2900n 0.000054 239.3000n 0.000016 239.3100n -0.000045 239.3200n -0.000127 239.3300n -0.000227 239.3400n -0.000344 239.3500n -0.000473 239.3600n -0.000610 239.3700n -0.000753 239.3800n -0.000898 239.3900n -0.001039
+ 239.4000n -0.001174 239.4100n -0.001299 239.4200n -0.001410 239.4300n -0.001504 239.4400n -0.001579 239.4500n -0.001632 239.4600n -0.001661 239.4700n -0.001665 239.4800n -0.001644 239.4900n -0.001596 239.5000n -0.001524 239.5100n -0.001427 239.5200n -0.001308 239.5300n -0.001168 239.5400n -0.001011
+ 239.5500n -0.000838 239.5600n -0.000654 239.5700n -0.000462 239.5800n -0.000265 239.5900n -0.000067 239.6000n 0.000128 239.6100n 0.000316 239.6200n 0.000494 239.6300n 0.000659 239.6400n 0.000808 239.6500n 0.000939 239.6600n 0.001049 239.6700n 0.001138 239.6800n 0.001204 239.6900n 0.001248
+ 239.7000n 0.001268 239.7100n 0.001267 239.7200n 0.001245 239.7300n 0.001204 239.7400n 0.001145 239.7500n 0.001073 239.7600n 0.000989 239.7700n 0.000896 239.7800n 0.000798 239.7900n 0.000698 239.8000n 0.000599 239.8100n 0.000504 239.8200n 0.000416 239.8300n 0.000339 239.8400n 0.000274
+ 239.8500n 0.000223 239.8600n 0.000189 239.8700n 0.000171 239.8800n 0.000171 239.8900n 0.000189 239.9000n 0.000224 239.9100n 0.000275 239.9200n 0.000341 239.9300n 0.000420 239.9400n 0.000510 239.9500n 0.000608 239.9600n 0.000712 239.9700n 0.000817 239.9800n 0.000921 239.9900n 0.001022
+ 240.0000n 0.001114 240.0100n 0.001196 240.0200n 0.001265 240.0300n 0.001318 240.0400n 0.001353 240.0500n 0.001368 240.0600n 0.001362 240.0700n 0.001334 240.0800n 0.001284 240.0900n 0.001212 240.1000n 0.001120 240.1100n 0.001008 240.1200n 0.000879 240.1300n 0.000735 240.1400n 0.000578
+ 240.1500n 0.000413 240.1600n 0.000243 240.1700n 0.000071 240.1800n -0.000098 240.1900n -0.000261 240.2000n -0.000413 240.2100n -0.000552 240.2200n -0.000672 240.2300n -0.000772 240.2400n -0.000848 240.2500n -0.000898 240.2600n -0.000919 240.2700n -0.000911 240.2800n -0.000873 240.2900n -0.000804
+ 240.3000n -0.000706 240.3100n -0.000579 240.3200n -0.000426 240.3300n -0.000248 240.3400n -0.000049 240.3500n 0.000168 240.3600n 0.000400 240.3700n 0.000641 240.3800n 0.000887 240.3900n 0.001134 240.4000n 0.001377 240.4100n 0.001612 240.4200n 0.001833 240.4300n 0.002036 240.4400n 0.002218
+ 240.4500n 0.002375 240.4600n 0.002502 240.4700n 0.002599 240.4800n 0.002662 240.4900n 0.002690 240.5000n 0.002683 240.5100n 0.002639 240.5200n 0.002560 240.5300n 0.002447 240.5400n 0.002302 240.5500n 0.002126 240.5600n 0.001923 240.5700n 0.001697 240.5800n 0.001450 240.5900n 0.001188
+ 240.6000n 0.000914 240.6100n 0.000634 240.6200n 0.000351 240.6300n 0.000071 240.6400n -0.000202 240.6500n -0.000463 240.6600n -0.000710 240.6700n -0.000937 240.6800n -0.001143 240.6900n -0.001323 240.7000n -0.001475 240.7100n -0.001599 240.7200n -0.001693 240.7300n -0.001756 240.7400n -0.001788
+ 240.7500n -0.001790 240.7600n -0.001764 240.7700n -0.001710 240.7800n -0.001630 240.7900n -0.001529 240.8000n -0.001407 240.8100n -0.001268 240.8200n -0.001116 240.8300n -0.000954 240.8400n -0.000786 240.8500n -0.000614 240.8600n -0.000443 240.8700n -0.000275 240.8800n -0.000113 240.8900n 0.000039
+ 240.9000n 0.000179 240.9100n 0.000306 240.9200n 0.000418 240.9300n 0.000513 240.9400n 0.000590 240.9500n 0.000650 240.9600n 0.000692 240.9700n 0.000717 240.9800n 0.000725 240.9900n 0.000717 241.0000n 0.000695 241.0100n 0.000661 241.0200n 0.000615 241.0300n 0.000560 241.0400n 0.000498
+ 241.0500n 0.000431 241.0600n 0.000360 241.0700n 0.000289 241.0800n 0.000218 241.0900n 0.000148 241.1000n 0.000083 241.1100n 0.000021 241.1200n -0.000034 241.1300n -0.000084 241.1400n -0.000127 241.1500n -0.000163 241.1600n -0.000193 241.1700n -0.000217 241.1800n -0.000236 241.1900n -0.000249
+ 241.2000n -0.000260 241.2100n -0.000268 241.2200n -0.000274 241.2300n -0.000281 241.2400n -0.000288 241.2500n -0.000299 241.2600n -0.000313 241.2700n -0.000331 241.2800n -0.000356 241.2900n -0.000386 241.3000n -0.000423 241.3100n -0.000468 241.3200n -0.000520 241.3300n -0.000578 241.3400n -0.000643
+ 241.3500n -0.000715 241.3600n -0.000791 241.3700n -0.000871 241.3800n -0.000954 241.3900n -0.001039 241.4000n -0.001123 241.4100n -0.001206 241.4200n -0.001285 241.4300n -0.001359 241.4400n -0.001427 241.4500n -0.001487 241.4600n -0.001538 241.4700n -0.001578 241.4800n -0.001606 241.4900n -0.001623
+ 241.5000n -0.001627 241.5100n -0.001617 241.5200n -0.001595 241.5300n -0.001560 241.5400n -0.001513 241.5500n -0.001455 241.5600n -0.001387 241.5700n -0.001310 241.5800n -0.001227 241.5900n -0.001138 241.6000n -0.001046 241.6100n -0.000953 241.6200n -0.000860 241.6300n -0.000771 241.6400n -0.000688
+ 241.6500n -0.000611 241.6600n -0.000544 241.6700n -0.000488 241.6800n -0.000446 241.6900n -0.000417 241.7000n -0.000404 241.7100n -0.000407 241.7200n -0.000427 241.7300n -0.000465 241.7400n -0.000519 241.7500n -0.000591 241.7600n -0.000678 241.7700n -0.000780 241.7800n -0.000895 241.7900n -0.001023
+ 241.8000n -0.001160 241.8100n -0.001305 241.8200n -0.001456 241.8300n -0.001609 241.8400n -0.001762 241.8500n -0.001914 241.8600n -0.002060 241.8700n -0.002198 241.8800n -0.002326 241.8900n -0.002442 241.9000n -0.002543 241.9100n -0.002626 241.9200n -0.002691 241.9300n -0.002736 241.9400n -0.002759
+ 241.9500n -0.002759 241.9600n -0.002737 241.9700n -0.002691 241.9800n -0.002623 241.9900n -0.002532 242.0000n -0.002420 242.0100n -0.002287 242.0200n -0.002136 242.0300n -0.001968 242.0400n -0.001785 242.0500n -0.001589 242.0600n -0.001384 242.0700n -0.001172 242.0800n -0.000956 242.0900n -0.000738
+ 242.1000n -0.000521 242.1100n -0.000310 242.1200n -0.000105 242.1300n 0.000089 242.1400n 0.000271 242.1500n 0.000437 242.1600n 0.000587 242.1700n 0.000717 242.1800n 0.000827 242.1900n 0.000915 242.2000n 0.000979 242.2100n 0.001021 242.2200n 0.001038 242.2300n 0.001032 242.2400n 0.001003
+ 242.2500n 0.000951 242.2600n 0.000878 242.2700n 0.000786 242.2800n 0.000676 242.2900n 0.000549 242.3000n 0.000410 242.3100n 0.000259 242.3200n 0.000099 242.3300n -0.000066 242.3400n -0.000234 242.3500n -0.000402 242.3600n -0.000567 242.3700n -0.000727 242.3800n -0.000879 242.3900n -0.001020
+ 242.4000n -0.001149 242.4100n -0.001262 242.4200n -0.001359 242.4300n -0.001437 242.4400n -0.001496 242.4500n -0.001535 242.4600n -0.001553 242.4700n -0.001550 242.4800n -0.001526 242.4900n -0.001482 242.5000n -0.001419 242.5100n -0.001338 242.5200n -0.001240 242.5300n -0.001128 242.5400n -0.001003
+ 242.5500n -0.000867 242.5600n -0.000724 242.5700n -0.000575 242.5800n -0.000424 242.5900n -0.000273 242.6000n -0.000124 242.6100n 0.000020 242.6200n 0.000157 242.6300n 0.000284 242.6400n 0.000399 242.6500n 0.000501 242.6600n 0.000588 242.6700n 0.000658 242.6800n 0.000712 242.6900n 0.000748
+ 242.7000n 0.000767 242.7100n 0.000768 242.7200n 0.000753 242.7300n 0.000721 242.7400n 0.000676 242.7500n 0.000617 242.7600n 0.000548 242.7700n 0.000470 242.7800n 0.000385 242.7900n 0.000296 242.8000n 0.000206 242.8100n 0.000118 242.8200n 0.000032 242.8300n -0.000046 242.8400n -0.000116
+ 242.8500n -0.000176 242.8600n -0.000222 242.8700n -0.000253 242.8800n -0.000269 242.8900n -0.000267 242.9000n -0.000248 242.9100n -0.000210 242.9200n -0.000154 242.9300n -0.000082 242.9400n 0.000008 242.9500n 0.000112 242.9600n 0.000230 242.9700n 0.000360 242.9800n 0.000498 242.9900n 0.000643
+ 243.0000n 0.000791 243.0100n 0.000940 243.0200n 0.001087 243.0300n 0.001228 243.0400n 0.001361 243.0500n 0.001483 243.0600n 0.001590 243.0700n 0.001681 243.0800n 0.001754 243.0900n 0.001806 243.1000n 0.001836 243.1100n 0.001843 243.1200n 0.001828 243.1300n 0.001789 243.1400n 0.001727
+ 243.1500n 0.001643 243.1600n 0.001539 243.1700n 0.001416 243.1800n 0.001277 243.1900n 0.001125 243.2000n 0.000963 243.2100n 0.000794 243.2200n 0.000622 243.2300n 0.000450 243.2400n 0.000283 243.2500n 0.000124 243.2600n -0.000024 243.2700n -0.000156 243.2800n -0.000269 243.2900n -0.000361
+ 243.3000n -0.000428 243.3100n -0.000469 243.3200n -0.000481 243.3300n -0.000464 243.3400n -0.000418 243.3500n -0.000342 243.3600n -0.000236 243.3700n -0.000102 243.3800n 0.000058 243.3900n 0.000241 243.4000n 0.000446 243.4100n 0.000668 243.4200n 0.000905 243.4300n 0.001151 243.4400n 0.001402
+ 243.4500n 0.001655 243.4600n 0.001905 243.4700n 0.002146 243.4800n 0.002375 243.4900n 0.002586 243.5000n 0.002777 243.5100n 0.002944 243.5200n 0.003082 243.5300n 0.003189 243.5400n 0.003264 243.5500n 0.003304 243.5600n 0.003308 243.5700n 0.003276 243.5800n 0.003208 243.5900n 0.003105
+ 243.6000n 0.002968 243.6100n 0.002799 243.6200n 0.002601 243.6300n 0.002378 243.6400n 0.002132 243.6500n 0.001867 243.6600n 0.001588 243.6700n 0.001299 243.6800n 0.001004 243.6900n 0.000708 243.7000n 0.000416 243.7100n 0.000131 243.7200n -0.000142 243.7300n -0.000401 243.7400n -0.000640
+ 243.7500n -0.000858 243.7600n -0.001053 243.7700n -0.001221 243.7800n -0.001363 243.7900n -0.001477 243.8000n -0.001564 243.8100n -0.001623 243.8200n -0.001656 243.8300n -0.001665 243.8400n -0.001651 243.8500n -0.001616 243.8600n -0.001564 243.8700n -0.001498 243.8800n -0.001420 243.8900n -0.001335
+ 243.9000n -0.001245 243.9100n -0.001154 243.9200n -0.001065 243.9300n -0.000982 243.9400n -0.000907 243.9500n -0.000843 243.9600n -0.000792 243.9700n -0.000755 243.9800n -0.000735 243.9900n -0.000731 244.0000n -0.000745 244.0100n -0.000776 244.0200n -0.000823 244.0300n -0.000886 244.0400n -0.000963
+ 244.0500n -0.001052 244.0600n -0.001152 244.0700n -0.001259 244.0800n -0.001372 244.0900n -0.001487 244.1000n -0.001602 244.1100n -0.001714 244.1200n -0.001821 244.1300n -0.001920 244.1400n -0.002009 244.1500n -0.002086 244.1600n -0.002149 244.1700n -0.002197 244.1800n -0.002229 244.1900n -0.002244
+ 244.2000n -0.002244 244.2100n -0.002227 244.2200n -0.002195 244.2300n -0.002149 244.2400n -0.002090 244.2500n -0.002021 244.2600n -0.001943 244.2700n -0.001859 244.2800n -0.001772 244.2900n -0.001684 244.3000n -0.001598 244.3100n -0.001516 244.3200n -0.001441 244.3300n -0.001375 244.3400n -0.001320
+ 244.3500n -0.001278 244.3600n -0.001250 244.3700n -0.001238 244.3800n -0.001242 244.3900n -0.001262 244.4000n -0.001298 244.4100n -0.001349 244.4200n -0.001415 244.4300n -0.001493 244.4400n -0.001582 244.4500n -0.001679 244.4600n -0.001782 244.4700n -0.001888 244.4800n -0.001995 244.4900n -0.002099
+ 244.5000n -0.002197 244.5100n -0.002287 244.5200n -0.002365 244.5300n -0.002429 244.5400n -0.002476 244.5500n -0.002505 244.5600n -0.002514 244.5700n -0.002500 244.5800n -0.002464 244.5900n -0.002405 244.6000n -0.002323 244.6100n -0.002219 244.6200n -0.002093 244.6300n -0.001948 244.6400n -0.001784
+ 244.6500n -0.001605 244.6600n -0.001412 244.6700n -0.001209 244.6800n -0.001000 244.6900n -0.000786 244.7000n -0.000572 244.7100n -0.000361 244.7200n -0.000156 244.7300n 0.000040 244.7400n 0.000223 244.7500n 0.000392 244.7600n 0.000542 244.7700n 0.000673 244.7800n 0.000784 244.7900n 0.000872
+ 244.8000n 0.000936 244.8100n 0.000978 244.8200n 0.000997 244.8300n 0.000993 244.8400n 0.000969 244.8500n 0.000924 244.8600n 0.000862 244.8700n 0.000785 244.8800n 0.000694 244.8900n 0.000593 244.9000n 0.000485 244.9100n 0.000372 244.9200n 0.000257 244.9300n 0.000143 244.9400n 0.000033
+ 244.9500n -0.000070 244.9600n -0.000166 244.9700n -0.000250 244.9800n -0.000323 244.9900n -0.000381 245.0000n -0.000426 245.0100n -0.000456 245.0200n -0.000471 245.0300n -0.000471 245.0400n -0.000457 245.0500n -0.000430 245.0600n -0.000392 245.0700n -0.000344 245.0800n -0.000288 245.0900n -0.000226
+ 245.1000n -0.000160 245.1100n -0.000092 245.1200n -0.000025 245.1300n 0.000039 245.1400n 0.000099 245.1500n 0.000152 245.1600n 0.000197 245.1700n 0.000233 245.1800n 0.000258 245.1900n 0.000271 245.2000n 0.000273 245.2100n 0.000263 245.2200n 0.000242 245.2300n 0.000211 245.2400n 0.000169
+ 245.2500n 0.000120 245.2600n 0.000063 245.2700n 0.000002 245.2800n -0.000062 245.2900n -0.000128 245.3000n -0.000191 245.3100n -0.000252 245.3200n -0.000307 245.3300n -0.000354 245.3400n -0.000393 245.3500n -0.000420 245.3600n -0.000435 245.3700n -0.000437 245.3800n -0.000424 245.3900n -0.000398
+ 245.4000n -0.000357 245.4100n -0.000303 245.4200n -0.000236 245.4300n -0.000157 245.4400n -0.000068 245.4500n 0.000029 245.4600n 0.000133 245.4700n 0.000240 245.4800n 0.000349 245.4900n 0.000456 245.5000n 0.000560 245.5100n 0.000657 245.5200n 0.000745 245.5300n 0.000822 245.5400n 0.000885
+ 245.5500n 0.000933 245.5600n 0.000963 245.5700n 0.000975 245.5800n 0.000968 245.5900n 0.000941 245.6000n 0.000894 245.6100n 0.000829 245.6200n 0.000745 245.6300n 0.000645 245.6400n 0.000529 245.6500n 0.000401 245.6600n 0.000263 245.6700n 0.000117 245.6800n -0.000033 245.6900n -0.000185
+ 245.7000n -0.000334 245.7100n -0.000477 245.7200n -0.000612 245.7300n -0.000734 245.7400n -0.000841 245.7500n -0.000930 245.7600n -0.000997 245.7700n -0.001043 245.7800n -0.001063 245.7900n -0.001058 245.8000n -0.001025 245.8100n -0.000966 245.8200n -0.000879 245.8300n -0.000767 245.8400n -0.000629
+ 245.8500n -0.000468 245.8600n -0.000285 245.8700n -0.000083 245.8800n 0.000134 245.8900n 0.000364 245.9000n 0.000604 245.9100n 0.000849 245.9200n 0.001096 245.9300n 0.001342 245.9400n 0.001582 245.9500n 0.001813 245.9600n 0.002032 245.9700n 0.002235 245.9800n 0.002419 245.9900n 0.002582
+ 246.0000n 0.002722 246.0100n 0.002837 246.0200n 0.002926 246.0300n 0.002988 246.0400n 0.003022 246.0500n 0.003029 246.0600n 0.003009 246.0700n 0.002963 246.0800n 0.002894 246.0900n 0.002801 246.1000n 0.002689 246.1100n 0.002559 246.1200n 0.002414 246.1300n 0.002256 246.1400n 0.002089
+ 246.1500n 0.001916 246.1600n 0.001739 246.1700n 0.001562 246.1800n 0.001387 246.1900n 0.001217 246.2000n 0.001054 246.2100n 0.000900 246.2200n 0.000757 246.2300n 0.000627 246.2400n 0.000511 246.2500n 0.000409 246.2600n 0.000322 246.2700n 0.000250 246.2800n 0.000193 246.2900n 0.000149
+ 246.3000n 0.000119 246.3100n 0.000101 246.3200n 0.000094 246.3300n 0.000096 246.3400n 0.000105 246.3500n 0.000120 246.3600n 0.000138 246.3700n 0.000158 246.3800n 0.000177 246.3900n 0.000195 246.4000n 0.000208 246.4100n 0.000216 246.4200n 0.000217 246.4300n 0.000210 246.4400n 0.000194
+ 246.4500n 0.000167 246.4600n 0.000130 246.4700n 0.000082 246.4800n 0.000023 246.4900n -0.000048 246.5000n -0.000129 246.5100n -0.000220 246.5200n -0.000320 246.5300n -0.000429 246.5400n -0.000545 246.5500n -0.000667 246.5600n -0.000793 246.5700n -0.000923 246.5800n -0.001054 246.5900n -0.001185
+ 246.6000n -0.001315 246.6100n -0.001442 246.6200n -0.001565 246.6300n -0.001681 246.6400n -0.001790 246.6500n -0.001890 246.6600n -0.001981 246.6700n -0.002060 246.6800n -0.002127 246.6900n -0.002181 246.7000n -0.002222 246.7100n -0.002248 246.7200n -0.002258 246.7300n -0.002253 246.7400n -0.002233
+ 246.7500n -0.002196 246.7600n -0.002143 246.7700n -0.002074 246.7800n -0.001988 246.7900n -0.001887 246.8000n -0.001770 246.8100n -0.001638 246.8200n -0.001491 246.8300n -0.001330 246.8400n -0.001157 246.8500n -0.000971 246.8600n -0.000773 246.8700n -0.000566 246.8800n -0.000350 246.8900n -0.000126
+ 246.9000n 0.000103 246.9100n 0.000337 246.9200n 0.000574 246.9300n 0.000811 246.9400n 0.001048 246.9500n 0.001281 246.9600n 0.001509 246.9700n 0.001729 246.9800n 0.001941 246.9900n 0.002140 247.0000n 0.002327 247.0100n 0.002498 247.0200n 0.002651 247.0300n 0.002785 247.0400n 0.002898
+ 247.0500n 0.002989 247.0600n 0.003056 247.0700n 0.003098 247.0800n 0.003114 247.0900n 0.003105 247.1000n 0.003069 247.1100n 0.003007 247.1200n 0.002919 247.1300n 0.002806 247.1400n 0.002669 247.1500n 0.002509 247.1600n 0.002328 247.1700n 0.002128 247.1800n 0.001912 247.1900n 0.001681
+ 247.2000n 0.001439 247.2100n 0.001188 247.2200n 0.000931 247.2300n 0.000671 247.2400n 0.000412 247.2500n 0.000157 247.2600n -0.000092 247.2700n -0.000332 247.2800n -0.000559 247.2900n -0.000771 247.3000n -0.000965 247.3100n -0.001141 247.3200n -0.001295 247.3300n -0.001426 247.3400n -0.001534
+ 247.3500n -0.001617 247.3600n -0.001675 247.3700n -0.001708 247.3800n -0.001717 247.3900n -0.001702 247.4000n -0.001665 247.4100n -0.001606 247.4200n -0.001527 247.4300n -0.001430 247.4400n -0.001318 247.4500n -0.001193 247.4600n -0.001057 247.4700n -0.000912 247.4800n -0.000761 247.4900n -0.000606
+ 247.5000n -0.000450 247.5100n -0.000296 247.5200n -0.000144 247.5300n 0.000002 247.5400n 0.000142 247.5500n 0.000273 247.5600n 0.000395 247.5700n 0.000506 247.5800n 0.000607 247.5900n 0.000696 247.6000n 0.000773 247.6100n 0.000840 247.6200n 0.000895 247.6300n 0.000940 247.6400n 0.000975
+ 247.6500n 0.001003 247.6600n 0.001022 247.6700n 0.001036 247.6800n 0.001045 247.6900n 0.001050 247.7000n 0.001053 247.7100n 0.001054 247.7200n 0.001055 247.7300n 0.001058 247.7400n 0.001062 247.7500n 0.001068 247.7600n 0.001077 247.7700n 0.001089 247.7800n 0.001105 247.7900n 0.001124
+ 247.8000n 0.001145 247.8100n 0.001169 247.8200n 0.001195 247.8300n 0.001222 247.8400n 0.001249 247.8500n 0.001276 247.8600n 0.001300 247.8700n 0.001322 247.8800n 0.001341 247.8900n 0.001355 247.9000n 0.001363 247.9100n 0.001365 247.9200n 0.001360 247.9300n 0.001347 247.9400n 0.001327
+ 247.9500n 0.001299 247.9600n 0.001263 247.9700n 0.001219 247.9800n 0.001169 247.9900n 0.001111 248.0000n 0.001049 248.0100n 0.000981 248.0200n 0.000910 248.0300n 0.000837 248.0400n 0.000762 248.0500n 0.000689 248.0600n 0.000617 248.0700n 0.000548 248.0800n 0.000484 248.0900n 0.000425
+ 248.1000n 0.000374 248.1100n 0.000331 248.1200n 0.000297 248.1300n 0.000273 248.1400n 0.000258 248.1500n 0.000254 248.1600n 0.000261 248.1700n 0.000278 248.1800n 0.000305 248.1900n 0.000341 248.2000n 0.000385 248.2100n 0.000437 248.2200n 0.000494 248.2300n 0.000557 248.2400n 0.000623
+ 248.2500n 0.000691 248.2600n 0.000759 248.2700n 0.000826 248.2800n 0.000889 248.2900n 0.000949 248.3000n 0.001003 248.3100n 0.001049 248.3200n 0.001088 248.3300n 0.001117 248.3400n 0.001137 248.3500n 0.001147 248.3600n 0.001146 248.3700n 0.001134 248.3800n 0.001111 248.3900n 0.001079
+ 248.4000n 0.001037 248.4100n 0.000986 248.4200n 0.000928 248.4300n 0.000863 248.4400n 0.000792 248.4500n 0.000718 248.4600n 0.000640 248.4700n 0.000562 248.4800n 0.000484 248.4900n 0.000407 248.5000n 0.000333 248.5100n 0.000264 248.5200n 0.000200 248.5300n 0.000142 248.5400n 0.000091
+ 248.5500n 0.000047 248.5600n 0.000012 248.5700n -0.000015 248.5800n -0.000033 248.5900n -0.000043 248.6000n -0.000045 248.6100n -0.000040 248.6200n -0.000028 248.6300n -0.000010 248.6400n 0.000013 248.6500n 0.000040 248.6600n 0.000070 248.6700n 0.000102 248.6800n 0.000135 248.6900n 0.000167
+ 248.7000n 0.000199 248.7100n 0.000228 248.7200n 0.000254 248.7300n 0.000277 248.7400n 0.000295 248.7500n 0.000309 248.7600n 0.000317 248.7700n 0.000320 248.7800n 0.000318 248.7900n 0.000311 248.8000n 0.000300 248.8100n 0.000284 248.8200n 0.000264 248.8300n 0.000241 248.8400n 0.000216
+ 248.8500n 0.000189 248.8600n 0.000162 248.8700n 0.000134 248.8800n 0.000108 248.8900n 0.000083 248.9000n 0.000060 248.9100n 0.000040 248.9200n 0.000024 248.9300n 0.000012 248.9400n 0.000004 248.9500n 0.000001 248.9600n 0.000002 248.9700n 0.000008 248.9800n 0.000019 248.9900n 0.000034
+ 249.0000n 0.000053 249.0100n 0.000076 249.0200n 0.000101 249.0300n 0.000129 249.0400n 0.000160 249.0500n 0.000191 249.0600n 0.000223 249.0700n 0.000256 249.0800n 0.000288 249.0900n 0.000319 249.1000n 0.000349 249.1100n 0.000378 249.1200n 0.000405 249.1300n 0.000430 249.1400n 0.000453
+ 249.1500n 0.000474 249.1600n 0.000493 249.1700n 0.000511 249.1800n 0.000527 249.1900n 0.000543 249.2000n 0.000558 249.2100n 0.000574 249.2200n 0.000590 249.2300n 0.000607 249.2400n 0.000625 249.2500n 0.000646 249.2600n 0.000669 249.2700n 0.000694 249.2800n 0.000723 249.2900n 0.000754
+ 249.3000n 0.000789 249.3100n 0.000826 249.3200n 0.000867 249.3300n 0.000909 249.3400n 0.000954 249.3500n 0.001000 249.3600n 0.001047 249.3700n 0.001095 249.3800n 0.001141 249.3900n 0.001187 249.4000n 0.001230 249.4100n 0.001270 249.4200n 0.001306 249.4300n 0.001338 249.4400n 0.001365
+ 249.4500n 0.001385 249.4600n 0.001399 249.4700n 0.001406 249.4800n 0.001406 249.4900n 0.001398 249.5000n 0.001383 249.5100n 0.001360 249.5200n 0.001330 249.5300n 0.001293 249.5400n 0.001250 249.5500n 0.001202 249.5600n 0.001148 249.5700n 0.001090 249.5800n 0.001028 249.5900n 0.000964
+ 249.6000n 0.000898 249.6100n 0.000831 249.6200n 0.000764 249.6300n 0.000698 249.6400n 0.000633 249.6500n 0.000570 249.6600n 0.000509 249.6700n 0.000451 249.6800n 0.000396 249.6900n 0.000344 249.7000n 0.000295 249.7100n 0.000249 249.7200n 0.000205 249.7300n 0.000163 249.7400n 0.000122
+ 249.7500n 0.000082 249.7600n 0.000042 249.7700n 0.000001 249.7800n -0.000041 249.7900n -0.000086 249.8000n -0.000133 249.8100n -0.000184 249.8200n -0.000239 249.8300n -0.000298 249.8400n -0.000362 249.8500n -0.000431 249.8600n -0.000504 249.8700n -0.000581 249.8800n -0.000662 249.8900n -0.000746
+ 249.9000n -0.000832 249.9100n -0.000919 249.9200n -0.001007 249.9300n -0.001092 249.9400n -0.001175 249.9500n -0.001253 249.9600n -0.001325 249.9700n -0.001390 249.9800n -0.001445 249.9900n -0.001489 250.0000n -0.001522 250.0100n -0.001541 250.0200n -0.001545 250.0300n -0.001535 250.0400n -0.001508
+ 250.0500n -0.001466 250.0600n -0.001407 250.0700n -0.001332 250.0800n -0.001241 250.0900n -0.001136 250.1000n -0.001018 250.1100n -0.000887 250.1200n -0.000746 250.1300n -0.000597 250.1400n -0.000441 250.1500n -0.000281 250.1600n -0.000119 250.1700n 0.000043 250.1800n 0.000202 250.1900n 0.000355
+ 250.2000n 0.000500 250.2100n 0.000636 250.2200n 0.000761 250.2300n 0.000871 250.2400n 0.000967 250.2500n 0.001047 250.2600n 0.001110 250.2700n 0.001156 250.2800n 0.001184 250.2900n 0.001195 250.3000n 0.001189 250.3100n 0.001168 250.3200n 0.001131 250.3300n 0.001082 250.3400n 0.001021
+ 250.3500n 0.000951 250.3600n 0.000874 250.3700n 0.000792 250.3800n 0.000708 250.3900n 0.000623 250.4000n 0.000540 250.4100n 0.000462 250.4200n 0.000389 250.4300n 0.000325 250.4400n 0.000270 250.4500n 0.000225 250.4600n 0.000192 250.4700n 0.000172 250.4800n 0.000164 250.4900n 0.000168
+ 250.5000n 0.000184 250.5100n 0.000210 250.5200n 0.000246 250.5300n 0.000291 250.5400n 0.000341 250.5500n 0.000396 250.5600n 0.000454 250.5700n 0.000511 250.5800n 0.000566 250.5900n 0.000617 250.6000n 0.000661 250.6100n 0.000696 250.6200n 0.000720 250.6300n 0.000732 250.6400n 0.000731
+ 250.6500n 0.000715 250.6600n 0.000683 250.6700n 0.000637 250.6800n 0.000575 250.6900n 0.000498 250.7000n 0.000407 250.7100n 0.000304 250.7200n 0.000191 250.7300n 0.000069 250.7400n -0.000059 250.7500n -0.000191 250.7600n -0.000323 250.7700n -0.000454 250.7800n -0.000579 250.7900n -0.000697
+ 250.8000n -0.000803 250.8100n -0.000897 250.8200n -0.000974 250.8300n -0.001034 250.8400n -0.001074 250.8500n -0.001094 250.8600n -0.001091 250.8700n -0.001067 250.8800n -0.001020 250.8900n -0.000952 250.9000n -0.000864 250.9100n -0.000757 250.9200n -0.000633 250.9300n -0.000495 250.9400n -0.000345
+ 250.9500n -0.000187 250.9600n -0.000024 250.9700n 0.000140 250.9800n 0.000302 250.9900n 0.000458 251.0000n 0.000604 251.0100n 0.000738 251.0200n 0.000855 251.0300n 0.000953 251.0400n 0.001030 251.0500n 0.001082 251.0600n 0.001110 251.0700n 0.001111 251.0800n 0.001084 251.0900n 0.001031
+ 251.1000n 0.000952 251.1100n 0.000847 251.1200n 0.000719 251.1300n 0.000570 251.1400n 0.000402 251.1500n 0.000219 251.1600n 0.000024 251.1700n -0.000178 251.1800n -0.000386 251.1900n -0.000593 251.2000n -0.000796 251.2100n -0.000992 251.2200n -0.001175 251.2300n -0.001344 251.2400n -0.001494
+ 251.2500n -0.001623 251.2600n -0.001728 251.2700n -0.001808 251.2800n -0.001862 251.2900n -0.001888 251.3000n -0.001886 251.3100n -0.001858 251.3200n -0.001804 251.3300n -0.001726 251.3400n -0.001626 251.3500n -0.001506 251.3600n -0.001371 251.3700n -0.001223 251.3800n -0.001065 251.3900n -0.000903
+ 251.4000n -0.000739 251.4100n -0.000577 251.4200n -0.000422 251.4300n -0.000277 251.4400n -0.000145 251.4500n -0.000029 251.4600n 0.000067 251.4700n 0.000144 251.4800n 0.000197 251.4900n 0.000227 251.5000n 0.000234 251.5100n 0.000217 251.5200n 0.000177 251.5300n 0.000115 251.5400n 0.000034
+ 251.5500n -0.000065 251.5600n -0.000178 251.5700n -0.000303 251.5800n -0.000436 251.5900n -0.000573 251.6000n -0.000712 251.6100n -0.000848 251.6200n -0.000978 251.6300n -0.001098 251.6400n -0.001206 251.6500n -0.001298 251.6600n -0.001372 251.6700n -0.001427 251.6800n -0.001460 251.6900n -0.001471
+ 251.7000n -0.001460 251.7100n -0.001427 251.7200n -0.001373 251.7300n -0.001300 251.7400n -0.001208 251.7500n -0.001102 251.7600n -0.000983 251.7700n -0.000855 251.7800n -0.000722 251.7900n -0.000587 251.8000n -0.000454 251.8100n -0.000326 251.8200n -0.000208 251.8300n -0.000103 251.8400n -0.000014
+ 251.8500n 0.000057 251.8600n 0.000105 251.8700n 0.000131 251.8800n 0.000132 251.8900n 0.000107 251.9000n 0.000057 251.9100n -0.000018 251.9200n -0.000118 251.9300n -0.000240 251.9400n -0.000382 251.9500n -0.000541 251.9600n -0.000715 251.9700n -0.000899 251.9800n -0.001089 251.9900n -0.001282
+ 252.0000n -0.001474 252.0100n -0.001658 252.0200n -0.001833 252.0300n -0.001993 252.0400n -0.002135 252.0500n -0.002255 252.0600n -0.002350 252.0700n -0.002418 252.0800n -0.002457 252.0900n -0.002466 252.1000n -0.002445 252.1100n -0.002392 252.1200n -0.002309 252.1300n -0.002198 252.1400n -0.002060
+ 252.1500n -0.001898 252.1600n -0.001716 252.1700n -0.001516 252.1800n -0.001303 252.1900n -0.001082 252.2000n -0.000856 252.2100n -0.000630 252.2200n -0.000410 252.2300n -0.000199 252.2400n -0.000001 252.2500n 0.000179 252.2600n 0.000338 252.2700n 0.000473 252.2800n 0.000581 252.2900n 0.000660
+ 252.3000n 0.000710 252.3100n 0.000730 252.3200n 0.000719 252.3300n 0.000680 252.3400n 0.000612 252.3500n 0.000520 252.3600n 0.000404 252.3700n 0.000268 252.3800n 0.000117 252.3900n -0.000046 252.4000n -0.000216 252.4100n -0.000390 252.4200n -0.000562 252.4300n -0.000728 252.4400n -0.000884
+ 252.4500n -0.001026 252.4600n -0.001150 252.4700n -0.001252 252.4800n -0.001330 252.4900n -0.001381 252.5000n -0.001405 252.5100n -0.001400 252.5200n -0.001365 252.5300n -0.001302 252.5400n -0.001211 252.5500n -0.001095 252.5600n -0.000955 252.5700n -0.000794 252.5800n -0.000615 252.5900n -0.000424
+ 252.6000n -0.000222 252.6100n -0.000016 252.6200n 0.000191 252.6300n 0.000395 252.6400n 0.000591 252.6500n 0.000774 252.6600n 0.000942 252.6700n 0.001090 252.6800n 0.001215 252.6900n 0.001316 252.7000n 0.001389 252.7100n 0.001434 252.7200n 0.001449 252.7300n 0.001436 252.7400n 0.001393
+ 252.7500n 0.001323 252.7600n 0.001226 252.7700n 0.001106 252.7800n 0.000966 252.7900n 0.000807 252.8000n 0.000634 252.8100n 0.000451 252.8200n 0.000261 252.8300n 0.000068 252.8400n -0.000123 252.8500n -0.000309 252.8600n -0.000487 252.8700n -0.000653 252.8800n -0.000803 252.8900n -0.000937
+ 252.9000n -0.001051 252.9100n -0.001145 252.9200n -0.001217 252.9300n -0.001267 252.9400n -0.001295 252.9500n -0.001303 252.9600n -0.001290 252.9700n -0.001260 252.9800n -0.001214 252.9900n -0.001155 253.0000n -0.001086 253.0100n -0.001010 253.0200n -0.000929 253.0300n -0.000848 253.0400n -0.000769
+ 253.0500n -0.000695 253.0600n -0.000629 253.0700n -0.000573 253.0800n -0.000531 253.0900n -0.000502 253.1000n -0.000489 253.1100n -0.000493 253.1200n -0.000512 253.1300n -0.000548 253.1400n -0.000600 253.1500n -0.000665 253.1600n -0.000742 253.1700n -0.000829 253.1800n -0.000923 253.1900n -0.001022
+ 253.2000n -0.001121 253.2100n -0.001219 253.2200n -0.001311 253.2300n -0.001395 253.2400n -0.001467 253.2500n -0.001524 253.2600n -0.001564 253.2700n -0.001584 253.2800n -0.001583 253.2900n -0.001559 253.3000n -0.001511 253.3100n -0.001439 253.3200n -0.001344 253.3300n -0.001227 253.3400n -0.001088
+ 253.3500n -0.000930 253.3600n -0.000756 253.3700n -0.000569 253.3800n -0.000372 253.3900n -0.000169 253.4000n 0.000037 253.4100n 0.000240 253.4200n 0.000437 253.4300n 0.000623 253.4400n 0.000795 253.4500n 0.000948 253.4600n 0.001078 253.4700n 0.001184 253.4800n 0.001262 253.4900n 0.001309
+ 253.5000n 0.001325 253.5100n 0.001309 253.5200n 0.001260 253.5300n 0.001178 253.5400n 0.001065 253.5500n 0.000923 253.5600n 0.000753 253.5700n 0.000559 253.5800n 0.000344 253.5900n 0.000113 253.6000n -0.000132 253.6100n -0.000384 253.6200n -0.000640 253.6300n -0.000895 253.6400n -0.001144
+ 253.6500n -0.001383 253.6600n -0.001606 253.6700n -0.001810 253.6800n -0.001992 253.6900n -0.002148 253.7000n -0.002274 253.7100n -0.002370 253.7200n -0.002434 253.7300n -0.002465 253.7400n -0.002462 253.7500n -0.002426 253.7600n -0.002358 253.7700n -0.002261 253.7800n -0.002135 253.7900n -0.001984
+ 253.8000n -0.001812 253.8100n -0.001621 253.8200n -0.001415 253.8300n -0.001199 253.8400n -0.000977 253.8500n -0.000752 253.8600n -0.000529 253.8700n -0.000312 253.8800n -0.000104 253.8900n 0.000092 253.9000n 0.000272 253.9100n 0.000435 253.9200n 0.000578 253.9300n 0.000699 253.9400n 0.000799
+ 253.9500n 0.000876 253.9600n 0.000930 253.9700n 0.000964 253.9800n 0.000976 253.9900n 0.000970 254.0000n 0.000947 254.0100n 0.000910 254.0200n 0.000861 254.0300n 0.000802 254.0400n 0.000738 254.0500n 0.000670 254.0600n 0.000601 254.0700n 0.000535 254.0800n 0.000473 254.0900n 0.000418
+ 254.1000n 0.000372 254.1100n 0.000337 254.1200n 0.000313 254.1300n 0.000303 254.1400n 0.000305 254.1500n 0.000320 254.1600n 0.000347 254.1700n 0.000387 254.1800n 0.000436 254.1900n 0.000495 254.2000n 0.000560 254.2100n 0.000630 254.2200n 0.000703 254.2300n 0.000776 254.2400n 0.000847
+ 254.2500n 0.000913 254.2600n 0.000973 254.2700n 0.001023 254.2800n 0.001063 254.2900n 0.001091 254.3000n 0.001105 254.3100n 0.001104 254.3200n 0.001088 254.3300n 0.001057 254.3400n 0.001010 254.3500n 0.000950 254.3600n 0.000876 254.3700n 0.000789 254.3800n 0.000693 254.3900n 0.000589
+ 254.4000n 0.000478 254.4100n 0.000364 254.4200n 0.000249 254.4300n 0.000136 254.4400n 0.000026 254.4500n -0.000076 254.4600n -0.000170 254.4700n -0.000252 254.4800n -0.000321 254.4900n -0.000376 254.5000n -0.000414 254.5100n -0.000436 254.5200n -0.000440 254.5300n -0.000427 254.5400n -0.000397
+ 254.5500n -0.000351 254.5600n -0.000290 254.5700n -0.000216 254.5800n -0.000130 254.5900n -0.000035 254.6000n 0.000067 254.6100n 0.000173 254.6200n 0.000281 254.6300n 0.000387 254.6400n 0.000489 254.6500n 0.000584 254.6600n 0.000669 254.6700n 0.000743 254.6800n 0.000802 254.6900n 0.000845
+ 254.7000n 0.000871 254.7100n 0.000878 254.7200n 0.000865 254.7300n 0.000833 254.7400n 0.000781 254.7500n 0.000709 254.7600n 0.000619 254.7700n 0.000511 254.7800n 0.000388 254.7900n 0.000251 254.8000n 0.000102 254.8100n -0.000056 254.8200n -0.000221 254.8300n -0.000390 254.8400n -0.000561
+ 254.8500n -0.000731 254.8600n -0.000897 254.8700n -0.001058 254.8800n -0.001210 254.8900n -0.001353 254.9000n -0.001483 254.9100n -0.001601 254.9200n -0.001704 254.9300n -0.001793 254.9400n -0.001866 254.9500n -0.001923 254.9600n -0.001965 254.9700n -0.001993 254.9800n -0.002007 254.9900n -0.002007
+ 255.0000n -0.001997 255.0100n -0.001975 255.0200n -0.001946 255.0300n -0.001909 255.0400n -0.001866 255.0500n -0.001820 255.0600n -0.001771 255.0700n -0.001722 255.0800n -0.001672 255.0900n -0.001623 255.1000n -0.001577 255.1100n -0.001534 255.1200n -0.001493 255.1300n -0.001456 255.1400n -0.001422
+ 255.1500n -0.001391 255.1600n -0.001363 255.1700n -0.001336 255.1800n -0.001311 255.1900n -0.001286 255.2000n -0.001260 255.2100n -0.001232 255.2200n -0.001202 255.2300n -0.001169 255.2400n -0.001131 255.2500n -0.001089 255.2600n -0.001041 255.2700n -0.000988 255.2800n -0.000929 255.2900n -0.000865
+ 255.3000n -0.000797 255.3100n -0.000724 255.3200n -0.000649 255.3300n -0.000572 255.3400n -0.000495 255.3500n -0.000419 255.3600n -0.000346 255.3700n -0.000277 255.3800n -0.000216 255.3900n -0.000163 255.4000n -0.000121 255.4100n -0.000091 255.4200n -0.000074 255.4300n -0.000073 255.4400n -0.000087
+ 255.4500n -0.000119 255.4600n -0.000167 255.4700n -0.000233 255.4800n -0.000316 255.4900n -0.000416 255.5000n -0.000530 255.5100n -0.000658 255.5200n -0.000798 255.5300n -0.000947 255.5400n -0.001104 255.5500n -0.001264 255.5600n -0.001427 255.5700n -0.001587 255.5800n -0.001743 255.5900n -0.001891
+ 255.6000n -0.002027 255.6100n -0.002150 255.6200n -0.002256 255.6300n -0.002342 255.6400n -0.002407 255.6500n -0.002450 255.6600n -0.002468 255.6700n -0.002461 255.6800n -0.002428 255.6900n -0.002371 255.7000n -0.002289 255.7100n -0.002185 255.7200n -0.002059 255.7300n -0.001914 255.7400n -0.001754
+ 255.7500n -0.001580 255.7600n -0.001397 255.7700n -0.001208 255.7800n -0.001017 255.7900n -0.000828 255.8000n -0.000645 255.8100n -0.000472 255.8200n -0.000312 255.8300n -0.000169 255.8400n -0.000045 255.8500n 0.000056 255.8600n 0.000132 255.8700n 0.000182 255.8800n 0.000205 255.8900n 0.000200
+ 255.9000n 0.000167 255.9100n 0.000108 255.9200n 0.000023 255.9300n -0.000085 255.9400n -0.000213 255.9500n -0.000359 255.9600n -0.000519 255.9700n -0.000689 255.9800n -0.000865 255.9900n -0.001043 256.0000n -0.001218 256.0100n -0.001385 256.0200n -0.001540 256.0300n -0.001678 256.0400n -0.001797
+ 256.0500n -0.001892 256.0600n -0.001961 256.0700n -0.002000 256.0800n -0.002007 256.0900n -0.001982 256.1000n -0.001924 256.1100n -0.001832 256.1200n -0.001708 256.1300n -0.001552 256.1400n -0.001368 256.1500n -0.001157 256.1600n -0.000923 256.1700n -0.000669 256.1800n -0.000401 256.1900n -0.000122
+ 256.2000n 0.000163 256.2100n 0.000448 256.2200n 0.000730 256.2300n 0.001002 256.2400n 0.001260 256.2500n 0.001500 256.2600n 0.001717 256.2700n 0.001908 256.2800n 0.002070 256.2900n 0.002199 256.3000n 0.002295 256.3100n 0.002355 256.3200n 0.002380 256.3300n 0.002369 256.3400n 0.002324
+ 256.3500n 0.002245 256.3600n 0.002136 256.3700n 0.001998 256.3800n 0.001835 256.3900n 0.001651 256.4000n 0.001450 256.4100n 0.001237 256.4200n 0.001015 256.4300n 0.000790 256.4400n 0.000565 256.4500n 0.000347 256.4600n 0.000138 256.4700n -0.000057 256.4800n -0.000235 256.4900n -0.000393
+ 256.5000n -0.000529 256.5100n -0.000640 256.5200n -0.000725 256.5300n -0.000784 256.5400n -0.000817 256.5500n -0.000825 256.5600n -0.000809 256.5700n -0.000771 256.5800n -0.000713 256.5900n -0.000639 256.6000n -0.000552 256.6100n -0.000456 256.6200n -0.000354 256.6300n -0.000251 256.6400n -0.000151
+ 256.6500n -0.000057 256.6600n 0.000026 256.6700n 0.000095 256.6800n 0.000146 256.6900n 0.000177 256.7000n 0.000185 256.7100n 0.000169 256.7200n 0.000128 256.7300n 0.000061 256.7400n -0.000032 256.7500n -0.000150 256.7600n -0.000292 256.7700n -0.000455 256.7800n -0.000636 256.7900n -0.000833
+ 256.8000n -0.001042 256.8100n -0.001259 256.8200n -0.001480 256.8300n -0.001700 256.8400n -0.001914 256.8500n -0.002118 256.8600n -0.002308 256.8700n -0.002480 256.8800n -0.002628 256.8900n -0.002751 256.9000n -0.002844 256.9100n -0.002906 256.9200n -0.002934 256.9300n -0.002927 256.9400n -0.002885
+ 256.9500n -0.002807 256.9600n -0.002695 256.9700n -0.002549 256.9800n -0.002373 256.9900n -0.002170 257.0000n -0.001942 257.0100n -0.001693 257.0200n -0.001428 257.0300n -0.001152 257.0400n -0.000869 257.0500n -0.000586 257.0600n -0.000306 257.0700n -0.000035 257.0800n 0.000222 257.0900n 0.000460
+ 257.1000n 0.000674 257.1100n 0.000862 257.1200n 0.001019 257.1300n 0.001143 257.1400n 0.001230 257.1500n 0.001281 257.1600n 0.001294 257.1700n 0.001269 257.1800n 0.001206 257.1900n 0.001107 257.2000n 0.000975 257.2100n 0.000810 257.2200n 0.000618 257.2300n 0.000402 257.2400n 0.000165
+ 257.2500n -0.000087 257.2600n -0.000350 257.2700n -0.000618 257.2800n -0.000886 257.2900n -0.001150 257.3000n -0.001404 257.3100n -0.001644 257.3200n -0.001864 257.3300n -0.002062 257.3400n -0.002232 257.3500n -0.002373 257.3600n -0.002482 257.3700n -0.002556 257.3800n -0.002595 257.3900n -0.002598
+ 257.4000n -0.002565 257.4100n -0.002497 257.4200n -0.002396 257.4300n -0.002262 257.4400n -0.002100 257.4500n -0.001911 257.4600n -0.001700 257.4700n -0.001471 257.4800n -0.001227 257.4900n -0.000974 257.5000n -0.000715 257.5100n -0.000456 257.5200n -0.000201 257.5300n 0.000046 257.5400n 0.000281
+ 257.5500n 0.000499 257.5600n 0.000697 257.5700n 0.000872 257.5800n 0.001021 257.5900n 0.001142 257.6000n 0.001233 257.6100n 0.001294 257.6200n 0.001324 257.6300n 0.001323 257.6400n 0.001292 257.6500n 0.001231 257.6600n 0.001144 257.6700n 0.001031 257.6800n 0.000896 257.6900n 0.000742
+ 257.7000n 0.000572 257.7100n 0.000389 257.7200n 0.000197 257.7300n 0.000001 257.7400n -0.000197 257.7500n -0.000391 257.7600n -0.000579 257.7700n -0.000758 257.7800n -0.000922 257.7900n -0.001071 257.8000n -0.001201 257.8100n -0.001309 257.8200n -0.001394 257.8300n -0.001455 257.8400n -0.001491
+ 257.8500n -0.001501 257.8600n -0.001485 257.8700n -0.001444 257.8800n -0.001379 257.8900n -0.001292 257.9000n -0.001183 257.9100n -0.001055 257.9200n -0.000911 257.9300n -0.000753 257.9400n -0.000585 257.9500n -0.000409 257.9600n -0.000229 257.9700n -0.000047 257.9800n 0.000133 257.9900n 0.000307
+ 258.0000n 0.000473 258.0100n 0.000628 258.0200n 0.000769 258.0300n 0.000895 258.0400n 0.001002 258.0500n 0.001090 258.0600n 0.001157 258.0700n 0.001202 258.0800n 0.001225 258.0900n 0.001225 258.1000n 0.001203 258.1100n 0.001160 258.1200n 0.001096 258.1300n 0.001013 258.1400n 0.000912
+ 258.1500n 0.000796 258.1600n 0.000667 258.1700n 0.000528 258.1800n 0.000380 258.1900n 0.000226 258.2000n 0.000070 258.2100n -0.000086 258.2200n -0.000239 258.2300n -0.000387 258.2400n -0.000527 258.2500n -0.000657 258.2600n -0.000774 258.2700n -0.000877 258.2800n -0.000965 258.2900n -0.001035
+ 258.3000n -0.001088 258.3100n -0.001122 258.3200n -0.001138 258.3300n -0.001135 258.3400n -0.001114 258.3500n -0.001076 258.3600n -0.001022 258.3700n -0.000953 258.3800n -0.000872 258.3900n -0.000779 258.4000n -0.000677 258.4100n -0.000568 258.4200n -0.000454 258.4300n -0.000339 258.4400n -0.000223
+ 258.4500n -0.000110 258.4600n -0.000001 258.4700n 0.000101 258.4800n 0.000195 258.4900n 0.000279 258.5000n 0.000351 258.5100n 0.000410 258.5200n 0.000457 258.5300n 0.000489 258.5400n 0.000508 258.5500n 0.000513 258.5600n 0.000504 258.5700n 0.000484 258.5800n 0.000452 258.5900n 0.000411
+ 258.6000n 0.000361 258.6100n 0.000306 258.6200n 0.000247 258.6300n 0.000186 258.6400n 0.000126 258.6500n 0.000069 258.6600n 0.000017 258.6700n -0.000027 258.6800n -0.000060 258.6900n -0.000082 258.7000n -0.000090 258.7100n -0.000083 258.7200n -0.000059 258.7300n -0.000017 258.7400n 0.000043
+ 258.7500n 0.000122 258.7600n 0.000218 258.7700n 0.000333 258.7800n 0.000465 258.7900n 0.000612 258.8000n 0.000774 258.8100n 0.000948 258.8200n 0.001132 258.8300n 0.001323 258.8400n 0.001520 258.8500n 0.001719 258.8600n 0.001917 258.8700n 0.002112 258.8800n 0.002300 258.8900n 0.002479
+ 258.9000n 0.002647 258.9100n 0.002800 258.9200n 0.002936 258.9300n 0.003053 258.9400n 0.003151 258.9500n 0.003226 258.9600n 0.003279 258.9700n 0.003309 258.9800n 0.003316 258.9900n 0.003300 259.0000n 0.003262 259.0100n 0.003202 259.0200n 0.003123 259.0300n 0.003026 259.0400n 0.002913
+ 259.0500n 0.002787 259.0600n 0.002649 259.0700n 0.002504 259.0800n 0.002352 259.0900n 0.002198 259.1000n 0.002044 259.1100n 0.001892 259.1200n 0.001745 259.1300n 0.001606 259.1400n 0.001476 259.1500n 0.001357 259.1600n 0.001250 259.1700n 0.001157 259.1800n 0.001078 259.1900n 0.001014
+ 259.2000n 0.000964 259.2100n 0.000927 259.2200n 0.000903 259.2300n 0.000891 259.2400n 0.000889 259.2500n 0.000894 259.2600n 0.000905 259.2700n 0.000920 259.2800n 0.000936 259.2900n 0.000950 259.3000n 0.000960 259.3100n 0.000964 259.3200n 0.000959 259.3300n 0.000943 259.3400n 0.000915
+ 259.3500n 0.000872 259.3600n 0.000813 259.3700n 0.000738 259.3800n 0.000645 259.3900n 0.000536 259.4000n 0.000409 259.4100n 0.000266 259.4200n 0.000108 259.4300n -0.000063 259.4400n -0.000246 259.4500n -0.000438 259.4600n -0.000636 259.4700n -0.000839 259.4800n -0.001043 259.4900n -0.001244
+ 259.5000n -0.001440 259.5100n -0.001628 259.5200n -0.001805 259.5300n -0.001967 259.5400n -0.002113 259.5500n -0.002239 259.5600n -0.002345 259.5700n -0.002428 259.5800n -0.002487 259.5900n -0.002522 259.6000n -0.002531 259.6100n -0.002516 259.6200n -0.002477 259.6300n -0.002416 259.6400n -0.002332
+ 259.6500n -0.002230 259.6600n -0.002110 259.6700n -0.001976 259.6800n -0.001830 259.6900n -0.001676 259.7000n -0.001517 259.7100n -0.001355 259.7200n -0.001195 259.7300n -0.001038 259.7400n -0.000889 259.7500n -0.000749 259.7600n -0.000622 259.7700n -0.000509 259.7800n -0.000412 259.7900n -0.000331
+ 259.8000n -0.000269 259.8100n -0.000225 259.8200n -0.000198 259.8300n -0.000189 259.8400n -0.000196 259.8500n -0.000217 259.8600n -0.000251 259.8700n -0.000295 259.8800n -0.000347 259.8900n -0.000403 259.9000n -0.000461 259.9100n -0.000519 259.9200n -0.000571 259.9300n -0.000616 259.9400n -0.000651
+ 259.9500n -0.000673 259.9600n -0.000680 259.9700n -0.000669 259.9800n -0.000639 259.9900n -0.000589 260.0000n -0.000517 260.0100n -0.000424 260.0200n -0.000310 260.0300n -0.000175 260.0400n -0.000020 260.0500n 0.000152 260.0600n 0.000340 260.0700n 0.000541 260.0800n 0.000752 260.0900n 0.000970
+ 260.1000n 0.001193 260.1100n 0.001415 260.1200n 0.001635 260.1300n 0.001848 260.1400n 0.002050 260.1500n 0.002240 260.1600n 0.002412 260.1700n 0.002566 260.1800n 0.002698 260.1900n 0.002807 260.2000n 0.002891 260.2100n 0.002948 260.2200n 0.002979 260.2300n 0.002984 260.2400n 0.002963
+ 260.2500n 0.002916 260.2600n 0.002846 260.2700n 0.002755 260.2800n 0.002645 260.2900n 0.002517 260.3000n 0.002377 260.3100n 0.002225 260.3200n 0.002066 260.3300n 0.001904 260.3400n 0.001740 260.3500n 0.001579 260.3600n 0.001423 260.3700n 0.001274 260.3800n 0.001137 260.3900n 0.001011
+ 260.4000n 0.000900 260.4100n 0.000804 260.4200n 0.000724 260.4300n 0.000659 260.4400n 0.000611 260.4500n 0.000578 260.4600n 0.000558 260.4700n 0.000551 260.4800n 0.000554 260.4900n 0.000565 260.5000n 0.000581 260.5100n 0.000600 260.5200n 0.000619 260.5300n 0.000634 260.5400n 0.000644
+ 260.5500n 0.000645 260.5600n 0.000634 260.5700n 0.000611 260.5800n 0.000571 260.5900n 0.000515 260.6000n 0.000441 260.6100n 0.000348 260.6200n 0.000237 260.6300n 0.000107 260.6400n -0.000040 260.6500n -0.000203 260.6600n -0.000380 260.6700n -0.000569 260.6800n -0.000766 260.6900n -0.000968
+ 260.7000n -0.001173 260.7100n -0.001375 260.7200n -0.001572 260.7300n -0.001760 260.7400n -0.001934 260.7500n -0.002091 260.7600n -0.002227 260.7700n -0.002339 260.7800n -0.002424 260.7900n -0.002479 260.8000n -0.002504 260.8100n -0.002495 260.8200n -0.002453 260.8300n -0.002377 260.8400n -0.002268
+ 260.8500n -0.002126 260.8600n -0.001953 260.8700n -0.001752 260.8800n -0.001526 260.8900n -0.001277 260.9000n -0.001009 260.9100n -0.000727 260.9200n -0.000435 260.9300n -0.000138 260.9400n 0.000160 260.9500n 0.000454 260.9600n 0.000739 260.9700n 0.001010 260.9800n 0.001263 260.9900n 0.001495
+ 261.0000n 0.001701 261.0100n 0.001879 261.0200n 0.002026 261.0300n 0.002140 261.0400n 0.002220 261.0500n 0.002265 261.0600n 0.002274 261.0700n 0.002250 261.0800n 0.002192 261.0900n 0.002102 261.1000n 0.001984 261.1100n 0.001839 261.1200n 0.001672 261.1300n 0.001485 261.1400n 0.001283
+ 261.1500n 0.001070 261.1600n 0.000850 261.1700n 0.000628 261.1800n 0.000407 261.1900n 0.000192 261.2000n -0.000014 261.2100n -0.000206 261.2200n -0.000382 261.2300n -0.000538 261.2400n -0.000674 261.2500n -0.000786 261.2600n -0.000875 261.2700n -0.000938 261.2800n -0.000976 261.2900n -0.000990
+ 261.3000n -0.000980 261.3100n -0.000949 261.3200n -0.000897 261.3300n -0.000827 261.3400n -0.000742 261.3500n -0.000645 261.3600n -0.000539 261.3700n -0.000427 261.3800n -0.000313 261.3900n -0.000200 261.4000n -0.000091 261.4100n 0.000011 261.4200n 0.000103 261.4300n 0.000183 261.4400n 0.000248
+ 261.4500n 0.000297 261.4600n 0.000327 261.4700n 0.000339 261.4800n 0.000331 261.4900n 0.000304 261.5000n 0.000258 261.5100n 0.000193 261.5200n 0.000111 261.5300n 0.000013 261.5400n -0.000098 261.5500n -0.000222 261.5600n -0.000354 261.5700n -0.000494 261.5800n -0.000637 261.5900n -0.000783
+ 261.6000n -0.000927 261.6100n -0.001068 261.6200n -0.001203 261.6300n -0.001329 261.6400n -0.001445 261.6500n -0.001550 261.6600n -0.001640 261.6700n -0.001717 261.6800n -0.001777 261.6900n -0.001822 261.7000n -0.001851 261.7100n -0.001863 261.7200n -0.001861 261.7300n -0.001844 261.7400n -0.001813
+ 261.7500n -0.001771 261.7600n -0.001718 261.7700n -0.001656 261.7800n -0.001587 261.7900n -0.001513 261.8000n -0.001435 261.8100n -0.001356 261.8200n -0.001278 261.8300n -0.001201 261.8400n -0.001129 261.8500n -0.001061 261.8600n -0.000999 261.8700n -0.000945 261.8800n -0.000898 261.8900n -0.000860
+ 261.9000n -0.000830 261.9100n -0.000810 261.9200n -0.000797 261.9300n -0.000793 261.9400n -0.000796 261.9500n -0.000805 261.9600n -0.000820 261.9700n -0.000839 261.9800n -0.000861 261.9900n -0.000885 262.0000n -0.000910 262.0100n -0.000934 262.0200n -0.000955 262.0300n -0.000974 262.0400n -0.000988
+ 262.0500n -0.000997 262.0600n -0.000999 262.0700n -0.000994 262.0800n -0.000981 262.0900n -0.000960 262.1000n -0.000930 262.1100n -0.000891 262.1200n -0.000844 262.1300n -0.000787 262.1400n -0.000722 262.1500n -0.000649 262.1600n -0.000568 262.1700n -0.000480 262.1800n -0.000385 262.1900n -0.000284
+ 262.2000n -0.000178 262.2100n -0.000068 262.2200n 0.000047 262.2300n 0.000164 262.2400n 0.000284 262.2500n 0.000407 262.2600n 0.000530 262.2700n 0.000655 262.2800n 0.000779 262.2900n 0.000904 262.3000n 0.001029 262.3100n 0.001152 262.3200n 0.001275 262.3300n 0.001396 262.3400n 0.001516
+ 262.3500n 0.001633 262.3600n 0.001749 262.3700n 0.001862 262.3800n 0.001971 262.3900n 0.002078 262.4000n 0.002181 262.4100n 0.002280 262.4200n 0.002374 262.4300n 0.002463 262.4400n 0.002546 262.4500n 0.002622 262.4600n 0.002691 262.4700n 0.002752 262.4800n 0.002804 262.4900n 0.002847
+ 262.5000n 0.002879 262.5100n 0.002899 262.5200n 0.002909 262.5300n 0.002905 262.5400n 0.002889 262.5500n 0.002860 262.5600n 0.002817 262.5700n 0.002760 262.5800n 0.002689 262.5900n 0.002605 262.6000n 0.002507 262.6100n 0.002397 262.6200n 0.002274 262.6300n 0.002140 262.6400n 0.001995
+ 262.6500n 0.001841 262.6600n 0.001679 262.6700n 0.001509 262.6800n 0.001335 262.6900n 0.001156 262.7000n 0.000975 262.7100n 0.000794 262.7200n 0.000614 262.7300n 0.000436 262.7400n 0.000262 262.7500n 0.000094 262.7600n -0.000068 262.7700n -0.000221 262.7800n -0.000364 262.7900n -0.000497
+ 262.8000n -0.000619 262.8100n -0.000729 262.8200n -0.000827 262.8300n -0.000912 262.8400n -0.000984 262.8500n -0.001043 262.8600n -0.001090 262.8700n -0.001124 262.8800n -0.001147 262.8900n -0.001159 262.9000n -0.001161 262.9100n -0.001154 262.9200n -0.001139 262.9300n -0.001116 262.9400n -0.001087
+ 262.9500n -0.001053 262.9600n -0.001015 262.9700n -0.000974 262.9800n -0.000931 262.9900n -0.000887 263.0000n -0.000844 263.0100n -0.000801 263.0200n -0.000759 263.0300n -0.000720 263.0400n -0.000684 263.0500n -0.000652 263.0600n -0.000623 263.0700n -0.000598 263.0800n -0.000578 263.0900n -0.000562
+ 263.1000n -0.000552 263.1100n -0.000546 263.1200n -0.000545 263.1300n -0.000548 263.1400n -0.000557 263.1500n -0.000570 263.1600n -0.000588 263.1700n -0.000610 263.1800n -0.000636 263.1900n -0.000667 263.2000n -0.000701 263.2100n -0.000738 263.2200n -0.000779 263.2300n -0.000823 263.2400n -0.000869
+ 263.2500n -0.000917 263.2600n -0.000967 263.2700n -0.001018 263.2800n -0.001070 263.2900n -0.001122 263.3000n -0.001173 263.3100n -0.001222 263.3200n -0.001268 263.3300n -0.001312 263.3400n -0.001351 263.3500n -0.001385 263.3600n -0.001412 263.3700n -0.001432 263.3800n -0.001443 263.3900n -0.001445
+ 263.4000n -0.001436 263.4100n -0.001415 263.4200n -0.001382 263.4300n -0.001336 263.4400n -0.001277 263.4500n -0.001203 263.4600n -0.001114 263.4700n -0.001011 263.4800n -0.000894 263.4900n -0.000763 263.5000n -0.000618 263.5100n -0.000461 263.5200n -0.000292 263.5300n -0.000114 263.5400n 0.000073
+ 263.5500n 0.000266 263.5600n 0.000464 263.5700n 0.000664 263.5800n 0.000863 263.5900n 0.001061 263.6000n 0.001253 263.6100n 0.001438 263.6200n 0.001613 263.6300n 0.001776 263.6400n 0.001923 263.6500n 0.002054 263.6600n 0.002167 263.6700n 0.002259 263.6800n 0.002329 263.6900n 0.002376
+ 263.7000n 0.002401 263.7100n 0.002401 263.7200n 0.002378 263.7300n 0.002332 263.7400n 0.002264 263.7500n 0.002175 263.7600n 0.002067 263.7700n 0.001942 263.7800n 0.001803 263.7900n 0.001651 263.8000n 0.001491 263.8100n 0.001324 263.8200n 0.001154 263.8300n 0.000984 263.8400n 0.000817
+ 263.8500n 0.000657 263.8600n 0.000506 263.8700n 0.000367 263.8800n 0.000242 263.8900n 0.000134 263.9000n 0.000044 263.9100n -0.000026 263.9200n -0.000075 263.9300n -0.000104 263.9400n -0.000112 263.9500n -0.000099 263.9600n -0.000067 263.9700n -0.000016 263.9800n 0.000050 263.9900n 0.000130
+ 264.0000n 0.000221 264.0100n 0.000321 264.0200n 0.000425 264.0300n 0.000532 264.0400n 0.000637 264.0500n 0.000738 264.0600n 0.000831 264.0700n 0.000912 264.0800n 0.000980 264.0900n 0.001031 264.1000n 0.001064 264.1100n 0.001076 264.1200n 0.001067 264.1300n 0.001035 264.1400n 0.000980
+ 264.1500n 0.000903 264.1600n 0.000804 264.1700n 0.000685 264.1800n 0.000548 264.1900n 0.000396 264.2000n 0.000230 264.2100n 0.000055 264.2200n -0.000126 264.2300n -0.000310 264.2400n -0.000491 264.2500n -0.000667 264.2600n -0.000832 264.2700n -0.000984 264.2800n -0.001117 264.2900n -0.001230
+ 264.3000n -0.001318 264.3100n -0.001378 264.3200n -0.001409 264.3300n -0.001409 264.3400n -0.001377 264.3500n -0.001312 264.3600n -0.001214 264.3700n -0.001085 264.3800n -0.000926 264.3900n -0.000738 264.4000n -0.000525 264.4100n -0.000290 264.4200n -0.000037 264.4300n 0.000231 264.4400n 0.000509
+ 264.4500n 0.000791 264.4600n 0.001074 264.4700n 0.001353 264.4800n 0.001622 264.4900n 0.001877 264.5000n 0.002114 264.5100n 0.002328 264.5200n 0.002516 264.5300n 0.002676 264.5400n 0.002804 264.5500n 0.002898 264.5600n 0.002958 264.5700n 0.002982 264.5800n 0.002972 264.5900n 0.002927
+ 264.6000n 0.002850 264.6100n 0.002743 264.6200n 0.002607 264.6300n 0.002448 264.6400n 0.002267 264.6500n 0.002071 264.6600n 0.001862 264.6700n 0.001646 264.6800n 0.001427 264.6900n 0.001211 264.7000n 0.001000 264.7100n 0.000801 264.7200n 0.000617 264.7300n 0.000451 264.7400n 0.000307
+ 264.7500n 0.000187 264.7600n 0.000094 264.7700n 0.000029 264.7800n -0.000008 264.7900n -0.000016 264.8000n 0.000004 264.8100n 0.000050 264.8200n 0.000122 264.8300n 0.000216 264.8400n 0.000329 264.8500n 0.000458 264.8600n 0.000600 264.8700n 0.000749 264.8800n 0.000903 264.8900n 0.001056
+ 264.9000n 0.001204 264.9100n 0.001344 264.9200n 0.001470 264.9300n 0.001580 264.9400n 0.001670 264.9500n 0.001737 264.9600n 0.001779 264.9700n 0.001795 264.9800n 0.001782 264.9900n 0.001741 265.0000n 0.001672 265.0100n 0.001576 265.0200n 0.001453 265.0300n 0.001306 265.0400n 0.001137
+ 265.0500n 0.000950 265.0600n 0.000748 265.0700n 0.000535 265.0800n 0.000314 265.0900n 0.000090 265.1000n -0.000133 265.1100n -0.000351 265.1200n -0.000560 265.1300n -0.000756 265.1400n -0.000935 265.1500n -0.001095 265.1600n -0.001232 265.1700n -0.001344 265.1800n -0.001430 265.1900n -0.001489
+ 265.2000n -0.001520 265.2100n -0.001523 265.2200n -0.001499 265.2300n -0.001449 265.2400n -0.001376 265.2500n -0.001280 265.2600n -0.001166 265.2700n -0.001036 265.2800n -0.000894 265.2900n -0.000743 265.3000n -0.000587 265.3100n -0.000430 265.3200n -0.000275 265.3300n -0.000127 265.3400n 0.000013
+ 265.3500n 0.000139 265.3600n 0.000251 265.3700n 0.000345 265.3800n 0.000419 265.3900n 0.000473 265.4000n 0.000506 265.4100n 0.000517 265.4200n 0.000508 265.4300n 0.000477 265.4400n 0.000428 265.4500n 0.000362 265.4600n 0.000281 265.4700n 0.000188 265.4800n 0.000086 265.4900n -0.000022
+ 265.5000n -0.000132 265.5100n -0.000242 265.5200n -0.000347 265.5300n -0.000445 265.5400n -0.000532 265.5500n -0.000605 265.5600n -0.000662 265.5700n -0.000700 265.5800n -0.000717 265.5900n -0.000713 265.6000n -0.000685 265.6100n -0.000634 265.6200n -0.000559 265.6300n -0.000462 265.6400n -0.000343
+ 265.6500n -0.000204 265.6600n -0.000046 265.6700n 0.000127 265.6800n 0.000314 265.6900n 0.000512 265.7000n 0.000717 265.7100n 0.000926 265.7200n 0.001136 265.7300n 0.001344 265.7400n 0.001546 265.7500n 0.001740 265.7600n 0.001922 265.7700n 0.002090 265.7800n 0.002242 265.7900n 0.002376
+ 265.8000n 0.002489 265.8100n 0.002582 265.8200n 0.002652 265.8300n 0.002701 265.8400n 0.002728 265.8500n 0.002732 265.8600n 0.002716 265.8700n 0.002681 265.8800n 0.002626 265.8900n 0.002556 265.9000n 0.002470 265.9100n 0.002371 265.9200n 0.002262 265.9300n 0.002144 265.9400n 0.002020
+ 265.9500n 0.001891 265.9600n 0.001759 265.9700n 0.001627 265.9800n 0.001495 265.9900n 0.001365 266.0000n 0.001239 266.0100n 0.001116 266.0200n 0.000998 266.0300n 0.000885 266.0400n 0.000776 266.0500n 0.000673 266.0600n 0.000574 266.0700n 0.000478 266.0800n 0.000386 266.0900n 0.000297
+ 266.1000n 0.000209 266.1100n 0.000121 266.1200n 0.000033 266.1300n -0.000056 266.1400n -0.000146 266.1500n -0.000239 266.1600n -0.000335 266.1700n -0.000433 266.1800n -0.000535 266.1900n -0.000640 266.2000n -0.000747 266.2100n -0.000855 266.2200n -0.000965 266.2300n -0.001075 266.2400n -0.001183
+ 266.2500n -0.001288 266.2600n -0.001389 266.2700n -0.001485 266.2800n -0.001573 266.2900n -0.001651 266.3000n -0.001720 266.3100n -0.001776 266.3200n -0.001818 266.3300n -0.001846 266.3400n -0.001859 266.3500n -0.001855 266.3600n -0.001835 266.3700n -0.001798 266.3800n -0.001745 266.3900n -0.001675
+ 266.4000n -0.001590 266.4100n -0.001491 266.4200n -0.001379 266.4300n -0.001256 266.4400n -0.001124 266.4500n -0.000984 266.4600n -0.000839 266.4700n -0.000692 266.4800n -0.000544 266.4900n -0.000398 266.5000n -0.000256 266.5100n -0.000121 266.5200n 0.000006 266.5300n 0.000122 266.5400n 0.000226
+ 266.5500n 0.000318 266.5600n 0.000394 266.5700n 0.000456 266.5800n 0.000502 266.5900n 0.000532 266.6000n 0.000548 266.6100n 0.000548 266.6200n 0.000535 266.6300n 0.000509 266.6400n 0.000472 266.6500n 0.000425 266.6600n 0.000371 266.6700n 0.000311 266.6800n 0.000248 266.6900n 0.000183
+ 266.7000n 0.000118 266.7100n 0.000056 266.7200n -0.000002 266.7300n -0.000054 266.7400n -0.000099 266.7500n -0.000135 266.7600n -0.000163 266.7700n -0.000180 266.7800n -0.000188 266.7900n -0.000186 266.8000n -0.000174 266.8100n -0.000153 266.8200n -0.000125 266.8300n -0.000090 266.8400n -0.000051
+ 266.8500n -0.000008 266.8600n 0.000036 266.8700n 0.000079 266.8800n 0.000119 266.8900n 0.000154 266.9000n 0.000182 266.9100n 0.000202 266.9200n 0.000211 266.9300n 0.000208 266.9400n 0.000192 266.9500n 0.000161 266.9600n 0.000116 266.9700n 0.000055 266.9800n -0.000021 266.9900n -0.000112
+ 267.0000n -0.000216 267.0100n -0.000334 267.0200n -0.000464 267.0300n -0.000604 267.0400n -0.000751 267.0500n -0.000904 267.0600n -0.001061 267.0700n -0.001218 267.0800n -0.001374 267.0900n -0.001526 267.1000n -0.001671 267.1100n -0.001806 267.1200n -0.001930 267.1300n -0.002041 267.1400n -0.002135
+ 267.1500n -0.002213 267.1600n -0.002272 267.1700n -0.002312 267.1800n -0.002332 267.1900n -0.002331 267.2000n -0.002311 267.2100n -0.002271 267.2200n -0.002213 267.2300n -0.002137 267.2400n -0.002045 267.2500n -0.001940 267.2600n -0.001822 267.2700n -0.001694 267.2800n -0.001559 267.2900n -0.001419
+ 267.3000n -0.001276 267.3100n -0.001132 267.3200n -0.000990 267.3300n -0.000853 267.3400n -0.000721 267.3500n -0.000597 267.3600n -0.000483 267.3700n -0.000379 267.3800n -0.000287 267.3900n -0.000207 267.4000n -0.000140 267.4100n -0.000086 267.4200n -0.000044 267.4300n -0.000014 267.4400n 0.000005
+ 267.4500n 0.000014 267.4600n 0.000014 267.4700n 0.000007 267.4800n -0.000006 267.4900n -0.000024 267.5000n -0.000044 267.5100n -0.000066 267.5200n -0.000086 267.5300n -0.000105 267.5400n -0.000121 267.5500n -0.000131 267.5600n -0.000136 267.5700n -0.000135 267.5800n -0.000126 267.5900n -0.000110
+ 267.6000n -0.000086 267.6100n -0.000055 267.6200n -0.000016 267.6300n 0.000030 267.6400n 0.000082 267.6500n 0.000139 267.6600n 0.000200 267.6700n 0.000265 267.6800n 0.000333 267.6900n 0.000401 267.7000n 0.000470 267.7100n 0.000537 267.7200n 0.000602 267.7300n 0.000664 267.7400n 0.000723
+ 267.7500n 0.000777 267.7600n 0.000826 267.7700n 0.000871 267.7800n 0.000909 267.7900n 0.000943 267.8000n 0.000972 267.8100n 0.000996 267.8200n 0.001016 267.8300n 0.001033 267.8400n 0.001048 267.8500n 0.001060 267.8600n 0.001072 267.8700n 0.001084 267.8800n 0.001097 267.8900n 0.001112
+ 267.9000n 0.001130 267.9100n 0.001150 267.9200n 0.001175 267.9300n 0.001203 267.9400n 0.001235 267.9500n 0.001272 267.9600n 0.001312 267.9700n 0.001356 267.9800n 0.001402 267.9900n 0.001451 268.0000n 0.001500 268.0100n 0.001550 268.0200n 0.001598 268.0300n 0.001643 268.0400n 0.001684
+ 268.0500n 0.001720 268.0600n 0.001750 268.0700n 0.001771 268.0800n 0.001783 268.0900n 0.001784 268.1000n 0.001775 268.1100n 0.001753 268.1200n 0.001720 268.1300n 0.001674 268.1400n 0.001615 268.1500n 0.001544 268.1600n 0.001462 268.1700n 0.001368 268.1800n 0.001266 268.1900n 0.001154
+ 268.2000n 0.001036 268.2100n 0.000913 268.2200n 0.000787 268.2300n 0.000659 268.2400n 0.000533 268.2500n 0.000408 268.2600n 0.000289 268.2700n 0.000176 268.2800n 0.000072 268.2900n -0.000023 268.3000n -0.000105 268.3100n -0.000176 268.3200n -0.000232 268.3300n -0.000275 268.3400n -0.000302
+ 268.3500n -0.000316 268.3600n -0.000315 268.3700n -0.000300 268.3800n -0.000273 268.3900n -0.000235 268.4000n -0.000187 268.4100n -0.000130 268.4200n -0.000067 268.4300n -0.000000 268.4400n 0.000069 268.4500n 0.000138 268.4600n 0.000206 268.4700n 0.000269 268.4800n 0.000325 268.4900n 0.000374
+ 268.5000n 0.000413 268.5100n 0.000441 268.5200n 0.000457 268.5300n 0.000460 268.5400n 0.000449 268.5500n 0.000425 268.5600n 0.000388 268.5700n 0.000338 268.5800n 0.000275 268.5900n 0.000202 268.6000n 0.000120 268.6100n 0.000030 268.6200n -0.000066 268.6300n -0.000165 268.6400n -0.000266
+ 268.6500n -0.000365 268.6600n -0.000462 268.6700n -0.000554 268.6800n -0.000637 268.6900n -0.000712 268.7000n -0.000775 268.7100n -0.000825 268.7200n -0.000860 268.7300n -0.000881 268.7400n -0.000885 268.7500n -0.000872 268.7600n -0.000844 268.7700n -0.000798 268.7800n -0.000737 268.7900n -0.000662
+ 268.8000n -0.000573 268.8100n -0.000472 268.8200n -0.000360 268.8300n -0.000241 268.8400n -0.000115 268.8500n 0.000015 268.8600n 0.000147 268.8700n 0.000279 268.8800n 0.000408 268.8900n 0.000533 268.9000n 0.000651 268.9100n 0.000761 268.9200n 0.000861 268.9300n 0.000950 268.9400n 0.001027
+ 268.9500n 0.001092 268.9600n 0.001143 268.9700n 0.001181 268.9800n 0.001205 268.9900n 0.001217 269.0000n 0.001216 269.0100n 0.001204 269.0200n 0.001182 269.0300n 0.001150 269.0400n 0.001111 269.0500n 0.001065 269.0600n 0.001015 269.0700n 0.000960 269.0800n 0.000904 269.0900n 0.000846
+ 269.1000n 0.000789 269.1100n 0.000732 269.1200n 0.000677 269.1300n 0.000625 269.1400n 0.000576 269.1500n 0.000529 269.1600n 0.000485 269.1700n 0.000443 269.1800n 0.000403 269.1900n 0.000365 269.2000n 0.000327 269.2100n 0.000288 269.2200n 0.000247 269.2300n 0.000203 269.2400n 0.000155
+ 269.2500n 0.000102 269.2600n 0.000043 269.2700n -0.000023 269.2800n -0.000097 269.2900n -0.000180 269.3000n -0.000272 269.3100n -0.000372 269.3200n -0.000481 269.3300n -0.000599 269.3400n -0.000725 269.3500n -0.000857 269.3600n -0.000994 269.3700n -0.001136 269.3800n -0.001280 269.3900n -0.001424
+ 269.4000n -0.001567 269.4100n -0.001707 269.4200n -0.001841 269.4300n -0.001966 269.4400n -0.002082 269.4500n -0.002186 269.4600n -0.002276 269.4700n -0.002350 269.4800n -0.002408 269.4900n -0.002447 269.5000n -0.002467 269.5100n -0.002469 269.5200n -0.002450 269.5300n -0.002413 269.5400n -0.002357
+ 269.5500n -0.002283 269.5600n -0.002193 269.5700n -0.002088 269.5800n -0.001971 269.5900n -0.001843 269.6000n -0.001707 269.6100n -0.001566 269.6200n -0.001421 269.6300n -0.001277 269.6400n -0.001135 269.6500n -0.000998 269.6600n -0.000868 269.6700n -0.000747 269.6800n -0.000639 269.6900n -0.000543
+ 269.7000n -0.000462 269.7100n -0.000397 269.7200n -0.000347 269.7300n -0.000314 269.7400n -0.000297 269.7500n -0.000294 269.7600n -0.000307 269.7700n -0.000331 269.7800n -0.000367 269.7900n -0.000412 269.8000n -0.000464 269.8100n -0.000521 269.8200n -0.000579 269.8300n -0.000636 269.8400n -0.000690
+ 269.8500n -0.000738 269.8600n -0.000778 269.8700n -0.000807 269.8800n -0.000825 269.8900n -0.000828 269.9000n -0.000816 269.9100n -0.000788 269.9200n -0.000744 269.9300n -0.000684 269.9400n -0.000608 269.9500n -0.000516 269.9600n -0.000411 269.9700n -0.000294 269.9800n -0.000167 269.9900n -0.000032
+ 270.0000n 0.000108 270.0100n 0.000250 270.0200n 0.000392 270.0300n 0.000530 270.0400n 0.000661 270.0500n 0.000783 270.0600n 0.000893 270.0700n 0.000988 270.0800n 0.001067 270.0900n 0.001127 270.1000n 0.001167 270.1100n 0.001185 270.1200n 0.001182 270.1300n 0.001157 270.1400n 0.001110
+ 270.1500n 0.001043 270.1600n 0.000956 270.1700n 0.000851 270.1800n 0.000732 270.1900n 0.000599 270.2000n 0.000456 270.2100n 0.000306 270.2200n 0.000153 270.2300n -0.000001 270.2400n -0.000153 270.2500n -0.000298 270.2600n -0.000434 270.2700n -0.000558 270.2800n -0.000667 270.2900n -0.000760
+ 270.3000n -0.000833 270.3100n -0.000885 270.3200n -0.000917 270.3300n -0.000926 270.3400n -0.000913 270.3500n -0.000879 270.3600n -0.000824 270.3700n -0.000750 270.3800n -0.000659 270.3900n -0.000553 270.4000n -0.000435 270.4100n -0.000307 270.4200n -0.000173 270.4300n -0.000036 270.4400n 0.000102
+ 270.4500n 0.000237 270.4600n 0.000366 270.4700n 0.000486 270.4800n 0.000595 270.4900n 0.000690 270.5000n 0.000770 270.5100n 0.000834 270.5200n 0.000881 270.5300n 0.000910 270.5400n 0.000922 270.5500n 0.000917 270.5600n 0.000896 270.5700n 0.000862 270.5800n 0.000816 270.5900n 0.000762
+ 270.6000n 0.000701 270.6100n 0.000638 270.6200n 0.000574 270.6300n 0.000515 270.6400n 0.000462 270.6500n 0.000420 270.6600n 0.000392 270.6700n 0.000380 270.6800n 0.000388 270.6900n 0.000416 270.7000n 0.000468 270.7100n 0.000544 270.7200n 0.000644 270.7300n 0.000769 270.7400n 0.000917
+ 270.7500n 0.001088 270.7600n 0.001280 270.7700n 0.001490 270.7800n 0.001714 270.7900n 0.001950 270.8000n 0.002194 270.8100n 0.002441 270.8200n 0.002685 270.8300n 0.002924 270.8400n 0.003151 270.8500n 0.003363 270.8600n 0.003553 270.8700n 0.003719 270.8800n 0.003855 270.8900n 0.003959
+ 270.9000n 0.004027 270.9100n 0.004056 270.9200n 0.004045 270.9300n 0.003993 270.9400n 0.003899 270.9500n 0.003764 270.9600n 0.003589 270.9700n 0.003375 270.9800n 0.003127 270.9900n 0.002847 271.0000n 0.002539 271.0100n 0.002208 271.0200n 0.001859 271.0300n 0.001498 271.0400n 0.001131
+ 271.0500n 0.000763 271.0600n 0.000401 271.0700n 0.000050 271.0800n -0.000282 271.0900n -0.000592 271.1000n -0.000873 271.1100n -0.001121 271.1200n -0.001332 271.1300n -0.001502 271.1400n -0.001629 271.1500n -0.001710 271.1600n -0.001744 271.1700n -0.001732 271.1800n -0.001673 271.1900n -0.001568
+ 271.2000n -0.001421 271.2100n -0.001234 271.2200n -0.001010 271.2300n -0.000753 271.2400n -0.000469 271.2500n -0.000163 271.2600n 0.000161 271.2700n 0.000495 271.2800n 0.000835 271.2900n 0.001174 271.3000n 0.001507 271.3100n 0.001827 271.3200n 0.002130 271.3300n 0.002411 271.3400n 0.002665
+ 271.3500n 0.002888 271.3600n 0.003077 271.3700n 0.003230 271.3800n 0.003344 271.3900n 0.003418 271.4000n 0.003451 271.4100n 0.003444 271.4200n 0.003398 271.4300n 0.003314 271.4400n 0.003195 271.4500n 0.003042 271.4600n 0.002859 271.4700n 0.002651 271.4800n 0.002419 271.4900n 0.002170
+ 271.5000n 0.001906 271.5100n 0.001633 271.5200n 0.001354 271.5300n 0.001074 271.5400n 0.000798 271.5500n 0.000527 271.5600n 0.000267 271.5700n 0.000020 271.5800n -0.000210 271.5900n -0.000422 271.6000n -0.000615 271.6100n -0.000785 271.6200n -0.000933 271.6300n -0.001058 271.6400n -0.001160
+ 271.6500n -0.001239 271.6600n -0.001296 271.6700n -0.001333 271.6800n -0.001350 271.6900n -0.001349 271.7000n -0.001333 271.7100n -0.001302 271.7200n -0.001259 271.7300n -0.001207 271.7400n -0.001146 271.7500n -0.001080 271.7600n -0.001009 271.7700n -0.000935 271.7800n -0.000861 271.7900n -0.000787
+ 271.8000n -0.000715 271.8100n -0.000645 271.8200n -0.000577 271.8300n -0.000514 271.8400n -0.000454 271.8500n -0.000399 271.8600n -0.000347 271.8700n -0.000299 271.8800n -0.000255 271.8900n -0.000214 271.9000n -0.000176 271.9100n -0.000140 271.9200n -0.000107 271.9300n -0.000076 271.9400n -0.000046
+ 271.9500n -0.000018 271.9600n 0.000008 271.9700n 0.000032 271.9800n 0.000055 271.9900n 0.000075 272.0000n 0.000093 272.0100n 0.000106 272.0200n 0.000116 272.0300n 0.000122 272.0400n 0.000121 272.0500n 0.000115 272.0600n 0.000101 272.0700n 0.000080 272.0800n 0.000050 272.0900n 0.000011
+ 272.1000n -0.000037 272.1100n -0.000094 272.1200n -0.000161 272.1300n -0.000238 272.1400n -0.000323 272.1500n -0.000417 272.1600n -0.000519 272.1700n -0.000627 272.1800n -0.000741 272.1900n -0.000859 272.2000n -0.000979 272.2100n -0.001099 272.2200n -0.001219 272.2300n -0.001335 272.2400n -0.001447
+ 272.2500n -0.001551 272.2600n -0.001647 272.2700n -0.001732 272.2800n -0.001804 272.2900n -0.001863 272.3000n -0.001907 272.3100n -0.001935 272.3200n -0.001946 272.3300n -0.001940 272.3400n -0.001916 272.3500n -0.001875 272.3600n -0.001817 272.3700n -0.001743 272.3800n -0.001654 272.3900n -0.001552
+ 272.4000n -0.001438 272.4100n -0.001313 272.4200n -0.001181 272.4300n -0.001043 272.4400n -0.000901 272.4500n -0.000757 272.4600n -0.000615 272.4700n -0.000476 272.4800n -0.000342 272.4900n -0.000216 272.5000n -0.000099 272.5100n 0.000007 272.5200n 0.000101 272.5300n 0.000183 272.5400n 0.000250
+ 272.5500n 0.000303 272.5600n 0.000343 272.5700n 0.000369 272.5800n 0.000381 272.5900n 0.000382 272.6000n 0.000373 272.6100n 0.000354 272.6200n 0.000329 272.6300n 0.000298 272.6400n 0.000264 272.6500n 0.000230 272.6600n 0.000198 272.6700n 0.000170 272.6800n 0.000148 272.6900n 0.000134
+ 272.7000n 0.000131 272.7100n 0.000140 272.7200n 0.000162 272.7300n 0.000199 272.7400n 0.000252 272.7500n 0.000321 272.7600n 0.000407 272.7700n 0.000508 272.7800n 0.000624 272.7900n 0.000755 272.8000n 0.000899 272.8100n 0.001055 272.8200n 0.001219 272.8300n 0.001391 272.8400n 0.001567
+ 272.8500n 0.001745 272.8600n 0.001922 272.8700n 0.002095 272.8800n 0.002262 272.8900n 0.002419 272.9000n 0.002564 272.9100n 0.002694 272.9200n 0.002807 272.9300n 0.002900 272.9400n 0.002973 272.9500n 0.003022 272.9600n 0.003048 272.9700n 0.003048 272.9800n 0.003023 272.9900n 0.002974
+ 273.0000n 0.002899 273.0100n 0.002800 273.0200n 0.002678 273.0300n 0.002534 273.0400n 0.002371 273.0500n 0.002190 273.0600n 0.001994 273.0700n 0.001785 273.0800n 0.001567 273.0900n 0.001341 273.1000n 0.001112 273.1100n 0.000881 273.1200n 0.000653 273.1300n 0.000429 273.1400n 0.000213
+ 273.1500n 0.000007 273.1600n -0.000186 273.1700n -0.000364 273.1800n -0.000526 273.1900n -0.000669 273.2000n -0.000792 273.2100n -0.000895 273.2200n -0.000976 273.2300n -0.001035 273.2400n -0.001073 273.2500n -0.001089 273.2600n -0.001084 273.2700n -0.001059 273.2800n -0.001015 273.2900n -0.000953
+ 273.3000n -0.000875 273.3100n -0.000783 273.3200n -0.000678 273.3300n -0.000563 273.3400n -0.000439 273.3500n -0.000309 273.3600n -0.000175 273.3700n -0.000039 273.3800n 0.000097 273.3900n 0.000231 273.4000n 0.000360 273.4100n 0.000484 273.4200n 0.000600 273.4300n 0.000707 273.4400n 0.000804
+ 273.4500n 0.000888 273.4600n 0.000961 273.4700n 0.001019 273.4800n 0.001064 273.4900n 0.001094 273.5000n 0.001109 273.5100n 0.001110 273.5200n 0.001096 273.5300n 0.001068 273.5400n 0.001026 273.5500n 0.000972 273.5600n 0.000905 273.5700n 0.000828 273.5800n 0.000740 273.5900n 0.000645
+ 273.6000n 0.000542 273.6100n 0.000433 273.6200n 0.000320 273.6300n 0.000205 273.6400n 0.000089 273.6500n -0.000026 273.6600n -0.000138 273.6700n -0.000246 273.6800n -0.000348 273.6900n -0.000442 273.7000n -0.000526 273.7100n -0.000600 273.7200n -0.000662 273.7300n -0.000710 273.7400n -0.000744
+ 273.7500n -0.000762 273.7600n -0.000764 273.7700n -0.000749 273.7800n -0.000716 273.7900n -0.000667 273.8000n -0.000600 273.8100n -0.000516 273.8200n -0.000415 273.8300n -0.000298 273.8400n -0.000167 273.8500n -0.000022 273.8600n 0.000135 273.8700n 0.000303 273.8800n 0.000480 273.8900n 0.000664
+ 273.9000n 0.000853 273.9100n 0.001045 273.9200n 0.001238 273.9300n 0.001429 273.9400n 0.001616 273.9500n 0.001797 273.9600n 0.001970 273.9700n 0.002132 273.9800n 0.002282 273.9900n 0.002418 274.0000n 0.002538 274.0100n 0.002641 274.0200n 0.002725 274.0300n 0.002790 274.0400n 0.002835
+ 274.0500n 0.002860 274.0600n 0.002864 274.0700n 0.002847 274.0800n 0.002810 274.0900n 0.002754 274.1000n 0.002679 274.1100n 0.002587 274.1200n 0.002478 274.1300n 0.002356 274.1400n 0.002221 274.1500n 0.002074 274.1600n 0.001919 274.1700n 0.001757 274.1800n 0.001590 274.1900n 0.001419
+ 274.2000n 0.001248 274.2100n 0.001077 274.2200n 0.000909 274.2300n 0.000744 274.2400n 0.000585 274.2500n 0.000433 274.2600n 0.000288 274.2700n 0.000152 274.2800n 0.000025 274.2900n -0.000093 274.3000n -0.000201 274.3100n -0.000300 274.3200n -0.000389 274.3300n -0.000470 274.3400n -0.000541
+ 274.3500n -0.000606 274.3600n -0.000663 274.3700n -0.000714 274.3800n -0.000759 274.3900n -0.000800 274.4000n -0.000837 274.4100n -0.000871 274.4200n -0.000903 274.4300n -0.000933 274.4400n -0.000961 274.4500n -0.000989 274.4600n -0.001015 274.4700n -0.001041 274.4800n -0.001066 274.4900n -0.001089
+ 274.5000n -0.001110 274.5100n -0.001129 274.5200n -0.001144 274.5300n -0.001156 274.5400n -0.001162 274.5500n -0.001162 274.5600n -0.001156 274.5700n -0.001141 274.5800n -0.001117 274.5900n -0.001084 274.6000n -0.001040 274.6100n -0.000984 274.6200n -0.000917 274.6300n -0.000838 274.6400n -0.000747
+ 274.6500n -0.000644 274.6600n -0.000529 274.6700n -0.000403 274.6800n -0.000266 274.6900n -0.000120 274.7000n 0.000035 274.7100n 0.000197 274.7200n 0.000364 274.7300n 0.000535 274.7400n 0.000709 274.7500n 0.000883 274.7600n 0.001056 274.7700n 0.001226 274.7800n 0.001391 274.7900n 0.001550
+ 274.8000n 0.001701 274.8100n 0.001842 274.8200n 0.001972 274.8300n 0.002090 274.8400n 0.002196 274.8500n 0.002289 274.8600n 0.002367 274.8700n 0.002432 274.8800n 0.002484 274.8900n 0.002522 274.9000n 0.002547 274.9100n 0.002561 274.9200n 0.002563 274.9300n 0.002556 274.9400n 0.002540
+ 274.9500n 0.002517 274.9600n 0.002488 274.9700n 0.002455 274.9800n 0.002419 274.9900n 0.002381 275.0000n 0.002343 275.0100n 0.002306 275.0200n 0.002271 275.0300n 0.002238 275.0400n 0.002208 275.0500n 0.002181 275.0600n 0.002158 275.0700n 0.002138 275.0800n 0.002121 275.0900n 0.002107
+ 275.1000n 0.002094 275.1100n 0.002082 275.1200n 0.002069 275.1300n 0.002054 275.1400n 0.002037 275.1500n 0.002014 275.1600n 0.001986 275.1700n 0.001950 275.1800n 0.001906 275.1900n 0.001851 275.2000n 0.001786 275.2100n 0.001708 275.2200n 0.001617 275.2300n 0.001514 275.2400n 0.001397
+ 275.2500n 0.001266 275.2600n 0.001123 275.2700n 0.000967 275.2800n 0.000801 275.2900n 0.000624 275.3000n 0.000438 275.3100n 0.000246 275.3200n 0.000049 275.3300n -0.000151 275.3400n -0.000352 275.3500n -0.000551 275.3600n -0.000746 275.3700n -0.000934 275.3800n -0.001114 275.3900n -0.001283
+ 275.4000n -0.001439 275.4100n -0.001580 275.4200n -0.001705 275.4300n -0.001812 275.4400n -0.001900 275.4500n -0.001969 275.4600n -0.002018 275.4700n -0.002047 275.4800n -0.002056 275.4900n -0.002045 275.5000n -0.002017 275.5100n -0.001971 275.5200n -0.001910 275.5300n -0.001834 275.5400n -0.001747
+ 275.5500n -0.001649 275.5600n -0.001543 275.5700n -0.001432 275.5800n -0.001317 275.5900n -0.001200 275.6000n -0.001084 275.6100n -0.000971 275.6200n -0.000861 275.6300n -0.000758 275.6400n -0.000661 275.6500n -0.000573 275.6600n -0.000494 275.6700n -0.000424 275.6800n -0.000364 275.6900n -0.000313
+ 275.7000n -0.000272 275.7100n -0.000240 275.7200n -0.000215 275.7300n -0.000198 275.7400n -0.000186 275.7500n -0.000179 275.7600n -0.000175 275.7700n -0.000172 275.7800n -0.000170 275.7900n -0.000166 275.8000n -0.000160 275.8100n -0.000151 275.8200n -0.000138 275.8300n -0.000119 275.8400n -0.000094
+ 275.8500n -0.000063 275.8600n -0.000027 275.8700n 0.000016 275.8800n 0.000064 275.8900n 0.000117 275.9000n 0.000174 275.9100n 0.000234 275.9200n 0.000295 275.9300n 0.000356 275.9400n 0.000416 275.9500n 0.000472 275.9600n 0.000524 275.9700n 0.000570 275.9800n 0.000608 275.9900n 0.000636
+ 276.0000n 0.000655 276.0100n 0.000663 276.0200n 0.000658 276.0300n 0.000642 276.0400n 0.000612 276.0500n 0.000571 276.0600n 0.000518 276.0700n 0.000453 276.0800n 0.000379 276.0900n 0.000296 276.1000n 0.000207 276.1100n 0.000112 276.1200n 0.000015 276.1300n -0.000083 276.1400n -0.000179
+ 276.1500n -0.000271 276.1600n -0.000356 276.1700n -0.000431 276.1800n -0.000495 276.1900n -0.000546 276.2000n -0.000580 276.2100n -0.000597 276.2200n -0.000596 276.2300n -0.000574 276.2400n -0.000532 276.2500n -0.000469 276.2600n -0.000384 276.2700n -0.000279 276.2800n -0.000155 276.2900n -0.000012
+ 276.3000n 0.000148 276.3100n 0.000324 276.3200n 0.000511 276.3300n 0.000710 276.3400n 0.000916 276.3500n 0.001127 276.3600n 0.001340 276.3700n 0.001552 276.3800n 0.001760 276.3900n 0.001962 276.4000n 0.002154 276.4100n 0.002335 276.4200n 0.002501 276.4300n 0.002651 276.4400n 0.002784
+ 276.4500n 0.002897 276.4600n 0.002990 276.4700n 0.003063 276.4800n 0.003114 276.4900n 0.003145 276.5000n 0.003155 276.5100n 0.003146 276.5200n 0.003119 276.5300n 0.003074 276.5400n 0.003015 276.5500n 0.002941 276.5600n 0.002857 276.5700n 0.002762 276.5800n 0.002661 276.5900n 0.002554
+ 276.6000n 0.002443 276.6100n 0.002332 276.6200n 0.002220 276.6300n 0.002110 276.6400n 0.002004 276.6500n 0.001901 276.6600n 0.001803 276.6700n 0.001711 276.6800n 0.001624 276.6900n 0.001543 276.7000n 0.001468 276.7100n 0.001397 276.7200n 0.001330 276.7300n 0.001266 276.7400n 0.001205
+ 276.7500n 0.001144 276.7600n 0.001084 276.7700n 0.001021 276.7800n 0.000957 276.7900n 0.000888 276.8000n 0.000816 276.8100n 0.000738 276.8200n 0.000654 276.8300n 0.000565 276.8400n 0.000469 276.8500n 0.000367 276.8600n 0.000260 276.8700n 0.000148 276.8800n 0.000033 276.8900n -0.000084
+ 276.9000n -0.000203 276.9100n -0.000320 276.9200n -0.000435 276.9300n -0.000546 276.9400n -0.000650 276.9500n -0.000745 276.9600n -0.000830 276.9700n -0.000904 276.9800n -0.000963 276.9900n -0.001007 277.0000n -0.001035 277.0100n -0.001045 277.0200n -0.001038 277.0300n -0.001013 277.0400n -0.000970
+ 277.0500n -0.000909 277.0600n -0.000833 277.0700n -0.000741 277.0800n -0.000637 277.0900n -0.000521 277.1000n -0.000396 277.1100n -0.000265 277.1200n -0.000130 277.1300n 0.000005 277.1400n 0.000137 277.1500n 0.000264 277.1600n 0.000383 277.1700n 0.000491 277.1800n 0.000584 277.1900n 0.000661
+ 277.2000n 0.000719 277.2100n 0.000757 277.2200n 0.000773 277.2300n 0.000767 277.2400n 0.000737 277.2500n 0.000685 277.2600n 0.000609 277.2700n 0.000513 277.2800n 0.000396 277.2900n 0.000261 277.3000n 0.000111 277.3100n -0.000052 277.3200n -0.000225 277.3300n -0.000405 277.3400n -0.000587
+ 277.3500n -0.000769 277.3600n -0.000946 277.3700n -0.001116 277.3800n -0.001273 277.3900n -0.001416 277.4000n -0.001541 277.4100n -0.001646 277.4200n -0.001727 277.4300n -0.001784 277.4400n -0.001814 277.4500n -0.001816 277.4600n -0.001792 277.4700n -0.001740 277.4800n -0.001661 277.4900n -0.001557
+ 277.5000n -0.001429 277.5100n -0.001280 277.5200n -0.001113 277.5300n -0.000930 277.5400n -0.000735 277.5500n -0.000531 277.5600n -0.000322 277.5700n -0.000112 277.5800n 0.000094 277.5900n 0.000295 277.6000n 0.000485 277.6100n 0.000662 277.6200n 0.000822 277.6300n 0.000963 277.6400n 0.001083
+ 277.6500n 0.001180 277.6600n 0.001252 277.6700n 0.001299 277.6800n 0.001321 277.6900n 0.001318 277.7000n 0.001290 277.7100n 0.001240 277.7200n 0.001169 277.7300n 0.001079 277.7400n 0.000973 277.7500n 0.000853 277.7600n 0.000724 277.7700n 0.000587 277.7800n 0.000447 277.7900n 0.000308
+ 277.8000n 0.000171 277.8100n 0.000041 277.8200n -0.000080 277.8300n -0.000188 277.8400n -0.000281 277.8500n -0.000358 277.8600n -0.000417 277.8700n -0.000456 277.8800n -0.000476 277.8900n -0.000474 277.9000n -0.000453 277.9100n -0.000413 277.9200n -0.000355 277.9300n -0.000280 277.9400n -0.000190
+ 277.9500n -0.000089 277.9600n 0.000023 277.9700n 0.000141 277.9800n 0.000263 277.9900n 0.000386 278.0000n 0.000508 278.0100n 0.000625 278.0200n 0.000734 278.0300n 0.000833 278.0400n 0.000920 278.0500n 0.000993 278.0600n 0.001049 278.0700n 0.001088 278.0800n 0.001109 278.0900n 0.001111
+ 278.1000n 0.001095 278.1100n 0.001059 278.1200n 0.001006 278.1300n 0.000937 278.1400n 0.000851 278.1500n 0.000753 278.1600n 0.000642 278.1700n 0.000522 278.1800n 0.000394 278.1900n 0.000262 278.2000n 0.000127 278.2100n -0.000009 278.2200n -0.000142 278.2300n -0.000271 278.2400n -0.000394
+ 278.2500n -0.000510 278.2600n -0.000616 278.2700n -0.000711 278.2800n -0.000796 278.2900n -0.000868 278.3000n -0.000929 278.3100n -0.000978 278.3200n -0.001015 278.3300n -0.001042 278.3400n -0.001060 278.3500n -0.001069 278.3600n -0.001072 278.3700n -0.001069 278.3800n -0.001063 278.3900n -0.001055
+ 278.4000n -0.001048 278.4100n -0.001042 278.4200n -0.001039 278.4300n -0.001042 278.4400n -0.001050 278.4500n -0.001066 278.4600n -0.001090 278.4700n -0.001123 278.4800n -0.001165 278.4900n -0.001216 278.5000n -0.001276 278.5100n -0.001344 278.5200n -0.001419 278.5300n -0.001501 278.5400n -0.001588
+ 278.5500n -0.001679 278.5600n -0.001771 278.5700n -0.001864 278.5800n -0.001956 278.5900n -0.002044 278.6000n -0.002128 278.6100n -0.002204 278.6200n -0.002273 278.6300n -0.002331 278.6400n -0.002379 278.6500n -0.002415 278.6600n -0.002439 278.6700n -0.002449 278.6800n -0.002446 278.6900n -0.002431
+ 278.7000n -0.002402 278.7100n -0.002362 278.7200n -0.002311 278.7300n -0.002250 278.7400n -0.002180 278.7500n -0.002104 278.7600n -0.002023 278.7700n -0.001938 278.7800n -0.001852 278.7900n -0.001767 278.8000n -0.001683 278.8100n -0.001605 278.8200n -0.001531 278.8300n -0.001466 278.8400n -0.001408
+ 278.8500n -0.001361 278.8600n -0.001324 278.8700n -0.001298 278.8800n -0.001283 278.8900n -0.001280 278.9000n -0.001288 278.9100n -0.001306 278.9200n -0.001333 278.9300n -0.001369 278.9400n -0.001413 278.9500n -0.001461 278.9600n -0.001514 278.9700n -0.001569 278.9800n -0.001624 278.9900n -0.001678
+ 279.0000n -0.001728 279.0100n -0.001773 279.0200n -0.001811 279.0300n -0.001841 279.0400n -0.001860 279.0500n -0.001869 279.0600n -0.001864 279.0700n -0.001847 279.0800n -0.001817 279.0900n -0.001773 279.1000n -0.001715 279.1100n -0.001643 279.1200n -0.001559 279.1300n -0.001463 279.1400n -0.001356
+ 279.1500n -0.001240 279.1600n -0.001115 279.1700n -0.000984 279.1800n -0.000848 279.1900n -0.000708 279.2000n -0.000568 279.2100n -0.000427 279.2200n -0.000289 279.2300n -0.000155 279.2400n -0.000027 279.2500n 0.000095 279.2600n 0.000209 279.2700n 0.000313 279.2800n 0.000407 279.2900n 0.000490
+ 279.3000n 0.000561 279.3100n 0.000621 279.3200n 0.000669 279.3300n 0.000705 279.3400n 0.000731 279.3500n 0.000745 279.3600n 0.000750 279.3700n 0.000745 279.3800n 0.000733 279.3900n 0.000713 279.4000n 0.000688 279.4100n 0.000658 279.4200n 0.000624 279.4300n 0.000589 279.4400n 0.000553
+ 279.4500n 0.000517 279.4600n 0.000482 279.4700n 0.000450 279.4800n 0.000421 279.4900n 0.000396 279.5000n 0.000376 279.5100n 0.000361 279.5200n 0.000352 279.5300n 0.000349 279.5400n 0.000352 279.5500n 0.000361 279.5600n 0.000375 279.5700n 0.000395 279.5800n 0.000421 279.5900n 0.000451
+ 279.6000n 0.000486 279.6100n 0.000525 279.6200n 0.000566 279.6300n 0.000610 279.6400n 0.000655 279.6500n 0.000701 279.6600n 0.000747 279.6700n 0.000792 279.6800n 0.000835 279.6900n 0.000876 279.7000n 0.000914 279.7100n 0.000947 279.7200n 0.000976 279.7300n 0.000999 279.7400n 0.001015
+ 279.7500n 0.001025 279.7600n 0.001027 279.7700n 0.001022 279.7800n 0.001007 279.7900n 0.000984 279.8000n 0.000951 279.8100n 0.000909 279.8200n 0.000856 279.8300n 0.000794 279.8400n 0.000722 279.8500n 0.000640 279.8600n 0.000548 279.8700n 0.000447 279.8800n 0.000337 279.8900n 0.000219
+ 279.9000n 0.000093 279.9100n -0.000039 279.9200n -0.000177 279.9300n -0.000318 279.9400n -0.000463 279.9500n -0.000609 279.9600n -0.000755 279.9700n -0.000899 279.9800n -0.001040 279.9900n -0.001175 280.0000n -0.001304 280.0100n -0.001423 280.0200n -0.001531 280.0300n -0.001627 280.0400n -0.001708
+ 280.0500n -0.001774 280.0600n -0.001822 280.0700n -0.001852 280.0800n -0.001863 280.0900n -0.001854 280.1000n -0.001824 280.1100n -0.001774 280.1200n -0.001703 280.1300n -0.001613 280.1400n -0.001504 280.1500n -0.001377 280.1600n -0.001235 280.1700n -0.001078 280.1800n -0.000909 280.1900n -0.000731
+ 280.2000n -0.000546 280.2100n -0.000357 280.2200n -0.000168 280.2300n 0.000020 280.2400n 0.000202 280.2500n 0.000375 280.2600n 0.000536 280.2700n 0.000683 280.2800n 0.000813 280.2900n 0.000922 280.3000n 0.001010 280.3100n 0.001073 280.3200n 0.001111 280.3300n 0.001122 280.3400n 0.001107
+ 280.3500n 0.001064 280.3600n 0.000996 280.3700n 0.000901 280.3800n 0.000783 280.3900n 0.000642 280.4000n 0.000482 280.4100n 0.000304 280.4200n 0.000113 280.4300n -0.000088 280.4400n -0.000296 280.4500n -0.000507 280.4600n -0.000717 280.4700n -0.000921 280.4800n -0.001117 280.4900n -0.001300
+ 280.5000n -0.001466 280.5100n -0.001613 280.5200n -0.001738 280.5300n -0.001838 280.5400n -0.001911 280.5500n -0.001956 280.5600n -0.001972 280.5700n -0.001958 280.5800n -0.001916 280.5900n -0.001845 280.6000n -0.001748 280.6100n -0.001627 280.6200n -0.001483 280.6300n -0.001321 280.6400n -0.001143
+ 280.6500n -0.000954 280.6600n -0.000757 280.6700n -0.000557 280.6800n -0.000357 280.6900n -0.000162 280.7000n 0.000023 280.7100n 0.000195 280.7200n 0.000350 280.7300n 0.000486 280.7400n 0.000598 280.7500n 0.000684 280.7600n 0.000744 280.7700n 0.000775 280.7800n 0.000777 280.7900n 0.000750
+ 280.8000n 0.000695 280.8100n 0.000612 280.8200n 0.000505 280.8300n 0.000375 280.8400n 0.000225 280.8500n 0.000059 280.8600n -0.000120 280.8700n -0.000306 280.8800n -0.000497 280.8900n -0.000688 280.9000n -0.000874 280.9100n -0.001052 280.9200n -0.001216 280.9300n -0.001364 280.9400n -0.001492
+ 280.9500n -0.001596 280.9600n -0.001675 280.9700n -0.001726 280.9800n -0.001749 280.9900n -0.001743 281.0000n -0.001707 281.0100n -0.001642 281.0200n -0.001550 281.0300n -0.001433 281.0400n -0.001293 281.0500n -0.001132 281.0600n -0.000956 281.0700n -0.000766 281.0800n -0.000568 281.0900n -0.000365
+ 281.1000n -0.000162 281.1100n 0.000038 281.1200n 0.000229 281.1300n 0.000408 281.1400n 0.000571 281.1500n 0.000716 281.1600n 0.000839 281.1700n 0.000939 281.1800n 0.001013 281.1900n 0.001062 281.2000n 0.001083 281.2100n 0.001079 281.2200n 0.001049 281.2300n 0.000996 281.2400n 0.000921
+ 281.2500n 0.000828 281.2600n 0.000719 281.2700n 0.000598 281.2800n 0.000468 281.2900n 0.000334 281.3000n 0.000200 281.3100n 0.000070 281.3200n -0.000053 281.3300n -0.000165 281.3400n -0.000261 281.3500n -0.000341 281.3600n -0.000400 281.3700n -0.000437 281.3800n -0.000452 281.3900n -0.000442
+ 281.4000n -0.000409 281.4100n -0.000353 281.4200n -0.000276 281.4300n -0.000179 281.4400n -0.000065 281.4500n 0.000061 281.4600n 0.000197 281.4700n 0.000338 281.4800n 0.000480 281.4900n 0.000618 281.5000n 0.000747 281.5100n 0.000863 281.5200n 0.000961 281.5300n 0.001037 281.5400n 0.001086
+ 281.5500n 0.001105 281.5600n 0.001092 281.5700n 0.001043 281.5800n 0.000959 281.5900n 0.000837 281.6000n 0.000678 281.6100n 0.000484 281.6200n 0.000254 281.6300n -0.000006 281.6400n -0.000295 281.6500n -0.000608 281.6600n -0.000940 281.6700n -0.001286 281.6800n -0.001641 281.6900n -0.001997
+ 281.7000n -0.002349 281.7100n -0.002691 281.7200n -0.003015 281.7300n -0.003315 281.7400n -0.003587 281.7500n -0.003823 281.7600n -0.004019 281.7700n -0.004172 281.7800n -0.004277 281.7900n -0.004332 281.8000n -0.004335 281.8100n -0.004285 281.8200n -0.004182 281.8300n -0.004029 281.8400n -0.003826
+ 281.8500n -0.003577 281.8600n -0.003285 281.8700n -0.002956 281.8800n -0.002595 281.8900n -0.002207 281.9000n -0.001800 281.9100n -0.001379 281.9200n -0.000953 281.9300n -0.000527 281.9400n -0.000109 281.9500n 0.000295 281.9600n 0.000677 281.9700n 0.001033 281.9800n 0.001358 281.9900n 0.001646
+ 282.0000n 0.001894 282.0100n 0.002099 282.0200n 0.002259 282.0300n 0.002374 282.0400n 0.002443 282.0500n 0.002467 282.0600n 0.002448 282.0700n 0.002390 282.0800n 0.002295 282.0900n 0.002167 282.1000n 0.002012 282.1100n 0.001836 282.1200n 0.001642 282.1300n 0.001439 282.1400n 0.001230
+ 282.1500n 0.001024 282.1600n 0.000825 282.1700n 0.000638 282.1800n 0.000470 282.1900n 0.000324 282.2000n 0.000205 282.2100n 0.000115 282.2200n 0.000057 282.2300n 0.000032 282.2400n 0.000041 282.2500n 0.000084 282.2600n 0.000159 282.2700n 0.000266 282.2800n 0.000400 282.2900n 0.000558
+ 282.3000n 0.000738 282.3100n 0.000933 282.3200n 0.001138 282.3300n 0.001350 282.3400n 0.001561 282.3500n 0.001767 282.3600n 0.001961 282.3700n 0.002140 282.3800n 0.002297 282.3900n 0.002428 282.4000n 0.002530 282.4100n 0.002599 282.4200n 0.002633 282.4300n 0.002629 282.4400n 0.002588
+ 282.4500n 0.002508 282.4600n 0.002390 282.4700n 0.002237 282.4800n 0.002050 282.4900n 0.001832 282.5000n 0.001587 282.5100n 0.001320 282.5200n 0.001035 282.5300n 0.000737 282.5400n 0.000433 282.5500n 0.000127 282.5600n -0.000175 282.5700n -0.000467 282.5800n -0.000744 282.5900n -0.001002
+ 282.6000n -0.001235 282.6100n -0.001439 282.6200n -0.001612 282.6300n -0.001750 282.6400n -0.001852 282.6500n -0.001916 282.6600n -0.001942 282.6700n -0.001931 282.6800n -0.001883 282.6900n -0.001802 282.7000n -0.001688 282.7100n -0.001546 282.7200n -0.001380 282.7300n -0.001193 282.7400n -0.000991
+ 282.7500n -0.000777 282.7600n -0.000558 282.7700n -0.000338 282.7800n -0.000123 282.7900n 0.000084 282.8000n 0.000278 282.8100n 0.000454 282.8200n 0.000609 282.8300n 0.000741 282.8400n 0.000845 282.8500n 0.000922 282.8600n 0.000969 282.8700n 0.000987 282.8800n 0.000975 282.8900n 0.000935
+ 282.9000n 0.000868 282.9100n 0.000776 282.9200n 0.000662 282.9300n 0.000530 282.9400n 0.000382 282.9500n 0.000222 282.9600n 0.000055 282.9700n -0.000116 282.9800n -0.000286 282.9900n -0.000451 283.0000n -0.000608 283.0100n -0.000753 283.0200n -0.000884 283.0300n -0.000997 283.0400n -0.001090
+ 283.0500n -0.001161 283.0600n -0.001210 283.0700n -0.001235 283.0800n -0.001237 283.0900n -0.001217 283.1000n -0.001175 283.1100n -0.001114 283.1200n -0.001034 283.1300n -0.000940 283.1400n -0.000833 283.1500n -0.000717 283.1600n -0.000594 283.1700n -0.000469 283.1800n -0.000345 283.1900n -0.000224
+ 283.2000n -0.000111 283.2100n -0.000008 283.2200n 0.000082 283.2300n 0.000157 283.2400n 0.000216 283.2500n 0.000256 283.2600n 0.000276 283.2700n 0.000277 283.2800n 0.000257 283.2900n 0.000219 283.3000n 0.000162 283.3100n 0.000087 283.3200n -0.000002 283.3300n -0.000105 283.3400n -0.000218
+ 283.3500n -0.000339 283.3600n -0.000466 283.3700n -0.000594 283.3800n -0.000722 283.3900n -0.000847 283.4000n -0.000965 283.4100n -0.001075 283.4200n -0.001173 283.4300n -0.001258 283.4400n -0.001328 283.4500n -0.001382 283.4600n -0.001418 283.4700n -0.001437 283.4800n -0.001437 283.4900n -0.001420
+ 283.5000n -0.001386 283.5100n -0.001336 283.5200n -0.001271 283.5300n -0.001194 283.5400n -0.001105 283.5500n -0.001008 283.5600n -0.000903 283.5700n -0.000794 283.5800n -0.000684 283.5900n -0.000573 283.6000n -0.000464 283.6100n -0.000360 283.6200n -0.000261 283.6300n -0.000170 283.6400n -0.000088
+ 283.6500n -0.000015 283.6600n 0.000047 283.6700n 0.000098 283.6800n 0.000139 283.6900n 0.000170 283.7000n 0.000190 283.7100n 0.000203 283.7200n 0.000208 283.7300n 0.000206 283.7400n 0.000201 283.7500n 0.000192 283.7600n 0.000182 283.7700n 0.000173 283.7800n 0.000167 283.7900n 0.000164
+ 283.8000n 0.000167 283.8100n 0.000177 283.8200n 0.000194 283.8300n 0.000221 283.8400n 0.000257 283.8500n 0.000302 283.8600n 0.000358 283.8700n 0.000423 283.8800n 0.000497 283.8900n 0.000579 283.9000n 0.000668 283.9100n 0.000764 283.9200n 0.000863 283.9300n 0.000966 283.9400n 0.001070
+ 283.9500n 0.001173 283.9600n 0.001274 283.9700n 0.001371 283.9800n 0.001463 283.9900n 0.001547 284.0000n 0.001624 284.0100n 0.001690 284.0200n 0.001747 284.0300n 0.001793 284.0400n 0.001827 284.0500n 0.001850 284.0600n 0.001863 284.0700n 0.001864 284.0800n 0.001856 284.0900n 0.001839
+ 284.1000n 0.001814 284.1100n 0.001783 284.1200n 0.001747 284.1300n 0.001707 284.1400n 0.001666 284.1500n 0.001624 284.1600n 0.001583 284.1700n 0.001544 284.1800n 0.001509 284.1900n 0.001479 284.2000n 0.001454 284.2100n 0.001435 284.2200n 0.001422 284.2300n 0.001415 284.2400n 0.001413
+ 284.2500n 0.001416 284.2600n 0.001423 284.2700n 0.001433 284.2800n 0.001444 284.2900n 0.001455 284.3000n 0.001463 284.3100n 0.001468 284.3200n 0.001466 284.3300n 0.001456 284.3400n 0.001435 284.3500n 0.001403 284.3600n 0.001357 284.3700n 0.001295 284.3800n 0.001218 284.3900n 0.001123
+ 284.4000n 0.001010 284.4100n 0.000879 284.4200n 0.000731 284.4300n 0.000565 284.4400n 0.000384 284.4500n 0.000188 284.4600n -0.000020 284.4700n -0.000239 284.4800n -0.000465 284.4900n -0.000696 284.5000n -0.000929 284.5100n -0.001159 284.5200n -0.001385 284.5300n -0.001602 284.5400n -0.001806
+ 284.5500n -0.001996 284.5600n -0.002166 284.5700n -0.002315 284.5800n -0.002440 284.5900n -0.002539 284.6000n -0.002610 284.6100n -0.002651 284.6200n -0.002661 284.6300n -0.002641 284.6400n -0.002591 284.6500n -0.002512 284.6600n -0.002404 284.6700n -0.002270 284.6800n -0.002112 284.6900n -0.001933
+ 284.7000n -0.001736 284.7100n -0.001525 284.7200n -0.001304 284.7300n -0.001076 284.7400n -0.000846 284.7500n -0.000618 284.7600n -0.000396 284.7700n -0.000184 284.7800n 0.000014 284.7900n 0.000194 284.8000n 0.000355 284.8100n 0.000492 284.8200n 0.000604 284.8300n 0.000689 284.8400n 0.000746
+ 284.8500n 0.000774 284.8600n 0.000775 284.8700n 0.000747 284.8800n 0.000693 284.8900n 0.000615 284.9000n 0.000514 284.9100n 0.000394 284.9200n 0.000257 284.9300n 0.000108 284.9400n -0.000051 284.9500n -0.000214 284.9600n -0.000378 284.9700n -0.000539 284.9800n -0.000694 284.9900n -0.000837
+ 285.0000n -0.000966 285.0100n -0.001078 285.0200n -0.001169 285.0300n -0.001238 285.0400n -0.001282 285.0500n -0.001300 285.0600n -0.001292 285.0700n -0.001257 285.0800n -0.001196 285.0900n -0.001109 285.1000n -0.001000 285.1100n -0.000869 285.1200n -0.000720 285.1300n -0.000555 285.1400n -0.000378
+ 285.1500n -0.000194 285.1600n -0.000005 285.1700n 0.000184 285.1800n 0.000369 285.1900n 0.000545 285.2000n 0.000709 285.2100n 0.000856 285.2200n 0.000984 285.2300n 0.001089 285.2400n 0.001168 285.2500n 0.001218 285.2600n 0.001240 285.2700n 0.001230 285.2800n 0.001188 285.2900n 0.001115
+ 285.3000n 0.001012 285.3100n 0.000879 285.3200n 0.000718 285.3300n 0.000532 285.3400n 0.000324 285.3500n 0.000096 285.3600n -0.000146 285.3700n -0.000399 285.3800n -0.000660 285.3900n -0.000922 285.4000n -0.001182 285.4100n -0.001436 285.4200n -0.001678 285.4300n -0.001905 285.4400n -0.002112
+ 285.4500n -0.002296 285.4600n -0.002454 285.4700n -0.002582 285.4800n -0.002678 285.4900n -0.002742 285.5000n -0.002770 285.5100n -0.002764 285.5200n -0.002722 285.5300n -0.002646 285.5400n -0.002536 285.5500n -0.002395 285.5600n -0.002225 285.5700n -0.002028 285.5800n -0.001808 285.5900n -0.001569
+ 285.6000n -0.001314 285.6100n -0.001048 285.6200n -0.000775 285.6300n -0.000498 285.6400n -0.000224 285.6500n 0.000045 285.6600n 0.000303 285.6700n 0.000547 285.6800n 0.000773 285.6900n 0.000978 285.7000n 0.001158 285.7100n 0.001312 285.7200n 0.001436 285.7300n 0.001531 285.7400n 0.001593
+ 285.7500n 0.001624 285.7600n 0.001623 285.7700n 0.001590 285.7800n 0.001527 285.7900n 0.001435 285.8000n 0.001317 285.8100n 0.001173 285.8200n 0.001009 285.8300n 0.000825 285.8400n 0.000626 285.8500n 0.000414 285.8600n 0.000195 285.8700n -0.000030 285.8800n -0.000256 285.8900n -0.000479
+ 285.9000n -0.000697 285.9100n -0.000906 285.9200n -0.001104 285.9300n -0.001287 285.9400n -0.001453 285.9500n -0.001601 285.9600n -0.001728 285.9700n -0.001834 285.9800n -0.001918 285.9900n -0.001979 286.0000n -0.002019 286.0100n -0.002036 286.0200n -0.002033 286.0300n -0.002010 286.0400n -0.001970
+ 286.0500n -0.001914 286.0600n -0.001845 286.0700n -0.001764 286.0800n -0.001675 286.0900n -0.001581 286.1000n -0.001484 286.1100n -0.001386 286.1200n -0.001292 286.1300n -0.001203 286.1400n -0.001121 286.1500n -0.001050 286.1600n -0.000992 286.1700n -0.000947 286.1800n -0.000919 286.1900n -0.000907
+ 286.2000n -0.000912 286.2100n -0.000936 286.2200n -0.000978 286.2300n -0.001037 286.2400n -0.001113 286.2500n -0.001205 286.2600n -0.001311 286.2700n -0.001429 286.2800n -0.001558 286.2900n -0.001695 286.3000n -0.001837 286.3100n -0.001983 286.3200n -0.002128 286.3300n -0.002270 286.3400n -0.002406
+ 286.3500n -0.002534 286.3600n -0.002650 286.3700n -0.002752 286.3800n -0.002838 286.3900n -0.002904 286.4000n -0.002950 286.4100n -0.002974 286.4200n -0.002975 286.4300n -0.002951 286.4400n -0.002903 286.4500n -0.002830 286.4600n -0.002733 286.4700n -0.002612 286.4800n -0.002470 286.4900n -0.002307
+ 286.5000n -0.002125 286.5100n -0.001928 286.5200n -0.001717 286.5300n -0.001496 286.5400n -0.001268 286.5500n -0.001036 286.5600n -0.000803 286.5700n -0.000574 286.5800n -0.000351 286.5900n -0.000137 286.6000n 0.000063 286.6100n 0.000247 286.6200n 0.000412 286.6300n 0.000555 286.6400n 0.000675
+ 286.6500n 0.000769 286.6600n 0.000836 286.6700n 0.000875 286.6800n 0.000885 286.6900n 0.000866 286.7000n 0.000820 286.7100n 0.000746 286.7200n 0.000645 286.7300n 0.000521 286.7400n 0.000374 286.7500n 0.000207 286.7600n 0.000024 286.7700n -0.000174 286.7800n -0.000382 286.7900n -0.000597
+ 286.8000n -0.000815 286.8100n -0.001034 286.8200n -0.001249 286.8300n -0.001458 286.8400n -0.001656 286.8500n -0.001840 286.8600n -0.002008 286.8700n -0.002158 286.8800n -0.002286 286.8900n -0.002392 286.9000n -0.002474 286.9100n -0.002530 286.9200n -0.002561 286.9300n -0.002566 286.9400n -0.002546
+ 286.9500n -0.002501 286.9600n -0.002433 286.9700n -0.002344 286.9800n -0.002235 286.9900n -0.002109 287.0000n -0.001968 287.0100n -0.001816 287.0200n -0.001654 287.0300n -0.001486 287.0400n -0.001315 287.0500n -0.001145 287.0600n -0.000977 287.0700n -0.000816 287.0800n -0.000663 287.0900n -0.000521
+ 287.1000n -0.000392 287.1100n -0.000279 287.1200n -0.000181 287.1300n -0.000102 287.1400n -0.000040 287.1500n 0.000002 287.1600n 0.000026 287.1700n 0.000032 287.1800n 0.000020 287.1900n -0.000009 287.2000n -0.000052 287.2100n -0.000108 287.2200n -0.000175 287.2300n -0.000251 287.2400n -0.000334
+ 287.2500n -0.000421 287.2600n -0.000510 287.2700n -0.000598 287.2800n -0.000682 287.2900n -0.000761 287.3000n -0.000831 287.3100n -0.000892 287.3200n -0.000941 287.3300n -0.000976 287.3400n -0.000997 287.3500n -0.001002 287.3600n -0.000991 287.3700n -0.000963 287.3800n -0.000918 287.3900n -0.000857
+ 287.4000n -0.000780 287.4100n -0.000688 287.4200n -0.000584 287.4300n -0.000467 287.4400n -0.000340 287.4500n -0.000205 287.4600n -0.000063 287.4700n 0.000082 287.4800n 0.000228 287.4900n 0.000374 287.5000n 0.000516 287.5100n 0.000652 287.5200n 0.000781 287.5300n 0.000899 287.5400n 0.001005
+ 287.5500n 0.001097 287.5600n 0.001172 287.5700n 0.001231 287.5800n 0.001271 287.5900n 0.001291 287.6000n 0.001291 287.6100n 0.001270 287.6200n 0.001229 287.6300n 0.001166 287.6400n 0.001083 287.6500n 0.000979 287.6600n 0.000857 287.6700n 0.000716 287.6800n 0.000559 287.6900n 0.000387
+ 287.7000n 0.000200 287.7100n 0.000003 287.7200n -0.000205 287.7300n -0.000420 287.7400n -0.000641 287.7500n -0.000865 287.7600n -0.001090 287.7700n -0.001313 287.7800n -0.001533 287.7900n -0.001746 287.8000n -0.001951 287.8100n -0.002146 287.8200n -0.002328 287.8300n -0.002495 287.8400n -0.002645
+ 287.8500n -0.002777 287.8600n -0.002889 287.8700n -0.002980 287.8800n -0.003048 287.8900n -0.003092 287.9000n -0.003113 287.9100n -0.003108 287.9200n -0.003079 287.9300n -0.003024 287.9400n -0.002945 287.9500n -0.002842 287.9600n -0.002716 287.9700n -0.002568 287.9800n -0.002399 287.9900n -0.002212
+ 288.0000n -0.002008 288.0100n -0.001790 288.0200n -0.001561 288.0300n -0.001322 288.0400n -0.001078 288.0500n -0.000830 288.0600n -0.000583 288.0700n -0.000340 288.0800n -0.000103 288.0900n 0.000123 288.1000n 0.000336 288.1100n 0.000532 288.1200n 0.000709 288.1300n 0.000863 288.1400n 0.000992
+ 288.1500n 0.001095 288.1600n 0.001168 288.1700n 0.001211 288.1800n 0.001224 288.1900n 0.001204 288.2000n 0.001152 288.2100n 0.001070 288.2200n 0.000957 288.2300n 0.000815 288.2400n 0.000646 288.2500n 0.000453 288.2600n 0.000238 288.2700n 0.000006 288.2800n -0.000241 288.2900n -0.000499
+ 288.3000n -0.000762 288.3100n -0.001028 288.3200n -0.001291 288.3300n -0.001546 288.3400n -0.001790 288.3500n -0.002017 288.3600n -0.002225 288.3700n -0.002408 288.3800n -0.002564 288.3900n -0.002690 288.4000n -0.002783 288.4100n -0.002841 288.4200n -0.002863 288.4300n -0.002849 288.4400n -0.002799
+ 288.4500n -0.002713 288.4600n -0.002592 288.4700n -0.002440 288.4800n -0.002259 288.4900n -0.002052 288.5000n -0.001823 288.5100n -0.001577 288.5200n -0.001319 288.5300n -0.001053 288.5400n -0.000784 288.5500n -0.000519 288.5600n -0.000263 288.5700n -0.000021 288.5800n 0.000202 288.5900n 0.000402
+ 288.6000n 0.000573 288.6100n 0.000712 288.6200n 0.000815 288.6300n 0.000881 288.6400n 0.000908 288.6500n 0.000894 288.6600n 0.000839 288.6700n 0.000744 288.6800n 0.000611 288.6900n 0.000441 288.7000n 0.000239 288.7100n 0.000007 288.7200n -0.000249 288.7300n -0.000524 288.7400n -0.000813
+ 288.7500n -0.001110 288.7600n -0.001408 288.7700n -0.001702 288.7800n -0.001983 288.7900n -0.002247 288.8000n -0.002488 288.8100n -0.002698 288.8200n -0.002874 288.8300n -0.003011 288.8400n -0.003104 288.8500n -0.003150 288.8600n -0.003148 288.8700n -0.003096 288.8800n -0.002993 288.8900n -0.002841
+ 288.9000n -0.002640 288.9100n -0.002394 288.9200n -0.002105 288.9300n -0.001779 288.9400n -0.001420 288.9500n -0.001034 288.9600n -0.000627 288.9700n -0.000207 288.9800n 0.000219 288.9900n 0.000645 289.0000n 0.001063 289.0100n 0.001465 289.0200n 0.001844 289.0300n 0.002195 289.0400n 0.002510
+ 289.0500n 0.002784 289.0600n 0.003012 289.0700n 0.003191 289.0800n 0.003317 289.0900n 0.003389 289.1000n 0.003405 289.1100n 0.003366 289.1200n 0.003273 289.1300n 0.003128 289.1400n 0.002933 289.1500n 0.002694 289.1600n 0.002414 289.1700n 0.002100 289.1800n 0.001757 289.1900n 0.001393
+ 289.2000n 0.001014 289.2100n 0.000628 289.2200n 0.000242 289.2300n -0.000137 289.2400n -0.000501 289.2500n -0.000845 289.2600n -0.001161 289.2700n -0.001445 289.2800n -0.001691 289.2900n -0.001895 289.3000n -0.002055 289.3100n -0.002168 289.3200n -0.002232 289.3300n -0.002247 289.3400n -0.002215
+ 289.3500n -0.002136 289.3600n -0.002014 289.3700n -0.001851 289.3800n -0.001652 289.3900n -0.001422 289.4000n -0.001165 289.4100n -0.000888 289.4200n -0.000597 289.4300n -0.000298 289.4400n 0.000003 289.4500n 0.000300 289.4600n 0.000587 289.4700n 0.000857 289.4800n 0.001107 289.4900n 0.001332
+ 289.5000n 0.001527 289.5100n 0.001690 289.5200n 0.001818 289.5300n 0.001910 289.5400n 0.001965 289.5500n 0.001983 289.5600n 0.001965 289.5700n 0.001913 289.5800n 0.001830 289.5900n 0.001718 289.6000n 0.001580 289.6100n 0.001422 289.6200n 0.001248 289.6300n 0.001062 289.6400n 0.000870
+ 289.6500n 0.000676 289.6600n 0.000485 289.6700n 0.000302 289.6800n 0.000131 289.6900n -0.000024 289.7000n -0.000159 289.7100n -0.000272 289.7200n -0.000359 289.7300n -0.000420 289.7400n -0.000454 289.7500n -0.000460 289.7600n -0.000439 289.7700n -0.000391 289.7800n -0.000318 289.7900n -0.000223
+ 289.8000n -0.000108 289.8100n 0.000024 289.8200n 0.000168 289.8300n 0.000323 289.8400n 0.000483 289.8500n 0.000645 289.8600n 0.000805 289.8700n 0.000959 289.8800n 0.001104 289.8900n 0.001237 289.9000n 0.001355 289.9100n 0.001455 289.9200n 0.001537 289.9300n 0.001599 289.9400n 0.001639
+ 289.9500n 0.001659 289.9600n 0.001659 289.9700n 0.001639 289.9800n 0.001601 289.9900n 0.001548 290.0000n 0.001481 290.0100n 0.001404 290.0200n 0.001320 290.0300n 0.001231 290.0400n 0.001141 290.0500n 0.001053 290.0600n 0.000970 290.0700n 0.000896 290.0800n 0.000833 290.0900n 0.000783
+ 290.1000n 0.000748 290.1100n 0.000730 290.1200n 0.000730 290.1300n 0.000748 290.1400n 0.000784 290.1500n 0.000838 290.1600n 0.000908 290.1700n 0.000994 290.1800n 0.001092 290.1900n 0.001200 290.2000n 0.001316 290.2100n 0.001436 290.2200n 0.001556 290.2300n 0.001675 290.2400n 0.001787
+ 290.2500n 0.001890 290.2600n 0.001980 290.2700n 0.002055 290.2800n 0.002111 290.2900n 0.002147 290.3000n 0.002160 290.3100n 0.002149 290.3200n 0.002114 290.3300n 0.002053 290.3400n 0.001968 290.3500n 0.001858 290.3600n 0.001727 290.3700n 0.001574 290.3800n 0.001404 290.3900n 0.001218
+ 290.4000n 0.001020 290.4100n 0.000814 290.4200n 0.000603 290.4300n 0.000391 290.4400n 0.000182 290.4500n -0.000020 290.4600n -0.000212 290.4700n -0.000390 290.4800n -0.000551 290.4900n -0.000692 290.5000n -0.000811 290.5100n -0.000906 290.5200n -0.000976 290.5300n -0.001020 290.5400n -0.001038
+ 290.5500n -0.001030 290.5600n -0.000998 290.5700n -0.000943 290.5800n -0.000867 290.5900n -0.000773 290.6000n -0.000663 290.6100n -0.000540 290.6200n -0.000409 290.6300n -0.000272 290.6400n -0.000133 290.6500n 0.000004 290.6600n 0.000137 290.6700n 0.000261 290.6800n 0.000374 290.6900n 0.000474
+ 290.7000n 0.000558 290.7100n 0.000624 290.7200n 0.000673 290.7300n 0.000702 290.7400n 0.000712 290.7500n 0.000704 290.7600n 0.000679 290.7700n 0.000638 290.7800n 0.000583 290.7900n 0.000517 290.8000n 0.000443 290.8100n 0.000364 290.8200n 0.000282 290.8300n 0.000202 290.8400n 0.000126
+ 290.8500n 0.000059 290.8600n 0.000003 290.8700n -0.000040 290.8800n -0.000066 290.8900n -0.000073 290.9000n -0.000060 290.9100n -0.000025 290.9200n 0.000032 290.9300n 0.000110 290.9400n 0.000210 290.9500n 0.000331 290.9600n 0.000470 290.9700n 0.000625 290.9800n 0.000794 290.9900n 0.000973
+ 291.0000n 0.001158 291.0100n 0.001347 291.0200n 0.001534 291.0300n 0.001717 291.0400n 0.001890 291.0500n 0.002050 291.0600n 0.002193 291.0700n 0.002315 291.0800n 0.002414 291.0900n 0.002487 291.1000n 0.002531 291.1100n 0.002545 291.1200n 0.002529 291.1300n 0.002482 291.1400n 0.002404
+ 291.1500n 0.002296 291.1600n 0.002161 291.1700n 0.002000 291.1800n 0.001817 291.1900n 0.001615 291.2000n 0.001398 291.2100n 0.001171 291.2200n 0.000937 291.2300n 0.000701 291.2400n 0.000469 291.2500n 0.000244 291.2600n 0.000033 291.2700n -0.000163 291.2800n -0.000337 291.2900n -0.000487
+ 291.3000n -0.000610 291.3100n -0.000703 291.3200n -0.000765 291.3300n -0.000794 291.3400n -0.000790 291.3500n -0.000754 291.3600n -0.000686 291.3700n -0.000589 291.3800n -0.000465 291.3900n -0.000316 291.4000n -0.000147 291.4100n 0.000040 291.4200n 0.000238 291.4300n 0.000445 291.4400n 0.000654
+ 291.4500n 0.000862 291.4600n 0.001063 291.4700n 0.001253 291.4800n 0.001427 291.4900n 0.001583 291.5000n 0.001715 291.5100n 0.001823 291.5200n 0.001902 291.5300n 0.001951 291.5400n 0.001971 291.5500n 0.001959 291.5600n 0.001918 291.5700n 0.001847 291.5800n 0.001750 291.5900n 0.001629
+ 291.6000n 0.001487 291.6100n 0.001327 291.6200n 0.001155 291.6300n 0.000974 291.6400n 0.000789 291.6500n 0.000605 291.6600n 0.000428 291.6700n 0.000262 291.6800n 0.000111 291.6900n -0.000020 291.7000n -0.000127 291.7100n -0.000206 291.7200n -0.000255 291.7300n -0.000271 291.7400n -0.000252
+ 291.7500n -0.000199 291.7600n -0.000110 291.7700n 0.000014 291.7800n 0.000171 291.7900n 0.000360 291.8000n 0.000577 291.8100n 0.000820 291.8200n 0.001084 291.8300n 0.001364 291.8400n 0.001657 291.8500n 0.001957 291.8600n 0.002258 291.8700n 0.002556 291.8800n 0.002846 291.8900n 0.003121
+ 291.9000n 0.003377 291.9100n 0.003610 291.9200n 0.003816 291.9300n 0.003990 291.9400n 0.004130 291.9500n 0.004233 291.9600n 0.004298 291.9700n 0.004323 291.9800n 0.004309 291.9900n 0.004255 292.0000n 0.004163 292.0100n 0.004034 292.0200n 0.003871 292.0300n 0.003677 292.0400n 0.003455
+ 292.0500n 0.003210 292.0600n 0.002944 292.0700n 0.002664 292.0800n 0.002373 292.0900n 0.002077 292.1000n 0.001779 292.1100n 0.001485 292.1200n 0.001198 292.1300n 0.000924 292.1400n 0.000666 292.1500n 0.000427 292.1600n 0.000209 292.1700n 0.000017 292.1800n -0.000150 292.1900n -0.000288
+ 292.2000n -0.000399 292.2100n -0.000481 292.2200n -0.000534 292.2300n -0.000561 292.2400n -0.000561 292.2500n -0.000537 292.2600n -0.000491 292.2700n -0.000426 292.2800n -0.000343 292.2900n -0.000247 292.3000n -0.000139 292.3100n -0.000023 292.3200n 0.000097 292.3300n 0.000220 292.3400n 0.000342
+ 292.3500n 0.000461 292.3600n 0.000574 292.3700n 0.000679 292.3800n 0.000774 292.3900n 0.000859 292.4000n 0.000930 292.4100n 0.000989 292.4200n 0.001035 292.4300n 0.001066 292.4400n 0.001084 292.4500n 0.001089 292.4600n 0.001082 292.4700n 0.001064 292.4800n 0.001035 292.4900n 0.000998
+ 292.5000n 0.000953 292.5100n 0.000903 292.5200n 0.000848 292.5300n 0.000790 292.5400n 0.000731 292.5500n 0.000672 292.5600n 0.000615 292.5700n 0.000559 292.5800n 0.000508 292.5900n 0.000461 292.6000n 0.000419 292.6100n 0.000383 292.6200n 0.000353 292.6300n 0.000329 292.6400n 0.000312
+ 292.6500n 0.000301 292.6600n 0.000297 292.6700n 0.000298 292.6800n 0.000305 292.6900n 0.000317 292.7000n 0.000334 292.7100n 0.000355 292.7200n 0.000380 292.7300n 0.000408 292.7400n 0.000439 292.7500n 0.000472 292.7600n 0.000508 292.7700n 0.000545 292.7800n 0.000583 292.7900n 0.000623
+ 292.8000n 0.000663 292.8100n 0.000704 292.8200n 0.000745 292.8300n 0.000786 292.8400n 0.000828 292.8500n 0.000869 292.8600n 0.000910 292.8700n 0.000950 292.8800n 0.000990 292.8900n 0.001027 292.9000n 0.001063 292.9100n 0.001097 292.9200n 0.001128 292.9300n 0.001155 292.9400n 0.001177
+ 292.9500n 0.001195 292.9600n 0.001207 292.9700n 0.001213 292.9800n 0.001211 292.9900n 0.001202 293.0000n 0.001184 293.0100n 0.001156 293.0200n 0.001119 293.0300n 0.001072 293.0400n 0.001015 293.0500n 0.000947 293.0600n 0.000870 293.0700n 0.000782 293.0800n 0.000685 293.0900n 0.000580
+ 293.1000n 0.000467 293.1100n 0.000348 293.1200n 0.000223 293.1300n 0.000095 293.1400n -0.000035 293.1500n -0.000165 293.1600n -0.000293 293.1700n -0.000418 293.1800n -0.000537 293.1900n -0.000649 293.2000n -0.000751 293.2100n -0.000843 293.2200n -0.000921 293.2300n -0.000986 293.2400n -0.001035
+ 293.2500n -0.001068 293.2600n -0.001083 293.2700n -0.001082 293.2800n -0.001063 293.2900n -0.001027 293.3000n -0.000974 293.3100n -0.000906 293.3200n -0.000824 293.3300n -0.000728 293.3400n -0.000622 293.3500n -0.000507 293.3600n -0.000385 293.3700n -0.000260 293.3800n -0.000132 293.3900n -0.000005
+ 293.4000n 0.000118 293.4100n 0.000236 293.4200n 0.000345 293.4300n 0.000444 293.4400n 0.000530 293.4500n 0.000602 293.4600n 0.000659 293.4700n 0.000698 293.4800n 0.000721 293.4900n 0.000725 293.5000n 0.000712 293.5100n 0.000682 293.5200n 0.000635 293.5300n 0.000573 293.5400n 0.000498
+ 293.5500n 0.000411 293.5600n 0.000315 293.5700n 0.000213 293.5800n 0.000105 293.5900n -0.000003 293.6000n -0.000110 293.6100n -0.000213 293.6200n -0.000309 293.6300n -0.000396 293.6400n -0.000471 293.6500n -0.000531 293.6600n -0.000575 293.6700n -0.000602 293.6800n -0.000610 293.6900n -0.000598
+ 293.7000n -0.000567 293.7100n -0.000515 293.7200n -0.000445 293.7300n -0.000355 293.7400n -0.000250 293.7500n -0.000128 293.7600n 0.000006 293.7700n 0.000150 293.7800n 0.000303 293.7900n 0.000461 293.8000n 0.000620 293.8100n 0.000778 293.8200n 0.000933 293.8300n 0.001080 293.8400n 0.001216
+ 293.8500n 0.001340 293.8600n 0.001449 293.8700n 0.001540 293.8800n 0.001612 293.8900n 0.001663 293.9000n 0.001693 293.9100n 0.001700 293.9200n 0.001685 293.9300n 0.001648 293.9400n 0.001590 293.9500n 0.001512 293.9600n 0.001415 293.9700n 0.001302 293.9800n 0.001174 293.9900n 0.001035
+ 294.0000n 0.000886 294.0100n 0.000732 294.0200n 0.000573 294.0300n 0.000415 294.0400n 0.000258 294.0500n 0.000107 294.0600n -0.000037 294.0700n -0.000171 294.0800n -0.000293 294.0900n -0.000401 294.1000n -0.000495 294.1100n -0.000573 294.1200n -0.000634 294.1300n -0.000678 294.1400n -0.000706
+ 294.1500n -0.000718 294.1600n -0.000714 294.1700n -0.000697 294.1800n -0.000667 294.1900n -0.000626 294.2000n -0.000577 294.2100n -0.000520 294.2200n -0.000459 294.2300n -0.000394 294.2400n -0.000329 294.2500n -0.000264 294.2600n -0.000202 294.2700n -0.000145 294.2800n -0.000092 294.2900n -0.000045
+ 294.3000n -0.000006 294.3100n 0.000027 294.3200n 0.000053 294.3300n 0.000073 294.3400n 0.000087 294.3500n 0.000096 294.3600n 0.000103 294.3700n 0.000108 294.3800n 0.000114 294.3900n 0.000122 294.4000n 0.000134 294.4100n 0.000154 294.4200n 0.000182 294.4300n 0.000221 294.4400n 0.000274
+ 294.4500n 0.000340 294.4600n 0.000423 294.4700n 0.000523 294.4800n 0.000640 294.4900n 0.000776 294.5000n 0.000930 294.5100n 0.001101 294.5200n 0.001289 294.5300n 0.001492 294.5400n 0.001708 294.5500n 0.001935 294.5600n 0.002170 294.5700n 0.002411 294.5800n 0.002653 294.5900n 0.002894
+ 294.6000n 0.003129 294.6100n 0.003356 294.6200n 0.003569 294.6300n 0.003765 294.6400n 0.003941 294.6500n 0.004093 294.6600n 0.004218 294.6700n 0.004313 294.6800n 0.004375 294.6900n 0.004403 294.7000n 0.004395 294.7100n 0.004349 294.7200n 0.004266 294.7300n 0.004146 294.7400n 0.003989
+ 294.7500n 0.003796 294.7600n 0.003570 294.7700n 0.003312 294.7800n 0.003026 294.7900n 0.002714 294.8000n 0.002380 294.8100n 0.002029 294.8200n 0.001664 294.8300n 0.001289 294.8400n 0.000910 294.8500n 0.000530 294.8600n 0.000154 294.8700n -0.000214 294.8800n -0.000570 294.8900n -0.000909
+ 294.9000n -0.001229 294.9100n -0.001526 294.9200n -0.001797 294.9300n -0.002041 294.9400n -0.002254 294.9500n -0.002437 294.9600n -0.002588 294.9700n -0.002706 294.9800n -0.002792 294.9900n -0.002846 295.0000n -0.002869 295.0100n -0.002863 295.0200n -0.002828 295.0300n -0.002768 295.0400n -0.002684
+ 295.0500n -0.002579 295.0600n -0.002455 295.0700n -0.002315 295.0800n -0.002161 295.0900n -0.001996 295.1000n -0.001823 295.1100n -0.001644 295.1200n -0.001462 295.1300n -0.001278 295.1400n -0.001095 295.1500n -0.000913 295.1600n -0.000736 295.1700n -0.000563 295.1800n -0.000396 295.1900n -0.000236
+ 295.2000n -0.000083 295.2100n 0.000062 295.2200n 0.000199 295.2300n 0.000329 295.2400n 0.000451 295.2500n 0.000566 295.2600n 0.000673 295.2700n 0.000773 295.2800n 0.000867 295.2900n 0.000954 295.3000n 0.001035 295.3100n 0.001111 295.3200n 0.001180 295.3300n 0.001243 295.3400n 0.001300
+ 295.3500n 0.001352 295.3600n 0.001396 295.3700n 0.001434 295.3800n 0.001465 295.3900n 0.001487 295.4000n 0.001501 295.4100n 0.001506 295.4200n 0.001502 295.4300n 0.001487 295.4400n 0.001462 295.4500n 0.001426 295.4600n 0.001378 295.4700n 0.001318 295.4800n 0.001247 295.4900n 0.001164
+ 295.5000n 0.001070 295.5100n 0.000965 295.5200n 0.000850 295.5300n 0.000725 295.5400n 0.000592 295.5500n 0.000452 295.5600n 0.000306 295.5700n 0.000155 295.5800n 0.000002 295.5900n -0.000153 295.6000n -0.000306 295.6100n -0.000458 295.6200n -0.000605 295.6300n -0.000746 295.6400n -0.000880
+ 295.6500n -0.001004 295.6600n -0.001118 295.6700n -0.001220 295.6800n -0.001309 295.6900n -0.001384 295.7000n -0.001444 295.7100n -0.001489 295.7200n -0.001519 295.7300n -0.001534 295.7400n -0.001533 295.7500n -0.001518 295.7600n -0.001489 295.7700n -0.001446 295.7800n -0.001392 295.7900n -0.001327
+ 295.8000n -0.001252 295.8100n -0.001170 295.8200n -0.001081 295.8300n -0.000987 295.8400n -0.000889 295.8500n -0.000790 295.8600n -0.000691 295.8700n -0.000594 295.8800n -0.000498 295.8900n -0.000407 295.9000n -0.000321 295.9100n -0.000241 295.9200n -0.000168 295.9300n -0.000102 295.9400n -0.000044
+ 295.9500n 0.000005 295.9600n 0.000045 295.9700n 0.000077 295.9800n 0.000099 295.9900n 0.000114 296.0000n 0.000120 296.0100n 0.000118 296.0200n 0.000109 296.0300n 0.000093 296.0400n 0.000070 296.0500n 0.000041 296.0600n 0.000007 296.0700n -0.000032 296.0800n -0.000075 296.0900n -0.000123
+ 296.1000n -0.000173 296.1100n -0.000227 296.1200n -0.000284 296.1300n -0.000343 296.1400n -0.000404 296.1500n -0.000467 296.1600n -0.000532 296.1700n -0.000598 296.1800n -0.000665 296.1900n -0.000733 296.2000n -0.000802 296.2100n -0.000871 296.2200n -0.000941 296.2300n -0.001010 296.2400n -0.001078
+ 296.2500n -0.001145 296.2600n -0.001210 296.2700n -0.001272 296.2800n -0.001332 296.2900n -0.001387 296.3000n -0.001438 296.3100n -0.001484 296.3200n -0.001524 296.3300n -0.001557 296.3400n -0.001582 296.3500n -0.001599 296.3600n -0.001608 296.3700n -0.001607 296.3800n -0.001597 296.3900n -0.001577
+ 296.4000n -0.001548 296.4100n -0.001508 296.4200n -0.001460 296.4300n -0.001402 296.4400n -0.001336 296.4500n -0.001263 296.4600n -0.001184 296.4700n -0.001099 296.4800n -0.001010 296.4900n -0.000920 296.5000n -0.000828 296.5100n -0.000738 296.5200n -0.000649 296.5300n -0.000566 296.5400n -0.000488
+ 296.5500n -0.000418 296.5600n -0.000357 296.5700n -0.000307 296.5800n -0.000268 296.5900n -0.000242 296.6000n -0.000230 296.6100n -0.000232 296.6200n -0.000248 296.6300n -0.000278 296.6400n -0.000322 296.6500n -0.000379 296.6600n -0.000449 296.6700n -0.000529 296.6800n -0.000619 296.6900n -0.000717
+ 296.7000n -0.000820 296.7100n -0.000926 296.7200n -0.001034 296.7300n -0.001141 296.7400n -0.001243 296.7500n -0.001340 296.7600n -0.001428 296.7700n -0.001505 296.7800n -0.001568 296.7900n -0.001617 296.8000n -0.001649 296.8100n -0.001663 296.8200n -0.001658 296.8300n -0.001632 296.8400n -0.001587
+ 296.8500n -0.001520 296.8600n -0.001434 296.8700n -0.001329 296.8800n -0.001206 296.8900n -0.001066 296.9000n -0.000911 296.9100n -0.000743 296.9200n -0.000566 296.9300n -0.000380 296.9400n -0.000190 296.9500n 0.000002 296.9600n 0.000194 296.9700n 0.000382 296.9800n 0.000564 296.9900n 0.000736
+ 297.0000n 0.000897 297.0100n 0.001044 297.0200n 0.001174 297.0300n 0.001288 297.0400n 0.001382 297.0500n 0.001456 297.0600n 0.001510 297.0700n 0.001543 297.0800n 0.001555 297.0900n 0.001547 297.1000n 0.001520 297.1100n 0.001474 297.1200n 0.001413 297.1300n 0.001336 297.1400n 0.001246
+ 297.1500n 0.001146 297.1600n 0.001038 297.1700n 0.000923 297.1800n 0.000805 297.1900n 0.000685 297.2000n 0.000566 297.2100n 0.000449 297.2200n 0.000337 297.2300n 0.000231 297.2400n 0.000132 297.2500n 0.000043 297.2600n -0.000038 297.2700n -0.000109 297.2800n -0.000170 297.2900n -0.000222
+ 297.3000n -0.000264 297.3100n -0.000298 297.3200n -0.000325 297.3300n -0.000345 297.3400n -0.000359 297.3500n -0.000371 297.3600n -0.000380 297.3700n -0.000388 297.3800n -0.000396 297.3900n -0.000407 297.4000n -0.000420 297.4100n -0.000438 297.4200n -0.000461 297.4300n -0.000488 297.4400n -0.000522
+ 297.4500n -0.000560 297.4600n -0.000604 297.4700n -0.000652 297.4800n -0.000704 297.4900n -0.000757 297.5000n -0.000812 297.5100n -0.000865 297.5200n -0.000915 297.5300n -0.000960 297.5400n -0.000998 297.5500n -0.001026 297.5600n -0.001044 297.5700n -0.001047 297.5800n -0.001036 297.5900n -0.001007
+ 297.6000n -0.000961 297.6100n -0.000895 297.6200n -0.000809 297.6300n -0.000703 297.6400n -0.000578 297.6500n -0.000433 297.6600n -0.000269 297.6700n -0.000089 297.6800n 0.000106 297.6900n 0.000313 297.7000n 0.000529 297.7100n 0.000752 297.7200n 0.000979 297.7300n 0.001204 297.7400n 0.001426
+ 297.7500n 0.001639 297.7600n 0.001840 297.7700n 0.002025 297.7800n 0.002191 297.7900n 0.002334 297.8000n 0.002452 297.8100n 0.002540 297.8200n 0.002598 297.8300n 0.002623 297.8400n 0.002615 297.8500n 0.002572 297.8600n 0.002494 297.8700n 0.002383 297.8800n 0.002240 297.8900n 0.002066
+ 297.9000n 0.001863 297.9100n 0.001636 297.9200n 0.001387 297.9300n 0.001120 297.9400n 0.000840 297.9500n 0.000552 297.9600n 0.000260 297.9700n -0.000031 297.9800n -0.000315 297.9900n -0.000588 298.0000n -0.000845 298.0100n -0.001081 298.0200n -0.001291 298.0300n -0.001473 298.0400n -0.001623
+ 298.0500n -0.001737 298.0600n -0.001814 298.0700n -0.001852 298.0800n -0.001851 298.0900n -0.001809 298.1000n -0.001729 298.1100n -0.001610 298.1200n -0.001455 298.1300n -0.001266 298.1400n -0.001047 298.1500n -0.000801 298.1600n -0.000532 298.1700n -0.000245 298.1800n 0.000055 298.1900n 0.000364
+ 298.2000n 0.000677 298.2100n 0.000987 298.2200n 0.001291 298.2300n 0.001582 298.2400n 0.001857 298.2500n 0.002112 298.2600n 0.002341 298.2700n 0.002542 298.2800n 0.002712 298.2900n 0.002849 298.3000n 0.002950 298.3100n 0.003014 298.3200n 0.003041 298.3300n 0.003032 298.3400n 0.002986
+ 298.3500n 0.002905 298.3600n 0.002790 298.3700n 0.002645 298.3800n 0.002472 298.3900n 0.002274 298.4000n 0.002055 298.4100n 0.001818 298.4200n 0.001568 298.4300n 0.001307 298.4400n 0.001041 298.4500n 0.000773 298.4600n 0.000507 298.4700n 0.000246 298.4800n -0.000006 298.4900n -0.000246
+ 298.5000n -0.000472 298.5100n -0.000681 298.5200n -0.000872 298.5300n -0.001043 298.5400n -0.001193 298.5500n -0.001322 298.5600n -0.001429 298.5700n -0.001516 298.5800n -0.001582 298.5900n -0.001630 298.6000n -0.001660 298.6100n -0.001674 298.6200n -0.001674 298.6300n -0.001662 298.6400n -0.001640
+ 298.6500n -0.001612 298.6600n -0.001578 298.6700n -0.001541 298.6800n -0.001503 298.6900n -0.001467 298.7000n -0.001434 298.7100n -0.001405 298.7200n -0.001382 298.7300n -0.001367 298.7400n -0.001359 298.7500n -0.001360 298.7600n -0.001369 298.7700n -0.001387 298.7800n -0.001413 298.7900n -0.001447
+ 298.8000n -0.001488 298.8100n -0.001534 298.8200n -0.001586 298.8300n -0.001640 298.8400n -0.001697 298.8500n -0.001754 298.8600n -0.001810 298.8700n -0.001863 298.8800n -0.001912 298.8900n -0.001955 298.9000n -0.001991 298.9100n -0.002019 298.9200n -0.002038 298.9300n -0.002046 298.9400n -0.002044
+ 298.9500n -0.002029 298.9600n -0.002003 298.9700n -0.001964 298.9800n -0.001914 298.9900n -0.001852 299.0000n -0.001778 299.0100n -0.001693 299.0200n -0.001598 299.0300n -0.001494 299.0400n -0.001382 299.0500n -0.001263 299.0600n -0.001137 299.0700n -0.001007 299.0800n -0.000874 299.0900n -0.000738
+ 299.1000n -0.000602 299.1100n -0.000466 299.1200n -0.000332 299.1300n -0.000201 299.1400n -0.000074 299.1500n 0.000048 299.1600n 0.000164 299.1700n 0.000273 299.1800n 0.000374 299.1900n 0.000467 299.2000n 0.000551 299.2100n 0.000626 299.2200n 0.000692 299.2300n 0.000747 299.2400n 0.000793
+ 299.2500n 0.000828 299.2600n 0.000853 299.2700n 0.000869 299.2800n 0.000875 299.2900n 0.000872 299.3000n 0.000861 299.3100n 0.000840 299.3200n 0.000813 299.3300n 0.000778 299.3400n 0.000736 299.3500n 0.000689 299.3600n 0.000636 299.3700n 0.000579 299.3800n 0.000519 299.3900n 0.000456
+ 299.4000n 0.000391 299.4100n 0.000324 299.4200n 0.000258 299.4300n 0.000192 299.4400n 0.000128 299.4500n 0.000066 299.4600n 0.000006 299.4700n -0.000050 299.4800n -0.000101 299.4900n -0.000148 299.5000n -0.000190 299.5100n -0.000226 299.5200n -0.000256 299.5300n -0.000279 299.5400n -0.000296
+ 299.5500n -0.000307 299.5600n -0.000311 299.5700n -0.000309 299.5800n -0.000300 299.5900n -0.000285 299.6000n -0.000265 299.6100n -0.000240 299.6200n -0.000210 299.6300n -0.000177 299.6400n -0.000139 299.6500n -0.000099 299.6600n -0.000056 299.6700n -0.000012 299.6800n 0.000033 299.6900n 0.000079
+ 299.7000n 0.000125 299.7100n 0.000170 299.7200n 0.000215 299.7300n 0.000258 299.7400n 0.000300 299.7500n 0.000341 299.7600n 0.000380 299.7700n 0.000418 299.7800n 0.000455 299.7900n 0.000491 299.8000n 0.000526 299.8100n 0.000561 299.8200n 0.000596 299.8300n 0.000632 299.8400n 0.000669
+ 299.8500n 0.000707 299.8600n 0.000747 299.8700n 0.000790 299.8800n 0.000834 299.8900n 0.000882 299.9000n 0.000931 299.9100n 0.000984 299.9200n 0.001038 299.9300n 0.001095 299.9400n 0.001152 299.9500n 0.001210 299.9600n 0.001268 299.9700n 0.001324 299.9800n 0.001377 299.9900n 0.001426
+ 300.0000n 0.001470 300.0100n 0.001507 300.0200n 0.001535 300.0300n 0.001553 300.0400n 0.001560 300.0500n 0.001553 300.0600n 0.001532 300.0700n 0.001495 300.0800n 0.001442 300.0900n 0.001371 300.1000n 0.001282 300.1100n 0.001175 300.1200n 0.001050 300.1300n 0.000907 300.1400n 0.000747
+ 300.1500n 0.000572 300.1600n 0.000382 300.1700n 0.000181 300.1800n -0.000031 300.1900n -0.000251 300.2000n -0.000475 300.2100n -0.000700 300.2200n -0.000924 300.2300n -0.001142 300.2400n -0.001352 300.2500n -0.001549 300.2600n -0.001730 300.2700n -0.001892 300.2800n -0.002031 300.2900n -0.002144
+ 300.3000n -0.002229 300.3100n -0.002283 300.3200n -0.002304 300.3300n -0.002292 300.3400n -0.002244 300.3500n -0.002161 300.3600n -0.002042 300.3700n -0.001890 300.3800n -0.001704 300.3900n -0.001488 300.4000n -0.001243 300.4100n -0.000973 300.4200n -0.000682 300.4300n -0.000373 300.4400n -0.000052
+ 300.4500n 0.000278 300.4600n 0.000611 300.4700n 0.000942 300.4800n 0.001266 300.4900n 0.001577 300.5000n 0.001871 300.5100n 0.002143 300.5200n 0.002389 300.5300n 0.002604 300.5400n 0.002785 300.5500n 0.002929 300.5600n 0.003033 300.5700n 0.003096 300.5800n 0.003117 300.5900n 0.003095
+ 300.6000n 0.003031 300.6100n 0.002926 300.6200n 0.002782 300.6300n 0.002601 300.6400n 0.002386 300.6500n 0.002142 300.6600n 0.001872 300.6700n 0.001581 300.6800n 0.001274 300.6900n 0.000956 300.7000n 0.000632 300.7100n 0.000309 300.7200n -0.000009 300.7300n -0.000317 300.7400n -0.000610
+ 300.7500n -0.000883 300.7600n -0.001133 300.7700n -0.001355 300.7800n -0.001548 300.7900n -0.001708 300.8000n -0.001834 300.8100n -0.001925 300.8200n -0.001981 300.8300n -0.002003 300.8400n -0.001992 300.8500n -0.001950 300.8600n -0.001879 300.8700n -0.001782 300.8800n -0.001663 300.8900n -0.001527
+ 300.9000n -0.001377 300.9100n -0.001217 300.9200n -0.001053 300.9300n -0.000889 300.9400n -0.000729 300.9500n -0.000579 300.9600n -0.000441 300.9700n -0.000321 300.9800n -0.000220 300.9900n -0.000142 301.0000n -0.000089 301.0100n -0.000062 301.0200n -0.000063 301.0300n -0.000092 301.0400n -0.000147
+ 301.0500n -0.000229 301.0600n -0.000335 301.0700n -0.000463 301.0800n -0.000611 301.0900n -0.000774 301.1000n -0.000950 301.1100n -0.001133 301.1200n -0.001321 301.1300n -0.001507 301.1400n -0.001689 301.1500n -0.001861 301.1600n -0.002020 301.1700n -0.002161 301.1800n -0.002281 301.1900n -0.002376
+ 301.2000n -0.002444 301.2100n -0.002482 301.2200n -0.002489 301.2300n -0.002464 301.2400n -0.002406 301.2500n -0.002316 301.2600n -0.002194 301.2700n -0.002043 301.2800n -0.001864 301.2900n -0.001659 301.3000n -0.001432 301.3100n -0.001187 301.3200n -0.000927 301.3300n -0.000657 301.3400n -0.000380
+ 301.3500n -0.000102 301.3600n 0.000174 301.3700n 0.000443 301.3800n 0.000700 301.3900n 0.000943 301.4000n 0.001167 301.4100n 0.001370 301.4200n 0.001548 301.4300n 0.001699 301.4400n 0.001821 301.4500n 0.001914 301.4600n 0.001977 301.4700n 0.002009 301.4800n 0.002011 301.4900n 0.001984
+ 301.5000n 0.001930 301.5100n 0.001851 301.5200n 0.001748 301.5300n 0.001624 301.5400n 0.001483 301.5500n 0.001327 301.5600n 0.001160 301.5700n 0.000985 301.5800n 0.000805 301.5900n 0.000624 301.6000n 0.000444 301.6100n 0.000268 301.6200n 0.000099 301.6300n -0.000061 301.6400n -0.000210
+ 301.6500n -0.000347 301.6600n -0.000470 301.6700n -0.000578 301.6800n -0.000672 301.6900n -0.000751 301.7000n -0.000815 301.7100n -0.000866 301.7200n -0.000904 301.7300n -0.000931 301.7400n -0.000948 301.7500n -0.000957 301.7600n -0.000959 301.7700n -0.000957 301.7800n -0.000951 301.7900n -0.000945
+ 301.8000n -0.000939 301.8100n -0.000935 301.8200n -0.000934 301.8300n -0.000939 301.8400n -0.000948 301.8500n -0.000964 301.8600n -0.000986 301.8700n -0.001015 301.8800n -0.001050 301.8900n -0.001090 301.9000n -0.001136 301.9100n -0.001186 301.9200n -0.001239 301.9300n -0.001294 301.9400n -0.001348
+ 301.9500n -0.001402 301.9600n -0.001453 301.9700n -0.001499 301.9800n -0.001539 301.9900n -0.001572 302.0000n -0.001596 302.0100n -0.001610 302.0200n -0.001613 302.0300n -0.001604 302.0400n -0.001583 302.0500n -0.001549 302.0600n -0.001503 302.0700n -0.001444 302.0800n -0.001372 302.0900n -0.001290
+ 302.1000n -0.001196 302.1100n -0.001093 302.1200n -0.000982 302.1300n -0.000864 302.1400n -0.000740 302.1500n -0.000612 302.1600n -0.000482 302.1700n -0.000352 302.1800n -0.000223 302.1900n -0.000096 302.2000n 0.000027 302.2100n 0.000144 302.2200n 0.000255 302.2300n 0.000358 302.2400n 0.000452
+ 302.2500n 0.000538 302.2600n 0.000613 302.2700n 0.000679 302.2800n 0.000734 302.2900n 0.000779 302.3000n 0.000814 302.3100n 0.000840 302.3200n 0.000856 302.3300n 0.000865 302.3400n 0.000865 302.3500n 0.000859 302.3600n 0.000847 302.3700n 0.000829 302.3800n 0.000808 302.3900n 0.000783
+ 302.4000n 0.000755 302.4100n 0.000725 302.4200n 0.000695 302.4300n 0.000663 302.4400n 0.000632 302.4500n 0.000601 302.4600n 0.000571 302.4700n 0.000543 302.4800n 0.000516 302.4900n 0.000490 302.5000n 0.000466 302.5100n 0.000444 302.5200n 0.000423 302.5300n 0.000405 302.5400n 0.000388
+ 302.5500n 0.000373 302.5600n 0.000360 302.5700n 0.000349 302.5800n 0.000341 302.5900n 0.000335 302.6000n 0.000331 302.6100n 0.000330 302.6200n 0.000332 302.6300n 0.000337 302.6400n 0.000346 302.6500n 0.000359 302.6600n 0.000376 302.6700n 0.000398 302.6800n 0.000424 302.6900n 0.000455
+ 302.7000n 0.000490 302.7100n 0.000531 302.7200n 0.000576 302.7300n 0.000625 302.7400n 0.000678 302.7500n 0.000733 302.7600n 0.000792 302.7700n 0.000851 302.7800n 0.000911 302.7900n 0.000970 302.8000n 0.001027 302.8100n 0.001080 302.8200n 0.001128 302.8300n 0.001169 302.8400n 0.001202
+ 302.8500n 0.001225 302.8600n 0.001236 302.8700n 0.001234 302.8800n 0.001218 302.8900n 0.001186 302.9000n 0.001137 302.9100n 0.001071 302.9200n 0.000987 302.9300n 0.000885 302.9400n 0.000765 302.9500n 0.000627 302.9600n 0.000473 302.9700n 0.000302 302.9800n 0.000117 302.9900n -0.000082
+ 303.0000n -0.000291 303.0100n -0.000509 303.0200n -0.000734 303.0300n -0.000962 303.0400n -0.001191 303.0500n -0.001418 303.0600n -0.001641 303.0700n -0.001855 303.0800n -0.002059 303.0900n -0.002250 303.1000n -0.002425 303.1100n -0.002581 303.1200n -0.002717 303.1300n -0.002831 303.1400n -0.002921
+ 303.1500n -0.002986 303.1600n -0.003026 303.1700n -0.003041 303.1800n -0.003030 303.1900n -0.002994 303.2000n -0.002935 303.2100n -0.002852 303.2200n -0.002750 303.2300n -0.002628 303.2400n -0.002490 303.2500n -0.002337 303.2600n -0.002174 303.2700n -0.002002 303.2800n -0.001824 303.2900n -0.001643
+ 303.3000n -0.001461 303.3100n -0.001282 303.3200n -0.001108 303.3300n -0.000940 303.3400n -0.000781 303.3500n -0.000633 303.3600n -0.000495 303.3700n -0.000370 303.3800n -0.000257 303.3900n -0.000157 303.4000n -0.000069 303.4100n 0.000007 303.4200n 0.000073 303.4300n 0.000130 303.4400n 0.000179
+ 303.4500n 0.000222 303.4600n 0.000261 303.4700n 0.000298 303.4800n 0.000336 303.4900n 0.000375 303.5000n 0.000419 303.5100n 0.000468 303.5200n 0.000525 303.5300n 0.000590 303.5400n 0.000664 303.5500n 0.000749 303.5600n 0.000844 303.5700n 0.000950 303.5800n 0.001065 303.5900n 0.001189
+ 303.6000n 0.001320 303.6100n 0.001456 303.6200n 0.001596 303.6300n 0.001738 303.6400n 0.001878 303.6500n 0.002015 303.6600n 0.002144 303.6700n 0.002264 303.6800n 0.002372 303.6900n 0.002464 303.7000n 0.002539 303.7100n 0.002594 303.7200n 0.002626 303.7300n 0.002636 303.7400n 0.002620
+ 303.7500n 0.002580 303.7600n 0.002514 303.7700n 0.002423 303.7800n 0.002308 303.7900n 0.002170 303.8000n 0.002011 303.8100n 0.001834 303.8200n 0.001642 303.8300n 0.001438 303.8400n 0.001225 303.8500n 0.001007 303.8600n 0.000789 303.8700n 0.000575 303.8800n 0.000369 303.8900n 0.000174
+ 303.9000n -0.000004 303.9100n -0.000164 303.9200n -0.000300 303.9300n -0.000410 303.9400n -0.000493 303.9500n -0.000545 303.9600n -0.000567 303.9700n -0.000557 303.9800n -0.000515 303.9900n -0.000443 304.0000n -0.000342 304.0100n -0.000213 304.0200n -0.000061 304.0300n 0.000112 304.0400n 0.000302
+ 304.0500n 0.000504 304.0600n 0.000715 304.0700n 0.000928 304.0800n 0.001139 304.0900n 0.001343 304.1000n 0.001534 304.1100n 0.001709 304.1200n 0.001861 304.1300n 0.001987 304.1400n 0.002083 304.1500n 0.002146 304.1600n 0.002174 304.1700n 0.002163 304.1800n 0.002114 304.1900n 0.002026
+ 304.2000n 0.001900 304.2100n 0.001736 304.2200n 0.001536 304.2300n 0.001304 304.2400n 0.001043 304.2500n 0.000756 304.2600n 0.000450 304.2700n 0.000128 304.2800n -0.000204 304.2900n -0.000539 304.3000n -0.000873 304.3100n -0.001198 304.3200n -0.001510 304.3300n -0.001803 304.3400n -0.002070
+ 304.3500n -0.002309 304.3600n -0.002513 304.3700n -0.002679 304.3800n -0.002805 304.3900n -0.002888 304.4000n -0.002927 304.4100n -0.002920 304.4200n -0.002869 304.4300n -0.002774 304.4400n -0.002637 304.4500n -0.002461 304.4600n -0.002249 304.4700n -0.002005 304.4800n -0.001735 304.4900n -0.001442
+ 304.5000n -0.001133 304.5100n -0.000814 304.5200n -0.000490 304.5300n -0.000167 304.5400n 0.000148 304.5500n 0.000450 304.5600n 0.000733 304.5700n 0.000992 304.5800n 0.001224 304.5900n 0.001422 304.6000n 0.001586 304.6100n 0.001710 304.6200n 0.001795 304.6300n 0.001838 304.6400n 0.001840
+ 304.6500n 0.001800 304.6600n 0.001720 304.6700n 0.001602 304.6800n 0.001448 304.6900n 0.001262 304.7000n 0.001048 304.7100n 0.000808 304.7200n 0.000549 304.7300n 0.000275 304.7400n -0.000009 304.7500n -0.000299 304.7600n -0.000588 304.7700n -0.000873 304.7800n -0.001149 304.7900n -0.001412
+ 304.8000n -0.001657 304.8100n -0.001881 304.8200n -0.002082 304.8300n -0.002257 304.8400n -0.002404 304.8500n -0.002523 304.8600n -0.002613 304.8700n -0.002673 304.8800n -0.002706 304.8900n -0.002712 304.9000n -0.002692 304.9100n -0.002651 304.9200n -0.002589 304.9300n -0.002510 304.9400n -0.002417
+ 304.9500n -0.002315 304.9600n -0.002205 304.9700n -0.002093 304.9800n -0.001981 304.9900n -0.001873 305.0000n -0.001772 305.0100n -0.001680 305.0200n -0.001601 305.0300n -0.001536 305.0400n -0.001488 305.0500n -0.001458 305.0600n -0.001446 305.0700n -0.001453 305.0800n -0.001479 305.0900n -0.001523
+ 305.1000n -0.001585 305.1100n -0.001664 305.1200n -0.001756 305.1300n -0.001862 305.1400n -0.001978 305.1500n -0.002102 305.1600n -0.002232 305.1700n -0.002364 305.1800n -0.002497 305.1900n -0.002627 305.2000n -0.002751 305.2100n -0.002869 305.2200n -0.002976 305.2300n -0.003071 305.2400n -0.003152
+ 305.2500n -0.003218 305.2600n -0.003267 305.2700n -0.003298 305.2800n -0.003311 305.2900n -0.003305 305.3000n -0.003280 305.3100n -0.003237 305.3200n -0.003175 305.3300n -0.003096 305.3400n -0.003000 305.3500n -0.002889 305.3600n -0.002764 305.3700n -0.002626 305.3800n -0.002478 305.3900n -0.002320
+ 305.4000n -0.002154 305.4100n -0.001982 305.4200n -0.001805 305.4300n -0.001625 305.4400n -0.001443 305.4500n -0.001262 305.4600n -0.001081 305.4700n -0.000902 305.4800n -0.000727 305.4900n -0.000556 305.5000n -0.000390 305.5100n -0.000230 305.5200n -0.000076 305.5300n 0.000070 305.5400n 0.000210
+ 305.5500n 0.000342 305.5600n 0.000466 305.5700n 0.000582 305.5800n 0.000689 305.5900n 0.000787 305.6000n 0.000877 305.6100n 0.000958 305.6200n 0.001030 305.6300n 0.001093 305.6400n 0.001147 305.6500n 0.001191 305.6600n 0.001226 305.6700n 0.001252 305.6800n 0.001268 305.6900n 0.001274
+ 305.7000n 0.001271 305.7100n 0.001259 305.7200n 0.001237 305.7300n 0.001207 305.7400n 0.001168 305.7500n 0.001120 305.7600n 0.001064 305.7700n 0.001001 305.7800n 0.000932 305.7900n 0.000856 305.8000n 0.000775 305.8100n 0.000689 305.8200n 0.000599 305.8300n 0.000507 305.8400n 0.000413
+ 305.8500n 0.000318 305.8600n 0.000222 305.8700n 0.000128 305.8800n 0.000035 305.8900n -0.000056 305.9000n -0.000143 305.9100n -0.000227 305.9200n -0.000308 305.9300n -0.000383 305.9400n -0.000455 305.9500n -0.000521 305.9600n -0.000584 305.9700n -0.000642 305.9800n -0.000695 305.9900n -0.000746
+ 306.0000n -0.000793 306.0100n -0.000838 306.0200n -0.000881 306.0300n -0.000923 306.0400n -0.000964 306.0500n -0.001005 306.0600n -0.001047 306.0700n -0.001091 306.0800n -0.001135 306.0900n -0.001182 306.1000n -0.001230 306.1100n -0.001280 306.1200n -0.001332 306.1300n -0.001385 306.1400n -0.001438
+ 306.1500n -0.001490 306.1600n -0.001541 306.1700n -0.001590 306.1800n -0.001634 306.1900n -0.001673 306.2000n -0.001705 306.2100n -0.001727 306.2200n -0.001739 306.2300n -0.001739 306.2400n -0.001725 306.2500n -0.001696 306.2600n -0.001650 306.2700n -0.001586 306.2800n -0.001504 306.2900n -0.001402
+ 306.3000n -0.001280 306.3100n -0.001138 306.3200n -0.000977 306.3300n -0.000797 306.3400n -0.000599 306.3500n -0.000385 306.3600n -0.000158 306.3700n 0.000082 306.3800n 0.000331 306.3900n 0.000586 306.4000n 0.000845 306.4100n 0.001103 306.4200n 0.001358 306.4300n 0.001605 306.4400n 0.001842
+ 306.4500n 0.002063 306.4600n 0.002266 306.4700n 0.002448 306.4800n 0.002604 306.4900n 0.002733 306.5000n 0.002832 306.5100n 0.002898 306.5200n 0.002931 306.5300n 0.002928 306.5400n 0.002890 306.5500n 0.002816 306.5600n 0.002707 306.5700n 0.002564 306.5800n 0.002388 306.5900n 0.002183
+ 306.6000n 0.001950 306.6100n 0.001693 306.6200n 0.001415 306.6300n 0.001120 306.6400n 0.000813 306.6500n 0.000498 306.6600n 0.000179 306.6700n -0.000140 306.6800n -0.000452 306.6900n -0.000755 306.7000n -0.001043 306.7100n -0.001314 306.7200n -0.001563 306.7300n -0.001786 306.7400n -0.001982
+ 306.7500n -0.002148 306.7600n -0.002283 306.7700n -0.002384 306.7800n -0.002453 306.7900n -0.002488 306.8000n -0.002490 306.8100n -0.002461 306.8200n -0.002402 306.8300n -0.002315 306.8400n -0.002204 306.8500n -0.002071 306.8600n -0.001919 306.8700n -0.001752 306.8800n -0.001573 306.8900n -0.001388
+ 306.9000n -0.001199 306.9100n -0.001010 306.9200n -0.000825 306.9300n -0.000647 306.9400n -0.000480 306.9500n -0.000327 306.9600n -0.000189 306.9700n -0.000070 306.9800n 0.000030 306.9900n 0.000109 307.0000n 0.000166 307.0100n 0.000202 307.0200n 0.000216 307.0300n 0.000208 307.0400n 0.000181
+ 307.0500n 0.000136 307.0600n 0.000074 307.0700n -0.000003 307.0800n -0.000092 307.0900n -0.000191 307.1000n -0.000297 307.1100n -0.000408 307.1200n -0.000520 307.1300n -0.000632 307.1400n -0.000741 307.1500n -0.000845 307.1600n -0.000941 307.1700n -0.001028 307.1800n -0.001104 307.1900n -0.001168
+ 307.2000n -0.001219 307.2100n -0.001257 307.2200n -0.001280 307.2300n -0.001290 307.2400n -0.001287 307.2500n -0.001270 307.2600n -0.001241 307.2700n -0.001201 307.2800n -0.001151 307.2900n -0.001092 307.3000n -0.001026 307.3100n -0.000953 307.3200n -0.000876 307.3300n -0.000795 307.3400n -0.000712
+ 307.3500n -0.000628 307.3600n -0.000544 307.3700n -0.000460 307.3800n -0.000378 307.3900n -0.000298 307.4000n -0.000219 307.4100n -0.000143 307.4200n -0.000069 307.4300n 0.000003 307.4400n 0.000074 307.4500n 0.000144 307.4600n 0.000214 307.4700n 0.000284 307.4800n 0.000355 307.4900n 0.000427
+ 307.5000n 0.000502 307.5100n 0.000580 307.5200n 0.000660 307.5300n 0.000744 307.5400n 0.000831 307.5500n 0.000922 307.5600n 0.001015 307.5700n 0.001111 307.5800n 0.001209 307.5900n 0.001307 307.6000n 0.001405 307.6100n 0.001502 307.6200n 0.001596 307.6300n 0.001685 307.6400n 0.001769
+ 307.6500n 0.001845 307.6600n 0.001912 307.6700n 0.001968 307.6800n 0.002012 307.6900n 0.002044 307.7000n 0.002060 307.7100n 0.002062 307.7200n 0.002047 307.7300n 0.002016 307.7400n 0.001969 307.7500n 0.001906 307.7600n 0.001826 307.7700n 0.001732 307.7800n 0.001625 307.7900n 0.001505
+ 307.8000n 0.001374 307.8100n 0.001235 307.8200n 0.001089 307.8300n 0.000939 307.8400n 0.000788 307.8500n 0.000637 307.8600n 0.000489 307.8700n 0.000347 307.8800n 0.000214 307.8900n 0.000090 307.9000n -0.000021 307.9100n -0.000118 307.9200n -0.000200 307.9300n -0.000264 307.9400n -0.000312
+ 307.9500n -0.000341 307.9600n -0.000352 307.9700n -0.000346 307.9800n -0.000323 307.9900n -0.000284 308.0000n -0.000231 308.0100n -0.000165 308.0200n -0.000089 308.0300n -0.000005 308.0400n 0.000085 308.0500n 0.000178 308.0600n 0.000272 308.0700n 0.000363 308.0800n 0.000449 308.0900n 0.000527
+ 308.1000n 0.000596 308.1100n 0.000652 308.1200n 0.000694 308.1300n 0.000720 308.1400n 0.000729 308.1500n 0.000721 308.1600n 0.000694 308.1700n 0.000648 308.1800n 0.000584 308.1900n 0.000503 308.2000n 0.000406 308.2100n 0.000294 308.2200n 0.000168 308.2300n 0.000032 308.2400n -0.000113
+ 308.2500n -0.000264 308.2600n -0.000418 308.2700n -0.000573 308.2800n -0.000726 308.2900n -0.000874 308.3000n -0.001016 308.3100n -0.001147 308.3200n -0.001266 308.3300n -0.001372 308.3400n -0.001462 308.3500n -0.001536 308.3600n -0.001592 308.3700n -0.001629 308.3800n -0.001649 308.3900n -0.001650
+ 308.4000n -0.001634 308.4100n -0.001601 308.4200n -0.001553 308.4300n -0.001492 308.4400n -0.001419 308.4500n -0.001336 308.4600n -0.001246 308.4700n -0.001151 308.4800n -0.001053 308.4900n -0.000954 308.5000n -0.000858 308.5100n -0.000766 308.5200n -0.000680 308.5300n -0.000602 308.5400n -0.000534
+ 308.5500n -0.000476 308.5600n -0.000430 308.5700n -0.000396 308.5800n -0.000375 308.5900n -0.000366 308.6000n -0.000369 308.6100n -0.000384 308.6200n -0.000408 308.6300n -0.000442 308.6400n -0.000483 308.6500n -0.000530 308.6600n -0.000580 308.6700n -0.000632 308.6800n -0.000684 308.6900n -0.000734
+ 308.7000n -0.000779 308.7100n -0.000819 308.7200n -0.000851 308.7300n -0.000874 308.7400n -0.000886 308.7500n -0.000887 308.7600n -0.000875 308.7700n -0.000852 308.7800n -0.000815 308.7900n -0.000766 308.8000n -0.000705 308.8100n -0.000633 308.8200n -0.000550 308.8300n -0.000459 308.8400n -0.000360
+ 308.8500n -0.000255 308.8600n -0.000146 308.8700n -0.000035 308.8800n 0.000077 308.8900n 0.000188 308.9000n 0.000296 308.9100n 0.000400 308.9200n 0.000497 308.9300n 0.000588 308.9400n 0.000671 308.9500n 0.000744 308.9600n 0.000809 308.9700n 0.000864 308.9800n 0.000910 308.9900n 0.000946
+ 309.0000n 0.000974 309.0100n 0.000994 309.0200n 0.001008 309.0300n 0.001016 309.0400n 0.001020 309.0500n 0.001021 309.0600n 0.001021 309.0700n 0.001022 309.0800n 0.001024 309.0900n 0.001030 309.1000n 0.001041 309.1100n 0.001057 309.1200n 0.001081 309.1300n 0.001111 309.1400n 0.001149
+ 309.1500n 0.001196 309.1600n 0.001250 309.1700n 0.001312 309.1800n 0.001380 309.1900n 0.001455 309.2000n 0.001533 309.2100n 0.001615 309.2200n 0.001699 309.2300n 0.001782 309.2400n 0.001863 309.2500n 0.001939 309.2600n 0.002010 309.2700n 0.002072 309.2800n 0.002124 309.2900n 0.002164
+ 309.3000n 0.002191 309.3100n 0.002204 309.3200n 0.002201 309.3300n 0.002181 309.3400n 0.002145 309.3500n 0.002092 309.3600n 0.002022 309.3700n 0.001937 309.3800n 0.001838 309.3900n 0.001725 309.4000n 0.001601 309.4100n 0.001467 309.4200n 0.001326 309.4300n 0.001181 309.4400n 0.001034
+ 309.4500n 0.000888 309.4600n 0.000746 309.4700n 0.000611 309.4800n 0.000484 309.4900n 0.000370 309.5000n 0.000271 309.5100n 0.000188 309.5200n 0.000124 309.5300n 0.000079 309.5400n 0.000056 309.5500n 0.000055 309.5600n 0.000077 309.5700n 0.000120 309.5800n 0.000186 309.5900n 0.000271
+ 309.6000n 0.000377 309.6100n 0.000499 309.6200n 0.000636 309.6300n 0.000787 309.6400n 0.000946 309.6500n 0.001113 309.6600n 0.001283 309.6700n 0.001453 309.6800n 0.001620 309.6900n 0.001780 309.7000n 0.001930 309.7100n 0.002067 309.7200n 0.002188 309.7300n 0.002290 309.7400n 0.002371
+ 309.7500n 0.002429 309.7600n 0.002462 309.7700n 0.002468 309.7800n 0.002448 309.7900n 0.002400 309.8000n 0.002325 309.8100n 0.002223 309.8200n 0.002095 309.8300n 0.001942 309.8400n 0.001766 309.8500n 0.001568 309.8600n 0.001352 309.8700n 0.001120 309.8800n 0.000874 309.8900n 0.000616
+ 309.9000n 0.000351 309.9100n 0.000081 309.9200n -0.000192 309.9300n -0.000464 309.9400n -0.000733 309.9500n -0.000996 309.9600n -0.001251 309.9700n -0.001496 309.9800n -0.001728 309.9900n -0.001947 310.0000n -0.002151 310.0100n -0.002339 310.0200n -0.002510 310.0300n -0.002664 310.0400n -0.002800
+ 310.0500n -0.002919 310.0600n -0.003021 310.0700n -0.003106 310.0800n -0.003175 310.0900n -0.003229 310.1000n -0.003268 310.1100n -0.003294 310.1200n -0.003307 310.1300n -0.003309 310.1400n -0.003300 310.1500n -0.003281 310.1600n -0.003253 310.1700n -0.003217 310.1800n -0.003173 310.1900n -0.003122
+ 310.2000n -0.003065 310.2100n -0.003002 310.2200n -0.002932 310.2300n -0.002857 310.2400n -0.002776 310.2500n -0.002690 310.2600n -0.002598 310.2700n -0.002500 310.2800n -0.002396 310.2900n -0.002287 310.3000n -0.002172 310.3100n -0.002052 310.3200n -0.001926 310.3300n -0.001795 310.3400n -0.001659
+ 310.3500n -0.001519 310.3600n -0.001375 310.3700n -0.001229 310.3800n -0.001081 310.3900n -0.000932 310.4000n -0.000783 310.4100n -0.000636 310.4200n -0.000491 310.4300n -0.000350 310.4400n -0.000214 310.4500n -0.000085 310.4600n 0.000037 310.4700n 0.000149 310.4800n 0.000251 310.4900n 0.000342
+ 310.5000n 0.000420 310.5100n 0.000486 310.5200n 0.000539 310.5300n 0.000577 310.5400n 0.000602 310.5500n 0.000613 310.5600n 0.000611 310.5700n 0.000595 310.5800n 0.000567 310.5900n 0.000527 310.6000n 0.000477 310.6100n 0.000418 310.6200n 0.000351 310.6300n 0.000277 310.6400n 0.000198
+ 310.6500n 0.000116 310.6600n 0.000033 310.6700n -0.000051 310.6800n -0.000134 310.6900n -0.000214 310.7000n -0.000289 310.7100n -0.000360 310.7200n -0.000424 310.7300n -0.000480 310.7400n -0.000529 310.7500n -0.000569 310.7600n -0.000600 310.7700n -0.000622 310.7800n -0.000635 310.7900n -0.000640
+ 310.8000n -0.000636 310.8100n -0.000625 310.8200n -0.000607 310.8300n -0.000582 310.8400n -0.000553 310.8500n -0.000519 310.8600n -0.000482 310.8700n -0.000443 310.8800n -0.000402 310.8900n -0.000362 310.9000n -0.000322 310.9100n -0.000283 310.9200n -0.000246 310.9300n -0.000213 310.9400n -0.000182
+ 310.9500n -0.000154 310.9600n -0.000130 310.9700n -0.000110 310.9800n -0.000093 310.9900n -0.000079 311.0000n -0.000067 311.0100n -0.000058 311.0200n -0.000051 311.0300n -0.000045 311.0400n -0.000040 311.0500n -0.000034 311.0600n -0.000028 311.0700n -0.000021 311.0800n -0.000012 311.0900n -0.000001
+ 311.1000n 0.000013 311.1100n 0.000029 311.1200n 0.000049 311.1300n 0.000071 311.1400n 0.000096 311.1500n 0.000123 311.1600n 0.000153 311.1700n 0.000184 311.1800n 0.000216 311.1900n 0.000248 311.2000n 0.000280 311.2100n 0.000311 311.2200n 0.000339 311.2300n 0.000365 311.2400n 0.000387
+ 311.2500n 0.000405 311.2600n 0.000418 311.2700n 0.000425 311.2800n 0.000426 311.2900n 0.000420 311.3000n 0.000408 311.3100n 0.000388 311.3200n 0.000363 311.3300n 0.000331 311.3400n 0.000293 311.3500n 0.000249 311.3600n 0.000201 311.3700n 0.000149 311.3800n 0.000094 311.3900n 0.000037
+ 311.4000n -0.000022 311.4100n -0.000080 311.4200n -0.000137 311.4300n -0.000191 311.4400n -0.000243 311.4500n -0.000290 311.4600n -0.000333 311.4700n -0.000370 311.4800n -0.000400 311.4900n -0.000425 311.5000n -0.000442 311.5100n -0.000453 311.5200n -0.000457 311.5300n -0.000455 311.5400n -0.000447
+ 311.5500n -0.000434 311.5600n -0.000417 311.5700n -0.000396 311.5800n -0.000373 311.5900n -0.000349 311.6000n -0.000324 311.6100n -0.000301 311.6200n -0.000279 311.6300n -0.000261 311.6400n -0.000247 311.6500n -0.000237 311.6600n -0.000234 311.6700n -0.000236 311.6800n -0.000245 311.6900n -0.000261
+ 311.7000n -0.000283 311.7100n -0.000311 311.7200n -0.000345 311.7300n -0.000384 311.7400n -0.000427 311.7500n -0.000473 311.7600n -0.000521 311.7700n -0.000568 311.7800n -0.000615 311.7900n -0.000658 311.8000n -0.000696 311.8100n -0.000728 311.8200n -0.000753 311.8300n -0.000767 311.8400n -0.000771
+ 311.8500n -0.000763 311.8600n -0.000742 311.8700n -0.000707 311.8800n -0.000657 311.8900n -0.000592 311.9000n -0.000513 311.9100n -0.000419 311.9200n -0.000311 311.9300n -0.000190 311.9400n -0.000057 311.9500n 0.000087 311.9600n 0.000239 311.9700n 0.000398 311.9800n 0.000563 311.9900n 0.000729
+ 312.0000n 0.000896 312.0100n 0.001061 312.0200n 0.001222 312.0300n 0.001375 312.0400n 0.001519 312.0500n 0.001652 312.0600n 0.001772 312.0700n 0.001877 312.0800n 0.001964 312.0900n 0.002034 312.1000n 0.002085 312.1100n 0.002116 312.1200n 0.002127 312.1300n 0.002118 312.1400n 0.002090
+ 312.1500n 0.002042 312.1600n 0.001976 312.1700n 0.001893 312.1800n 0.001795 312.1900n 0.001683 312.2000n 0.001559 312.2100n 0.001425 312.2200n 0.001284 312.2300n 0.001137 312.2400n 0.000987 312.2500n 0.000836 312.2600n 0.000687 312.2700n 0.000540 312.2800n 0.000399 312.2900n 0.000266
+ 312.3000n 0.000140 312.3100n 0.000025 312.3200n -0.000079 312.3300n -0.000171 312.3400n -0.000251 312.3500n -0.000317 312.3600n -0.000371 312.3700n -0.000412 312.3800n -0.000441 312.3900n -0.000458 312.4000n -0.000465 312.4100n -0.000461 312.4200n -0.000448 312.4300n -0.000428 312.4400n -0.000402
+ 312.4500n -0.000370 312.4600n -0.000334 312.4700n -0.000296 312.4800n -0.000257 312.4900n -0.000217 312.5000n -0.000178 312.5100n -0.000140 312.5200n -0.000105 312.5300n -0.000072 312.5400n -0.000043 312.5500n -0.000017 312.5600n 0.000005 312.5700n 0.000024 312.5800n 0.000039 312.5900n 0.000051
+ 312.6000n 0.000060 312.6100n 0.000067 312.6200n 0.000073 312.6300n 0.000077 312.6400n 0.000080 312.6500n 0.000083 312.6600n 0.000086 312.6700n 0.000091 312.6800n 0.000096 312.6900n 0.000102 312.7000n 0.000110 312.7100n 0.000120 312.7200n 0.000131 312.7300n 0.000144 312.7400n 0.000158
+ 312.7500n 0.000172 312.7600n 0.000187 312.7700n 0.000202 312.7800n 0.000216 312.7900n 0.000229 312.8000n 0.000240 312.8100n 0.000249 312.8200n 0.000254 312.8300n 0.000256 312.8400n 0.000254 312.8500n 0.000247 312.8600n 0.000235 312.8700n 0.000219 312.8800n 0.000197 312.8900n 0.000171
+ 312.9000n 0.000140 312.9100n 0.000104 312.9200n 0.000065 312.9300n 0.000022 312.9400n -0.000024 312.9500n -0.000072 312.9600n -0.000120 312.9700n -0.000169 312.9800n -0.000217 312.9900n -0.000264 313.0000n -0.000308 313.0100n -0.000349 313.0200n -0.000386 313.0300n -0.000417 313.0400n -0.000444
+ 313.0500n -0.000464 313.0600n -0.000478 313.0700n -0.000486 313.0800n -0.000487 313.0900n -0.000481 313.1000n -0.000470 313.1100n -0.000452 313.1200n -0.000429 313.1300n -0.000401 313.1400n -0.000369 313.1500n -0.000334 313.1600n -0.000297 313.1700n -0.000257 313.1800n -0.000217 313.1900n -0.000177
+ 313.2000n -0.000138 313.2100n -0.000100 313.2200n -0.000064 313.2300n -0.000030 313.2400n 0.000000 313.2500n 0.000028 313.2600n 0.000053 313.2700n 0.000075 313.2800n 0.000094 313.2900n 0.000111 313.3000n 0.000127 313.3100n 0.000143 313.3200n 0.000158 313.3300n 0.000175 313.3400n 0.000193
+ 313.3500n 0.000215 313.3600n 0.000241 313.3700n 0.000272 313.3800n 0.000309 313.3900n 0.000353 313.4000n 0.000404 313.4100n 0.000463 313.4200n 0.000530 313.4300n 0.000605 313.4400n 0.000689 313.4500n 0.000780 313.4600n 0.000877 313.4700n 0.000981 313.4800n 0.001089 313.4900n 0.001201
+ 313.5000n 0.001314 313.5100n 0.001427 313.5200n 0.001538 313.5300n 0.001645 313.5400n 0.001745 313.5500n 0.001836 313.5600n 0.001917 313.5700n 0.001984 313.5800n 0.002037 313.5900n 0.002072 313.6000n 0.002088 313.6100n 0.002085 313.6200n 0.002060 313.6300n 0.002013 313.6400n 0.001943
+ 313.6500n 0.001851 313.6600n 0.001735 313.6700n 0.001598 313.6800n 0.001440 313.6900n 0.001263 313.7000n 0.001068 313.7100n 0.000857 313.7200n 0.000633 313.7300n 0.000398 313.7400n 0.000156 313.7500n -0.000091 313.7600n -0.000339 313.7700n -0.000586 313.7800n -0.000827 313.7900n -0.001061
+ 313.8000n -0.001282 313.8100n -0.001490 313.8200n -0.001681 313.8300n -0.001853 313.8400n -0.002003 313.8500n -0.002131 313.8600n -0.002234 313.8700n -0.002312 313.8800n -0.002364 313.8900n -0.002390 313.9000n -0.002391 313.9100n -0.002367 313.9200n -0.002319 313.9300n -0.002249 313.9400n -0.002158
+ 313.9500n -0.002049 313.9600n -0.001924 313.9700n -0.001785 313.9800n -0.001636 313.9900n -0.001478 314.0000n -0.001315 314.0100n -0.001149 314.0200n -0.000983 314.0300n -0.000819 314.0400n -0.000661 314.0500n -0.000509 314.0600n -0.000366 314.0700n -0.000233 314.0800n -0.000112 314.0900n -0.000004
+ 314.1000n 0.000090 314.1100n 0.000171 314.1200n 0.000237 314.1300n 0.000289 314.1400n 0.000328 314.1500n 0.000353 314.1600n 0.000367 314.1700n 0.000368 314.1800n 0.000360 314.1900n 0.000342 314.2000n 0.000317 314.2100n 0.000285 314.2200n 0.000247 314.2300n 0.000205 314.2400n 0.000159
+ 314.2500n 0.000110 314.2600n 0.000060 314.2700n 0.000009 314.2800n -0.000044 314.2900n -0.000096 314.3000n -0.000149 314.3100n -0.000203 314.3200n -0.000257 314.3300n -0.000311 314.3400n -0.000367 314.3500n -0.000424 314.3600n -0.000483 314.3700n -0.000543 314.3800n -0.000607 314.3900n -0.000672
+ 314.4000n -0.000741 314.4100n -0.000812 314.4200n -0.000886 314.4300n -0.000962 314.4400n -0.001039 314.4500n -0.001117 314.4600n -0.001196 314.4700n -0.001272 314.4800n -0.001347 314.4900n -0.001417 314.5000n -0.001482 314.5100n -0.001539 314.5200n -0.001587 314.5300n -0.001624 314.5400n -0.001649
+ 314.5500n -0.001659 314.5600n -0.001653 314.5700n -0.001630 314.5800n -0.001589 314.5900n -0.001528 314.6000n -0.001447 314.6100n -0.001347 314.6200n -0.001226 314.6300n -0.001086 314.6400n -0.000928 314.6500n -0.000752 314.6600n -0.000561 314.6700n -0.000356 314.6800n -0.000141 314.6900n 0.000082
+ 314.7000n 0.000311 314.7100n 0.000541 314.7200n 0.000770 314.7300n 0.000993 314.7400n 0.001208 314.7500n 0.001410 314.7600n 0.001596 314.7700n 0.001764 314.7800n 0.001909 314.7900n 0.002029 314.8000n 0.002122 314.8100n 0.002185 314.8200n 0.002219 314.8300n 0.002221 314.8400n 0.002191
+ 314.8500n 0.002130 314.8600n 0.002039 314.8700n 0.001918 314.8800n 0.001770 314.8900n 0.001597 314.9000n 0.001402 314.9100n 0.001189 314.9200n 0.000962 314.9300n 0.000723 314.9400n 0.000479 314.9500n 0.000232 314.9600n -0.000012 314.9700n -0.000250 314.9800n -0.000476 314.9900n -0.000687
+ 315.0000n -0.000879 315.0100n -0.001049 315.0200n -0.001194 315.0300n -0.001310 315.0400n -0.001398 315.0500n -0.001454 315.0600n -0.001479 315.0700n -0.001472 315.0800n -0.001435 315.0900n -0.001367 315.1000n -0.001271 315.1100n -0.001149 315.1200n -0.001004 315.1300n -0.000840 315.1400n -0.000658
+ 315.1500n -0.000465 315.1600n -0.000263 315.1700n -0.000056 315.1800n 0.000151 315.1900n 0.000354 315.2000n 0.000550 315.2100n 0.000734 315.2200n 0.000904 315.2300n 0.001057 315.2400n 0.001190 315.2500n 0.001301 315.2600n 0.001389 315.2700n 0.001454 315.2800n 0.001494 315.2900n 0.001511
+ 315.3000n 0.001505 315.3100n 0.001478 315.3200n 0.001432 315.3300n 0.001368 315.3400n 0.001290 315.3500n 0.001201 315.3600n 0.001105 315.3700n 0.001003 315.3800n 0.000901 315.3900n 0.000801 315.4000n 0.000706 315.4100n 0.000620 315.4200n 0.000546 315.4300n 0.000486 315.4400n 0.000441
+ 315.4500n 0.000414 315.4600n 0.000406 315.4700n 0.000416 315.4800n 0.000446 315.4900n 0.000494 315.5000n 0.000559 315.5100n 0.000639 315.5200n 0.000733 315.5300n 0.000838 315.5400n 0.000950 315.5500n 0.001068 315.5600n 0.001186 315.5700n 0.001302 315.5800n 0.001413 315.5900n 0.001513
+ 315.6000n 0.001601 315.6100n 0.001673 315.6200n 0.001725 315.6300n 0.001756 315.6400n 0.001763 315.6500n 0.001745 315.6600n 0.001700 315.6700n 0.001628 315.6800n 0.001530 315.6900n 0.001405 315.7000n 0.001255 315.7100n 0.001083 315.7200n 0.000890 315.7300n 0.000679 315.7400n 0.000453
+ 315.7500n 0.000217 315.7600n -0.000026 315.7700n -0.000271 315.7800n -0.000515 315.7900n -0.000754 315.8000n -0.000982 315.8100n -0.001196 315.8200n -0.001392 315.8300n -0.001568 315.8400n -0.001718 315.8500n -0.001842 315.8600n -0.001937 315.8700n -0.002002 315.8800n -0.002035 315.8900n -0.002037
+ 315.9000n -0.002007 315.9100n -0.001948 315.9200n -0.001860 315.9300n -0.001746 315.9400n -0.001608 315.9500n -0.001449 315.9600n -0.001273 315.9700n -0.001084 315.9800n -0.000884 315.9900n -0.000680 316.0000n -0.000474 316.0100n -0.000271 316.0200n -0.000074 316.0300n 0.000111 316.0400n 0.000284
+ 316.0500n 0.000439 316.0600n 0.000574 316.0700n 0.000688 316.0800n 0.000779 316.0900n 0.000845 316.1000n 0.000885 316.1100n 0.000901 316.1200n 0.000892 316.1300n 0.000859 316.1400n 0.000804 316.1500n 0.000730 316.1600n 0.000637 316.1700n 0.000529 316.1800n 0.000409 316.1900n 0.000280
+ 316.2000n 0.000145 316.2100n 0.000007 316.2200n -0.000131 316.2300n -0.000265 316.2400n -0.000392 316.2500n -0.000511 316.2600n -0.000619 316.2700n -0.000714 316.2800n -0.000794 316.2900n -0.000858 316.3000n -0.000906 316.3100n -0.000937 316.3200n -0.000952 316.3300n -0.000951 316.3400n -0.000936
+ 316.3500n -0.000907 316.3600n -0.000866 316.3700n -0.000815 316.3800n -0.000757 316.3900n -0.000694 316.4000n -0.000627 316.4100n -0.000560 316.4200n -0.000494 316.4300n -0.000432 316.4400n -0.000376 316.4500n -0.000327 316.4600n -0.000288 316.4700n -0.000259 316.4800n -0.000241 316.4900n -0.000235
+ 316.5000n -0.000241 316.5100n -0.000259 316.5200n -0.000289 316.5300n -0.000328 316.5400n -0.000377 316.5500n -0.000434 316.5600n -0.000498 316.5700n -0.000565 316.5800n -0.000635 316.5900n -0.000706 316.6000n -0.000775 316.6100n -0.000841 316.6200n -0.000901 316.6300n -0.000953 316.6400n -0.000997
+ 316.6500n -0.001031 316.6600n -0.001053 316.6700n -0.001063 316.6800n -0.001060 316.6900n -0.001045 316.7000n -0.001017 316.7100n -0.000976 316.7200n -0.000923 316.7300n -0.000860 316.7400n -0.000788 316.7500n -0.000707 316.7600n -0.000620 316.7700n -0.000527 316.7800n -0.000432 316.7900n -0.000335
+ 316.8000n -0.000238 316.8100n -0.000143 316.8200n -0.000051 316.8300n 0.000036 316.8400n 0.000118 316.8500n 0.000193 316.8600n 0.000262 316.8700n 0.000323 316.8800n 0.000378 316.8900n 0.000425 316.9000n 0.000466 316.9100n 0.000502 316.9200n 0.000533 316.9300n 0.000560 316.9400n 0.000586
+ 316.9500n 0.000612 316.9600n 0.000639 316.9700n 0.000668 316.9800n 0.000701 316.9900n 0.000740 317.0000n 0.000785 317.0100n 0.000838 317.0200n 0.000899 317.0300n 0.000969 317.0400n 0.001048 317.0500n 0.001136 317.0600n 0.001233 317.0700n 0.001336 317.0800n 0.001447 317.0900n 0.001562
+ 317.1000n 0.001680 317.1100n 0.001799 317.1200n 0.001918 317.1300n 0.002032 317.1400n 0.002141 317.1500n 0.002242 317.1600n 0.002332 317.1700n 0.002408 317.1800n 0.002470 317.1900n 0.002514 317.2000n 0.002539 317.2100n 0.002544 317.2200n 0.002528 317.2300n 0.002490 317.2400n 0.002430
+ 317.2500n 0.002349 317.2600n 0.002248 317.2700n 0.002128 317.2800n 0.001992 317.2900n 0.001840 317.3000n 0.001677 317.3100n 0.001505 317.3200n 0.001327 317.3300n 0.001148 317.3400n 0.000971 317.3500n 0.000799 317.3600n 0.000637 317.3700n 0.000489 317.3800n 0.000357 317.3900n 0.000245
+ 317.4000n 0.000156 317.4100n 0.000092 317.4200n 0.000056 317.4300n 0.000048 317.4400n 0.000069 317.4500n 0.000120 317.4600n 0.000200 317.4700n 0.000308 317.4800n 0.000441 317.4900n 0.000598 317.5000n 0.000776 317.5100n 0.000971 317.5200n 0.001180 317.5300n 0.001396 317.5400n 0.001617
+ 317.5500n 0.001838 317.5600n 0.002052 317.5700n 0.002257 317.5800n 0.002445 317.5900n 0.002614 317.6000n 0.002758 317.6100n 0.002874 317.6200n 0.002959 317.6300n 0.003009 317.6400n 0.003023 317.6500n 0.002999 317.6600n 0.002937 317.6700n 0.002836 317.6800n 0.002698 317.6900n 0.002524
+ 317.7000n 0.002317 317.7100n 0.002080 317.7200n 0.001816 317.7300n 0.001530 317.7400n 0.001227 317.7500n 0.000912 317.7600n 0.000591 317.7700n 0.000268 317.7800n -0.000049 317.7900n -0.000355 317.8000n -0.000645 317.8100n -0.000913 317.8200n -0.001155 317.8300n -0.001366 317.8400n -0.001542
+ 317.8500n -0.001680 317.8600n -0.001777 317.8700n -0.001833 317.8800n -0.001846 317.8900n -0.001816 317.9000n -0.001744 317.9100n -0.001632 317.9200n -0.001482 317.9300n -0.001297 317.9400n -0.001081 317.9500n -0.000839 317.9600n -0.000575 317.9700n -0.000294 317.9800n -0.000003 317.9900n 0.000293
+ 318.0000n 0.000589 318.0100n 0.000878 318.0200n 0.001155 318.0300n 0.001415 318.0400n 0.001654 318.0500n 0.001866 318.0600n 0.002048 318.0700n 0.002198 318.0800n 0.002312 318.0900n 0.002388 318.1000n 0.002427 318.1100n 0.002428 318.1200n 0.002392 318.1300n 0.002320 318.1400n 0.002214
+ 318.1500n 0.002076 318.1600n 0.001911 318.1700n 0.001723 318.1800n 0.001514 318.1900n 0.001290 318.2000n 0.001056 318.2100n 0.000816 318.2200n 0.000575 318.2300n 0.000338 318.2400n 0.000110 318.2500n -0.000107 318.2600n -0.000307 318.2700n -0.000487 318.2800n -0.000645 318.2900n -0.000779
+ 318.3000n -0.000888 318.3100n -0.000969 318.3200n -0.001024 318.3300n -0.001052 318.3400n -0.001055 318.3500n -0.001035 318.3600n -0.000993 318.3700n -0.000932 318.3800n -0.000857 318.3900n -0.000769 318.4000n -0.000673 318.4100n -0.000572 318.4200n -0.000472 318.4300n -0.000375 318.4400n -0.000285
+ 318.4500n -0.000206 318.4600n -0.000142 318.4700n -0.000094 318.4800n -0.000067 318.4900n -0.000061 318.5000n -0.000077 318.5100n -0.000118 318.5200n -0.000183 318.5300n -0.000273 318.5400n -0.000385 318.5500n -0.000518 318.5600n -0.000672 318.5700n -0.000842 318.5800n -0.001027 318.5900n -0.001223
+ 318.6000n -0.001427 318.6100n -0.001634 318.6200n -0.001842 318.6300n -0.002045 318.6400n -0.002241 318.6500n -0.002426 318.6600n -0.002595 318.6700n -0.002746 318.6800n -0.002876 318.6900n -0.002983 318.7000n -0.003064 318.7100n -0.003117 318.7200n -0.003143 318.7300n -0.003139 318.7400n -0.003107
+ 318.7500n -0.003047 318.7600n -0.002960 318.7700n -0.002847 318.7800n -0.002711 318.7900n -0.002554 318.8000n -0.002379 318.8100n -0.002188 318.8200n -0.001986 318.8300n -0.001776 318.8400n -0.001560 318.8500n -0.001344 318.8600n -0.001129 318.8700n -0.000920 318.8800n -0.000720 318.8900n -0.000532
+ 318.9000n -0.000358 318.9100n -0.000201 318.9200n -0.000063 318.9300n 0.000056 318.9400n 0.000153 318.9500n 0.000228 318.9600n 0.000280 318.9700n 0.000311 318.9800n 0.000320 318.9900n 0.000308 319.0000n 0.000277 319.0100n 0.000228 319.0200n 0.000162 319.0300n 0.000083 319.0400n -0.000007
+ 319.0500n -0.000108 319.0600n -0.000215 319.0700n -0.000326 319.0800n -0.000440 319.0900n -0.000553 319.1000n -0.000664 319.1100n -0.000770 319.1200n -0.000870 319.1300n -0.000961 319.1400n -0.001042 319.1500n -0.001113 319.1600n -0.001171 319.1700n -0.001216 319.1800n -0.001248 319.1900n -0.001267
+ 319.2000n -0.001271 319.2100n -0.001262 319.2200n -0.001239 319.2300n -0.001204 319.2400n -0.001156 319.2500n -0.001097 319.2600n -0.001028 319.2700n -0.000949 319.2800n -0.000861 319.2900n -0.000766 319.3000n -0.000664 319.3100n -0.000557 319.3200n -0.000445 319.3300n -0.000329 319.3400n -0.000210
+ 319.3500n -0.000090 319.3600n 0.000032 319.3700n 0.000154 319.3800n 0.000276 319.3900n 0.000398 319.4000n 0.000518 319.4100n 0.000636 319.4200n 0.000751 319.4300n 0.000864 319.4400n 0.000973 319.4500n 0.001079 319.4600n 0.001181 319.4700n 0.001277 319.4800n 0.001369 319.4900n 0.001455
+ 319.5000n 0.001535 319.5100n 0.001609 319.5200n 0.001675 319.5300n 0.001734 319.5400n 0.001786 319.5500n 0.001828 319.5600n 0.001862 319.5700n 0.001888 319.5800n 0.001903 319.5900n 0.001910 319.6000n 0.001906 319.6100n 0.001894 319.6200n 0.001871 319.6300n 0.001840 319.6400n 0.001799
+ 319.6500n 0.001750 319.6600n 0.001694 319.6700n 0.001630 319.6800n 0.001560 319.6900n 0.001484 319.7000n 0.001405 319.7100n 0.001322 319.7200n 0.001237 319.7300n 0.001151 319.7400n 0.001066 319.7500n 0.000983 319.7600n 0.000902 319.7700n 0.000826 319.7800n 0.000754 319.7900n 0.000690
+ 319.8000n 0.000632 319.8100n 0.000582 319.8200n 0.000540 319.8300n 0.000508 319.8400n 0.000484 319.8500n 0.000470 319.8600n 0.000465 319.8700n 0.000469 319.8800n 0.000481 319.8900n 0.000500 319.9000n 0.000527 319.9100n 0.000560 319.9200n 0.000597 319.9300n 0.000639 319.9400n 0.000682
+ 319.9500n 0.000727 319.9600n 0.000772 319.9700n 0.000815 319.9800n 0.000856 319.9900n 0.000893 320.0000n 0.000925 320.0100n 0.000951 320.0200n 0.000970 320.0300n 0.000981 320.0400n 0.000985 320.0500n 0.000980 320.0600n 0.000967 320.0700n 0.000945 320.0800n 0.000915 320.0900n 0.000876
+ 320.1000n 0.000831 320.1100n 0.000778 320.1200n 0.000720 320.1300n 0.000657 320.1400n 0.000591 320.1500n 0.000521 320.1600n 0.000451 320.1700n 0.000380 320.1800n 0.000310 320.1900n 0.000243 320.2000n 0.000179 320.2100n 0.000119 320.2200n 0.000066 320.2300n 0.000018 320.2400n -0.000021
+ 320.2500n -0.000053 320.2600n -0.000077 320.2700n -0.000091 320.2800n -0.000096 320.2900n -0.000092 320.3000n -0.000079 320.3100n -0.000056 320.3200n -0.000024 320.3300n 0.000016 320.3400n 0.000064 320.3500n 0.000120 320.3600n 0.000183 320.3700n 0.000253 320.3800n 0.000329 320.3900n 0.000410
+ 320.4000n 0.000496 320.4100n 0.000586 320.4200n 0.000680 320.4300n 0.000777 320.4400n 0.000876 320.4500n 0.000977 320.4600n 0.001081 320.4700n 0.001185 320.4800n 0.001291 320.4900n 0.001397 320.5000n 0.001503 320.5100n 0.001609 320.5200n 0.001715 320.5300n 0.001820 320.5400n 0.001924
+ 320.5500n 0.002026 320.5600n 0.002126 320.5700n 0.002224 320.5800n 0.002318 320.5900n 0.002409 320.6000n 0.002494 320.6100n 0.002575 320.6200n 0.002649 320.6300n 0.002716 320.6400n 0.002775 320.6500n 0.002826 320.6600n 0.002866 320.6700n 0.002897 320.6800n 0.002916 320.6900n 0.002923
+ 320.7000n 0.002918 320.7100n 0.002900 320.7200n 0.002870 320.7300n 0.002826 320.7400n 0.002769 320.7500n 0.002700 320.7600n 0.002619 320.7700n 0.002528 320.7800n 0.002426 320.7900n 0.002316 320.8000n 0.002198 320.8100n 0.002076 320.8200n 0.001950 320.8300n 0.001823 320.8400n 0.001697
+ 320.8500n 0.001574 320.8600n 0.001457 320.8700n 0.001348 320.8800n 0.001250 320.8900n 0.001165 320.9000n 0.001094 320.9100n 0.001040 320.9200n 0.001005 320.9300n 0.000989 320.9400n 0.000994 320.9500n 0.001021 320.9600n 0.001070 320.9700n 0.001141 320.9800n 0.001233 320.9900n 0.001346
+ 321.0000n 0.001477 321.0100n 0.001626 321.0200n 0.001790 321.0300n 0.001967 321.0400n 0.002152 321.0500n 0.002345 321.0600n 0.002540 321.0700n 0.002734 321.0800n 0.002925 321.0900n 0.003107 321.1000n 0.003277 321.1100n 0.003432 321.1200n 0.003568 321.1300n 0.003682 321.1400n 0.003771
+ 321.1500n 0.003833 321.1600n 0.003865 321.1700n 0.003867 321.1800n 0.003836 321.1900n 0.003773 321.2000n 0.003678 321.2100n 0.003551 321.2200n 0.003394 321.2300n 0.003208 321.2400n 0.002996 321.2500n 0.002760 321.2600n 0.002505 321.2700n 0.002234 321.2800n 0.001950 321.2900n 0.001658
+ 321.3000n 0.001363 321.3100n 0.001069 321.3200n 0.000781 321.3300n 0.000503 321.3400n 0.000240 321.3500n -0.000005 321.3600n -0.000228 321.3700n -0.000425 321.3800n -0.000594 321.3900n -0.000733 321.4000n -0.000839 321.4100n -0.000913 321.4200n -0.000952 321.4300n -0.000958 321.4400n -0.000932
+ 321.4500n -0.000875 321.4600n -0.000789 321.4700n -0.000676 321.4800n -0.000541 321.4900n -0.000387 321.5000n -0.000217 321.5100n -0.000037 321.5200n 0.000150 321.5300n 0.000339 321.5400n 0.000525 321.5500n 0.000704 321.5600n 0.000871 321.5700n 0.001023 321.5800n 0.001155 321.5900n 0.001264
+ 321.6000n 0.001347 321.6100n 0.001402 321.6200n 0.001427 321.6300n 0.001422 321.6400n 0.001384 321.6500n 0.001316 321.6600n 0.001217 321.6700n 0.001089 321.6800n 0.000933 321.6900n 0.000754 321.7000n 0.000553 321.7100n 0.000333 321.7200n 0.000100 321.7300n -0.000144 321.7400n -0.000393
+ 321.7500n -0.000643 321.7600n -0.000891 321.7700n -0.001131 321.7800n -0.001360 321.7900n -0.001573 321.8000n -0.001768 321.8100n -0.001940 321.8200n -0.002087 321.8300n -0.002207 321.8400n -0.002298 321.8500n -0.002359 321.8600n -0.002390 321.8700n -0.002390 321.8800n -0.002360 321.8900n -0.002301
+ 321.9000n -0.002216 321.9100n -0.002105 321.9200n -0.001973 321.9300n -0.001821 321.9400n -0.001654 321.9500n -0.001474 321.9600n -0.001285 321.9700n -0.001092 321.9800n -0.000897 321.9900n -0.000705 322.0000n -0.000519 322.0100n -0.000343 322.0200n -0.000178 322.0300n -0.000029 322.0400n 0.000102
+ 322.0500n 0.000214 322.0600n 0.000305 322.0700n 0.000375 322.0800n 0.000422 322.0900n 0.000446 322.1000n 0.000448 322.1100n 0.000429 322.1200n 0.000389 322.1300n 0.000331 322.1400n 0.000256 322.1500n 0.000167 322.1600n 0.000065 322.1700n -0.000047 322.1800n -0.000166 322.1900n -0.000290
+ 322.2000n -0.000416 322.2100n -0.000541 322.2200n -0.000664 322.2300n -0.000782 322.2400n -0.000894 322.2500n -0.000996 322.2600n -0.001089 322.2700n -0.001172 322.2800n -0.001242 322.2900n -0.001300 322.3000n -0.001346 322.3100n -0.001380 322.3200n -0.001402 322.3300n -0.001413 322.3400n -0.001414
+ 322.3500n -0.001406 322.3600n -0.001390 322.3700n -0.001368 322.3800n -0.001341 322.3900n -0.001311 322.4000n -0.001278 322.4100n -0.001244 322.4200n -0.001211 322.4300n -0.001179 322.4400n -0.001150 322.4500n -0.001125 322.4600n -0.001103 322.4700n -0.001085 322.4800n -0.001072 322.4900n -0.001064
+ 322.5000n -0.001059 322.5100n -0.001059 322.5200n -0.001061 322.5300n -0.001066 322.5400n -0.001072 322.5500n -0.001078 322.5600n -0.001084 322.5700n -0.001088 322.5800n -0.001090 322.5900n -0.001088 322.6000n -0.001081 322.6100n -0.001069 322.6200n -0.001050 322.6300n -0.001025 322.6400n -0.000992
+ 322.6500n -0.000952 322.6600n -0.000905 322.6700n -0.000851 322.6800n -0.000790 322.6900n -0.000722 322.7000n -0.000650 322.7100n -0.000572 322.7200n -0.000492 322.7300n -0.000409 322.7400n -0.000324 322.7500n -0.000240 322.7600n -0.000158 322.7700n -0.000078 322.7800n -0.000002 322.7900n 0.000069
+ 322.8000n 0.000134 322.8100n 0.000191 322.8200n 0.000241 322.8300n 0.000283 322.8400n 0.000315 322.8500n 0.000339 322.8600n 0.000353 322.8700n 0.000359 322.8800n 0.000357 322.8900n 0.000346 322.9000n 0.000329 322.9100n 0.000305 322.9200n 0.000276 322.9300n 0.000243 322.9400n 0.000208
+ 322.9500n 0.000170 322.9600n 0.000132 322.9700n 0.000095 322.9800n 0.000060 322.9900n 0.000028 323.0000n -0.000000 323.0100n -0.000024 323.0200n -0.000042 323.0300n -0.000054 323.0400n -0.000060 323.0500n -0.000060 323.0600n -0.000054 323.0700n -0.000041 323.0800n -0.000023 323.0900n -0.000001
+ 323.1000n 0.000026 323.1100n 0.000056 323.1200n 0.000088 323.1300n 0.000121 323.1400n 0.000153 323.1500n 0.000184 323.1600n 0.000212 323.1700n 0.000236 323.1800n 0.000255 323.1900n 0.000268 323.2000n 0.000274 323.2100n 0.000272 323.2200n 0.000262 323.2300n 0.000242 323.2400n 0.000213
+ 323.2500n 0.000175 323.2600n 0.000128 323.2700n 0.000071 323.2800n 0.000006 323.2900n -0.000066 323.3000n -0.000146 323.3100n -0.000232 323.3200n -0.000322 323.3300n -0.000416 323.3400n -0.000513 323.3500n -0.000610 323.3600n -0.000708 323.3700n -0.000803 323.3800n -0.000896 323.3900n -0.000984
+ 323.4000n -0.001067 323.4100n -0.001143 323.4200n -0.001211 323.4300n -0.001271 323.4400n -0.001321 323.4500n -0.001362 323.4600n -0.001393 323.4700n -0.001413 323.4800n -0.001423 323.4900n -0.001422 323.5000n -0.001411 323.5100n -0.001390 323.5200n -0.001360 323.5300n -0.001321 323.5400n -0.001274
+ 323.5500n -0.001219 323.5600n -0.001158 323.5700n -0.001091 323.5800n -0.001019 323.5900n -0.000942 323.6000n -0.000863 323.6100n -0.000781 323.6200n -0.000697 323.6300n -0.000612 323.6400n -0.000526 323.6500n -0.000441 323.6600n -0.000356 323.6700n -0.000272 323.6800n -0.000190 323.6900n -0.000109
+ 323.7000n -0.000030 323.7100n 0.000046 323.7200n 0.000120 323.7300n 0.000192 323.7400n 0.000261 323.7500n 0.000327 323.7600n 0.000390 323.7700n 0.000450 323.7800n 0.000507 323.7900n 0.000560 323.8000n 0.000610 323.8100n 0.000657 323.8200n 0.000699 323.8300n 0.000737 323.8400n 0.000771
+ 323.8500n 0.000800 323.8600n 0.000825 323.8700n 0.000844 323.8800n 0.000858 323.8900n 0.000866 323.9000n 0.000869 323.9100n 0.000866 323.9200n 0.000857 323.9300n 0.000843 323.9400n 0.000823 323.9500n 0.000798 323.9600n 0.000768 323.9700n 0.000734 323.9800n 0.000695 323.9900n 0.000654
+ 324.0000n 0.000610 324.0100n 0.000564 324.0200n 0.000517 324.0300n 0.000471 324.0400n 0.000425 324.0500n 0.000381 324.0600n 0.000341 324.0700n 0.000304 324.0800n 0.000272 324.0900n 0.000246 324.1000n 0.000226 324.1100n 0.000214 324.1200n 0.000209 324.1300n 0.000212 324.1400n 0.000224
+ 324.1500n 0.000245 324.1600n 0.000273 324.1700n 0.000310 324.1800n 0.000355 324.1900n 0.000407 324.2000n 0.000466 324.2100n 0.000530 324.2200n 0.000599 324.2300n 0.000671 324.2400n 0.000746 324.2500n 0.000822 324.2600n 0.000897 324.2700n 0.000971 324.2800n 0.001042 324.2900n 0.001108
+ 324.3000n 0.001170 324.3100n 0.001225 324.3200n 0.001272 324.3300n 0.001312 324.3400n 0.001343 324.3500n 0.001365 324.3600n 0.001378 324.3700n 0.001381 324.3800n 0.001375 324.3900n 0.001361 324.4000n 0.001339 324.4100n 0.001309 324.4200n 0.001273 324.4300n 0.001232 324.4400n 0.001188
+ 324.4500n 0.001140 324.4600n 0.001092 324.4700n 0.001044 324.4800n 0.000998 324.4900n 0.000954 324.5000n 0.000915 324.5100n 0.000882 324.5200n 0.000856 324.5300n 0.000837 324.5400n 0.000826 324.5500n 0.000824 324.5600n 0.000831 324.5700n 0.000847 324.5800n 0.000872 324.5900n 0.000905
+ 324.6000n 0.000945 324.6100n 0.000993 324.6200n 0.001045 324.6300n 0.001102 324.6400n 0.001161 324.6500n 0.001221 324.6600n 0.001280 324.6700n 0.001336 324.6800n 0.001388 324.6900n 0.001433 324.7000n 0.001470 324.7100n 0.001497 324.7200n 0.001512 324.7300n 0.001515 324.7400n 0.001503
+ 324.7500n 0.001476 324.7600n 0.001433 324.7700n 0.001374 324.7800n 0.001299 324.7900n 0.001207 324.8000n 0.001099 324.8100n 0.000976 324.8200n 0.000838 324.8300n 0.000688 324.8400n 0.000526 324.8500n 0.000354 324.8600n 0.000174 324.8700n -0.000012 324.8800n -0.000201 324.8900n -0.000393
+ 324.9000n -0.000583 324.9100n -0.000771 324.9200n -0.000953 324.9300n -0.001128 324.9400n -0.001294 324.9500n -0.001448 324.9600n -0.001589 324.9700n -0.001716 324.9800n -0.001826 324.9900n -0.001920 325.0000n -0.001996 325.0100n -0.002054 325.0200n -0.002093 325.0300n -0.002114 325.0400n -0.002116
+ 325.0500n -0.002100 325.0600n -0.002066 325.0700n -0.002016 325.0800n -0.001950 325.0900n -0.001870 325.1000n -0.001776 325.1100n -0.001671 325.1200n -0.001554 325.1300n -0.001429 325.1400n -0.001296 325.1500n -0.001157 325.1600n -0.001013 325.1700n -0.000866 325.1800n -0.000716 325.1900n -0.000565
+ 325.2000n -0.000414 325.2100n -0.000264 325.2200n -0.000116 325.2300n 0.000029 325.2400n 0.000171 325.2500n 0.000309 325.2600n 0.000442 325.2700n 0.000570 325.2800n 0.000693 325.2900n 0.000810 325.3000n 0.000920 325.3100n 0.001025 325.3200n 0.001122 325.3300n 0.001212 325.3400n 0.001295
+ 325.3500n 0.001371 325.3600n 0.001438 325.3700n 0.001496 325.3800n 0.001546 325.3900n 0.001586 325.4000n 0.001616 325.4100n 0.001637 325.4200n 0.001646 325.4300n 0.001645 325.4400n 0.001632 325.4500n 0.001608 325.4600n 0.001572 325.4700n 0.001524 325.4800n 0.001465 325.4900n 0.001393
+ 325.5000n 0.001310 325.5100n 0.001216 325.5200n 0.001111 325.5300n 0.000996 325.5400n 0.000872 325.5500n 0.000740 325.5600n 0.000601 325.5700n 0.000456 325.5800n 0.000307 325.5900n 0.000156 325.6000n 0.000003 325.6100n -0.000150 325.6200n -0.000300 325.6300n -0.000447 325.6400n -0.000589
+ 325.6500n -0.000723 325.6600n -0.000850 325.6700n -0.000966 325.6800n -0.001072 325.6900n -0.001165 325.7000n -0.001246 325.7100n -0.001313 325.7200n -0.001367 325.7300n -0.001406 325.7400n -0.001431 325.7500n -0.001443 325.7600n -0.001441 325.7700n -0.001426 325.7800n -0.001400 325.7900n -0.001363
+ 325.8000n -0.001317 325.8100n -0.001263 325.8200n -0.001203 325.8300n -0.001137 325.8400n -0.001068 325.8500n -0.000998 325.8600n -0.000926 325.8700n -0.000856 325.8800n -0.000789 325.8900n -0.000725 325.9000n -0.000665 325.9100n -0.000611 325.9200n -0.000562 325.9300n -0.000520 325.9400n -0.000485
+ 325.9500n -0.000456 325.9600n -0.000433 325.9700n -0.000416 325.9800n -0.000404 325.9900n -0.000396 326.0000n -0.000392 326.0100n -0.000389 326.0200n -0.000388 326.0300n -0.000387 326.0400n -0.000385 326.0500n -0.000381 326.0600n -0.000373 326.0700n -0.000362 326.0800n -0.000345 326.0900n -0.000323
+ 326.1000n -0.000295 326.1100n -0.000262 326.1200n -0.000223 326.1300n -0.000178 326.1400n -0.000130 326.1500n -0.000077 326.1600n -0.000022 326.1700n 0.000035 326.1800n 0.000091 326.1900n 0.000144 326.2000n 0.000194 326.2100n 0.000238 326.2200n 0.000274 326.2300n 0.000300 326.2400n 0.000315
+ 326.2500n 0.000316 326.2600n 0.000302 326.2700n 0.000272 326.2800n 0.000223 326.2900n 0.000157 326.3000n 0.000071 326.3100n -0.000034 326.3200n -0.000157 326.3300n -0.000299 326.3400n -0.000459 326.3500n -0.000634 326.3600n -0.000823 326.3700n -0.001024 326.3800n -0.001235 326.3900n -0.001452
+ 326.4000n -0.001673 326.4100n -0.001894 326.4200n -0.002112 326.4300n -0.002324 326.4400n -0.002525 326.4500n -0.002713 326.4600n -0.002885 326.4700n -0.003036 326.4800n -0.003165 326.4900n -0.003268 326.5000n -0.003343 326.5100n -0.003388 326.5200n -0.003402 326.5300n -0.003384 326.5400n -0.003334
+ 326.5500n -0.003251 326.5600n -0.003135 326.5700n -0.002989 326.5800n -0.002813 326.5900n -0.002609 326.6000n -0.002380 326.6100n -0.002129 326.6200n -0.001858 326.6300n -0.001571 326.6400n -0.001272 326.6500n -0.000965 326.6600n -0.000653 326.6700n -0.000340 326.6800n -0.000031 326.6900n 0.000272
+ 326.7000n 0.000564 326.7100n 0.000842 326.7200n 0.001103 326.7300n 0.001345 326.7400n 0.001564 326.7500n 0.001759 326.7600n 0.001929 326.7700n 0.002072 326.7800n 0.002187 326.7900n 0.002274 326.8000n 0.002334 326.8100n 0.002367 326.8200n 0.002373 326.8300n 0.002355 326.8400n 0.002314
+ 326.8500n 0.002251 326.8600n 0.002170 326.8700n 0.002071 326.8800n 0.001957 326.8900n 0.001832 326.9000n 0.001696 326.9100n 0.001553 326.9200n 0.001405 326.9300n 0.001254 326.9400n 0.001102 326.9500n 0.000950 326.9600n 0.000802 326.9700n 0.000657 326.9800n 0.000517 326.9900n 0.000384
+ 327.0000n 0.000257 327.0100n 0.000138 327.0200n 0.000026 327.0300n -0.000078 327.0400n -0.000175 327.0500n -0.000264 327.0600n -0.000347 327.0700n -0.000423 327.0800n -0.000492 327.0900n -0.000556 327.1000n -0.000616 327.1100n -0.000670 327.1200n -0.000721 327.1300n -0.000768 327.1400n -0.000811
+ 327.1500n -0.000852 327.1600n -0.000889 327.1700n -0.000924 327.1800n -0.000955 327.1900n -0.000984 327.2000n -0.001009 327.2100n -0.001030 327.2200n -0.001048 327.2300n -0.001062 327.2400n -0.001071 327.2500n -0.001075 327.2600n -0.001075 327.2700n -0.001070 327.2800n -0.001060 327.2900n -0.001045
+ 327.3000n -0.001025 327.3100n -0.001001 327.3200n -0.000972 327.3300n -0.000941 327.3400n -0.000907 327.3500n -0.000871 327.3600n -0.000835 327.3700n -0.000798 327.3800n -0.000763 327.3900n -0.000730 327.4000n -0.000700 327.4100n -0.000675 327.4200n -0.000655 327.4300n -0.000641 327.4400n -0.000634
+ 327.4500n -0.000635 327.4600n -0.000643 327.4700n -0.000659 327.4800n -0.000683 327.4900n -0.000714 327.5000n -0.000753 327.5100n -0.000797 327.5200n -0.000845 327.5300n -0.000897 327.5400n -0.000951 327.5500n -0.001005 327.5600n -0.001056 327.5700n -0.001104 327.5800n -0.001145 327.5900n -0.001178
+ 327.6000n -0.001201 327.6100n -0.001211 327.6200n -0.001206 327.6300n -0.001186 327.6400n -0.001148 327.6500n -0.001091 327.6600n -0.001016 327.6700n -0.000920 327.6800n -0.000804 327.6900n -0.000669 327.7000n -0.000515 327.7100n -0.000344 327.7200n -0.000157 327.7300n 0.000043 327.7400n 0.000255
+ 327.7500n 0.000474 327.7600n 0.000699 327.7700n 0.000926 327.7800n 0.001151 327.7900n 0.001371 327.8000n 0.001582 327.8100n 0.001781 327.8200n 0.001964 327.8300n 0.002127 327.8400n 0.002269 327.8500n 0.002386 327.8600n 0.002476 327.8700n 0.002538 327.8800n 0.002570 327.8900n 0.002572
+ 327.9000n 0.002544 327.9100n 0.002486 327.9200n 0.002399 327.9300n 0.002287 327.9400n 0.002149 327.9500n 0.001991 327.9600n 0.001815 327.9700n 0.001624 327.9800n 0.001423 327.9900n 0.001217 328.0000n 0.001010 328.0100n 0.000805 328.0200n 0.000609 328.0300n 0.000426 328.0400n 0.000259
+ 328.0500n 0.000113 328.0600n -0.000009 328.0700n -0.000105 328.0800n -0.000170 328.0900n -0.000205 328.1000n -0.000206 328.1100n -0.000175 328.1200n -0.000112 328.1300n -0.000017 328.1400n 0.000108 328.1500n 0.000260 328.1600n 0.000436 328.1700n 0.000633 328.1800n 0.000846 328.1900n 0.001071
+ 328.2000n 0.001303 328.2100n 0.001537 328.2200n 0.001767 328.2300n 0.001988 328.2400n 0.002194 328.2500n 0.002383 328.2600n 0.002547 328.2700n 0.002684 328.2800n 0.002790 328.2900n 0.002861 328.3000n 0.002896 328.3100n 0.002894 328.3200n 0.002853 328.3300n 0.002773 328.3400n 0.002656
+ 328.3500n 0.002504 328.3600n 0.002319 328.3700n 0.002104 328.3800n 0.001864 328.3900n 0.001603 328.4000n 0.001327 328.4100n 0.001041 328.4200n 0.000751 328.4300n 0.000463 328.4400n 0.000183 328.4500n -0.000083 328.4600n -0.000329 328.4700n -0.000549 328.4800n -0.000739 328.4900n -0.000894
+ 328.5000n -0.001010 328.5100n -0.001085 328.5200n -0.001116 328.5300n -0.001102 328.5400n -0.001042 328.5500n -0.000938 328.5600n -0.000790 328.5700n -0.000601 328.5800n -0.000375 328.5900n -0.000115 328.6000n 0.000174 328.6100n 0.000486 328.6200n 0.000816 328.6300n 0.001157 328.6400n 0.001502
+ 328.6500n 0.001845 328.6600n 0.002179 328.6700n 0.002497 328.6800n 0.002792 328.6900n 0.003060 328.7000n 0.003295 328.7100n 0.003490 328.7200n 0.003644 328.7300n 0.003751 328.7400n 0.003810 328.7500n 0.003819 328.7600n 0.003778 328.7700n 0.003686 328.7800n 0.003546 328.7900n 0.003359
+ 328.8000n 0.003129 328.8100n 0.002859 328.8200n 0.002554 328.8300n 0.002220 328.8400n 0.001861 328.8500n 0.001484 328.8600n 0.001096 328.8700n 0.000702 328.8800n 0.000310 328.8900n -0.000075 328.9000n -0.000446 328.9100n -0.000797 328.9200n -0.001123 328.9300n -0.001420 328.9400n -0.001683
+ 328.9500n -0.001910 328.9600n -0.002098 328.9700n -0.002244 328.9800n -0.002350 328.9900n -0.002413 329.0000n -0.002436 329.0100n -0.002420 329.0200n -0.002367 329.0300n -0.002280 329.0400n -0.002164 329.0500n -0.002022 329.0600n -0.001858 329.0700n -0.001678 329.0800n -0.001487 329.0900n -0.001289
+ 329.1000n -0.001090 329.1100n -0.000894 329.1200n -0.000706 329.1300n -0.000530 329.1400n -0.000370 329.1500n -0.000228 329.1600n -0.000109 329.1700n -0.000013 329.1800n 0.000059 329.1900n 0.000105 329.2000n 0.000126 329.2100n 0.000122 329.2200n 0.000095 329.2300n 0.000047 329.2400n -0.000020
+ 329.2500n -0.000102 329.2600n -0.000196 329.2700n -0.000299 329.2800n -0.000407 329.2900n -0.000515 329.3000n -0.000620 329.3100n -0.000717 329.3200n -0.000803 329.3300n -0.000875 329.3400n -0.000930 329.3500n -0.000964 329.3600n -0.000975 329.3700n -0.000963 329.3800n -0.000925 329.3900n -0.000861
+ 329.4000n -0.000772 329.4100n -0.000658 329.4200n -0.000520 329.4300n -0.000360 329.4400n -0.000181 329.4500n 0.000016 329.4600n 0.000225 329.4700n 0.000445 329.4800n 0.000671 329.4900n 0.000899 329.5000n 0.001126 329.5100n 0.001348 329.5200n 0.001559 329.5300n 0.001758 329.5400n 0.001940
+ 329.5500n 0.002103 329.5600n 0.002242 329.5700n 0.002357 329.5800n 0.002446 329.5900n 0.002506 329.6000n 0.002537 329.6100n 0.002539 329.6200n 0.002513 329.6300n 0.002458 329.6400n 0.002375 329.6500n 0.002268 329.6600n 0.002138 329.6700n 0.001986 329.6800n 0.001817 329.6900n 0.001633
+ 329.7000n 0.001437 329.7100n 0.001233 329.7200n 0.001023 329.7300n 0.000812 329.7400n 0.000602 329.7500n 0.000396 329.7600n 0.000198 329.7700n 0.000010 329.7800n -0.000166 329.7900n -0.000328 329.8000n -0.000474 329.8100n -0.000603 329.8200n -0.000713 329.8300n -0.000805 329.8400n -0.000878
+ 329.8500n -0.000932 329.8600n -0.000968 329.8700n -0.000987 329.8800n -0.000989 329.8900n -0.000976 329.9000n -0.000950 329.9100n -0.000911 329.9200n -0.000862 329.9300n -0.000804 329.9400n -0.000739 329.9500n -0.000668 329.9600n -0.000595 329.9700n -0.000519 329.9800n -0.000442 329.9900n -0.000366
+ 330.0000n -0.000291 330.0100n -0.000220 330.0200n -0.000151 330.0300n -0.000087 330.0400n -0.000027 330.0500n 0.000028 330.0600n 0.000079 330.0700n 0.000125 330.0800n 0.000166 330.0900n 0.000203 330.1000n 0.000236 330.1100n 0.000266 330.1200n 0.000292 330.1300n 0.000316 330.1400n 0.000337
+ 330.1500n 0.000356 330.1600n 0.000374 330.1700n 0.000390 330.1800n 0.000405 330.1900n 0.000419 330.2000n 0.000432 330.2100n 0.000444 330.2200n 0.000455 330.2300n 0.000465 330.2400n 0.000473 330.2500n 0.000480 330.2600n 0.000484 330.2700n 0.000487 330.2800n 0.000488 330.2900n 0.000485
+ 330.3000n 0.000481 330.3100n 0.000473 330.3200n 0.000463 330.3300n 0.000449 330.3400n 0.000433 330.3500n 0.000415 330.3600n 0.000394 330.3700n 0.000371 330.3800n 0.000347 330.3900n 0.000321 330.4000n 0.000294 330.4100n 0.000268 330.4200n 0.000241 330.4300n 0.000216 330.4400n 0.000192
+ 330.4500n 0.000169 330.4600n 0.000148 330.4700n 0.000130 330.4800n 0.000115 330.4900n 0.000102 330.5000n 0.000091 330.5100n 0.000084 330.5200n 0.000078 330.5300n 0.000075 330.5400n 0.000072 330.5500n 0.000071 330.5600n 0.000070 330.5700n 0.000068 330.5800n 0.000064 330.5900n 0.000059
+ 330.6000n 0.000050 330.6100n 0.000037 330.6200n 0.000019 330.6300n -0.000005 330.6400n -0.000035 330.6500n -0.000071 330.6600n -0.000115 330.6700n -0.000166 330.6800n -0.000224 330.6900n -0.000289 330.7000n -0.000362 330.7100n -0.000440 330.7200n -0.000524 330.7300n -0.000613 330.7400n -0.000705
+ 330.7500n -0.000799 330.7600n -0.000894 330.7700n -0.000988 330.7800n -0.001079 330.7900n -0.001166 330.8000n -0.001248 330.8100n -0.001322 330.8200n -0.001387 330.8300n -0.001442 330.8400n -0.001486 330.8500n -0.001516 330.8600n -0.001533 330.8700n -0.001536 330.8800n -0.001524 330.8900n -0.001497
+ 330.9000n -0.001455 330.9100n -0.001399 330.9200n -0.001329 330.9300n -0.001247 330.9400n -0.001153 330.9500n -0.001049 330.9600n -0.000937 330.9700n -0.000818 330.9800n -0.000694 330.9900n -0.000568 331.0000n -0.000441 331.0100n -0.000315 331.0200n -0.000192 331.0300n -0.000074 331.0400n 0.000037
+ 331.0500n 0.000140 331.0600n 0.000234 331.0700n 0.000317 331.0800n 0.000389 331.0900n 0.000450 331.1000n 0.000500 331.1100n 0.000538 331.1200n 0.000565 331.1300n 0.000583 331.1400n 0.000591 331.1500n 0.000592 331.1600n 0.000586 331.1700n 0.000576 331.1800n 0.000564 331.1900n 0.000550
+ 331.2000n 0.000537 331.2100n 0.000527 331.2200n 0.000521 331.2300n 0.000521 331.2400n 0.000528 331.2500n 0.000543 331.2600n 0.000567 331.2700n 0.000600 331.2800n 0.000644 331.2900n 0.000696 331.3000n 0.000757 331.3100n 0.000826 331.3200n 0.000901 331.3300n 0.000981 331.3400n 0.001064
+ 331.3500n 0.001147 331.3600n 0.001228 331.3700n 0.001306 331.3800n 0.001376 331.3900n 0.001436 331.4000n 0.001484 331.4100n 0.001518 331.4200n 0.001534 331.4300n 0.001531 331.4400n 0.001507 331.4500n 0.001461 331.4600n 0.001392 331.4700n 0.001299 331.4800n 0.001182 331.4900n 0.001043
+ 331.5000n 0.000881 331.5100n 0.000699 331.5200n 0.000499 331.5300n 0.000284 331.5400n 0.000056 331.5500n -0.000181 331.5600n -0.000423 331.5700n -0.000665 331.5800n -0.000905 331.5900n -0.001136 331.6000n -0.001354 331.6100n -0.001556 331.6200n -0.001736 331.6300n -0.001892 331.6400n -0.002018
+ 331.6500n -0.002112 331.6600n -0.002171 331.6700n -0.002193 331.6800n -0.002176 331.6900n -0.002120 331.7000n -0.002023 331.7100n -0.001888 331.7200n -0.001714 331.7300n -0.001504 331.7400n -0.001261 331.7500n -0.000987 331.7600n -0.000688 331.7700n -0.000366 331.7800n -0.000027 331.7900n 0.000323
+ 331.8000n 0.000680 331.8100n 0.001037 331.8200n 0.001389 331.8300n 0.001730 331.8400n 0.002055 331.8500n 0.002358 331.8600n 0.002635 331.8700n 0.002881 331.8800n 0.003092 331.8900n 0.003266 331.9000n 0.003399 331.9100n 0.003491 331.9200n 0.003539 331.9300n 0.003544 331.9400n 0.003506
+ 331.9500n 0.003428 331.9600n 0.003310 331.9700n 0.003155 331.9800n 0.002968 331.9900n 0.002753 332.0000n 0.002513 332.0100n 0.002254 332.0200n 0.001981 332.0300n 0.001700 332.0400n 0.001417 332.0500n 0.001136 332.0600n 0.000863 332.0700n 0.000604 332.0800n 0.000363 332.0900n 0.000145
+ 332.1000n -0.000046 332.1100n -0.000208 332.1200n -0.000337 332.1300n -0.000431 332.1400n -0.000489 332.1500n -0.000510 332.1600n -0.000495 332.1700n -0.000445 332.1800n -0.000360 332.1900n -0.000244 332.2000n -0.000099 332.2100n 0.000071 332.2200n 0.000264 332.2300n 0.000474 332.2400n 0.000697
+ 332.2500n 0.000929 332.2600n 0.001164 332.2700n 0.001399 332.2800n 0.001628 332.2900n 0.001848 332.3000n 0.002053 332.3100n 0.002241 332.3200n 0.002408 332.3300n 0.002551 332.3400n 0.002667 332.3500n 0.002756 332.3600n 0.002815 332.3700n 0.002844 332.3800n 0.002843 332.3900n 0.002813
+ 332.4000n 0.002754 332.4100n 0.002668 332.4200n 0.002556 332.4300n 0.002422 332.4400n 0.002268 332.4500n 0.002096 332.4600n 0.001911 332.4700n 0.001714 332.4800n 0.001510 332.4900n 0.001301 332.5000n 0.001092 332.5100n 0.000884 332.5200n 0.000681 332.5300n 0.000485 332.5400n 0.000298
+ 332.5500n 0.000123 332.5600n -0.000039 332.5700n -0.000187 332.5800n -0.000320 332.5900n -0.000437 332.6000n -0.000538 332.6100n -0.000623 332.6200n -0.000694 332.6300n -0.000749 332.6400n -0.000791 332.6500n -0.000821 332.6600n -0.000839 332.6700n -0.000847 332.6800n -0.000847 332.6900n -0.000840
+ 332.7000n -0.000827 332.7100n -0.000809 332.7200n -0.000788 332.7300n -0.000765 332.7400n -0.000740 332.7500n -0.000715 332.7600n -0.000690 332.7700n -0.000665 332.7800n -0.000641 332.7900n -0.000618 332.8000n -0.000595 332.8100n -0.000573 332.8200n -0.000552 332.8300n -0.000530 332.8400n -0.000509
+ 332.8500n -0.000487 332.8600n -0.000464 332.8700n -0.000440 332.8800n -0.000415 332.8900n -0.000389 332.9000n -0.000361 332.9100n -0.000333 332.9200n -0.000304 332.9300n -0.000275 332.9400n -0.000246 332.9500n -0.000219 332.9600n -0.000194 332.9700n -0.000172 332.9800n -0.000155 332.9900n -0.000142
+ 333.0000n -0.000136 333.0100n -0.000138 333.0200n -0.000148 333.0300n -0.000167 333.0400n -0.000195 333.0500n -0.000235 333.0600n -0.000284 333.0700n -0.000345 333.0800n -0.000416 333.0900n -0.000497 333.1000n -0.000588 333.1100n -0.000686 333.1200n -0.000792 333.1300n -0.000902 333.1400n -0.001017
+ 333.1500n -0.001132 333.1600n -0.001247 333.1700n -0.001359 333.1800n -0.001465 333.1900n -0.001563 333.2000n -0.001651 333.2100n -0.001726 333.2200n -0.001786 333.2300n -0.001829 333.2400n -0.001853 333.2500n -0.001857 333.2600n -0.001840 333.2700n -0.001802 333.2800n -0.001741 333.2900n -0.001658
+ 333.3000n -0.001554 333.3100n -0.001430 333.3200n -0.001288 333.3300n -0.001129 333.3400n -0.000956 333.3500n -0.000772 333.3600n -0.000580 333.3700n -0.000383 333.3800n -0.000185 333.3900n 0.000010 333.4000n 0.000199 333.4100n 0.000378 333.4200n 0.000543 333.4300n 0.000691 333.4400n 0.000819
+ 333.4500n 0.000923 333.4600n 0.001002 333.4700n 0.001053 333.4800n 0.001074 333.4900n 0.001066 333.5000n 0.001027 333.5100n 0.000957 333.5200n 0.000858 333.5300n 0.000731 333.5400n 0.000578 333.5500n 0.000401 333.5600n 0.000204 333.5700n -0.000010 333.5800n -0.000237 333.5900n -0.000473
+ 333.6000n -0.000713 333.6100n -0.000953 333.6200n -0.001189 333.6300n -0.001415 333.6400n -0.001627 333.6500n -0.001821 333.6600n -0.001994 333.6700n -0.002141 333.6800n -0.002260 333.6900n -0.002348 333.7000n -0.002404 333.7100n -0.002426 333.7200n -0.002413 333.7300n -0.002366 333.7400n -0.002285
+ 333.7500n -0.002172 333.7600n -0.002029 333.7700n -0.001859 333.7800n -0.001664 333.7900n -0.001448 333.8000n -0.001216 333.8100n -0.000971 333.8200n -0.000718 333.8300n -0.000462 333.8400n -0.000208 333.8500n 0.000039 333.8600n 0.000276 333.8700n 0.000498 333.8800n 0.000701 333.8900n 0.000881
+ 333.9000n 0.001035 333.9100n 0.001161 333.9200n 0.001257 333.9300n 0.001322 333.9400n 0.001354 333.9500n 0.001354 333.9600n 0.001323 333.9700n 0.001262 333.9800n 0.001172 333.9900n 0.001056 334.0000n 0.000918 334.0100n 0.000760 334.0200n 0.000585 334.0300n 0.000399 334.0400n 0.000205
+ 334.0500n 0.000008 334.0600n -0.000189 334.0700n -0.000380 334.0800n -0.000563 334.0900n -0.000733 334.1000n -0.000886 334.1100n -0.001020 334.1200n -0.001132 334.1300n -0.001219 334.1400n -0.001281 334.1500n -0.001316 334.1600n -0.001324 334.1700n -0.001305 334.1800n -0.001259 334.1900n -0.001188
+ 334.2000n -0.001093 334.2100n -0.000977 334.2200n -0.000842 334.2300n -0.000691 334.2400n -0.000528 334.2500n -0.000356 334.2600n -0.000178 334.2700n 0.000002 334.2800n 0.000180 334.2900n 0.000353 334.3000n 0.000518 334.3100n 0.000671 334.3200n 0.000810 334.3300n 0.000932 334.3400n 0.001036
+ 334.3500n 0.001120 334.3600n 0.001182 334.3700n 0.001222 334.3800n 0.001240 334.3900n 0.001237 334.4000n 0.001212 334.4100n 0.001167 334.4200n 0.001104 334.4300n 0.001025 334.4400n 0.000931 334.4500n 0.000826 334.4600n 0.000712 334.4700n 0.000592 334.4800n 0.000468 334.4900n 0.000344
+ 334.5000n 0.000222 334.5100n 0.000105 334.5200n -0.000004 334.5300n -0.000103 334.5400n -0.000191 334.5500n -0.000265 334.5600n -0.000325 334.5700n -0.000368 334.5800n -0.000395 334.5900n -0.000405 334.6000n -0.000398 334.6100n -0.000375 334.6200n -0.000336 334.6300n -0.000283 334.6400n -0.000217
+ 334.6500n -0.000139 334.6600n -0.000052 334.6700n 0.000043 334.6800n 0.000143 334.6900n 0.000246 334.7000n 0.000350 334.7100n 0.000453 334.7200n 0.000552 334.7300n 0.000646 334.7400n 0.000733 334.7500n 0.000810 334.7600n 0.000876 334.7700n 0.000930 334.7800n 0.000971 334.7900n 0.000998
+ 334.8000n 0.001010 334.8100n 0.001007 334.8200n 0.000990 334.8300n 0.000957 334.8400n 0.000910 334.8500n 0.000849 334.8600n 0.000776 334.8700n 0.000690 334.8800n 0.000594 334.8900n 0.000489 334.9000n 0.000376 334.9100n 0.000256 334.9200n 0.000132 334.9300n 0.000004 334.9400n -0.000125
+ 334.9500n -0.000254 334.9600n -0.000382 334.9700n -0.000507 334.9800n -0.000627 334.9900n -0.000743 335.0000n -0.000851 335.0100n -0.000952 335.0200n -0.001044 335.0300n -0.001126 335.0400n -0.001198 335.0500n -0.001259 335.0600n -0.001309 335.0700n -0.001346 335.0800n -0.001372 335.0900n -0.001386
+ 335.1000n -0.001387 335.1100n -0.001376 335.1200n -0.001354 335.1300n -0.001319 335.1400n -0.001273 335.1500n -0.001216 335.1600n -0.001149 335.1700n -0.001072 335.1800n -0.000986 335.1900n -0.000892 335.2000n -0.000790 335.2100n -0.000682 335.2200n -0.000569 335.2300n -0.000451 335.2400n -0.000330
+ 335.2500n -0.000207 335.2600n -0.000084 335.2700n 0.000039 335.2800n 0.000159 335.2900n 0.000276 335.3000n 0.000389 335.3100n 0.000495 335.3200n 0.000595 335.3300n 0.000685 335.3400n 0.000766 335.3500n 0.000836 335.3600n 0.000895 335.3700n 0.000941 335.3800n 0.000974 335.3900n 0.000993
+ 335.4000n 0.000999 335.4100n 0.000991 335.4200n 0.000969 335.4300n 0.000934 335.4400n 0.000887 335.4500n 0.000827 335.4600n 0.000756 335.4700n 0.000676 335.4800n 0.000588 335.4900n 0.000493 335.5000n 0.000392 335.5100n 0.000289 335.5200n 0.000184 335.5300n 0.000080 335.5400n -0.000022
+ 335.5500n -0.000119 335.5600n -0.000211 335.5700n -0.000294 335.5800n -0.000367 335.5900n -0.000430 335.6000n -0.000481 335.6100n -0.000518 335.6200n -0.000542 335.6300n -0.000552 335.6400n -0.000548 335.6500n -0.000529 335.6600n -0.000498 335.6700n -0.000454 335.6800n -0.000399 335.6900n -0.000334
+ 335.7000n -0.000262 335.7100n -0.000183 335.7200n -0.000100 335.7300n -0.000015 335.7400n 0.000068 335.7500n 0.000148 335.7600n 0.000223 335.7700n 0.000289 335.7800n 0.000345 335.7900n 0.000388 335.8000n 0.000417 335.8100n 0.000429 335.8200n 0.000423 335.8300n 0.000399 335.8400n 0.000355
+ 335.8500n 0.000290 335.8600n 0.000206 335.8700n 0.000102 335.8800n -0.000021 335.8900n -0.000161 335.9000n -0.000317 335.9100n -0.000487 335.9200n -0.000669 335.9300n -0.000860 335.9400n -0.001057 335.9500n -0.001258 335.9600n -0.001460 335.9700n -0.001658 335.9800n -0.001851 335.9900n -0.002035
+ 336.0000n -0.002207 336.0100n -0.002365 336.0200n -0.002505 336.0300n -0.002627 336.0400n -0.002728 336.0500n -0.002806 336.0600n -0.002861 336.0700n -0.002892 336.0800n -0.002899 336.0900n -0.002882 336.1000n -0.002842 336.1100n -0.002780 336.1200n -0.002699 336.1300n -0.002599 336.1400n -0.002484
+ 336.1500n -0.002356 336.1600n -0.002217 336.1700n -0.002072 336.1800n -0.001923 336.1900n -0.001773 336.2000n -0.001626 336.2100n -0.001485 336.2200n -0.001353 336.2300n -0.001233 336.2400n -0.001126 336.2500n -0.001036 336.2600n -0.000963 336.2700n -0.000911 336.2800n -0.000878 336.2900n -0.000867
+ 336.3000n -0.000876 336.3100n -0.000906 336.3200n -0.000955 336.3300n -0.001023 336.3400n -0.001107 336.3500n -0.001205 336.3600n -0.001315 336.3700n -0.001434 336.3800n -0.001559 336.3900n -0.001688 336.4000n -0.001816 336.4100n -0.001941 336.4200n -0.002059 336.4300n -0.002167 336.4400n -0.002264
+ 336.4500n -0.002345 336.4600n -0.002409 336.4700n -0.002453 336.4800n -0.002476 336.4900n -0.002477 336.5000n -0.002456 336.5100n -0.002411 336.5200n -0.002343 336.5300n -0.002253 336.5400n -0.002142 336.5500n -0.002012 336.5600n -0.001863 336.5700n -0.001700 336.5800n -0.001524 336.5900n -0.001338
+ 336.6000n -0.001145 336.6100n -0.000950 336.6200n -0.000754 336.6300n -0.000561 336.6400n -0.000375 336.6500n -0.000199 336.6600n -0.000036 336.6700n 0.000111 336.6800n 0.000241 336.6900n 0.000350 336.7000n 0.000437 336.7100n 0.000500 336.7200n 0.000538 336.7300n 0.000552 336.7400n 0.000540
+ 336.7500n 0.000503 336.7600n 0.000442 336.7700n 0.000359 336.7800n 0.000253 336.7900n 0.000129 336.8000n -0.000013 336.8100n -0.000170 336.8200n -0.000338 336.8300n -0.000515 336.8400n -0.000698 336.8500n -0.000883 336.8600n -0.001068 336.8700n -0.001248 336.8800n -0.001422 336.8900n -0.001585
+ 336.9000n -0.001736 336.9100n -0.001870 336.9200n -0.001987 336.9300n -0.002084 336.9400n -0.002159 336.9500n -0.002211 336.9600n -0.002239 336.9700n -0.002242 336.9800n -0.002219 336.9900n -0.002171 337.0000n -0.002098 337.0100n -0.002000 337.0200n -0.001879 337.0300n -0.001736 337.0400n -0.001572
+ 337.0500n -0.001390 337.0600n -0.001191 337.0700n -0.000977 337.0800n -0.000752 337.0900n -0.000517 337.1000n -0.000275 337.1100n -0.000029 337.1200n 0.000219 337.1300n 0.000465 337.1400n 0.000708 337.1500n 0.000945 337.1600n 0.001173 337.1700n 0.001389 337.1800n 0.001593 337.1900n 0.001781
+ 337.2000n 0.001951 337.2100n 0.002103 337.2200n 0.002234 337.2300n 0.002343 337.2400n 0.002430 337.2500n 0.002493 337.2600n 0.002532 337.2700n 0.002547 337.2800n 0.002537 337.2900n 0.002503 337.3000n 0.002446 337.3100n 0.002366 337.3200n 0.002264 337.3300n 0.002141 337.3400n 0.001999
+ 337.3500n 0.001840 337.3600n 0.001665 337.3700n 0.001476 337.3800n 0.001275 337.3900n 0.001066 337.4000n 0.000850 337.4100n 0.000630 337.4200n 0.000408 337.4300n 0.000188 337.4400n -0.000029 337.4500n -0.000239 337.4600n -0.000440 337.4700n -0.000630 337.4800n -0.000806 337.4900n -0.000965
+ 337.5000n -0.001107 337.5100n -0.001229 337.5200n -0.001331 337.5300n -0.001409 337.5400n -0.001465 337.5500n -0.001496 337.5600n -0.001504 337.5700n -0.001488 337.5800n -0.001448 337.5900n -0.001385 337.6000n -0.001301 337.6100n -0.001197 337.6200n -0.001074 337.6300n -0.000936 337.6400n -0.000783
+ 337.6500n -0.000618 337.6600n -0.000445 337.6700n -0.000266 337.6800n -0.000084 337.6900n 0.000099 337.7000n 0.000278 337.7100n 0.000453 337.7200n 0.000619 337.7300n 0.000774 337.7400n 0.000917 337.7500n 0.001044 337.7600n 0.001155 337.7700n 0.001247 337.7800n 0.001320 337.7900n 0.001373
+ 337.8000n 0.001406 337.8100n 0.001419 337.8200n 0.001412 337.8300n 0.001386 337.8400n 0.001343 337.8500n 0.001284 337.8600n 0.001211 337.8700n 0.001127 337.8800n 0.001033 337.8900n 0.000933 337.9000n 0.000829 337.9100n 0.000723 337.9200n 0.000619 337.9300n 0.000519 337.9400n 0.000427
+ 337.9500n 0.000344 337.9600n 0.000272 337.9700n 0.000214 337.9800n 0.000170 337.9900n 0.000144 338.0000n 0.000134 338.0100n 0.000142 338.0200n 0.000168 338.0300n 0.000212 338.0400n 0.000272 338.0500n 0.000348 338.0600n 0.000437 338.0700n 0.000539 338.0800n 0.000651 338.0900n 0.000770
+ 338.1000n 0.000895 338.1100n 0.001021 338.1200n 0.001147 338.1300n 0.001269 338.1400n 0.001385 338.1500n 0.001492 338.1600n 0.001588 338.1700n 0.001670 338.1800n 0.001737 338.1900n 0.001786 338.2000n 0.001816 338.2100n 0.001827 338.2200n 0.001818 338.2300n 0.001790 338.2400n 0.001742
+ 338.2500n 0.001675 338.2600n 0.001592 338.2700n 0.001493 338.2800n 0.001380 338.2900n 0.001257 338.3000n 0.001125 338.3100n 0.000988 338.3200n 0.000848 338.3300n 0.000709 338.3400n 0.000573 338.3500n 0.000445 338.3600n 0.000326 338.3700n 0.000220 338.3800n 0.000129 338.3900n 0.000055
+ 338.4000n 0.000001 338.4100n -0.000033 338.4200n -0.000045 338.4300n -0.000035 338.4400n -0.000001 338.4500n 0.000054 338.4600n 0.000131 338.4700n 0.000229 338.4800n 0.000345 338.4900n 0.000478 338.5000n 0.000626 338.5100n 0.000786 338.5200n 0.000955 338.5300n 0.001130 338.5400n 0.001308
+ 338.5500n 0.001486 338.5600n 0.001661 338.5700n 0.001831 338.5800n 0.001991 338.5900n 0.002139 338.6000n 0.002274 338.6100n 0.002393 338.6200n 0.002494 338.6300n 0.002576 338.6400n 0.002638 338.6500n 0.002680 338.6600n 0.002701 338.6700n 0.002702 338.6800n 0.002684 338.6900n 0.002646
+ 338.7000n 0.002592 338.7100n 0.002522 338.7200n 0.002438 338.7300n 0.002343 338.7400n 0.002238 338.7500n 0.002126 338.7600n 0.002008 338.7700n 0.001888 338.7800n 0.001768 338.7900n 0.001648 338.8000n 0.001531 338.8100n 0.001419 338.8200n 0.001312 338.8300n 0.001212 338.8400n 0.001119
+ 338.8500n 0.001033 338.8600n 0.000955 338.8700n 0.000884 338.8800n 0.000819 338.8900n 0.000760 338.9000n 0.000705 338.9100n 0.000653 338.9200n 0.000603 338.9300n 0.000553 338.9400n 0.000501 338.9500n 0.000447 338.9600n 0.000388 338.9700n 0.000324 338.9800n 0.000252 338.9900n 0.000174
+ 339.0000n 0.000086 339.0100n -0.000009 339.0200n -0.000113 339.0300n -0.000226 339.0400n -0.000346 339.0500n -0.000472 339.0600n -0.000603 339.0700n -0.000738 339.0800n -0.000873 339.0900n -0.001008 339.1000n -0.001139 339.1100n -0.001265 339.1200n -0.001381 339.1300n -0.001487 339.1400n -0.001578
+ 339.1500n -0.001653 339.1600n -0.001709 339.1700n -0.001744 339.1800n -0.001756 339.1900n -0.001744 339.2000n -0.001707 339.2100n -0.001644 339.2200n -0.001555 339.2300n -0.001441 339.2400n -0.001302 339.2500n -0.001140 339.2600n -0.000957 339.2700n -0.000755 339.2800n -0.000536 339.2900n -0.000305
+ 339.3000n -0.000064 339.3100n 0.000183 339.3200n 0.000432 339.3300n 0.000679 339.3400n 0.000920 339.3500n 0.001151 339.3600n 0.001368 339.3700n 0.001568 339.3800n 0.001747 339.3900n 0.001902 339.4000n 0.002031 339.4100n 0.002131 339.4200n 0.002202 339.4300n 0.002242 339.4400n 0.002250
+ 339.4500n 0.002228 339.4600n 0.002175 339.4700n 0.002094 339.4800n 0.001986 339.4900n 0.001854 339.5000n 0.001701 339.5100n 0.001530 339.5200n 0.001344 339.5300n 0.001149 339.5400n 0.000947 339.5500n 0.000744 339.5600n 0.000543 339.5700n 0.000348 339.5800n 0.000164 339.5900n -0.000006
+ 339.6000n -0.000158 339.6100n -0.000290 339.6200n -0.000398 339.6300n -0.000482 339.6400n -0.000540 339.6500n -0.000571 339.6600n -0.000574 339.6700n -0.000551 339.6800n -0.000502 339.6900n -0.000430 339.7000n -0.000335 339.7100n -0.000221 339.7200n -0.000092 339.7300n 0.000050 339.7400n 0.000200
+ 339.7500n 0.000356 339.7600n 0.000511 339.7700n 0.000663 339.7800n 0.000807 339.7900n 0.000939 339.8000n 0.001055 339.8100n 0.001153 339.8200n 0.001228 339.8300n 0.001278 339.8400n 0.001302 339.8500n 0.001297 339.8600n 0.001262 339.8700n 0.001197 339.8800n 0.001103 339.8900n 0.000980
+ 339.9000n 0.000829 339.9100n 0.000652 339.9200n 0.000452 339.9300n 0.000232 339.9400n -0.000006 339.9500n -0.000256 339.9600n -0.000517 339.9700n -0.000783 339.9800n -0.001050 339.9900n -0.001314 340.0000n -0.001571 340.0100n -0.001818 340.0200n -0.002050 340.0300n -0.002264 340.0400n -0.002456
+ 340.0500n -0.002625 340.0600n -0.002768 340.0700n -0.002883 340.0800n -0.002969 340.0900n -0.003025 340.1000n -0.003052 340.1100n -0.003048 340.1200n -0.003017 340.1300n -0.002958 340.1400n -0.002873 340.1500n -0.002765 340.1600n -0.002636 340.1700n -0.002489 340.1800n -0.002327 340.1900n -0.002152
+ 340.2000n -0.001969 340.2100n -0.001780 340.2200n -0.001588 340.2300n -0.001396 340.2400n -0.001208 340.2500n -0.001025 340.2600n -0.000851 340.2700n -0.000687 340.2800n -0.000535 340.2900n -0.000396 340.3000n -0.000272 340.3100n -0.000162 340.3200n -0.000068 340.3300n 0.000010 340.3400n 0.000074
+ 340.3500n 0.000124 340.3600n 0.000160 340.3700n 0.000184 340.3800n 0.000197 340.3900n 0.000201 340.4000n 0.000197 340.4100n 0.000186 340.4200n 0.000171 340.4300n 0.000153 340.4400n 0.000134 340.4500n 0.000114 340.4600n 0.000096 340.4700n 0.000079 340.4800n 0.000065 340.4900n 0.000055
+ 340.5000n 0.000049 340.5100n 0.000047 340.5200n 0.000049 340.5300n 0.000056 340.5400n 0.000066 340.5500n 0.000079 340.5600n 0.000094 340.5700n 0.000111 340.5800n 0.000129 340.5900n 0.000147 340.6000n 0.000163 340.6100n 0.000178 340.6200n 0.000190 340.6300n 0.000198 340.6400n 0.000202
+ 340.6500n 0.000201 340.6600n 0.000195 340.6700n 0.000183 340.6800n 0.000166 340.6900n 0.000143 340.7000n 0.000114 340.7100n 0.000081 340.7200n 0.000043 340.7300n 0.000001 340.7400n -0.000045 340.7500n -0.000092 340.7600n -0.000142 340.7700n -0.000191 340.7800n -0.000241 340.7900n -0.000289
+ 340.8000n -0.000335 340.8100n -0.000378 340.8200n -0.000418 340.8300n -0.000453 340.8400n -0.000483 340.8500n -0.000508 340.8600n -0.000528 340.8700n -0.000543 340.8800n -0.000553 340.8900n -0.000557 340.9000n -0.000557 340.9100n -0.000553 340.9200n -0.000545 340.9300n -0.000534 340.9400n -0.000522
+ 340.9500n -0.000508 340.9600n -0.000494 340.9700n -0.000480 340.9800n -0.000468 340.9900n -0.000457 341.0000n -0.000449 341.0100n -0.000444 341.0200n -0.000442 341.0300n -0.000444 341.0400n -0.000450 341.0500n -0.000459 341.0600n -0.000472 341.0700n -0.000489 341.0800n -0.000508 341.0900n -0.000529
+ 341.1000n -0.000551 341.1100n -0.000574 341.1200n -0.000597 341.1300n -0.000618 341.1400n -0.000637 341.1500n -0.000652 341.1600n -0.000663 341.1700n -0.000669 341.1800n -0.000669 341.1900n -0.000662 341.2000n -0.000648 341.2100n -0.000626 341.2200n -0.000597 341.2300n -0.000559 341.2400n -0.000513
+ 341.2500n -0.000461 341.2600n -0.000401 341.2700n -0.000335 341.2800n -0.000264 341.2900n -0.000189 341.3000n -0.000111 341.3100n -0.000031 341.3200n 0.000049 341.3300n 0.000127 341.3400n 0.000202 341.3500n 0.000272 341.3600n 0.000336 341.3700n 0.000393 341.3800n 0.000440 341.3900n 0.000478
+ 341.4000n 0.000503 341.4100n 0.000517 341.4200n 0.000517 341.4300n 0.000504 341.4400n 0.000477 341.4500n 0.000436 341.4600n 0.000382 341.4700n 0.000314 341.4800n 0.000233 341.4900n 0.000140 341.5000n 0.000037 341.5100n -0.000076 341.5200n -0.000197 341.5300n -0.000325 341.5400n -0.000457
+ 341.5500n -0.000593 341.5600n -0.000731 341.5700n -0.000868 341.5800n -0.001003 341.5900n -0.001134 341.6000n -0.001260 341.6100n -0.001379 341.6200n -0.001490 341.6300n -0.001590 341.6400n -0.001681 341.6500n -0.001759 341.6600n -0.001825 341.6700n -0.001877 341.6800n -0.001916 341.6900n -0.001941
+ 341.7000n -0.001953 341.7100n -0.001950 341.7200n -0.001934 341.7300n -0.001905 341.7400n -0.001864 341.7500n -0.001811 341.7600n -0.001746 341.7700n -0.001672 341.7800n -0.001588 341.7900n -0.001496 341.8000n -0.001396 341.8100n -0.001291 341.8200n -0.001180 341.8300n -0.001064 341.8400n -0.000946
+ 341.8500n -0.000825 341.8600n -0.000703 341.8700n -0.000580 341.8800n -0.000459 341.8900n -0.000338 341.9000n -0.000220 341.9100n -0.000105 341.9200n 0.000006 341.9300n 0.000112 341.9400n 0.000213 341.9500n 0.000307 341.9600n 0.000395 341.9700n 0.000474 341.9800n 0.000545 341.9900n 0.000607
+ 342.0000n 0.000660 342.0100n 0.000701 342.0200n 0.000732 342.0300n 0.000751 342.0400n 0.000759 342.0500n 0.000754 342.0600n 0.000736 342.0700n 0.000706 342.0800n 0.000663 342.0900n 0.000607 342.1000n 0.000539 342.1100n 0.000458 342.1200n 0.000366 342.1300n 0.000263 342.1400n 0.000150
+ 342.1500n 0.000028 342.1600n -0.000101 342.1700n -0.000237 342.1800n -0.000378 342.1900n -0.000521 342.2000n -0.000666 342.2100n -0.000811 342.2200n -0.000953 342.2300n -0.001091 342.2400n -0.001222 342.2500n -0.001345 342.2600n -0.001458 342.2700n -0.001558 342.2800n -0.001646 342.2900n -0.001719
+ 342.3000n -0.001775 342.3100n -0.001815 342.3200n -0.001837 342.3300n -0.001841 342.3400n -0.001827 342.3500n -0.001794 342.3600n -0.001745 342.3700n -0.001679 342.3800n -0.001597 342.3900n -0.001501 342.4000n -0.001394 342.4100n -0.001276 342.4200n -0.001150 342.4300n -0.001018 342.4400n -0.000884
+ 342.4500n -0.000748 342.4600n -0.000615 342.4700n -0.000486 342.4800n -0.000364 342.4900n -0.000252 342.5000n -0.000152 342.5100n -0.000065 342.5200n 0.000007 342.5300n 0.000061 342.5400n 0.000098 342.5500n 0.000117 342.5600n 0.000116 342.5700n 0.000097 342.5800n 0.000060 342.5900n 0.000005
+ 342.6000n -0.000065 342.6100n -0.000150 342.6200n -0.000248 342.6300n -0.000356 342.6400n -0.000471 342.6500n -0.000592 342.6600n -0.000715 342.6700n -0.000837 342.6800n -0.000955 342.6900n -0.001067 342.7000n -0.001170 342.7100n -0.001261 342.7200n -0.001337 342.7300n -0.001397 342.7400n -0.001439
+ 342.7500n -0.001461 342.7600n -0.001463 342.7700n -0.001443 342.7800n -0.001402 342.7900n -0.001340 342.8000n -0.001257 342.8100n -0.001155 342.8200n -0.001035 342.8300n -0.000900 342.8400n -0.000751 342.8500n -0.000590 342.8600n -0.000422 342.8700n -0.000248 342.8800n -0.000071 342.8900n 0.000104
+ 342.9000n 0.000276 342.9100n 0.000441 342.9200n 0.000597 342.9300n 0.000741 342.9400n 0.000870 342.9500n 0.000982 342.9600n 0.001077 342.9700n 0.001152 342.9800n 0.001208 342.9900n 0.001243 343.0000n 0.001257 343.0100n 0.001252 343.0200n 0.001229 343.0300n 0.001187 343.0400n 0.001131
+ 343.0500n 0.001061 343.0600n 0.000979 343.0700n 0.000890 343.0800n 0.000794 343.0900n 0.000696 343.1000n 0.000598 343.1100n 0.000503 343.1200n 0.000414 343.1300n 0.000334 343.1400n 0.000265 343.1500n 0.000208 343.1600n 0.000167 343.1700n 0.000142 343.1800n 0.000135 343.1900n 0.000146
+ 343.2000n 0.000175 343.2100n 0.000223 343.2200n 0.000287 343.2300n 0.000369 343.2400n 0.000465 343.2500n 0.000573 343.2600n 0.000693 343.2700n 0.000821 343.2800n 0.000955 343.2900n 0.001092 343.3000n 0.001228 343.3100n 0.001362 343.3200n 0.001490 343.3300n 0.001610 343.3400n 0.001718
+ 343.3500n 0.001813 343.3600n 0.001892 343.3700n 0.001953 343.3800n 0.001996 343.3900n 0.002019 343.4000n 0.002022 343.4100n 0.002004 343.4200n 0.001966 343.4300n 0.001907 343.4400n 0.001830 343.4500n 0.001736 343.4600n 0.001626 343.4700n 0.001502 343.4800n 0.001367 343.4900n 0.001223
+ 343.5000n 0.001072 343.5100n 0.000917 343.5200n 0.000761 343.5300n 0.000606 343.5400n 0.000455 343.5500n 0.000309 343.5600n 0.000171 343.5700n 0.000043 343.5800n -0.000075 343.5900n -0.000180 343.6000n -0.000273 343.6100n -0.000352 343.6200n -0.000418 343.6300n -0.000471 343.6400n -0.000512
+ 343.6500n -0.000542 343.6600n -0.000562 343.6700n -0.000573 343.6800n -0.000578 343.6900n -0.000578 343.7000n -0.000576 343.7100n -0.000572 343.7200n -0.000570 343.7300n -0.000572 343.7400n -0.000578 343.7500n -0.000592 343.7600n -0.000613 343.7700n -0.000644 343.7800n -0.000686 343.7900n -0.000738
+ 343.8000n -0.000801 343.8100n -0.000876 343.8200n -0.000961 343.8300n -0.001056 343.8400n -0.001160 343.8500n -0.001271 343.8600n -0.001387 343.8700n -0.001507 343.8800n -0.001629 343.8900n -0.001750 343.9000n -0.001868 343.9100n -0.001981 343.9200n -0.002086 343.9300n -0.002181 343.9400n -0.002264
+ 343.9500n -0.002333 343.9600n -0.002386 343.9700n -0.002422 343.9800n -0.002440 343.9900n -0.002439 344.0000n -0.002418 344.0100n -0.002378 344.0200n -0.002318 344.0300n -0.002240 344.0400n -0.002144 344.0500n -0.002031 344.0600n -0.001903 344.0700n -0.001762 344.0800n -0.001611 344.0900n -0.001450
+ 344.1000n -0.001283 344.1100n -0.001112 344.1200n -0.000939 344.1300n -0.000767 344.1400n -0.000598 344.1500n -0.000434 344.1600n -0.000278 344.1700n -0.000130 344.1800n 0.000007 344.1900n 0.000131 344.2000n 0.000243 344.2100n 0.000341 344.2200n 0.000425 344.2300n 0.000495 344.2400n 0.000551
+ 344.2500n 0.000593 344.2600n 0.000622 344.2700n 0.000639 344.2800n 0.000645 344.2900n 0.000642 344.3000n 0.000629 344.3100n 0.000610 344.3200n 0.000585 344.3300n 0.000555 344.3400n 0.000522 344.3500n 0.000487 344.3600n 0.000451 344.3700n 0.000415 344.3800n 0.000379 344.3900n 0.000344
+ 344.4000n 0.000310 344.4100n 0.000278 344.4200n 0.000246 344.4300n 0.000215 344.4400n 0.000183 344.4500n 0.000151 344.4600n 0.000116 344.4700n 0.000080 344.4800n 0.000039 344.4900n -0.000007 344.5000n -0.000059 344.5100n -0.000117 344.5200n -0.000184 344.5300n -0.000259 344.5400n -0.000344
+ 344.5500n -0.000437 344.5600n -0.000541 344.5700n -0.000654 344.5800n -0.000776 344.5900n -0.000906 344.6000n -0.001044 344.6100n -0.001188 344.6200n -0.001336 344.6300n -0.001488 344.6400n -0.001640 344.6500n -0.001791 344.6600n -0.001939 344.6700n -0.002080 344.6800n -0.002214 344.6900n -0.002336
+ 344.7000n -0.002446 344.7100n -0.002541 344.7200n -0.002619 344.7300n -0.002678 344.7400n -0.002717 344.7500n -0.002734 344.7600n -0.002729 344.7700n -0.002701 344.7800n -0.002649 344.7900n -0.002575 344.8000n -0.002479 344.8100n -0.002362 344.8200n -0.002225 344.8300n -0.002070 344.8400n -0.001899
+ 344.8500n -0.001715 344.8600n -0.001520 344.8700n -0.001317 344.8800n -0.001110 344.8900n -0.000900 344.9000n -0.000691 344.9100n -0.000487 344.9200n -0.000289 344.9300n -0.000102 344.9400n 0.000074 344.9500n 0.000234 344.9600n 0.000378 344.9700n 0.000503 344.9800n 0.000608 344.9900n 0.000693
+ 345.0000n 0.000756 345.0100n 0.000797 345.0200n 0.000818 345.0300n 0.000817 345.0400n 0.000797 345.0500n 0.000758 345.0600n 0.000702 345.0700n 0.000631 345.0800n 0.000547 345.0900n 0.000453 345.1000n 0.000350 345.1100n 0.000240 345.1200n 0.000128 345.1300n 0.000014 345.1400n -0.000099
+ 345.1500n -0.000209 345.1600n -0.000314 345.1700n -0.000412 345.1800n -0.000501 345.1900n -0.000581 345.2000n -0.000650 345.2100n -0.000708 345.2200n -0.000754 345.2300n -0.000789 345.2400n -0.000811 345.2500n -0.000823 345.2600n -0.000824 345.2700n -0.000815 345.2800n -0.000797 345.2900n -0.000772
+ 345.3000n -0.000740 345.3100n -0.000703 345.3200n -0.000662 345.3300n -0.000619 345.3400n -0.000574 345.3500n -0.000529 345.3600n -0.000484 345.3700n -0.000441 345.3800n -0.000400 345.3900n -0.000361 345.4000n -0.000325 345.4100n -0.000292 345.4200n -0.000262 345.4300n -0.000235 345.4400n -0.000210
+ 345.4500n -0.000187 345.4600n -0.000165 345.4700n -0.000144 345.4800n -0.000122 345.4900n -0.000100 345.5000n -0.000077 345.5100n -0.000051 345.5200n -0.000023 345.5300n 0.000008 345.5400n 0.000042 345.5500n 0.000079 345.5600n 0.000120 345.5700n 0.000163 345.5800n 0.000208 345.5900n 0.000256
+ 345.6000n 0.000304 345.6100n 0.000351 345.6200n 0.000397 345.6300n 0.000440 345.6400n 0.000479 345.6500n 0.000513 345.6600n 0.000539 345.6700n 0.000557 345.6800n 0.000565 345.6900n 0.000561 345.7000n 0.000546 345.7100n 0.000517 345.7200n 0.000474 345.7300n 0.000416 345.7400n 0.000345
+ 345.7500n 0.000258 345.7600n 0.000158 345.7700n 0.000044 345.7800n -0.000082 345.7900n -0.000220 345.8000n -0.000366 345.8100n -0.000520 345.8200n -0.000680 345.8300n -0.000843 345.8400n -0.001006 345.8500n -0.001168 345.8600n -0.001325 345.8700n -0.001475 345.8800n -0.001616 345.8900n -0.001745
+ 345.9000n -0.001860 345.9100n -0.001959 345.9200n -0.002041 345.9300n -0.002103 345.9400n -0.002145 345.9500n -0.002166 345.9600n -0.002165 345.9700n -0.002143 345.9800n -0.002100 345.9900n -0.002037 346.0000n -0.001955 346.0100n -0.001855 346.0200n -0.001740 346.0300n -0.001611 346.0400n -0.001470
+ 346.0500n -0.001321 346.0600n -0.001165 346.0700n -0.001006 346.0800n -0.000846 346.0900n -0.000688 346.1000n -0.000534 346.1100n -0.000386 346.1200n -0.000247 346.1300n -0.000118 346.1400n -0.000001 346.1500n 0.000102 346.1600n 0.000192 346.1700n 0.000267 346.1800n 0.000327 346.1900n 0.000373
+ 346.2000n 0.000406 346.2100n 0.000425 346.2200n 0.000433 346.2300n 0.000431 346.2400n 0.000421 346.2500n 0.000404 346.2600n 0.000383 346.2700n 0.000360 346.2800n 0.000337 346.2900n 0.000315 346.3000n 0.000298 346.3100n 0.000286 346.3200n 0.000280 346.3300n 0.000283 346.3400n 0.000295
+ 346.3500n 0.000316 346.3600n 0.000347 346.3700n 0.000387 346.3800n 0.000436 346.3900n 0.000492 346.4000n 0.000555 346.4100n 0.000623 346.4200n 0.000692 346.4300n 0.000762 346.4400n 0.000830 346.4500n 0.000892 346.4600n 0.000947 346.4700n 0.000991 346.4800n 0.001022 346.4900n 0.001036
+ 346.5000n 0.001032 346.5100n 0.001008 346.5200n 0.000961 346.5300n 0.000890 346.5400n 0.000794 346.5500n 0.000672 346.5600n 0.000524 346.5700n 0.000350 346.5800n 0.000152 346.5900n -0.000070 346.6000n -0.000313 346.6100n -0.000575 346.6200n -0.000853 346.6300n -0.001145 346.6400n -0.001446
+ 346.6500n -0.001753 346.6600n -0.002061 346.6700n -0.002368 346.6800n -0.002667 346.6900n -0.002956 346.7000n -0.003229 346.7100n -0.003484 346.7200n -0.003716 346.7300n -0.003921 346.7400n -0.004099 346.7500n -0.004244 346.7600n -0.004356 346.7700n -0.004434 346.7800n -0.004475 346.7900n -0.004481
+ 346.8000n -0.004451 346.8100n -0.004385 346.8200n -0.004287 346.8300n -0.004156 346.8400n -0.003997 346.8500n -0.003811 346.8600n -0.003603 346.8700n -0.003375 346.8800n -0.003131 346.8900n -0.002876 346.9000n -0.002614 346.9100n -0.002348 346.9200n -0.002084 346.9300n -0.001824 346.9400n -0.001572
+ 346.9500n -0.001333 346.9600n -0.001108 346.9700n -0.000902 346.9800n -0.000715 346.9900n -0.000550 347.0000n -0.000409 347.0100n -0.000291 347.0200n -0.000198 347.0300n -0.000129 347.0400n -0.000084 347.0500n -0.000061 347.0600n -0.000059 347.0700n -0.000076 347.0800n -0.000110 347.0900n -0.000159
+ 347.1000n -0.000219 347.1100n -0.000289 347.1200n -0.000364 347.1300n -0.000443 347.1400n -0.000523 347.1500n -0.000601 347.1600n -0.000674 347.1700n -0.000740 347.1800n -0.000797 347.1900n -0.000843 347.2000n -0.000877 347.2100n -0.000898 347.2200n -0.000905 347.2300n -0.000897 347.2400n -0.000875
+ 347.2500n -0.000839 347.2600n -0.000789 347.2700n -0.000727 347.2800n -0.000653 347.2900n -0.000569 347.3000n -0.000477 347.3100n -0.000378 347.3200n -0.000274 347.3300n -0.000167 347.3400n -0.000059 347.3500n 0.000049 347.3600n 0.000155 347.3700n 0.000257 347.3800n 0.000355 347.3900n 0.000445
+ 347.4000n 0.000529 347.4100n 0.000604 347.4200n 0.000671 347.4300n 0.000729 347.4400n 0.000777 347.4500n 0.000817 347.4600n 0.000847 347.4700n 0.000870 347.4800n 0.000885 347.4900n 0.000893 347.5000n 0.000896 347.5100n 0.000893 347.5200n 0.000887 347.5300n 0.000878 347.5400n 0.000867
+ 347.5500n 0.000855 347.5600n 0.000843 347.5700n 0.000832 347.5800n 0.000823 347.5900n 0.000816 347.6000n 0.000811 347.6100n 0.000809 347.6200n 0.000810 347.6300n 0.000813 347.6400n 0.000819 347.6500n 0.000827 347.6600n 0.000837 347.6700n 0.000849 347.6800n 0.000861 347.6900n 0.000873
+ 347.7000n 0.000884 347.7100n 0.000895 347.7200n 0.000903 347.7300n 0.000908 347.7400n 0.000910 347.7500n 0.000909 347.7600n 0.000903 347.7700n 0.000893 347.7800n 0.000878 347.7900n 0.000859 347.8000n 0.000835 347.8100n 0.000807 347.8200n 0.000775 347.8300n 0.000740 347.8400n 0.000701
+ 347.8500n 0.000660 347.8600n 0.000618 347.8700n 0.000574 347.8800n 0.000531 347.8900n 0.000488 347.9000n 0.000446 347.9100n 0.000407 347.9200n 0.000371 347.9300n 0.000337 347.9400n 0.000308 347.9500n 0.000283 347.9600n 0.000263 347.9700n 0.000248 347.9800n 0.000237 347.9900n 0.000231
+ 348.0000n 0.000230 348.0100n 0.000234 348.0200n 0.000241 348.0300n 0.000252 348.0400n 0.000266 348.0500n 0.000282 348.0600n 0.000300 348.0700n 0.000320 348.0800n 0.000340 348.0900n 0.000359 348.1000n 0.000379 348.1100n 0.000397 348.1200n 0.000413 348.1300n 0.000428 348.1400n 0.000440
+ 348.1500n 0.000449 348.1600n 0.000456 348.1700n 0.000461 348.1800n 0.000462 348.1900n 0.000462 348.2000n 0.000459 348.2100n 0.000455 348.2200n 0.000449 348.2300n 0.000441 348.2400n 0.000433 348.2500n 0.000425 348.2600n 0.000417 348.2700n 0.000408 348.2800n 0.000401 348.2900n 0.000394
+ 348.3000n 0.000388 348.3100n 0.000382 348.3200n 0.000378 348.3300n 0.000374 348.3400n 0.000370 348.3500n 0.000366 348.3600n 0.000362 348.3700n 0.000356 348.3800n 0.000348 348.3900n 0.000338 348.4000n 0.000325 348.4100n 0.000308 348.4200n 0.000286 348.4300n 0.000260 348.4400n 0.000227
+ 348.4500n 0.000188 348.4600n 0.000142 348.4700n 0.000090 348.4800n 0.000030 348.4900n -0.000037 348.5000n -0.000111 348.5100n -0.000192 348.5200n -0.000278 348.5300n -0.000370 348.5400n -0.000467 348.5500n -0.000567 348.5600n -0.000669 348.5700n -0.000773 348.5800n -0.000877 348.5900n -0.000979
+ 348.6000n -0.001078 348.6100n -0.001173 348.6200n -0.001262 348.6300n -0.001345 348.6400n -0.001420 348.6500n -0.001485 348.6600n -0.001540 348.6700n -0.001585 348.6800n -0.001619 348.6900n -0.001640 348.7000n -0.001651 348.7100n -0.001649 348.7200n -0.001637 348.7300n -0.001614 348.7400n -0.001581
+ 348.7500n -0.001540 348.7600n -0.001491 348.7700n -0.001435 348.7800n -0.001375 348.7900n -0.001311 348.8000n -0.001245 348.8100n -0.001178 348.8200n -0.001112 348.8300n -0.001049 348.8400n -0.000989 348.8500n -0.000933 348.8600n -0.000883 348.8700n -0.000839 348.8800n -0.000801 348.8900n -0.000770
+ 348.9000n -0.000745 348.9100n -0.000726 348.9200n -0.000713 348.9300n -0.000705 348.9400n -0.000700 348.9500n -0.000698 348.9600n -0.000696 348.9700n -0.000695 348.9800n -0.000691 348.9900n -0.000683 349.0000n -0.000670 349.0100n -0.000650 349.0200n -0.000621 349.0300n -0.000583 349.0400n -0.000534
+ 349.0500n -0.000474 349.0600n -0.000401 349.0700n -0.000317 349.0800n -0.000220 349.0900n -0.000112 349.1000n 0.000007 349.1100n 0.000135 349.1200n 0.000271 349.1300n 0.000413 349.1400n 0.000559 349.1500n 0.000705 349.1600n 0.000850 349.1700n 0.000991 349.1800n 0.001124 349.1900n 0.001247
+ 349.2000n 0.001357 349.2100n 0.001450 349.2200n 0.001525 349.2300n 0.001578 349.2400n 0.001608 349.2500n 0.001612 349.2600n 0.001590 349.2700n 0.001541 349.2800n 0.001463 349.2900n 0.001358 349.3000n 0.001225 349.3100n 0.001067 349.3200n 0.000884 349.3300n 0.000680 349.3400n 0.000457
+ 349.3500n 0.000218 349.3600n -0.000033 349.3700n -0.000293 349.3800n -0.000556 349.3900n -0.000819 349.4000n -0.001078 349.4100n -0.001327 349.4200n -0.001563 349.4300n -0.001781 349.4400n -0.001977 349.4500n -0.002149 349.4600n -0.002292 349.4700n -0.002404 349.4800n -0.002483 349.4900n -0.002528
+ 349.5000n -0.002539 349.5100n -0.002514 349.5200n -0.002455 349.5300n -0.002363 349.5400n -0.002240 349.5500n -0.002088 349.5600n -0.001911 349.5700n -0.001713 349.5800n -0.001498 349.5900n -0.001270 349.6000n -0.001035 349.6100n -0.000797 349.6200n -0.000561 349.6300n -0.000332 349.6400n -0.000116
+ 349.6500n 0.000083 349.6600n 0.000260 349.6700n 0.000412 349.6800n 0.000535 349.6900n 0.000627 349.7000n 0.000684 349.7100n 0.000707 349.7200n 0.000694 349.7300n 0.000645 349.7400n 0.000561 349.7500n 0.000443 349.7600n 0.000295 349.7700n 0.000118 349.7800n -0.000083 349.7900n -0.000303
+ 349.8000n -0.000540 349.8100n -0.000787 349.8200n -0.001039 349.8300n -0.001291 349.8400n -0.001537 349.8500n -0.001772 349.8600n -0.001991 349.8700n -0.002188 349.8800n -0.002359 349.8900n -0.002499 349.9000n -0.002607 349.9100n -0.002678 349.9200n -0.002710 349.9300n -0.002702 349.9400n -0.002653
+ 349.9500n -0.002564 349.9600n -0.002436 349.9700n -0.002270 349.9800n -0.002068 349.9900n -0.001835 350.0000n -0.001573 350.0100n -0.001287 350.0200n -0.000982 350.0300n -0.000663 350.0400n -0.000336 350.0500n -0.000006 350.0600n 0.000321 350.0700n 0.000640 350.0800n 0.000945 350.0900n 0.001232
+ 350.1000n 0.001495 350.1100n 0.001730 350.1200n 0.001934 350.1300n 0.002103 350.1400n 0.002235 350.1500n 0.002329 350.1600n 0.002383 350.1700n 0.002397 350.1800n 0.002372 350.1900n 0.002308 350.2000n 0.002209 350.2100n 0.002075 350.2200n 0.001912 350.2300n 0.001721 350.2400n 0.001507
+ 350.2500n 0.001275 350.2600n 0.001028 350.2700n 0.000772 350.2800n 0.000512 350.2900n 0.000251 350.3000n -0.000004 350.3100n -0.000251 350.3200n -0.000484 350.3300n -0.000701 350.3400n -0.000897 350.3500n -0.001071 350.3600n -0.001219 350.3700n -0.001341 350.3800n -0.001435 350.3900n -0.001500
+ 350.4000n -0.001536 350.4100n -0.001545 350.4200n -0.001526 350.4300n -0.001481 350.4400n -0.001413 350.4500n -0.001323 350.4600n -0.001214 350.4700n -0.001089 350.4800n -0.000950 350.4900n -0.000800 350.5000n -0.000643 350.5100n -0.000481 350.5200n -0.000317 350.5300n -0.000153 350.5400n 0.000008
+ 350.5500n 0.000164 350.5600n 0.000313 350.5700n 0.000453 350.5800n 0.000584 350.5900n 0.000704 350.6000n 0.000813 350.6100n 0.000910 350.6200n 0.000997 350.6300n 0.001072 350.6400n 0.001137 350.6500n 0.001192 350.6600n 0.001238 350.6700n 0.001276 350.6800n 0.001308 350.6900n 0.001334
+ 350.7000n 0.001355 350.7100n 0.001373 350.7200n 0.001388 350.7300n 0.001402 350.7400n 0.001414 350.7500n 0.001425 350.7600n 0.001436 350.7700n 0.001447 350.7800n 0.001458 350.7900n 0.001468 350.8000n 0.001476 350.8100n 0.001484 350.8200n 0.001489 350.8300n 0.001491 350.8400n 0.001490
+ 350.8500n 0.001483 350.8600n 0.001471 350.8700n 0.001453 350.8800n 0.001427 350.8900n 0.001394 350.9000n 0.001353 350.9100n 0.001303 350.9200n 0.001244 350.9300n 0.001176 350.9400n 0.001100 350.9500n 0.001015 350.9600n 0.000923 350.9700n 0.000825 350.9800n 0.000721 350.9900n 0.000612
+ 351.0000n 0.000500 351.0100n 0.000386 351.0200n 0.000271 351.0300n 0.000158 351.0400n 0.000047 351.0500n -0.000060 351.0600n -0.000162 351.0700n -0.000258 351.0800n -0.000346 351.0900n -0.000426 351.1000n -0.000497 351.1100n -0.000559 351.1200n -0.000611 351.1300n -0.000654 351.1400n -0.000687
+ 351.1500n -0.000712 351.1600n -0.000729 351.1700n -0.000738 351.1800n -0.000741 351.1900n -0.000739 351.2000n -0.000733 351.2100n -0.000725 351.2200n -0.000716 351.2300n -0.000707 351.2400n -0.000699 351.2500n -0.000694 351.2600n -0.000692 351.2700n -0.000695 351.2800n -0.000702 351.2900n -0.000715
+ 351.3000n -0.000732 351.3100n -0.000755 351.3200n -0.000783 351.3300n -0.000814 351.3400n -0.000849 351.3500n -0.000885 351.3600n -0.000921 351.3700n -0.000957 351.3800n -0.000990 351.3900n -0.001018 351.4000n -0.001040 351.4100n -0.001053 351.4200n -0.001058 351.4300n -0.001050 351.4400n -0.001031
+ 351.4500n -0.000997 351.4600n -0.000950 351.4700n -0.000887 351.4800n -0.000809 351.4900n -0.000715 351.5000n -0.000608 351.5100n -0.000487 351.5200n -0.000353 351.5300n -0.000209 351.5400n -0.000057 351.5500n 0.000101 351.5600n 0.000263 351.5700n 0.000425 351.5800n 0.000584 351.5900n 0.000738
+ 351.6000n 0.000883 351.6100n 0.001015 351.6200n 0.001133 351.6300n 0.001232 351.6400n 0.001311 351.6500n 0.001367 351.6600n 0.001399 351.6700n 0.001404 351.6800n 0.001381 351.6900n 0.001331 351.7000n 0.001253 351.7100n 0.001148 351.7200n 0.001016 351.7300n 0.000860 351.7400n 0.000682
+ 351.7500n 0.000485 351.7600n 0.000271 351.7700n 0.000044 351.7800n -0.000192 351.7900n -0.000433 351.8000n -0.000675 351.8100n -0.000912 351.8200n -0.001143 351.8300n -0.001360 351.8400n -0.001562 351.8500n -0.001744 351.8600n -0.001902 351.8700n -0.002033 351.8800n -0.002136 351.8900n -0.002207
+ 351.9000n -0.002246 351.9100n -0.002251 351.9200n -0.002223 351.9300n -0.002162 351.9400n -0.002069 351.9500n -0.001946 351.9600n -0.001795 351.9700n -0.001619 351.9800n -0.001421 351.9900n -0.001205 352.0000n -0.000974 352.0100n -0.000734 352.0200n -0.000488 352.0300n -0.000241 352.0400n 0.000002
+ 352.0500n 0.000238 352.0600n 0.000462 352.0700n 0.000671 352.0800n 0.000861 352.0900n 0.001029 352.1000n 0.001173 352.1100n 0.001290 352.1200n 0.001380 352.1300n 0.001441 352.1400n 0.001474 352.1500n 0.001479 352.1600n 0.001456 352.1700n 0.001409 352.1800n 0.001338 352.1900n 0.001246
+ 352.2000n 0.001136 352.2100n 0.001011 352.2200n 0.000875 352.2300n 0.000731 352.2400n 0.000582 352.2500n 0.000433 352.2600n 0.000286 352.2700n 0.000145 352.2800n 0.000013 352.2900n -0.000108 352.3000n -0.000215 352.3100n -0.000307 352.3200n -0.000383 352.3300n -0.000441 352.3400n -0.000481
+ 352.3500n -0.000505 352.3600n -0.000512 352.3700n -0.000504 352.3800n -0.000482 352.3900n -0.000448 352.4000n -0.000405 352.4100n -0.000355 352.4200n -0.000302 352.4300n -0.000247 352.4400n -0.000193 352.4500n -0.000144 352.4600n -0.000101 352.4700n -0.000068 352.4800n -0.000046 352.4900n -0.000036
+ 352.5000n -0.000040 352.5100n -0.000059 352.5200n -0.000093 352.5300n -0.000142 352.5400n -0.000204 352.5500n -0.000279 352.5600n -0.000365 352.5700n -0.000460 352.5800n -0.000561 352.5900n -0.000665 352.6000n -0.000769 352.6100n -0.000870 352.6200n -0.000964 352.6300n -0.001048 352.6400n -0.001118
+ 352.6500n -0.001171 352.6600n -0.001204 352.6700n -0.001215 352.6800n -0.001200 352.6900n -0.001159 352.7000n -0.001090 352.7100n -0.000992 352.7200n -0.000865 352.7300n -0.000710 352.7400n -0.000528 352.7500n -0.000321 352.7600n -0.000092 352.7700n 0.000158 352.7800n 0.000424 352.7900n 0.000702
+ 352.8000n 0.000988 352.8100n 0.001277 352.8200n 0.001566 352.8300n 0.001848 352.8400n 0.002118 352.8500n 0.002373 352.8600n 0.002608 352.8700n 0.002818 352.8800n 0.002999 352.8900n 0.003149 352.9000n 0.003264 352.9100n 0.003343 352.9200n 0.003384 352.9300n 0.003386 352.9400n 0.003349
+ 352.9500n 0.003275 352.9600n 0.003165 352.9700n 0.003020 352.9800n 0.002844 352.9900n 0.002641 353.0000n 0.002414 353.0100n 0.002169 353.0200n 0.001908 353.0300n 0.001639 353.0400n 0.001366 353.0500n 0.001094 353.0600n 0.000829 353.0700n 0.000576 353.0800n 0.000339 353.0900n 0.000123
+ 353.1000n -0.000068 353.1100n -0.000232 353.1200n -0.000364 353.1300n -0.000465 353.1400n -0.000531 353.1500n -0.000563 353.1600n -0.000560 353.1700n -0.000525 353.1800n -0.000459 353.1900n -0.000363 353.2000n -0.000242 353.2100n -0.000099 353.2200n 0.000062 353.2300n 0.000236 353.2400n 0.000419
+ 353.2500n 0.000605 353.2600n 0.000789 353.2700n 0.000967 353.2800n 0.001133 353.2900n 0.001282 353.3000n 0.001411 353.3100n 0.001515 353.3200n 0.001590 353.3300n 0.001636 353.3400n 0.001648 353.3500n 0.001626 353.3600n 0.001569 353.3700n 0.001477 353.3800n 0.001352 353.3900n 0.001194
+ 353.4000n 0.001007 353.4100n 0.000792 353.4200n 0.000555 353.4300n 0.000298 353.4400n 0.000027 353.4500n -0.000254 353.4600n -0.000539 353.4700n -0.000824 353.4800n -0.001102 353.4900n -0.001369 353.5000n -0.001620 353.5100n -0.001850 353.5200n -0.002054 353.5300n -0.002229 353.5400n -0.002371
+ 353.5500n -0.002478 353.5600n -0.002547 353.5700n -0.002577 353.5800n -0.002567 353.5900n -0.002518 353.6000n -0.002430 353.6100n -0.002305 353.6200n -0.002144 353.6300n -0.001951 353.6400n -0.001728 353.6500n -0.001480 353.6600n -0.001211 353.6700n -0.000925 353.6800n -0.000626 353.6900n -0.000321
+ 353.7000n -0.000013 353.7100n 0.000293 353.7200n 0.000591 353.7300n 0.000878 353.7400n 0.001149 353.7500n 0.001401 353.7600n 0.001630 353.7700n 0.001834 353.7800n 0.002010 353.7900n 0.002157 353.8000n 0.002274 353.8100n 0.002360 353.8200n 0.002416 353.8300n 0.002442 353.8400n 0.002440
+ 353.8500n 0.002411 353.8600n 0.002357 353.8700n 0.002282 353.8800n 0.002188 353.8900n 0.002078 353.9000n 0.001955 353.9100n 0.001824 353.9200n 0.001688 353.9300n 0.001550 353.9400n 0.001413 353.9500n 0.001280 353.9600n 0.001156 353.9700n 0.001041 353.9800n 0.000939 353.9900n 0.000851
+ 354.0000n 0.000778 354.0100n 0.000723 354.0200n 0.000684 354.0300n 0.000663 354.0400n 0.000660 354.0500n 0.000672 354.0600n 0.000700 354.0700n 0.000741 354.0800n 0.000794 354.0900n 0.000857 354.1000n 0.000928 354.1100n 0.001004 354.1200n 0.001082 354.1300n 0.001161 354.1400n 0.001236
+ 354.1500n 0.001306 354.1600n 0.001369 354.1700n 0.001421 354.1800n 0.001461 354.1900n 0.001487 354.2000n 0.001497 354.2100n 0.001490 354.2200n 0.001465 354.2300n 0.001421 354.2400n 0.001359 354.2500n 0.001277 354.2600n 0.001176 354.2700n 0.001057 354.2800n 0.000921 354.2900n 0.000768
+ 354.3000n 0.000602 354.3100n 0.000422 354.3200n 0.000231 354.3300n 0.000032 354.3400n -0.000175 354.3500n -0.000386 354.3600n -0.000599 354.3700n -0.000813 354.3800n -0.001025 354.3900n -0.001232 354.4000n -0.001433 354.4100n -0.001626 354.4200n -0.001809 354.4300n -0.001981 354.4400n -0.002139
+ 354.4500n -0.002283 354.4600n -0.002412 354.4700n -0.002525 354.4800n -0.002620 354.4900n -0.002699 354.5000n -0.002760 354.5100n -0.002804 354.5200n -0.002831 354.5300n -0.002841 354.5400n -0.002835 354.5500n -0.002813 354.5600n -0.002777 354.5700n -0.002727 354.5800n -0.002664 354.5900n -0.002589
+ 354.6000n -0.002505 354.6100n -0.002411 354.6200n -0.002309 354.6300n -0.002202 354.6400n -0.002089 354.6500n -0.001972 354.6600n -0.001852 354.6700n -0.001732 354.6800n -0.001611 354.6900n -0.001492 354.7000n -0.001374 354.7100n -0.001260 354.7200n -0.001149 354.7300n -0.001044 354.7400n -0.000943
+ 354.7500n -0.000849 354.7600n -0.000761 354.7700n -0.000680 354.7800n -0.000606 354.7900n -0.000539 354.8000n -0.000478 354.8100n -0.000425 354.8200n -0.000377 354.8300n -0.000336 354.8400n -0.000300 354.8500n -0.000270 354.8600n -0.000243 354.8700n -0.000219 354.8800n -0.000199 354.8900n -0.000179
+ 354.9000n -0.000161 354.9100n -0.000142 354.9200n -0.000122 354.9300n -0.000099 354.9400n -0.000074 354.9500n -0.000045 354.9600n -0.000011 354.9700n 0.000029 354.9800n 0.000074 354.9900n 0.000126 355.0000n 0.000185 355.0100n 0.000251 355.0200n 0.000324 355.0300n 0.000404 355.0400n 0.000491
+ 355.0500n 0.000584 355.0600n 0.000682 355.0700n 0.000786 355.0800n 0.000894 355.0900n 0.001005 355.1000n 0.001119 355.1100n 0.001233 355.1200n 0.001348 355.1300n 0.001461 355.1400n 0.001571 355.1500n 0.001678 355.1600n 0.001779 355.1700n 0.001875 355.1800n 0.001962 355.1900n 0.002042
+ 355.2000n 0.002112 355.2100n 0.002172 355.2200n 0.002222 355.2300n 0.002260 355.2400n 0.002288 355.2500n 0.002305 355.2600n 0.002311 355.2700n 0.002306 355.2800n 0.002292 355.2900n 0.002268 355.3000n 0.002236 355.3100n 0.002197 355.3200n 0.002152 355.3300n 0.002101 355.3400n 0.002048
+ 355.3500n 0.001991 355.3600n 0.001934 355.3700n 0.001877 355.3800n 0.001822 355.3900n 0.001769 355.4000n 0.001720 355.4100n 0.001675 355.4200n 0.001636 355.4300n 0.001602 355.4400n 0.001574 355.4500n 0.001553 355.4600n 0.001537 355.4700n 0.001527 355.4800n 0.001523 355.4900n 0.001523
+ 355.5000n 0.001526 355.5100n 0.001532 355.5200n 0.001539 355.5300n 0.001546 355.5400n 0.001552 355.5500n 0.001556 355.5600n 0.001555 355.5700n 0.001548 355.5800n 0.001535 355.5900n 0.001514 355.6000n 0.001484 355.6100n 0.001443 355.6200n 0.001393 355.6300n 0.001331 355.6400n 0.001258
+ 355.6500n 0.001174 355.6600n 0.001079 355.6700n 0.000974 355.6800n 0.000859 355.6900n 0.000737 355.7000n 0.000608 355.7100n 0.000473 355.7200n 0.000336 355.7300n 0.000197 355.7400n 0.000059 355.7500n -0.000076 355.7600n -0.000205 355.7700n -0.000326 355.7800n -0.000438 355.7900n -0.000538
+ 355.8000n -0.000623 355.8100n -0.000693 355.8200n -0.000745 355.8300n -0.000778 355.8400n -0.000791 355.8500n -0.000784 355.8600n -0.000755 355.8700n -0.000705 355.8800n -0.000634 355.8900n -0.000542 355.9000n -0.000432 355.9100n -0.000303 355.9200n -0.000158 355.9300n 0.000001 355.9400n 0.000173
+ 355.9500n 0.000354 355.9600n 0.000543 355.9700n 0.000736 355.9800n 0.000930 355.9900n 0.001123 356.0000n 0.001312 356.0100n 0.001494 356.0200n 0.001666 356.0300n 0.001826 356.0400n 0.001971 356.0500n 0.002099 356.0600n 0.002208 356.0700n 0.002296 356.0800n 0.002363 356.0900n 0.002407
+ 356.1000n 0.002428 356.1100n 0.002425 356.1200n 0.002398 356.1300n 0.002349 356.1400n 0.002277 356.1500n 0.002183 356.1600n 0.002069 356.1700n 0.001937 356.1800n 0.001788 356.1900n 0.001623 356.2000n 0.001447 356.2100n 0.001259 356.2200n 0.001063 356.2300n 0.000861 356.2400n 0.000655
+ 356.2500n 0.000448 356.2600n 0.000241 356.2700n 0.000038 356.2800n -0.000161 356.2900n -0.000354 356.3000n -0.000538 356.3100n -0.000712 356.3200n -0.000875 356.3300n -0.001026 356.3400n -0.001163 356.3500n -0.001286 356.3600n -0.001395 356.3700n -0.001488 356.3800n -0.001566 356.3900n -0.001629
+ 356.4000n -0.001675 356.4100n -0.001706 356.4200n -0.001722 356.4300n -0.001722 356.4400n -0.001708 356.4500n -0.001679 356.4600n -0.001636 356.4700n -0.001579 356.4800n -0.001510 356.4900n -0.001428 356.5000n -0.001334 356.5100n -0.001229 356.5200n -0.001114 356.5300n -0.000990 356.5400n -0.000856
+ 356.5500n -0.000715 356.5600n -0.000567 356.5700n -0.000412 356.5800n -0.000253 356.5900n -0.000091 356.6000n 0.000074 356.6100n 0.000240 356.6200n 0.000405 356.6300n 0.000568 356.6400n 0.000728 356.6500n 0.000882 356.6600n 0.001029 356.6700n 0.001167 356.6800n 0.001294 356.6900n 0.001409
+ 356.7000n 0.001511 356.7100n 0.001597 356.7200n 0.001666 356.7300n 0.001717 356.7400n 0.001749 356.7500n 0.001761 356.7600n 0.001752 356.7700n 0.001722 356.7800n 0.001671 356.7900n 0.001599 356.8000n 0.001507 356.8100n 0.001395 356.8200n 0.001266 356.8300n 0.001121 356.8400n 0.000960
+ 356.8500n 0.000788 356.8600n 0.000607 356.8700n 0.000418 356.8800n 0.000226 356.8900n 0.000033 356.9000n -0.000158 356.9100n -0.000342 356.9200n -0.000516 356.9300n -0.000678 356.9400n -0.000824 356.9500n -0.000951 356.9600n -0.001056 356.9700n -0.001136 356.9800n -0.001190 356.9900n -0.001215
+ 357.0000n -0.001210 357.0100n -0.001175 357.0200n -0.001109 357.0300n -0.001011 357.0400n -0.000884 357.0500n -0.000727 357.0600n -0.000543 357.0700n -0.000334 357.0800n -0.000102 357.0900n 0.000149 357.1000n 0.000415 357.1100n 0.000693 357.1200n 0.000979 357.1300n 0.001269 357.1400n 0.001557
+ 357.1500n 0.001840 357.1600n 0.002112 357.1700n 0.002370 357.1800n 0.002609 357.1900n 0.002825 357.2000n 0.003015 357.2100n 0.003175 357.2200n 0.003302 357.2300n 0.003395 357.2400n 0.003452 357.2500n 0.003470 357.2600n 0.003451 357.2700n 0.003394 357.2800n 0.003299 357.2900n 0.003168
+ 357.3000n 0.003003 357.3100n 0.002806 357.3200n 0.002580 357.3300n 0.002328 357.3400n 0.002055 357.3500n 0.001764 357.3600n 0.001459 357.3700n 0.001145 357.3800n 0.000827 357.3900n 0.000510 357.4000n 0.000196 357.4100n -0.000108 357.4200n -0.000398 357.4300n -0.000672 357.4400n -0.000925
+ 357.4500n -0.001154 357.4600n -0.001357 357.4700n -0.001532 357.4800n -0.001676 357.4900n -0.001788 357.5000n -0.001869 357.5100n -0.001918 357.5200n -0.001936 357.5300n -0.001922 357.5400n -0.001880 357.5500n -0.001811 357.5600n -0.001716 357.5700n -0.001599 357.5800n -0.001463 357.5900n -0.001311
+ 357.6000n -0.001145 357.6100n -0.000969 357.6200n -0.000786 357.6300n -0.000600 357.6400n -0.000414 357.6500n -0.000230 357.6600n -0.000053 357.6700n 0.000117 357.6800n 0.000277 357.6900n 0.000424 357.7000n 0.000557 357.7100n 0.000675 357.7200n 0.000778 357.7300n 0.000863 357.7400n 0.000932
+ 357.7500n 0.000984 357.7600n 0.001020 357.7700n 0.001041 357.7800n 0.001046 357.7900n 0.001039 357.8000n 0.001019 357.8100n 0.000989 357.8200n 0.000949 357.8300n 0.000902 357.8400n 0.000849 357.8500n 0.000791 357.8600n 0.000730 357.8700n 0.000668 357.8800n 0.000605 357.8900n 0.000543
+ 357.9000n 0.000483 357.9100n 0.000425 357.9200n 0.000370 357.9300n 0.000318 357.9400n 0.000270 357.9500n 0.000226 357.9600n 0.000186 357.9700n 0.000149 357.9800n 0.000115 357.9900n 0.000085 358.0000n 0.000057 358.0100n 0.000030 358.0200n 0.000005 358.0300n -0.000018 358.0400n -0.000041
+ 358.0500n -0.000064 358.0600n -0.000087 358.0700n -0.000111 358.0800n -0.000134 358.0900n -0.000158 358.1000n -0.000183 358.1100n -0.000207 358.1200n -0.000231 358.1300n -0.000255 358.1400n -0.000277 358.1500n -0.000298 358.1600n -0.000316 358.1700n -0.000332 358.1800n -0.000343 358.1900n -0.000351
+ 358.2000n -0.000353 358.2100n -0.000350 358.2200n -0.000341 358.2300n -0.000325 358.2400n -0.000303 358.2500n -0.000274 358.2600n -0.000238 358.2700n -0.000195 358.2800n -0.000146 358.2900n -0.000091 358.3000n -0.000030 358.3100n 0.000037 358.3200n 0.000107 358.3300n 0.000181 358.3400n 0.000257
+ 358.3500n 0.000334 358.3600n 0.000412 358.3700n 0.000489 358.3800n 0.000564 358.3900n 0.000636 358.4000n 0.000704 358.4100n 0.000767 358.4200n 0.000824 358.4300n 0.000875 358.4400n 0.000918 358.4500n 0.000954 358.4600n 0.000981 358.4700n 0.001001 358.4800n 0.001012 358.4900n 0.001014
+ 358.5000n 0.001009 358.5100n 0.000997 358.5200n 0.000977 358.5300n 0.000951 358.5400n 0.000920 358.5500n 0.000883 358.5600n 0.000843 358.5700n 0.000800 358.5800n 0.000755 358.5900n 0.000708 358.6000n 0.000662 358.6100n 0.000616 358.6200n 0.000572 358.6300n 0.000531 358.6400n 0.000492
+ 358.6500n 0.000457 358.6600n 0.000425 358.6700n 0.000398 358.6800n 0.000376 358.6900n 0.000358 358.7000n 0.000344 358.7100n 0.000335 358.7200n 0.000331 358.7300n 0.000330 358.7400n 0.000333 358.7500n 0.000340 358.7600n 0.000349 358.7700n 0.000361 358.7800n 0.000375 358.7900n 0.000390
+ 358.8000n 0.000407 358.8100n 0.000424 358.8200n 0.000441 358.8300n 0.000459 358.8400n 0.000476 358.8500n 0.000493 358.8600n 0.000509 358.8700n 0.000525 358.8800n 0.000540 358.8900n 0.000555 358.9000n 0.000569 358.9100n 0.000583 358.9200n 0.000596 358.9300n 0.000609 358.9400n 0.000623
+ 358.9500n 0.000636 358.9600n 0.000650 358.9700n 0.000664 358.9800n 0.000678 358.9900n 0.000692 359.0000n 0.000706 359.0100n 0.000720 359.0200n 0.000734 359.0300n 0.000746 359.0400n 0.000758 359.0500n 0.000768 359.0600n 0.000776 359.0700n 0.000781 359.0800n 0.000782 359.0900n 0.000781
+ 359.1000n 0.000774 359.1100n 0.000763 359.1200n 0.000747 359.1300n 0.000725 359.1400n 0.000697 359.1500n 0.000663 359.1600n 0.000623 359.1700n 0.000576 359.1800n 0.000524 359.1900n 0.000465 359.2000n 0.000401 359.2100n 0.000332 359.2200n 0.000260 359.2300n 0.000184 359.2400n 0.000105
+ 359.2500n 0.000025 359.2600n -0.000055 359.2700n -0.000134 359.2800n -0.000210 359.2900n -0.000284 359.3000n -0.000353 359.3100n -0.000416 359.3200n -0.000473 359.3300n -0.000521 359.3400n -0.000562 359.3500n -0.000592 359.3600n -0.000614 359.3700n -0.000624 359.3800n -0.000625 359.3900n -0.000615
+ 359.4000n -0.000595 359.4100n -0.000565 359.4200n -0.000526 359.4300n -0.000479 359.4400n -0.000424 359.4500n -0.000363 359.4600n -0.000297 359.4700n -0.000227 359.4800n -0.000154 359.4900n -0.000080 359.5000n -0.000006 359.5100n 0.000067 359.5200n 0.000137 359.5300n 0.000203 359.5400n 0.000265
+ 359.5500n 0.000321 359.5600n 0.000371 359.5700n 0.000414 359.5800n 0.000450 359.5900n 0.000479 359.6000n 0.000502 359.6100n 0.000518 359.6200n 0.000529 359.6300n 0.000535 359.6400n 0.000538 359.6500n 0.000538 359.6600n 0.000537 359.6700n 0.000536 359.6800n 0.000538 359.6900n 0.000542
+ 359.7000n 0.000551 359.7100n 0.000567 359.7200n 0.000590 359.7300n 0.000621 359.7400n 0.000662 359.7500n 0.000713 359.7600n 0.000776 359.7700n 0.000849 359.7800n 0.000932 359.7900n 0.001027 359.8000n 0.001131 359.8100n 0.001244 359.8200n 0.001365 359.8300n 0.001492 359.8400n 0.001623
+ 359.8500n 0.001756 359.8600n 0.001890 359.8700n 0.002020 359.8800n 0.002147 359.8900n 0.002265 359.9000n 0.002374 359.9100n 0.002471 359.9200n 0.002553 359.9300n 0.002618 359.9400n 0.002664 359.9500n 0.002690 359.9600n 0.002694 359.9700n 0.002675 359.9800n 0.002631 359.9900n 0.002564
+ 360.0000n 0.002472 360.0100n 0.002356 360.0200n 0.002217 360.0300n 0.002057 360.0400n 0.001876 360.0500n 0.001677 360.0600n 0.001462 360.0700n 0.001234 360.0800n 0.000995 360.0900n 0.000748 360.1000n 0.000497 360.1100n 0.000245 360.1200n -0.000006 360.1300n -0.000251 360.1400n -0.000488
+ 360.1500n -0.000714 360.1600n -0.000926 360.1700n -0.001121 360.1800n -0.001298 360.1900n -0.001454 360.2000n -0.001588 360.2100n -0.001698 360.2200n -0.001785 360.2300n -0.001847 360.2400n -0.001884 360.2500n -0.001898 360.2600n -0.001888 360.2700n -0.001856 360.2800n -0.001804 360.2900n -0.001732
+ 360.3000n -0.001644 360.3100n -0.001541 360.3200n -0.001426 360.3300n -0.001300 360.3400n -0.001168 360.3500n -0.001030 360.3600n -0.000890 360.3700n -0.000751 360.3800n -0.000613 360.3900n -0.000480 360.4000n -0.000354 360.4100n -0.000235 360.4200n -0.000126 360.4300n -0.000028 360.4400n 0.000058
+ 360.4500n 0.000132 360.4600n 0.000193 360.4700n 0.000240 360.4800n 0.000275 360.4900n 0.000297 360.5000n 0.000307 360.5100n 0.000304 360.5200n 0.000291 360.5300n 0.000268 360.5400n 0.000236 360.5500n 0.000196 360.5600n 0.000150 360.5700n 0.000097 360.5800n 0.000040 360.5900n -0.000021
+ 360.6000n -0.000084 360.6100n -0.000149 360.6200n -0.000216 360.6300n -0.000282 360.6400n -0.000348 360.6500n -0.000413 360.6600n -0.000477 360.6700n -0.000539 360.6800n -0.000599 360.6900n -0.000657 360.7000n -0.000712 360.7100n -0.000765 360.7200n -0.000814 360.7300n -0.000861 360.7400n -0.000905
+ 360.7500n -0.000946 360.7600n -0.000983 360.7700n -0.001016 360.7800n -0.001046 360.7900n -0.001071 360.8000n -0.001093 360.8100n -0.001109 360.8200n -0.001120 360.8300n -0.001126 360.8400n -0.001126 360.8500n -0.001119 360.8600n -0.001107 360.8700n -0.001088 360.8800n -0.001063 360.8900n -0.001031
+ 360.9000n -0.000994 360.9100n -0.000950 360.9200n -0.000901 360.9300n -0.000847 360.9400n -0.000789 360.9500n -0.000728 360.9600n -0.000666 360.9700n -0.000603 360.9800n -0.000540 360.9900n -0.000480 361.0000n -0.000424 361.0100n -0.000374 361.0200n -0.000330 361.0300n -0.000295 361.0400n -0.000271
+ 361.0500n -0.000258 361.0600n -0.000258 361.0700n -0.000272 361.0800n -0.000301 361.0900n -0.000345 361.1000n -0.000405 361.1100n -0.000480 361.1200n -0.000571 361.1300n -0.000676 361.1400n -0.000795 361.1500n -0.000925 361.1600n -0.001065 361.1700n -0.001213 361.1800n -0.001367 361.1900n -0.001524
+ 361.2000n -0.001680 361.2100n -0.001833 361.2200n -0.001979 361.2300n -0.002116 361.2400n -0.002240 361.2500n -0.002349 361.2600n -0.002438 361.2700n -0.002506 361.2800n -0.002550 361.2900n -0.002569 361.3000n -0.002560 361.3100n -0.002523 361.3200n -0.002458 361.3300n -0.002363 361.3400n -0.002240
+ 361.3500n -0.002090 361.3600n -0.001914 361.3700n -0.001715 361.3800n -0.001496 361.3900n -0.001259 361.4000n -0.001009 361.4100n -0.000750 361.4200n -0.000485 361.4300n -0.000220 361.4400n 0.000041 361.4500n 0.000293 361.4600n 0.000532 361.4700n 0.000753 361.4800n 0.000953 361.4900n 0.001127
+ 361.5000n 0.001273 361.5100n 0.001387 361.5200n 0.001467 361.5300n 0.001512 361.5400n 0.001522 361.5500n 0.001495 361.5600n 0.001434 361.5700n 0.001339 361.5800n 0.001213 361.5900n 0.001058 361.6000n 0.000879 361.6100n 0.000678 361.6200n 0.000462 361.6300n 0.000235 361.6400n 0.000002
+ 361.6500n -0.000230 361.6600n -0.000458 361.6700n -0.000674 361.6800n -0.000873 361.6900n -0.001051 361.7000n -0.001203 361.7100n -0.001324 361.7200n -0.001411 361.7300n -0.001461 361.7400n -0.001472 361.7500n -0.001443 361.7600n -0.001373 361.7700n -0.001263 361.7800n -0.001115 361.7900n -0.000931
+ 361.8000n -0.000714 361.8100n -0.000468 361.8200n -0.000198 361.8300n 0.000090 361.8400n 0.000392 361.8500n 0.000700 361.8600n 0.001007 361.8700n 0.001308 361.8800n 0.001596 361.8900n 0.001863 361.9000n 0.002104 361.9100n 0.002313 361.9200n 0.002484 361.9300n 0.002614 361.9400n 0.002697
+ 361.9500n 0.002732 361.9600n 0.002715 361.9700n 0.002648 361.9800n 0.002529 361.9900n 0.002359 362.0000n 0.002141 362.0100n 0.001879 362.0200n 0.001576 362.0300n 0.001237 362.0400n 0.000869 362.0500n 0.000477 362.0600n 0.000070 362.0700n -0.000346 362.0800n -0.000763 362.0900n -0.001173
+ 362.1000n -0.001568 362.1100n -0.001941 362.1200n -0.002284 362.1300n -0.002592 362.1400n -0.002857 362.1500n -0.003075 362.1600n -0.003242 362.1700n -0.003355 362.1800n -0.003411 362.1900n -0.003409 362.2000n -0.003350 362.2100n -0.003235 362.2200n -0.003066 362.2300n -0.002847 362.2400n -0.002582
+ 362.2500n -0.002277 362.2600n -0.001937 362.2700n -0.001571 362.2800n -0.001184 362.2900n -0.000785 362.3000n -0.000383 362.3100n 0.000016 362.3200n 0.000404 362.3300n 0.000771 362.3400n 0.001113 362.3500n 0.001421 362.3600n 0.001690 362.3700n 0.001915 362.3800n 0.002093 362.3900n 0.002219
+ 362.4000n 0.002293 362.4100n 0.002313 362.4200n 0.002280 362.4300n 0.002195 362.4400n 0.002061 362.4500n 0.001881 362.4600n 0.001661 362.4700n 0.001405 362.4800n 0.001119 362.4900n 0.000810 362.5000n 0.000486 362.5100n 0.000153 362.5200n -0.000181 362.5300n -0.000508 362.5400n -0.000821
+ 362.5500n -0.001114 362.5600n -0.001380 362.5700n -0.001613 362.5800n -0.001808 362.5900n -0.001961 362.6000n -0.002070 362.6100n -0.002131 362.6200n -0.002144 362.6300n -0.002110 362.6400n -0.002028 362.6500n -0.001901 362.6600n -0.001732 362.6700n -0.001526 362.6800n -0.001286 362.6900n -0.001018
+ 362.7000n -0.000729 362.7100n -0.000424 362.7200n -0.000111 362.7300n 0.000204 362.7400n 0.000514 362.7500n 0.000812 362.7600n 0.001092 362.7700n 0.001348 362.7800n 0.001575 362.7900n 0.001768 362.8000n 0.001922 362.8100n 0.002036 362.8200n 0.002107 362.8300n 0.002134 362.8400n 0.002117
+ 362.8500n 0.002057 362.8600n 0.001954 362.8700n 0.001813 362.8800n 0.001637 362.8900n 0.001429 362.9000n 0.001194 362.9100n 0.000938 362.9200n 0.000667 362.9300n 0.000385 362.9400n 0.000101 362.9500n -0.000181 362.9600n -0.000455 362.9700n -0.000715 362.9800n -0.000955 362.9900n -0.001172
+ 363.0000n -0.001360 363.0100n -0.001517 363.0200n -0.001641 363.0300n -0.001728 363.0400n -0.001779 363.0500n -0.001792 363.0600n -0.001770 363.0700n -0.001713 363.0800n -0.001623 363.0900n -0.001504 363.1000n -0.001359 363.1100n -0.001193 363.1200n -0.001009 363.1300n -0.000812 363.1400n -0.000608
+ 363.1500n -0.000402 363.1600n -0.000198 363.1700n -0.000001 363.1800n 0.000184 363.1900n 0.000353 363.2000n 0.000503 363.2100n 0.000630 363.2200n 0.000732 363.2300n 0.000808 363.2400n 0.000857 363.2500n 0.000877 363.2600n 0.000870 363.2700n 0.000837 363.2800n 0.000780 363.2900n 0.000701
+ 363.3000n 0.000603 363.3100n 0.000489 363.3200n 0.000364 363.3300n 0.000232 363.3400n 0.000096 363.3500n -0.000038 363.3600n -0.000167 363.3700n -0.000286 363.3800n -0.000391 363.3900n -0.000478 363.4000n -0.000546 363.4100n -0.000590 363.4200n -0.000608 363.4300n -0.000600 363.4400n -0.000565
+ 363.4500n -0.000501 363.4600n -0.000411 363.4700n -0.000295 363.4800n -0.000154 363.4900n 0.000008 363.5000n 0.000188 363.5100n 0.000385 363.5200n 0.000592 363.5300n 0.000807 363.5400n 0.001025 363.5500n 0.001242 363.5600n 0.001453 363.5700n 0.001654 363.5800n 0.001841 363.5900n 0.002010
+ 363.6000n 0.002157 363.6100n 0.002281 363.6200n 0.002377 363.6300n 0.002445 363.6400n 0.002482 363.6500n 0.002489 363.6600n 0.002464 363.6700n 0.002409 363.6800n 0.002325 363.6900n 0.002214 363.7000n 0.002077 363.7100n 0.001917 363.7200n 0.001738 363.7300n 0.001542 363.7400n 0.001335
+ 363.7500n 0.001118 363.7600n 0.000898 363.7700n 0.000676 363.7800n 0.000458 363.7900n 0.000247 363.8000n 0.000047 363.8100n -0.000140 363.8200n -0.000311 363.8300n -0.000463 363.8400n -0.000594 363.8500n -0.000704 363.8600n -0.000790 363.8700n -0.000853 363.8800n -0.000893 363.8900n -0.000910
+ 363.9000n -0.000905 363.9100n -0.000879 363.9200n -0.000835 363.9300n -0.000774 363.9400n -0.000699 363.9500n -0.000611 363.9600n -0.000513 363.9700n -0.000409 363.9800n -0.000299 363.9900n -0.000187 364.0000n -0.000074 364.0100n 0.000036 364.0200n 0.000144 364.0300n 0.000246 364.0400n 0.000342
+ 364.0500n 0.000432 364.0600n 0.000514 364.0700n 0.000589 364.0800n 0.000657 364.0900n 0.000718 364.1000n 0.000772 364.1100n 0.000822 364.1200n 0.000867 364.1300n 0.000909 364.1400n 0.000950 364.1500n 0.000990 364.1600n 0.001032 364.1700n 0.001075 364.1800n 0.001122 364.1900n 0.001172
+ 364.2000n 0.001227 364.2100n 0.001287 364.2200n 0.001352 364.2300n 0.001422 364.2400n 0.001495 364.2500n 0.001572 364.2600n 0.001652 364.2700n 0.001732 364.2800n 0.001811 364.2900n 0.001888 364.3000n 0.001959 364.3100n 0.002024 364.3200n 0.002080 364.3300n 0.002124 364.3400n 0.002155
+ 364.3500n 0.002171 364.3600n 0.002169 364.3700n 0.002149 364.3800n 0.002108 364.3900n 0.002046 364.4000n 0.001963 364.4100n 0.001858 364.4200n 0.001731 364.4300n 0.001584 364.4400n 0.001417 364.4500n 0.001231 364.4600n 0.001029 364.4700n 0.000814 364.4800n 0.000587 364.4900n 0.000352
+ 364.5000n 0.000112 364.5100n -0.000129 364.5200n -0.000369 364.5300n -0.000603 364.5400n -0.000828 364.5500n -0.001040 364.5600n -0.001237 364.5700n -0.001415 364.5800n -0.001572 364.5900n -0.001704 364.6000n -0.001811 364.6100n -0.001890 364.6200n -0.001940 364.6300n -0.001962 364.6400n -0.001954
+ 364.6500n -0.001917 364.6600n -0.001853 364.6700n -0.001762 364.6800n -0.001647 364.6900n -0.001509 364.7000n -0.001352 364.7100n -0.001178 364.7200n -0.000990 364.7300n -0.000792 364.7400n -0.000587 364.7500n -0.000378 364.7600n -0.000170 364.7700n 0.000035 364.7800n 0.000234 364.7900n 0.000423
+ 364.8000n 0.000600 364.8100n 0.000763 364.8200n 0.000909 364.8300n 0.001038 364.8400n 0.001147 364.8500n 0.001235 364.8600n 0.001304 364.8700n 0.001352 364.8800n 0.001381 364.8900n 0.001390 364.9000n 0.001382 364.9100n 0.001357 364.9200n 0.001317 364.9300n 0.001264 364.9400n 0.001200
+ 364.9500n 0.001127 364.9600n 0.001048 364.9700n 0.000964 364.9800n 0.000877 364.9900n 0.000789 365.0000n 0.000702 365.0100n 0.000617 365.0200n 0.000535 365.0300n 0.000458 365.0400n 0.000386 365.0500n 0.000320 365.0600n 0.000260 365.0700n 0.000205 365.0800n 0.000155 365.0900n 0.000110
+ 365.1000n 0.000069 365.1100n 0.000031 365.1200n -0.000005 365.1300n -0.000041 365.1400n -0.000077 365.1500n -0.000116 365.1600n -0.000157 365.1700n -0.000201 365.1800n -0.000251 365.1900n -0.000307 365.2000n -0.000368 365.2100n -0.000436 365.2200n -0.000510 365.2300n -0.000591 365.2400n -0.000677
+ 365.2500n -0.000769 365.2600n -0.000865 365.2700n -0.000964 365.2800n -0.001065 365.2900n -0.001166 365.3000n -0.001265 365.3100n -0.001361 365.3200n -0.001453 365.3300n -0.001538 365.3400n -0.001614 365.3500n -0.001680 365.3600n -0.001735 365.3700n -0.001777 365.3800n -0.001806 365.3900n -0.001819
+ 365.4000n -0.001817 365.4100n -0.001800 365.4200n -0.001766 365.4300n -0.001718 365.4400n -0.001655 365.4500n -0.001578 365.4600n -0.001488 365.4700n -0.001387 365.4800n -0.001277 365.4900n -0.001158 365.5000n -0.001034 365.5100n -0.000906 365.5200n -0.000777 365.5300n -0.000648 365.5400n -0.000521
+ 365.5500n -0.000399 365.5600n -0.000283 365.5700n -0.000175 365.5800n -0.000077 365.5900n 0.000012 365.6000n 0.000089 365.6100n 0.000155 365.6200n 0.000208 365.6300n 0.000250 365.6400n 0.000280 365.6500n 0.000299 365.6600n 0.000309 365.6700n 0.000310 365.6800n 0.000303 365.6900n 0.000291
+ 365.7000n 0.000275 365.7100n 0.000257 365.7200n 0.000239 365.7300n 0.000223 365.7400n 0.000211 365.7500n 0.000203 365.7600n 0.000202 365.7700n 0.000210 365.7800n 0.000226 365.7900n 0.000253 365.8000n 0.000291 365.8100n 0.000339 365.8200n 0.000398 365.8300n 0.000467 365.8400n 0.000546
+ 365.8500n 0.000634 365.8600n 0.000729 365.8700n 0.000830 365.8800n 0.000935 365.8900n 0.001042 365.9000n 0.001149 365.9100n 0.001254 365.9200n 0.001354 365.9300n 0.001449 365.9400n 0.001534 365.9500n 0.001610 365.9600n 0.001673 365.9700n 0.001723 365.9800n 0.001758 365.9900n 0.001777
+ 366.0000n 0.001779 366.0100n 0.001765 366.0200n 0.001734 366.0300n 0.001686 366.0400n 0.001623 366.0500n 0.001545 366.0600n 0.001454 366.0700n 0.001352 366.0800n 0.001240 366.0900n 0.001120 366.1000n 0.000995 366.1100n 0.000868 366.1200n 0.000739 366.1300n 0.000613 366.1400n 0.000491
+ 366.1500n 0.000375 366.1600n 0.000268 366.1700n 0.000170 366.1800n 0.000085 366.1900n 0.000012 366.2000n -0.000047 366.2100n -0.000093 366.2200n -0.000123 366.2300n -0.000140 366.2400n -0.000144 366.2500n -0.000135 366.2600n -0.000115 366.2700n -0.000086 366.2800n -0.000050 366.2900n -0.000008
+ 366.3000n 0.000036 366.3100n 0.000080 366.3200n 0.000121 366.3300n 0.000158 366.3400n 0.000186 366.3500n 0.000204 366.3600n 0.000210 366.3700n 0.000200 366.3800n 0.000174 366.3900n 0.000130 366.4000n 0.000066 366.4100n -0.000018 366.4200n -0.000124 366.4300n -0.000250 366.4400n -0.000396
+ 366.4500n -0.000562 366.4600n -0.000746 366.4700n -0.000947 366.4800n -0.001162 366.4900n -0.001389 366.5000n -0.001626 366.5100n -0.001869 366.5200n -0.002116 366.5300n -0.002363 366.5400n -0.002606 366.5500n -0.002844 366.5600n -0.003071 366.5700n -0.003285 366.5800n -0.003483 366.5900n -0.003663
+ 366.6000n -0.003820 366.6100n -0.003955 366.6200n -0.004063 366.6300n -0.004145 366.6400n -0.004199 366.6500n -0.004224 366.6600n -0.004220 366.6700n -0.004187 366.6800n -0.004127 366.6900n -0.004039 366.7000n -0.003926 366.7100n -0.003789 366.7200n -0.003630 366.7300n -0.003453 366.7400n -0.003258
+ 366.7500n -0.003050 366.7600n -0.002831 366.7700n -0.002604 366.7800n -0.002373 366.7900n -0.002139 366.8000n -0.001907 366.8100n -0.001679 366.8200n -0.001458 366.8300n -0.001245 366.8400n -0.001044 366.8500n -0.000857 366.8600n -0.000684 366.8700n -0.000528 366.8800n -0.000388 366.8900n -0.000267
+ 366.9000n -0.000165 366.9100n -0.000080 366.9200n -0.000014 366.9300n 0.000034 366.9400n 0.000066 366.9500n 0.000082 366.9600n 0.000084 366.9700n 0.000072 366.9800n 0.000050 366.9900n 0.000018 367.0000n -0.000022 367.0100n -0.000068 367.0200n -0.000118 367.0300n -0.000169 367.0400n -0.000221
+ 367.0500n -0.000272 367.0600n -0.000319 367.0700n -0.000361 367.0800n -0.000397 367.0900n -0.000426 367.1000n -0.000447 367.1100n -0.000458 367.1200n -0.000460 367.1300n -0.000451 367.1400n -0.000432 367.1500n -0.000402 367.1600n -0.000362 367.1700n -0.000312 367.1800n -0.000253 367.1900n -0.000184
+ 367.2000n -0.000108 367.2100n -0.000026 367.2200n 0.000063 367.2300n 0.000155 367.2400n 0.000251 367.2500n 0.000348 367.2600n 0.000445 367.2700n 0.000541 367.2800n 0.000633 367.2900n 0.000721 367.3000n 0.000802 367.3100n 0.000876 367.3200n 0.000941 367.3300n 0.000995 367.3400n 0.001037
+ 367.3500n 0.001066 367.3600n 0.001082 367.3700n 0.001083 367.3800n 0.001068 367.3900n 0.001038 367.4000n 0.000992 367.4100n 0.000930 367.4200n 0.000852 367.4300n 0.000759 367.4400n 0.000650 367.4500n 0.000528 367.4600n 0.000393 367.4700n 0.000246 367.4800n 0.000089 367.4900n -0.000077
+ 367.5000n -0.000249 367.5100n -0.000425 367.5200n -0.000604 367.5300n -0.000784 367.5400n -0.000960 367.5500n -0.001132 367.5600n -0.001297 367.5700n -0.001453 367.5800n -0.001597 367.5900n -0.001726 367.6000n -0.001840 367.6100n -0.001935 367.6200n -0.002011 367.6300n -0.002065 367.6400n -0.002096
+ 367.6500n -0.002105 367.6600n -0.002089 367.6700n -0.002048 367.6800n -0.001984 367.6900n -0.001895 367.7000n -0.001784 367.7100n -0.001651 367.7200n -0.001497 367.7300n -0.001325 367.7400n -0.001136 367.7500n -0.000933 367.7600n -0.000720 367.7700n -0.000497 367.7800n -0.000269 367.7900n -0.000039
+ 367.8000n 0.000190 367.8100n 0.000416 367.8200n 0.000634 367.8300n 0.000843 367.8400n 0.001038 367.8500n 0.001218 367.8600n 0.001380 367.8700n 0.001522 367.8800n 0.001642 367.8900n 0.001739 367.9000n 0.001811 367.9100n 0.001859 367.9200n 0.001882 367.9300n 0.001880 367.9400n 0.001854
+ 367.9500n 0.001805 367.9600n 0.001735 367.9700n 0.001644 367.9800n 0.001536 367.9900n 0.001413 368.0000n 0.001276 368.0100n 0.001130 368.0200n 0.000976 368.0300n 0.000817 368.0400n 0.000656 368.0500n 0.000497 368.0600n 0.000341 368.0700n 0.000191 368.0800n 0.000048 368.0900n -0.000084
+ 368.1000n -0.000205 368.1100n -0.000313 368.1200n -0.000408 368.1300n -0.000489 368.1400n -0.000557 368.1500n -0.000611 368.1600n -0.000653 368.1700n -0.000684 368.1800n -0.000705 368.1900n -0.000718 368.2000n -0.000725 368.2100n -0.000728 368.2200n -0.000730 368.2300n -0.000733 368.2400n -0.000740
+ 368.2500n -0.000752 368.2600n -0.000773 368.2700n -0.000804 368.2800n -0.000846 368.2900n -0.000903 368.3000n -0.000974 368.3100n -0.001060 368.3200n -0.001162 368.3300n -0.001280 368.3400n -0.001413 368.3500n -0.001559 368.3600n -0.001719 368.3700n -0.001889 368.3800n -0.002067 368.3900n -0.002251
+ 368.4000n -0.002438 368.4100n -0.002624 368.4200n -0.002805 368.4300n -0.002978 368.4400n -0.003140 368.4500n -0.003287 368.4600n -0.003415 368.4700n -0.003520 368.4800n -0.003600 368.4900n -0.003652 368.5000n -0.003673 368.5100n -0.003661 368.5200n -0.003614 368.5300n -0.003533 368.5400n -0.003415
+ 368.5500n -0.003262 368.5600n -0.003075 368.5700n -0.002854 368.5800n -0.002602 368.5900n -0.002321 368.6000n -0.002015 368.6100n -0.001687 368.6200n -0.001341 368.6300n -0.000981 368.6400n -0.000612 368.6500n -0.000238 368.6600n 0.000134 368.6700n 0.000500 368.6800n 0.000856 368.6900n 0.001197
+ 368.7000n 0.001517 368.7100n 0.001813 368.7200n 0.002080 368.7300n 0.002317 368.7400n 0.002518 368.7500n 0.002683 368.7600n 0.002810 368.7700n 0.002897 368.7800n 0.002943 368.7900n 0.002950 368.8000n 0.002918 368.8100n 0.002848 368.8200n 0.002742 368.8300n 0.002604 368.8400n 0.002435
+ 368.8500n 0.002240 368.8600n 0.002022 368.8700n 0.001785 368.8800n 0.001534 368.8900n 0.001273 368.9000n 0.001007 368.9100n 0.000739 368.9200n 0.000475 368.9300n 0.000219 368.9400n -0.000027 368.9500n -0.000258 368.9600n -0.000470 368.9700n -0.000663 368.9800n -0.000832 368.9900n -0.000977
+ 369.0000n -0.001097 369.0100n -0.001189 369.0200n -0.001256 369.0300n -0.001296 369.0400n -0.001310 369.0500n -0.001301 369.0600n -0.001268 369.0700n -0.001216 369.0800n -0.001145 369.0900n -0.001058 369.1000n -0.000959 369.1100n -0.000850 369.1200n -0.000734 369.1300n -0.000614 369.1400n -0.000493
+ 369.1500n -0.000373 369.1600n -0.000258 369.1700n -0.000150 369.1800n -0.000050 369.1900n 0.000039 369.2000n 0.000116 369.2100n 0.000179 369.2200n 0.000228 369.2300n 0.000262 369.2400n 0.000281 369.2500n 0.000286 369.2600n 0.000276 369.2700n 0.000253 369.2800n 0.000217 369.2900n 0.000171
+ 369.3000n 0.000114 369.3100n 0.000050 369.3200n -0.000021 369.3300n -0.000096 369.3400n -0.000175 369.3500n -0.000254 369.3600n -0.000332 369.3700n -0.000409 369.3800n -0.000481 369.3900n -0.000549 369.4000n -0.000610 369.4100n -0.000664 369.4200n -0.000710 369.4300n -0.000747 369.4400n -0.000776
+ 369.4500n -0.000796 369.4600n -0.000807 369.4700n -0.000809 369.4800n -0.000804 369.4900n -0.000791 369.5000n -0.000771 369.5100n -0.000746 369.5200n -0.000716 369.5300n -0.000682 369.5400n -0.000646 369.5500n -0.000608 369.5600n -0.000569 369.5700n -0.000530 369.5800n -0.000493 369.5900n -0.000459
+ 369.6000n -0.000427 369.6100n -0.000399 369.6200n -0.000375 369.6300n -0.000356 369.6400n -0.000341 369.6500n -0.000332 369.6600n -0.000328 369.6700n -0.000330 369.6800n -0.000336 369.6900n -0.000348 369.7000n -0.000363 369.7100n -0.000383 369.7200n -0.000407 369.7300n -0.000434 369.7400n -0.000464
+ 369.7500n -0.000496 369.7600n -0.000529 369.7700n -0.000564 369.7800n -0.000600 369.7900n -0.000635 369.8000n -0.000670 369.8100n -0.000705 369.8200n -0.000738 369.8300n -0.000770 369.8400n -0.000800 369.8500n -0.000827 369.8600n -0.000852 369.8700n -0.000874 369.8800n -0.000893 369.8900n -0.000908
+ 369.9000n -0.000920 369.9100n -0.000929 369.9200n -0.000933 369.9300n -0.000933 369.9400n -0.000928 369.9500n -0.000919 369.9600n -0.000906 369.9700n -0.000887 369.9800n -0.000863 369.9900n -0.000833 370.0000n -0.000799 370.0100n -0.000759 370.0200n -0.000713 370.0300n -0.000661 370.0400n -0.000605
+ 370.0500n -0.000543 370.0600n -0.000475 370.0700n -0.000403 370.0800n -0.000327 370.0900n -0.000246 370.1000n -0.000162 370.1100n -0.000076 370.1200n 0.000013 370.1300n 0.000103 370.1400n 0.000194 370.1500n 0.000284 370.1600n 0.000372 370.1700n 0.000458 370.1800n 0.000540 370.1900n 0.000618
+ 370.2000n 0.000689 370.2100n 0.000754 370.2200n 0.000811 370.2300n 0.000859 370.2400n 0.000897 370.2500n 0.000926 370.2600n 0.000943 370.2700n 0.000949 370.2800n 0.000943 370.2900n 0.000925 370.3000n 0.000896 370.3100n 0.000855 370.3200n 0.000802 370.3300n 0.000739 370.3400n 0.000666
+ 370.3500n 0.000583 370.3600n 0.000492 370.3700n 0.000395 370.3800n 0.000291 370.3900n 0.000183 370.4000n 0.000071 370.4100n -0.000042 370.4200n -0.000156 370.4300n -0.000268 370.4400n -0.000378 370.4500n -0.000484 370.4600n -0.000585 370.4700n -0.000680 370.4800n -0.000767 370.4900n -0.000846
+ 370.5000n -0.000915 370.5100n -0.000975 370.5200n -0.001024 370.5300n -0.001063 370.5400n -0.001092 370.5500n -0.001109 370.5600n -0.001116 370.5700n -0.001114 370.5800n -0.001101 370.5900n -0.001080 370.6000n -0.001051 370.6100n -0.001014 370.6200n -0.000971 370.6300n -0.000922 370.6400n -0.000868
+ 370.6500n -0.000811 370.6600n -0.000751 370.6700n -0.000690 370.6800n -0.000628 370.6900n -0.000565 370.7000n -0.000504 370.7100n -0.000444 370.7200n -0.000385 370.7300n -0.000330 370.7400n -0.000277 370.7500n -0.000226 370.7600n -0.000180 370.7700n -0.000136 370.7800n -0.000096 370.7900n -0.000059
+ 370.8000n -0.000025 370.8100n 0.000007 370.8200n 0.000035 370.8300n 0.000062 370.8400n 0.000086 370.8500n 0.000109 370.8600n 0.000130 370.8700n 0.000151 370.8800n 0.000170 370.8900n 0.000189 370.9000n 0.000208 370.9100n 0.000226 370.9200n 0.000245 370.9300n 0.000264 370.9400n 0.000283
+ 370.9500n 0.000302 370.9600n 0.000323 370.9700n 0.000343 370.9800n 0.000365 370.9900n 0.000387 371.0000n 0.000409 371.0100n 0.000433 371.0200n 0.000458 371.0300n 0.000484 371.0400n 0.000511 371.0500n 0.000540 371.0600n 0.000571 371.0700n 0.000603 371.0800n 0.000638 371.0900n 0.000676
+ 371.1000n 0.000716 371.1100n 0.000760 371.1200n 0.000807 371.1300n 0.000858 371.1400n 0.000913 371.1500n 0.000971 371.1600n 0.001033 371.1700n 0.001099 371.1800n 0.001169 371.1900n 0.001242 371.2000n 0.001317 371.2100n 0.001394 371.2200n 0.001473 371.2300n 0.001552 371.2400n 0.001631
+ 371.2500n 0.001708 371.2600n 0.001781 371.2700n 0.001850 371.2800n 0.001913 371.2900n 0.001969 371.3000n 0.002016 371.3100n 0.002052 371.3200n 0.002077 371.3300n 0.002088 371.3400n 0.002085 371.3500n 0.002066 371.3600n 0.002031 371.3700n 0.001978 371.3800n 0.001908 371.3900n 0.001820
+ 371.4000n 0.001714 371.4100n 0.001591 371.4200n 0.001452 371.4300n 0.001298 371.4400n 0.001129 371.4500n 0.000949 371.4600n 0.000758 371.4700n 0.000560 371.4800n 0.000357 371.4900n 0.000152 371.5000n -0.000052 371.5100n -0.000253 371.5200n -0.000447 371.5300n -0.000631 371.5400n -0.000802
+ 371.5500n -0.000957 371.5600n -0.001094 371.5700n -0.001209 371.5800n -0.001301 371.5900n -0.001368 371.6000n -0.001409 371.6100n -0.001422 371.6200n -0.001408 371.6300n -0.001366 371.6400n -0.001296 371.6500n -0.001201 371.6600n -0.001081 371.6700n -0.000939 371.6800n -0.000776 371.6900n -0.000598
+ 371.7000n -0.000405 371.7100n -0.000203 371.7200n 0.000005 371.7300n 0.000214 371.7400n 0.000421 371.7500n 0.000621 371.7600n 0.000809 371.7700n 0.000983 371.7800n 0.001138 371.7900n 0.001270 371.8000n 0.001376 371.8100n 0.001454 371.8200n 0.001502 371.8300n 0.001518 371.8400n 0.001500
+ 371.8500n 0.001449 371.8600n 0.001365 371.8700n 0.001249 371.8800n 0.001103 371.8900n 0.000928 371.9000n 0.000728 371.9100n 0.000506 371.9200n 0.000265 371.9300n 0.000011 371.9400n -0.000253 371.9500n -0.000522 371.9600n -0.000791 371.9700n -0.001055 371.9800n -0.001309 371.9900n -0.001548
+ 372.0000n -0.001768 372.0100n -0.001965 372.0200n -0.002136 372.0300n -0.002276 372.0400n -0.002384 372.0500n -0.002458 372.0600n -0.002496 372.0700n -0.002499 372.0800n -0.002465 372.0900n -0.002397 372.1000n -0.002295 372.1100n -0.002163 372.1200n -0.002002 372.1300n -0.001818 372.1400n -0.001613
+ 372.1500n -0.001392 372.1600n -0.001160 372.1700n -0.000922 372.1800n -0.000682 372.1900n -0.000447 372.2000n -0.000221 372.2100n -0.000009 372.2200n 0.000185 372.2300n 0.000356 372.2400n 0.000500 372.2500n 0.000616 372.2600n 0.000699 372.2700n 0.000749 372.2800n 0.000764 372.2900n 0.000745
+ 372.3000n 0.000690 372.3100n 0.000602 372.3200n 0.000482 372.3300n 0.000332 372.3400n 0.000157 372.3500n -0.000041 372.3600n -0.000258 372.3700n -0.000488 372.3800n -0.000728 372.3900n -0.000971 372.4000n -0.001214 372.4100n -0.001451 372.4200n -0.001677 372.4300n -0.001888 372.4400n -0.002079
+ 372.4500n -0.002246 372.4600n -0.002386 372.4700n -0.002496 372.4800n -0.002574 372.4900n -0.002619 372.5000n -0.002629 372.5100n -0.002605 372.5200n -0.002546 372.5300n -0.002455 372.5400n -0.002332 372.5500n -0.002182 372.5600n -0.002006 372.5700n -0.001808 372.5800n -0.001592 372.5900n -0.001362
+ 372.6000n -0.001122 372.6100n -0.000878 372.6200n -0.000633 372.6300n -0.000392 372.6400n -0.000160 372.6500n 0.000060 372.6600n 0.000264 372.6700n 0.000450 372.6800n 0.000613 372.6900n 0.000752 372.7000n 0.000865 372.7100n 0.000952 372.7200n 0.001011 372.7300n 0.001044 372.7400n 0.001050
+ 372.7500n 0.001032 372.7600n 0.000990 372.7700n 0.000927 372.7800n 0.000847 372.7900n 0.000751 372.8000n 0.000644 372.8100n 0.000529 372.8200n 0.000408 372.8300n 0.000287 372.8400n 0.000168 372.8500n 0.000054 372.8600n -0.000051 372.8700n -0.000145 372.8800n -0.000225 372.8900n -0.000289
+ 372.9000n -0.000336 372.9100n -0.000365 372.9200n -0.000376 372.9300n -0.000368 372.9400n -0.000341 372.9500n -0.000297 372.9600n -0.000238 372.9700n -0.000164 372.9800n -0.000079 372.9900n 0.000016 373.0000n 0.000118 373.0100n 0.000224 373.0200n 0.000332 373.0300n 0.000437 373.0400n 0.000539
+ 373.0500n 0.000633 373.0600n 0.000718 373.0700n 0.000790 373.0800n 0.000850 373.0900n 0.000894 373.1000n 0.000922 373.1100n 0.000932 373.1200n 0.000925 373.1300n 0.000901 373.1400n 0.000861 373.1500n 0.000804 373.1600n 0.000733 373.1700n 0.000649 373.1800n 0.000554 373.1900n 0.000450
+ 373.2000n 0.000340 373.2100n 0.000225 373.2200n 0.000109 373.2300n -0.000006 373.2400n -0.000118 373.2500n -0.000224 373.2600n -0.000323 373.2700n -0.000413 373.2800n -0.000491 373.2900n -0.000558 373.3000n -0.000611 373.3100n -0.000651 373.3200n -0.000677 373.3300n -0.000689 373.3400n -0.000689
+ 373.3500n -0.000677 373.3600n -0.000654 373.3700n -0.000621 373.3800n -0.000581 373.3900n -0.000536 373.4000n -0.000487 373.4100n -0.000436 373.4200n -0.000385 373.4300n -0.000337 373.4400n -0.000293 373.4500n -0.000256 373.4600n -0.000226 373.4700n -0.000205 373.4800n -0.000194 373.4900n -0.000194
+ 373.5000n -0.000204 373.5100n -0.000226 373.5200n -0.000258 373.5300n -0.000301 373.5400n -0.000353 373.5500n -0.000413 373.5600n -0.000480 373.5700n -0.000551 373.5800n -0.000626 373.5900n -0.000702 373.6000n -0.000777 373.6100n -0.000849 373.6200n -0.000916 373.6300n -0.000977 373.6400n -0.001030
+ 373.6500n -0.001074 373.6600n -0.001107 373.6700n -0.001128 373.6800n -0.001137 373.6900n -0.001133 373.7000n -0.001117 373.7100n -0.001089 373.7200n -0.001049 373.7300n -0.001000 373.7400n -0.000941 373.7500n -0.000876 373.7600n -0.000804 373.7700n -0.000729 373.7800n -0.000653 373.7900n -0.000577
+ 373.8000n -0.000504 373.8100n -0.000435 373.8200n -0.000373 373.8300n -0.000319 373.8400n -0.000274 373.8500n -0.000241 373.8600n -0.000219 373.8700n -0.000209 373.8800n -0.000212 373.8900n -0.000227 373.9000n -0.000254 373.9100n -0.000292 373.9200n -0.000338 373.9300n -0.000393 373.9400n -0.000453
+ 373.9500n -0.000517 373.9600n -0.000582 373.9700n -0.000646 373.9800n -0.000706 373.9900n -0.000760 374.0000n -0.000806 374.0100n -0.000840 374.0200n -0.000861 374.0300n -0.000866 374.0400n -0.000856 374.0500n -0.000827 374.0600n -0.000780 374.0700n -0.000713 374.0800n -0.000628 374.0900n -0.000525
+ 374.1000n -0.000404 374.1100n -0.000268 374.1200n -0.000119 374.1300n 0.000042 374.1400n 0.000212 374.1500n 0.000387 374.1600n 0.000565 374.1700n 0.000741 374.1800n 0.000913 374.1900n 0.001076 374.2000n 0.001228 374.2100n 0.001364 374.2200n 0.001483 374.2300n 0.001580 374.2400n 0.001654
+ 374.2500n 0.001702 374.2600n 0.001724 374.2700n 0.001717 374.2800n 0.001682 374.2900n 0.001619 374.3000n 0.001528 374.3100n 0.001410 374.3200n 0.001267 374.3300n 0.001102 374.3400n 0.000917 374.3500n 0.000716 374.3600n 0.000502 374.3700n 0.000278 374.3800n 0.000050 374.3900n -0.000180
+ 374.4000n -0.000407 374.4100n -0.000626 374.4200n -0.000834 374.4300n -0.001028 374.4400n -0.001203 374.4500n -0.001357 374.4600n -0.001488 374.4700n -0.001592 374.4800n -0.001670 374.4900n -0.001719 374.5000n -0.001740 374.5100n -0.001733 374.5200n -0.001698 374.5300n -0.001638 374.5400n -0.001554
+ 374.5500n -0.001448 374.5600n -0.001325 374.5700n -0.001186 374.5800n -0.001035 374.5900n -0.000876 374.6000n -0.000714 374.6100n -0.000552 374.6200n -0.000393 374.6300n -0.000241 374.6400n -0.000101 374.6500n 0.000026 374.6600n 0.000136 374.6700n 0.000227 374.6800n 0.000297 374.6900n 0.000345
+ 374.7000n 0.000370 374.7100n 0.000372 374.7200n 0.000352 374.7300n 0.000311 374.7400n 0.000249 374.7500n 0.000170 374.7600n 0.000075 374.7700n -0.000032 374.7800n -0.000149 374.7900n -0.000271 374.8000n -0.000396 374.8100n -0.000519 374.8200n -0.000638 374.8300n -0.000748 374.8400n -0.000846
+ 374.8500n -0.000929 374.8600n -0.000994 374.8700n -0.001038 374.8800n -0.001061 374.8900n -0.001060 374.9000n -0.001034 374.9100n -0.000984 374.9200n -0.000909 374.9300n -0.000809 374.9400n -0.000687 374.9500n -0.000544 374.9600n -0.000382 374.9700n -0.000203 374.9800n -0.000011 374.9900n 0.000191
+ 375.0000n 0.000399 375.0100n 0.000611 375.0200n 0.000823 375.0300n 0.001031 375.0400n 0.001232 375.0500n 0.001422 375.0600n 0.001599 375.0700n 0.001759 375.0800n 0.001902 375.0900n 0.002024 375.1000n 0.002124 375.1100n 0.002202 375.1200n 0.002257 375.1300n 0.002289 375.1400n 0.002298
+ 375.1500n 0.002286 375.1600n 0.002254 375.1700n 0.002204 375.1800n 0.002137 375.1900n 0.002056 375.2000n 0.001964 375.2100n 0.001863 375.2200n 0.001755 375.2300n 0.001644 375.2400n 0.001532 375.2500n 0.001421 375.2600n 0.001314 375.2700n 0.001212 375.2800n 0.001117 375.2900n 0.001031
+ 375.3000n 0.000954 375.3100n 0.000886 375.3200n 0.000829 375.3300n 0.000780 375.3400n 0.000741 375.3500n 0.000709 375.3600n 0.000683 375.3700n 0.000663 375.3800n 0.000644 375.3900n 0.000627 375.4000n 0.000608 375.4100n 0.000586 375.4200n 0.000557 375.4300n 0.000521 375.4400n 0.000476
+ 375.4500n 0.000418 375.4600n 0.000348 375.4700n 0.000265 375.4800n 0.000166 375.4900n 0.000053 375.5000n -0.000075 375.5100n -0.000217 375.5200n -0.000373 375.5300n -0.000541 375.5400n -0.000719 375.5500n -0.000905 375.5600n -0.001097 375.5700n -0.001292 375.5800n -0.001488 375.5900n -0.001681
+ 375.6000n -0.001868 375.6100n -0.002046 375.6200n -0.002213 375.6300n -0.002364 375.6400n -0.002499 375.6500n -0.002614 375.6600n -0.002708 375.6700n -0.002779 375.6800n -0.002825 375.6900n -0.002846 375.7000n -0.002843 375.7100n -0.002814 375.7200n -0.002761 375.7300n -0.002686 375.7400n -0.002590
+ 375.7500n -0.002474 375.7600n -0.002342 375.7700n -0.002197 375.7800n -0.002041 375.7900n -0.001879 375.8000n -0.001712 375.8100n -0.001546 375.8200n -0.001383 375.8300n -0.001226 375.8400n -0.001080 375.8500n -0.000946 375.8600n -0.000827 375.8700n -0.000725 375.8800n -0.000643 375.8900n -0.000581
+ 375.9000n -0.000540 375.9100n -0.000520 375.9200n -0.000522 375.9300n -0.000543 375.9400n -0.000584 375.9500n -0.000641 375.9600n -0.000714 375.9700n -0.000799 375.9800n -0.000893 375.9900n -0.000994 376.0000n -0.001098 376.0100n -0.001201 376.0200n -0.001300 376.0300n -0.001392 376.0400n -0.001474
+ 376.0500n -0.001542 376.0600n -0.001594 376.0700n -0.001628 376.0800n -0.001641 376.0900n -0.001633 376.1000n -0.001602 376.1100n -0.001548 376.1200n -0.001470 376.1300n -0.001371 376.1400n -0.001251 376.1500n -0.001111 376.1600n -0.000954 376.1700n -0.000783 376.1800n -0.000601 376.1900n -0.000410
+ 376.2000n -0.000215 376.2100n -0.000020 376.2200n 0.000172 376.2300n 0.000358 376.2400n 0.000532 376.2500n 0.000692 376.2600n 0.000834 376.2700n 0.000955 376.2800n 0.001053 376.2900n 0.001125 376.3000n 0.001169 376.3100n 0.001184 376.3200n 0.001171 376.3300n 0.001127 376.3400n 0.001055
+ 376.3500n 0.000955 376.3600n 0.000828 376.3700n 0.000677 376.3800n 0.000504 376.3900n 0.000313 376.4000n 0.000106 376.4100n -0.000113 376.4200n -0.000340 376.4300n -0.000571 376.4400n -0.000802 376.4500n -0.001028 376.4600n -0.001247 376.4700n -0.001455 376.4800n -0.001647 376.4900n -0.001821
+ 376.5000n -0.001975 376.5100n -0.002105 376.5200n -0.002210 376.5300n -0.002288 376.5400n -0.002340 376.5500n -0.002364 376.5600n -0.002360 376.5700n -0.002331 376.5800n -0.002276 376.5900n -0.002198 376.6000n -0.002099 376.6100n -0.001982 376.6200n -0.001849 376.6300n -0.001703 376.6400n -0.001549
+ 376.6500n -0.001389 376.6600n -0.001227 376.6700n -0.001066 376.6800n -0.000911 376.6900n -0.000764 376.7000n -0.000629 376.7100n -0.000507 376.7200n -0.000403 376.7300n -0.000318 376.7400n -0.000253 376.7500n -0.000211 376.7600n -0.000192 376.7700n -0.000196 376.7800n -0.000224 376.7900n -0.000275
+ 376.8000n -0.000348 376.8100n -0.000442 376.8200n -0.000556 376.8300n -0.000686 376.8400n -0.000832 376.8500n -0.000991 376.8600n -0.001159 376.8700n -0.001334 376.8800n -0.001512 376.8900n -0.001692 376.9000n -0.001870 376.9100n -0.002043 376.9200n -0.002207 376.9300n -0.002362 376.9400n -0.002502
+ 376.9500n -0.002628 376.9600n -0.002736 376.9700n -0.002825 376.9800n -0.002893 376.9900n -0.002940 377.0000n -0.002964 377.0100n -0.002964 377.0200n -0.002942 377.0300n -0.002896 377.0400n -0.002827 377.0500n -0.002737 377.0600n -0.002625 377.0700n -0.002494 377.0800n -0.002345 377.0900n -0.002179
+ 377.1000n -0.001998 377.1100n -0.001805 377.1200n -0.001601 377.1300n -0.001388 377.1400n -0.001170 377.1500n -0.000948 377.1600n -0.000724 377.1700n -0.000502 377.1800n -0.000283 377.1900n -0.000069 377.2000n 0.000137 377.2100n 0.000334 377.2200n 0.000519 377.2300n 0.000690 377.2400n 0.000847
+ 377.2500n 0.000986 377.2600n 0.001108 377.2700n 0.001211 377.2800n 0.001293 377.2900n 0.001355 377.3000n 0.001396 377.3100n 0.001415 377.3200n 0.001412 377.3300n 0.001388 377.3400n 0.001343 377.3500n 0.001277 377.3600n 0.001192 377.3700n 0.001088 377.3800n 0.000967 377.3900n 0.000831
+ 377.4000n 0.000680 377.4100n 0.000518 377.4200n 0.000346 377.4300n 0.000166 377.4400n -0.000019 377.4500n -0.000207 377.4600n -0.000395 377.4700n -0.000581 377.4800n -0.000762 377.4900n -0.000934 377.5000n -0.001097 377.5100n -0.001247 377.5200n -0.001382 377.5300n -0.001500 377.5400n -0.001599
+ 377.5500n -0.001677 377.5600n -0.001733 377.5700n -0.001765 377.5800n -0.001773 377.5900n -0.001755 377.6000n -0.001713 377.6100n -0.001645 377.6200n -0.001553 377.6300n -0.001437 377.6400n -0.001299 377.6500n -0.001139 377.6600n -0.000961 377.6700n -0.000766 377.6800n -0.000556 377.6900n -0.000334
+ 377.7000n -0.000104 377.7100n 0.000133 377.7200n 0.000372 377.7300n 0.000611 377.7400n 0.000847 377.7500n 0.001076 377.7600n 0.001296 377.7700n 0.001503 377.7800n 0.001696 377.7900n 0.001871 377.8000n 0.002026 377.8100n 0.002160 377.8200n 0.002271 377.8300n 0.002359 377.8400n 0.002421
+ 377.8500n 0.002458 377.8600n 0.002469 377.8700n 0.002456 377.8800n 0.002418 377.8900n 0.002356 377.9000n 0.002273 377.9100n 0.002169 377.9200n 0.002047 377.9300n 0.001908 377.9400n 0.001755 377.9500n 0.001589 377.9600n 0.001415 377.9700n 0.001232 377.9800n 0.001046 377.9900n 0.000856
+ 378.0000n 0.000666 378.0100n 0.000479 378.0200n 0.000294 378.0300n 0.000115 378.0400n -0.000057 378.0500n -0.000220 378.0600n -0.000375 378.0700n -0.000521 378.0800n -0.000656 378.0900n -0.000781 378.1000n -0.000895 378.1100n -0.000999 378.1200n -0.001094 378.1300n -0.001180 378.1400n -0.001257
+ 378.1500n -0.001327 378.1600n -0.001390 378.1700n -0.001447 378.1800n -0.001499 378.1900n -0.001546 378.2000n -0.001591 378.2100n -0.001632 378.2200n -0.001671 378.2300n -0.001708 378.2400n -0.001743 378.2500n -0.001775 378.2600n -0.001806 378.2700n -0.001833 378.2800n -0.001858 378.2900n -0.001878
+ 378.3000n -0.001894 378.3100n -0.001904 378.3200n -0.001907 378.3300n -0.001902 378.3400n -0.001888 378.3500n -0.001864 378.3600n -0.001829 378.3700n -0.001782 378.3800n -0.001722 378.3900n -0.001648 378.4000n -0.001561 378.4100n -0.001459 378.4200n -0.001343 378.4300n -0.001213 378.4400n -0.001070
+ 378.4500n -0.000914 378.4600n -0.000747 378.4700n -0.000569 378.4800n -0.000383 378.4900n -0.000189 378.5000n 0.000010 378.5100n 0.000212 378.5200n 0.000414 378.5300n 0.000615 378.5400n 0.000813 378.5500n 0.001005 378.5600n 0.001188 378.5700n 0.001361 378.5800n 0.001522 378.5900n 0.001669
+ 378.6000n 0.001800 378.6100n 0.001914 378.6200n 0.002010 378.6300n 0.002088 378.6400n 0.002145 378.6500n 0.002184 378.6600n 0.002203 378.6700n 0.002203 378.6800n 0.002186 378.6900n 0.002151 378.7000n 0.002100 378.7100n 0.002036 378.7200n 0.001959 378.7300n 0.001871 378.7400n 0.001774
+ 378.7500n 0.001671 378.7600n 0.001563 378.7700n 0.001453 378.7800n 0.001342 378.7900n 0.001232 378.8000n 0.001124 378.8100n 0.001021 378.8200n 0.000923 378.8300n 0.000832 378.8400n 0.000748 378.8500n 0.000672 378.8600n 0.000604 378.8700n 0.000544 378.8800n 0.000492 378.8900n 0.000448
+ 378.9000n 0.000410 378.9100n 0.000378 378.9200n 0.000351 378.9300n 0.000328 378.9400n 0.000307 378.9500n 0.000288 378.9600n 0.000269 378.9700n 0.000250 378.9800n 0.000228 378.9900n 0.000204 379.0000n 0.000175 379.0100n 0.000143 379.0200n 0.000106 379.0300n 0.000063 379.0400n 0.000016
+ 379.0500n -0.000036 379.0600n -0.000092 379.0700n -0.000152 379.0800n -0.000215 379.0900n -0.000279 379.1000n -0.000344 379.1100n -0.000408 379.1200n -0.000470 379.1300n -0.000528 379.1400n -0.000581 379.1500n -0.000628 379.1600n -0.000667 379.1700n -0.000696 379.1800n -0.000716 379.1900n -0.000725
+ 379.2000n -0.000722 379.2100n -0.000707 379.2200n -0.000680 379.2300n -0.000642 379.2400n -0.000591 379.2500n -0.000530 379.2600n -0.000458 379.2700n -0.000378 379.2800n -0.000291 379.2900n -0.000197 379.3000n -0.000100 379.3100n -0.000001 379.3200n 0.000098 379.3300n 0.000195 379.3400n 0.000288
+ 379.3500n 0.000375 379.3600n 0.000454 379.3700n 0.000523 379.3800n 0.000581 379.3900n 0.000626 379.4000n 0.000657 379.4100n 0.000674 379.4200n 0.000676 379.4300n 0.000662 379.4400n 0.000633 379.4500n 0.000590 379.4600n 0.000533 379.4700n 0.000462 379.4800n 0.000381 379.4900n 0.000289
+ 379.5000n 0.000189 379.5100n 0.000083 379.5200n -0.000027 379.5300n -0.000139 379.5400n -0.000251 379.5500n -0.000360 379.5600n -0.000465 379.5700n -0.000563 379.5800n -0.000653 379.5900n -0.000733 379.6000n -0.000802 379.6100n -0.000859 379.6200n -0.000903 379.6300n -0.000933 379.6400n -0.000950
+ 379.6500n -0.000953 379.6600n -0.000944 379.6700n -0.000922 379.6800n -0.000890 379.6900n -0.000848 379.7000n -0.000797 379.7100n -0.000741 379.7200n -0.000680 379.7300n -0.000617 379.7400n -0.000553 379.7500n -0.000491 379.7600n -0.000432 379.7700n -0.000379 379.7800n -0.000332 379.7900n -0.000295
+ 379.8000n -0.000267 379.8100n -0.000249 379.8200n -0.000243 379.8300n -0.000249 379.8400n -0.000267 379.8500n -0.000297 379.8600n -0.000338 379.8700n -0.000389 379.8800n -0.000449 379.8900n -0.000518 379.9000n -0.000593 379.9100n -0.000672 379.9200n -0.000755 379.9300n -0.000839 379.9400n -0.000922
+ 379.9500n -0.001002 379.9600n -0.001077 379.9700n -0.001146 379.9800n -0.001207 379.9900n -0.001258 380.0000n -0.001299 380.0100n -0.001329 380.0200n -0.001346 380.0300n -0.001351 380.0400n -0.001343 380.0500n -0.001322 380.0600n -0.001290 380.0700n -0.001247 380.0800n -0.001193 380.0900n -0.001130
+ 380.1000n -0.001060 380.1100n -0.000984 380.1200n -0.000903 380.1300n -0.000820 380.1400n -0.000736 380.1500n -0.000652 380.1600n -0.000570 380.1700n -0.000492 380.1800n -0.000420 380.1900n -0.000353 380.2000n -0.000293 380.2100n -0.000240 380.2200n -0.000195 380.2300n -0.000159 380.2400n -0.000130
+ 380.2500n -0.000108 380.2600n -0.000093 380.2700n -0.000083 380.2800n -0.000078 380.2900n -0.000076 380.3000n -0.000076 380.3100n -0.000076 380.3200n -0.000075 380.3300n -0.000071 380.3400n -0.000063 380.3500n -0.000050 380.3600n -0.000029 380.3700n -0.000000 380.3800n 0.000037 380.3900n 0.000083
+ 380.4000n 0.000139 380.4100n 0.000204 380.4200n 0.000278 380.4300n 0.000361 380.4400n 0.000450 380.4500n 0.000546 380.4600n 0.000647 380.4700n 0.000751 380.4800n 0.000855 380.4900n 0.000958 380.5000n 0.001058 380.5100n 0.001153 380.5200n 0.001240 380.5300n 0.001317 380.5400n 0.001382
+ 380.5500n 0.001433 380.5600n 0.001469 380.5700n 0.001489 380.5800n 0.001491 380.5900n 0.001475 380.6000n 0.001440 380.6100n 0.001388 380.6200n 0.001317 380.6300n 0.001230 380.6400n 0.001127 380.6500n 0.001011 380.6600n 0.000883 380.6700n 0.000746 380.6800n 0.000602 380.6900n 0.000455
+ 380.7000n 0.000306 380.7100n 0.000160 380.7200n 0.000019 380.7300n -0.000115 380.7400n -0.000237 380.7500n -0.000346 380.7600n -0.000438 380.7700n -0.000513 380.7800n -0.000569 380.7900n -0.000603 380.8000n -0.000616 380.8100n -0.000607 380.8200n -0.000577 380.8300n -0.000525 380.8400n -0.000453
+ 380.8500n -0.000363 380.8600n -0.000257 380.8700n -0.000137 380.8800n -0.000005 380.8900n 0.000134 380.9000n 0.000278 380.9100n 0.000424 380.9200n 0.000568 380.9300n 0.000706 380.9400n 0.000836 380.9500n 0.000953 380.9600n 0.001056 380.9700n 0.001141 380.9800n 0.001206 380.9900n 0.001249
+ 381.0000n 0.001270 381.0100n 0.001267 381.0200n 0.001239 381.0300n 0.001188 381.0400n 0.001114 381.0500n 0.001018 381.0600n 0.000902 381.0700n 0.000769 381.0800n 0.000620 381.0900n 0.000460 381.1000n 0.000291 381.1100n 0.000118 381.1200n -0.000057 381.1300n -0.000230 381.1400n -0.000396
+ 381.1500n -0.000553 381.1600n -0.000696 381.1700n -0.000823 381.1800n -0.000931 381.1900n -0.001017 381.2000n -0.001081 381.2100n -0.001119 381.2200n -0.001133 381.2300n -0.001121 381.2400n -0.001083 381.2500n -0.001022 381.2600n -0.000938 381.2700n -0.000833 381.2800n -0.000710 381.2900n -0.000573
+ 381.3000n -0.000423 381.3100n -0.000266 381.3200n -0.000104 381.3300n 0.000058 381.3400n 0.000216 381.3500n 0.000366 381.3600n 0.000504 381.3700n 0.000627 381.3800n 0.000731 381.3900n 0.000813 381.4000n 0.000872 381.4100n 0.000904 381.4200n 0.000909 381.4300n 0.000885 381.4400n 0.000833
+ 381.4500n 0.000753 381.4600n 0.000645 381.4700n 0.000512 381.4800n 0.000355 381.4900n 0.000177 381.5000n -0.000018 381.5100n -0.000228 381.5200n -0.000448 381.5300n -0.000674 381.5400n -0.000903 381.5500n -0.001129 381.5600n -0.001350 381.5700n -0.001560 381.5800n -0.001756 381.5900n -0.001934
+ 381.6000n -0.002091 381.6100n -0.002224 381.6200n -0.002332 381.6300n -0.002412 381.6400n -0.002463 381.6500n -0.002484 381.6600n -0.002477 381.6700n -0.002440 381.6800n -0.002376 381.6900n -0.002287 381.7000n -0.002174 381.7100n -0.002040 381.7200n -0.001888 381.7300n -0.001722 381.7400n -0.001546
+ 381.7500n -0.001362 381.7600n -0.001175 381.7700n -0.000989 381.7800n -0.000807 381.7900n -0.000633 381.8000n -0.000470 381.8100n -0.000321 381.8200n -0.000188 381.8300n -0.000073 381.8400n 0.000021 381.8500n 0.000095 381.8600n 0.000147 381.8700n 0.000178 381.8800n 0.000188 381.8900n 0.000178
+ 381.9000n 0.000150 381.9100n 0.000105 381.9200n 0.000047 381.9300n -0.000023 381.9400n -0.000101 381.9500n -0.000185 381.9600n -0.000270 381.9700n -0.000355 381.9800n -0.000436 381.9900n -0.000510 382.0000n -0.000574 382.0100n -0.000627 382.0200n -0.000664 382.0300n -0.000686 382.0400n -0.000691
+ 382.0500n -0.000678 382.0600n -0.000646 382.0700n -0.000596 382.0800n -0.000528 382.0900n -0.000444 382.1000n -0.000345 382.1100n -0.000233 382.1200n -0.000111 382.1300n 0.000020 382.1400n 0.000155 382.1500n 0.000292 382.1600n 0.000428 382.1700n 0.000560 382.1800n 0.000684 382.1900n 0.000798
+ 382.2000n 0.000898 382.2100n 0.000983 382.2200n 0.001049 382.2300n 0.001095 382.2400n 0.001119 382.2500n 0.001121 382.2600n 0.001101 382.2700n 0.001057 382.2800n 0.000991 382.2900n 0.000903 382.3000n 0.000795 382.3100n 0.000670 382.3200n 0.000529 382.3300n 0.000374 382.3400n 0.000210
+ 382.3500n 0.000039 382.3600n -0.000135 382.3700n -0.000309 382.3800n -0.000480 382.3900n -0.000643 382.4000n -0.000796 382.4100n -0.000934 382.4200n -0.001056 382.4300n -0.001159 382.4400n -0.001240 382.4500n -0.001298 382.4600n -0.001330 382.4700n -0.001337 382.4800n -0.001318 382.4900n -0.001272
+ 382.5000n -0.001201 382.5100n -0.001105 382.5200n -0.000985 382.5300n -0.000845 382.5400n -0.000686 382.5500n -0.000510 382.5600n -0.000321 382.5700n -0.000122 382.5800n 0.000085 382.5900n 0.000294 382.6000n 0.000504 382.6100n 0.000711 382.6200n 0.000910 382.6300n 0.001100 382.6400n 0.001277
+ 382.6500n 0.001438 382.6600n 0.001581 382.6700n 0.001704 382.6800n 0.001805 382.6900n 0.001882 382.7000n 0.001935 382.7100n 0.001963 382.7200n 0.001965 382.7300n 0.001943 382.7400n 0.001896 382.7500n 0.001825 382.7600n 0.001732 382.7700n 0.001618 382.7800n 0.001485 382.7900n 0.001334
+ 382.8000n 0.001168 382.8100n 0.000989 382.8200n 0.000799 382.8300n 0.000601 382.8400n 0.000396 382.8500n 0.000188 382.8600n -0.000021 382.8700n -0.000231 382.8800n -0.000437 382.8900n -0.000639 382.9000n -0.000836 382.9100n -0.001024 382.9200n -0.001204 382.9300n -0.001373 382.9400n -0.001531
+ 382.9500n -0.001678 382.9600n -0.001811 382.9700n -0.001932 382.9800n -0.002038 382.9900n -0.002131 383.0000n -0.002210 383.0100n -0.002275 383.0200n -0.002325 383.0300n -0.002362 383.0400n -0.002384 383.0500n -0.002392 383.0600n -0.002387 383.0700n -0.002368 383.0800n -0.002335 383.0900n -0.002289
+ 383.1000n -0.002230 383.1100n -0.002158 383.1200n -0.002073 383.1300n -0.001976 383.1400n -0.001867 383.1500n -0.001746 383.1600n -0.001614 383.1700n -0.001472 383.1800n -0.001320 383.1900n -0.001159 383.2000n -0.000990 383.2100n -0.000814 383.2200n -0.000632 383.2300n -0.000446 383.2400n -0.000256
+ 383.2500n -0.000065 383.2600n 0.000127 383.2700n 0.000316 383.2800n 0.000502 383.2900n 0.000683 383.3000n 0.000856 383.3100n 0.001020 383.3200n 0.001172 383.3300n 0.001312 383.3400n 0.001438 383.3500n 0.001546 383.3600n 0.001638 383.3700n 0.001710 383.3800n 0.001761 383.3900n 0.001792
+ 383.4000n 0.001801 383.4100n 0.001789 383.4200n 0.001754 383.4300n 0.001697 383.4400n 0.001619 383.4500n 0.001521 383.4600n 0.001403 383.4700n 0.001267 383.4800n 0.001115 383.4900n 0.000949 383.5000n 0.000771 383.5100n 0.000583 383.5200n 0.000387 383.5300n 0.000188 383.5400n -0.000014
+ 383.5500n -0.000215 383.5600n -0.000411 383.5700n -0.000602 383.5800n -0.000783 383.5900n -0.000952 383.6000n -0.001107 383.6100n -0.001245 383.6200n -0.001365 383.6300n -0.001465 383.6400n -0.001543 383.6500n -0.001598 383.6600n -0.001629 383.6700n -0.001635 383.6800n -0.001617 383.6900n -0.001574
+ 383.7000n -0.001507 383.7100n -0.001416 383.7200n -0.001303 383.7300n -0.001168 383.7400n -0.001014 383.7500n -0.000842 383.7600n -0.000654 383.7700n -0.000453 383.7800n -0.000240 383.7900n -0.000019 383.8000n 0.000209 383.8100n 0.000441 383.8200n 0.000673 383.8300n 0.000904 383.8400n 0.001130
+ 383.8500n 0.001350 383.8600n 0.001560 383.8700n 0.001759 383.8800n 0.001944 383.8900n 0.002113 383.9000n 0.002265 383.9100n 0.002397 383.9200n 0.002509 383.9300n 0.002599 383.9400n 0.002666 383.9500n 0.002709 383.9600n 0.002728 383.9700n 0.002723 383.9800n 0.002693 383.9900n 0.002638
+ 384.0000n 0.002560 384.0100n 0.002458 384.0200n 0.002334 384.0300n 0.002189 384.0400n 0.002023 384.0500n 0.001838 384.0600n 0.001637 384.0700n 0.001420 384.0800n 0.001189 384.0900n 0.000948 384.1000n 0.000697 384.1100n 0.000439 384.1200n 0.000178 384.1300n -0.000086 384.1400n -0.000350
+ 384.1500n -0.000610 384.1600n -0.000865 384.1700n -0.001112 384.1800n -0.001349 384.1900n -0.001573 384.2000n -0.001782 384.2100n -0.001974 384.2200n -0.002147 384.2300n -0.002300 384.2400n -0.002431 384.2500n -0.002538 384.2600n -0.002620 384.2700n -0.002678 384.2800n -0.002709 384.2900n -0.002715
+ 384.3000n -0.002694 384.3100n -0.002648 384.3200n -0.002577 384.3300n -0.002482 384.3400n -0.002364 384.3500n -0.002225 384.3600n -0.002067 384.3700n -0.001891 384.3800n -0.001701 384.3900n -0.001497 384.4000n -0.001283 384.4100n -0.001062 384.4200n -0.000836 384.4300n -0.000608 384.4400n -0.000380
+ 384.4500n -0.000156 384.4600n 0.000063 384.4700n 0.000273 384.4800n 0.000472 384.4900n 0.000659 384.5000n 0.000832 384.5100n 0.000988 384.5200n 0.001128 384.5300n 0.001249 384.5400n 0.001352 384.5500n 0.001436 384.5600n 0.001501 384.5700n 0.001547 384.5800n 0.001576 384.5900n 0.001589
+ 384.6000n 0.001586 384.6100n 0.001570 384.6200n 0.001542 384.6300n 0.001504 384.6400n 0.001458 384.6500n 0.001407 384.6600n 0.001352 384.6700n 0.001297 384.6800n 0.001243 384.6900n 0.001193 384.7000n 0.001148 384.7100n 0.001111 384.7200n 0.001083 384.7300n 0.001065 384.7400n 0.001059
+ 384.7500n 0.001066 384.7600n 0.001085 384.7700n 0.001119 384.7800n 0.001165 384.7900n 0.001225 384.8000n 0.001296 384.8100n 0.001379 384.8200n 0.001472 384.8300n 0.001574 384.8400n 0.001682 384.8500n 0.001795 384.8600n 0.001911 384.8700n 0.002028 384.8800n 0.002143 384.8900n 0.002255
+ 384.9000n 0.002360 384.9100n 0.002458 384.9200n 0.002546 384.9300n 0.002622 384.9400n 0.002684 384.9500n 0.002732 384.9600n 0.002763 384.9700n 0.002778 384.9800n 0.002775 384.9900n 0.002754 385.0000n 0.002715 385.0100n 0.002658 385.0200n 0.002584 385.0300n 0.002494 385.0400n 0.002387
+ 385.0500n 0.002267 385.0600n 0.002133 385.0700n 0.001988 385.0800n 0.001834 385.0900n 0.001672 385.1000n 0.001504 385.1100n 0.001332 385.1200n 0.001158 385.1300n 0.000984 385.1400n 0.000812 385.1500n 0.000644 385.1600n 0.000481 385.1700n 0.000325 385.1800n 0.000178 385.1900n 0.000040
+ 385.2000n -0.000088 385.2100n -0.000204 385.2200n -0.000309 385.2300n -0.000400 385.2400n -0.000479 385.2500n -0.000544 385.2600n -0.000597 385.2700n -0.000636 385.2800n -0.000663 385.2900n -0.000677 385.3000n -0.000680 385.3100n -0.000671 385.3200n -0.000651 385.3300n -0.000621 385.3400n -0.000582
+ 385.3500n -0.000534 385.3600n -0.000478 385.3700n -0.000415 385.3800n -0.000346 385.3900n -0.000271 385.4000n -0.000190 385.4100n -0.000106 385.4200n -0.000018 385.4300n 0.000074 385.4400n 0.000167 385.4500n 0.000262 385.4600n 0.000358 385.4700n 0.000453 385.4800n 0.000548 385.4900n 0.000642
+ 385.5000n 0.000734 385.5100n 0.000823 385.5200n 0.000908 385.5300n 0.000988 385.5400n 0.001064 385.5500n 0.001133 385.5600n 0.001195 385.5700n 0.001250 385.5800n 0.001296 385.5900n 0.001334 385.6000n 0.001361 385.6100n 0.001379 385.6200n 0.001387 385.6300n 0.001384 385.6400n 0.001370
+ 385.6500n 0.001345 385.6600n 0.001310 385.6700n 0.001265 385.6800n 0.001211 385.6900n 0.001148 385.7000n 0.001077 385.7100n 0.000999 385.7200n 0.000915 385.7300n 0.000828 385.7400n 0.000738 385.7500n 0.000647 385.7600n 0.000556 385.7700n 0.000468 385.7800n 0.000383 385.7900n 0.000304
+ 385.8000n 0.000232 385.8100n 0.000169 385.8200n 0.000116 385.8300n 0.000073 385.8400n 0.000042 385.8500n 0.000024 385.8600n 0.000018 385.8700n 0.000025 385.8800n 0.000045 385.8900n 0.000077 385.9000n 0.000120 385.9100n 0.000173 385.9200n 0.000235 385.9300n 0.000303 385.9400n 0.000377
+ 385.9500n 0.000453 385.9600n 0.000529 385.9700n 0.000603 385.9800n 0.000673 385.9900n 0.000735 386.0000n 0.000788 386.0100n 0.000829 386.0200n 0.000855 386.0300n 0.000865 386.0400n 0.000857 386.0500n 0.000830 386.0600n 0.000782 386.0700n 0.000713 386.0800n 0.000623 386.0900n 0.000512
+ 386.1000n 0.000381 386.1100n 0.000231 386.1200n 0.000063 386.1300n -0.000119 386.1400n -0.000315 386.1500n -0.000519 386.1600n -0.000731 386.1700n -0.000945 386.1800n -0.001158 386.1900n -0.001367 386.2000n -0.001566 386.2100n -0.001753 386.2200n -0.001924 386.2300n -0.002075 386.2400n -0.002202
+ 386.2500n -0.002302 386.2600n -0.002374 386.2700n -0.002414 386.2800n -0.002421 386.2900n -0.002394 386.3000n -0.002332 386.3100n -0.002236 386.3200n -0.002106 386.3300n -0.001943 386.3400n -0.001751 386.3500n -0.001530 386.3600n -0.001285 386.3700n -0.001019 386.3800n -0.000736 386.3900n -0.000440
+ 386.4000n -0.000136 386.4100n 0.000170 386.4200n 0.000475 386.4300n 0.000773 386.4400n 0.001060 386.4500n 0.001331 386.4600n 0.001581 386.4700n 0.001807 386.4800n 0.002005 386.4900n 0.002172 386.5000n 0.002307 386.5100n 0.002407 386.5200n 0.002471 386.5300n 0.002500 386.5400n 0.002493
+ 386.5500n 0.002451 386.5600n 0.002376 386.5700n 0.002271 386.5800n 0.002139 386.5900n 0.001982 386.6000n 0.001804 386.6100n 0.001611 386.6200n 0.001406 386.6300n 0.001193 386.6400n 0.000978 386.6500n 0.000765 386.6600n 0.000558 386.6700n 0.000361 386.6800n 0.000179 386.6900n 0.000015
+ 386.7000n -0.000128 386.7100n -0.000249 386.7200n -0.000344 386.7300n -0.000414 386.7400n -0.000457 386.7500n -0.000474 386.7600n -0.000465 386.7700n -0.000433 386.7800n -0.000378 386.7900n -0.000304 386.8000n -0.000214 386.8100n -0.000111 386.8200n 0.000001 386.8300n 0.000119 386.8400n 0.000238
+ 386.8500n 0.000354 386.8600n 0.000464 386.8700n 0.000563 386.8800n 0.000648 386.8900n 0.000717 386.9000n 0.000766 386.9100n 0.000793 386.9200n 0.000798 386.9300n 0.000779 386.9400n 0.000736 386.9500n 0.000669 386.9600n 0.000580 386.9700n 0.000471 386.9800n 0.000344 386.9900n 0.000201
+ 387.0000n 0.000047 387.0100n -0.000115 387.0200n -0.000281 387.0300n -0.000447 387.0400n -0.000606 387.0500n -0.000757 387.0600n -0.000893 387.0700n -0.001011 387.0800n -0.001106 387.0900n -0.001176 387.1000n -0.001217 387.1100n -0.001228 387.1200n -0.001205 387.1300n -0.001148 387.1400n -0.001058
+ 387.1500n -0.000933 387.1600n -0.000777 387.1700n -0.000590 387.1800n -0.000375 387.1900n -0.000136 387.2000n 0.000123 387.2100n 0.000398 387.2200n 0.000684 387.2300n 0.000975 387.2400n 0.001266 387.2500n 0.001550 387.2600n 0.001823 387.2700n 0.002079 387.2800n 0.002312 387.2900n 0.002518
+ 387.3000n 0.002692 387.3100n 0.002829 387.3200n 0.002928 387.3300n 0.002985 387.3400n 0.002999 387.3500n 0.002969 387.3600n 0.002894 387.3700n 0.002776 387.3800n 0.002617 387.3900n 0.002418 387.4000n 0.002184 387.4100n 0.001919 387.4200n 0.001626 387.4300n 0.001313 387.4400n 0.000983
+ 387.4500n 0.000643 387.4600n 0.000300 387.4700n -0.000040 387.4800n -0.000372 387.4900n -0.000689 387.5000n -0.000985 387.5100n -0.001255 387.5200n -0.001495 387.5300n -0.001700 387.5400n -0.001867 387.5500n -0.001993 387.5600n -0.002078 387.5700n -0.002119 387.5800n -0.002117 387.5900n -0.002073
+ 387.6000n -0.001988 387.6100n -0.001866 387.6200n -0.001709 387.6300n -0.001523 387.6400n -0.001310 387.6500n -0.001078 387.6600n -0.000830 387.6700n -0.000574 387.6800n -0.000314 387.6900n -0.000058 387.7000n 0.000189 387.7100n 0.000422 387.7200n 0.000635 387.7300n 0.000823 387.7400n 0.000982
+ 387.7500n 0.001108 387.7600n 0.001198 387.7700n 0.001250 387.7800n 0.001263 387.7900n 0.001236 387.8000n 0.001170 387.8100n 0.001065 387.8200n 0.000923 387.8300n 0.000748 387.8400n 0.000542 387.8500n 0.000310 387.8600n 0.000055 387.8700n -0.000217 387.8800n -0.000500 387.8900n -0.000790
+ 387.9000n -0.001082 387.9100n -0.001369 387.9200n -0.001646 387.9300n -0.001908 387.9400n -0.002151 387.9500n -0.002369 387.9600n -0.002560 387.9700n -0.002720 387.9800n -0.002846 387.9900n -0.002937 388.0000n -0.002991 388.0100n -0.003009 388.0200n -0.002989 388.0300n -0.002934 388.0400n -0.002844
+ 388.0500n -0.002722 388.0600n -0.002572 388.0700n -0.002395 388.0800n -0.002197 388.0900n -0.001980 388.1000n -0.001749 388.1100n -0.001509 388.1200n -0.001264 388.1300n -0.001018 388.1400n -0.000776 388.1500n -0.000541 388.1600n -0.000318 388.1700n -0.000109 388.1800n 0.000083 388.1900n 0.000254
+ 388.2000n 0.000404 388.2100n 0.000530 388.2200n 0.000633 388.2300n 0.000711 388.2400n 0.000765 388.2500n 0.000796 388.2600n 0.000804 388.2700n 0.000792 388.2800n 0.000762 388.2900n 0.000716 388.3000n 0.000656 388.3100n 0.000585 388.3200n 0.000506 388.3300n 0.000423 388.3400n 0.000337
+ 388.3500n 0.000252 388.3600n 0.000171 388.3700n 0.000095 388.3800n 0.000027 388.3900n -0.000031 388.4000n -0.000077 388.4100n -0.000111 388.4200n -0.000131 388.4300n -0.000138 388.4400n -0.000130 388.4500n -0.000109 388.4600n -0.000074 388.4700n -0.000027 388.4800n 0.000032 388.4900n 0.000100
+ 388.5000n 0.000177 388.5100n 0.000261 388.5200n 0.000350 388.5300n 0.000442 388.5400n 0.000535 388.5500n 0.000628 388.5600n 0.000719 388.5700n 0.000807 388.5800n 0.000889 388.5900n 0.000966 388.6000n 0.001035 388.6100n 0.001096 388.6200n 0.001149 388.6300n 0.001193 388.6400n 0.001227
+ 388.6500n 0.001253 388.6600n 0.001270 388.6700n 0.001278 388.6800n 0.001279 388.6900n 0.001272 388.7000n 0.001259 388.7100n 0.001240 388.7200n 0.001215 388.7300n 0.001187 388.7400n 0.001155 388.7500n 0.001120 388.7600n 0.001083 388.7700n 0.001044 388.7800n 0.001003 388.7900n 0.000962
+ 388.8000n 0.000920 388.8100n 0.000876 388.8200n 0.000832 388.8300n 0.000787 388.8400n 0.000741 388.8500n 0.000693 388.8600n 0.000643 388.8700n 0.000592 388.8800n 0.000537 388.8900n 0.000480 388.9000n 0.000421 388.9100n 0.000358 388.9200n 0.000292 388.9300n 0.000223 388.9400n 0.000151
+ 388.9500n 0.000077 388.9600n 0.000001 388.9700n -0.000076 388.9800n -0.000153 388.9900n -0.000231 389.0000n -0.000306 389.0100n -0.000379 389.0200n -0.000448 389.0300n -0.000512 389.0400n -0.000570 389.0500n -0.000620 389.0600n -0.000661 389.0700n -0.000693 389.0800n -0.000714 389.0900n -0.000723
+ 389.1000n -0.000720 389.1100n -0.000705 389.1200n -0.000677 389.1300n -0.000637 389.1400n -0.000584 389.1500n -0.000519 389.1600n -0.000444 389.1700n -0.000358 389.1800n -0.000264 389.1900n -0.000163 389.2000n -0.000057 389.2100n 0.000053 389.2200n 0.000164 389.2300n 0.000275 389.2400n 0.000383
+ 389.2500n 0.000486 389.2600n 0.000583 389.2700n 0.000672 389.2800n 0.000750 389.2900n 0.000817 389.3000n 0.000870 389.3100n 0.000910 389.3200n 0.000934 389.3300n 0.000944 389.3400n 0.000938 389.3500n 0.000917 389.3600n 0.000881 389.3700n 0.000831 389.3800n 0.000768 389.3900n 0.000695
+ 389.4000n 0.000612 389.4100n 0.000521 389.4200n 0.000424 389.4300n 0.000324 389.4400n 0.000222 389.4500n 0.000122 389.4600n 0.000024 389.4700n -0.000068 389.4800n -0.000153 389.4900n -0.000229 389.5000n -0.000294 389.5100n -0.000348 389.5200n -0.000389 389.5300n -0.000416 389.5400n -0.000430
+ 389.5500n -0.000430 389.5600n -0.000417 389.5700n -0.000391 389.5800n -0.000354 389.5900n -0.000308 389.6000n -0.000253 389.6100n -0.000192 389.6200n -0.000127 389.6300n -0.000060 389.6400n 0.000006 389.6500n 0.000069 389.6600n 0.000127 389.6700n 0.000177 389.6800n 0.000217 389.6900n 0.000245
+ 389.7000n 0.000259 389.7100n 0.000259 389.7200n 0.000242 389.7300n 0.000209 389.7400n 0.000158 389.7500n 0.000090 389.7600n 0.000005 389.7700n -0.000095 389.7800n -0.000210 389.7900n -0.000338 389.8000n -0.000476 389.8100n -0.000624 389.8200n -0.000777 389.8300n -0.000935 389.8400n -0.001092
+ 389.8500n -0.001247 389.8600n -0.001397 389.8700n -0.001539 389.8800n -0.001669 389.8900n -0.001786 389.9000n -0.001886 389.9100n -0.001968 389.9200n -0.002030 389.9300n -0.002071 389.9400n -0.002088 389.9500n -0.002083 389.9600n -0.002054 389.9700n -0.002002 389.9800n -0.001927 389.9900n -0.001832
+ 390.0000n -0.001716 390.0100n -0.001583 390.0200n -0.001434 390.0300n -0.001272 390.0400n -0.001100 390.0500n -0.000921 390.0600n -0.000738 390.0700n -0.000554 390.0800n -0.000372 390.0900n -0.000196 390.1000n -0.000027 390.1100n 0.000130 390.1200n 0.000274 390.1300n 0.000402 390.1400n 0.000513
+ 390.1500n 0.000605 390.1600n 0.000678 390.1700n 0.000729 390.1800n 0.000760 390.1900n 0.000770 390.2000n 0.000759 390.2100n 0.000730 390.2200n 0.000684 390.2300n 0.000621 390.2400n 0.000544 390.2500n 0.000456 390.2600n 0.000359 390.2700n 0.000255 390.2800n 0.000147 390.2900n 0.000038
+ 390.3000n -0.000070 390.3100n -0.000173 390.3200n -0.000269 390.3300n -0.000357 390.3400n -0.000433 390.3500n -0.000496 390.3600n -0.000545 390.3700n -0.000579 390.3800n -0.000595 390.3900n -0.000595 390.4000n -0.000577 390.4100n -0.000543 390.4200n -0.000491 390.4300n -0.000424 390.4400n -0.000343
+ 390.4500n -0.000248 390.4600n -0.000141 390.4700n -0.000024 390.4800n 0.000101 390.4900n 0.000231 390.5000n 0.000366 390.5100n 0.000502 390.5200n 0.000638 390.5300n 0.000772 390.5400n 0.000901 390.5500n 0.001025 390.5600n 0.001141 390.5700n 0.001248 390.5800n 0.001344 390.5900n 0.001429
+ 390.6000n 0.001503 390.6100n 0.001563 390.6200n 0.001611 390.6300n 0.001646 390.6400n 0.001668 390.6500n 0.001678 390.6600n 0.001676 390.6700n 0.001662 390.6800n 0.001638 390.6900n 0.001605 390.7000n 0.001564 390.7100n 0.001515 390.7200n 0.001461 390.7300n 0.001402 390.7400n 0.001339
+ 390.7500n 0.001274 390.7600n 0.001208 390.7700n 0.001142 390.7800n 0.001076 390.7900n 0.001013 390.8000n 0.000953 390.8100n 0.000896 390.8200n 0.000844 390.8300n 0.000797 390.8400n 0.000755 390.8500n 0.000720 390.8600n 0.000690 390.8700n 0.000668 390.8800n 0.000652 390.8900n 0.000643
+ 390.9000n 0.000641 390.9100n 0.000646 390.9200n 0.000658 390.9300n 0.000677 390.9400n 0.000702 390.9500n 0.000733 390.9600n 0.000771 390.9700n 0.000814 390.9800n 0.000862 390.9900n 0.000915 391.0000n 0.000972 391.0100n 0.001032 391.0200n 0.001095 391.0300n 0.001159 391.0400n 0.001225
+ 391.0500n 0.001290 391.0600n 0.001355 391.0700n 0.001417 391.0800n 0.001476 391.0900n 0.001530 391.1000n 0.001578 391.1100n 0.001619 391.1200n 0.001652 391.1300n 0.001676 391.1400n 0.001689 391.1500n 0.001690 391.1600n 0.001678 391.1700n 0.001653 391.1800n 0.001614 391.1900n 0.001560
+ 391.2000n 0.001491 391.2100n 0.001407 391.2200n 0.001308 391.2300n 0.001195 391.2400n 0.001069 391.2500n 0.000930 391.2600n 0.000780 391.2700n 0.000620 391.2800n 0.000453 391.2900n 0.000280 391.3000n 0.000103 391.3100n -0.000074 391.3200n -0.000249 391.3300n -0.000420 391.3400n -0.000583
+ 391.3500n -0.000735 391.3600n -0.000875 391.3700n -0.000999 391.3800n -0.001104 391.3900n -0.001189 391.4000n -0.001250 391.4100n -0.001287 391.4200n -0.001298 391.4300n -0.001282 391.4400n -0.001238 391.4500n -0.001166 391.4600n -0.001066 391.4700n -0.000940 391.4800n -0.000789 391.4900n -0.000614
+ 391.5000n -0.000418 391.5100n -0.000204 391.5200n 0.000025 391.5300n 0.000267 391.5400n 0.000516 391.5500n 0.000768 391.5600n 0.001021 391.5700n 0.001269 391.5800n 0.001508 391.5900n 0.001733 391.6000n 0.001941 391.6100n 0.002128 391.6200n 0.002290 391.6300n 0.002423 391.6400n 0.002526
+ 391.6500n 0.002596 391.6600n 0.002630 391.6700n 0.002629 391.6800n 0.002591 391.6900n 0.002517 391.7000n 0.002407 391.7100n 0.002263 391.7200n 0.002088 391.7300n 0.001882 391.7400n 0.001651 391.7500n 0.001397 391.7600n 0.001125 391.7700n 0.000839 391.7800n 0.000544 391.7900n 0.000244
+ 391.8000n -0.000054 391.8100n -0.000347 391.8200n -0.000628 391.8300n -0.000895 391.8400n -0.001141 391.8500n -0.001363 391.8600n -0.001557 391.8700n -0.001721 391.8800n -0.001851 391.8900n -0.001945 391.9000n -0.002003 391.9100n -0.002023 391.9200n -0.002006 391.9300n -0.001953 391.9400n -0.001864
+ 391.9500n -0.001741 391.9600n -0.001589 391.9700n -0.001408 391.9800n -0.001204 391.9900n -0.000979 392.0000n -0.000739 392.0100n -0.000487 392.0200n -0.000229 392.0300n 0.000031 392.0400n 0.000288 392.0500n 0.000539 392.0600n 0.000778 392.0700n 0.001001 392.0800n 0.001206 392.0900n 0.001389
+ 392.1000n 0.001547 392.1100n 0.001678 392.1200n 0.001782 392.1300n 0.001855 392.1400n 0.001900 392.1500n 0.001915 392.1600n 0.001901 392.1700n 0.001860 392.1800n 0.001793 392.1900n 0.001703 392.2000n 0.001592 392.2100n 0.001464 392.2200n 0.001320 392.2300n 0.001166 392.2400n 0.001003
+ 392.2500n 0.000835 392.2600n 0.000666 392.2700n 0.000499 392.2800n 0.000337 392.2900n 0.000182 392.3000n 0.000037 392.3100n -0.000096 392.3200n -0.000215 392.3300n -0.000320 392.3400n -0.000408 392.3500n -0.000481 392.3600n -0.000537 392.3700n -0.000578 392.3800n -0.000604 392.3900n -0.000616
+ 392.4000n -0.000615 392.4100n -0.000604 392.4200n -0.000583 392.4300n -0.000555 392.4400n -0.000523 392.4500n -0.000487 392.4600n -0.000450 392.4700n -0.000414 392.4800n -0.000380 392.4900n -0.000350 392.5000n -0.000325 392.5100n -0.000306 392.5200n -0.000294 392.5300n -0.000290 392.5400n -0.000292
+ 392.5500n -0.000302 392.5600n -0.000318 392.5700n -0.000340 392.5800n -0.000367 392.5900n -0.000397 392.6000n -0.000429 392.6100n -0.000461 392.6200n -0.000493 392.6300n -0.000521 392.6400n -0.000546 392.6500n -0.000565 392.6600n -0.000576 392.6700n -0.000579 392.6800n -0.000573 392.6900n -0.000557
+ 392.7000n -0.000530 392.7100n -0.000492 392.7200n -0.000444 392.7300n -0.000386 392.7400n -0.000318 392.7500n -0.000242 392.7600n -0.000159 392.7700n -0.000070 392.7800n 0.000023 392.7900n 0.000118 392.8000n 0.000213 392.8100n 0.000306 392.8200n 0.000395 392.8300n 0.000479 392.8400n 0.000556
+ 392.8500n 0.000623 392.8600n 0.000680 392.8700n 0.000726 392.8800n 0.000760 392.8900n 0.000781 392.9000n 0.000789 392.9100n 0.000784 392.9200n 0.000768 392.9300n 0.000741 392.9400n 0.000704 392.9500n 0.000659 392.9600n 0.000608 392.9700n 0.000554 392.9800n 0.000497 392.9900n 0.000442
+ 393.0000n 0.000390 393.0100n 0.000345 393.0200n 0.000308 393.0300n 0.000282 393.0400n 0.000270 393.0500n 0.000272 393.0600n 0.000292 393.0700n 0.000330 393.0800n 0.000387 393.0900n 0.000463 393.1000n 0.000560 393.1100n 0.000675 393.1200n 0.000809 393.1300n 0.000959 393.1400n 0.001124
+ 393.1500n 0.001302 393.1600n 0.001490 393.1700n 0.001685 393.1800n 0.001884 393.1900n 0.002082 393.2000n 0.002277 393.2100n 0.002464 393.2200n 0.002640 393.2300n 0.002801 393.2400n 0.002943 393.2500n 0.003064 393.2600n 0.003160 393.2700n 0.003229 393.2800n 0.003267 393.2900n 0.003275
+ 393.3000n 0.003250 393.3100n 0.003192 393.3200n 0.003101 393.3300n 0.002977 393.3400n 0.002822 393.3500n 0.002636 393.3600n 0.002423 393.3700n 0.002186 393.3800n 0.001926 393.3900n 0.001648 393.4000n 0.001356 393.4100n 0.001053 393.4200n 0.000745 393.4300n 0.000435 393.4400n 0.000127
+ 393.4500n -0.000173 393.4600n -0.000463 393.4700n -0.000737 393.4800n -0.000992 393.4900n -0.001226 393.5000n -0.001435 393.5100n -0.001617 393.5200n -0.001771 393.5300n -0.001894 393.5400n -0.001987 393.5500n -0.002049 393.5600n -0.002081 393.5700n -0.002083 393.5800n -0.002058 393.5900n -0.002006
+ 393.6000n -0.001931 393.6100n -0.001835 393.6200n -0.001722 393.6300n -0.001593 393.6400n -0.001454 393.6500n -0.001307 393.6600n -0.001156 393.6700n -0.001005 393.6800n -0.000857 393.6900n -0.000715 393.7000n -0.000582 393.7100n -0.000460 393.7200n -0.000353 393.7300n -0.000262 393.7400n -0.000189
+ 393.7500n -0.000135 393.7600n -0.000100 393.7700n -0.000085 393.7800n -0.000090 393.7900n -0.000114 393.8000n -0.000156 393.8100n -0.000216 393.8200n -0.000292 393.8300n -0.000381 393.8400n -0.000482 393.8500n -0.000593 393.8600n -0.000712 393.8700n -0.000835 393.8800n -0.000962 393.8900n -0.001089
+ 393.9000n -0.001214 393.9100n -0.001336 393.9200n -0.001452 393.9300n -0.001561 393.9400n -0.001660 393.9500n -0.001750 393.9600n -0.001827 393.9700n -0.001893 393.9800n -0.001946 393.9900n -0.001985 394.0000n -0.002011 394.0100n -0.002023 394.0200n -0.002022 394.0300n -0.002008 394.0400n -0.001981
+ 394.0500n -0.001943 394.0600n -0.001892 394.0700n -0.001831 394.0800n -0.001760 394.0900n -0.001680 394.1000n -0.001590 394.1100n -0.001492 394.1200n -0.001387 394.1300n -0.001274 394.1400n -0.001155 394.1500n -0.001029 394.1600n -0.000898 394.1700n -0.000761 394.1800n -0.000618 394.1900n -0.000471
+ 394.2000n -0.000319 394.2100n -0.000162 394.2200n -0.000002 394.2300n 0.000162 394.2400n 0.000329 394.2500n 0.000499 394.2600n 0.000670 394.2700n 0.000842 394.2800n 0.001013 394.2900n 0.001183 394.3000n 0.001350 394.3100n 0.001513 394.3200n 0.001671 394.3300n 0.001821 394.3400n 0.001962
+ 394.3500n 0.002093 394.3600n 0.002211 394.3700n 0.002315 394.3800n 0.002403 394.3900n 0.002474 394.4000n 0.002527 394.4100n 0.002560 394.4200n 0.002573 394.4300n 0.002564 394.4400n 0.002533 394.4500n 0.002481 394.4600n 0.002407 394.4700n 0.002312 394.4800n 0.002197 394.4900n 0.002064
+ 394.5000n 0.001913 394.5100n 0.001748 394.5200n 0.001569 394.5300n 0.001380 394.5400n 0.001184 394.5500n 0.000984 394.5600n 0.000782 394.5700n 0.000582 394.5800n 0.000388 394.5900n 0.000201 394.6000n 0.000027 394.6100n -0.000133 394.6200n -0.000276 394.6300n -0.000400 394.6400n -0.000501
+ 394.6500n -0.000579 394.6600n -0.000632 394.6700n -0.000658 394.6800n -0.000659 394.6900n -0.000633 394.7000n -0.000582 394.7100n -0.000505 394.7200n -0.000406 394.7300n -0.000285 394.7400n -0.000145 394.7500n 0.000012 394.7600n 0.000181 394.7700n 0.000361 394.7800n 0.000548 394.7900n 0.000737
+ 394.8000n 0.000926 394.8100n 0.001111 394.8200n 0.001289 394.8300n 0.001455 394.8400n 0.001607 394.8500n 0.001742 394.8600n 0.001858 394.8700n 0.001952 394.8800n 0.002023 394.8900n 0.002070 394.9000n 0.002092 394.9100n 0.002088 394.9200n 0.002060 394.9300n 0.002007 394.9400n 0.001932
+ 394.9500n 0.001836 394.9600n 0.001720 394.9700n 0.001588 394.9800n 0.001442 394.9900n 0.001286 395.0000n 0.001121 395.0100n 0.000953 395.0200n 0.000783 395.0300n 0.000615 395.0400n 0.000452 395.0500n 0.000298 395.0600n 0.000154 395.0700n 0.000024 395.0800n -0.000091 395.0900n -0.000189
+ 395.1000n -0.000269 395.1100n -0.000331 395.1200n -0.000372 395.1300n -0.000395 395.1400n -0.000398 395.1500n -0.000384 395.1600n -0.000353 395.1700n -0.000308 395.1800n -0.000250 395.1900n -0.000181 395.2000n -0.000103 395.2100n -0.000021 395.2200n 0.000065 395.2300n 0.000151 395.2400n 0.000235
+ 395.2500n 0.000314 395.2600n 0.000385 395.2700n 0.000448 395.2800n 0.000500 395.2900n 0.000539 395.3000n 0.000565 395.3100n 0.000576 395.3200n 0.000573 395.3300n 0.000555 395.3400n 0.000522 395.3500n 0.000476 395.3600n 0.000418 395.3700n 0.000348 395.3800n 0.000269 395.3900n 0.000182
+ 395.4000n 0.000091 395.4100n -0.000004 395.4200n -0.000100 395.4300n -0.000195 395.4400n -0.000285 395.4500n -0.000370 395.4600n -0.000447 395.4700n -0.000514 395.4800n -0.000570 395.4900n -0.000613 395.5000n -0.000642 395.5100n -0.000658 395.5200n -0.000659 395.5300n -0.000647 395.5400n -0.000620
+ 395.5500n -0.000580 395.5600n -0.000529 395.5700n -0.000467 395.5800n -0.000397 395.5900n -0.000320 395.6000n -0.000238 395.6100n -0.000154 395.6200n -0.000070 395.6300n 0.000012 395.6400n 0.000090 395.6500n 0.000161 395.6600n 0.000224 395.6700n 0.000277 395.6800n 0.000318 395.6900n 0.000345
+ 395.7000n 0.000359 395.7100n 0.000358 395.7200n 0.000343 395.7300n 0.000312 395.7400n 0.000268 395.7500n 0.000210 395.7600n 0.000139 395.7700n 0.000058 395.7800n -0.000033 395.7900n -0.000130 395.8000n -0.000233 395.8100n -0.000338 395.8200n -0.000444 395.8300n -0.000548 395.8400n -0.000648
+ 395.8500n -0.000741 395.8600n -0.000825 395.8700n -0.000899 395.8800n -0.000959 395.8900n -0.001006 395.9000n -0.001037 395.9100n -0.001052 395.9200n -0.001051 395.9300n -0.001032 395.9400n -0.000996 395.9500n -0.000944 395.9600n -0.000877 395.9700n -0.000795 395.9800n -0.000701 395.9900n -0.000596
+ 396.0000n -0.000481 396.0100n -0.000360 396.0200n -0.000235 396.0300n -0.000108 396.0400n 0.000019 396.0500n 0.000143 396.0600n 0.000261 396.0700n 0.000371 396.0800n 0.000470 396.0900n 0.000558 396.1000n 0.000631 396.1100n 0.000688 396.1200n 0.000728 396.1300n 0.000750 396.1400n 0.000753
+ 396.1500n 0.000737 396.1600n 0.000701 396.1700n 0.000646 396.1800n 0.000572 396.1900n 0.000480 396.2000n 0.000371 396.2100n 0.000247 396.2200n 0.000108 396.2300n -0.000043 396.2400n -0.000205 396.2500n -0.000375 396.2600n -0.000552 396.2700n -0.000734 396.2800n -0.000918 396.2900n -0.001102
+ 396.3000n -0.001286 396.3100n -0.001466 396.3200n -0.001641 396.3300n -0.001809 396.3400n -0.001969 396.3500n -0.002119 396.3600n -0.002259 396.3700n -0.002387 396.3800n -0.002503 396.3900n -0.002606 396.4000n -0.002694 396.4100n -0.002769 396.4200n -0.002830 396.4300n -0.002876 396.4400n -0.002908
+ 396.4500n -0.002926 396.4600n -0.002930 396.4700n -0.002921 396.4800n -0.002899 396.4900n -0.002863 396.5000n -0.002816 396.5100n -0.002757 396.5200n -0.002687 396.5300n -0.002607 396.5400n -0.002516 396.5500n -0.002417 396.5600n -0.002309 396.5700n -0.002192 396.5800n -0.002069 396.5900n -0.001939
+ 396.6000n -0.001804 396.6100n -0.001664 396.6200n -0.001520 396.6300n -0.001372 396.6400n -0.001223 396.6500n -0.001073 396.6600n -0.000923 396.6700n -0.000774 396.6800n -0.000627 396.6900n -0.000483 396.7000n -0.000344 396.7100n -0.000211 396.7200n -0.000085 396.7300n 0.000033 396.7400n 0.000142
+ 396.7500n 0.000241 396.7600n 0.000329 396.7700n 0.000405 396.7800n 0.000468 396.7900n 0.000518 396.8000n 0.000555 396.8100n 0.000578 396.8200n 0.000587 396.8300n 0.000583 396.8400n 0.000566 396.8500n 0.000536 396.8600n 0.000494 396.8700n 0.000441 396.8800n 0.000379 396.8900n 0.000308
+ 396.9000n 0.000230 396.9100n 0.000147 396.9200n 0.000060 396.9300n -0.000030 396.9400n -0.000119 396.9500n -0.000207 396.9600n -0.000291 396.9700n -0.000371 396.9800n -0.000444 396.9900n -0.000509 397.0000n -0.000565 397.0100n -0.000611 397.0200n -0.000645 397.0300n -0.000667 397.0400n -0.000677
+ 397.0500n -0.000673 397.0600n -0.000658 397.0700n -0.000629 397.0800n -0.000589 397.0900n -0.000537 397.1000n -0.000475 397.1100n -0.000403 397.1200n -0.000323 397.1300n -0.000237 397.1400n -0.000145 397.1500n -0.000050 397.1600n 0.000048 397.1700n 0.000146 397.1800n 0.000244 397.1900n 0.000339
+ 397.2000n 0.000432 397.2100n 0.000519 397.2200n 0.000601 397.2300n 0.000678 397.2400n 0.000747 397.2500n 0.000810 397.2600n 0.000865 397.2700n 0.000914 397.2800n 0.000956 397.2900n 0.000993 397.3000n 0.001024 397.3100n 0.001051 397.3200n 0.001075 397.3300n 0.001097 397.3400n 0.001119
+ 397.3500n 0.001141 397.3600n 0.001166 397.3700n 0.001194 397.3800n 0.001226 397.3900n 0.001263 397.4000n 0.001308 397.4100n 0.001359 397.4200n 0.001418 397.4300n 0.001484 397.4400n 0.001559 397.4500n 0.001642 397.4600n 0.001732 397.4700n 0.001829 397.4800n 0.001931 397.4900n 0.002038
+ 397.5000n 0.002147 397.5100n 0.002259 397.5200n 0.002370 397.5300n 0.002479 397.5400n 0.002584 397.5500n 0.002683 397.5600n 0.002775 397.5700n 0.002857 397.5800n 0.002928 397.5900n 0.002987 397.6000n 0.003031 397.6100n 0.003060 397.6200n 0.003074 397.6300n 0.003070 397.6400n 0.003051
+ 397.6500n 0.003014 397.6600n 0.002961 397.6700n 0.002893 397.6800n 0.002811 397.6900n 0.002715 397.7000n 0.002608 397.7100n 0.002491 397.7200n 0.002367 397.7300n 0.002238 397.7400n 0.002105 397.7500n 0.001972 397.7600n 0.001841 397.7700n 0.001715 397.7800n 0.001594 397.7900n 0.001483
+ 397.8000n 0.001382 397.8100n 0.001294 397.8200n 0.001219 397.8300n 0.001159 397.8400n 0.001115 397.8500n 0.001087 397.8600n 0.001075 397.8700n 0.001079 397.8800n 0.001098 397.8900n 0.001131 397.9000n 0.001177 397.9100n 0.001235 397.9200n 0.001301 397.9300n 0.001375 397.9400n 0.001453
+ 397.9500n 0.001534 397.9600n 0.001614 397.9700n 0.001692 397.9800n 0.001764 397.9900n 0.001829 398.0000n 0.001883 398.0100n 0.001926 398.0200n 0.001955 398.0300n 0.001969 398.0400n 0.001967 398.0500n 0.001947 398.0600n 0.001910 398.0700n 0.001855 398.0800n 0.001783 398.0900n 0.001694
+ 398.1000n 0.001589 398.1100n 0.001471 398.1200n 0.001340 398.1300n 0.001199 398.1400n 0.001050 398.1500n 0.000895 398.1600n 0.000737 398.1700n 0.000579 398.1800n 0.000423 398.1900n 0.000272 398.2000n 0.000128 398.2100n -0.000005 398.2200n -0.000127 398.2300n -0.000234 398.2400n -0.000326
+ 398.2500n -0.000400 398.2600n -0.000457 398.2700n -0.000494 398.2800n -0.000513 398.2900n -0.000512 398.3000n -0.000493 398.3100n -0.000457 398.3200n -0.000404 398.3300n -0.000336 398.3400n -0.000255 398.3500n -0.000163 398.3600n -0.000062 398.3700n 0.000045 398.3800n 0.000157 398.3900n 0.000270
+ 398.4000n 0.000383 398.4100n 0.000492 398.4200n 0.000596 398.4300n 0.000693 398.4400n 0.000780 398.4500n 0.000857 398.4600n 0.000921 398.4700n 0.000972 398.4800n 0.001008 398.4900n 0.001031 398.5000n 0.001039 398.5100n 0.001033 398.5200n 0.001013 398.5300n 0.000981 398.5400n 0.000938
+ 398.5500n 0.000884 398.5600n 0.000822 398.5700n 0.000753 398.5800n 0.000680 398.5900n 0.000604 398.6000n 0.000527 398.6100n 0.000452 398.6200n 0.000379 398.6300n 0.000312 398.6400n 0.000251 398.6500n 0.000198 398.6600n 0.000155 398.6700n 0.000122 398.6800n 0.000101 398.6900n 0.000091
+ 398.7000n 0.000093 398.7100n 0.000107 398.7200n 0.000133 398.7300n 0.000170 398.7400n 0.000217 398.7500n 0.000274 398.7600n 0.000338 398.7700n 0.000410 398.7800n 0.000486 398.7900n 0.000567 398.8000n 0.000649 398.8100n 0.000731 398.8200n 0.000813 398.8300n 0.000891 398.8400n 0.000965
+ 398.8500n 0.001034 398.8600n 0.001095 398.8700n 0.001148 398.8800n 0.001192 398.8900n 0.001227 398.9000n 0.001251 398.9100n 0.001265 398.9200n 0.001268 398.9300n 0.001260 398.9400n 0.001242 398.9500n 0.001215 398.9600n 0.001178 398.9700n 0.001132 398.9800n 0.001078 398.9900n 0.001018
+ 399.0000n 0.000952 399.0100n 0.000880 399.0200n 0.000805 399.0300n 0.000727 399.0400n 0.000647 399.0500n 0.000565 399.0600n 0.000484 399.0700n 0.000402 399.0800n 0.000322 399.0900n 0.000244 399.1000n 0.000167 399.1100n 0.000093 399.1200n 0.000022 399.1300n -0.000047 399.1400n -0.000113
+ 399.1500n -0.000175 399.1600n -0.000235 399.1700n -0.000292 399.1800n -0.000346 399.1900n -0.000397 399.2000n -0.000446 399.2100n -0.000493 399.2200n -0.000537 399.2300n -0.000579 399.2400n -0.000619 399.2500n -0.000656 399.2600n -0.000691 399.2700n -0.000722 399.2800n -0.000751 399.2900n -0.000777
+ 399.3000n -0.000799 399.3100n -0.000816 399.3200n -0.000830 399.3300n -0.000839 399.3400n -0.000842 399.3500n -0.000840 399.3600n -0.000832 399.3700n -0.000818 399.3800n -0.000798 399.3900n -0.000772 399.4000n -0.000739 399.4100n -0.000700 399.4200n -0.000656 399.4300n -0.000605 399.4400n -0.000550
+ 399.4500n -0.000491 399.4600n -0.000428 399.4700n -0.000362 399.4800n -0.000294 399.4900n -0.000225 399.5000n -0.000156 399.5100n -0.000089 399.5200n -0.000024 399.5300n 0.000038 399.5400n 0.000095 399.5500n 0.000147 399.5600n 0.000192 399.5700n 0.000231 399.5800n 0.000261 399.5900n 0.000284
+ 399.6000n 0.000298 399.6100n 0.000302 399.6200n 0.000299 399.6300n 0.000286 399.6400n 0.000265 399.6500n 0.000237 399.6600n 0.000201 399.6700n 0.000159 399.6800n 0.000112 399.6900n 0.000061 399.7000n 0.000006 399.7100n -0.000050 399.7200n -0.000106 399.7300n -0.000162 399.7400n -0.000216
+ 399.7500n -0.000267 399.7600n -0.000313 399.7700n -0.000355 399.7800n -0.000390 399.7900n -0.000419 399.8000n -0.000441 399.8100n -0.000455 399.8200n -0.000462 399.8300n -0.000461 399.8400n -0.000454 399.8500n -0.000441 399.8600n -0.000422 399.8700n -0.000398 399.8800n -0.000372 399.8900n -0.000342
+ 399.9000n -0.000313 399.9100n -0.000283 399.9200n -0.000256 399.9300n -0.000233 399.9400n -0.000214 399.9500n -0.000203 399.9600n -0.000199 399.9700n -0.000204 399.9800n -0.000219 399.9900n -0.000245 400.0000n -0.000282 400.0100n -0.000332 400.0200n -0.000394 400.0300n -0.000468 400.0400n -0.000553
+ 400.0500n -0.000650 400.0600n -0.000757 400.0700n -0.000873 400.0800n -0.000998 400.0900n -0.001129 400.1000n -0.001265 400.1100n -0.001404 400.1200n -0.001544 400.1300n -0.001684 400.1400n -0.001822 400.1500n -0.001955 400.1600n -0.002081 400.1700n -0.002200 400.1800n -0.002309 400.1900n -0.002407
+ 400.2000n -0.002492 400.2100n -0.002563 400.2200n -0.002620 400.2300n -0.002662 400.2400n -0.002687 400.2500n -0.002697 400.2600n -0.002691 400.2700n -0.002670 400.2800n -0.002634 400.2900n -0.002583 400.3000n -0.002520 400.3100n -0.002444 400.3200n -0.002358 400.3300n -0.002263 400.3400n -0.002161
+ 400.3500n -0.002052 400.3600n -0.001939 400.3700n -0.001824 400.3800n -0.001707 400.3900n -0.001591 400.4000n -0.001477 400.4100n -0.001366 400.4200n -0.001260 400.4300n -0.001159 400.4400n -0.001065 400.4500n -0.000979 400.4600n -0.000900 400.4700n -0.000829 400.4800n -0.000767 400.4900n -0.000713
+ 400.5000n -0.000668 400.5100n -0.000632 400.5200n -0.000603 400.5300n -0.000582 400.5400n -0.000567 400.5500n -0.000559 400.5600n -0.000557 400.5700n -0.000560 400.5800n -0.000566 400.5900n -0.000577 400.6000n -0.000590 400.6100n -0.000606 400.6200n -0.000623 400.6300n -0.000641 400.6400n -0.000659
+ 400.6500n -0.000677 400.6600n -0.000695 400.6700n -0.000712 400.6800n -0.000728 400.6900n -0.000742 400.7000n -0.000754 400.7100n -0.000765 400.7200n -0.000773 400.7300n -0.000779 400.7400n -0.000783 400.7500n -0.000784 400.7600n -0.000781 400.7700n -0.000776 400.7800n -0.000767 400.7900n -0.000755
+ 400.8000n -0.000739 400.8100n -0.000718 400.8200n -0.000693 400.8300n -0.000662 400.8400n -0.000627 400.8500n -0.000586 400.8600n -0.000539 400.8700n -0.000487 400.8800n -0.000428 400.8900n -0.000363 400.9000n -0.000291 400.9100n -0.000214 400.9200n -0.000130 400.9300n -0.000041 400.9400n 0.000054
+ 400.9500n 0.000153 400.9600n 0.000257 400.9700n 0.000363 400.9800n 0.000472 400.9900n 0.000583 401.0000n 0.000693 401.0100n 0.000802 401.0200n 0.000910 401.0300n 0.001013 401.0400n 0.001112 401.0500n 0.001205 401.0600n 0.001291 401.0700n 0.001368 401.0800n 0.001436 401.0900n 0.001494
+ 401.1000n 0.001541 401.1100n 0.001577 401.1200n 0.001601 401.1300n 0.001614 401.1400n 0.001614 401.1500n 0.001604 401.1600n 0.001583 401.1700n 0.001552 401.1800n 0.001512 401.1900n 0.001465 401.2000n 0.001412 401.2100n 0.001355 401.2200n 0.001296 401.2300n 0.001235 401.2400n 0.001176
+ 401.2500n 0.001119 401.2600n 0.001068 401.2700n 0.001023 401.2800n 0.000986 401.2900n 0.000960 401.3000n 0.000944 401.3100n 0.000940 401.3200n 0.000950 401.3300n 0.000972 401.3400n 0.001008 401.3500n 0.001058 401.3600n 0.001120 401.3700n 0.001195 401.3800n 0.001280 401.3900n 0.001375
+ 401.4000n 0.001477 401.4100n 0.001585 401.4200n 0.001697 401.4300n 0.001810 401.4400n 0.001922 401.4500n 0.002030 401.4600n 0.002132 401.4700n 0.002226 401.4800n 0.002308 401.4900n 0.002377 401.5000n 0.002432 401.5100n 0.002470 401.5200n 0.002489 401.5300n 0.002490 401.5400n 0.002471
+ 401.5500n 0.002433 401.5600n 0.002375 401.5700n 0.002298 401.5800n 0.002204 401.5900n 0.002093 401.6000n 0.001967 401.6100n 0.001830 401.6200n 0.001682 401.6300n 0.001527 401.6400n 0.001369 401.6500n 0.001208 401.6600n 0.001050 401.6700n 0.000897 401.6800n 0.000751 401.6900n 0.000616
+ 401.7000n 0.000494 401.7100n 0.000388 401.7200n 0.000299 401.7300n 0.000229 401.7400n 0.000180 401.7500n 0.000151 401.7600n 0.000143 401.7700n 0.000155 401.7800n 0.000187 401.7900n 0.000238 401.8000n 0.000305 401.8100n 0.000386 401.8200n 0.000479 401.8300n 0.000581 401.8400n 0.000688
+ 401.8500n 0.000797 401.8600n 0.000905 401.8700n 0.001008 401.8800n 0.001102 401.8900n 0.001185 401.9000n 0.001252 401.9100n 0.001302 401.9200n 0.001331 401.9300n 0.001338 401.9400n 0.001321 401.9500n 0.001279 401.9600n 0.001212 401.9700n 0.001119 401.9800n 0.001003 401.9900n 0.000863
+ 402.0000n 0.000703 402.0100n 0.000524 402.0200n 0.000330 402.0300n 0.000125 402.0400n -0.000089 402.0500n -0.000306 402.0600n -0.000522 402.0700n -0.000732 402.0800n -0.000933 402.0900n -0.001118 402.1000n -0.001285 402.1100n -0.001428 402.1200n -0.001545 402.1300n -0.001631 402.1400n -0.001684
+ 402.1500n -0.001702 402.1600n -0.001683 402.1700n -0.001627 402.1800n -0.001533 402.1900n -0.001402 402.2000n -0.001235 402.2100n -0.001034 402.2200n -0.000802 402.2300n -0.000543 402.2400n -0.000260 402.2500n 0.000042 402.2600n 0.000358 402.2700n 0.000683 402.2800n 0.001012 402.2900n 0.001339
+ 402.3000n 0.001658 402.3100n 0.001964 402.3200n 0.002252 402.3300n 0.002517 402.3400n 0.002755 402.3500n 0.002961 402.3600n 0.003132 402.3700n 0.003266 402.3800n 0.003361 402.3900n 0.003415 402.4000n 0.003428 402.4100n 0.003401 402.4200n 0.003335 402.4300n 0.003231 402.4400n 0.003092
+ 402.4500n 0.002922 402.4600n 0.002725 402.4700n 0.002504 402.4800n 0.002265 402.4900n 0.002013 402.5000n 0.001753 402.5100n 0.001491 402.5200n 0.001231 402.5300n 0.000980 402.5400n 0.000742 402.5500n 0.000521 402.5600n 0.000323 402.5700n 0.000150 402.5800n 0.000006 402.5900n -0.000106
+ 402.6000n -0.000186 402.6100n -0.000231 402.6200n -0.000242 402.6300n -0.000219 402.6400n -0.000164 402.6500n -0.000078 402.6600n 0.000037 402.6700n 0.000177 402.6800n 0.000339 402.6900n 0.000518 402.7000n 0.000711 402.7100n 0.000912 402.7200n 0.001118 402.7300n 0.001323 402.7400n 0.001523
+ 402.7500n 0.001714 402.7600n 0.001890 402.7700n 0.002049 402.7800n 0.002187 402.7900n 0.002301 402.8000n 0.002389 402.8100n 0.002449 402.8200n 0.002479 402.8300n 0.002481 402.8400n 0.002452 402.8500n 0.002396 402.8600n 0.002312 402.8700n 0.002203 402.8800n 0.002071 402.8900n 0.001919
+ 402.9000n 0.001750 402.9100n 0.001568 402.9200n 0.001377 402.9300n 0.001180 402.9400n 0.000982 402.9500n 0.000785 402.9600n 0.000594 402.9700n 0.000413 402.9800n 0.000243 402.9900n 0.000089 403.0000n -0.000048 403.0100n -0.000165 403.0200n -0.000262 403.0300n -0.000336 403.0400n -0.000389
+ 403.0500n -0.000419 403.0600n -0.000428 403.0700n -0.000416 403.0800n -0.000384 403.0900n -0.000336 403.1000n -0.000272 403.1100n -0.000195 403.1200n -0.000107 403.1300n -0.000012 403.1400n 0.000089 403.1500n 0.000192 403.1600n 0.000295 403.1700n 0.000396 403.1800n 0.000492 403.1900n 0.000581
+ 403.2000n 0.000662 403.2100n 0.000734 403.2200n 0.000796 403.2300n 0.000847 403.2400n 0.000886 403.2500n 0.000915 403.2600n 0.000934 403.2700n 0.000943 403.2800n 0.000944 403.2900n 0.000938 403.3000n 0.000928 403.3100n 0.000914 403.3200n 0.000898 403.3300n 0.000883 403.3400n 0.000870
+ 403.3500n 0.000862 403.3600n 0.000858 403.3700n 0.000862 403.3800n 0.000874 403.3900n 0.000895 403.4000n 0.000926 403.4100n 0.000966 403.4200n 0.001016 403.4300n 0.001075 403.4400n 0.001143 403.4500n 0.001218 403.4600n 0.001299 403.4700n 0.001384 403.4800n 0.001472 403.4900n 0.001560
+ 403.5000n 0.001645 403.5100n 0.001727 403.5200n 0.001802 403.5300n 0.001869 403.5400n 0.001925 403.5500n 0.001968 403.5600n 0.001997 403.5700n 0.002011 403.5800n 0.002007 403.5900n 0.001986 403.6000n 0.001947 403.6100n 0.001890 403.6200n 0.001815 403.6300n 0.001724 403.6400n 0.001616
+ 403.6500n 0.001495 403.6600n 0.001360 403.6700n 0.001216 403.6800n 0.001063 403.6900n 0.000904 403.7000n 0.000743 403.7100n 0.000580 403.7200n 0.000420 403.7300n 0.000265 403.7400n 0.000117 403.7500n -0.000022 403.7600n -0.000150 403.7700n -0.000264 403.7800n -0.000364 403.7900n -0.000449
+ 403.8000n -0.000517 403.8100n -0.000569 403.8200n -0.000605 403.8300n -0.000625 403.8400n -0.000630 403.8500n -0.000623 403.8600n -0.000603 403.8700n -0.000574 403.8800n -0.000538 403.8900n -0.000496 403.9000n -0.000452 403.9100n -0.000408 403.9200n -0.000366 403.9300n -0.000330 403.9400n -0.000301
+ 403.9500n -0.000281 403.9600n -0.000274 403.9700n -0.000280 403.9800n -0.000300 403.9900n -0.000336 404.0000n -0.000388 404.0100n -0.000457 404.0200n -0.000542 404.0300n -0.000643 404.0400n -0.000758 404.0500n -0.000886 404.0600n -0.001026 404.0700n -0.001175 404.0800n -0.001331 404.0900n -0.001491
+ 404.1000n -0.001653 404.1100n -0.001814 404.1200n -0.001972 404.1300n -0.002122 404.1400n -0.002264 404.1500n -0.002394 404.1600n -0.002510 404.1700n -0.002610 404.1800n -0.002693 404.1900n -0.002756 404.2000n -0.002799 404.2100n -0.002822 404.2200n -0.002823 404.2300n -0.002804 404.2400n -0.002765
+ 404.2500n -0.002707 404.2600n -0.002630 404.2700n -0.002537 404.2800n -0.002430 404.2900n -0.002309 404.3000n -0.002178 404.3100n -0.002040 404.3200n -0.001895 404.3300n -0.001747 404.3400n -0.001597 404.3500n -0.001448 404.3600n -0.001303 404.3700n -0.001162 404.3800n -0.001027 404.3900n -0.000899
+ 404.4000n -0.000780 404.4100n -0.000670 404.4200n -0.000569 404.4300n -0.000478 404.4400n -0.000396 404.4500n -0.000322 404.4600n -0.000255 404.4700n -0.000196 404.4800n -0.000141 404.4900n -0.000091 404.5000n -0.000043 404.5100n 0.000004 404.5200n 0.000052 404.5300n 0.000102 404.5400n 0.000154
+ 404.5500n 0.000212 404.5600n 0.000274 404.5700n 0.000343 404.5800n 0.000418 404.5900n 0.000500 404.6000n 0.000588 404.6100n 0.000683 404.6200n 0.000782 404.6300n 0.000887 404.6400n 0.000994 404.6500n 0.001103 404.6600n 0.001211 404.6700n 0.001317 404.6800n 0.001419 404.6900n 0.001515
+ 404.7000n 0.001603 404.7100n 0.001680 404.7200n 0.001744 404.7300n 0.001794 404.7400n 0.001829 404.7500n 0.001846 404.7600n 0.001844 404.7700n 0.001823 404.7800n 0.001783 404.7900n 0.001723 404.8000n 0.001644 404.8100n 0.001545 404.8200n 0.001429 404.8300n 0.001297 404.8400n 0.001150
+ 404.8500n 0.000990 404.8600n 0.000820 404.8700n 0.000642 404.8800n 0.000459 404.8900n 0.000273 404.9000n 0.000087 404.9100n -0.000096 404.9200n -0.000273 404.9300n -0.000441 404.9400n -0.000600 404.9500n -0.000745 404.9600n -0.000877 404.9700n -0.000992 404.9800n -0.001090 404.9900n -0.001171
+ 405.0000n -0.001233 405.0100n -0.001277 405.0200n -0.001303 405.0300n -0.001312 405.0400n -0.001305 405.0500n -0.001284 405.0600n -0.001250 405.0700n -0.001205 405.0800n -0.001151 405.0900n -0.001091 405.1000n -0.001027 405.1100n -0.000961 405.1200n -0.000896 405.1300n -0.000833 405.1400n -0.000775
+ 405.1500n -0.000724 405.1600n -0.000681 405.1700n -0.000647 405.1800n -0.000624 405.1900n -0.000612 405.2000n -0.000611 405.2100n -0.000622 405.2200n -0.000643 405.2300n -0.000674 405.2400n -0.000715 405.2500n -0.000762 405.2600n -0.000816 405.2700n -0.000874 405.2800n -0.000935 405.2900n -0.000995
+ 405.3000n -0.001054 405.3100n -0.001108 405.3200n -0.001156 405.3300n -0.001197 405.3400n -0.001228 405.3500n -0.001247 405.3600n -0.001255 405.3700n -0.001248 405.3800n -0.001228 405.3900n -0.001194 405.4000n -0.001146 405.4100n -0.001084 405.4200n -0.001009 405.4300n -0.000922 405.4400n -0.000825
+ 405.4500n -0.000719 405.4600n -0.000607 405.4700n -0.000489 405.4800n -0.000370 405.4900n -0.000250 405.5000n -0.000132 405.5100n -0.000019 405.5200n 0.000087 405.5300n 0.000185 405.5400n 0.000272 405.5500n 0.000346 405.5600n 0.000407 405.5700n 0.000454 405.5800n 0.000485 405.5900n 0.000500
+ 405.6000n 0.000499 405.6100n 0.000483 405.6200n 0.000453 405.6300n 0.000408 405.6400n 0.000352 405.6500n 0.000285 405.6600n 0.000209 405.6700n 0.000126 405.6800n 0.000039 405.6900n -0.000051 405.7000n -0.000141 405.7100n -0.000228 405.7200n -0.000312 405.7300n -0.000389 405.7400n -0.000458
+ 405.7500n -0.000518 405.7600n -0.000567 405.7700n -0.000604 405.7800n -0.000629 405.7900n -0.000641 405.8000n -0.000641 405.8100n -0.000628 405.8200n -0.000603 405.8300n -0.000568 405.8400n -0.000524 405.8500n -0.000472 405.8600n -0.000414 405.8700n -0.000351 405.8800n -0.000286 405.8900n -0.000221
+ 405.9000n -0.000158 405.9100n -0.000098 405.9200n -0.000043 405.9300n 0.000005 405.9400n 0.000044 405.9500n 0.000075 405.9600n 0.000095 405.9700n 0.000105 405.9800n 0.000105 405.9900n 0.000095 406.0000n 0.000074 406.0100n 0.000046 406.0200n 0.000010 406.0300n -0.000032 406.0400n -0.000078
+ 406.0500n -0.000125 406.0600n -0.000172 406.0700n -0.000216 406.0800n -0.000256 406.0900n -0.000287 406.1000n -0.000310 406.1100n -0.000320 406.1200n -0.000317 406.1300n -0.000298 406.1400n -0.000262 406.1500n -0.000209 406.1600n -0.000137 406.1700n -0.000047 406.1800n 0.000062 406.1900n 0.000188
+ 406.2000n 0.000331 406.2100n 0.000489 406.2200n 0.000661 406.2300n 0.000843 406.2400n 0.001034 406.2500n 0.001231 406.2600n 0.001430 406.2700n 0.001629 406.2800n 0.001824 406.2900n 0.002012 406.3000n 0.002190 406.3100n 0.002355 406.3200n 0.002504 406.3300n 0.002635 406.3400n 0.002746
+ 406.3500n 0.002834 406.3600n 0.002898 406.3700n 0.002939 406.3800n 0.002954 406.3900n 0.002945 406.4000n 0.002911 406.4100n 0.002855 406.4200n 0.002778 406.4300n 0.002681 406.4400n 0.002568 406.4500n 0.002441 406.4600n 0.002303 406.4700n 0.002158 406.4800n 0.002009 406.4900n 0.001859
+ 406.5000n 0.001713 406.5100n 0.001574 406.5200n 0.001445 406.5300n 0.001328 406.5400n 0.001228 406.5500n 0.001146 406.5600n 0.001085 406.5700n 0.001045 406.5800n 0.001028 406.5900n 0.001035 406.6000n 0.001065 406.6100n 0.001118 406.6200n 0.001194 406.6300n 0.001289 406.6400n 0.001403
+ 406.6500n 0.001533 406.6600n 0.001677 406.6700n 0.001830 406.6800n 0.001991 406.6900n 0.002154 406.7000n 0.002318 406.7100n 0.002479 406.7200n 0.002632 406.7300n 0.002775 406.7400n 0.002905 406.7500n 0.003019 406.7600n 0.003114 406.7700n 0.003189 406.7800n 0.003242 406.7900n 0.003272
+ 406.8000n 0.003278 406.8100n 0.003260 406.8200n 0.003219 406.8300n 0.003155 406.8400n 0.003070 406.8500n 0.002966 406.8600n 0.002845 406.8700n 0.002708 406.8800n 0.002560 406.8900n 0.002403 406.9000n 0.002239 406.9100n 0.002072 406.9200n 0.001906 406.9300n 0.001742 406.9400n 0.001584
+ 406.9500n 0.001434 406.9600n 0.001295 406.9700n 0.001169 406.9800n 0.001057 406.9900n 0.000960 407.0000n 0.000879 407.0100n 0.000814 407.0200n 0.000766 407.0300n 0.000733 407.0400n 0.000714 407.0500n 0.000708 407.0600n 0.000714 407.0700n 0.000729 407.0800n 0.000751 407.0900n 0.000777
+ 407.1000n 0.000805 407.1100n 0.000832 407.1200n 0.000856 407.1300n 0.000874 407.1400n 0.000883 407.1500n 0.000882 407.1600n 0.000869 407.1700n 0.000842 407.1800n 0.000800 407.1900n 0.000742 407.2000n 0.000669 407.2100n 0.000579 407.2200n 0.000474 407.2300n 0.000354 407.2400n 0.000222
+ 407.2500n 0.000078 407.2600n -0.000075 407.2700n -0.000234 407.2800n -0.000398 407.2900n -0.000562 407.3000n -0.000724 407.3100n -0.000881 407.3200n -0.001029 407.3300n -0.001167 407.3400n -0.001290 407.3500n -0.001396 407.3600n -0.001483 407.3700n -0.001548 407.3800n -0.001591 407.3900n -0.001609
+ 407.4000n -0.001601 407.4100n -0.001568 407.4200n -0.001509 407.4300n -0.001426 407.4400n -0.001317 407.4500n -0.001186 407.4600n -0.001034 407.4700n -0.000864 407.4800n -0.000676 407.4900n -0.000476 407.5000n -0.000264 407.5100n -0.000046 407.5200n 0.000177 407.5300n 0.000400 407.5400n 0.000622
+ 407.5500n 0.000837 407.5600n 0.001044 407.5700n 0.001240 407.5800n 0.001422 407.5900n 0.001588 407.6000n 0.001736 407.6100n 0.001864 407.6200n 0.001972 407.6300n 0.002058 407.6400n 0.002123 407.6500n 0.002166 407.6600n 0.002188 407.6700n 0.002189 407.6800n 0.002171 407.6900n 0.002135
+ 407.7000n 0.002083 407.7100n 0.002016 407.7200n 0.001936 407.7300n 0.001846 407.7400n 0.001747 407.7500n 0.001643 407.7600n 0.001533 407.7700n 0.001422 407.7800n 0.001310 407.7900n 0.001200 407.8000n 0.001092 407.8100n 0.000988 407.8200n 0.000889 407.8300n 0.000796 407.8400n 0.000709
+ 407.8500n 0.000628 407.8600n 0.000554 407.8700n 0.000486 407.8800n 0.000425 407.8900n 0.000368 407.9000n 0.000317 407.9100n 0.000269 407.9200n 0.000225 407.9300n 0.000182 407.9400n 0.000141 407.9500n 0.000101 407.9600n 0.000060 407.9700n 0.000018 407.9800n -0.000025 407.9900n -0.000070
+ 408.0000n -0.000116 408.0100n -0.000165 408.0200n -0.000216 408.0300n -0.000267 408.0400n -0.000320 408.0500n -0.000372 408.0600n -0.000424 408.0700n -0.000473 408.0800n -0.000519 408.0900n -0.000560 408.1000n -0.000596 408.1100n -0.000624 408.1200n -0.000644 408.1300n -0.000654 408.1400n -0.000653
+ 408.1500n -0.000640 408.1600n -0.000614 408.1700n -0.000575 408.1800n -0.000521 408.1900n -0.000453 408.2000n -0.000370 408.2100n -0.000274 408.2200n -0.000164 408.2300n -0.000041 408.2400n 0.000094 408.2500n 0.000240 408.2600n 0.000394 408.2700n 0.000557 408.2800n 0.000724 408.2900n 0.000896
+ 408.3000n 0.001069 408.3100n 0.001242 408.3200n 0.001413 408.3300n 0.001579 408.3400n 0.001738 408.3500n 0.001888 408.3600n 0.002028 408.3700n 0.002156 408.3800n 0.002270 408.3900n 0.002370 408.4000n 0.002453 408.4100n 0.002519 408.4200n 0.002568 408.4300n 0.002600 408.4400n 0.002613
+ 408.4500n 0.002609 408.4600n 0.002588 408.4700n 0.002551 408.4800n 0.002498 408.4900n 0.002431 408.5000n 0.002350 408.5100n 0.002257 408.5200n 0.002154 408.5300n 0.002043 408.5400n 0.001923 408.5500n 0.001798 408.5600n 0.001669 408.5700n 0.001537 408.5800n 0.001404 408.5900n 0.001272
+ 408.6000n 0.001140 408.6100n 0.001011 408.6200n 0.000886 408.6300n 0.000765 408.6400n 0.000649 408.6500n 0.000539 408.6600n 0.000436 408.6700n 0.000338 408.6800n 0.000248 408.6900n 0.000164 408.7000n 0.000086 408.7100n 0.000016 408.7200n -0.000049 408.7300n -0.000108 408.7400n -0.000160
+ 408.7500n -0.000208 408.7600n -0.000251 408.7700n -0.000288 408.7800n -0.000322 408.7900n -0.000352 408.8000n -0.000378 408.8100n -0.000400 408.8200n -0.000419 408.8300n -0.000436 408.8400n -0.000449 408.8500n -0.000460 408.8600n -0.000468 408.8700n -0.000473 408.8800n -0.000476 408.8900n -0.000476
+ 408.9000n -0.000474 408.9100n -0.000470 408.9200n -0.000463 408.9300n -0.000453 408.9400n -0.000442 408.9500n -0.000429 408.9600n -0.000414 408.9700n -0.000397 408.9800n -0.000379 408.9900n -0.000361 409.0000n -0.000341 409.0100n -0.000322 409.0200n -0.000303 409.0300n -0.000284 409.0400n -0.000267
+ 409.0500n -0.000251 409.0600n -0.000237 409.0700n -0.000225 409.0800n -0.000215 409.0900n -0.000209 409.1000n -0.000205 409.1100n -0.000205 409.1200n -0.000208 409.1300n -0.000213 409.1400n -0.000222 409.1500n -0.000234 409.1600n -0.000248 409.1700n -0.000263 409.1800n -0.000281 409.1900n -0.000299
+ 409.2000n -0.000318 409.2100n -0.000336 409.2200n -0.000353 409.2300n -0.000369 409.2400n -0.000382 409.2500n -0.000392 409.2600n -0.000398 409.2700n -0.000399 409.2800n -0.000396 409.2900n -0.000388 409.3000n -0.000374 409.3100n -0.000354 409.3200n -0.000328 409.3300n -0.000297 409.3400n -0.000259
+ 409.3500n -0.000216 409.3600n -0.000169 409.3700n -0.000116 409.3800n -0.000060 409.3900n -0.000001 409.4000n 0.000060 409.4100n 0.000123 409.4200n 0.000186 409.4300n 0.000248 409.4400n 0.000309 409.4500n 0.000366 409.4600n 0.000420 409.4700n 0.000470 409.4800n 0.000513 409.4900n 0.000551
+ 409.5000n 0.000581 409.5100n 0.000604 409.5200n 0.000619 409.5300n 0.000625 409.5400n 0.000623 409.5500n 0.000612 409.5600n 0.000593 409.5700n 0.000566 409.5800n 0.000531 409.5900n 0.000488 409.6000n 0.000439 409.6100n 0.000383 409.6200n 0.000322 409.6300n 0.000256 409.6400n 0.000187
+ 409.6500n 0.000114 409.6600n 0.000039 409.6700n -0.000037 409.6800n -0.000114 409.6900n -0.000190 409.7000n -0.000266 409.7100n -0.000341 409.7200n -0.000414 409.7300n -0.000485 409.7400n -0.000553 409.7500n -0.000618 409.7600n -0.000681 409.7700n -0.000741 409.7800n -0.000797 409.7900n -0.000851
+ 409.8000n -0.000903 409.8100n -0.000952 409.8200n -0.000998 409.8300n -0.001043 409.8400n -0.001085 409.8500n -0.001126 409.8600n -0.001165 409.8700n -0.001202 409.8800n -0.001238 409.8900n -0.001272 409.9000n -0.001305 409.9100n -0.001336 409.9200n -0.001364 409.9300n -0.001391 409.9400n -0.001414
+ 409.9500n -0.001434 409.9600n -0.001451 409.9700n -0.001463 409.9800n -0.001472 409.9900n -0.001475 410.0000n -0.001473 410.0100n -0.001465 410.0200n -0.001452 410.0300n -0.001432 410.0400n -0.001407 410.0500n -0.001375 410.0600n -0.001338 410.0700n -0.001295 410.0800n -0.001248 410.0900n -0.001196
+ 410.1000n -0.001141 410.1100n -0.001084 410.1200n -0.001025 410.1300n -0.000966 410.1400n -0.000908 410.1500n -0.000852 410.1600n -0.000801 410.1700n -0.000754 410.1800n -0.000714 410.1900n -0.000681 410.2000n -0.000658 410.2100n -0.000645 410.2200n -0.000643 410.2300n -0.000653 410.2400n -0.000675
+ 410.2500n -0.000710 410.2600n -0.000758 410.2700n -0.000819 410.2800n -0.000892 410.2900n -0.000976 410.3000n -0.001071 410.3100n -0.001175 410.3200n -0.001286 410.3300n -0.001404 410.3400n -0.001526 410.3500n -0.001649 410.3600n -0.001773 410.3700n -0.001893 410.3800n -0.002009 410.3900n -0.002117
+ 410.4000n -0.002215 410.4100n -0.002302 410.4200n -0.002374 410.4300n -0.002430 410.4400n -0.002468 410.4500n -0.002486 410.4600n -0.002485 410.4700n -0.002462 410.4800n -0.002417 410.4900n -0.002350 410.5000n -0.002261 410.5100n -0.002151 410.5200n -0.002021 410.5300n -0.001871 410.5400n -0.001705
+ 410.5500n -0.001523 410.5600n -0.001327 410.5700n -0.001121 410.5800n -0.000906 410.5900n -0.000685 410.6000n -0.000462 410.6100n -0.000238 410.6200n -0.000017 410.6300n 0.000198 410.6400n 0.000406 410.6500n 0.000604 410.6600n 0.000789 410.6700n 0.000959 410.6800n 0.001114 410.6900n 0.001251
+ 410.7000n 0.001370 410.7100n 0.001470 410.7200n 0.001550 410.7300n 0.001611 410.7400n 0.001653 410.7500n 0.001677 410.7600n 0.001684 410.7700n 0.001674 410.7800n 0.001649 410.7900n 0.001612 410.8000n 0.001563 410.8100n 0.001504 410.8200n 0.001437 410.8300n 0.001364 410.8400n 0.001287
+ 410.8500n 0.001207 410.8600n 0.001126 410.8700n 0.001045 410.8800n 0.000966 410.8900n 0.000889 410.9000n 0.000815 410.9100n 0.000744 410.9200n 0.000676 410.9300n 0.000612 410.9400n 0.000551 410.9500n 0.000492 410.9600n 0.000435 410.9700n 0.000379 410.9800n 0.000323 410.9900n 0.000265
+ 411.0000n 0.000205 411.0100n 0.000140 411.0200n 0.000071 411.0300n -0.000004 411.0400n -0.000087 411.0500n -0.000177 411.0600n -0.000275 411.0700n -0.000383 411.0800n -0.000499 411.0900n -0.000624 411.1000n -0.000757 411.1100n -0.000898 411.1200n -0.001045 411.1300n -0.001197 411.1400n -0.001353
+ 411.1500n -0.001512 411.1600n -0.001670 411.1700n -0.001826 411.1800n -0.001977 411.1900n -0.002122 411.2000n -0.002259 411.2100n -0.002384 411.2200n -0.002496 411.2300n -0.002593 411.2400n -0.002672 411.2500n -0.002733 411.2600n -0.002775 411.2700n -0.002795 411.2800n -0.002793 411.2900n -0.002770
+ 411.3000n -0.002725 411.3100n -0.002658 411.3200n -0.002571 411.3300n -0.002464 411.3400n -0.002340 411.3500n -0.002199 411.3600n -0.002043 411.3700n -0.001876 411.3800n -0.001699 411.3900n -0.001516 411.4000n -0.001328 411.4100n -0.001138 411.4200n -0.000949 411.4300n -0.000764 411.4400n -0.000584
+ 411.4500n -0.000412 411.4600n -0.000250 411.4700n -0.000098 411.4800n 0.000040 411.4900n 0.000166 411.5000n 0.000277 411.5100n 0.000375 411.5200n 0.000458 411.5300n 0.000529 411.5400n 0.000587 411.5500n 0.000635 411.5600n 0.000673 411.5700n 0.000703 411.5800n 0.000727 411.5900n 0.000748
+ 411.6000n 0.000768 411.6100n 0.000788 411.6200n 0.000810 411.6300n 0.000838 411.6400n 0.000872 411.6500n 0.000915 411.6600n 0.000967 411.6700n 0.001030 411.6800n 0.001104 411.6900n 0.001190 411.7000n 0.001288 411.7100n 0.001396 411.7200n 0.001516 411.7300n 0.001644 411.7400n 0.001780
+ 411.7500n 0.001922 411.7600n 0.002067 411.7700n 0.002213 411.7800n 0.002358 411.7900n 0.002498 411.8000n 0.002630 411.8100n 0.002752 411.8200n 0.002861 411.8300n 0.002954 411.8400n 0.003029 411.8500n 0.003082 411.8600n 0.003113 411.8700n 0.003120 411.8800n 0.003101 411.8900n 0.003056
+ 411.9000n 0.002984 411.9100n 0.002886 411.9200n 0.002761 411.9300n 0.002612 411.9400n 0.002439 411.9500n 0.002245 411.9600n 0.002033 411.9700n 0.001804 411.9800n 0.001562 411.9900n 0.001310 412.0000n 0.001052 412.0100n 0.000792 412.0200n 0.000532 412.0300n 0.000277 412.0400n 0.000030
+ 412.0500n -0.000205 412.0600n -0.000426 412.0700n -0.000629 412.0800n -0.000813 412.0900n -0.000974 412.1000n -0.001111 412.1100n -0.001223 412.1200n -0.001310 412.1300n -0.001370 412.1400n -0.001405 412.1500n -0.001414 412.1600n -0.001399 412.1700n -0.001362 412.1800n -0.001303 412.1900n -0.001227
+ 412.2000n -0.001134 412.2100n -0.001028 412.2200n -0.000911 412.2300n -0.000787 412.2400n -0.000659 412.2500n -0.000529 412.2600n -0.000400 412.2700n -0.000275 412.2800n -0.000157 412.2900n -0.000047 412.3000n 0.000052 412.3100n 0.000139 412.3200n 0.000212 412.3300n 0.000271 412.3400n 0.000315
+ 412.3500n 0.000343 412.3600n 0.000357 412.3700n 0.000356 412.3800n 0.000341 412.3900n 0.000314 412.4000n 0.000275 412.4100n 0.000226 412.4200n 0.000169 412.4300n 0.000105 412.4400n 0.000036 412.4500n -0.000035 412.4600n -0.000108 412.4700n -0.000181 412.4800n -0.000252 412.4900n -0.000319
+ 412.5000n -0.000383 412.5100n -0.000442 412.5200n -0.000494 412.5300n -0.000541 412.5400n -0.000582 412.5500n -0.000616 412.5600n -0.000644 412.5700n -0.000667 412.5800n -0.000686 412.5900n -0.000700 412.6000n -0.000712 412.6100n -0.000722 412.6200n -0.000731 412.6300n -0.000740 412.6400n -0.000750
+ 412.6500n -0.000763 412.6600n -0.000779 412.6700n -0.000798 412.6800n -0.000822 412.6900n -0.000851 412.7000n -0.000884 412.7100n -0.000921 412.7200n -0.000963 412.7300n -0.001009 412.7400n -0.001057 412.7500n -0.001108 412.7600n -0.001159 412.7700n -0.001210 412.7800n -0.001259 412.7900n -0.001305
+ 412.8000n -0.001347 412.8100n -0.001382 412.8200n -0.001411 412.8300n -0.001430 412.8400n -0.001440 412.8500n -0.001439 412.8600n -0.001427 412.8700n -0.001403 412.8800n -0.001367 412.8900n -0.001318 412.9000n -0.001258 412.9100n -0.001186 412.9200n -0.001104 412.9300n -0.001013 412.9400n -0.000913
+ 412.9500n -0.000807 412.9600n -0.000697 412.9700n -0.000583 412.9800n -0.000468 412.9900n -0.000354 413.0000n -0.000243 413.0100n -0.000137 413.0200n -0.000037 413.0300n 0.000055 413.0400n 0.000137 413.0500n 0.000208 413.0600n 0.000268 413.0700n 0.000315 413.0800n 0.000350 413.0900n 0.000372
+ 413.1000n 0.000382 413.1100n 0.000380 413.1200n 0.000367 413.1300n 0.000346 413.1400n 0.000316 413.1500n 0.000281 413.1600n 0.000243 413.1700n 0.000202 413.1800n 0.000162 413.1900n 0.000125 413.2000n 0.000094 413.2100n 0.000069 413.2200n 0.000055 413.2300n 0.000052 413.2400n 0.000061
+ 413.2500n 0.000086 413.2600n 0.000126 413.2700n 0.000181 413.2800n 0.000254 413.2900n 0.000343 413.3000n 0.000447 413.3100n 0.000567 413.3200n 0.000700 413.3300n 0.000845 413.3400n 0.001000 413.3500n 0.001162 413.3600n 0.001330 413.3700n 0.001500 413.3800n 0.001669 413.3900n 0.001835
+ 413.4000n 0.001994 413.4100n 0.002143 413.4200n 0.002280 413.4300n 0.002401 413.4400n 0.002505 413.4500n 0.002590 413.4600n 0.002653 413.4700n 0.002693 413.4800n 0.002709 413.4900n 0.002701 413.5000n 0.002668 413.5100n 0.002612 413.5200n 0.002532 413.5300n 0.002430 413.5400n 0.002308
+ 413.5500n 0.002167 413.5600n 0.002011 413.5700n 0.001841 413.5800n 0.001661 413.5900n 0.001474 413.6000n 0.001282 413.6100n 0.001090 413.6200n 0.000900 413.6300n 0.000714 413.6400n 0.000537 413.6500n 0.000370 413.6600n 0.000216 413.6700n 0.000077 413.6800n -0.000046 413.6900n -0.000152
+ 413.7000n -0.000239 413.7100n -0.000307 413.7200n -0.000356 413.7300n -0.000387 413.7400n -0.000401 413.7500n -0.000399 413.7600n -0.000382 413.7700n -0.000353 413.7800n -0.000313 413.7900n -0.000265 413.8000n -0.000211 413.8100n -0.000153 413.8200n -0.000095 413.8300n -0.000037 413.8400n 0.000017
+ 413.8500n 0.000065 413.8600n 0.000107 413.8700n 0.000139 413.8800n 0.000162 413.8900n 0.000175 413.9000n 0.000176 413.9100n 0.000166 413.9200n 0.000146 413.9300n 0.000115 413.9400n 0.000076 413.9500n 0.000029 413.9600n -0.000025 413.9700n -0.000082 413.9800n -0.000141 413.9900n -0.000201
+ 414.0000n -0.000258 414.0100n -0.000311 414.0200n -0.000357 414.0300n -0.000395 414.0400n -0.000422 414.0500n -0.000437 414.0600n -0.000439 414.0700n -0.000426 414.0800n -0.000399 414.0900n -0.000356 414.1000n -0.000298 414.1100n -0.000225 414.1200n -0.000138 414.1300n -0.000039 414.1400n 0.000070
+ 414.1500n 0.000189 414.1600n 0.000315 414.1700n 0.000444 414.1800n 0.000576 414.1900n 0.000706 414.2000n 0.000833 414.2100n 0.000953 414.2200n 0.001064 414.2300n 0.001164 414.2400n 0.001250 414.2500n 0.001320 414.2600n 0.001373 414.2700n 0.001408 414.2800n 0.001423 414.2900n 0.001419
+ 414.3000n 0.001395 414.3100n 0.001353 414.3200n 0.001291 414.3300n 0.001214 414.3400n 0.001121 414.3500n 0.001015 414.3600n 0.000899 414.3700n 0.000775 414.3800n 0.000646 414.3900n 0.000515 414.4000n 0.000385 414.4100n 0.000259 414.4200n 0.000141 414.4300n 0.000032 414.4400n -0.000063
+ 414.4500n -0.000145 414.4600n -0.000209 414.4700n -0.000255 414.4800n -0.000282 414.4900n -0.000289 414.5000n -0.000276 414.5100n -0.000243 414.5200n -0.000192 414.5300n -0.000123 414.5400n -0.000038 414.5500n 0.000060 414.5600n 0.000168 414.5700n 0.000285 414.5800n 0.000406 414.5900n 0.000529
+ 414.6000n 0.000650 414.6100n 0.000765 414.6200n 0.000871 414.6300n 0.000965 414.6400n 0.001044 414.6500n 0.001104 414.6600n 0.001144 414.6700n 0.001160 414.6800n 0.001153 414.6900n 0.001119 414.7000n 0.001060 414.7100n 0.000974 414.7200n 0.000862 414.7300n 0.000725 414.7400n 0.000565
+ 414.7500n 0.000384 414.7600n 0.000184 414.7700n -0.000032 414.7800n -0.000261 414.7900n -0.000500 414.8000n -0.000743 414.8100n -0.000989 414.8200n -0.001232 414.8300n -0.001469 414.8400n -0.001696 414.8500n -0.001909 414.8600n -0.002106 414.8700n -0.002282 414.8800n -0.002435 414.8900n -0.002564
+ 414.9000n -0.002665 414.9100n -0.002739 414.9200n -0.002783 414.9300n -0.002798 414.9400n -0.002785 414.9500n -0.002742 414.9600n -0.002673 414.9700n -0.002579 414.9800n -0.002461 414.9900n -0.002322 415.0000n -0.002165 415.0100n -0.001994 415.0200n -0.001810 415.0300n -0.001617 415.0400n -0.001419
+ 415.0500n -0.001218 415.0600n -0.001019 415.0700n -0.000823 415.0800n -0.000633 415.0900n -0.000452 415.1000n -0.000283 415.1100n -0.000126 415.1200n 0.000017 415.1300n 0.000145 415.1400n 0.000257 415.1500n 0.000353 415.1600n 0.000433 415.1700n 0.000498 415.1800n 0.000549 415.1900n 0.000586
+ 415.2000n 0.000612 415.2100n 0.000627 415.2200n 0.000633 415.2300n 0.000633 415.2400n 0.000628 415.2500n 0.000619 415.2600n 0.000609 415.2700n 0.000600 415.2800n 0.000592 415.2900n 0.000587 415.3000n 0.000586 415.3100n 0.000590 415.3200n 0.000599 415.3300n 0.000613 415.3400n 0.000633
+ 415.3500n 0.000658 415.3600n 0.000688 415.3700n 0.000721 415.3800n 0.000757 415.3900n 0.000794 415.4000n 0.000831 415.4100n 0.000867 415.4200n 0.000900 415.4300n 0.000930 415.4400n 0.000953 415.4500n 0.000970 415.4600n 0.000980 415.4700n 0.000980 415.4800n 0.000971 415.4900n 0.000952
+ 415.5000n 0.000924 415.5100n 0.000885 415.5200n 0.000837 415.5300n 0.000780 415.5400n 0.000715 415.5500n 0.000644 415.5600n 0.000568 415.5700n 0.000489 415.5800n 0.000408 415.5900n 0.000328 415.6000n 0.000251 415.6100n 0.000179 415.6200n 0.000113 415.6300n 0.000056 415.6400n 0.000010
+ 415.6500n -0.000023 415.6600n -0.000043 415.6700n -0.000047 415.6800n -0.000036 415.6900n -0.000007 415.7000n 0.000038 415.7100n 0.000099 415.7200n 0.000177 415.7300n 0.000270 415.7400n 0.000376 415.7500n 0.000495 415.7600n 0.000624 415.7700n 0.000761 415.7800n 0.000904 415.7900n 0.001049
+ 415.8000n 0.001195 415.8100n 0.001337 415.8200n 0.001474 415.8300n 0.001602 415.8400n 0.001718 415.8500n 0.001820 415.8600n 0.001905 415.8700n 0.001972 415.8800n 0.002018 415.8900n 0.002041 415.9000n 0.002041 415.9100n 0.002017 415.9200n 0.001968 415.9300n 0.001894 415.9400n 0.001797
+ 415.9500n 0.001677 415.9600n 0.001535 415.9700n 0.001373 415.9800n 0.001194 415.9900n 0.000999 416.0000n 0.000791 416.0100n 0.000574 416.0200n 0.000350 416.0300n 0.000122 416.0400n -0.000106 416.0500n -0.000332 416.0600n -0.000551 416.0700n -0.000762 416.0800n -0.000961 416.0900n -0.001146
+ 416.1000n -0.001315 416.1100n -0.001465 416.1200n -0.001594 416.1300n -0.001703 416.1400n -0.001789 416.1500n -0.001852 416.1600n -0.001893 416.1700n -0.001910 416.1800n -0.001905 416.1900n -0.001880 416.2000n -0.001834 416.2100n -0.001770 416.2200n -0.001690 416.2300n -0.001595 416.2400n -0.001487
+ 416.2500n -0.001370 416.2600n -0.001246 416.2700n -0.001116 416.2800n -0.000983 416.2900n -0.000851 416.3000n -0.000720 416.3100n -0.000594 416.3200n -0.000473 416.3300n -0.000361 416.3400n -0.000259 416.3500n -0.000167 416.3600n -0.000087 416.3700n -0.000021 416.3800n 0.000032 416.3900n 0.000070
+ 416.4000n 0.000095 416.4100n 0.000105 416.4200n 0.000102 416.4300n 0.000085 416.4400n 0.000056 416.4500n 0.000015 416.4600n -0.000037 416.4700n -0.000099 416.4800n -0.000169 416.4900n -0.000246 416.5000n -0.000329 416.5100n -0.000417 416.5200n -0.000508 416.5300n -0.000601 416.5400n -0.000695
+ 416.5500n -0.000788 416.5600n -0.000879 416.5700n -0.000968 416.5800n -0.001052 416.5900n -0.001132 416.6000n -0.001206 416.6100n -0.001273 416.6200n -0.001334 416.6300n -0.001386 416.6400n -0.001430 416.6500n -0.001466 416.6600n -0.001492 416.6700n -0.001508 416.6800n -0.001516 416.6900n -0.001513
+ 416.7000n -0.001500 416.7100n -0.001478 416.7200n -0.001446 416.7300n -0.001405 416.7400n -0.001354 416.7500n -0.001295 416.7600n -0.001227 416.7700n -0.001152 416.7800n -0.001069 416.7900n -0.000980 416.8000n -0.000885 416.8100n -0.000785 416.8200n -0.000681 416.8300n -0.000574 416.8400n -0.000465
+ 416.8500n -0.000355 416.8600n -0.000246 416.8700n -0.000139 416.8800n -0.000034 416.8900n 0.000067 416.9000n 0.000163 416.9100n 0.000252 416.9200n 0.000334 416.9300n 0.000407 416.9400n 0.000471 416.9500n 0.000525 416.9600n 0.000567 416.9700n 0.000598 416.9800n 0.000617 416.9900n 0.000623
+ 417.0000n 0.000618 417.0100n 0.000600 417.0200n 0.000570 417.0300n 0.000529 417.0400n 0.000477 417.0500n 0.000415 417.0600n 0.000344 417.0700n 0.000265 417.0800n 0.000180 417.0900n 0.000090 417.1000n -0.000003 417.1100n -0.000099 417.1200n -0.000195 417.1300n -0.000290 417.1400n -0.000383
+ 417.1500n -0.000472 417.1600n -0.000555 417.1700n -0.000632 417.1800n -0.000702 417.1900n -0.000763 417.2000n -0.000815 417.2100n -0.000858 417.2200n -0.000890 417.2300n -0.000913 417.2400n -0.000926 417.2500n -0.000930 417.2600n -0.000925 417.2700n -0.000912 417.2800n -0.000892 417.2900n -0.000866
+ 417.3000n -0.000836 417.3100n -0.000803 417.3200n -0.000767 417.3300n -0.000732 417.3400n -0.000697 417.3500n -0.000665 417.3600n -0.000636 417.3700n -0.000613 417.3800n -0.000595 417.3900n -0.000585 417.4000n -0.000582 417.4100n -0.000588 417.4200n -0.000602 417.4300n -0.000625 417.4400n -0.000656
+ 417.4500n -0.000695 417.4600n -0.000742 417.4700n -0.000796 417.4800n -0.000856 417.4900n -0.000920 417.5000n -0.000988 417.5100n -0.001059 417.5200n -0.001130 417.5300n -0.001200 417.5400n -0.001269 417.5500n -0.001334 417.5600n -0.001394 417.5700n -0.001449 417.5800n -0.001497 417.5900n -0.001538
+ 417.6000n -0.001570 417.6100n -0.001594 417.6200n -0.001610 417.6300n -0.001616 417.6400n -0.001615 417.6500n -0.001606 417.6600n -0.001590 417.6700n -0.001568 417.6800n -0.001542 417.6900n -0.001512 417.7000n -0.001480 417.7100n -0.001447 417.7200n -0.001415 417.7300n -0.001386 417.7400n -0.001360
+ 417.7500n -0.001339 417.7600n -0.001325 417.7700n -0.001318 417.7800n -0.001319 417.7900n -0.001328 417.8000n -0.001346 417.8100n -0.001372 417.8200n -0.001407 417.8300n -0.001450 417.8400n -0.001499 417.8500n -0.001553 417.8600n -0.001611 417.8700n -0.001670 417.8800n -0.001730 417.8900n -0.001787
+ 417.9000n -0.001840 417.9100n -0.001886 417.9200n -0.001922 417.9300n -0.001946 417.9400n -0.001956 417.9500n -0.001950 417.9600n -0.001926 417.9700n -0.001882 417.9800n -0.001817 417.9900n -0.001729 418.0000n -0.001619 418.0100n -0.001485 418.0200n -0.001329 418.0300n -0.001151 418.0400n -0.000951
+ 418.0500n -0.000733 418.0600n -0.000496 418.0700n -0.000245 418.0800n 0.000018 418.0900n 0.000290 418.1000n 0.000568 418.1100n 0.000849 418.1200n 0.001128 418.1300n 0.001401 418.1400n 0.001666 418.1500n 0.001917 418.1600n 0.002153 418.1700n 0.002368 418.1800n 0.002561 418.1900n 0.002728
+ 418.2000n 0.002868 418.2100n 0.002977 418.2200n 0.003055 418.2300n 0.003101 418.2400n 0.003114 418.2500n 0.003095 418.2600n 0.003045 418.2700n 0.002963 418.2800n 0.002853 418.2900n 0.002716 418.3000n 0.002556 418.3100n 0.002374 418.3200n 0.002175 418.3300n 0.001961 418.3400n 0.001738
+ 418.3500n 0.001507 418.3600n 0.001275 418.3700n 0.001043 418.3800n 0.000817 418.3900n 0.000600 418.4000n 0.000394 418.4100n 0.000203 418.4200n 0.000030 418.4300n -0.000123 418.4400n -0.000254 418.4500n -0.000362 418.4600n -0.000447 418.4700n -0.000507 418.4800n -0.000543 418.4900n -0.000556
+ 418.5000n -0.000547 418.5100n -0.000517 418.5200n -0.000468 418.5300n -0.000402 418.5400n -0.000322 418.5500n -0.000231 418.5600n -0.000131 418.5700n -0.000025 418.5800n 0.000083 418.5900n 0.000191 418.6000n 0.000297 418.6100n 0.000396 418.6200n 0.000487 418.6300n 0.000568 418.6400n 0.000637
+ 418.6500n 0.000692 418.6600n 0.000733 418.6700n 0.000757 418.6800n 0.000766 418.6900n 0.000758 418.7000n 0.000735 418.7100n 0.000696 418.7200n 0.000643 418.7300n 0.000577 418.7400n 0.000499 418.7500n 0.000411 418.7600n 0.000316 418.7700n 0.000214 418.7800n 0.000109 418.7900n 0.000001
+ 418.8000n -0.000107 418.8100n -0.000213 418.8200n -0.000316 418.8300n -0.000414 418.8400n -0.000506 418.8500n -0.000591 418.8600n -0.000667 418.8700n -0.000735 418.8800n -0.000793 418.8900n -0.000842 418.9000n -0.000882 418.9100n -0.000914 418.9200n -0.000938 418.9300n -0.000954 418.9400n -0.000964
+ 418.9500n -0.000969 418.9600n -0.000969 418.9700n -0.000967 418.9800n -0.000963 418.9900n -0.000958 419.0000n -0.000953 419.0100n -0.000949 419.0200n -0.000947 419.0300n -0.000947 419.0400n -0.000951 419.0500n -0.000957 419.0600n -0.000967 419.0700n -0.000979 419.0800n -0.000994 419.0900n -0.001011
+ 419.1000n -0.001029 419.1100n -0.001047 419.1200n -0.001064 419.1300n -0.001080 419.1400n -0.001093 419.1500n -0.001101 419.1600n -0.001105 419.1700n -0.001102 419.1800n -0.001092 419.1900n -0.001073 419.2000n -0.001046 419.2100n -0.001010 419.2200n -0.000964 419.2300n -0.000909 419.2400n -0.000844
+ 419.2500n -0.000770 419.2600n -0.000688 419.2700n -0.000599 419.2800n -0.000503 419.2900n -0.000402 419.3000n -0.000298 419.3100n -0.000192 419.3200n -0.000085 419.3300n 0.000020 419.3400n 0.000122 419.3500n 0.000219 419.3600n 0.000309 419.3700n 0.000391 419.3800n 0.000464 419.3900n 0.000525
+ 419.4000n 0.000575 419.4100n 0.000612 419.4200n 0.000636 419.4300n 0.000647 419.4400n 0.000644 419.4500n 0.000628 419.4600n 0.000600 419.4700n 0.000560 419.4800n 0.000510 419.4900n 0.000450 419.5000n 0.000382 419.5100n 0.000309 419.5200n 0.000231 419.5300n 0.000151 419.5400n 0.000071
+ 419.5500n -0.000009 419.5600n -0.000085 419.5700n -0.000157 419.5800n -0.000222 419.5900n -0.000280 419.6000n -0.000330 419.6100n -0.000369 419.6200n -0.000399 419.6300n -0.000418 419.6400n -0.000427 419.6500n -0.000426 419.6600n -0.000415 419.6700n -0.000396 419.6800n -0.000368 419.6900n -0.000334
+ 419.7000n -0.000295 419.7100n -0.000252 419.7200n -0.000207 419.7300n -0.000161 419.7400n -0.000117 419.7500n -0.000077 419.7600n -0.000040 419.7700n -0.000009 419.7800n 0.000014 419.7900n 0.000029 419.8000n 0.000036 419.8100n 0.000033 419.8200n 0.000021 419.8300n 0.000000 419.8400n -0.000030
+ 419.8500n -0.000068 419.8600n -0.000113 419.8700n -0.000163 419.8800n -0.000218 419.8900n -0.000275 419.9000n -0.000332 419.9100n -0.000387 419.9200n -0.000438 419.9300n -0.000483 419.9400n -0.000520 419.9500n -0.000546 419.9600n -0.000560 419.9700n -0.000560 419.9800n -0.000544 419.9900n -0.000512
+ 420.0000n -0.000462 420.0100n -0.000394 420.0200n -0.000307 420.0300n -0.000202 420.0400n -0.000080 420.0500n 0.000059 420.0600n 0.000212 420.0700n 0.000380 420.0800n 0.000558 420.0900n 0.000746 420.1000n 0.000940 420.1100n 0.001138 420.1200n 0.001336 420.1300n 0.001532 420.1400n 0.001723
+ 420.1500n 0.001905 420.1600n 0.002076 420.1700n 0.002232 420.1800n 0.002372 420.1900n 0.002492 420.2000n 0.002592 420.2100n 0.002668 420.2200n 0.002720 420.2300n 0.002747 420.2400n 0.002749 420.2500n 0.002725 420.2600n 0.002675 420.2700n 0.002601 420.2800n 0.002504 420.2900n 0.002384
+ 420.3000n 0.002245 420.3100n 0.002087 420.3200n 0.001914 420.3300n 0.001728 420.3400n 0.001532 420.3500n 0.001329 420.3600n 0.001121 420.3700n 0.000911 420.3800n 0.000703 420.3900n 0.000498 420.4000n 0.000300 420.4100n 0.000110 420.4200n -0.000070 420.4300n -0.000237 420.4400n -0.000390
+ 420.4500n -0.000528 420.4600n -0.000651 420.4700n -0.000757 420.4800n -0.000846 420.4900n -0.000919 420.5000n -0.000975 420.5100n -0.001016 420.5200n -0.001041 420.5300n -0.001053 420.5400n -0.001051 420.5500n -0.001037 420.5600n -0.001012 420.5700n -0.000978 420.5800n -0.000936 420.5900n -0.000886
+ 420.6000n -0.000830 420.6100n -0.000769 420.6200n -0.000703 420.6300n -0.000634 420.6400n -0.000561 420.6500n -0.000486 420.6600n -0.000408 420.6700n -0.000328 420.6800n -0.000245 420.6900n -0.000160 420.7000n -0.000072 420.7100n 0.000020 420.7200n 0.000114 420.7300n 0.000212 420.7400n 0.000314
+ 420.7500n 0.000419 420.7600n 0.000529 420.7700n 0.000643 420.7800n 0.000760 420.7900n 0.000881 420.8000n 0.001005 420.8100n 0.001131 420.8200n 0.001258 420.8300n 0.001385 420.8400n 0.001511 420.8500n 0.001634 420.8600n 0.001752 420.8700n 0.001865 420.8800n 0.001970 420.8900n 0.002065
+ 420.9000n 0.002149 420.9100n 0.002220 420.9200n 0.002276 420.9300n 0.002315 420.9400n 0.002337 420.9500n 0.002340 420.9600n 0.002322 420.9700n 0.002285 420.9800n 0.002226 420.9900n 0.002147 421.0000n 0.002047 421.0100n 0.001928 421.0200n 0.001790 421.0300n 0.001635 421.0400n 0.001465
+ 421.0500n 0.001281 421.0600n 0.001086 421.0700n 0.000883 421.0800n 0.000674 421.0900n 0.000461 421.1000n 0.000249 421.1100n 0.000039 421.1200n -0.000166 421.1300n -0.000361 421.1400n -0.000546 421.1500n -0.000718 421.1600n -0.000874 421.1700n -0.001012 421.1800n -0.001132 421.1900n -0.001232
+ 421.2000n -0.001311 421.2100n -0.001369 421.2200n -0.001406 421.2300n -0.001423 421.2400n -0.001420 421.2500n -0.001399 421.2600n -0.001362 421.2700n -0.001310 421.2800n -0.001245 421.2900n -0.001170 421.3000n -0.001088 421.3100n -0.001000 421.3200n -0.000910 421.3300n -0.000821 421.3400n -0.000733
+ 421.3500n -0.000651 421.3600n -0.000576 421.3700n -0.000510 421.3800n -0.000455 421.3900n -0.000411 421.4000n -0.000379 421.4100n -0.000361 421.4200n -0.000355 421.4300n -0.000362 421.4400n -0.000381 421.4500n -0.000411 421.4600n -0.000450 421.4700n -0.000497 421.4800n -0.000550 421.4900n -0.000607
+ 421.5000n -0.000666 421.5100n -0.000723 421.5200n -0.000778 421.5300n -0.000827 421.5400n -0.000868 421.5500n -0.000901 421.5600n -0.000922 421.5700n -0.000931 421.5800n -0.000926 421.5900n -0.000906 421.6000n -0.000872 421.6100n -0.000824 421.6200n -0.000761 421.6300n -0.000685 421.6400n -0.000597
+ 421.6500n -0.000499 421.6600n -0.000393 421.6700n -0.000280 421.6800n -0.000164 421.6900n -0.000047 421.7000n 0.000069 421.7100n 0.000179 421.7200n 0.000282 421.7300n 0.000375 421.7400n 0.000456 421.7500n 0.000521 421.7600n 0.000569 421.7700n 0.000598 421.7800n 0.000607 421.7900n 0.000596
+ 421.8000n 0.000563 421.8100n 0.000509 421.8200n 0.000434 421.8300n 0.000340 421.8400n 0.000228 421.8500n 0.000100 421.8600n -0.000042 421.8700n -0.000195 421.8800n -0.000356 421.8900n -0.000521 421.9000n -0.000688 421.9100n -0.000853 421.9200n -0.001012 421.9300n -0.001162 421.9400n -0.001300
+ 421.9500n -0.001423 421.9600n -0.001527 421.9700n -0.001611 421.9800n -0.001673 421.9900n -0.001711 422.0000n -0.001725 422.0100n -0.001713 422.0200n -0.001677 422.0300n -0.001616 422.0400n -0.001531 422.0500n -0.001426 422.0600n -0.001301 422.0700n -0.001159 422.0800n -0.001004 422.0900n -0.000838
+ 422.1000n -0.000666 422.1100n -0.000490 422.1200n -0.000315 422.1300n -0.000144 422.1400n 0.000018 422.1500n 0.000170 422.1600n 0.000307 422.1700n 0.000426 422.1800n 0.000526 422.1900n 0.000603 422.2000n 0.000658 422.2100n 0.000688 422.2200n 0.000694 422.2300n 0.000675 422.2400n 0.000633
+ 422.2500n 0.000568 422.2600n 0.000483 422.2700n 0.000380 422.2800n 0.000262 422.2900n 0.000132 422.3000n -0.000008 422.3100n -0.000152 422.3200n -0.000297 422.3300n -0.000440 422.3400n -0.000576 422.3500n -0.000702 422.3600n -0.000815 422.3700n -0.000911 422.3800n -0.000988 422.3900n -0.001043
+ 422.4000n -0.001074 422.4100n -0.001081 422.4200n -0.001062 422.4300n -0.001017 422.4400n -0.000947 422.4500n -0.000853 422.4600n -0.000737 422.4700n -0.000600 422.4800n -0.000445 422.4900n -0.000276 422.5000n -0.000096 422.5100n 0.000092 422.5200n 0.000284 422.5300n 0.000475 422.5400n 0.000662
+ 422.5500n 0.000840 422.5600n 0.001006 422.5700n 0.001156 422.5800n 0.001288 422.5900n 0.001397 422.6000n 0.001482 422.6100n 0.001541 422.6200n 0.001573 422.6300n 0.001576 422.6400n 0.001552 422.6500n 0.001499 422.6600n 0.001421 422.6700n 0.001317 422.6800n 0.001191 422.6900n 0.001045
+ 422.7000n 0.000882 422.7100n 0.000706 422.7200n 0.000521 422.7300n 0.000330 422.7400n 0.000138 422.7500n -0.000051 422.7600n -0.000233 422.7700n -0.000405 422.7800n -0.000562 422.7900n -0.000702 422.8000n -0.000822 422.8100n -0.000918 422.8200n -0.000990 422.8300n -0.001036 422.8400n -0.001055
+ 422.8500n -0.001047 422.8600n -0.001013 422.8700n -0.000953 422.8800n -0.000870 422.8900n -0.000765 422.9000n -0.000642 422.9100n -0.000503 422.9200n -0.000352 422.9300n -0.000192 422.9400n -0.000028 422.9500n 0.000136 422.9600n 0.000297 422.9700n 0.000450 422.9800n 0.000590 422.9900n 0.000716
+ 423.0000n 0.000823 423.0100n 0.000908 423.0200n 0.000968 423.0300n 0.001003 423.0400n 0.001009 423.0500n 0.000987 423.0600n 0.000936 423.0700n 0.000856 423.0800n 0.000747 423.0900n 0.000612 423.1000n 0.000453 423.1100n 0.000271 423.1200n 0.000070 423.1300n -0.000148 423.1400n -0.000378
+ 423.1500n -0.000617 423.1600n -0.000861 423.1700n -0.001105 423.1800n -0.001346 423.1900n -0.001580 423.2000n -0.001803 423.2100n -0.002011 423.2200n -0.002201 423.2300n -0.002370 423.2400n -0.002516 423.2500n -0.002636 423.2600n -0.002728 423.2700n -0.002792 423.2800n -0.002827 423.2900n -0.002833
+ 423.3000n -0.002810 423.3100n -0.002758 423.3200n -0.002680 423.3300n -0.002577 423.3400n -0.002451 423.3500n -0.002304 423.3600n -0.002139 423.3700n -0.001960 423.3800n -0.001768 423.3900n -0.001567 423.4000n -0.001360 423.4100n -0.001151 423.4200n -0.000942 423.4300n -0.000736 423.4400n -0.000536
+ 423.4500n -0.000344 423.4600n -0.000162 423.4700n 0.000007 423.4800n 0.000162 423.4900n 0.000303 423.5000n 0.000427 423.5100n 0.000534 423.5200n 0.000624 423.5300n 0.000698 423.5400n 0.000754 423.5500n 0.000795 423.5600n 0.000820 423.5700n 0.000830 423.5800n 0.000827 423.5900n 0.000813
+ 423.6000n 0.000787 423.6100n 0.000752 423.6200n 0.000709 423.6300n 0.000659 423.6400n 0.000604 423.6500n 0.000545 423.6600n 0.000483 423.6700n 0.000419 423.6800n 0.000354 423.6900n 0.000290 423.7000n 0.000226 423.7100n 0.000164 423.7200n 0.000104 423.7300n 0.000046 423.7400n -0.000009
+ 423.7500n -0.000062 423.7600n -0.000111 423.7700n -0.000157 423.7800n -0.000199 423.7900n -0.000239 423.8000n -0.000275 423.8100n -0.000307 423.8200n -0.000336 423.8300n -0.000361 423.8400n -0.000383 423.8500n -0.000400 423.8600n -0.000413 423.8700n -0.000422 423.8800n -0.000426 423.8900n -0.000425
+ 423.9000n -0.000418 423.9100n -0.000406 423.9200n -0.000389 423.9300n -0.000365 423.9400n -0.000335 423.9500n -0.000298 423.9600n -0.000256 423.9700n -0.000207 423.9800n -0.000152 423.9900n -0.000092 424.0000n -0.000026 424.0100n 0.000044 424.0200n 0.000118 424.0300n 0.000196 424.0400n 0.000275
+ 424.0500n 0.000356 424.0600n 0.000436 424.0700n 0.000516 424.0800n 0.000593 424.0900n 0.000666 424.1000n 0.000735 424.1100n 0.000798 424.1200n 0.000853 424.1300n 0.000900 424.1400n 0.000939 424.1500n 0.000967 424.1600n 0.000985 424.1700n 0.000992 424.1800n 0.000988 424.1900n 0.000973
+ 424.2000n 0.000947 424.2100n 0.000910 424.2200n 0.000864 424.2300n 0.000809 424.2400n 0.000745 424.2500n 0.000676 424.2600n 0.000600 424.2700n 0.000521 424.2800n 0.000440 424.2900n 0.000358 424.3000n 0.000278 424.3100n 0.000200 424.3200n 0.000127 424.3300n 0.000061 424.3400n 0.000002
+ 424.3500n -0.000048 424.3600n -0.000088 424.3700n -0.000116 424.3800n -0.000133 424.3900n -0.000137 424.4000n -0.000128 424.4100n -0.000106 424.4200n -0.000072 424.4300n -0.000026 424.4400n 0.000032 424.4500n 0.000100 424.4600n 0.000177 424.4700n 0.000262 424.4800n 0.000354 424.4900n 0.000450
+ 424.5000n 0.000550 424.5100n 0.000651 424.5200n 0.000751 424.5300n 0.000850 424.5400n 0.000945 424.5500n 0.001035 424.5600n 0.001118 424.5700n 0.001193 424.5800n 0.001260 424.5900n 0.001317 424.6000n 0.001364 424.6100n 0.001401 424.6200n 0.001427 424.6300n 0.001443 424.6400n 0.001449
+ 424.6500n 0.001446 424.6600n 0.001434 424.6700n 0.001414 424.6800n 0.001388 424.6900n 0.001357 424.7000n 0.001322 424.7100n 0.001285 424.7200n 0.001247 424.7300n 0.001209 424.7400n 0.001172 424.7500n 0.001139 424.7600n 0.001109 424.7700n 0.001084 424.7800n 0.001065 424.7900n 0.001052
+ 424.8000n 0.001045 424.8100n 0.001044 424.8200n 0.001051 424.8300n 0.001063 424.8400n 0.001080 424.8500n 0.001102 424.8600n 0.001128 424.8700n 0.001157 424.8800n 0.001187 424.8900n 0.001216 424.9000n 0.001245 424.9100n 0.001270 424.9200n 0.001291 424.9300n 0.001306 424.9400n 0.001314
+ 424.9500n 0.001314 424.9600n 0.001305 424.9700n 0.001285 424.9800n 0.001254 424.9900n 0.001211 425.0000n 0.001157 425.0100n 0.001091 425.0200n 0.001013 425.0300n 0.000925 425.0400n 0.000826 425.0500n 0.000717 425.0600n 0.000600 425.0700n 0.000476 425.0800n 0.000347 425.0900n 0.000213
+ 425.1000n 0.000078 425.1100n -0.000059 425.1200n -0.000194 425.1300n -0.000326 425.1400n -0.000453 425.1500n -0.000574 425.1600n -0.000688 425.1700n -0.000792 425.1800n -0.000886 425.1900n -0.000969 425.2000n -0.001040 425.2100n -0.001099 425.2200n -0.001144 425.2300n -0.001177 425.2400n -0.001197
+ 425.2500n -0.001205 425.2600n -0.001201 425.2700n -0.001186 425.2800n -0.001162 425.2900n -0.001128 425.3000n -0.001087 425.3100n -0.001040 425.3200n -0.000988 425.3300n -0.000933 425.3400n -0.000875 425.3500n -0.000817 425.3600n -0.000760 425.3700n -0.000704 425.3800n -0.000652 425.3900n -0.000604
+ 425.4000n -0.000562 425.4100n -0.000524 425.4200n -0.000494 425.4300n -0.000470 425.4400n -0.000453 425.4500n -0.000443 425.4600n -0.000440 425.4700n -0.000444 425.4800n -0.000454 425.4900n -0.000471 425.5000n -0.000493 425.5100n -0.000519 425.5200n -0.000550 425.5300n -0.000584 425.5400n -0.000621
+ 425.5500n -0.000660 425.5600n -0.000700 425.5700n -0.000741 425.5800n -0.000781 425.5900n -0.000822 425.6000n -0.000861 425.6100n -0.000898 425.6200n -0.000934 425.6300n -0.000967 425.6400n -0.000998 425.6500n -0.001026 425.6600n -0.001052 425.6700n -0.001075 425.6800n -0.001095 425.6900n -0.001113
+ 425.7000n -0.001127 425.7100n -0.001139 425.7200n -0.001148 425.7300n -0.001153 425.7400n -0.001156 425.7500n -0.001155 425.7600n -0.001150 425.7700n -0.001141 425.7800n -0.001129 425.7900n -0.001111 425.8000n -0.001089 425.8100n -0.001061 425.8200n -0.001027 425.8300n -0.000987 425.8400n -0.000940
+ 425.8500n -0.000886 425.8600n -0.000825 425.8700n -0.000756 425.8800n -0.000678 425.8900n -0.000593 425.9000n -0.000500 425.9100n -0.000400 425.9200n -0.000292 425.9300n -0.000177 425.9400n -0.000057 425.9500n 0.000069 425.9600n 0.000198 425.9700n 0.000330 425.9800n 0.000464 425.9900n 0.000597
+ 426.0000n 0.000728 426.0100n 0.000856 426.0200n 0.000978 426.0300n 0.001093 426.0400n 0.001199 426.0500n 0.001294 426.0600n 0.001376 426.0700n 0.001444 426.0800n 0.001497 426.0900n 0.001533 426.1000n 0.001551 426.1100n 0.001550 426.1200n 0.001530 426.1300n 0.001491 426.1400n 0.001431
+ 426.1500n 0.001353 426.1600n 0.001257 426.1700n 0.001142 426.1800n 0.001012 426.1900n 0.000867 426.2000n 0.000709 426.2100n 0.000541 426.2200n 0.000364 426.2300n 0.000181 426.2400n -0.000006 426.2500n -0.000193 426.2600n -0.000378 426.2700n -0.000559 426.2800n -0.000733 426.2900n -0.000896
+ 426.3000n -0.001048 426.3100n -0.001185 426.3200n -0.001306 426.3300n -0.001409 426.3400n -0.001493 426.3500n -0.001557 426.3600n -0.001599 426.3700n -0.001620 426.3800n -0.001619 426.3900n -0.001597 426.4000n -0.001555 426.4100n -0.001494 426.4200n -0.001415 426.4300n -0.001319 426.4400n -0.001209
+ 426.4500n -0.001086 426.4600n -0.000954 426.4700n -0.000814 426.4800n -0.000668 426.4900n -0.000520 426.5000n -0.000373 426.5100n -0.000227 426.5200n -0.000087 426.5300n 0.000047 426.5400n 0.000171 426.5500n 0.000284 426.5600n 0.000384 426.5700n 0.000471 426.5800n 0.000542 426.5900n 0.000597
+ 426.6000n 0.000635 426.6100n 0.000657 426.6200n 0.000662 426.6300n 0.000650 426.6400n 0.000622 426.6500n 0.000579 426.6600n 0.000522 426.6700n 0.000452 426.6800n 0.000371 426.6900n 0.000279 426.7000n 0.000179 426.7100n 0.000072 426.7200n -0.000041 426.7300n -0.000158 426.7400n -0.000276
+ 426.7500n -0.000396 426.7600n -0.000515 426.7700n -0.000631 426.7800n -0.000745 426.7900n -0.000854 426.8000n -0.000959 426.8100n -0.001057 426.8200n -0.001149 426.8300n -0.001233 426.8400n -0.001311 426.8500n -0.001381 426.8600n -0.001443 426.8700n -0.001498 426.8800n -0.001545 426.8900n -0.001584
+ 426.9000n -0.001617 426.9100n -0.001643 426.9200n -0.001662 426.9300n -0.001675 426.9400n -0.001682 426.9500n -0.001684 426.9600n -0.001681 426.9700n -0.001672 426.9800n -0.001659 426.9900n -0.001642 427.0000n -0.001620 427.0100n -0.001595 427.0200n -0.001565 427.0300n -0.001533 427.0400n -0.001497
+ 427.0500n -0.001458 427.0600n -0.001416 427.0700n -0.001372 427.0800n -0.001326 427.0900n -0.001278 427.1000n -0.001228 427.1100n -0.001177 427.1200n -0.001126 427.1300n -0.001075 427.1400n -0.001025 427.1500n -0.000975 427.1600n -0.000928 427.1700n -0.000882 427.1800n -0.000840 427.1900n -0.000801
+ 427.2000n -0.000766 427.2100n -0.000735 427.2200n -0.000709 427.2300n -0.000688 427.2400n -0.000672 427.2500n -0.000662 427.2600n -0.000656 427.2700n -0.000655 427.2800n -0.000658 427.2900n -0.000665 427.3000n -0.000675 427.3100n -0.000687 427.3200n -0.000701 427.3300n -0.000714 427.3400n -0.000727
+ 427.3500n -0.000736 427.3600n -0.000743 427.3700n -0.000744 427.3800n -0.000739 427.3900n -0.000726 427.4000n -0.000705 427.4100n -0.000674 427.4200n -0.000633 427.4300n -0.000581 427.4400n -0.000518 427.4500n -0.000444 427.4600n -0.000358 427.4700n -0.000262 427.4800n -0.000157 427.4900n -0.000042
+ 427.5000n 0.000079 427.5100n 0.000206 427.5200n 0.000337 427.5300n 0.000468 427.5400n 0.000598 427.5500n 0.000724 427.5600n 0.000844 427.5700n 0.000953 427.5800n 0.001051 427.5900n 0.001132 427.6000n 0.001196 427.6100n 0.001239 427.6200n 0.001260 427.6300n 0.001255 427.6400n 0.001224
+ 427.6500n 0.001165 427.6600n 0.001078 427.6700n 0.000962 427.6800n 0.000817 427.6900n 0.000644 427.7000n 0.000445 427.7100n 0.000220 427.7200n -0.000027 427.7300n -0.000293 427.7400n -0.000576 427.7500n -0.000872 427.7600n -0.001176 427.7700n -0.001484 427.7800n -0.001792 427.7900n -0.002096
+ 427.8000n -0.002389 427.8100n -0.002668 427.8200n -0.002927 427.8300n -0.003164 427.8400n -0.003372 427.8500n -0.003550 427.8600n -0.003693 427.8700n -0.003799 427.8800n -0.003866 427.8900n -0.003891 427.9000n -0.003876 427.9100n -0.003819 427.9200n -0.003721 427.9300n -0.003583 427.9400n -0.003408
+ 427.9500n -0.003198 427.9600n -0.002957 427.9700n -0.002688 427.9800n -0.002396 427.9900n -0.002085 428.0000n -0.001761 428.0100n -0.001429 428.0200n -0.001094 428.0300n -0.000762 428.0400n -0.000438 428.0500n -0.000127 428.0600n 0.000166 428.0700n 0.000436 428.0800n 0.000680 428.0900n 0.000894
+ 428.1000n 0.001075 428.1100n 0.001222 428.1200n 0.001333 428.1300n 0.001407 428.1400n 0.001444 428.1500n 0.001446 428.1600n 0.001414 428.1700n 0.001350 428.1800n 0.001257 428.1900n 0.001138 428.2000n 0.000999 428.2100n 0.000842 428.2200n 0.000673 428.2300n 0.000497 428.2400n 0.000318
+ 428.2500n 0.000142 428.2600n -0.000026 428.2700n -0.000183 428.2800n -0.000323 428.2900n -0.000443 428.3000n -0.000539 428.3100n -0.000608 428.3200n -0.000649 428.3300n -0.000659 428.3400n -0.000639 428.3500n -0.000587 428.3600n -0.000505 428.3700n -0.000395 428.3800n -0.000257 428.3900n -0.000095
+ 428.4000n 0.000087 428.4100n 0.000287 428.4200n 0.000499 428.4300n 0.000720 428.4400n 0.000944 428.4500n 0.001167 428.4600n 0.001383 428.4700n 0.001589 428.4800n 0.001779 428.4900n 0.001948 428.5000n 0.002094 428.5100n 0.002213 428.5200n 0.002301 428.5300n 0.002357 428.5400n 0.002378
+ 428.5500n 0.002365 428.5600n 0.002316 428.5700n 0.002233 428.5800n 0.002116 428.5900n 0.001968 428.6000n 0.001791 428.6100n 0.001587 428.6200n 0.001362 428.6300n 0.001118 428.6400n 0.000860 428.6500n 0.000592 428.6600n 0.000320 428.6700n 0.000049 428.6800n -0.000218 428.6900n -0.000475
+ 428.7000n -0.000717 428.7100n -0.000942 428.7200n -0.001145 428.7300n -0.001324 428.7400n -0.001475 428.7500n -0.001597 428.7600n -0.001688 428.7700n -0.001747 428.7800n -0.001775 428.7900n -0.001773 428.8000n -0.001740 428.8100n -0.001680 428.8200n -0.001594 428.8300n -0.001485 428.8400n -0.001357
+ 428.8500n -0.001213 428.8600n -0.001056 428.8700n -0.000890 428.8800n -0.000720 428.8900n -0.000549 428.9000n -0.000382 428.9100n -0.000221 428.9200n -0.000070 428.9300n 0.000067 428.9400n 0.000189 428.9500n 0.000293 428.9600n 0.000378 428.9700n 0.000441 428.9800n 0.000484 428.9900n 0.000505
+ 429.0000n 0.000505 429.0100n 0.000484 429.0200n 0.000445 429.0300n 0.000389 429.0400n 0.000318 429.0500n 0.000235 429.0600n 0.000141 429.0700n 0.000041 429.0800n -0.000064 429.0900n -0.000170 429.1000n -0.000274 429.1100n -0.000375 429.1200n -0.000469 429.1300n -0.000553 429.1400n -0.000627
+ 429.1500n -0.000689 429.1600n -0.000737 429.1700n -0.000771 429.1800n -0.000790 429.1900n -0.000794 429.2000n -0.000784 429.2100n -0.000760 429.2200n -0.000725 429.2300n -0.000679 429.2400n -0.000624 429.2500n -0.000561 429.2600n -0.000495 429.2700n -0.000426 429.2800n -0.000356 429.2900n -0.000289
+ 429.3000n -0.000226 429.3100n -0.000170 429.3200n -0.000122 429.3300n -0.000084 429.3400n -0.000057 429.3500n -0.000042 429.3600n -0.000040 429.3700n -0.000051 429.3800n -0.000075 429.3900n -0.000112 429.4000n -0.000161 429.4100n -0.000220 429.4200n -0.000288 429.4300n -0.000364 429.4400n -0.000446
+ 429.4500n -0.000531 429.4600n -0.000618 429.4700n -0.000704 429.4800n -0.000787 429.4900n -0.000865 429.5000n -0.000935 429.5100n -0.000997 429.5200n -0.001049 429.5300n -0.001088 429.5400n -0.001115 429.5500n -0.001128 429.5600n -0.001127 429.5700n -0.001112 429.5800n -0.001084 429.5900n -0.001042
+ 429.6000n -0.000989 429.6100n -0.000924 429.6200n -0.000851 429.6300n -0.000771 429.6400n -0.000685 429.6500n -0.000597 429.6600n -0.000507 429.6700n -0.000419 429.6800n -0.000334 429.6900n -0.000255 429.7000n -0.000183 429.7100n -0.000120 429.7200n -0.000068 429.7300n -0.000028 429.7400n -0.000000
+ 429.7500n 0.000014 429.7600n 0.000015 429.7700n 0.000003 429.7800n -0.000022 429.7900n -0.000059 429.8000n -0.000106 429.8100n -0.000163 429.8200n -0.000227 429.8300n -0.000296 429.8400n -0.000368 429.8500n -0.000442 429.8600n -0.000515 429.8700n -0.000584 429.8800n -0.000648 429.8900n -0.000704
+ 429.9000n -0.000750 429.9100n -0.000786 429.9200n -0.000809 429.9300n -0.000819 429.9400n -0.000814 429.9500n -0.000795 429.9600n -0.000761 429.9700n -0.000713 429.9800n -0.000651 429.9900n -0.000578 430.0000n -0.000493 430.0100n -0.000400 430.0200n -0.000299 430.0300n -0.000194 430.0400n -0.000086
+ 430.0500n 0.000022 430.0600n 0.000127 430.0700n 0.000227 430.0800n 0.000319 430.0900n 0.000402 430.1000n 0.000473 430.1100n 0.000530 430.1200n 0.000572 430.1300n 0.000597 430.1400n 0.000605 430.1500n 0.000596 430.1600n 0.000568 430.1700n 0.000523 430.1800n 0.000461 430.1900n 0.000384
+ 430.2000n 0.000293 430.2100n 0.000190 430.2200n 0.000077 430.2300n -0.000044 430.2400n -0.000169 430.2500n -0.000297 430.2600n -0.000425 430.2700n -0.000549 430.2800n -0.000667 430.2900n -0.000777 430.3000n -0.000876 430.3100n -0.000961 430.3200n -0.001032 430.3300n -0.001085 430.3400n -0.001121
+ 430.3500n -0.001138 430.3600n -0.001137 430.3700n -0.001116 430.3800n -0.001077 430.3900n -0.001020 430.4000n -0.000948 430.4100n -0.000860 430.4200n -0.000760 430.4300n -0.000649 430.4400n -0.000531 430.4500n -0.000408 430.4600n -0.000282 430.4700n -0.000157 430.4800n -0.000035 430.4900n 0.000081
+ 430.5000n 0.000189 430.5100n 0.000285 430.5200n 0.000367 430.5300n 0.000435 430.5400n 0.000486 430.5500n 0.000518 430.5600n 0.000532 430.5700n 0.000527 430.5800n 0.000503 430.5900n 0.000460 430.6000n 0.000400 430.6100n 0.000323 430.6200n 0.000231 430.6300n 0.000126 430.6400n 0.000010
+ 430.6500n -0.000114 430.6600n -0.000244 430.6700n -0.000378 430.6800n -0.000511 430.6900n -0.000643 430.7000n -0.000769 430.7100n -0.000888 430.7200n -0.000998 430.7300n -0.001095 430.7400n -0.001178 430.7500n -0.001246 430.7600n -0.001297 430.7700n -0.001330 430.7800n -0.001346 430.7900n -0.001343
+ 430.8000n -0.001322 430.8100n -0.001283 430.8200n -0.001227 430.8300n -0.001155 430.8400n -0.001070 430.8500n -0.000971 430.8600n -0.000862 430.8700n -0.000743 430.8800n -0.000618 430.8900n -0.000487 430.9000n -0.000354 430.9100n -0.000219 430.9200n -0.000085 430.9300n 0.000046 430.9400n 0.000174
+ 430.9500n 0.000296 430.9600n 0.000412 430.9700n 0.000522 430.9800n 0.000624 430.9900n 0.000718 431.0000n 0.000805 431.0100n 0.000885 431.0200n 0.000958 431.0300n 0.001025 431.0400n 0.001087 431.0500n 0.001145 431.0600n 0.001201 431.0700n 0.001255 431.0800n 0.001309 431.0900n 0.001364
+ 431.1000n 0.001421 431.1100n 0.001481 431.1200n 0.001546 431.1300n 0.001616 431.1400n 0.001691 431.1500n 0.001771 431.1600n 0.001857 431.1700n 0.001949 431.1800n 0.002045 431.1900n 0.002145 431.2000n 0.002247 431.2100n 0.002351 431.2200n 0.002454 431.2300n 0.002555 431.2400n 0.002651
+ 431.2500n 0.002741 431.2600n 0.002822 431.2700n 0.002891 431.2800n 0.002947 431.2900n 0.002987 431.3000n 0.003009 431.3100n 0.003010 431.3200n 0.002990 431.3300n 0.002945 431.3400n 0.002876 431.3500n 0.002780 431.3600n 0.002658 431.3700n 0.002508 431.3800n 0.002332 431.3900n 0.002128
+ 431.4000n 0.001899 431.4100n 0.001645 431.4200n 0.001369 431.4300n 0.001071 431.4400n 0.000754 431.4500n 0.000421 431.4600n 0.000075 431.4700n -0.000281 431.4800n -0.000644 431.4900n -0.001010 431.5000n -0.001376 431.5100n -0.001739 431.5200n -0.002094 431.5300n -0.002438 431.5400n -0.002768
+ 431.5500n -0.003080 431.5600n -0.003371 431.5700n -0.003639 431.5800n -0.003880 431.5900n -0.004093 431.6000n -0.004276 431.6100n -0.004427 431.6200n -0.004544 431.6300n -0.004627 431.6400n -0.004676 431.6500n -0.004690 431.6600n -0.004670 431.6700n -0.004616 431.6800n -0.004530 431.6900n -0.004412
+ 431.7000n -0.004265 431.7100n -0.004091 431.7200n -0.003891 431.7300n -0.003669 431.7400n -0.003427 431.7500n -0.003168 431.7600n -0.002894 431.7700n -0.002611 431.7800n -0.002319 431.7900n -0.002024 431.8000n -0.001728 431.8100n -0.001433 431.8200n -0.001145 431.8300n -0.000865 431.8400n -0.000597
+ 431.8500n -0.000343 431.8600n -0.000106 431.8700n 0.000111 431.8800n 0.000306 431.8900n 0.000478 431.9000n 0.000625 431.9100n 0.000745 431.9200n 0.000837 431.9300n 0.000901 431.9400n 0.000936 431.9500n 0.000942 431.9600n 0.000918 431.9700n 0.000867 431.9800n 0.000789 431.9900n 0.000684
+ 432.0000n 0.000554 432.0100n 0.000402 432.0200n 0.000229 432.0300n 0.000038 432.0400n -0.000170 432.0500n -0.000390 432.0600n -0.000620 432.0700n -0.000858 432.0800n -0.001099 432.0900n -0.001342 432.1000n -0.001582 432.1100n -0.001816 432.1200n -0.002041 432.1300n -0.002255 432.1400n -0.002454
+ 432.1500n -0.002636 432.1600n -0.002798 432.1700n -0.002939 432.1800n -0.003056 432.1900n -0.003148 432.2000n -0.003214 432.2100n -0.003254 432.2200n -0.003266 432.2300n -0.003252 432.2400n -0.003211 432.2500n -0.003145 432.2600n -0.003055 432.2700n -0.002943 432.2800n -0.002810 432.2900n -0.002660
+ 432.3000n -0.002494 432.3100n -0.002315 432.3200n -0.002127 432.3300n -0.001933 432.3400n -0.001736 432.3500n -0.001539 432.3600n -0.001346 432.3700n -0.001160 432.3800n -0.000983 432.3900n -0.000818 432.4000n -0.000669 432.4100n -0.000537 432.4200n -0.000424 432.4300n -0.000331 432.4400n -0.000260
+ 432.4500n -0.000212 432.4600n -0.000185 432.4700n -0.000182 432.4800n -0.000200 432.4900n -0.000238 432.5000n -0.000296 432.5100n -0.000371 432.5200n -0.000461 432.5300n -0.000564 432.5400n -0.000676 432.5500n -0.000796 432.5600n -0.000920 432.5700n -0.001044 432.5800n -0.001166 432.5900n -0.001284
+ 432.6000n -0.001393 432.6100n -0.001491 432.6200n -0.001577 432.6300n -0.001647 432.6400n -0.001699 432.6500n -0.001733 432.6600n -0.001747 432.6700n -0.001741 432.6800n -0.001714 432.6900n -0.001666 432.7000n -0.001598 432.7100n -0.001512 432.7200n -0.001408 432.7300n -0.001288 432.7400n -0.001154
+ 432.7500n -0.001009 432.7600n -0.000855 432.7700n -0.000695 432.7800n -0.000531 432.7900n -0.000367 432.8000n -0.000205 432.8100n -0.000047 432.8200n 0.000103 432.8300n 0.000243 432.8400n 0.000371 432.8500n 0.000486 432.8600n 0.000585 432.8700n 0.000667 432.8800n 0.000733 432.8900n 0.000780
+ 432.9000n 0.000810 432.9100n 0.000823 432.9200n 0.000818 432.9300n 0.000798 432.9400n 0.000764 432.9500n 0.000716 432.9600n 0.000658 432.9700n 0.000590 432.9800n 0.000515 432.9900n 0.000435 433.0000n 0.000353 433.0100n 0.000270 433.0200n 0.000189 433.0300n 0.000111 433.0400n 0.000037
+ 433.0500n -0.000029 433.0600n -0.000088 433.0700n -0.000138 433.0800n -0.000179 433.0900n -0.000210 433.1000n -0.000232 433.1100n -0.000244 433.1200n -0.000247 433.1300n -0.000243 433.1400n -0.000232 433.1500n -0.000216 433.1600n -0.000196 433.1700n -0.000173 433.1800n -0.000150 433.1900n -0.000128
+ 433.2000n -0.000108 433.2100n -0.000093 433.2200n -0.000084 433.2300n -0.000081 433.2400n -0.000086 433.2500n -0.000100 433.2600n -0.000123 433.2700n -0.000156 433.2800n -0.000198 433.2900n -0.000248 433.3000n -0.000307 433.3100n -0.000373 433.3200n -0.000444 433.3300n -0.000519 433.3400n -0.000597
+ 433.3500n -0.000675 433.3600n -0.000751 433.3700n -0.000823 433.3800n -0.000889 433.3900n -0.000948 433.4000n -0.000996 433.4100n -0.001032 433.4200n -0.001055 433.4300n -0.001062 433.4400n -0.001054 433.4500n -0.001030 433.4600n -0.000989 433.4700n -0.000930 433.4800n -0.000856 433.4900n -0.000766
+ 433.5000n -0.000663 433.5100n -0.000547 433.5200n -0.000420 433.5300n -0.000286 433.5400n -0.000146 433.5500n -0.000003 433.5600n 0.000139 433.5700n 0.000277 433.5800n 0.000409 433.5900n 0.000532 433.6000n 0.000641 433.6100n 0.000736 433.6200n 0.000812 433.6300n 0.000868 433.6400n 0.000903
+ 433.6500n 0.000914 433.6600n 0.000900 433.6700n 0.000862 433.6800n 0.000798 433.6900n 0.000710 433.7000n 0.000598 433.7100n 0.000465 433.7200n 0.000311 433.7300n 0.000139 433.7400n -0.000048 433.7500n -0.000247 433.7600n -0.000455 433.7700n -0.000668 433.7800n -0.000882 433.7900n -0.001094
+ 433.8000n -0.001300 433.8100n -0.001496 433.8200n -0.001678 433.8300n -0.001845 433.8400n -0.001991 433.8500n -0.002116 433.8600n -0.002216 433.8700n -0.002291 433.8800n -0.002338 433.8900n -0.002357 433.9000n -0.002348 433.9100n -0.002311 433.9200n -0.002247 433.9300n -0.002157 433.9400n -0.002042
+ 433.9500n -0.001906 433.9600n -0.001751 433.9700n -0.001579 433.9800n -0.001394 433.9900n -0.001198 434.0000n -0.000995 434.0100n -0.000789 434.0200n -0.000583 434.0300n -0.000380 434.0400n -0.000183 434.0500n 0.000005 434.0600n 0.000182 434.0700n 0.000345 434.0800n 0.000492 434.0900n 0.000622
+ 434.1000n 0.000735 434.1100n 0.000829 434.1200n 0.000905 434.1300n 0.000962 434.1400n 0.001001 434.1500n 0.001024 434.1600n 0.001032 434.1700n 0.001025 434.1800n 0.001007 434.1900n 0.000980 434.2000n 0.000944 434.2100n 0.000904 434.2200n 0.000859 434.2300n 0.000814 434.2400n 0.000769
+ 434.2500n 0.000727 434.2600n 0.000689 434.2700n 0.000656 434.2800n 0.000629 434.2900n 0.000610 434.3000n 0.000597 434.3100n 0.000592 434.3200n 0.000595 434.3300n 0.000603 434.3400n 0.000617 434.3500n 0.000636 434.3600n 0.000658 434.3700n 0.000681 434.3800n 0.000704 434.3900n 0.000726
+ 434.4000n 0.000744 434.4100n 0.000756 434.4200n 0.000763 434.4300n 0.000761 434.4400n 0.000750 434.4500n 0.000729 434.4600n 0.000697 434.4700n 0.000654 434.4800n 0.000600 434.4900n 0.000536 434.5000n 0.000462 434.5100n 0.000379 434.5200n 0.000289 434.5300n 0.000193 434.5400n 0.000094
+ 434.5500n -0.000007 434.5600n -0.000107 434.5700n -0.000202 434.5800n -0.000292 434.5900n -0.000373 434.6000n -0.000442 434.6100n -0.000497 434.6200n -0.000537 434.6300n -0.000558 434.6400n -0.000561 434.6500n -0.000542 434.6600n -0.000502 434.6700n -0.000439 434.6800n -0.000355 434.6900n -0.000249
+ 434.7000n -0.000123 434.7100n 0.000022 434.7200n 0.000184 434.7300n 0.000361 434.7400n 0.000550 434.7500n 0.000747 434.7600n 0.000950 434.7700n 0.001154 434.7800n 0.001357 434.7900n 0.001553 434.8000n 0.001740 434.8100n 0.001914 434.8200n 0.002071 434.8300n 0.002207 434.8400n 0.002320
+ 434.8500n 0.002407 434.8600n 0.002466 434.8700n 0.002494 434.8800n 0.002491 434.8900n 0.002456 434.9000n 0.002388 434.9100n 0.002288 434.9200n 0.002157 434.9300n 0.001997 434.9400n 0.001809 434.9500n 0.001595 434.9600n 0.001360 434.9700n 0.001105 434.9800n 0.000835 434.9900n 0.000553
+ 435.0000n 0.000264 435.0100n -0.000029 435.0200n -0.000321 435.0300n -0.000609 435.0400n -0.000888 435.0500n -0.001155 435.0600n -0.001406 435.0700n -0.001638 435.0800n -0.001849 435.0900n -0.002035 435.1000n -0.002196 435.1100n -0.002329 435.1200n -0.002434 435.1300n -0.002511 435.1400n -0.002559
+ 435.1500n -0.002579 435.1600n -0.002571 435.1700n -0.002538 435.1800n -0.002481 435.1900n -0.002402 435.2000n -0.002304 435.2100n -0.002188 435.2200n -0.002058 435.2300n -0.001916 435.2400n -0.001765 435.2500n -0.001608 435.2600n -0.001448 435.2700n -0.001286 435.2800n -0.001127 435.2900n -0.000971
+ 435.3000n -0.000821 435.3100n -0.000678 435.3200n -0.000544 435.3300n -0.000419 435.3400n -0.000306 435.3500n -0.000204 435.3600n -0.000113 435.3700n -0.000034 435.3800n 0.000033 435.3900n 0.000090 435.4000n 0.000135 435.4100n 0.000171 435.4200n 0.000198 435.4300n 0.000216 435.4400n 0.000226
+ 435.4500n 0.000230 435.4600n 0.000228 435.4700n 0.000220 435.4800n 0.000207 435.4900n 0.000190 435.5000n 0.000169 435.5100n 0.000145 435.5200n 0.000116 435.5300n 0.000084 435.5400n 0.000048 435.5500n 0.000009 435.5600n -0.000035 435.5700n -0.000083 435.5800n -0.000136 435.5900n -0.000193
+ 435.6000n -0.000256 435.6100n -0.000324 435.6200n -0.000397 435.6300n -0.000476 435.6400n -0.000559 435.6500n -0.000647 435.6600n -0.000739 435.6700n -0.000833 435.6800n -0.000930 435.6900n -0.001027 435.7000n -0.001124 435.7100n -0.001219 435.7200n -0.001310 435.7300n -0.001396 435.7400n -0.001474
+ 435.7500n -0.001544 435.7600n -0.001602 435.7700n -0.001648 435.7800n -0.001679 435.7900n -0.001695 435.8000n -0.001694 435.8100n -0.001674 435.8200n -0.001635 435.8300n -0.001577 435.8400n -0.001500 435.8500n -0.001403 435.8600n -0.001287 435.8700n -0.001154 435.8800n -0.001004 435.8900n -0.000839
+ 435.9000n -0.000662 435.9100n -0.000474 435.9200n -0.000279 435.9300n -0.000079 435.9400n 0.000123 435.9500n 0.000324 435.9600n 0.000520 435.9700n 0.000709 435.9800n 0.000886 435.9900n 0.001050 436.0000n 0.001197 436.0100n 0.001325 436.0200n 0.001431 436.0300n 0.001514 436.0400n 0.001573
+ 436.0500n 0.001605 436.0600n 0.001611 436.0700n 0.001591 436.0800n 0.001545 436.0900n 0.001474 436.1000n 0.001379 436.1100n 0.001263 436.1200n 0.001127 436.1300n 0.000975 436.1400n 0.000810 436.1500n 0.000634 436.1600n 0.000451 436.1700n 0.000265 436.1800n 0.000080 436.1900n -0.000100
+ 436.2000n -0.000273 436.2100n -0.000434 436.2200n -0.000581 436.2300n -0.000710 436.2400n -0.000818 436.2500n -0.000905 436.2600n -0.000967 436.2700n -0.001004 436.2800n -0.001015 436.2900n -0.001000 436.3000n -0.000959 436.3100n -0.000892 436.3200n -0.000802 436.3300n -0.000690 436.3400n -0.000559
+ 436.3500n -0.000410 436.3600n -0.000247 436.3700n -0.000073 436.3800n 0.000109 436.3900n 0.000295 436.4000n 0.000482 436.4100n 0.000666 436.4200n 0.000844 436.4300n 0.001012 436.4400n 0.001168 436.4500n 0.001309 436.4600n 0.001433 436.4700n 0.001538 436.4800n 0.001621 436.4900n 0.001683
+ 436.5000n 0.001722 436.5100n 0.001739 436.5200n 0.001733 436.5300n 0.001706 436.5400n 0.001658 436.5500n 0.001591 436.5600n 0.001507 436.5700n 0.001409 436.5800n 0.001298 436.5900n 0.001177 436.6000n 0.001048 436.6100n 0.000915 436.6200n 0.000780 436.6300n 0.000646 436.6400n 0.000515
+ 436.6500n 0.000390 436.6600n 0.000272 436.6700n 0.000163 436.6800n 0.000066 436.6900n -0.000020 436.7000n -0.000094 436.7100n -0.000154 436.7200n -0.000202 436.7300n -0.000236 436.7400n -0.000259 436.7500n -0.000271 436.7600n -0.000273 436.7700n -0.000267 436.7800n -0.000254 436.7900n -0.000236
+ 436.8000n -0.000216 436.8100n -0.000194 436.8200n -0.000174 436.8300n -0.000156 436.8400n -0.000143 436.8500n -0.000136 436.8600n -0.000137 436.8700n -0.000147 436.8800n -0.000165 436.8900n -0.000194 436.9000n -0.000234 436.9100n -0.000283 436.9200n -0.000343 436.9300n -0.000411 436.9400n -0.000488
+ 436.9500n -0.000572 436.9600n -0.000661 436.9700n -0.000755 436.9800n -0.000851 436.9900n -0.000946 437.0000n -0.001041 437.0100n -0.001131 437.0200n -0.001216 437.0300n -0.001293 437.0400n -0.001360 437.0500n -0.001417 437.0600n -0.001461 437.0700n -0.001491 437.0800n -0.001507 437.0900n -0.001507
+ 437.1000n -0.001492 437.1100n -0.001460 437.1200n -0.001413 437.1300n -0.001350 437.1400n -0.001272 437.1500n -0.001181 437.1600n -0.001077 437.1700n -0.000961 437.1800n -0.000836 437.1900n -0.000703 437.2000n -0.000564 437.2100n -0.000420 437.2200n -0.000273 437.2300n -0.000125 437.2400n 0.000021
+ 437.2500n 0.000166 437.2600n 0.000306 437.2700n 0.000440 437.2800n 0.000568 437.2900n 0.000687 437.3000n 0.000798 437.3100n 0.000899 437.3200n 0.000989 437.3300n 0.001069 437.3400n 0.001138 437.3500n 0.001195 437.3600n 0.001242 437.3700n 0.001277 437.3800n 0.001302 437.3900n 0.001317
+ 437.4000n 0.001321 437.4100n 0.001316 437.4200n 0.001303 437.4300n 0.001280 437.4400n 0.001249 437.4500n 0.001211 437.4600n 0.001165 437.4700n 0.001112 437.4800n 0.001053 437.4900n 0.000987 437.5000n 0.000915 437.5100n 0.000836 437.5200n 0.000752 437.5300n 0.000662 437.5400n 0.000566
+ 437.5500n 0.000465 437.5600n 0.000359 437.5700n 0.000248 437.5800n 0.000133 437.5900n 0.000014 437.6000n -0.000108 437.6100n -0.000232 437.6200n -0.000358 437.6300n -0.000484 437.6400n -0.000610 437.6500n -0.000733 437.6600n -0.000853 437.6700n -0.000969 437.6800n -0.001077 437.6900n -0.001178
+ 437.7000n -0.001269 437.7100n -0.001348 437.7200n -0.001415 437.7300n -0.001468 437.7400n -0.001504 437.7500n -0.001525 437.7600n -0.001527 437.7700n -0.001511 437.7800n -0.001477 437.7900n -0.001423 437.8000n -0.001351 437.8100n -0.001260 437.8200n -0.001153 437.8300n -0.001029 437.8400n -0.000890
+ 437.8500n -0.000739 437.8600n -0.000577 437.8700n -0.000407 437.8800n -0.000232 437.8900n -0.000054 437.9000n 0.000124 437.9100n 0.000299 437.9200n 0.000467 437.9300n 0.000626 437.9400n 0.000773 437.9500n 0.000905 437.9600n 0.001020 437.9700n 0.001115 437.9800n 0.001189 437.9900n 0.001240
+ 438.0000n 0.001266 438.0100n 0.001269 438.0200n 0.001247 438.0300n 0.001201 438.0400n 0.001131 438.0500n 0.001040 438.0600n 0.000929 438.0700n 0.000800 438.0800n 0.000656 438.0900n 0.000501 438.1000n 0.000337 438.1100n 0.000168 438.1200n -0.000002 438.1300n -0.000169 438.1400n -0.000330
+ 438.1500n -0.000481 438.1600n -0.000617 438.1700n -0.000737 438.1800n -0.000836 438.1900n -0.000913 438.2000n -0.000964 438.2100n -0.000989 438.2200n -0.000986 438.2300n -0.000955 438.2400n -0.000895 438.2500n -0.000808 438.2600n -0.000694 438.2700n -0.000556 438.2800n -0.000395 438.2900n -0.000215
+ 438.3000n -0.000019 438.3100n 0.000190 438.3200n 0.000407 438.3300n 0.000628 438.3400n 0.000850 438.3500n 0.001067 438.3600n 0.001275 438.3700n 0.001470 438.3800n 0.001649 438.3900n 0.001807 438.4000n 0.001941 438.4100n 0.002049 438.4200n 0.002128 438.4300n 0.002177 438.4400n 0.002195
+ 438.4500n 0.002181 438.4600n 0.002136 438.4700n 0.002060 438.4800n 0.001955 438.4900n 0.001824 438.5000n 0.001670 438.5100n 0.001495 438.5200n 0.001303 438.5300n 0.001098 438.5400n 0.000885 438.5500n 0.000668 438.5600n 0.000452 438.5700n 0.000241 438.5800n 0.000040 438.5900n -0.000147
+ 438.6000n -0.000315 438.6100n -0.000463 438.6200n -0.000586 438.6300n -0.000682 438.6400n -0.000749 438.6500n -0.000786 438.6600n -0.000792 438.6700n -0.000767 438.6800n -0.000713 438.6900n -0.000630 438.7000n -0.000522 438.7100n -0.000389 438.7200n -0.000237 438.7300n -0.000068 438.7400n 0.000112
+ 438.7500n 0.000301 438.7600n 0.000492 438.7700n 0.000682 438.7800n 0.000866 438.7900n 0.001038 438.8000n 0.001194 438.8100n 0.001330 438.8200n 0.001442 438.8300n 0.001527 438.8400n 0.001581 438.8500n 0.001603 438.8600n 0.001592 438.8700n 0.001545 438.8800n 0.001463 438.8900n 0.001346
+ 438.9000n 0.001195 438.9100n 0.001013 438.9200n 0.000802 438.9300n 0.000564 438.9400n 0.000304 438.9500n 0.000026 438.9600n -0.000267 438.9700n -0.000568 438.9800n -0.000875 438.9900n -0.001180 439.0000n -0.001481 439.0100n -0.001771 439.0200n -0.002045 439.0300n -0.002301 439.0400n -0.002533
+ 439.0500n -0.002739 439.0600n -0.002914 439.0700n -0.003058 439.0800n -0.003167 439.0900n -0.003241 439.1000n -0.003279 439.1100n -0.003282 439.1200n -0.003249 439.1300n -0.003184 439.1400n -0.003086 439.1500n -0.002959 439.1600n -0.002806 439.1700n -0.002631 439.1800n -0.002435 439.1900n -0.002225
+ 439.2000n -0.002003 439.2100n -0.001774 439.2200n -0.001541 439.2300n -0.001310 439.2400n -0.001083 439.2500n -0.000865 439.2600n -0.000658 439.2700n -0.000465 439.2800n -0.000290 439.2900n -0.000134 439.3000n 0.000001 439.3100n 0.000114 439.3200n 0.000205 439.3300n 0.000273 439.3400n 0.000318
+ 439.3500n 0.000342 439.3600n 0.000345 439.3700n 0.000329 439.3800n 0.000295 439.3900n 0.000246 439.4000n 0.000185 439.4100n 0.000112 439.4200n 0.000032 439.4300n -0.000055 439.4400n -0.000144 439.4500n -0.000235 439.4600n -0.000324 439.4700n -0.000410 439.4800n -0.000491 439.4900n -0.000566
+ 439.5000n -0.000633 439.5100n -0.000692 439.5200n -0.000741 439.5300n -0.000780 439.5400n -0.000811 439.5500n -0.000831 439.5600n -0.000843 439.5700n -0.000847 439.5800n -0.000843 439.5900n -0.000833 439.6000n -0.000818 439.6100n -0.000799 439.6200n -0.000777 439.6300n -0.000753 439.6400n -0.000729
+ 439.6500n -0.000705 439.6600n -0.000682 439.6700n -0.000661 439.6800n -0.000642 439.6900n -0.000626 439.7000n -0.000613 439.7100n -0.000603 439.7200n -0.000595 439.7300n -0.000589 439.7400n -0.000585 439.7500n -0.000582 439.7600n -0.000578 439.7700n -0.000574 439.7800n -0.000567 439.7900n -0.000558
+ 439.8000n -0.000545 439.8100n -0.000526 439.8200n -0.000503 439.8300n -0.000473 439.8400n -0.000436 439.8500n -0.000392 439.8600n -0.000341 439.8700n -0.000284 439.8800n -0.000219 439.8900n -0.000148 439.9000n -0.000072 439.9100n 0.000008 439.9200n 0.000091 439.9300n 0.000176 439.9400n 0.000261
+ 439.9500n 0.000344 439.9600n 0.000424 439.9700n 0.000499 439.9800n 0.000568 439.9900n 0.000628 440.0000n 0.000678 440.0100n 0.000716 440.0200n 0.000742 440.0300n 0.000753 440.0400n 0.000750 440.0500n 0.000732 440.0600n 0.000699 440.0700n 0.000650 440.0800n 0.000586 440.0900n 0.000507
+ 440.1000n 0.000416 440.1100n 0.000312 440.1200n 0.000198 440.1300n 0.000075 440.1400n -0.000054 440.1500n -0.000187 440.1600n -0.000323 440.1700n -0.000457 440.1800n -0.000589 440.1900n -0.000715 440.2000n -0.000833 440.2100n -0.000940 440.2200n -0.001035 440.2300n -0.001115 440.2400n -0.001179
+ 440.2500n -0.001224 440.2600n -0.001251 440.2700n -0.001257 440.2800n -0.001242 440.2900n -0.001207 440.3000n -0.001152 440.3100n -0.001076 440.3200n -0.000981 440.3300n -0.000868 440.3400n -0.000738 440.3500n -0.000594 440.3600n -0.000437 440.3700n -0.000269 440.3800n -0.000094 440.3900n 0.000087
+ 440.4000n 0.000272 440.4100n 0.000456 440.4200n 0.000639 440.4300n 0.000816 440.4400n 0.000987 440.4500n 0.001148 440.4600n 0.001298 440.4700n 0.001435 440.4800n 0.001557 440.4900n 0.001663 440.5000n 0.001751 440.5100n 0.001821 440.5200n 0.001873 440.5300n 0.001905 440.5400n 0.001919
+ 440.5500n 0.001914 440.5600n 0.001891 440.5700n 0.001851 440.5800n 0.001795 440.5900n 0.001723 440.6000n 0.001638 440.6100n 0.001540 440.6200n 0.001431 440.6300n 0.001313 440.6400n 0.001187 440.6500n 0.001054 440.6600n 0.000916 440.6700n 0.000776 440.6800n 0.000633 440.6900n 0.000489
+ 440.7000n 0.000346 440.7100n 0.000205 440.7200n 0.000067 440.7300n -0.000068 440.7400n -0.000198 440.7500n -0.000323 440.7600n -0.000443 440.7700n -0.000556 440.7800n -0.000663 440.7900n -0.000763 440.8000n -0.000857 440.8100n -0.000943 440.8200n -0.001021 440.8300n -0.001092 440.8400n -0.001156
+ 440.8500n -0.001213 440.8600n -0.001261 440.8700n -0.001302 440.8800n -0.001336 440.8900n -0.001362 440.9000n -0.001380 440.9100n -0.001391 440.9200n -0.001394 440.9300n -0.001389 440.9400n -0.001377 440.9500n -0.001358 440.9600n -0.001332 440.9700n -0.001298 440.9800n -0.001258 440.9900n -0.001212
+ 441.0000n -0.001160 441.0100n -0.001102 441.0200n -0.001040 441.0300n -0.000973 441.0400n -0.000904 441.0500n -0.000832 441.0600n -0.000758 441.0700n -0.000684 441.0800n -0.000610 441.0900n -0.000538 441.1000n -0.000468 441.1100n -0.000402 441.1200n -0.000340 441.1300n -0.000284 441.1400n -0.000234
+ 441.1500n -0.000192 441.1600n -0.000158 441.1700n -0.000132 441.1800n -0.000115 441.1900n -0.000108 441.2000n -0.000111 441.2100n -0.000123 441.2200n -0.000144 441.2300n -0.000175 441.2400n -0.000214 441.2500n -0.000261 441.2600n -0.000316 441.2700n -0.000376 441.2800n -0.000442 441.2900n -0.000511
+ 441.3000n -0.000584 441.3100n -0.000657 441.3200n -0.000731 441.3300n -0.000804 441.3400n -0.000874 441.3500n -0.000941 441.3600n -0.001003 441.3700n -0.001058 441.3800n -0.001107 441.3900n -0.001148 441.4000n -0.001180 441.4100n -0.001203 441.4200n -0.001218 441.4300n -0.001222 441.4400n -0.001217
+ 441.4500n -0.001203 441.4600n -0.001180 441.4700n -0.001148 441.4800n -0.001109 441.4900n -0.001062 441.5000n -0.001009 441.5100n -0.000950 441.5200n -0.000887 441.5300n -0.000820 441.5400n -0.000751 441.5500n -0.000680 441.5600n -0.000608 441.5700n -0.000536 441.5800n -0.000465 441.5900n -0.000396
+ 441.6000n -0.000328 441.6100n -0.000263 441.6200n -0.000200 441.6300n -0.000140 441.6400n -0.000083 441.6500n -0.000029 441.6600n 0.000023 441.6700n 0.000073 441.6800n 0.000121 441.6900n 0.000168 441.7000n 0.000214 441.7100n 0.000259 441.7200n 0.000305 441.7300n 0.000352 441.7400n 0.000399
+ 441.7500n 0.000448 441.7600n 0.000499 441.7700n 0.000552 441.7800n 0.000607 441.7900n 0.000664 441.8000n 0.000722 441.8100n 0.000782 441.8200n 0.000843 441.8300n 0.000904 441.8400n 0.000965 441.8500n 0.001025 441.8600n 0.001082 441.8700n 0.001137 441.8800n 0.001188 441.8900n 0.001234
+ 441.9000n 0.001274 441.9100n 0.001308 441.9200n 0.001334 441.9300n 0.001352 441.9400n 0.001360 441.9500n 0.001360 441.9600n 0.001350 441.9700n 0.001330 441.9800n 0.001300 441.9900n 0.001261 442.0000n 0.001213 442.0100n 0.001156 442.0200n 0.001092 442.0300n 0.001022 442.0400n 0.000946
+ 442.0500n 0.000866 442.0600n 0.000784 442.0700n 0.000700 442.0800n 0.000617 442.0900n 0.000537 442.1000n 0.000459 442.1100n 0.000387 442.1200n 0.000320 442.1300n 0.000262 442.1400n 0.000211 442.1500n 0.000170 442.1600n 0.000139 442.1700n 0.000119 442.1800n 0.000108 442.1900n 0.000108
+ 442.2000n 0.000118 442.2100n 0.000137 442.2200n 0.000165 442.2300n 0.000199 442.2400n 0.000240 442.2500n 0.000284 442.2600n 0.000331 442.2700n 0.000379 442.2800n 0.000425 442.2900n 0.000469 442.3000n 0.000507 442.3100n 0.000539 442.3200n 0.000563 442.3300n 0.000576 442.3400n 0.000578
+ 442.3500n 0.000568 442.3600n 0.000544 442.3700n 0.000506 442.3800n 0.000455 442.3900n 0.000390 442.4000n 0.000311 442.4100n 0.000219 442.4200n 0.000116 442.4300n 0.000003 442.4400n -0.000118 442.4500n -0.000246 442.4600n -0.000378 442.4700n -0.000512 442.4800n -0.000644 442.4900n -0.000774
+ 442.5000n -0.000897 442.5100n -0.001011 442.5200n -0.001113 442.5300n -0.001202 442.5400n -0.001274 442.5500n -0.001328 442.5600n -0.001362 442.5700n -0.001374 442.5800n -0.001363 442.5900n -0.001329 442.6000n -0.001271 442.6100n -0.001188 442.6200n -0.001082 442.6300n -0.000953 442.6400n -0.000802
+ 442.6500n -0.000632 442.6600n -0.000442 442.6700n -0.000237 442.6800n -0.000018 442.6900n 0.000212 442.7000n 0.000451 442.7100n 0.000696 442.7200n 0.000943 442.7300n 0.001190 442.7400n 0.001434 442.7500n 0.001672 442.7600n 0.001902 442.7700n 0.002121 442.7800n 0.002328 442.7900n 0.002520
+ 442.8000n 0.002695 442.8100n 0.002854 442.8200n 0.002995 442.8300n 0.003117 442.8400n 0.003220 442.8500n 0.003305 442.8600n 0.003371 442.8700n 0.003421 442.8800n 0.003453 442.8900n 0.003471 442.9000n 0.003475 442.9100n 0.003466 442.9200n 0.003447 442.9300n 0.003419 442.9400n 0.003384
+ 442.9500n 0.003343 442.9600n 0.003297 442.9700n 0.003249 442.9800n 0.003199 442.9900n 0.003148 443.0000n 0.003098 443.0100n 0.003048 443.0200n 0.003000 443.0300n 0.002952 443.0400n 0.002906 443.0500n 0.002860 443.0600n 0.002815 443.0700n 0.002769 443.0800n 0.002721 443.0900n 0.002671
+ 443.1000n 0.002617 443.1100n 0.002558 443.1200n 0.002494 443.1300n 0.002422 443.1400n 0.002343 443.1500n 0.002254 443.1600n 0.002156 443.1700n 0.002048 443.1800n 0.001929 443.1900n 0.001799 443.2000n 0.001659 443.2100n 0.001509 443.2200n 0.001350 443.2300n 0.001181 443.2400n 0.001006
+ 443.2500n 0.000825 443.2600n 0.000639 443.2700n 0.000451 443.2800n 0.000262 443.2900n 0.000075 443.3000n -0.000109 443.3100n -0.000287 443.3200n -0.000458 443.3300n -0.000619 443.3400n -0.000769 443.3500n -0.000906 443.3600n -0.001029 443.3700n -0.001136 443.3800n -0.001226 443.3900n -0.001300
+ 443.4000n -0.001356 443.4100n -0.001394 443.4200n -0.001416 443.4300n -0.001421 443.4400n -0.001411 443.4500n -0.001387 443.4600n -0.001351 443.4700n -0.001303 443.4800n -0.001247 443.4900n -0.001185 443.5000n -0.001118 443.5100n -0.001050 443.5200n -0.000981 443.5300n -0.000916 443.5400n -0.000855
+ 443.5500n -0.000801 443.5600n -0.000756 443.5700n -0.000721 443.5800n -0.000699 443.5900n -0.000689 443.6000n -0.000692 443.6100n -0.000710 443.6200n -0.000742 443.6300n -0.000788 443.6400n -0.000848 443.6500n -0.000920 443.6600n -0.001003 443.6700n -0.001096 443.6800n -0.001197 443.6900n -0.001305
+ 443.7000n -0.001417 443.7100n -0.001531 443.7200n -0.001645 443.7300n -0.001756 443.7400n -0.001862 443.7500n -0.001962 443.7600n -0.002053 443.7700n -0.002134 443.7800n -0.002202 443.7900n -0.002256 443.8000n -0.002295 443.8100n -0.002319 443.8200n -0.002327 443.8300n -0.002318 443.8400n -0.002293
+ 443.8500n -0.002252 443.8600n -0.002196 443.8700n -0.002125 443.8800n -0.002041 443.8900n -0.001945 443.9000n -0.001839 443.9100n -0.001724 443.9200n -0.001603 443.9300n -0.001476 443.9400n -0.001346 443.9500n -0.001215 443.9600n -0.001085 443.9700n -0.000956 443.9800n -0.000831 443.9900n -0.000711
+ 444.0000n -0.000597 444.0100n -0.000490 444.0200n -0.000390 444.0300n -0.000299 444.0400n -0.000215 444.0500n -0.000141 444.0600n -0.000074 444.0700n -0.000015 444.0800n 0.000037 444.0900n 0.000083 444.1000n 0.000124 444.1100n 0.000159 444.1200n 0.000192 444.1300n 0.000222 444.1400n 0.000251
+ 444.1500n 0.000279 444.1600n 0.000307 444.1700n 0.000337 444.1800n 0.000369 444.1900n 0.000404 444.2000n 0.000441 444.2100n 0.000481 444.2200n 0.000523 444.2300n 0.000568 444.2400n 0.000616 444.2500n 0.000664 444.2600n 0.000713 444.2700n 0.000762 444.2800n 0.000809 444.2900n 0.000853
+ 444.3000n 0.000894 444.3100n 0.000929 444.3200n 0.000958 444.3300n 0.000980 444.3400n 0.000992 444.3500n 0.000995 444.3600n 0.000986 444.3700n 0.000967 444.3800n 0.000935 444.3900n 0.000891 444.4000n 0.000835 444.4100n 0.000767 444.4200n 0.000687 444.4300n 0.000595 444.4400n 0.000494
+ 444.4500n 0.000384 444.4600n 0.000266 444.4700n 0.000142 444.4800n 0.000014 444.4900n -0.000116 444.5000n -0.000247 444.5100n -0.000376 444.5200n -0.000502 444.5300n -0.000622 444.5400n -0.000734 444.5500n -0.000836 444.5600n -0.000927 444.5700n -0.001005 444.5800n -0.001069 444.5900n -0.001117
+ 444.6000n -0.001148 444.6100n -0.001161 444.6200n -0.001157 444.6300n -0.001135 444.6400n -0.001095 444.6500n -0.001037 444.6600n -0.000963 444.6700n -0.000872 444.6800n -0.000767 444.6900n -0.000649 444.7000n -0.000518 444.7100n -0.000378 444.7200n -0.000229 444.7300n -0.000074 444.7400n 0.000085
+ 444.7500n 0.000246 444.7600n 0.000408 444.7700n 0.000568 444.7800n 0.000724 444.7900n 0.000874 444.8000n 0.001017 444.8100n 0.001151 444.8200n 0.001275 444.8300n 0.001387 444.8400n 0.001486 444.8500n 0.001572 444.8600n 0.001644 444.8700n 0.001701 444.8800n 0.001743 444.8900n 0.001771
+ 444.9000n 0.001783 444.9100n 0.001782 444.9200n 0.001766 444.9300n 0.001737 444.9400n 0.001695 444.9500n 0.001641 444.9600n 0.001577 444.9700n 0.001503 444.9800n 0.001420 444.9900n 0.001330 445.0000n 0.001233 445.0100n 0.001131 445.0200n 0.001024 445.0300n 0.000915 445.0400n 0.000805
+ 445.0500n 0.000694 445.0600n 0.000583 445.0700n 0.000474 445.0800n 0.000368 445.0900n 0.000265 445.1000n 0.000168 445.1100n 0.000076 445.1200n -0.000010 445.1300n -0.000088 445.1400n -0.000159 445.1500n -0.000220 445.1600n -0.000272 445.1700n -0.000315 445.1800n -0.000347 445.1900n -0.000368
+ 445.2000n -0.000379 445.2100n -0.000378 445.2200n -0.000366 445.2300n -0.000343 445.2400n -0.000309 445.2500n -0.000265 445.2600n -0.000210 445.2700n -0.000145 445.2800n -0.000072 445.2900n 0.000010 445.3000n 0.000098 445.3100n 0.000193 445.3200n 0.000292 445.3300n 0.000394 445.3400n 0.000498
+ 445.3500n 0.000603 445.3600n 0.000706 445.3700n 0.000806 445.3800n 0.000901 445.3900n 0.000990 445.4000n 0.001070 445.4100n 0.001141 445.4200n 0.001200 445.4300n 0.001247 445.4400n 0.001279 445.4500n 0.001296 445.4600n 0.001298 445.4700n 0.001282 445.4800n 0.001250 445.4900n 0.001200
+ 445.5000n 0.001133 445.5100n 0.001049 445.5200n 0.000949 445.5300n 0.000834 445.5400n 0.000705 445.5500n 0.000563 445.5600n 0.000410 445.5700n 0.000248 445.5800n 0.000079 445.5900n -0.000094 445.6000n -0.000269 445.6100n -0.000445 445.6200n -0.000617 445.6300n -0.000785 445.6400n -0.000945
+ 445.6500n -0.001094 445.6600n -0.001232 445.6700n -0.001356 445.6800n -0.001463 445.6900n -0.001553 445.7000n -0.001624 445.7100n -0.001675 445.7200n -0.001705 445.7300n -0.001714 445.7400n -0.001702 445.7500n -0.001670 445.7600n -0.001617 445.7700n -0.001544 445.7800n -0.001454 445.7900n -0.001346
+ 445.8000n -0.001224 445.8100n -0.001088 445.8200n -0.000941 445.8300n -0.000785 445.8400n -0.000622 445.8500n -0.000454 445.8600n -0.000283 445.8700n -0.000112 445.8800n 0.000058 445.8900n 0.000225 445.9000n 0.000386 445.9100n 0.000542 445.9200n 0.000689 445.9300n 0.000829 445.9400n 0.000958
+ 445.9500n 0.001079 445.9600n 0.001189 445.9700n 0.001290 445.9800n 0.001381 445.9900n 0.001463 446.0000n 0.001537 446.0100n 0.001603 446.0200n 0.001663 446.0300n 0.001718 446.0400n 0.001768 446.0500n 0.001816 446.0600n 0.001862 446.0700n 0.001906 446.0800n 0.001951 446.0900n 0.001997
+ 446.1000n 0.002044 446.1100n 0.002094 446.1200n 0.002145 446.1300n 0.002199 446.1400n 0.002255 446.1500n 0.002312 446.1600n 0.002371 446.1700n 0.002429 446.1800n 0.002486 446.1900n 0.002541 446.2000n 0.002593 446.2100n 0.002639 446.2200n 0.002679 446.2300n 0.002711 446.2400n 0.002734
+ 446.2500n 0.002746 446.2600n 0.002745 446.2700n 0.002732 446.2800n 0.002705 446.2900n 0.002663 446.3000n 0.002605 446.3100n 0.002533 446.3200n 0.002445 446.3300n 0.002343 446.3400n 0.002226 446.3500n 0.002097 446.3600n 0.001956 446.3700n 0.001805 446.3800n 0.001646 446.3900n 0.001481
+ 446.4000n 0.001311 446.4100n 0.001140 446.4200n 0.000969 446.4300n 0.000801 446.4400n 0.000638 446.4500n 0.000482 446.4600n 0.000336 446.4700n 0.000200 446.4800n 0.000077 446.4900n -0.000033 446.5000n -0.000127 446.5100n -0.000207 446.5200n -0.000271 446.5300n -0.000320 446.5400n -0.000354
+ 446.5500n -0.000374 446.5600n -0.000381 446.5700n -0.000378 446.5800n -0.000365 446.5900n -0.000345 446.6000n -0.000321 446.6100n -0.000294 446.6200n -0.000268 446.6300n -0.000245 446.6400n -0.000227 446.6500n -0.000217 446.6600n -0.000217 446.6700n -0.000229 446.6800n -0.000255 446.6900n -0.000296
+ 446.7000n -0.000354 446.7100n -0.000429 446.7200n -0.000521 446.7300n -0.000629 446.7400n -0.000754 446.7500n -0.000894 446.7600n -0.001047 446.7700n -0.001211 446.7800n -0.001384 446.7900n -0.001563 446.8000n -0.001746 446.8100n -0.001927 446.8200n -0.002105 446.8300n -0.002276 446.8400n -0.002436
+ 446.8500n -0.002582 446.8600n -0.002710 446.8700n -0.002818 446.8800n -0.002902 446.8900n -0.002960 446.9000n -0.002991 446.9100n -0.002992 446.9200n -0.002963 446.9300n -0.002903 446.9400n -0.002812 446.9500n -0.002691 446.9600n -0.002540 446.9700n -0.002363 446.9800n -0.002160 446.9900n -0.001935
+ 447.0000n -0.001691 447.0100n -0.001432 447.0200n -0.001161 447.0300n -0.000882 447.0400n -0.000599 447.0500n -0.000318 447.0600n -0.000042 447.0700n 0.000225 447.0800n 0.000478 447.0900n 0.000714 447.1000n 0.000930 447.1100n 0.001121 447.1200n 0.001287 447.1300n 0.001424 447.1400n 0.001531
+ 447.1500n 0.001608 447.1600n 0.001653 447.1700n 0.001667 447.1800n 0.001650 447.1900n 0.001605 447.2000n 0.001532 447.2100n 0.001434 447.2200n 0.001314 447.2300n 0.001175 447.2400n 0.001021 447.2500n 0.000853 447.2600n 0.000678 447.2700n 0.000498 447.2800n 0.000316 447.2900n 0.000137
+ 447.3000n -0.000035 447.3100n -0.000199 447.3200n -0.000350 447.3300n -0.000487 447.3400n -0.000606 447.3500n -0.000708 447.3600n -0.000789 447.3700n -0.000851 447.3800n -0.000891 447.3900n -0.000912 447.4000n -0.000913 447.4100n -0.000896 447.4200n -0.000863 447.4300n -0.000815 447.4400n -0.000755
+ 447.4500n -0.000685 447.4600n -0.000609 447.4700n -0.000528 447.4800n -0.000447 447.4900n -0.000368 447.5000n -0.000294 447.5100n -0.000227 447.5200n -0.000170 447.5300n -0.000126 447.5400n -0.000096 447.5500n -0.000082 447.5600n -0.000084 447.5700n -0.000105 447.5800n -0.000144 447.5900n -0.000201
+ 447.6000n -0.000276 447.6100n -0.000368 447.6200n -0.000475 447.6300n -0.000597 447.6400n -0.000732 447.6500n -0.000877 447.6600n -0.001030 447.6700n -0.001189 447.6800n -0.001352 447.6900n -0.001515 447.7000n -0.001677 447.7100n -0.001834 447.7200n -0.001985 447.7300n -0.002127 447.7400n -0.002259
+ 447.7500n -0.002379 447.7600n -0.002485 447.7700n -0.002576 447.7800n -0.002652 447.7900n -0.002711 447.8000n -0.002754 447.8100n -0.002781 447.8200n -0.002791 447.8300n -0.002786 447.8400n -0.002765 447.8500n -0.002731 447.8600n -0.002684 447.8700n -0.002626 447.8800n -0.002557 447.8900n -0.002479
+ 447.9000n -0.002394 447.9100n -0.002303 447.9200n -0.002206 447.9300n -0.002106 447.9400n -0.002002 447.9500n -0.001897 447.9600n -0.001790 447.9700n -0.001683 447.9800n -0.001575 447.9900n -0.001468 448.0000n -0.001360 448.0100n -0.001253 448.0200n -0.001145 448.0300n -0.001037 448.0400n -0.000928
+ 448.0500n -0.000818 448.0600n -0.000707 448.0700n -0.000594 448.0800n -0.000479 448.0900n -0.000361 448.1000n -0.000241 448.1100n -0.000119 448.1200n 0.000006 448.1300n 0.000133 448.1400n 0.000262 448.1500n 0.000391 448.1600n 0.000522 448.1700n 0.000651 448.1800n 0.000779 448.1900n 0.000905
+ 448.2000n 0.001026 448.2100n 0.001143 448.2200n 0.001252 448.2300n 0.001354 448.2400n 0.001447 448.2500n 0.001530 448.2600n 0.001601 448.2700n 0.001660 448.2800n 0.001705 448.2900n 0.001737 448.3000n 0.001754 448.3100n 0.001757 448.3200n 0.001745 448.3300n 0.001720 448.3400n 0.001681
+ 448.3500n 0.001629 448.3600n 0.001566 448.3700n 0.001492 448.3800n 0.001410 448.3900n 0.001321 448.4000n 0.001227 448.4100n 0.001129 448.4200n 0.001030 448.4300n 0.000931 448.4400n 0.000835 448.4500n 0.000743 448.4600n 0.000657 448.4700n 0.000579 448.4800n 0.000510 448.4900n 0.000451
+ 448.5000n 0.000403 448.5100n 0.000368 448.5200n 0.000345 448.5300n 0.000334 448.5400n 0.000335 448.5500n 0.000349 448.5600n 0.000373 448.5700n 0.000408 448.5800n 0.000452 448.5900n 0.000504 448.6000n 0.000561 448.6100n 0.000623 448.6200n 0.000688 448.6300n 0.000754 448.6400n 0.000819
+ 448.6500n 0.000882 448.6600n 0.000940 448.6700n 0.000993 448.6800n 0.001040 448.6900n 0.001078 448.7000n 0.001107 448.7100n 0.001127 448.7200n 0.001137 448.7300n 0.001137 448.7400n 0.001127 448.7500n 0.001108 448.7600n 0.001079 448.7700n 0.001042 448.7800n 0.000998 448.7900n 0.000948
+ 448.8000n 0.000893 448.8100n 0.000833 448.8200n 0.000772 448.8300n 0.000709 448.8400n 0.000646 448.8500n 0.000585 448.8600n 0.000525 448.8700n 0.000469 448.8800n 0.000416 448.8900n 0.000368 448.9000n 0.000324 448.9100n 0.000284 448.9200n 0.000249 448.9300n 0.000217 448.9400n 0.000189
+ 448.9500n 0.000163 448.9600n 0.000139 448.9700n 0.000115 448.9800n 0.000090 448.9900n 0.000064 449.0000n 0.000034 449.0100n 0.000000 449.0200n -0.000039 449.0300n -0.000084 449.0400n -0.000137 449.0500n -0.000196 449.0600n -0.000263 449.0700n -0.000338 449.0800n -0.000420 449.0900n -0.000508
+ 449.1000n -0.000602 449.1100n -0.000701 449.1200n -0.000802 449.1300n -0.000905 449.1400n -0.001006 449.1500n -0.001104 449.1600n -0.001197 449.1700n -0.001281 449.1800n -0.001356 449.1900n -0.001417 449.2000n -0.001464 449.2100n -0.001493 449.2200n -0.001504 449.2300n -0.001493 449.2400n -0.001461
+ 449.2500n -0.001407 449.2600n -0.001329 449.2700n -0.001229 449.2800n -0.001106 449.2900n -0.000962 449.3000n -0.000799 449.3100n -0.000619 449.3200n -0.000424 449.3300n -0.000217 449.3400n -0.000002 449.3500n 0.000218 449.3600n 0.000438 449.3700n 0.000654 449.3800n 0.000863 449.3900n 0.001059
+ 449.4000n 0.001240 449.4100n 0.001400 449.4200n 0.001537 449.4300n 0.001647 449.4400n 0.001727 449.4500n 0.001776 449.4600n 0.001790 449.4700n 0.001771 449.4800n 0.001717 449.4900n 0.001628 449.5000n 0.001506 449.5100n 0.001354 449.5200n 0.001173 449.5300n 0.000967 449.5400n 0.000739
+ 449.5500n 0.000495 449.5600n 0.000239 449.5700n -0.000023 449.5800n -0.000286 449.5900n -0.000544 449.6000n -0.000791 449.6100n -0.001022 449.6200n -0.001231 449.6300n -0.001413 449.6400n -0.001564 449.6500n -0.001679 449.6600n -0.001754 449.6700n -0.001788 449.6800n -0.001778 449.6900n -0.001723
+ 449.7000n -0.001623 449.7100n -0.001480 449.7200n -0.001294 449.7300n -0.001068 449.7400n -0.000806 449.7500n -0.000513 449.7600n -0.000193 449.7700n 0.000147 449.7800n 0.000502 449.7900n 0.000865 449.8000n 0.001229 449.8100n 0.001586 449.8200n 0.001930 449.8300n 0.002253 449.8400n 0.002550
+ 449.8500n 0.002813 449.8600n 0.003037 449.8700n 0.003217 449.8800n 0.003350 449.8900n 0.003430 449.9000n 0.003458 449.9100n 0.003430 449.9200n 0.003346 449.9300n 0.003208 449.9400n 0.003018 449.9500n 0.002778 449.9600n 0.002491 449.9700n 0.002163 449.9800n 0.001800 449.9900n 0.001407
+ 450.0000n 0.000991 450.0100n 0.000560 450.0200n 0.000120 450.0300n -0.000320 450.0400n -0.000753 450.0500n -0.001171 450.0600n -0.001568 450.0700n -0.001937 450.0800n -0.002272 450.0900n -0.002567 450.1000n -0.002819 450.1100n -0.003023 450.1200n -0.003177 450.1300n -0.003280 450.1400n -0.003331
+ 450.1500n -0.003331 450.1600n -0.003281 450.1700n -0.003184 450.1800n -0.003044 450.1900n -0.002865 450.2000n -0.002651 450.2100n -0.002409 450.2200n -0.002146 450.2300n -0.001867 450.2400n -0.001579 450.2500n -0.001289 450.2600n -0.001004 450.2700n -0.000731 450.2800n -0.000475 450.2900n -0.000242
+ 450.3000n -0.000037 450.3100n 0.000135 450.3200n 0.000271 450.3300n 0.000370 450.3400n 0.000428 450.3500n 0.000446 450.3600n 0.000423 450.3700n 0.000361 450.3800n 0.000263 450.3900n 0.000130 450.4000n -0.000032 450.4100n -0.000220 450.4200n -0.000429 450.4300n -0.000652 450.4400n -0.000885
+ 450.4500n -0.001122 450.4600n -0.001356 450.4700n -0.001581 450.4800n -0.001792 450.4900n -0.001983 450.5000n -0.002150 450.5100n -0.002289 450.5200n -0.002395 450.5300n -0.002466 450.5400n -0.002501 450.5500n -0.002497 450.5600n -0.002455 450.5700n -0.002375 450.5800n -0.002258 450.5900n -0.002108
+ 450.6000n -0.001927 450.6100n -0.001719 450.6200n -0.001488 450.6300n -0.001238 450.6400n -0.000976 450.6500n -0.000707 450.6600n -0.000436 450.6700n -0.000169 450.6800n 0.000089 450.6900n 0.000332 450.7000n 0.000556 450.7100n 0.000755 450.7200n 0.000927 450.7300n 0.001068 450.7400n 0.001176
+ 450.7500n 0.001248 450.7600n 0.001284 450.7700n 0.001283 450.7800n 0.001246 450.7900n 0.001175 450.8000n 0.001072 450.8100n 0.000938 450.8200n 0.000779 450.8300n 0.000596 450.8400n 0.000395 450.8500n 0.000181 450.8600n -0.000044 450.8700n -0.000272 450.8800n -0.000500 450.8900n -0.000724
+ 450.9000n -0.000938 450.9100n -0.001139 450.9200n -0.001323 450.9300n -0.001488 450.9400n -0.001630 450.9500n -0.001749 450.9600n -0.001842 450.9700n -0.001909 450.9800n -0.001950 450.9900n -0.001967 451.0000n -0.001960 451.0100n -0.001932 451.0200n -0.001884 451.0300n -0.001821 451.0400n -0.001744
+ 451.0500n -0.001657 451.0600n -0.001565 451.0700n -0.001470 451.0800n -0.001377 451.0900n -0.001288 451.1000n -0.001207 451.1100n -0.001137 451.1200n -0.001080 451.1300n -0.001038 451.1400n -0.001013 451.1500n -0.001006 451.1600n -0.001017 451.1700n -0.001045 451.1800n -0.001090 451.1900n -0.001150
+ 451.2000n -0.001224 451.2100n -0.001309 451.2200n -0.001403 451.2300n -0.001502 451.2400n -0.001602 451.2500n -0.001701 451.2600n -0.001794 451.2700n -0.001879 451.2800n -0.001952 451.2900n -0.002009 451.3000n -0.002047 451.3100n -0.002065 451.3200n -0.002060 451.3300n -0.002032 451.3400n -0.001978
+ 451.3500n -0.001899 451.3600n -0.001795 451.3700n -0.001667 451.3800n -0.001517 451.3900n -0.001348 451.4000n -0.001161 451.4100n -0.000961 451.4200n -0.000752 451.4300n -0.000537 451.4400n -0.000320 451.4500n -0.000107 451.4600n 0.000098 451.4700n 0.000290 451.4800n 0.000466 451.4900n 0.000620
+ 451.5000n 0.000749 451.5100n 0.000849 451.5200n 0.000919 451.5300n 0.000955 451.5400n 0.000956 451.5500n 0.000920 451.5600n 0.000849 451.5700n 0.000743 451.5800n 0.000602 451.5900n 0.000429 451.6000n 0.000227 451.6100n -0.000001 451.6200n -0.000251 451.6300n -0.000519 451.6400n -0.000799
+ 451.6500n -0.001086 451.6600n -0.001376 451.6700n -0.001663 451.6800n -0.001940 451.6900n -0.002204 451.7000n -0.002449 451.7100n -0.002670 451.7200n -0.002862 451.7300n -0.003023 451.7400n -0.003149 451.7500n -0.003238 451.7600n -0.003287 451.7700n -0.003295 451.7800n -0.003263 451.7900n -0.003190
+ 451.8000n -0.003079 451.8100n -0.002929 451.8200n -0.002745 451.8300n -0.002530 451.8400n -0.002285 451.8500n -0.002017 451.8600n -0.001729 451.8700n -0.001426 451.8800n -0.001112 451.8900n -0.000793 451.9000n -0.000473 451.9100n -0.000157 451.9200n 0.000150 451.9300n 0.000445 451.9400n 0.000724
+ 451.9500n 0.000983 451.9600n 0.001220 451.9700n 0.001432 451.9800n 0.001619 451.9900n 0.001778 452.0000n 0.001910 452.0100n 0.002014 452.0200n 0.002092 452.0300n 0.002144 452.0400n 0.002173 452.0500n 0.002180 452.0600n 0.002167 452.0700n 0.002138 452.0800n 0.002095 452.0900n 0.002042
+ 452.1000n 0.001980 452.1100n 0.001914 452.1200n 0.001845 452.1300n 0.001777 452.1400n 0.001712 452.1500n 0.001651 452.1600n 0.001596 452.1700n 0.001549 452.1800n 0.001510 452.1900n 0.001479 452.2000n 0.001457 452.2100n 0.001443 452.2200n 0.001435 452.2300n 0.001433 452.2400n 0.001435
+ 452.2500n 0.001438 452.2600n 0.001442 452.2700n 0.001443 452.2800n 0.001440 452.2900n 0.001430 452.3000n 0.001410 452.3100n 0.001379 452.3200n 0.001335 452.3300n 0.001276 452.3400n 0.001201 452.3500n 0.001108 452.3600n 0.000998 452.3700n 0.000870 452.3800n 0.000725 452.3900n 0.000562
+ 452.4000n 0.000384 452.4100n 0.000192 452.4200n -0.000012 452.4300n -0.000225 452.4400n -0.000446 452.4500n -0.000671 452.4600n -0.000896 452.4700n -0.001120 452.4800n -0.001337 452.4900n -0.001546 452.5000n -0.001743 452.5100n -0.001925 452.5200n -0.002088 452.5300n -0.002232 452.5400n -0.002352
+ 452.5500n -0.002449 452.5600n -0.002519 452.5700n -0.002563 452.5800n -0.002580 452.5900n -0.002569 452.6000n -0.002532 452.6100n -0.002470 452.6200n -0.002383 452.6300n -0.002274 452.6400n -0.002146 452.6500n -0.001999 452.6600n -0.001839 452.6700n -0.001666 452.6800n -0.001486 452.6900n -0.001300
+ 452.7000n -0.001113 452.7100n -0.000927 452.7200n -0.000746 452.7300n -0.000572 452.7400n -0.000408 452.7500n -0.000256 452.7600n -0.000118 452.7700n 0.000003 452.7800n 0.000107 452.7900n 0.000194 452.8000n 0.000262 452.8100n 0.000312 452.8200n 0.000345 452.8300n 0.000361 452.8400n 0.000361
+ 452.8500n 0.000348 452.8600n 0.000322 452.8700n 0.000287 452.8800n 0.000245 452.8900n 0.000197 452.9000n 0.000147 452.9100n 0.000096 452.9200n 0.000049 452.9300n 0.000006 452.9400n -0.000031 452.9500n -0.000058 452.9600n -0.000074 452.9700n -0.000079 452.9800n -0.000070 452.9900n -0.000047
+ 453.0000n -0.000010 453.0100n 0.000042 453.0200n 0.000109 453.0300n 0.000188 453.0400n 0.000281 453.0500n 0.000385 453.0600n 0.000499 453.0700n 0.000621 453.0800n 0.000749 453.0900n 0.000881 453.1000n 0.001016 453.1100n 0.001150 453.1200n 0.001282 453.1300n 0.001409 453.1400n 0.001530
+ 453.1500n 0.001642 453.1600n 0.001743 453.1700n 0.001832 453.1800n 0.001907 453.1900n 0.001968 453.2000n 0.002014 453.2100n 0.002043 453.2200n 0.002056 453.2300n 0.002052 453.2400n 0.002032 453.2500n 0.001997 453.2600n 0.001946 453.2700n 0.001882 453.2800n 0.001805 453.2900n 0.001716
+ 453.3000n 0.001616 453.3100n 0.001509 453.3200n 0.001394 453.3300n 0.001273 453.3400n 0.001149 453.3500n 0.001023 453.3600n 0.000896 453.3700n 0.000770 453.3800n 0.000646 453.3900n 0.000525 453.4000n 0.000408 453.4100n 0.000297 453.4200n 0.000192 453.4300n 0.000094 453.4400n 0.000003
+ 453.4500n -0.000081 453.4600n -0.000156 453.4700n -0.000224 453.4800n -0.000284 453.4900n -0.000337 453.5000n -0.000382 453.5100n -0.000420 453.5200n -0.000452 453.5300n -0.000477 453.5400n -0.000497 453.5500n -0.000511 453.5600n -0.000521 453.5700n -0.000526 453.5800n -0.000528 453.5900n -0.000526
+ 453.6000n -0.000521 453.6100n -0.000514 453.6200n -0.000505 453.6300n -0.000493 453.6400n -0.000480 453.6500n -0.000466 453.6600n -0.000451 453.6700n -0.000435 453.6800n -0.000419 453.6900n -0.000403 453.7000n -0.000387 453.7100n -0.000371 453.7200n -0.000356 453.7300n -0.000342 453.7400n -0.000330
+ 453.7500n -0.000319 453.7600n -0.000310 453.7700n -0.000303 453.7800n -0.000299 453.7900n -0.000297 453.8000n -0.000299 453.8100n -0.000304 453.8200n -0.000312 453.8300n -0.000324 453.8400n -0.000340 453.8500n -0.000359 453.8600n -0.000382 453.8700n -0.000407 453.8800n -0.000436 453.8900n -0.000467
+ 453.9000n -0.000501 453.9100n -0.000535 453.9200n -0.000571 453.9300n -0.000606 453.9400n -0.000641 453.9500n -0.000674 453.9600n -0.000705 453.9700n -0.000732 453.9800n -0.000755 453.9900n -0.000772 454.0000n -0.000784 454.0100n -0.000789 454.0200n -0.000786 454.0300n -0.000775 454.0400n -0.000756
+ 454.0500n -0.000728 454.0600n -0.000691 454.0700n -0.000645 454.0800n -0.000591 454.0900n -0.000529 454.1000n -0.000459 454.1100n -0.000383 454.1200n -0.000301 454.1300n -0.000214 454.1400n -0.000124 454.1500n -0.000031 454.1600n 0.000062 454.1700n 0.000154 454.1800n 0.000243 454.1900n 0.000329
+ 454.2000n 0.000409 454.2100n 0.000483 454.2200n 0.000549 454.2300n 0.000605 454.2400n 0.000651 454.2500n 0.000686 454.2600n 0.000710 454.2700n 0.000721 454.2800n 0.000721 454.2900n 0.000709 454.3000n 0.000686 454.3100n 0.000653 454.3200n 0.000610 454.3300n 0.000559 454.3400n 0.000501
+ 454.3500n 0.000438 454.3600n 0.000372 454.3700n 0.000304 454.3800n 0.000237 454.3900n 0.000173 454.4000n 0.000114 454.4100n 0.000062 454.4200n 0.000019 454.4300n -0.000013 454.4400n -0.000033 454.4500n -0.000038 454.4600n -0.000029 454.4700n -0.000004 454.4800n 0.000037 454.4900n 0.000096
+ 454.5000n 0.000171 454.5100n 0.000262 454.5200n 0.000369 454.5300n 0.000490 454.5400n 0.000624 454.5500n 0.000768 454.5600n 0.000922 454.5700n 0.001083 454.5800n 0.001247 454.5900n 0.001413 454.6000n 0.001579 454.6100n 0.001740 454.6200n 0.001894 454.6300n 0.002039 454.6400n 0.002172
+ 454.6500n 0.002290 454.6600n 0.002392 454.6700n 0.002475 454.6800n 0.002537 454.6900n 0.002578 454.7000n 0.002596 454.7100n 0.002591 454.7200n 0.002563 454.7300n 0.002511 454.7400n 0.002437 454.7500n 0.002341 454.7600n 0.002225 454.7700n 0.002090 454.7800n 0.001939 454.7900n 0.001773
+ 454.8000n 0.001596 454.8100n 0.001410 454.8200n 0.001218 454.8300n 0.001022 454.8400n 0.000827 454.8500n 0.000633 454.8600n 0.000445 454.8700n 0.000265 454.8800n 0.000096 454.8900n -0.000061 454.9000n -0.000204 454.9100n -0.000330 454.9200n -0.000439 454.9300n -0.000529 454.9400n -0.000601
+ 454.9500n -0.000653 454.9600n -0.000687 454.9700n -0.000702 454.9800n -0.000699 454.9900n -0.000681 455.0000n -0.000648 455.0100n -0.000601 455.0200n -0.000544 455.0300n -0.000478 455.0400n -0.000405 455.0500n -0.000328 455.0600n -0.000249 455.0700n -0.000171 455.0800n -0.000095 455.0900n -0.000024
+ 455.1000n 0.000041 455.1100n 0.000096 455.1200n 0.000142 455.1300n 0.000176 455.1400n 0.000197 455.1500n 0.000205 455.1600n 0.000199 455.1700n 0.000180 455.1800n 0.000146 455.1900n 0.000099 455.2000n 0.000040 455.2100n -0.000032 455.2200n -0.000113 455.2300n -0.000205 455.2400n -0.000304
+ 455.2500n -0.000409 455.2600n -0.000518 455.2700n -0.000630 455.2800n -0.000743 455.2900n -0.000854 455.3000n -0.000963 455.3100n -0.001068 455.3200n -0.001167 455.3300n -0.001258 455.3400n -0.001341 455.3500n -0.001414 455.3600n -0.001476 455.3700n -0.001528 455.3800n -0.001568 455.3900n -0.001597
+ 455.4000n -0.001613 455.4100n -0.001618 455.4200n -0.001612 455.4300n -0.001595 455.4400n -0.001568 455.4500n -0.001531 455.4600n -0.001487 455.4700n -0.001435 455.4800n -0.001376 455.4900n -0.001313 455.5000n -0.001245 455.5100n -0.001175 455.5200n -0.001102 455.5300n -0.001029 455.5400n -0.000956
+ 455.5500n -0.000884 455.5600n -0.000813 455.5700n -0.000745 455.5800n -0.000680 455.5900n -0.000619 455.6000n -0.000561 455.6100n -0.000508 455.6200n -0.000460 455.6300n -0.000415 455.6400n -0.000376 455.6500n -0.000340 455.6600n -0.000309 455.6700n -0.000282 455.6800n -0.000258 455.6900n -0.000238
+ 455.7000n -0.000221 455.7100n -0.000207 455.7200n -0.000194 455.7300n -0.000184 455.7400n -0.000174 455.7500n -0.000166 455.7600n -0.000158 455.7700n -0.000151 455.7800n -0.000143 455.7900n -0.000134 455.8000n -0.000125 455.8100n -0.000114 455.8200n -0.000101 455.8300n -0.000087 455.8400n -0.000070
+ 455.8500n -0.000050 455.8600n -0.000028 455.8700n -0.000003 455.8800n 0.000026 455.8900n 0.000057 455.9000n 0.000093 455.9100n 0.000133 455.9200n 0.000176 455.9300n 0.000223 455.9400n 0.000275 455.9500n 0.000331 455.9600n 0.000390 455.9700n 0.000454 455.9800n 0.000522 455.9900n 0.000593
+ 456.0000n 0.000667 456.0100n 0.000745 456.0200n 0.000824 456.0300n 0.000906 456.0400n 0.000989 456.0500n 0.001073 456.0600n 0.001156 456.0700n 0.001239 456.0800n 0.001320 456.0900n 0.001398 456.1000n 0.001472 456.1100n 0.001542 456.1200n 0.001606 456.1300n 0.001664 456.1400n 0.001715
+ 456.1500n 0.001757 456.1600n 0.001790 456.1700n 0.001813 456.1800n 0.001826 456.1900n 0.001828 456.2000n 0.001819 456.2100n 0.001799 456.2200n 0.001767 456.2300n 0.001723 456.2400n 0.001669 456.2500n 0.001604 456.2600n 0.001528 456.2700n 0.001444 456.2800n 0.001351 456.2900n 0.001251
+ 456.3000n 0.001144 456.3100n 0.001033 456.3200n 0.000919 456.3300n 0.000802 456.3400n 0.000685 456.3500n 0.000570 456.3600n 0.000457 456.3700n 0.000348 456.3800n 0.000244 456.3900n 0.000148 456.4000n 0.000060 456.4100n -0.000019 456.4200n -0.000087 456.4300n -0.000144 456.4400n -0.000189
+ 456.4500n -0.000222 456.4600n -0.000242 456.4700n -0.000250 456.4800n -0.000245 456.4900n -0.000227 456.5000n -0.000198 456.5100n -0.000158 456.5200n -0.000108 456.5300n -0.000049 456.5400n 0.000019 456.5500n 0.000093 456.5600n 0.000173 456.5700n 0.000256 456.5800n 0.000343 456.5900n 0.000430
+ 456.6000n 0.000518 456.6100n 0.000603 456.6200n 0.000686 456.6300n 0.000765 456.6400n 0.000839 456.6500n 0.000906 456.6600n 0.000966 456.6700n 0.001019 456.6800n 0.001062 456.6900n 0.001096 456.7000n 0.001121 456.7100n 0.001137 456.7200n 0.001143 456.7300n 0.001139 456.7400n 0.001125
+ 456.7500n 0.001103 456.7600n 0.001071 456.7700n 0.001032 456.7800n 0.000984 456.7900n 0.000930 456.8000n 0.000869 456.8100n 0.000803 456.8200n 0.000731 456.8300n 0.000655 456.8400n 0.000575 456.8500n 0.000492 456.8600n 0.000407 456.8700n 0.000320 456.8800n 0.000232 456.8900n 0.000144
+ 456.9000n 0.000055 456.9100n -0.000033 456.9200n -0.000119 456.9300n -0.000204 456.9400n -0.000287 456.9500n -0.000367 456.9600n -0.000444 456.9700n -0.000517 456.9800n -0.000586 456.9900n -0.000651 457.0000n -0.000710 457.0100n -0.000764 457.0200n -0.000811 457.0300n -0.000852 457.0400n -0.000885
+ 457.0500n -0.000911 457.0600n -0.000928 457.0700n -0.000937 457.0800n -0.000937 457.0900n -0.000927 457.1000n -0.000908 457.1100n -0.000879 457.1200n -0.000840 457.1300n -0.000792 457.1400n -0.000734 457.1500n -0.000667 457.1600n -0.000592 457.1700n -0.000508 457.1800n -0.000418 457.1900n -0.000322
+ 457.2000n -0.000221 457.2100n -0.000116 457.2200n -0.000009 457.2300n 0.000098 457.2400n 0.000205 457.2500n 0.000308 457.2600n 0.000407 457.2700n 0.000500 457.2800n 0.000584 457.2900n 0.000659 457.3000n 0.000721 457.3100n 0.000771 457.3200n 0.000806 457.3300n 0.000826 457.3400n 0.000828
+ 457.3500n 0.000813 457.3600n 0.000780 457.3700n 0.000728 457.3800n 0.000657 457.3900n 0.000569 457.4000n 0.000463 457.4100n 0.000340 457.4200n 0.000202 457.4300n 0.000049 457.4400n -0.000116 457.4500n -0.000291 457.4600n -0.000475 457.4700n -0.000665 457.4800n -0.000858 457.4900n -0.001053
+ 457.5000n -0.001246 457.5100n -0.001436 457.5200n -0.001619 457.5300n -0.001794 457.5400n -0.001959 457.5500n -0.002111 457.5600n -0.002248 457.5700n -0.002370 457.5800n -0.002476 457.5900n -0.002563 457.6000n -0.002633 457.6100n -0.002684 457.6200n -0.002717 457.6300n -0.002733 457.6400n -0.002732
+ 457.6500n -0.002716 457.6600n -0.002685 457.6700n -0.002643 457.6800n -0.002590 457.6900n -0.002529 457.7000n -0.002462 457.7100n -0.002392 457.7200n -0.002319 457.7300n -0.002248 457.7400n -0.002179 457.7500n -0.002115 457.7600n -0.002057 457.7700n -0.002007 457.7800n -0.001967 457.7900n -0.001936
+ 457.8000n -0.001917 457.8100n -0.001908 457.8200n -0.001910 457.8300n -0.001922 457.8400n -0.001944 457.8500n -0.001975 457.8600n -0.002012 457.8700n -0.002055 457.8800n -0.002100 457.8900n -0.002147 457.9000n -0.002192 457.9100n -0.002234 457.9200n -0.002270 457.9300n -0.002297 457.9400n -0.002314
+ 457.9500n -0.002318 457.9600n -0.002307 457.9700n -0.002281 457.9800n -0.002236 457.9900n -0.002173 458.0000n -0.002091 458.0100n -0.001989 458.0200n -0.001868 458.0300n -0.001729 458.0400n -0.001572 458.0500n -0.001400 458.0600n -0.001214 458.0700n -0.001015 458.0800n -0.000808 458.0900n -0.000594
+ 458.1000n -0.000377 458.1100n -0.000160 458.1200n 0.000054 458.1300n 0.000261 458.1400n 0.000459 458.1500n 0.000644 458.1600n 0.000813 458.1700n 0.000964 458.1800n 0.001095 458.1900n 0.001202 458.2000n 0.001286 458.2100n 0.001343 458.2200n 0.001375 458.2300n 0.001381 458.2400n 0.001361
+ 458.2500n 0.001316 458.2600n 0.001247 458.2700n 0.001157 458.2800n 0.001047 458.2900n 0.000921 458.3000n 0.000781 458.3100n 0.000631 458.3200n 0.000474 458.3300n 0.000314 458.3400n 0.000155 458.3500n 0.000001 458.3600n -0.000146 458.3700n -0.000280 458.3800n -0.000399 458.3900n -0.000501
+ 458.4000n -0.000581 458.4100n -0.000638 458.4200n -0.000670 458.4300n -0.000677 458.4400n -0.000656 458.4500n -0.000608 458.4600n -0.000533 458.4700n -0.000433 458.4800n -0.000308 458.4900n -0.000160 458.5000n 0.000008 458.5100n 0.000193 458.5200n 0.000392 458.5300n 0.000602 458.5400n 0.000819
+ 458.5500n 0.001039 458.5600n 0.001258 458.5700n 0.001472 458.5800n 0.001677 458.5900n 0.001870 458.6000n 0.002046 458.6100n 0.002203 458.6200n 0.002337 458.6300n 0.002446 458.6400n 0.002528 458.6500n 0.002582 458.6600n 0.002605 458.6700n 0.002598 458.6800n 0.002560 458.6900n 0.002492
+ 458.7000n 0.002395 458.7100n 0.002270 458.7200n 0.002119 458.7300n 0.001946 458.7400n 0.001751 458.7500n 0.001540 458.7600n 0.001314 458.7700n 0.001078 458.7800n 0.000835 458.7900n 0.000589 458.8000n 0.000343 458.8100n 0.000103 458.8200n -0.000130 458.8300n -0.000351 458.8400n -0.000558
+ 458.8500n -0.000747 458.8600n -0.000916 458.8700n -0.001062 458.8800n -0.001184 458.8900n -0.001281 458.9000n -0.001351 458.9100n -0.001395 458.9200n -0.001411 458.9300n -0.001400 458.9400n -0.001362 458.9500n -0.001300 458.9600n -0.001214 458.9700n -0.001105 458.9800n -0.000977 458.9900n -0.000830
+ 459.0000n -0.000668 459.0100n -0.000493 459.0200n -0.000307 459.0300n -0.000113 459.0400n 0.000086 459.0500n 0.000288 459.0600n 0.000491 459.0700n 0.000691 459.0800n 0.000886 459.0900n 0.001075 459.1000n 0.001256 459.1100n 0.001426 459.1200n 0.001584 459.1300n 0.001730 459.1400n 0.001861
+ 459.1500n 0.001977 459.1600n 0.002078 459.1700n 0.002162 459.1800n 0.002231 459.1900n 0.002283 459.2000n 0.002319 459.2100n 0.002339 459.2200n 0.002343 459.2300n 0.002333 459.2400n 0.002309 459.2500n 0.002272 459.2600n 0.002223 459.2700n 0.002162 459.2800n 0.002091 459.2900n 0.002011
+ 459.3000n 0.001923 459.3100n 0.001827 459.3200n 0.001726 459.3300n 0.001620 459.3400n 0.001511 459.3500n 0.001399 459.3600n 0.001285 459.3700n 0.001171 459.3800n 0.001058 459.3900n 0.000946 459.4000n 0.000836 459.4100n 0.000730 459.4200n 0.000628 459.4300n 0.000531 459.4400n 0.000439
+ 459.4500n 0.000353 459.4600n 0.000273 459.4700n 0.000200 459.4800n 0.000135 459.4900n 0.000076 459.5000n 0.000024 459.5100n -0.000020 459.5200n -0.000057 459.5300n -0.000088 459.5400n -0.000113 459.5500n -0.000132 459.5600n -0.000146 459.5700n -0.000156 459.5800n -0.000162 459.5900n -0.000165
+ 459.6000n -0.000167 459.6100n -0.000168 459.6200n -0.000169 459.6300n -0.000171 459.6400n -0.000174 459.6500n -0.000181 459.6600n -0.000190 459.6700n -0.000203 459.6800n -0.000221 459.6900n -0.000243 459.7000n -0.000270 459.7100n -0.000302 459.7200n -0.000338 459.7300n -0.000378 459.7400n -0.000422
+ 459.7500n -0.000468 459.7600n -0.000515 459.7700n -0.000563 459.7800n -0.000610 459.7900n -0.000654 459.8000n -0.000695 459.8100n -0.000729 459.8200n -0.000756 459.8300n -0.000775 459.8400n -0.000782 459.8500n -0.000777 459.8600n -0.000759 459.8700n -0.000725 459.8800n -0.000676 459.8900n -0.000610
+ 459.9000n -0.000527 459.9100n -0.000426 459.9200n -0.000308 459.9300n -0.000173 459.9400n -0.000022 459.9500n 0.000144 459.9600n 0.000323 459.9700n 0.000513 459.9800n 0.000712 459.9900n 0.000918 460.0000n 0.001128 460.0100n 0.001338 460.0200n 0.001546 460.0300n 0.001748 460.0400n 0.001942
+ 460.0500n 0.002124 460.0600n 0.002290 460.0700n 0.002437 460.0800n 0.002564 460.0900n 0.002667 460.1000n 0.002744 460.1100n 0.002793 460.1200n 0.002813 460.1300n 0.002803 460.1400n 0.002763 460.1500n 0.002693 460.1600n 0.002593 460.1700n 0.002464 460.1800n 0.002310 460.1900n 0.002131
+ 460.2000n 0.001930 460.2100n 0.001711 460.2200n 0.001478 460.2300n 0.001233 460.2400n 0.000981 460.2500n 0.000727 460.2600n 0.000474 460.2700n 0.000227 460.2800n -0.000010 460.2900n -0.000233 460.3000n -0.000438 460.3100n -0.000621 460.3200n -0.000780 460.3300n -0.000913 460.3400n -0.001016
+ 460.3500n -0.001089 460.3600n -0.001131 460.3700n -0.001141 460.3800n -0.001121 460.3900n -0.001070 460.4000n -0.000992 460.4100n -0.000887 460.4200n -0.000760 460.4300n -0.000612 460.4400n -0.000449 460.4500n -0.000273 460.4600n -0.000088 460.4700n 0.000099 460.4800n 0.000286 460.4900n 0.000468
+ 460.5000n 0.000640 460.5100n 0.000799 460.5200n 0.000941 460.5300n 0.001062 460.5400n 0.001160 460.5500n 0.001233 460.5600n 0.001278 460.5700n 0.001295 460.5800n 0.001284 460.5900n 0.001244 460.6000n 0.001177 460.6100n 0.001085 460.6200n 0.000969 460.6300n 0.000832 460.6400n 0.000679
+ 460.6500n 0.000511 460.6600n 0.000334 460.6700n 0.000153 460.6800n -0.000030 460.6900n -0.000209 460.7000n -0.000379 460.7100n -0.000536 460.7200n -0.000676 460.7300n -0.000796 460.7400n -0.000892 460.7500n -0.000961 460.7600n -0.001001 460.7700n -0.001011 460.7800n -0.000990 460.7900n -0.000937
+ 460.8000n -0.000853 460.8100n -0.000740 460.8200n -0.000599 460.8300n -0.000434 460.8400n -0.000247 460.8500n -0.000042 460.8600n 0.000176 460.8700n 0.000404 460.8800n 0.000635 460.8900n 0.000865 460.9000n 0.001089 460.9100n 0.001302 460.9200n 0.001498 460.9300n 0.001675 460.9400n 0.001826
+ 460.9500n 0.001949 460.9600n 0.002040 460.9700n 0.002097 460.9800n 0.002118 460.9900n 0.002102 461.0000n 0.002048 461.0100n 0.001958 461.0200n 0.001832 461.0300n 0.001673 461.0400n 0.001483 461.0500n 0.001265 461.0600n 0.001024 461.0700n 0.000764 461.0800n 0.000490 461.0900n 0.000207
+ 461.1000n -0.000079 461.1100n -0.000363 461.1200n -0.000640 461.1300n -0.000905 461.1400n -0.001152 461.1500n -0.001376 461.1600n -0.001574 461.1700n -0.001742 461.1800n -0.001877 461.1900n -0.001977 461.2000n -0.002040 461.2100n -0.002065 461.2200n -0.002053 461.2300n -0.002004 461.2400n -0.001920
+ 461.2500n -0.001803 461.2600n -0.001656 461.2700n -0.001483 461.2800n -0.001288 461.2900n -0.001075 461.3000n -0.000849 461.3100n -0.000615 461.3200n -0.000379 461.3300n -0.000145 461.3400n 0.000082 461.3500n 0.000295 461.3600n 0.000492 461.3700n 0.000669 461.3800n 0.000820 461.3900n 0.000944
+ 461.4000n 0.001038 461.4100n 0.001101 461.4200n 0.001131 461.4300n 0.001129 461.4400n 0.001094 461.4500n 0.001028 461.4600n 0.000933 461.4700n 0.000811 461.4800n 0.000666 461.4900n 0.000500 461.5000n 0.000318 461.5100n 0.000124 461.5200n -0.000078 461.5300n -0.000284 461.5400n -0.000489
+ 461.5500n -0.000688 461.5600n -0.000878 461.5700n -0.001055 461.5800n -0.001215 461.5900n -0.001355 461.6000n -0.001472 461.6100n -0.001566 461.6200n -0.001634 461.6300n -0.001675 461.6400n -0.001690 461.6500n -0.001679 461.6600n -0.001643 461.6700n -0.001583 461.6800n -0.001502 461.6900n -0.001402
+ 461.7000n -0.001286 461.7100n -0.001156 461.7200n -0.001017 461.7300n -0.000870 461.7400n -0.000721 461.7500n -0.000572 461.7600n -0.000426 461.7700n -0.000286 461.7800n -0.000155 461.7900n -0.000035 461.8000n 0.000073 461.8100n 0.000166 461.8200n 0.000245 461.8300n 0.000309 461.8400n 0.000358
+ 461.8500n 0.000393 461.8600n 0.000415 461.8700n 0.000426 461.8800n 0.000428 461.8900n 0.000422 461.9000n 0.000412 461.9100n 0.000400 461.9200n 0.000390 461.9300n 0.000383 461.9400n 0.000383 461.9500n 0.000392 461.9600n 0.000412 461.9700n 0.000446 461.9800n 0.000496 461.9900n 0.000562
+ 462.0000n 0.000645 462.0100n 0.000746 462.0200n 0.000864 462.0300n 0.000998 462.0400n 0.001148 462.0500n 0.001311 462.0600n 0.001485 462.0700n 0.001667 462.0800n 0.001854 462.0900n 0.002043 462.1000n 0.002230 462.1100n 0.002412 462.1200n 0.002584 462.1300n 0.002742 462.1400n 0.002884
+ 462.1500n 0.003005 462.1600n 0.003103 462.1700n 0.003174 462.1800n 0.003217 462.1900n 0.003229 462.2000n 0.003210 462.2100n 0.003158 462.2200n 0.003074 462.2300n 0.002959 462.2400n 0.002813 462.2500n 0.002638 462.2600n 0.002437 462.2700n 0.002213 462.2800n 0.001969 462.2900n 0.001709
+ 462.3000n 0.001438 462.3100n 0.001159 462.3200n 0.000878 462.3300n 0.000599 462.3400n 0.000326 462.3500n 0.000064 462.3600n -0.000182 462.3700n -0.000409 462.3800n -0.000614 462.3900n -0.000792 462.4000n -0.000943 462.4100n -0.001063 462.4200n -0.001151 462.4300n -0.001208 462.4400n -0.001232
+ 462.4500n -0.001225 462.4600n -0.001187 462.4700n -0.001121 462.4800n -0.001029 462.4900n -0.000913 462.5000n -0.000778 462.5100n -0.000627 462.5200n -0.000463 462.5300n -0.000291 462.5400n -0.000116 462.5500n 0.000060 462.5600n 0.000231 462.5700n 0.000395 462.5800n 0.000546 462.5900n 0.000683
+ 462.6000n 0.000802 462.6100n 0.000900 462.6200n 0.000977 462.6300n 0.001030 462.6400n 0.001059 462.6500n 0.001064 462.6600n 0.001044 462.6700n 0.001002 462.6800n 0.000939 462.6900n 0.000855 462.7000n 0.000755 462.7100n 0.000640 462.7200n 0.000513 462.7300n 0.000379 462.7400n 0.000239
+ 462.7500n 0.000097 462.7600n -0.000043 462.7700n -0.000178 462.7800n -0.000305 462.7900n -0.000421 462.8000n -0.000524 462.8100n -0.000611 462.8200n -0.000682 462.8300n -0.000733 462.8400n -0.000766 462.8500n -0.000779 462.8600n -0.000772 462.8700n -0.000746 462.8800n -0.000702 462.8900n -0.000642
+ 462.9000n -0.000566 462.9100n -0.000478 462.9200n -0.000379 462.9300n -0.000272 462.9400n -0.000160 462.9500n -0.000044 462.9600n 0.000071 462.9700n 0.000184 462.9800n 0.000292 462.9900n 0.000394 463.0000n 0.000486 463.0100n 0.000567 463.0200n 0.000636 463.0300n 0.000693 463.0400n 0.000735
+ 463.0500n 0.000763 463.0600n 0.000778 463.0700n 0.000779 463.0800n 0.000767 463.0900n 0.000744 463.1000n 0.000711 463.1100n 0.000669 463.1200n 0.000621 463.1300n 0.000568 463.1400n 0.000513 463.1500n 0.000456 463.1600n 0.000401 463.1700n 0.000350 463.1800n 0.000303 463.1900n 0.000263
+ 463.2000n 0.000232 463.2100n 0.000209 463.2200n 0.000196 463.2300n 0.000194 463.2400n 0.000203 463.2500n 0.000222 463.2600n 0.000252 463.2700n 0.000291 463.2800n 0.000339 463.2900n 0.000395 463.3000n 0.000457 463.3100n 0.000524 463.3200n 0.000594 463.3300n 0.000666 463.3400n 0.000737
+ 463.3500n 0.000806 463.3600n 0.000873 463.3700n 0.000934 463.3800n 0.000990 463.3900n 0.001038 463.4000n 0.001078 463.4100n 0.001110 463.4200n 0.001132 463.4300n 0.001146 463.4400n 0.001151 463.4500n 0.001147 463.4600n 0.001135 463.4700n 0.001116 463.4800n 0.001092 463.4900n 0.001062
+ 463.5000n 0.001029 463.5100n 0.000994 463.5200n 0.000958 463.5300n 0.000923 463.5400n 0.000889 463.5500n 0.000858 463.5600n 0.000831 463.5700n 0.000809 463.5800n 0.000792 463.5900n 0.000781 463.6000n 0.000775 463.6100n 0.000775 463.6200n 0.000779 463.6300n 0.000788 463.6400n 0.000801
+ 463.6500n 0.000815 463.6600n 0.000830 463.6700n 0.000845 463.6800n 0.000857 463.6900n 0.000866 463.7000n 0.000868 463.7100n 0.000863 463.7200n 0.000849 463.7300n 0.000825 463.7400n 0.000789 463.7500n 0.000741 463.7600n 0.000679 463.7700n 0.000604 463.7800n 0.000514 463.7900n 0.000411
+ 463.8000n 0.000295 463.8100n 0.000167 463.8200n 0.000029 463.8300n -0.000118 463.8400n -0.000272 463.8500n -0.000431 463.8600n -0.000592 463.8700n -0.000753 463.8800n -0.000910 463.8900n -0.001061 463.9000n -0.001203 463.9100n -0.001333 463.9200n -0.001449 463.9300n -0.001548 463.9400n -0.001628
+ 463.9500n -0.001687 463.9600n -0.001724 463.9700n -0.001738 463.9800n -0.001727 463.9900n -0.001693 464.0000n -0.001635 464.0100n -0.001554 464.0200n -0.001451 464.0300n -0.001329 464.0400n -0.001188 464.0500n -0.001033 464.0600n -0.000866 464.0700n -0.000690 464.0800n -0.000508 464.0900n -0.000325
+ 464.1000n -0.000143 464.1100n 0.000033 464.1200n 0.000201 464.1300n 0.000356 464.1400n 0.000496 464.1500n 0.000617 464.1600n 0.000717 464.1700n 0.000795 464.1800n 0.000848 464.1900n 0.000875 464.2000n 0.000876 464.2100n 0.000851 464.2200n 0.000800 464.2300n 0.000724 464.2400n 0.000625
+ 464.2500n 0.000505 464.2600n 0.000366 464.2700n 0.000211 464.2800n 0.000042 464.2900n -0.000136 464.3000n -0.000320 464.3100n -0.000507 464.3200n -0.000692 464.3300n -0.000874 464.3400n -0.001047 464.3500n -0.001210 464.3600n -0.001359 464.3700n -0.001491 464.3800n -0.001606 464.3900n -0.001700
+ 464.4000n -0.001773 464.4100n -0.001825 464.4200n -0.001854 464.4300n -0.001862 464.4400n -0.001849 464.4500n -0.001816 464.4600n -0.001765 464.4700n -0.001699 464.4800n -0.001619 464.4900n -0.001529 464.5000n -0.001430 464.5100n -0.001326 464.5200n -0.001220 464.5300n -0.001115 464.5400n -0.001013
+ 464.5500n -0.000917 464.5600n -0.000829 464.5700n -0.000752 464.5800n -0.000686 464.5900n -0.000634 464.6000n -0.000596 464.6100n -0.000572 464.6200n -0.000563 464.6300n -0.000567 464.6400n -0.000584 464.6500n -0.000612 464.6600n -0.000650 464.6700n -0.000696 464.6800n -0.000747 464.6900n -0.000800
+ 464.7000n -0.000854 464.7100n -0.000905 464.7200n -0.000951 464.7300n -0.000990 464.7400n -0.001018 464.7500n -0.001034 464.7600n -0.001035 464.7700n -0.001022 464.7800n -0.000991 464.7900n -0.000943 464.8000n -0.000878 464.8100n -0.000797 464.8200n -0.000698 464.8300n -0.000586 464.8400n -0.000460
+ 464.8500n -0.000323 464.8600n -0.000179 464.8700n -0.000029 464.8800n 0.000123 464.8900n 0.000273 464.9000n 0.000418 464.9100n 0.000555 464.9200n 0.000680 464.9300n 0.000790 464.9400n 0.000882 464.9500n 0.000952 464.9600n 0.000999 464.9700n 0.001021 464.9800n 0.001016 464.9900n 0.000983
+ 465.0000n 0.000922 465.0100n 0.000834 465.0200n 0.000718 465.0300n 0.000578 465.0400n 0.000414 465.0500n 0.000229 465.0600n 0.000027 465.0700n -0.000190 465.0800n -0.000416 465.0900n -0.000648 465.1000n -0.000881 465.1100n -0.001112 465.1200n -0.001334 465.1300n -0.001544 465.1400n -0.001738
+ 465.1500n -0.001911 465.1600n -0.002060 465.1700n -0.002181 465.1800n -0.002272 465.1900n -0.002330 465.2000n -0.002354 465.2100n -0.002343 465.2200n -0.002297 465.2300n -0.002216 465.2400n -0.002102 465.2500n -0.001955 465.2600n -0.001780 465.2700n -0.001577 465.2800n -0.001352 465.2900n -0.001108
+ 465.3000n -0.000850 465.3100n -0.000582 465.3200n -0.000308 465.3300n -0.000035 465.3400n 0.000234 465.3500n 0.000493 465.3600n 0.000738 465.3700n 0.000965 465.3800n 0.001170 465.3900n 0.001349 465.4000n 0.001499 465.4100n 0.001619 465.4200n 0.001706 465.4300n 0.001760 465.4400n 0.001781
+ 465.4500n 0.001767 465.4600n 0.001722 465.4700n 0.001645 465.4800n 0.001540 465.4900n 0.001409 465.5000n 0.001256 465.5100n 0.001083 465.5200n 0.000895 465.5300n 0.000696 465.5400n 0.000491 465.5500n 0.000282 465.5600n 0.000076 465.5700n -0.000125 465.5800n -0.000315 465.5900n -0.000493
+ 465.6000n -0.000654 465.6100n -0.000796 465.6200n -0.000917 465.6300n -0.001014 465.6400n -0.001088 465.6500n -0.001136 465.6600n -0.001160 465.6700n -0.001159 465.6800n -0.001135 465.6900n -0.001090 465.7000n -0.001025 465.7100n -0.000943 465.7200n -0.000847 465.7300n -0.000739 465.7400n -0.000624
+ 465.7500n -0.000504 465.7600n -0.000383 465.7700n -0.000263 465.7800n -0.000149 465.7900n -0.000042 465.8000n 0.000054 465.8100n 0.000136 465.8200n 0.000204 465.8300n 0.000256 465.8400n 0.000291 465.8500n 0.000307 465.8600n 0.000306 465.8700n 0.000288 465.8800n 0.000253 465.8900n 0.000203
+ 465.9000n 0.000140 465.9100n 0.000066 465.9200n -0.000016 465.9300n -0.000104 465.9400n -0.000195 465.9500n -0.000286 465.9600n -0.000374 465.9700n -0.000456 465.9800n -0.000528 465.9900n -0.000589 466.0000n -0.000636 466.0100n -0.000666 466.0200n -0.000678 466.0300n -0.000671 466.0400n -0.000644
+ 466.0500n -0.000596 466.0600n -0.000527 466.0700n -0.000439 466.0800n -0.000331 466.0900n -0.000206 466.1000n -0.000065 466.1100n 0.000089 466.1200n 0.000254 466.1300n 0.000426 466.1400n 0.000603 466.1500n 0.000780 466.1600n 0.000956 466.1700n 0.001125 466.1800n 0.001285 466.1900n 0.001433
+ 466.2000n 0.001565 466.2100n 0.001678 466.2200n 0.001770 466.2300n 0.001839 466.2400n 0.001882 466.2500n 0.001899 466.2600n 0.001889 466.2700n 0.001851 466.2800n 0.001786 466.2900n 0.001693 466.3000n 0.001575 466.3100n 0.001432 466.3200n 0.001268 466.3300n 0.001083 466.3400n 0.000881
+ 466.3500n 0.000665 466.3600n 0.000439 466.3700n 0.000205 466.3800n -0.000034 466.3900n -0.000272 466.4000n -0.000507 466.4100n -0.000736 466.4200n -0.000954 466.4300n -0.001159 466.4400n -0.001349 466.4500n -0.001520 466.4600n -0.001670 466.4700n -0.001798 466.4800n -0.001903 466.4900n -0.001982
+ 466.5000n -0.002037 466.5100n -0.002066 466.5200n -0.002070 466.5300n -0.002050 466.5400n -0.002007 466.5500n -0.001942 466.5600n -0.001858 466.5700n -0.001757 466.5800n -0.001640 466.5900n -0.001511 466.6000n -0.001372 466.6100n -0.001226 466.6200n -0.001076 466.6300n -0.000925 466.6400n -0.000775
+ 466.6500n -0.000629 466.6600n -0.000490 466.6700n -0.000361 466.6800n -0.000242 466.6900n -0.000136 466.7000n -0.000045 466.7100n 0.000030 466.7200n 0.000089 466.7300n 0.000130 466.7400n 0.000154 466.7500n 0.000159 466.7600n 0.000148 466.7700n 0.000120 466.7800n 0.000076 466.7900n 0.000017
+ 466.8000n -0.000055 466.8100n -0.000140 466.8200n -0.000234 466.8300n -0.000336 466.8400n -0.000445 466.8500n -0.000558 466.8600n -0.000674 466.8700n -0.000790 466.8800n -0.000904 466.8900n -0.001015 466.9000n -0.001121 466.9100n -0.001221 466.9200n -0.001312 466.9300n -0.001394 466.9400n -0.001466
+ 466.9500n -0.001526 466.9600n -0.001574 466.9700n -0.001610 466.9800n -0.001633 466.9900n -0.001643 467.0000n -0.001641 467.0100n -0.001627 467.0200n -0.001602 467.0300n -0.001566 467.0400n -0.001520 467.0500n -0.001466 467.0600n -0.001404 467.0700n -0.001336 467.0800n -0.001263 467.0900n -0.001187
+ 467.1000n -0.001108 467.1100n -0.001029 467.1200n -0.000951 467.1300n -0.000875 467.1400n -0.000802 467.1500n -0.000733 467.1600n -0.000670 467.1700n -0.000614 467.1800n -0.000564 467.1900n -0.000522 467.2000n -0.000488 467.2100n -0.000462 467.2200n -0.000445 467.2300n -0.000436 467.2400n -0.000435
+ 467.2500n -0.000441 467.2600n -0.000454 467.2700n -0.000473 467.2800n -0.000497 467.2900n -0.000525 467.3000n -0.000556 467.3100n -0.000589 467.3200n -0.000621 467.3300n -0.000653 467.3400n -0.000682 467.3500n -0.000708 467.3600n -0.000729 467.3700n -0.000744 467.3800n -0.000751 467.3900n -0.000751
+ 467.4000n -0.000741 467.4100n -0.000723 467.4200n -0.000694 467.4300n -0.000655 467.4400n -0.000605 467.4500n -0.000546 467.4600n -0.000477 467.4700n -0.000399 467.4800n -0.000312 467.4900n -0.000219 467.5000n -0.000119 467.5100n -0.000015 467.5200n 0.000093 467.5300n 0.000202 467.5400n 0.000311
+ 467.5500n 0.000417 467.5600n 0.000520 467.5700n 0.000618 467.5800n 0.000708 467.5900n 0.000788 467.6000n 0.000859 467.6100n 0.000917 467.6200n 0.000962 467.6300n 0.000992 467.6400n 0.001007 467.6500n 0.001007 467.6600n 0.000990 467.6700n 0.000957 467.6800n 0.000909 467.6900n 0.000845
+ 467.7000n 0.000767 467.7100n 0.000675 467.7200n 0.000571 467.7300n 0.000457 467.7400n 0.000334 467.7500n 0.000205 467.7600n 0.000070 467.7700n -0.000067 467.7800n -0.000204 467.7900n -0.000339 467.8000n -0.000470 467.8100n -0.000594 467.8200n -0.000710 467.8300n -0.000816 467.8400n -0.000910
+ 467.8500n -0.000990 467.8600n -0.001056 467.8700n -0.001106 467.8800n -0.001139 467.8900n -0.001156 467.9000n -0.001157 467.9100n -0.001141 467.9200n -0.001109 467.9300n -0.001063 467.9400n -0.001003 467.9500n -0.000931 467.9600n -0.000848 467.9700n -0.000756 467.9800n -0.000657 467.9900n -0.000554
+ 468.0000n -0.000448 468.0100n -0.000342 468.0200n -0.000237 468.0300n -0.000136 468.0400n -0.000040 468.0500n 0.000049 468.0600n 0.000129 468.0700n 0.000199 468.0800n 0.000258 468.0900n 0.000305 468.1000n 0.000340 468.1100n 0.000363 468.1200n 0.000373 468.1300n 0.000372 468.1400n 0.000359
+ 468.1500n 0.000336 468.1600n 0.000305 468.1700n 0.000266 468.1800n 0.000220 468.1900n 0.000171 468.2000n 0.000118 468.2100n 0.000065 468.2200n 0.000012 468.2300n -0.000038 468.2400n -0.000084 468.2500n -0.000124 468.2600n -0.000158 468.2700n -0.000184 468.2800n -0.000202 468.2900n -0.000211
+ 468.3000n -0.000211 468.3100n -0.000201 468.3200n -0.000183 468.3300n -0.000157 468.3400n -0.000124 468.3500n -0.000085 468.3600n -0.000041 468.3700n 0.000007 468.3800n 0.000055 468.3900n 0.000104 468.4000n 0.000150 468.4100n 0.000193 468.4200n 0.000231 468.4300n 0.000261 468.4400n 0.000283
+ 468.4500n 0.000295 468.4600n 0.000297 468.4700n 0.000287 468.4800n 0.000266 468.4900n 0.000233 468.5000n 0.000188 468.5100n 0.000132 468.5200n 0.000066 468.5300n -0.000009 468.5400n -0.000090 468.5500n -0.000178 468.5600n -0.000268 468.5700n -0.000359 468.5800n -0.000449 468.5900n -0.000536
+ 468.6000n -0.000615 468.6100n -0.000686 468.6200n -0.000745 468.6300n -0.000791 468.6400n -0.000821 468.6500n -0.000833 468.6600n -0.000827 468.6700n -0.000800 468.6800n -0.000753 468.6900n -0.000685 468.7000n -0.000596 468.7100n -0.000487 468.7200n -0.000359 468.7300n -0.000214 468.7400n -0.000053
+ 468.7500n 0.000121 468.7600n 0.000306 468.7700n 0.000497 468.7800n 0.000693 468.7900n 0.000890 468.8000n 0.001084 468.8100n 0.001271 468.8200n 0.001448 468.8300n 0.001612 468.8400n 0.001759 468.8500n 0.001886 468.8600n 0.001991 468.8700n 0.002071 468.8800n 0.002124 468.8900n 0.002150
+ 468.9000n 0.002148 468.9100n 0.002116 468.9200n 0.002056 468.9300n 0.001968 468.9400n 0.001854 468.9500n 0.001716 468.9600n 0.001556 468.9700n 0.001377 468.9800n 0.001182 468.9900n 0.000975 469.0000n 0.000760 469.0100n 0.000541 469.0200n 0.000322 469.0300n 0.000107 469.0400n -0.000100
+ 469.0500n -0.000294 469.0600n -0.000473 469.0700n -0.000633 469.0800n -0.000770 469.0900n -0.000883 469.1000n -0.000968 469.1100n -0.001026 469.1200n -0.001055 469.1300n -0.001054 469.1400n -0.001024 469.1500n -0.000966 469.1600n -0.000881 469.1700n -0.000771 469.1800n -0.000639 469.1900n -0.000488
+ 469.2000n -0.000320 469.2100n -0.000140 469.2200n 0.000048 469.2300n 0.000242 469.2400n 0.000435 469.2500n 0.000626 469.2600n 0.000809 469.2700n 0.000981 469.2800n 0.001138 469.2900n 0.001278 469.3000n 0.001398 469.3100n 0.001495 469.3200n 0.001568 469.3300n 0.001615 469.3400n 0.001637
+ 469.3500n 0.001632 469.3600n 0.001601 469.3700n 0.001546 469.3800n 0.001468 469.3900n 0.001369 469.4000n 0.001251 469.4100n 0.001117 469.4200n 0.000971 469.4300n 0.000815 469.4400n 0.000653 469.4500n 0.000489 469.4600n 0.000326 469.4700n 0.000167 469.4800n 0.000016 469.4900n -0.000124
+ 469.5000n -0.000251 469.5100n -0.000363 469.5200n -0.000456 469.5300n -0.000531 469.5400n -0.000586 469.5500n -0.000620 469.5600n -0.000633 469.5700n -0.000627 469.5800n -0.000602 469.5900n -0.000558 469.6000n -0.000500 469.6100n -0.000427 469.6200n -0.000343 469.6300n -0.000251 469.6400n -0.000153
+ 469.6500n -0.000052 469.6600n 0.000049 469.6700n 0.000147 469.6800n 0.000239 469.6900n 0.000323 469.7000n 0.000396 469.7100n 0.000457 469.7200n 0.000504 469.7300n 0.000536 469.7400n 0.000551 469.7500n 0.000551 469.7600n 0.000534 469.7700n 0.000501 469.7800n 0.000455 469.7900n 0.000395
+ 469.8000n 0.000323 469.8100n 0.000243 469.8200n 0.000155 469.8300n 0.000064 469.8400n -0.000029 469.8500n -0.000120 469.8600n -0.000207 469.8700n -0.000287 469.8800n -0.000357 469.8900n -0.000415 469.9000n -0.000458 469.9100n -0.000485 469.9200n -0.000493 469.9300n -0.000483 469.9400n -0.000453
+ 469.9500n -0.000402 469.9600n -0.000331 469.9700n -0.000241 469.9800n -0.000133 469.9900n -0.000007 470.0000n 0.000133 470.0100n 0.000286 470.0200n 0.000450 470.0300n 0.000621 470.0400n 0.000797 470.0500n 0.000974 470.0600n 0.001149 470.0700n 0.001320 470.0800n 0.001482 470.0900n 0.001634
+ 470.1000n 0.001772 470.1100n 0.001895 470.1200n 0.001999 470.1300n 0.002083 470.1400n 0.002146 470.1500n 0.002186 470.1600n 0.002203 470.1700n 0.002198 470.1800n 0.002169 470.1900n 0.002118 470.2000n 0.002047 470.2100n 0.001955 470.2200n 0.001846 470.2300n 0.001721 470.2400n 0.001583
+ 470.2500n 0.001433 470.2600n 0.001275 470.2700n 0.001112 470.2800n 0.000945 470.2900n 0.000778 470.3000n 0.000614 470.3100n 0.000453 470.3200n 0.000299 470.3300n 0.000154 470.3400n 0.000019 470.3500n -0.000105 470.3600n -0.000216 470.3700n -0.000314 470.3800n -0.000398 470.3900n -0.000469
+ 470.4000n -0.000527 470.4100n -0.000571 470.4200n -0.000603 470.4300n -0.000625 470.4400n -0.000636 470.4500n -0.000639 470.4600n -0.000634 470.4700n -0.000624 470.4800n -0.000610 470.4900n -0.000592 470.5000n -0.000573 470.5100n -0.000554 470.5200n -0.000536 470.5300n -0.000519 470.5400n -0.000505
+ 470.5500n -0.000494 470.5600n -0.000485 470.5700n -0.000480 470.5800n -0.000478 470.5900n -0.000478 470.6000n -0.000480 470.6100n -0.000483 470.6200n -0.000486 470.6300n -0.000488 470.6400n -0.000489 470.6500n -0.000486 470.6600n -0.000479 470.6700n -0.000468 470.6800n -0.000449 470.6900n -0.000425
+ 470.7000n -0.000392 470.7100n -0.000351 470.7200n -0.000302 470.7300n -0.000245 470.7400n -0.000179 470.7500n -0.000106 470.7600n -0.000025 470.7700n 0.000061 470.7800n 0.000152 470.7900n 0.000247 470.8000n 0.000344 470.8100n 0.000441 470.8200n 0.000536 470.8300n 0.000627 470.8400n 0.000714
+ 470.8500n 0.000792 470.8600n 0.000862 470.8700n 0.000920 470.8800n 0.000965 470.8900n 0.000997 470.9000n 0.001012 470.9100n 0.001012 470.9200n 0.000994 470.9300n 0.000959 470.9400n 0.000906 470.9500n 0.000835 470.9600n 0.000747 470.9700n 0.000643 470.9800n 0.000523 470.9900n 0.000390
+ 471.0000n 0.000243 471.0100n 0.000086 471.0200n -0.000079 471.0300n -0.000252 471.0400n -0.000430 471.0500n -0.000610 471.0600n -0.000791 471.0700n -0.000971 471.0800n -0.001146 471.0900n -0.001317 471.1000n -0.001481 471.1100n -0.001636 471.1200n -0.001782 471.1300n -0.001916 471.1400n -0.002040
+ 471.1500n -0.002151 471.1600n -0.002251 471.1700n -0.002338 471.1800n -0.002413 471.1900n -0.002477 471.2000n -0.002530 471.2100n -0.002574 471.2200n -0.002609 471.2300n -0.002636 471.2400n -0.002657 471.2500n -0.002673 471.2600n -0.002685 471.2700n -0.002694 471.2800n -0.002702 471.2900n -0.002710
+ 471.3000n -0.002718 471.3100n -0.002727 471.3200n -0.002738 471.3300n -0.002751 471.3400n -0.002766 471.3500n -0.002783 471.3600n -0.002802 471.3700n -0.002823 471.3800n -0.002844 471.3900n -0.002866 471.4000n -0.002886 471.4100n -0.002905 471.4200n -0.002921 471.4300n -0.002932 471.4400n -0.002938
+ 471.4500n -0.002938 471.4600n -0.002930 471.4700n -0.002914 471.4800n -0.002888 471.4900n -0.002852 471.5000n -0.002806 471.5100n -0.002749 471.5200n -0.002681 471.5300n -0.002602 471.5400n -0.002513 471.5500n -0.002414 471.5600n -0.002306 471.5700n -0.002190 471.5800n -0.002067 471.5900n -0.001938
+ 471.6000n -0.001805 471.6100n -0.001669 471.6200n -0.001532 471.6300n -0.001396 471.6400n -0.001261 471.6500n -0.001130 471.6600n -0.001004 471.6700n -0.000884 471.6800n -0.000771 471.6900n -0.000667 471.7000n -0.000572 471.7100n -0.000487 471.7200n -0.000412 471.7300n -0.000347 471.7400n -0.000293
+ 471.7500n -0.000248 471.7600n -0.000213 471.7700n -0.000187 471.7800n -0.000168 471.7900n -0.000156 471.8000n -0.000149 471.8100n -0.000147 471.8200n -0.000147 471.8300n -0.000149 471.8400n -0.000152 471.8500n -0.000153 471.8600n -0.000151 471.8700n -0.000147 471.8800n -0.000138 471.8900n -0.000124
+ 471.9000n -0.000103 471.9100n -0.000077 471.9200n -0.000044 471.9300n -0.000005 471.9400n 0.000041 471.9500n 0.000093 471.9600n 0.000151 471.9700n 0.000213 471.9800n 0.000279 471.9900n 0.000349 472.0000n 0.000420 472.0100n 0.000492 472.0200n 0.000564 472.0300n 0.000635 472.0400n 0.000703
+ 472.0500n 0.000767 472.0600n 0.000827 472.0700n 0.000882 472.0800n 0.000932 472.0900n 0.000974 472.1000n 0.001010 472.1100n 0.001039 472.1200n 0.001061 472.1300n 0.001076 472.1400n 0.001085 472.1500n 0.001088 472.1600n 0.001085 472.1700n 0.001077 472.1800n 0.001066 472.1900n 0.001052
+ 472.2000n 0.001035 472.2100n 0.001017 472.2200n 0.000999 472.2300n 0.000980 472.2400n 0.000963 472.2500n 0.000947 472.2600n 0.000933 472.2700n 0.000921 472.2800n 0.000912 472.2900n 0.000904 472.3000n 0.000899 472.3100n 0.000894 472.3200n 0.000891 472.3300n 0.000888 472.3400n 0.000883
+ 472.3500n 0.000878 472.3600n 0.000869 472.3700n 0.000856 472.3800n 0.000839 472.3900n 0.000816 472.4000n 0.000785 472.4100n 0.000747 472.4200n 0.000701 472.4300n 0.000645 472.4400n 0.000581 472.4500n 0.000507 472.4600n 0.000424 472.4700n 0.000332 472.4800n 0.000233 472.4900n 0.000127
+ 472.5000n 0.000016 472.5100n -0.000100 472.5200n -0.000217 472.5300n -0.000334 472.5400n -0.000450 472.5500n -0.000560 472.5600n -0.000664 472.5700n -0.000759 472.5800n -0.000842 472.5900n -0.000911 472.6000n -0.000963 472.6100n -0.000998 472.6200n -0.001012 472.6300n -0.001006 472.6400n -0.000976
+ 472.6500n -0.000924 472.6600n -0.000848 472.6700n -0.000748 472.6800n -0.000626 472.6900n -0.000482 472.7000n -0.000317 472.7100n -0.000134 472.7200n 0.000066 472.7300n 0.000279 472.7400n 0.000502 472.7500n 0.000733 472.7600n 0.000968 472.7700n 0.001203 472.7800n 0.001434 472.7900n 0.001657
+ 472.8000n 0.001869 472.8100n 0.002066 472.8200n 0.002245 472.8300n 0.002401 472.8400n 0.002534 472.8500n 0.002639 472.8600n 0.002715 472.8700n 0.002761 472.8800n 0.002774 472.8900n 0.002756 472.9000n 0.002705 472.9100n 0.002622 472.9200n 0.002509 472.9300n 0.002366 472.9400n 0.002197
+ 472.9500n 0.002003 472.9600n 0.001788 472.9700n 0.001554 472.9800n 0.001307 472.9900n 0.001048 473.0000n 0.000782 473.0100n 0.000513 473.0200n 0.000246 473.0300n -0.000017 473.0400n -0.000272 473.0500n -0.000515 473.0600n -0.000743 473.0700n -0.000953 473.0800n -0.001144 473.0900n -0.001313
+ 473.1000n -0.001458 473.1100n -0.001580 473.1200n -0.001677 473.1300n -0.001750 473.1400n -0.001799 473.1500n -0.001826 473.1600n -0.001832 473.1700n -0.001818 473.1800n -0.001788 473.1900n -0.001742 473.2000n -0.001685 473.2100n -0.001619 473.2200n -0.001547 473.2300n -0.001471 473.2400n -0.001394
+ 473.2500n -0.001320 473.2600n -0.001250 473.2700n -0.001187 473.2800n -0.001132 473.2900n -0.001088 473.3000n -0.001054 473.3100n -0.001033 473.3200n -0.001024 473.3300n -0.001028 473.3400n -0.001043 473.3500n -0.001070 473.3600n -0.001106 473.3700n -0.001151 473.3800n -0.001202 473.3900n -0.001257
+ 473.4000n -0.001315 473.4100n -0.001372 473.4200n -0.001427 473.4300n -0.001476 473.4400n -0.001519 473.4500n -0.001551 473.4600n -0.001572 473.4700n -0.001580 473.4800n -0.001573 473.4900n -0.001549 473.5000n -0.001509 473.5100n -0.001450 473.5200n -0.001374 473.5300n -0.001281 473.5400n -0.001171
+ 473.5500n -0.001045 473.5600n -0.000904 473.5700n -0.000750 473.5800n -0.000585 473.5900n -0.000411 473.6000n -0.000230 473.6100n -0.000044 473.6200n 0.000144 473.6300n 0.000331 473.6400n 0.000515 473.6500n 0.000695 473.6600n 0.000868 473.6700n 0.001031 473.6800n 0.001184 473.6900n 0.001325
+ 473.7000n 0.001453 473.7100n 0.001567 473.7200n 0.001666 473.7300n 0.001751 473.7400n 0.001822 473.7500n 0.001879 473.7600n 0.001922 473.7700n 0.001954 473.7800n 0.001974 473.7900n 0.001985 473.8000n 0.001988 473.8100n 0.001985 473.8200n 0.001977 473.8300n 0.001966 473.8400n 0.001953
+ 473.8500n 0.001940 473.8600n 0.001928 473.8700n 0.001918 473.8800n 0.001911 473.8900n 0.001907 473.9000n 0.001908 473.9100n 0.001912 473.9200n 0.001920 473.9300n 0.001931 473.9400n 0.001944 473.9500n 0.001958 473.9600n 0.001973 473.9700n 0.001986 473.9800n 0.001997 473.9900n 0.002003
+ 474.0000n 0.002002 474.0100n 0.001994 474.0200n 0.001977 474.0300n 0.001949 474.0400n 0.001909 474.0500n 0.001855 474.0600n 0.001787 474.0700n 0.001705 474.0800n 0.001608 474.0900n 0.001495 474.1000n 0.001368 474.1100n 0.001227 474.1200n 0.001073 474.1300n 0.000908 474.1400n 0.000733
+ 474.1500n 0.000551 474.1600n 0.000363 474.1700n 0.000172 474.1800n -0.000019 474.1900n -0.000208 474.2000n -0.000392 474.2100n -0.000569 474.2200n -0.000734 474.2300n -0.000887 474.2400n -0.001024 474.2500n -0.001144 474.2600n -0.001244 474.2700n -0.001323 474.2800n -0.001380 474.2900n -0.001414
+ 474.3000n -0.001424 474.3100n -0.001411 474.3200n -0.001374 474.3300n -0.001315 474.3400n -0.001235 474.3500n -0.001136 474.3600n -0.001018 474.3700n -0.000885 474.3800n -0.000739 474.3900n -0.000582 474.4000n -0.000416 474.4100n -0.000246 474.4200n -0.000073 474.4300n 0.000099 474.4400n 0.000268
+ 474.4500n 0.000431 474.4600n 0.000587 474.4700n 0.000732 474.4800n 0.000865 474.4900n 0.000984 474.5000n 0.001088 474.5100n 0.001176 474.5200n 0.001248 474.5300n 0.001304 474.5400n 0.001343 474.5500n 0.001366 474.5600n 0.001373 474.5700n 0.001367 474.5800n 0.001347 474.5900n 0.001317
+ 474.6000n 0.001276 474.6100n 0.001228 474.6200n 0.001173 474.6300n 0.001114 474.6400n 0.001052 474.6500n 0.000989 474.6600n 0.000928 474.6700n 0.000868 474.6800n 0.000812 474.6900n 0.000761 474.7000n 0.000714 474.7100n 0.000674 474.7200n 0.000640 474.7300n 0.000613 474.7400n 0.000592
+ 474.7500n 0.000577 474.7600n 0.000567 474.7700n 0.000562 474.7800n 0.000561 474.7900n 0.000563 474.8000n 0.000566 474.8100n 0.000571 474.8200n 0.000575 474.8300n 0.000578 474.8400n 0.000578 474.8500n 0.000575 474.8600n 0.000569 474.8700n 0.000557 474.8800n 0.000541 474.8900n 0.000520
+ 474.9000n 0.000494 474.9100n 0.000462 474.9200n 0.000426 474.9300n 0.000386 474.9400n 0.000342 474.9500n 0.000296 474.9600n 0.000247 474.9700n 0.000199 474.9800n 0.000150 474.9900n 0.000103 475.0000n 0.000058 475.0100n 0.000016 475.0200n -0.000021 475.0300n -0.000053 475.0400n -0.000080
+ 475.0500n -0.000100 475.0600n -0.000114 475.0700n -0.000122 475.0800n -0.000124 475.0900n -0.000120 475.1000n -0.000110 475.1100n -0.000097 475.1200n -0.000079 475.1300n -0.000060 475.1400n -0.000039 475.1500n -0.000018 475.1600n 0.000002 475.1700n 0.000018 475.1800n 0.000031 475.1900n 0.000039
+ 475.2000n 0.000041 475.2100n 0.000036 475.2200n 0.000023 475.2300n 0.000003 475.2400n -0.000026 475.2500n -0.000063 475.2600n -0.000108 475.2700n -0.000160 475.2800n -0.000217 475.2900n -0.000279 475.3000n -0.000343 475.3100n -0.000409 475.3200n -0.000474 475.3300n -0.000536 475.3400n -0.000592
+ 475.3500n -0.000640 475.3600n -0.000678 475.3700n -0.000703 475.3800n -0.000714 475.3900n -0.000708 475.4000n -0.000683 475.4100n -0.000638 475.4200n -0.000572 475.4300n -0.000484 475.4400n -0.000373 475.4500n -0.000240 475.4600n -0.000085 475.4700n 0.000090 475.4800n 0.000285 475.4900n 0.000497
+ 475.5000n 0.000724 475.5100n 0.000963 475.5200n 0.001210 475.5300n 0.001463 475.5400n 0.001718 475.5500n 0.001970 475.5600n 0.002216 475.5700n 0.002452 475.5800n 0.002673 475.5900n 0.002876 475.6000n 0.003057 475.6100n 0.003213 475.6200n 0.003341 475.6300n 0.003439 475.6400n 0.003504
+ 475.6500n 0.003535 475.6600n 0.003531 475.6700n 0.003492 475.6800n 0.003418 475.6900n 0.003310 475.7000n 0.003170 475.7100n 0.003000 475.7200n 0.002803 475.7300n 0.002581 475.7400n 0.002339 475.7500n 0.002081 475.7600n 0.001810 475.7700n 0.001532 475.7800n 0.001252 475.7900n 0.000973
+ 475.8000n 0.000701 475.8100n 0.000440 475.8200n 0.000195 475.8300n -0.000032 475.8400n -0.000235 475.8500n -0.000412 475.8600n -0.000562 475.8700n -0.000680 475.8800n -0.000767 475.8900n -0.000822 475.9000n -0.000845 475.9100n -0.000836 475.9200n -0.000797 475.9300n -0.000729 475.9400n -0.000635
+ 475.9500n -0.000518 475.9600n -0.000381 475.9700n -0.000229 475.9800n -0.000064 475.9900n 0.000109 476.0000n 0.000285 476.0100n 0.000460 476.0200n 0.000631 476.0300n 0.000792 476.0400n 0.000941 476.0500n 0.001074 476.0600n 0.001189 476.0700n 0.001281 476.0800n 0.001351 476.0900n 0.001396
+ 476.1000n 0.001415 476.1100n 0.001409 476.1200n 0.001377 476.1300n 0.001322 476.1400n 0.001244 476.1500n 0.001146 476.1600n 0.001030 476.1700n 0.000899 476.1800n 0.000757 476.1900n 0.000607 476.2000n 0.000454 476.2100n 0.000300 476.2200n 0.000150 476.2300n 0.000008 476.2400n -0.000123
+ 476.2500n -0.000239 476.2600n -0.000338 476.2700n -0.000416 476.2800n -0.000471 476.2900n -0.000503 476.3000n -0.000508 476.3100n -0.000488 476.3200n -0.000442 476.3300n -0.000370 476.3400n -0.000273 476.3500n -0.000154 476.3600n -0.000014 476.3700n 0.000144 476.3800n 0.000318 476.3900n 0.000503
+ 476.4000n 0.000697 476.4100n 0.000896 476.4200n 0.001096 476.4300n 0.001294 476.4400n 0.001485 476.4500n 0.001666 476.4600n 0.001834 476.4700n 0.001986 476.4800n 0.002119 476.4900n 0.002232 476.5000n 0.002321 476.5100n 0.002386 476.5200n 0.002427 476.5300n 0.002443 476.5400n 0.002434
+ 476.5500n 0.002401 476.5600n 0.002345 476.5700n 0.002269 476.5800n 0.002173 476.5900n 0.002061 476.6000n 0.001936 476.6100n 0.001800 476.6200n 0.001657 476.6300n 0.001509 476.6400n 0.001361 476.6500n 0.001215 476.6600n 0.001075 476.6700n 0.000943 476.6800n 0.000822 476.6900n 0.000714
+ 476.7000n 0.000622 476.7100n 0.000548 476.7200n 0.000491 476.7300n 0.000454 476.7400n 0.000436 476.7500n 0.000438 476.7600n 0.000459 476.7700n 0.000498 476.7800n 0.000554 476.7900n 0.000625 476.8000n 0.000709 476.8100n 0.000804 476.8200n 0.000909 476.8300n 0.001019 476.8400n 0.001134
+ 476.8500n 0.001249 476.8600n 0.001364 476.8700n 0.001474 476.8800n 0.001578 476.8900n 0.001674 476.9000n 0.001760 476.9100n 0.001833 476.9200n 0.001894 476.9300n 0.001940 476.9400n 0.001971 476.9500n 0.001987 476.9600n 0.001987 476.9700n 0.001973 476.9800n 0.001943 476.9900n 0.001900
+ 477.0000n 0.001844 477.0100n 0.001777 477.0200n 0.001699 477.0300n 0.001614 477.0400n 0.001521 477.0500n 0.001424 477.0600n 0.001323 477.0700n 0.001221 477.0800n 0.001119 477.0900n 0.001019 477.1000n 0.000921 477.1100n 0.000828 477.1200n 0.000740 477.1300n 0.000659 477.1400n 0.000584
+ 477.1500n 0.000516 477.1600n 0.000456 477.1700n 0.000403 477.1800n 0.000357 477.1900n 0.000318 477.2000n 0.000285 477.2100n 0.000258 477.2200n 0.000235 477.2300n 0.000217 477.2400n 0.000202 477.2500n 0.000190 477.2600n 0.000179 477.2700n 0.000169 477.2800n 0.000159 477.2900n 0.000149
+ 477.3000n 0.000137 477.3100n 0.000125 477.3200n 0.000111 477.3300n 0.000095 477.3400n 0.000078 477.3500n 0.000060 477.3600n 0.000040 477.3700n 0.000021 477.3800n 0.000001 477.3900n -0.000017 477.4000n -0.000034 477.4100n -0.000049 477.4200n -0.000060 477.4300n -0.000067 477.4400n -0.000069
+ 477.4500n -0.000066 477.4600n -0.000057 477.4700n -0.000041 477.4800n -0.000017 477.4900n 0.000014 477.5000n 0.000052 477.5100n 0.000098 477.5200n 0.000152 477.5300n 0.000212 477.5400n 0.000280 477.5500n 0.000353 477.5600n 0.000432 477.5700n 0.000516 477.5800n 0.000603 477.5900n 0.000693
+ 477.6000n 0.000784 477.6100n 0.000876 477.6200n 0.000968 477.6300n 0.001057 477.6400n 0.001144 477.6500n 0.001227 477.6600n 0.001306 477.6700n 0.001379 477.6800n 0.001446 477.6900n 0.001507 477.7000n 0.001560 477.7100n 0.001607 477.7200n 0.001645 477.7300n 0.001676 477.7400n 0.001700
+ 477.7500n 0.001716 477.7600n 0.001725 477.7700n 0.001728 477.7800n 0.001724 477.7900n 0.001715 477.8000n 0.001701 477.8100n 0.001682 477.8200n 0.001659 477.8300n 0.001632 477.8400n 0.001603 477.8500n 0.001570 477.8600n 0.001536 477.8700n 0.001499 477.8800n 0.001461 477.8900n 0.001420
+ 477.9000n 0.001378 477.9100n 0.001334 477.9200n 0.001288 477.9300n 0.001240 477.9400n 0.001190 477.9500n 0.001136 477.9600n 0.001079 477.9700n 0.001019 477.9800n 0.000955 477.9900n 0.000887 478.0000n 0.000814 478.0100n 0.000737 478.0200n 0.000655 478.0300n 0.000569 478.0400n 0.000477
+ 478.0500n 0.000382 478.0600n 0.000282 478.0700n 0.000179 478.0800n 0.000074 478.0900n -0.000034 478.1000n -0.000143 478.1100n -0.000253 478.1200n -0.000361 478.1300n -0.000468 478.1400n -0.000572 478.1500n -0.000671 478.1600n -0.000765 478.1700n -0.000853 478.1800n -0.000932 478.1900n -0.001003
+ 478.2000n -0.001064 478.2100n -0.001114 478.2200n -0.001154 478.2300n -0.001181 478.2400n -0.001197 478.2500n -0.001200 478.2600n -0.001191 478.2700n -0.001170 478.2800n -0.001138 478.2900n -0.001095 478.3000n -0.001042 478.3100n -0.000980 478.3200n -0.000911 478.3300n -0.000834 478.3400n -0.000753
+ 478.3500n -0.000668 478.3600n -0.000580 478.3700n -0.000492 478.3800n -0.000405 478.3900n -0.000319 478.4000n -0.000238 478.4100n -0.000161 478.4200n -0.000090 478.4300n -0.000025 478.4400n 0.000031 478.4500n 0.000079 478.4600n 0.000119 478.4700n 0.000149 478.4800n 0.000171 478.4900n 0.000183
+ 478.5000n 0.000188 478.5100n 0.000184 478.5200n 0.000173 478.5300n 0.000156 478.5400n 0.000134 478.5500n 0.000107 478.5600n 0.000077 478.5700n 0.000045 478.5800n 0.000012 478.5900n -0.000021 478.6000n -0.000052 478.6100n -0.000081 478.6200n -0.000106 478.6300n -0.000128 478.6400n -0.000145
+ 478.6500n -0.000156 478.6600n -0.000163 478.6700n -0.000163 478.6800n -0.000158 478.6900n -0.000148 478.7000n -0.000133 478.7100n -0.000113 478.7200n -0.000090 478.7300n -0.000064 478.7400n -0.000036 478.7500n -0.000007 478.7600n 0.000022 478.7700n 0.000050 478.7800n 0.000076 478.7900n 0.000098
+ 478.8000n 0.000117 478.8100n 0.000130 478.8200n 0.000138 478.8300n 0.000139 478.8400n 0.000133 478.8500n 0.000121 478.8600n 0.000100 478.8700n 0.000073 478.8800n 0.000039 478.8900n -0.000003 478.9000n -0.000050 478.9100n -0.000103 478.9200n -0.000160 478.9300n -0.000221 478.9400n -0.000285
+ 478.9500n -0.000350 478.9600n -0.000415 478.9700n -0.000480 478.9800n -0.000542 478.9900n -0.000601 479.0000n -0.000656 479.0100n -0.000706 479.0200n -0.000749 479.0300n -0.000786 479.0400n -0.000815 479.0500n -0.000837 479.0600n -0.000850 479.0700n -0.000855 479.0800n -0.000851 479.0900n -0.000841
+ 479.1000n -0.000822 479.1100n -0.000797 479.1200n -0.000767 479.1300n -0.000731 479.1400n -0.000692 479.1500n -0.000649 479.1600n -0.000606 479.1700n -0.000562 479.1800n -0.000519 479.1900n -0.000479 479.2000n -0.000442 479.2100n -0.000410 479.2200n -0.000384 479.2300n -0.000365 479.2400n -0.000354
+ 479.2500n -0.000352 479.2600n -0.000358 479.2700n -0.000375 479.2800n -0.000401 479.2900n -0.000438 479.3000n -0.000485 479.3100n -0.000541 479.3200n -0.000607 479.3300n -0.000682 479.3400n -0.000766 479.3500n -0.000856 479.3600n -0.000954 479.3700n -0.001057 479.3800n -0.001165 479.3900n -0.001276
+ 479.4000n -0.001390 479.4100n -0.001504 479.4200n -0.001619 479.4300n -0.001732 479.4400n -0.001842 479.4500n -0.001949 479.4600n -0.002051 479.4700n -0.002147 479.4800n -0.002236 479.4900n -0.002317 479.5000n -0.002389 479.5100n -0.002452 479.5200n -0.002504 479.5300n -0.002545 479.5400n -0.002575
+ 479.5500n -0.002592 479.5600n -0.002597 479.5700n -0.002589 479.5800n -0.002568 479.5900n -0.002533 479.6000n -0.002485 479.6100n -0.002422 479.6200n -0.002346 479.6300n -0.002257 479.6400n -0.002154 479.6500n -0.002037 479.6600n -0.001907 479.6700n -0.001765 479.6800n -0.001611 479.6900n -0.001446
+ 479.7000n -0.001269 479.7100n -0.001083 479.7200n -0.000888 479.7300n -0.000685 479.7400n -0.000476 479.7500n -0.000261 479.7600n -0.000043 479.7700n 0.000178 479.7800n 0.000399 479.7900n 0.000620 479.8000n 0.000837 479.8100n 0.001051 479.8200n 0.001257 479.8300n 0.001456 479.8400n 0.001644
+ 479.8500n 0.001820 479.8600n 0.001983 479.8700n 0.002131 479.8800n 0.002262 479.8900n 0.002375 479.9000n 0.002469 479.9100n 0.002543 479.9200n 0.002596 479.9300n 0.002628 479.9400n 0.002638 479.9500n 0.002627 479.9600n 0.002595 479.9700n 0.002543 479.9800n 0.002471 479.9900n 0.002380
+ 480.0000n 0.002273 480.0100n 0.002150 480.0200n 0.002014 480.0300n 0.001866 480.0400n 0.001708 480.0500n 0.001544 480.0600n 0.001375 480.0700n 0.001204 480.0800n 0.001033 480.0900n 0.000864 480.1000n 0.000700 480.1100n 0.000543 480.1200n 0.000395 480.1300n 0.000257 480.1400n 0.000132
+ 480.1500n 0.000020 480.1600n -0.000077 480.1700n -0.000159 480.1800n -0.000225 480.1900n -0.000275 480.2000n -0.000310 480.2100n -0.000330 480.2200n -0.000335 480.2300n -0.000327 480.2400n -0.000307 480.2500n -0.000276 480.2600n -0.000236 480.2700n -0.000188 480.2800n -0.000136 480.2900n -0.000079
+ 480.3000n -0.000021 480.3100n 0.000037 480.3200n 0.000093 480.3300n 0.000146 480.3400n 0.000194 480.3500n 0.000236 480.3600n 0.000271 480.3700n 0.000298 480.3800n 0.000317 480.3900n 0.000327 480.4000n 0.000328 480.4100n 0.000320 480.4200n 0.000305 480.4300n 0.000283 480.4400n 0.000254
+ 480.4500n 0.000221 480.4600n 0.000183 480.4700n 0.000144 480.4800n 0.000103 480.4900n 0.000063 480.5000n 0.000026 480.5100n -0.000008 480.5200n -0.000037 480.5300n -0.000060 480.5400n -0.000075 480.5500n -0.000082 480.5600n -0.000081 480.5700n -0.000070 480.5800n -0.000050 480.5900n -0.000021
+ 480.6000n 0.000017 480.6100n 0.000063 480.6200n 0.000117 480.6300n 0.000176 480.6400n 0.000241 480.6500n 0.000308 480.6600n 0.000377 480.6700n 0.000446 480.6800n 0.000514 480.6900n 0.000577 480.7000n 0.000636 480.7100n 0.000687 480.7200n 0.000730 480.7300n 0.000763 480.7400n 0.000785
+ 480.7500n 0.000795 480.7600n 0.000792 480.7700n 0.000776 480.7800n 0.000747 480.7900n 0.000705 480.8000n 0.000651 480.8100n 0.000585 480.8200n 0.000509 480.8300n 0.000423 480.8400n 0.000330 480.8500n 0.000230 480.8600n 0.000126 480.8700n 0.000020 480.8800n -0.000087 480.8900n -0.000192
+ 480.9000n -0.000294 480.9100n -0.000391 480.9200n -0.000480 480.9300n -0.000562 480.9400n -0.000633 480.9500n -0.000694 480.9600n -0.000744 480.9700n -0.000783 480.9800n -0.000809 480.9900n -0.000824 481.0000n -0.000828 481.0100n -0.000821 481.0200n -0.000806 481.0300n -0.000783 481.0400n -0.000754
+ 481.0500n -0.000721 481.0600n -0.000685 481.0700n -0.000649 481.0800n -0.000615 481.0900n -0.000584 481.1000n -0.000558 481.1100n -0.000539 481.1200n -0.000529 481.1300n -0.000529 481.1400n -0.000540 481.1500n -0.000563 481.1600n -0.000597 481.1700n -0.000644 481.1800n -0.000702 481.1900n -0.000772
+ 481.2000n -0.000851 481.2100n -0.000939 481.2200n -0.001034 481.2300n -0.001134 481.2400n -0.001236 481.2500n -0.001339 481.2600n -0.001440 481.2700n -0.001536 481.2800n -0.001624 481.2900n -0.001703 481.3000n -0.001770 481.3100n -0.001822 481.3200n -0.001857 481.3300n -0.001875 481.3400n -0.001874
+ 481.3500n -0.001852 481.3600n -0.001810 481.3700n -0.001748 481.3800n -0.001665 481.3900n -0.001563 481.4000n -0.001443 481.4100n -0.001307 481.4200n -0.001158 481.4300n -0.000997 481.4400n -0.000827 481.4500n -0.000653 481.4600n -0.000476 481.4700n -0.000301 481.4800n -0.000130 481.4900n 0.000032
+ 481.5000n 0.000183 481.5100n 0.000319 481.5200n 0.000438 481.5300n 0.000537 481.5400n 0.000615 481.5500n 0.000669 481.5600n 0.000698 481.5700n 0.000702 481.5800n 0.000682 481.5900n 0.000636 481.6000n 0.000567 481.6100n 0.000476 481.6200n 0.000365 481.6300n 0.000237 481.6400n 0.000095
+ 481.6500n -0.000059 481.6600n -0.000219 481.6700n -0.000383 481.6800n -0.000546 481.6900n -0.000705 481.7000n -0.000856 481.7100n -0.000994 481.7200n -0.001116 481.7300n -0.001220 481.7400n -0.001302 481.7500n -0.001360 481.7600n -0.001391 481.7700n -0.001396 481.7800n -0.001373 481.7900n -0.001322
+ 481.8000n -0.001243 481.8100n -0.001138 481.8200n -0.001010 481.8300n -0.000859 481.8400n -0.000689 481.8500n -0.000503 481.8600n -0.000306 481.8700n -0.000101 481.8800n 0.000108 481.8900n 0.000316 481.9000n 0.000519 481.9100n 0.000712 481.9200n 0.000891 481.9300n 0.001053 481.9400n 0.001193
+ 481.9500n 0.001308 481.9600n 0.001395 481.9700n 0.001453 481.9800n 0.001481 481.9900n 0.001476 482.0000n 0.001439 482.0100n 0.001370 482.0200n 0.001270 482.0300n 0.001142 482.0400n 0.000988 482.0500n 0.000810 482.0600n 0.000612 482.0700n 0.000398 482.0800n 0.000173 482.0900n -0.000060
+ 482.1000n -0.000295 482.1100n -0.000528 482.1200n -0.000754 482.1300n -0.000969 482.1400n -0.001167 482.1500n -0.001345 482.1600n -0.001500 482.1700n -0.001628 482.1800n -0.001726 482.1900n -0.001793 482.2000n -0.001827 482.2100n -0.001828 482.2200n -0.001794 482.2300n -0.001728 482.2400n -0.001630
+ 482.2500n -0.001501 482.2600n -0.001345 482.2700n -0.001165 482.2800n -0.000963 482.2900n -0.000744 482.3000n -0.000511 482.3100n -0.000270 482.3200n -0.000023 482.3300n 0.000224 482.3400n 0.000467 482.3500n 0.000702 482.3600n 0.000925 482.3700n 0.001133 482.3800n 0.001323 482.3900n 0.001491
+ 482.4000n 0.001635 482.4100n 0.001754 482.4200n 0.001847 482.4300n 0.001913 482.4400n 0.001953 482.4500n 0.001966 482.4600n 0.001953 482.4700n 0.001918 482.4800n 0.001860 482.4900n 0.001783 482.5000n 0.001689 482.5100n 0.001581 482.5200n 0.001463 482.5300n 0.001336 482.5400n 0.001205
+ 482.5500n 0.001072 482.5600n 0.000939 482.5700n 0.000811 482.5800n 0.000689 482.5900n 0.000575 482.6000n 0.000470 482.6100n 0.000377 482.6200n 0.000296 482.6300n 0.000227 482.6400n 0.000171 482.6500n 0.000127 482.6600n 0.000095 482.6700n 0.000073 482.6800n 0.000061 482.6900n 0.000057
+ 482.7000n 0.000058 482.7100n 0.000064 482.7200n 0.000072 482.7300n 0.000080 482.7400n 0.000088 482.7500n 0.000091 482.7600n 0.000091 482.7700n 0.000084 482.7800n 0.000070 482.7900n 0.000048 482.8000n 0.000018 482.8100n -0.000020 482.8200n -0.000066 482.8300n -0.000119 482.8400n -0.000179
+ 482.8500n -0.000244 482.8600n -0.000313 482.8700n -0.000384 482.8800n -0.000454 482.8900n -0.000522 482.9000n -0.000587 482.9100n -0.000645 482.9200n -0.000695 482.9300n -0.000735 482.9400n -0.000763 482.9500n -0.000777 482.9600n -0.000778 482.9700n -0.000763 482.9800n -0.000732 482.9900n -0.000686
+ 483.0000n -0.000625 483.0100n -0.000549 483.0200n -0.000459 483.0300n -0.000358 483.0400n -0.000247 483.0500n -0.000128 483.0600n -0.000005 483.0700n 0.000122 483.0800n 0.000248 483.0900n 0.000370 483.1000n 0.000487 483.1100n 0.000594 483.1200n 0.000689 483.1300n 0.000770 483.1400n 0.000834
+ 483.1500n 0.000880 483.1600n 0.000905 483.1700n 0.000909 483.1800n 0.000892 483.1900n 0.000853 483.2000n 0.000792 483.2100n 0.000712 483.2200n 0.000612 483.2300n 0.000495 483.2400n 0.000363 483.2500n 0.000220 483.2600n 0.000068 483.2700n -0.000090 483.2800n -0.000249 483.2900n -0.000406
+ 483.3000n -0.000558 483.3100n -0.000700 483.3200n -0.000829 483.3300n -0.000942 483.3400n -0.001036 483.3500n -0.001108 483.3600n -0.001156 483.3700n -0.001178 483.3800n -0.001174 483.3900n -0.001142 483.4000n -0.001082 483.4100n -0.000996 483.4200n -0.000885 483.4300n -0.000750 483.4400n -0.000594
+ 483.4500n -0.000420 483.4600n -0.000231 483.4700n -0.000031 483.4800n 0.000176 483.4900n 0.000386 483.5000n 0.000595 483.5100n 0.000797 483.5200n 0.000989 483.5300n 0.001167 483.5400n 0.001327 483.5500n 0.001464 483.5600n 0.001577 483.5700n 0.001663 483.5800n 0.001718 483.5900n 0.001743
+ 483.6000n 0.001736 483.6100n 0.001697 483.6200n 0.001627 483.6300n 0.001527 483.6400n 0.001398 483.6500n 0.001243 483.6600n 0.001065 483.6700n 0.000867 483.6800n 0.000654 483.6900n 0.000429 483.7000n 0.000197 483.7100n -0.000037 483.7200n -0.000270 483.7300n -0.000497 483.7400n -0.000712
+ 483.7500n -0.000913 483.7600n -0.001095 483.7700n -0.001255 483.7800n -0.001391 483.7900n -0.001499 483.8000n -0.001578 483.8100n -0.001628 483.8200n -0.001647 483.8300n -0.001635 483.8400n -0.001594 483.8500n -0.001525 483.8600n -0.001430 483.8700n -0.001311 483.8800n -0.001171 483.8900n -0.001014
+ 483.9000n -0.000843 483.9100n -0.000662 483.9200n -0.000475 483.9300n -0.000286 483.9400n -0.000099 483.9500n 0.000082 483.9600n 0.000254 483.9700n 0.000414 483.9800n 0.000559 483.9900n 0.000686 484.0000n 0.000794 484.0100n 0.000880 484.0200n 0.000945 484.0300n 0.000988 484.0400n 0.001010
+ 484.0500n 0.001010 484.0600n 0.000991 484.0700n 0.000954 484.0800n 0.000902 484.0900n 0.000837 484.1000n 0.000762 484.1100n 0.000679 484.1200n 0.000593 484.1300n 0.000505 484.1400n 0.000420 484.1500n 0.000340 484.1600n 0.000268 484.1700n 0.000206 484.1800n 0.000157 484.1900n 0.000122
+ 484.2000n 0.000102 484.2100n 0.000098 484.2200n 0.000110 484.2300n 0.000139 484.2400n 0.000183 484.2500n 0.000241 484.2600n 0.000311 484.2700n 0.000392 484.2800n 0.000480 484.2900n 0.000573 484.3000n 0.000668 484.3100n 0.000763 484.3200n 0.000852 484.3300n 0.000935 484.3400n 0.001007
+ 484.3500n 0.001065 484.3600n 0.001108 484.3700n 0.001133 484.3800n 0.001137 484.3900n 0.001121 484.4000n 0.001082 484.4100n 0.001020 484.4200n 0.000936 484.4300n 0.000831 484.4400n 0.000705 484.4500n 0.000561 484.4600n 0.000401 484.4700n 0.000228 484.4800n 0.000044 484.4900n -0.000146
+ 484.5000n -0.000338 484.5100n -0.000530 484.5200n -0.000716 484.5300n -0.000893 484.5400n -0.001057 484.5500n -0.001204 484.5600n -0.001330 484.5700n -0.001433 484.5800n -0.001510 484.5900n -0.001559 484.6000n -0.001577 484.6100n -0.001565 484.6200n -0.001521 484.6300n -0.001445 484.6400n -0.001339
+ 484.6500n -0.001204 484.6600n -0.001041 484.6700n -0.000854 484.6800n -0.000645 484.6900n -0.000418 484.7000n -0.000176 484.7100n 0.000076 484.7200n 0.000333 484.7300n 0.000593 484.7400n 0.000849 484.7500n 0.001097 484.7600n 0.001334 484.7700n 0.001556 484.7800n 0.001757 484.7900n 0.001936
+ 484.8000n 0.002089 484.8100n 0.002214 484.8200n 0.002309 484.8300n 0.002373 484.8400n 0.002405 484.8500n 0.002405 484.8600n 0.002374 484.8700n 0.002312 484.8800n 0.002221 484.8900n 0.002103 484.9000n 0.001960 484.9100n 0.001796 484.9200n 0.001614 484.9300n 0.001417 484.9400n 0.001207
+ 484.9500n 0.000990 484.9600n 0.000769 484.9700n 0.000546 484.9800n 0.000325 484.9900n 0.000110 485.0000n -0.000097 485.0100n -0.000294 485.0200n -0.000478 485.0300n -0.000647 485.0400n -0.000801 485.0500n -0.000939 485.0600n -0.001060 485.0700n -0.001164 485.0800n -0.001252 485.0900n -0.001324
+ 485.1000n -0.001382 485.1100n -0.001427 485.1200n -0.001461 485.1300n -0.001484 485.1400n -0.001500 485.1500n -0.001510 485.1600n -0.001516 485.1700n -0.001520 485.1800n -0.001522 485.1900n -0.001526 485.2000n -0.001531 485.2100n -0.001540 485.2200n -0.001551 485.2300n -0.001566 485.2400n -0.001585
+ 485.2500n -0.001607 485.2600n -0.001632 485.2700n -0.001657 485.2800n -0.001683 485.2900n -0.001708 485.3000n -0.001729 485.3100n -0.001744 485.3200n -0.001753 485.3300n -0.001752 485.3400n -0.001740 485.3500n -0.001715 485.3600n -0.001675 485.3700n -0.001618 485.3800n -0.001543 485.3900n -0.001449
+ 485.4000n -0.001335 485.4100n -0.001201 485.4200n -0.001048 485.4300n -0.000875 485.4400n -0.000684 485.4500n -0.000475 485.4600n -0.000252 485.4700n -0.000015 485.4800n 0.000233 485.4900n 0.000488 485.5000n 0.000748 485.5100n 0.001010 485.5200n 0.001270 485.5300n 0.001524 485.5400n 0.001770
+ 485.5500n 0.002004 485.5600n 0.002223 485.5700n 0.002423 485.5800n 0.002602 485.5900n 0.002758 485.6000n 0.002887 485.6100n 0.002990 485.6200n 0.003063 485.6300n 0.003107 485.6400n 0.003121 485.6500n 0.003105 485.6600n 0.003060 485.6700n 0.002987 485.6800n 0.002887 485.6900n 0.002762
+ 485.7000n 0.002615 485.7100n 0.002448 485.7200n 0.002265 485.7300n 0.002067 485.7400n 0.001858 485.7500n 0.001642 485.7600n 0.001421 485.7700n 0.001200 485.7800n 0.000980 485.7900n 0.000765 485.8000n 0.000557 485.8100n 0.000360 485.8200n 0.000174 485.8300n 0.000002 485.8400n -0.000155
+ 485.8500n -0.000296 485.8600n -0.000420 485.8700n -0.000527 485.8800n -0.000617 485.8900n -0.000690 485.9000n -0.000748 485.9100n -0.000791 485.9200n -0.000820 485.9300n -0.000838 485.9400n -0.000845 485.9500n -0.000843 485.9600n -0.000834 485.9700n -0.000820 485.9800n -0.000802 485.9900n -0.000782
+ 486.0000n -0.000761 486.0100n -0.000741 486.0200n -0.000722 486.0300n -0.000705 486.0400n -0.000691 486.0500n -0.000680 486.0600n -0.000671 486.0700n -0.000666 486.0800n -0.000662 486.0900n -0.000660 486.1000n -0.000658 486.1100n -0.000655 486.1200n -0.000651 486.1300n -0.000643 486.1400n -0.000630
+ 486.1500n -0.000612 486.1600n -0.000586 486.1700n -0.000552 486.1800n -0.000508 486.1900n -0.000453 486.2000n -0.000387 486.2100n -0.000310 486.2200n -0.000221 486.2300n -0.000120 486.2400n -0.000008 486.2500n 0.000115 486.2600n 0.000248 486.2700n 0.000388 486.2800n 0.000535 486.2900n 0.000687
+ 486.3000n 0.000841 486.3100n 0.000996 486.3200n 0.001149 486.3300n 0.001298 486.3400n 0.001440 486.3500n 0.001572 486.3600n 0.001693 486.3700n 0.001799 486.3800n 0.001889 486.3900n 0.001961 486.4000n 0.002013 486.4100n 0.002044 486.4200n 0.002052 486.4300n 0.002037 486.4400n 0.001999
+ 486.4500n 0.001937 486.4600n 0.001852 486.4700n 0.001745 486.4800n 0.001617 486.4900n 0.001470 486.5000n 0.001305 486.5100n 0.001125 486.5200n 0.000933 486.5300n 0.000731 486.5400n 0.000522 486.5500n 0.000309 486.5600n 0.000095 486.5700n -0.000116 486.5800n -0.000321 486.5900n -0.000518
+ 486.6000n -0.000702 486.6100n -0.000872 486.6200n -0.001024 486.6300n -0.001157 486.6400n -0.001268 486.6500n -0.001355 486.6600n -0.001418 486.6700n -0.001456 486.6800n -0.001467 486.6900n -0.001451 486.7000n -0.001410 486.7100n -0.001342 486.7200n -0.001251 486.7300n -0.001136 486.7400n -0.000999
+ 486.7500n -0.000843 486.7600n -0.000669 486.7700n -0.000481 486.7800n -0.000280 486.7900n -0.000070 486.8000n 0.000147 486.8100n 0.000367 486.8200n 0.000587 486.8300n 0.000805 486.8400n 0.001018 486.8500n 0.001223 486.8600n 0.001416 486.8700n 0.001596 486.8800n 0.001761 486.8900n 0.001908
+ 486.9000n 0.002035 486.9100n 0.002142 486.9200n 0.002226 486.9300n 0.002287 486.9400n 0.002324 486.9500n 0.002337 486.9600n 0.002326 486.9700n 0.002291 486.9800n 0.002233 486.9900n 0.002151 487.0000n 0.002049 487.0100n 0.001926 487.0200n 0.001784 487.0300n 0.001625 487.0400n 0.001451
+ 487.0500n 0.001264 487.0600n 0.001065 487.0700n 0.000858 487.0800n 0.000643 487.0900n 0.000425 487.1000n 0.000204 487.1100n -0.000017 487.1200n -0.000235 487.1300n -0.000448 487.1400n -0.000655 487.1500n -0.000853 487.1600n -0.001041 487.1700n -0.001216 487.1800n -0.001378 487.1900n -0.001524
+ 487.2000n -0.001654 487.2100n -0.001766 487.2200n -0.001860 487.2300n -0.001935 487.2400n -0.001992 487.2500n -0.002028 487.2600n -0.002045 487.2700n -0.002044 487.2800n -0.002023 487.2900n -0.001984 487.3000n -0.001929 487.3100n -0.001857 487.3200n -0.001770 487.3300n -0.001669 487.3400n -0.001555
+ 487.3500n -0.001431 487.3600n -0.001298 487.3700n -0.001156 487.3800n -0.001009 487.3900n -0.000857 487.4000n -0.000703 487.4100n -0.000547 487.4200n -0.000392 487.4300n -0.000239 487.4400n -0.000090 487.4500n 0.000055 487.4600n 0.000195 487.4700n 0.000327 487.4800n 0.000452 487.4900n 0.000568
+ 487.5000n 0.000676 487.5100n 0.000774 487.5200n 0.000862 487.5300n 0.000941 487.5400n 0.001010 487.5500n 0.001070 487.5600n 0.001121 487.5700n 0.001163 487.5800n 0.001197 487.5900n 0.001224 487.6000n 0.001244 487.6100n 0.001258 487.6200n 0.001266 487.6300n 0.001270 487.6400n 0.001269
+ 487.6500n 0.001265 487.6600n 0.001257 487.6700n 0.001247 487.6800n 0.001235 487.6900n 0.001221 487.7000n 0.001204 487.7100n 0.001186 487.7200n 0.001166 487.7300n 0.001143 487.7400n 0.001118 487.7500n 0.001090 487.7600n 0.001058 487.7700n 0.001022 487.7800n 0.000982 487.7900n 0.000937
+ 487.8000n 0.000886 487.8100n 0.000828 487.8200n 0.000764 487.8300n 0.000693 487.8400n 0.000614 487.8500n 0.000528 487.8600n 0.000433 487.8700n 0.000331 487.8800n 0.000222 487.8900n 0.000105 487.9000n -0.000019 487.9100n -0.000148 487.9200n -0.000282 487.9300n -0.000420 487.9400n -0.000560
+ 487.9500n -0.000702 487.9600n -0.000843 487.9700n -0.000982 487.9800n -0.001118 487.9900n -0.001248 488.0000n -0.001372 488.0100n -0.001486 488.0200n -0.001591 488.0300n -0.001684 488.0400n -0.001763 488.0500n -0.001828 488.0600n -0.001878 488.0700n -0.001911 488.0800n -0.001927 488.0900n -0.001925
+ 488.1000n -0.001906 488.1100n -0.001870 488.1200n -0.001816 488.1300n -0.001746 488.1400n -0.001660 488.1500n -0.001560 488.1600n -0.001446 488.1700n -0.001322 488.1800n -0.001187 488.1900n -0.001044 488.2000n -0.000896 488.2100n -0.000743 488.2200n -0.000589 488.2300n -0.000435 488.2400n -0.000283
+ 488.2500n -0.000135 488.2600n 0.000006 488.2700n 0.000139 488.2800n 0.000263 488.2900n 0.000376 488.3000n 0.000477 488.3100n 0.000565 488.3200n 0.000639 488.3300n 0.000698 488.3400n 0.000743 488.3500n 0.000774 488.3600n 0.000790 488.3700n 0.000792 488.3800n 0.000781 488.3900n 0.000758
+ 488.4000n 0.000723 488.4100n 0.000677 488.4200n 0.000622 488.4300n 0.000559 488.4400n 0.000489 488.4500n 0.000413 488.4600n 0.000333 488.4700n 0.000249 488.4800n 0.000163 488.4900n 0.000076 488.5000n -0.000011 488.5100n -0.000099 488.5200n -0.000185 488.5300n -0.000269 488.5400n -0.000352
+ 488.5500n -0.000432 488.5600n -0.000510 488.5700n -0.000585 488.5800n -0.000659 488.5900n -0.000729 488.6000n -0.000798 488.6100n -0.000865 488.6200n -0.000930 488.6300n -0.000993 488.6400n -0.001055 488.6500n -0.001114 488.6600n -0.001172 488.6700n -0.001229 488.6800n -0.001283 488.6900n -0.001334
+ 488.7000n -0.001383 488.7100n -0.001427 488.7200n -0.001468 488.7300n -0.001503 488.7400n -0.001532 488.7500n -0.001554 488.7600n -0.001568 488.7700n -0.001573 488.7800n -0.001569 488.7900n -0.001554 488.8000n -0.001527 488.8100n -0.001489 488.8200n -0.001438 488.8300n -0.001374 488.8400n -0.001297
+ 488.8500n -0.001208 488.8600n -0.001107 488.8700n -0.000993 488.8800n -0.000870 488.8900n -0.000736 488.9000n -0.000595 488.9100n -0.000447 488.9200n -0.000294 488.9300n -0.000139 488.9400n 0.000016 488.9500n 0.000169 488.9600n 0.000318 488.9700n 0.000460 488.9800n 0.000593 488.9900n 0.000714
+ 489.0000n 0.000822 489.0100n 0.000914 489.0200n 0.000989 489.0300n 0.001045 489.0400n 0.001081 489.0500n 0.001096 489.0600n 0.001091 489.0700n 0.001064 489.0800n 0.001017 489.0900n 0.000951 489.1000n 0.000866 489.1100n 0.000765 489.1200n 0.000650 489.1300n 0.000523 489.1400n 0.000387
+ 489.1500n 0.000245 489.1600n 0.000100 489.1700n -0.000044 489.1800n -0.000183 489.1900n -0.000315 489.2000n -0.000436 489.2100n -0.000542 489.2200n -0.000631 489.2300n -0.000700 489.2400n -0.000745 489.2500n -0.000767 489.2600n -0.000762 489.2700n -0.000729 489.2800n -0.000669 489.2900n -0.000582
+ 489.3000n -0.000467 489.3100n -0.000326 489.3200n -0.000161 489.3300n 0.000025 489.3400n 0.000231 489.3500n 0.000453 489.3600n 0.000687 489.3700n 0.000929 489.3800n 0.001175 489.3900n 0.001421 489.4000n 0.001663 489.4100n 0.001895 489.4200n 0.002114 489.4300n 0.002316 489.4400n 0.002496
+ 489.4500n 0.002652 489.4600n 0.002779 489.4700n 0.002876 489.4800n 0.002941 489.4900n 0.002971 489.5000n 0.002967 489.5100n 0.002928 489.5200n 0.002855 489.5300n 0.002748 489.5400n 0.002609 489.5500n 0.002442 489.5600n 0.002248 489.5700n 0.002032 489.5800n 0.001797 489.5900n 0.001547
+ 489.6000n 0.001286 489.6100n 0.001020 489.6200n 0.000753 489.6300n 0.000490 489.6400n 0.000235 489.6500n -0.000008 489.6600n -0.000234 489.6700n -0.000439 489.6800n -0.000621 489.6900n -0.000776 489.7000n -0.000903 489.7100n -0.000999 489.7200n -0.001065 489.7300n -0.001100 489.7400n -0.001103
+ 489.7500n -0.001077 489.7600n -0.001023 489.7700n -0.000943 489.7800n -0.000840 489.7900n -0.000716 489.8000n -0.000577 489.8100n -0.000425 489.8200n -0.000264 489.8300n -0.000100 489.8400n 0.000065 489.8500n 0.000225 489.8600n 0.000377 489.8700n 0.000517 489.8800n 0.000642 489.8900n 0.000748
+ 489.9000n 0.000833 489.9100n 0.000895 489.9200n 0.000932 489.9300n 0.000944 489.9400n 0.000930 489.9500n 0.000890 489.9600n 0.000827 489.9700n 0.000740 489.9800n 0.000632 489.9900n 0.000506 490.0000n 0.000365 490.0100n 0.000212 490.0200n 0.000050 490.0300n -0.000116 490.0400n -0.000283
+ 490.0500n -0.000446 490.0600n -0.000602 490.0700n -0.000747 490.0800n -0.000878 490.0900n -0.000990 490.1000n -0.001083 490.1100n -0.001152 490.1200n -0.001197 490.1300n -0.001216 490.1400n -0.001208 490.1500n -0.001173 490.1600n -0.001112 490.1700n -0.001026 490.1800n -0.000916 490.1900n -0.000784
+ 490.2000n -0.000632 490.2100n -0.000465 490.2200n -0.000285 490.2300n -0.000096 490.2400n 0.000099 490.2500n 0.000295 490.2600n 0.000489 490.2700n 0.000676 490.2800n 0.000852 490.2900n 0.001015 490.3000n 0.001161 490.3100n 0.001287 490.3200n 0.001390 490.3300n 0.001468 490.3400n 0.001520
+ 490.3500n 0.001544 490.3600n 0.001541 490.3700n 0.001510 490.3800n 0.001451 490.3900n 0.001367 490.4000n 0.001257 490.4100n 0.001126 490.4200n 0.000974 490.4300n 0.000805 490.4400n 0.000621 490.4500n 0.000427 490.4600n 0.000226 490.4700n 0.000021 490.4800n -0.000184 490.4900n -0.000386
+ 490.5000n -0.000581 490.5100n -0.000766 490.5200n -0.000938 490.5300n -0.001095 490.5400n -0.001233 490.5500n -0.001352 490.5600n -0.001449 490.5700n -0.001524 490.5800n -0.001576 490.5900n -0.001604 490.6000n -0.001609 490.6100n -0.001591 490.6200n -0.001552 490.6300n -0.001492 490.6400n -0.001413
+ 490.6500n -0.001317 490.6600n -0.001207 490.6700n -0.001084 490.6800n -0.000950 490.6900n -0.000809 490.7000n -0.000663 490.7100n -0.000513 490.7200n -0.000363 490.7300n -0.000214 490.7400n -0.000069 490.7500n 0.000070 490.7600n 0.000203 490.7700n 0.000326 490.7800n 0.000440 490.7900n 0.000543
+ 490.8000n 0.000634 490.8100n 0.000712 490.8200n 0.000778 490.8300n 0.000831 490.8400n 0.000871 490.8500n 0.000898 490.8600n 0.000913 490.8700n 0.000916 490.8800n 0.000906 490.8900n 0.000886 490.9000n 0.000854 490.9100n 0.000812 490.9200n 0.000761 490.9300n 0.000700 490.9400n 0.000630
+ 490.9500n 0.000551 490.9600n 0.000465 490.9700n 0.000370 490.9800n 0.000268 490.9900n 0.000158 491.0000n 0.000041 491.0100n -0.000083 491.0200n -0.000214 491.0300n -0.000352 491.0400n -0.000495 491.0500n -0.000644 491.0600n -0.000798 491.0700n -0.000956 491.0800n -0.001118 491.0900n -0.001283
+ 491.1000n -0.001449 491.1100n -0.001616 491.1200n -0.001781 491.1300n -0.001945 491.1400n -0.002104 491.1500n -0.002257 491.1600n -0.002403 491.1700n -0.002539 491.1800n -0.002664 491.1900n -0.002776 491.2000n -0.002873 491.2100n -0.002953 491.2200n -0.003015 491.2300n -0.003058 491.2400n -0.003079
+ 491.2500n -0.003079 491.2600n -0.003056 491.2700n -0.003010 491.2800n -0.002940 491.2900n -0.002848 491.3000n -0.002734 491.3100n -0.002598 491.3200n -0.002442 491.3300n -0.002268 491.3400n -0.002077 491.3500n -0.001871 491.3600n -0.001654 491.3700n -0.001426 491.3800n -0.001193 491.3900n -0.000955
+ 491.4000n -0.000717 491.4100n -0.000481 491.4200n -0.000250 491.4300n -0.000028 491.4400n 0.000184 491.4500n 0.000383 491.4600n 0.000566 491.4700n 0.000731 491.4800n 0.000877 491.4900n 0.001003 491.5000n 0.001107 491.5100n 0.001189 491.5200n 0.001249 491.5300n 0.001287 491.5400n 0.001305
+ 491.5500n 0.001302 491.5600n 0.001280 491.5700n 0.001242 491.5800n 0.001189 491.5900n 0.001123 491.6000n 0.001048 491.6100n 0.000964 491.6200n 0.000876 491.6300n 0.000786 491.6400n 0.000696 491.6500n 0.000609 491.6600n 0.000528 491.6700n 0.000454 491.6800n 0.000390 491.6900n 0.000337
+ 491.7000n 0.000298 491.7100n 0.000272 491.7200n 0.000261 491.7300n 0.000265 491.7400n 0.000283 491.7500n 0.000317 491.7600n 0.000365 491.7700n 0.000426 491.7800n 0.000498 491.7900n 0.000581 491.8000n 0.000673 491.8100n 0.000771 491.8200n 0.000874 491.8300n 0.000980 491.8400n 0.001086
+ 491.8500n 0.001190 491.8600n 0.001291 491.8700n 0.001386 491.8800n 0.001474 491.8900n 0.001553 491.9000n 0.001621 491.9100n 0.001679 491.9200n 0.001724 491.9300n 0.001757 491.9400n 0.001776 491.9500n 0.001783 491.9600n 0.001776 491.9700n 0.001758 491.9800n 0.001727 491.9900n 0.001686
+ 492.0000n 0.001635 492.0100n 0.001576 492.0200n 0.001510 492.0300n 0.001438 492.0400n 0.001361 492.0500n 0.001281 492.0600n 0.001200 492.0700n 0.001118 492.0800n 0.001037 492.0900n 0.000957 492.1000n 0.000880 492.1100n 0.000806 492.1200n 0.000735 492.1300n 0.000669 492.1400n 0.000607
+ 492.1500n 0.000548 492.1600n 0.000494 492.1700n 0.000443 492.1800n 0.000395 492.1900n 0.000350 492.2000n 0.000307 492.2100n 0.000266 492.2200n 0.000225 492.2300n 0.000184 492.2400n 0.000142 492.2500n 0.000100 492.2600n 0.000057 492.2700n 0.000012 492.2800n -0.000034 492.2900n -0.000082
+ 492.3000n -0.000132 492.3100n -0.000182 492.3200n -0.000232 492.3300n -0.000283 492.3400n -0.000332 492.3500n -0.000380 492.3600n -0.000424 492.3700n -0.000465 492.3800n -0.000500 492.3900n -0.000530 492.4000n -0.000553 492.4100n -0.000568 492.4200n -0.000574 492.4300n -0.000571 492.4400n -0.000559
+ 492.4500n -0.000536 492.4600n -0.000503 492.4700n -0.000461 492.4800n -0.000409 492.4900n -0.000349 492.5000n -0.000280 492.5100n -0.000206 492.5200n -0.000126 492.5300n -0.000042 492.5400n 0.000044 492.5500n 0.000130 492.5600n 0.000215 492.5700n 0.000296 492.5800n 0.000371 492.5900n 0.000439
+ 492.6000n 0.000498 492.6100n 0.000545 492.6200n 0.000581 492.6300n 0.000603 492.6400n 0.000610 492.6500n 0.000603 492.6600n 0.000579 492.6700n 0.000540 492.6800n 0.000486 492.6900n 0.000417 492.7000n 0.000335 492.7100n 0.000239 492.7200n 0.000134 492.7300n 0.000019 492.7400n -0.000103
+ 492.7500n -0.000230 492.7600n -0.000359 492.7700n -0.000487 492.7800n -0.000613 492.7900n -0.000734 492.8000n -0.000847 492.8100n -0.000950 492.8200n -0.001041 492.8300n -0.001118 492.8400n -0.001180 492.8500n -0.001225 492.8600n -0.001252 492.8700n -0.001261 492.8800n -0.001252 492.8900n -0.001225
+ 492.9000n -0.001180 492.9100n -0.001118 492.9200n -0.001041 492.9300n -0.000950 492.9400n -0.000848 492.9500n -0.000735 492.9600n -0.000616 492.9700n -0.000491 492.9800n -0.000365 492.9900n -0.000238 493.0000n -0.000113 493.0100n 0.000006 493.0200n 0.000118 493.0300n 0.000221 493.0400n 0.000313
+ 493.0500n 0.000393 493.0600n 0.000460 493.0700n 0.000513 493.0800n 0.000551 493.0900n 0.000575 493.1000n 0.000585 493.1100n 0.000582 493.1200n 0.000566 493.1300n 0.000540 493.1400n 0.000505 493.1500n 0.000463 493.1600n 0.000415 493.1700n 0.000365 493.1800n 0.000314 493.1900n 0.000264
+ 493.2000n 0.000218 493.2100n 0.000177 493.2200n 0.000144 493.2300n 0.000120 493.2400n 0.000106 493.2500n 0.000103 493.2600n 0.000113 493.2700n 0.000134 493.2800n 0.000167 493.2900n 0.000211 493.3000n 0.000267 493.3100n 0.000331 493.3200n 0.000403 493.3300n 0.000481 493.3400n 0.000562
+ 493.3500n 0.000645 493.3600n 0.000727 493.3700n 0.000806 493.3800n 0.000879 493.3900n 0.000944 493.4000n 0.000998 493.4100n 0.001040 493.4200n 0.001068 493.4300n 0.001081 493.4400n 0.001077 493.4500n 0.001056 493.4600n 0.001018 493.4700n 0.000963 493.4800n 0.000891 493.4900n 0.000805
+ 493.5000n 0.000705 493.5100n 0.000594 493.5200n 0.000473 493.5300n 0.000347 493.5400n 0.000217 493.5500n 0.000088 493.5600n -0.000039 493.5700n -0.000159 493.5800n -0.000269 493.5900n -0.000366 493.6000n -0.000448 493.6100n -0.000511 493.6200n -0.000553 493.6300n -0.000573 493.6400n -0.000569
+ 493.6500n -0.000540 493.6600n -0.000486 493.6700n -0.000408 493.6800n -0.000306 493.6900n -0.000182 493.7000n -0.000039 493.7100n 0.000123 493.7200n 0.000298 493.7300n 0.000484 493.7400n 0.000677 493.7500n 0.000872 493.7600n 0.001066 493.7700n 0.001254 493.7800n 0.001430 493.7900n 0.001592
+ 493.8000n 0.001736 493.8100n 0.001856 493.8200n 0.001950 493.8300n 0.002016 493.8400n 0.002050 493.8500n 0.002051 493.8600n 0.002019 493.8700n 0.001953 493.8800n 0.001853 493.8900n 0.001721 493.9000n 0.001559 493.9100n 0.001369 493.9200n 0.001155 493.9300n 0.000921 493.9400n 0.000672
+ 493.9500n 0.000411 493.9600n 0.000145 493.9700n -0.000122 493.9800n -0.000384 493.9900n -0.000634 494.0000n -0.000869 494.0100n -0.001083 494.0200n -0.001271 494.0300n -0.001429 494.0400n -0.001553 494.0500n -0.001641 494.0600n -0.001690 494.0700n -0.001699 494.0800n -0.001668 494.0900n -0.001597
+ 494.1000n -0.001486 494.1100n -0.001339 494.1200n -0.001158 494.1300n -0.000947 494.1400n -0.000711 494.1500n -0.000454 494.1600n -0.000182 494.1700n 0.000099 494.1800n 0.000383 494.1900n 0.000663 494.2000n 0.000933 494.2100n 0.001186 494.2200n 0.001416 494.2300n 0.001619 494.2400n 0.001787
+ 494.2500n 0.001918 494.2600n 0.002006 494.2700n 0.002050 494.2800n 0.002046 494.2900n 0.001994 494.3000n 0.001894 494.3100n 0.001746 494.3200n 0.001552 494.3300n 0.001315 494.3400n 0.001038 494.3500n 0.000725 494.3600n 0.000383 494.3700n 0.000016 494.3800n -0.000369 494.3900n -0.000765
+ 494.4000n -0.001165 494.4100n -0.001562 494.4200n -0.001950 494.4300n -0.002320 494.4400n -0.002667 494.4500n -0.002985 494.4600n -0.003267 494.4700n -0.003509 494.4800n -0.003707 494.4900n -0.003857 494.5000n -0.003957 494.5100n -0.004006 494.5200n -0.004003 494.5300n -0.003949 494.5400n -0.003846
+ 494.5500n -0.003695 494.5600n -0.003501 494.5700n -0.003268 494.5800n -0.003000 494.5900n -0.002704 494.6000n -0.002384 494.6100n -0.002049 494.6200n -0.001703 494.6300n -0.001355 494.6400n -0.001010 494.6500n -0.000675 494.6600n -0.000357 494.6700n -0.000061 494.6800n 0.000207 494.6900n 0.000444
+ 494.7000n 0.000645 494.7100n 0.000808 494.7200n 0.000929 494.7300n 0.001008 494.7400n 0.001045 494.7500n 0.001040 494.7600n 0.000995 494.7700n 0.000911 494.7800n 0.000792 494.7900n 0.000641 494.8000n 0.000463 494.8100n 0.000262 494.8200n 0.000045 494.8300n -0.000185 494.8400n -0.000421
+ 494.8500n -0.000658 494.8600n -0.000890 494.8700n -0.001113 494.8800n -0.001320 494.8900n -0.001507 494.9000n -0.001671 494.9100n -0.001807 494.9200n -0.001914 494.9300n -0.001989 494.9400n -0.002031 494.9500n -0.002039 494.9600n -0.002013 494.9700n -0.001954 494.9800n -0.001864 494.9900n -0.001745
+ 495.0000n -0.001599 495.0100n -0.001431 495.0200n -0.001243 495.0300n -0.001040 495.0400n -0.000826 495.0500n -0.000606 495.0600n -0.000383 495.0700n -0.000163 495.0800n 0.000051 495.0900n 0.000255 495.1000n 0.000445 495.1100n 0.000617 495.1200n 0.000770 495.1300n 0.000900 495.1400n 0.001006
+ 495.1500n 0.001088 495.1600n 0.001143 495.1700n 0.001174 495.1800n 0.001179 495.1900n 0.001161 495.2000n 0.001120 495.2100n 0.001059 495.2200n 0.000981 495.2300n 0.000887 495.2400n 0.000781 495.2500n 0.000666 495.2600n 0.000544 495.2700n 0.000420 495.2800n 0.000295 495.2900n 0.000174
+ 495.3000n 0.000057 495.3100n -0.000052 495.3200n -0.000151 495.3300n -0.000238 495.3400n -0.000313 495.3500n -0.000375 495.3600n -0.000422 495.3700n -0.000456 495.3800n -0.000476 495.3900n -0.000484 495.4000n -0.000479 495.4100n -0.000464 495.4200n -0.000440 495.4300n -0.000409 495.4400n -0.000372
+ 495.4500n -0.000331 495.4600n -0.000289 495.4700n -0.000246 495.4800n -0.000205 495.4900n -0.000167 495.5000n -0.000133 495.5100n -0.000104 495.5200n -0.000081 495.5300n -0.000064 495.5400n -0.000052 495.5500n -0.000047 495.5600n -0.000045 495.5700n -0.000048 495.5800n -0.000053 495.5900n -0.000059
+ 495.6000n -0.000064 495.6100n -0.000066 495.6200n -0.000064 495.6300n -0.000054 495.6400n -0.000036 495.6500n -0.000007 495.6600n 0.000034 495.6700n 0.000089 495.6800n 0.000160 495.6900n 0.000246 495.7000n 0.000349 495.7100n 0.000469 495.7200n 0.000605 495.7300n 0.000756 495.7400n 0.000922
+ 495.7500n 0.001100 495.7600n 0.001290 495.7700n 0.001487 495.7800n 0.001689 495.7900n 0.001893 495.8000n 0.002096 495.8100n 0.002294 495.8200n 0.002483 495.8300n 0.002660 495.8400n 0.002820 495.8500n 0.002959 495.8600n 0.003076 495.8700n 0.003165 495.8800n 0.003225 495.8900n 0.003253
+ 495.9000n 0.003247 495.9100n 0.003205 495.9200n 0.003126 495.9300n 0.003010 495.9400n 0.002858 495.9500n 0.002669 495.9600n 0.002446 495.9700n 0.002190 495.9800n 0.001904 495.9900n 0.001592 496.0000n 0.001256 496.0100n 0.000901 496.0200n 0.000531 496.0300n 0.000150 496.0400n -0.000236
+ 496.0500n -0.000622 496.0600n -0.001003 496.0700n -0.001376 496.0800n -0.001733 496.0900n -0.002072 496.1000n -0.002388 496.1100n -0.002677 496.1200n -0.002935 496.1300n -0.003159 496.1400n -0.003348 496.1500n -0.003498 496.1600n -0.003608 496.1700n -0.003679 496.1800n -0.003708 496.1900n -0.003698
+ 496.2000n -0.003649 496.2100n -0.003563 496.2200n -0.003442 496.2300n -0.003288 496.2400n -0.003104 496.2500n -0.002894 496.2600n -0.002661 496.2700n -0.002410 496.2800n -0.002144 496.2900n -0.001868 496.3000n -0.001586 496.3100n -0.001301 496.3200n -0.001018 496.3300n -0.000741 496.3400n -0.000474
+ 496.3500n -0.000219 496.3600n 0.000019 496.3700n 0.000239 496.3800n 0.000438 496.3900n 0.000614 496.4000n 0.000766 496.4100n 0.000892 496.4200n 0.000992 496.4300n 0.001065 496.4400n 0.001112 496.4500n 0.001133 496.4600n 0.001129 496.4700n 0.001100 496.4800n 0.001050 496.4900n 0.000978
+ 496.5000n 0.000888 496.5100n 0.000780 496.5200n 0.000658 496.5300n 0.000524 496.5400n 0.000379 496.5500n 0.000227 496.5600n 0.000069 496.5700n -0.000092 496.5800n -0.000254 496.5900n -0.000415 496.6000n -0.000573 496.6100n -0.000725 496.6200n -0.000871 496.6300n -0.001009 496.6400n -0.001138
+ 496.6500n -0.001255 496.6600n -0.001361 496.6700n -0.001455 496.6800n -0.001535 496.6900n -0.001602 496.7000n -0.001656 496.7100n -0.001695 496.7200n -0.001720 496.7300n -0.001732 496.7400n -0.001731 496.7500n -0.001717 496.7600n -0.001691 496.7700n -0.001653 496.7800n -0.001605 496.7900n -0.001547
+ 496.8000n -0.001480 496.8100n -0.001406 496.8200n -0.001326 496.8300n -0.001240 496.8400n -0.001151 496.8500n -0.001058 496.8600n -0.000965 496.8700n -0.000871 496.8800n -0.000779 496.8900n -0.000689 496.9000n -0.000603 496.9100n -0.000523 496.9200n -0.000448 496.9300n -0.000380 496.9400n -0.000321
+ 496.9500n -0.000271 496.9600n -0.000230 496.9700n -0.000199 496.9800n -0.000179 496.9900n -0.000169 497.0000n -0.000170 497.0100n -0.000182 497.0200n -0.000204 497.0300n -0.000236 497.0400n -0.000276 497.0500n -0.000325 497.0600n -0.000380 497.0700n -0.000441 497.0800n -0.000506 497.0900n -0.000574
+ 497.1000n -0.000643 497.1100n -0.000712 497.1200n -0.000778 497.1300n -0.000840 497.1400n -0.000896 497.1500n -0.000944 497.1600n -0.000984 497.1700n -0.001012 497.1800n -0.001029 497.1900n -0.001032 497.2000n -0.001020 497.2100n -0.000994 497.2200n -0.000952 497.2300n -0.000894 497.2400n -0.000820
+ 497.2500n -0.000730 497.2600n -0.000625 497.2700n -0.000506 497.2800n -0.000374 497.2900n -0.000229 497.3000n -0.000075 497.3100n 0.000089 497.3200n 0.000259 497.3300n 0.000434 497.3400n 0.000611 497.3500n 0.000789 497.3600n 0.000964 497.3700n 0.001135 497.3800n 0.001300 497.3900n 0.001456
+ 497.4000n 0.001602 497.4100n 0.001735 497.4200n 0.001854 497.4300n 0.001958 497.4400n 0.002045 497.4500n 0.002115 497.4600n 0.002167 497.4700n 0.002201 497.4800n 0.002217 497.4900n 0.002215 497.5000n 0.002196 497.5100n 0.002161 497.5200n 0.002111 497.5300n 0.002047 497.5400n 0.001971
+ 497.5500n 0.001884 497.5600n 0.001789 497.5700n 0.001687 497.5800n 0.001580 497.5900n 0.001470 497.6000n 0.001359 497.6100n 0.001248 497.6200n 0.001140 497.6300n 0.001036 497.6400n 0.000937 497.6500n 0.000844 497.6600n 0.000759 497.6700n 0.000681 497.6800n 0.000612 497.6900n 0.000552
+ 497.7000n 0.000501 497.7100n 0.000458 497.7200n 0.000423 497.7300n 0.000396 497.7400n 0.000375 497.7500n 0.000360 497.7600n 0.000349 497.7700n 0.000342 497.7800n 0.000338 497.7900n 0.000335 497.8000n 0.000333 497.8100n 0.000329 497.8200n 0.000324 497.8300n 0.000317 497.8400n 0.000306
+ 497.8500n 0.000292 497.8600n 0.000274 497.8700n 0.000252 497.8800n 0.000226 497.8900n 0.000197 497.9000n 0.000164 497.9100n 0.000129 497.9200n 0.000092 497.9300n 0.000054 497.9400n 0.000016 497.9500n -0.000020 497.9600n -0.000054 497.9700n -0.000084 497.9800n -0.000109 497.9900n -0.000129
+ 498.0000n -0.000142 498.0100n -0.000147 498.0200n -0.000143 498.0300n -0.000131 498.0400n -0.000109 498.0500n -0.000077 498.0600n -0.000037 498.0700n 0.000013 498.0800n 0.000072 498.0900n 0.000139 498.1000n 0.000212 498.1100n 0.000291 498.1200n 0.000375 498.1300n 0.000462 498.1400n 0.000551
+ 498.1500n 0.000640 498.1600n 0.000727 498.1700n 0.000810 498.1800n 0.000889 498.1900n 0.000962 498.2000n 0.001027 498.2100n 0.001083 498.2200n 0.001129 498.2300n 0.001165 498.2400n 0.001189 498.2500n 0.001202 498.2600n 0.001203 498.2700n 0.001192 498.2800n 0.001171 498.2900n 0.001139
+ 498.3000n 0.001099 498.3100n 0.001050 498.3200n 0.000995 498.3300n 0.000935 498.3400n 0.000871 498.3500n 0.000807 498.3600n 0.000742 498.3700n 0.000680 498.3800n 0.000623 498.3900n 0.000571 498.4000n 0.000527 498.4100n 0.000491 498.4200n 0.000466 498.4300n 0.000452 498.4400n 0.000450
+ 498.4500n 0.000461 498.4600n 0.000484 498.4700n 0.000519 498.4800n 0.000566 498.4900n 0.000624 498.5000n 0.000693 498.5100n 0.000769 498.5200n 0.000853 498.5300n 0.000942 498.5400n 0.001033 498.5500n 0.001126 498.5600n 0.001217 498.5700n 0.001304 498.5800n 0.001386 498.5900n 0.001458
+ 498.6000n 0.001521 498.6100n 0.001571 498.6200n 0.001606 498.6300n 0.001626 498.6400n 0.001628 498.6500n 0.001613 498.6600n 0.001578 498.6700n 0.001525 498.6800n 0.001453 498.6900n 0.001362 498.7000n 0.001254 498.7100n 0.001129 498.7200n 0.000990 498.7300n 0.000837 498.7400n 0.000674
+ 498.7500n 0.000502 498.7600n 0.000324 498.7700n 0.000143 498.7800n -0.000039 498.7900n -0.000218 498.8000n -0.000392 498.8100n -0.000558 498.8200n -0.000714 498.8300n -0.000857 498.8400n -0.000984 498.8500n -0.001095 498.8600n -0.001186 498.8700n -0.001257 498.8800n -0.001307 498.8900n -0.001335
+ 498.9000n -0.001340 498.9100n -0.001324 498.9200n -0.001286 498.9300n -0.001228 498.9400n -0.001150 498.9500n -0.001054 498.9600n -0.000942 498.9700n -0.000815 498.9800n -0.000678 498.9900n -0.000530 499.0000n -0.000376 499.0100n -0.000218 499.0200n -0.000058 499.0300n 0.000100 499.0400n 0.000255
+ 499.0500n 0.000404 499.0600n 0.000544 499.0700n 0.000675 499.0800n 0.000793 499.0900n 0.000897 499.1000n 0.000987 499.1100n 0.001061 499.1200n 0.001119 499.1300n 0.001160 499.1400n 0.001184 499.1500n 0.001192 499.1600n 0.001185 499.1700n 0.001163 499.1800n 0.001128 499.1900n 0.001080
+ 499.2000n 0.001023 499.2100n 0.000956 499.2200n 0.000884 499.2300n 0.000806 499.2400n 0.000726 499.2500n 0.000645 499.2600n 0.000565 499.2700n 0.000489 499.2800n 0.000417 499.2900n 0.000353 499.3000n 0.000296 499.3100n 0.000250 499.3200n 0.000214 499.3300n 0.000189 499.3400n 0.000177
+ 499.3500n 0.000177 499.3600n 0.000190 499.3700n 0.000216 499.3800n 0.000254 499.3900n 0.000304 499.4000n 0.000365 499.4100n 0.000437 499.4200n 0.000518 499.4300n 0.000606 499.4400n 0.000702 499.4500n 0.000802 499.4600n 0.000906 499.4700n 0.001012 499.4800n 0.001119 499.4900n 0.001224
+ 499.5000n 0.001327 499.5100n 0.001426 499.5200n 0.001519 499.5300n 0.001606 499.5400n 0.001684 499.5500n 0.001754 499.5600n 0.001813 499.5700n 0.001862 499.5800n 0.001900 499.5900n 0.001925 499.6000n 0.001939 499.6100n 0.001941 499.6200n 0.001931 499.6300n 0.001909 499.6400n 0.001875
+ 499.6500n 0.001831 499.6600n 0.001777 499.6700n 0.001713 499.6800n 0.001641 499.6900n 0.001562 499.7000n 0.001476 499.7100n 0.001384 499.7200n 0.001289 499.7300n 0.001191 499.7400n 0.001091 499.7500n 0.000991 499.7600n 0.000891 499.7700n 0.000794 499.7800n 0.000699 499.7900n 0.000609
+ 499.8000n 0.000523 499.8100n 0.000443 499.8200n 0.000370 499.8300n 0.000304 499.8400n 0.000245 499.8500n 0.000195 499.8600n 0.000152 499.8700n 0.000118 499.8800n 0.000091 499.8900n 0.000073 499.9000n 0.000061 499.9100n 0.000057 499.9200n 0.000058 499.9300n 0.000065 499.9400n 0.000076
+ 499.9500n 0.000090 499.9600n 0.000106 499.9700n 0.000123 499.9800n 0.000140 499.9900n 0.000155 500.0000n 0.000167 500.0100n 0.000175 500.0200n 0.000178 500.0300n 0.000175 500.0400n 0.000164 )
V_NOISE_N b1_src b_cm DC 0 PWL ( 0.0000n -0.001153 0.0100n -0.001041 0.0200n -0.000918 0.0300n -0.000787 0.0400n -0.000651 0.0500n -0.000511 0.0600n -0.000370 0.0700n -0.000230 0.0800n -0.000094 0.0900n 0.000036 0.1000n 0.000157 0.1100n 0.000269 0.1200n 0.000368 0.1300n 0.000453 0.1400n 0.000523
+ 0.1500n 0.000577 0.1600n 0.000614 0.1700n 0.000634 0.1800n 0.000636 0.1900n 0.000622 0.2000n 0.000591 0.2100n 0.000546 0.2200n 0.000487 0.2300n 0.000415 0.2400n 0.000334 0.2500n 0.000245 0.2600n 0.000150 0.2700n 0.000051 0.2800n -0.000048 0.2900n -0.000145
+ 0.3000n -0.000239 0.3100n -0.000326 0.3200n -0.000404 0.3300n -0.000472 0.3400n -0.000529 0.3500n -0.000572 0.3600n -0.000601 0.3700n -0.000615 0.3800n -0.000614 0.3900n -0.000598 0.4000n -0.000568 0.4100n -0.000524 0.4200n -0.000469 0.4300n -0.000403 0.4400n -0.000329
+ 0.4500n -0.000248 0.4600n -0.000163 0.4700n -0.000077 0.4800n 0.000009 0.4900n 0.000091 0.5000n 0.000167 0.5100n 0.000234 0.5200n 0.000291 0.5300n 0.000336 0.5400n 0.000366 0.5500n 0.000381 0.5600n 0.000380 0.5700n 0.000362 0.5800n 0.000327 0.5900n 0.000275
+ 0.6000n 0.000208 0.6100n 0.000127 0.6200n 0.000033 0.6300n -0.000072 0.6400n -0.000184 0.6500n -0.000302 0.6600n -0.000423 0.6700n -0.000543 0.6800n -0.000659 0.6900n -0.000767 0.7000n -0.000866 0.7100n -0.000951 0.7200n -0.001020 0.7300n -0.001071 0.7400n -0.001100
+ 0.7500n -0.001108 0.7600n -0.001091 0.7700n -0.001049 0.7800n -0.000983 0.7900n -0.000892 0.8000n -0.000777 0.8100n -0.000640 0.8200n -0.000482 0.8300n -0.000307 0.8400n -0.000116 0.8500n 0.000086 0.8600n 0.000296 0.8700n 0.000510 0.8800n 0.000724 0.8900n 0.000934
+ 0.9000n 0.001135 0.9100n 0.001324 0.9200n 0.001495 0.9300n 0.001646 0.9400n 0.001773 0.9500n 0.001873 0.9600n 0.001943 0.9700n 0.001982 0.9800n 0.001988 0.9900n 0.001961 1.0000n 0.001901 1.0100n 0.001807 1.0200n 0.001683 1.0300n 0.001528 1.0400n 0.001347
+ 1.0500n 0.001142 1.0600n 0.000916 1.0700n 0.000675 1.0800n 0.000422 1.0900n 0.000162 1.1000n -0.000100 1.1100n -0.000359 1.1200n -0.000611 1.1300n -0.000850 1.1400n -0.001072 1.1500n -0.001274 1.1600n -0.001450 1.1700n -0.001598 1.1800n -0.001716 1.1900n -0.001801
+ 1.2000n -0.001852 1.2100n -0.001867 1.2200n -0.001849 1.2300n -0.001796 1.2400n -0.001711 1.2500n -0.001595 1.2600n -0.001452 1.2700n -0.001284 1.2800n -0.001096 1.2900n -0.000892 1.3000n -0.000676 1.3100n -0.000453 1.3200n -0.000228 1.3300n -0.000006 1.3400n 0.000208
+ 1.3500n 0.000411 1.3600n 0.000596 1.3700n 0.000762 1.3800n 0.000903 1.3900n 0.001018 1.4000n 0.001104 1.4100n 0.001158 1.4200n 0.001181 1.4300n 0.001172 1.4400n 0.001131 1.4500n 0.001059 1.4600n 0.000958 1.4700n 0.000830 1.4800n 0.000679 1.4900n 0.000508
+ 1.5000n 0.000319 1.5100n 0.000119 1.5200n -0.000089 1.5300n -0.000301 1.5400n -0.000512 1.5500n -0.000717 1.5600n -0.000912 1.5700n -0.001093 1.5800n -0.001256 1.5900n -0.001397 1.6000n -0.001514 1.6100n -0.001605 1.6200n -0.001668 1.6300n -0.001700 1.6400n -0.001703
+ 1.6500n -0.001676 1.6600n -0.001620 1.6700n -0.001536 1.6800n -0.001427 1.6900n -0.001294 1.7000n -0.001140 1.7100n -0.000970 1.7200n -0.000786 1.7300n -0.000593 1.7400n -0.000394 1.7500n -0.000193 1.7600n 0.000004 1.7700n 0.000196 1.7800n 0.000376 1.7900n 0.000543
+ 1.8000n 0.000693 1.8100n 0.000824 1.8200n 0.000932 1.8300n 0.001017 1.8400n 0.001076 1.8500n 0.001109 1.8600n 0.001117 1.8700n 0.001098 1.8800n 0.001055 1.8900n 0.000988 1.9000n 0.000898 1.9100n 0.000789 1.9200n 0.000662 1.9300n 0.000520 1.9400n 0.000367
+ 1.9500n 0.000203 1.9600n 0.000034 1.9700n -0.000138 1.9800n -0.000311 1.9900n -0.000482 2.0000n -0.000648 2.0100n -0.000806 2.0200n -0.000956 2.0300n -0.001096 2.0400n -0.001223 2.0500n -0.001339 2.0600n -0.001441 2.0700n -0.001530 2.0800n -0.001607 2.0900n -0.001672
+ 2.1000n -0.001725 2.1100n -0.001769 2.1200n -0.001804 2.1300n -0.001833 2.1400n -0.001856 2.1500n -0.001876 2.1600n -0.001894 2.1700n -0.001912 2.1800n -0.001931 2.1900n -0.001953 2.2000n -0.001979 2.2100n -0.002011 2.2200n -0.002047 2.2300n -0.002090 2.2400n -0.002139
+ 2.2500n -0.002193 2.2600n -0.002253 2.2700n -0.002317 2.2800n -0.002384 2.2900n -0.002453 2.3000n -0.002523 2.3100n -0.002591 2.3200n -0.002656 2.3300n -0.002716 2.3400n -0.002769 2.3500n -0.002814 2.3600n -0.002847 2.3700n -0.002869 2.3800n -0.002878 2.3900n -0.002872
+ 2.4000n -0.002851 2.4100n -0.002813 2.4200n -0.002760 2.4300n -0.002691 2.4400n -0.002606 2.4500n -0.002506 2.4600n -0.002392 2.4700n -0.002266 2.4800n -0.002129 2.4900n -0.001983 2.5000n -0.001831 2.5100n -0.001674 2.5200n -0.001514 2.5300n -0.001355 2.5400n -0.001198
+ 2.5500n -0.001045 2.5600n -0.000900 2.5700n -0.000762 2.5800n -0.000636 2.5900n -0.000521 2.6000n -0.000418 2.6100n -0.000330 2.6200n -0.000256 2.6300n -0.000196 2.6400n -0.000150 2.6500n -0.000118 2.6600n -0.000098 2.6700n -0.000090 2.6800n -0.000092 2.6900n -0.000101
+ 2.7000n -0.000117 2.7100n -0.000137 2.7200n -0.000160 2.7300n -0.000182 2.7400n -0.000201 2.7500n -0.000216 2.7600n -0.000225 2.7700n -0.000226 2.7800n -0.000217 2.7900n -0.000196 2.8000n -0.000164 2.8100n -0.000119 2.8200n -0.000061 2.8300n 0.000010 2.8400n 0.000094
+ 2.8500n 0.000190 2.8600n 0.000297 2.8700n 0.000413 2.8800n 0.000538 2.8900n 0.000669 2.9000n 0.000804 2.9100n 0.000941 2.9200n 0.001078 2.9300n 0.001213 2.9400n 0.001343 2.9500n 0.001466 2.9600n 0.001580 2.9700n 0.001684 2.9800n 0.001776 2.9900n 0.001853
+ 3.0000n 0.001916 3.0100n 0.001964 3.0200n 0.001995 3.0300n 0.002010 3.0400n 0.002010 3.0500n 0.001994 3.0600n 0.001963 3.0700n 0.001919 3.0800n 0.001863 3.0900n 0.001796 3.1000n 0.001721 3.1100n 0.001639 3.1200n 0.001552 3.1300n 0.001462 3.1400n 0.001371
+ 3.1500n 0.001281 3.1600n 0.001194 3.1700n 0.001111 3.1800n 0.001033 3.1900n 0.000963 3.2000n 0.000899 3.2100n 0.000844 3.2200n 0.000798 3.2300n 0.000759 3.2400n 0.000729 3.2500n 0.000706 3.2600n 0.000690 3.2700n 0.000679 3.2800n 0.000673 3.2900n 0.000669
+ 3.3000n 0.000666 3.3100n 0.000663 3.3200n 0.000657 3.3300n 0.000648 3.3400n 0.000634 3.3500n 0.000613 3.3600n 0.000583 3.3700n 0.000545 3.3800n 0.000497 3.3900n 0.000439 3.4000n 0.000370 3.4100n 0.000291 3.4200n 0.000202 3.4300n 0.000104 3.4400n -0.000003
+ 3.4500n -0.000116 3.4600n -0.000235 3.4700n -0.000357 3.4800n -0.000481 3.4900n -0.000604 3.5000n -0.000724 3.5100n -0.000840 3.5200n -0.000947 3.5300n -0.001046 3.5400n -0.001133 3.5500n -0.001207 3.5600n -0.001265 3.5700n -0.001308 3.5800n -0.001333 3.5900n -0.001340
+ 3.6000n -0.001328 3.6100n -0.001298 3.6200n -0.001250 3.6300n -0.001184 3.6400n -0.001102 3.6500n -0.001005 3.6600n -0.000894 3.6700n -0.000771 3.6800n -0.000640 3.6900n -0.000501 3.7000n -0.000357 3.7100n -0.000212 3.7200n -0.000066 3.7300n 0.000076 3.7400n 0.000214
+ 3.7500n 0.000344 3.7600n 0.000465 3.7700n 0.000575 3.7800n 0.000673 3.7900n 0.000757 3.8000n 0.000827 3.8100n 0.000883 3.8200n 0.000923 3.8300n 0.000949 3.8400n 0.000962 3.8500n 0.000961 3.8600n 0.000949 3.8700n 0.000926 3.8800n 0.000896 3.8900n 0.000858
+ 3.9000n 0.000816 3.9100n 0.000772 3.9200n 0.000727 3.9300n 0.000683 3.9400n 0.000643 3.9500n 0.000608 3.9600n 0.000580 3.9700n 0.000560 3.9800n 0.000549 3.9900n 0.000548 4.0000n 0.000557 4.0100n 0.000576 4.0200n 0.000605 4.0300n 0.000644 4.0400n 0.000691
+ 4.0500n 0.000745 4.0600n 0.000805 4.0700n 0.000869 4.0800n 0.000935 4.0900n 0.001002 4.1000n 0.001067 4.1100n 0.001127 4.1200n 0.001182 4.1300n 0.001229 4.1400n 0.001265 4.1500n 0.001291 4.1600n 0.001303 4.1700n 0.001301 4.1800n 0.001284 4.1900n 0.001251
+ 4.2000n 0.001203 4.2100n 0.001140 4.2200n 0.001062 4.2300n 0.000969 4.2400n 0.000864 4.2500n 0.000748 4.2600n 0.000622 4.2700n 0.000489 4.2800n 0.000351 4.2900n 0.000210 4.3000n 0.000069 4.3100n -0.000070 4.3200n -0.000204 4.3300n -0.000332 4.3400n -0.000451
+ 4.3500n -0.000559 4.3600n -0.000654 4.3700n -0.000735 4.3800n -0.000802 4.3900n -0.000852 4.4000n -0.000886 4.4100n -0.000904 4.4200n -0.000906 4.4300n -0.000893 4.4400n -0.000866 4.4500n -0.000826 4.4600n -0.000775 4.4700n -0.000715 4.4800n -0.000649 4.4900n -0.000577
+ 4.5000n -0.000503 4.5100n -0.000430 4.5200n -0.000358 4.5300n -0.000291 4.5400n -0.000230 4.5500n -0.000177 4.5600n -0.000135 4.5700n -0.000104 4.5800n -0.000085 4.5900n -0.000078 4.6000n -0.000085 4.6100n -0.000105 4.6200n -0.000138 4.6300n -0.000182 4.6400n -0.000237
+ 4.6500n -0.000301 4.6600n -0.000373 4.6700n -0.000450 4.6800n -0.000531 4.6900n -0.000613 4.7000n -0.000694 4.7100n -0.000772 4.7200n -0.000845 4.7300n -0.000909 4.7400n -0.000965 4.7500n -0.001009 4.7600n -0.001041 4.7700n -0.001059 4.7800n -0.001062 4.7900n -0.001051
+ 4.8000n -0.001025 4.8100n -0.000984 4.8200n -0.000930 4.8300n -0.000864 4.8400n -0.000786 4.8500n -0.000699 4.8600n -0.000605 4.8700n -0.000506 4.8800n -0.000404 4.8900n -0.000302 4.9000n -0.000202 4.9100n -0.000108 4.9200n -0.000021 4.9300n 0.000056 4.9400n 0.000121
+ 4.9500n 0.000172 4.9600n 0.000208 4.9700n 0.000227 4.9800n 0.000229 4.9900n 0.000212 5.0000n 0.000177 5.0100n 0.000125 5.0200n 0.000056 5.0300n -0.000029 5.0400n -0.000128 5.0500n -0.000239 5.0600n -0.000361 5.0700n -0.000490 5.0800n -0.000625 5.0900n -0.000762
+ 5.1000n -0.000899 5.1100n -0.001033 5.1200n -0.001161 5.1300n -0.001281 5.1400n -0.001390 5.1500n -0.001486 5.1600n -0.001569 5.1700n -0.001635 5.1800n -0.001684 5.1900n -0.001717 5.2000n -0.001731 5.2100n -0.001728 5.2200n -0.001709 5.2300n -0.001674 5.2400n -0.001625
+ 5.2500n -0.001564 5.2600n -0.001493 5.2700n -0.001414 5.2800n -0.001331 5.2900n -0.001245 5.3000n -0.001160 5.3100n -0.001079 5.3200n -0.001003 5.3300n -0.000937 5.3400n -0.000882 5.3500n -0.000840 5.3600n -0.000814 5.3700n -0.000804 5.3800n -0.000812 5.3900n -0.000838
+ 5.4000n -0.000883 5.4100n -0.000947 5.4200n -0.001028 5.4300n -0.001125 5.4400n -0.001237 5.4500n -0.001362 5.4600n -0.001497 5.4700n -0.001640 5.4800n -0.001788 5.4900n -0.001938 5.5000n -0.002087 5.5100n -0.002231 5.5200n -0.002368 5.5300n -0.002494 5.5400n -0.002607
+ 5.5500n -0.002704 5.5600n -0.002783 5.5700n -0.002843 5.5800n -0.002880 5.5900n -0.002896 5.6000n -0.002888 5.6100n -0.002857 5.6200n -0.002804 5.6300n -0.002729 5.6400n -0.002633 5.6500n -0.002518 5.6600n -0.002387 5.6700n -0.002241 5.6800n -0.002084 5.6900n -0.001918
+ 5.7000n -0.001746 5.7100n -0.001572 5.7200n -0.001399 5.7300n -0.001229 5.7400n -0.001065 5.7500n -0.000911 5.7600n -0.000768 5.7700n -0.000639 5.7800n -0.000525 5.7900n -0.000428 5.8000n -0.000349 5.8100n -0.000287 5.8200n -0.000244 5.8300n -0.000218 5.8400n -0.000208
+ 5.8500n -0.000213 5.8600n -0.000232 5.8700n -0.000262 5.8800n -0.000300 5.8900n -0.000346 5.9000n -0.000394 5.9100n -0.000444 5.9200n -0.000492 5.9300n -0.000535 5.9400n -0.000570 5.9500n -0.000596 5.9600n -0.000610 5.9700n -0.000611 5.9800n -0.000596 5.9900n -0.000564
+ 6.0000n -0.000516 6.0100n -0.000450 6.0200n -0.000368 6.0300n -0.000269 6.0400n -0.000156 6.0500n -0.000029 6.0600n 0.000110 6.0700n 0.000257 6.0800n 0.000411 6.0900n 0.000569 6.1000n 0.000726 6.1100n 0.000881 6.1200n 0.001030 6.1300n 0.001170 6.1400n 0.001298
+ 6.1500n 0.001410 6.1600n 0.001504 6.1700n 0.001578 6.1800n 0.001630 6.1900n 0.001657 6.2000n 0.001660 6.2100n 0.001636 6.2200n 0.001586 6.2300n 0.001510 6.2400n 0.001409 6.2500n 0.001283 6.2600n 0.001135 6.2700n 0.000966 6.2800n 0.000779 6.2900n 0.000576
+ 6.3000n 0.000361 6.3100n 0.000137 6.3200n -0.000094 6.3300n -0.000328 6.3400n -0.000561 6.3500n -0.000790 6.3600n -0.001012 6.3700n -0.001224 6.3800n -0.001424 6.3900n -0.001608 6.4000n -0.001775 6.4100n -0.001923 6.4200n -0.002050 6.4300n -0.002156 6.4400n -0.002241
+ 6.4500n -0.002304 6.4600n -0.002345 6.4700n -0.002365 6.4800n -0.002365 6.4900n -0.002347 6.5000n -0.002312 6.5100n -0.002261 6.5200n -0.002198 6.5300n -0.002124 6.5400n -0.002041 6.5500n -0.001952 6.5600n -0.001858 6.5700n -0.001762 6.5800n -0.001667 6.5900n -0.001572
+ 6.6000n -0.001481 6.6100n -0.001395 6.6200n -0.001314 6.6300n -0.001239 6.6400n -0.001172 6.6500n -0.001112 6.6600n -0.001059 6.6700n -0.001014 6.6800n -0.000975 6.6900n -0.000942 6.7000n -0.000914 6.7100n -0.000890 6.7200n -0.000869 6.7300n -0.000851 6.7400n -0.000833
+ 6.7500n -0.000815 6.7600n -0.000796 6.7700n -0.000775 6.7800n -0.000751 6.7900n -0.000724 6.8000n -0.000693 6.8100n -0.000659 6.8200n -0.000620 6.8300n -0.000579 6.8400n -0.000534 6.8500n -0.000487 6.8600n -0.000439 6.8700n -0.000391 6.8800n -0.000344 6.8900n -0.000299
+ 6.9000n -0.000259 6.9100n -0.000223 6.9200n -0.000195 6.9300n -0.000175 6.9400n -0.000164 6.9500n -0.000165 6.9600n -0.000177 6.9700n -0.000201 6.9800n -0.000239 6.9900n -0.000291 7.0000n -0.000356 7.0100n -0.000434 7.0200n -0.000526 7.0300n -0.000629 7.0400n -0.000744
+ 7.0500n -0.000867 7.0600n -0.000999 7.0700n -0.001137 7.0800n -0.001278 7.0900n -0.001421 7.1000n -0.001564 7.1100n -0.001704 7.1200n -0.001838 7.1300n -0.001965 7.1400n -0.002081 7.1500n -0.002185 7.1600n -0.002275 7.1700n -0.002348 7.1800n -0.002404 7.1900n -0.002441
+ 7.2000n -0.002458 7.2100n -0.002454 7.2200n -0.002429 7.2300n -0.002383 7.2400n -0.002316 7.2500n -0.002230 7.2600n -0.002124 7.2700n -0.002000 7.2800n -0.001861 7.2900n -0.001707 7.3000n -0.001541 7.3100n -0.001365 7.3200n -0.001181 7.3300n -0.000992 7.3400n -0.000799
+ 7.3500n -0.000607 7.3600n -0.000417 7.3700n -0.000231 7.3800n -0.000052 7.3900n 0.000119 7.4000n 0.000279 7.4100n 0.000427 7.4200n 0.000561 7.4300n 0.000681 7.4400n 0.000785 7.4500n 0.000873 7.4600n 0.000944 7.4700n 0.000999 7.4800n 0.001037 7.4900n 0.001059
+ 7.5000n 0.001066 7.5100n 0.001058 7.5200n 0.001037 7.5300n 0.001003 7.5400n 0.000957 7.5500n 0.000902 7.5600n 0.000839 7.5700n 0.000768 7.5800n 0.000692 7.5900n 0.000611 7.6000n 0.000527 7.6100n 0.000442 7.6200n 0.000356 7.6300n 0.000270 7.6400n 0.000186
+ 7.6500n 0.000105 7.6600n 0.000026 7.6700n -0.000049 7.6800n -0.000120 7.6900n -0.000187 7.7000n -0.000248 7.7100n -0.000305 7.7200n -0.000357 7.7300n -0.000403 7.7400n -0.000444 7.7500n -0.000480 7.7600n -0.000511 7.7700n -0.000537 7.7800n -0.000558 7.7900n -0.000574
+ 7.8000n -0.000585 7.8100n -0.000592 7.8200n -0.000594 7.8300n -0.000591 7.8400n -0.000583 7.8500n -0.000571 7.8600n -0.000554 7.8700n -0.000532 7.8800n -0.000505 7.8900n -0.000474 7.9000n -0.000438 7.9100n -0.000397 7.9200n -0.000351 7.9300n -0.000301 7.9400n -0.000247
+ 7.9500n -0.000188 7.9600n -0.000127 7.9700n -0.000062 7.9800n 0.000006 7.9900n 0.000075 8.0000n 0.000146 8.0100n 0.000217 8.0200n 0.000289 8.0300n 0.000359 8.0400n 0.000427 8.0500n 0.000493 8.0600n 0.000555 8.0700n 0.000613 8.0800n 0.000665 8.0900n 0.000711
+ 8.1000n 0.000751 8.1100n 0.000783 8.1200n 0.000807 8.1300n 0.000823 8.1400n 0.000831 8.1500n 0.000829 8.1600n 0.000819 8.1700n 0.000800 8.1800n 0.000772 8.1900n 0.000736 8.2000n 0.000692 8.2100n 0.000642 8.2200n 0.000584 8.2300n 0.000522 8.2400n 0.000454
+ 8.2500n 0.000383 8.2600n 0.000309 8.2700n 0.000233 8.2800n 0.000156 8.2900n 0.000080 8.3000n 0.000004 8.3100n -0.000069 8.3200n -0.000139 8.3300n -0.000205 8.3400n -0.000266 8.3500n -0.000323 8.3600n -0.000373 8.3700n -0.000418 8.3800n -0.000456 8.3900n -0.000487
+ 8.4000n -0.000512 8.4100n -0.000530 8.4200n -0.000541 8.4300n -0.000546 8.4400n -0.000545 8.4500n -0.000538 8.4600n -0.000526 8.4700n -0.000509 8.4800n -0.000487 8.4900n -0.000460 8.5000n -0.000431 8.5100n -0.000398 8.5200n -0.000362 8.5300n -0.000323 8.5400n -0.000282
+ 8.5500n -0.000240 8.5600n -0.000196 8.5700n -0.000151 8.5800n -0.000104 8.5900n -0.000057 8.6000n -0.000009 8.6100n 0.000040 8.6200n 0.000089 8.6300n 0.000138 8.6400n 0.000188 8.6500n 0.000237 8.6600n 0.000287 8.6700n 0.000336 8.6800n 0.000384 8.6900n 0.000432
+ 8.7000n 0.000478 8.7100n 0.000522 8.7200n 0.000565 8.7300n 0.000605 8.7400n 0.000641 8.7500n 0.000675 8.7600n 0.000704 8.7700n 0.000728 8.7800n 0.000748 8.7900n 0.000762 8.8000n 0.000771 8.8100n 0.000773 8.8200n 0.000769 8.8300n 0.000759 8.8400n 0.000743
+ 8.8500n 0.000721 8.8600n 0.000692 8.8700n 0.000659 8.8800n 0.000621 8.8900n 0.000579 8.9000n 0.000534 8.9100n 0.000487 8.9200n 0.000439 8.9300n 0.000392 8.9400n 0.000346 8.9500n 0.000304 8.9600n 0.000267 8.9700n 0.000236 8.9800n 0.000213 8.9900n 0.000199
+ 9.0000n 0.000195 9.0100n 0.000203 9.0200n 0.000223 9.0300n 0.000256 9.0400n 0.000302 9.0500n 0.000363 9.0600n 0.000438 9.0700n 0.000527 9.0800n 0.000628 9.0900n 0.000742 9.1000n 0.000867 9.1100n 0.001001 9.1200n 0.001144 9.1300n 0.001292 9.1400n 0.001444
+ 9.1500n 0.001597 9.1600n 0.001748 9.1700n 0.001896 9.1800n 0.002037 9.1900n 0.002168 9.2000n 0.002287 9.2100n 0.002390 9.2200n 0.002477 9.2300n 0.002544 9.2400n 0.002589 9.2500n 0.002611 9.2600n 0.002608 9.2700n 0.002579 9.2800n 0.002524 9.2900n 0.002442
+ 9.3000n 0.002333 9.3100n 0.002199 9.3200n 0.002040 9.3300n 0.001858 9.3400n 0.001655 9.3500n 0.001432 9.3600n 0.001193 9.3700n 0.000941 9.3800n 0.000678 9.3900n 0.000408 9.4000n 0.000135 9.4100n -0.000139 9.4200n -0.000409 9.4300n -0.000672 9.4400n -0.000925
+ 9.4500n -0.001165 9.4600n -0.001389 9.4700n -0.001593 9.4800n -0.001777 9.4900n -0.001937 9.5000n -0.002072 9.5100n -0.002182 9.5200n -0.002266 9.5300n -0.002322 9.5400n -0.002353 9.5500n -0.002357 9.5600n -0.002336 9.5700n -0.002292 9.5800n -0.002227 9.5900n -0.002141
+ 9.6000n -0.002038 9.6100n -0.001920 9.6200n -0.001789 9.6300n -0.001648 9.6400n -0.001500 9.6500n -0.001346 9.6600n -0.001191 9.6700n -0.001035 9.6800n -0.000881 9.6900n -0.000731 9.7000n -0.000586 9.7100n -0.000448 9.7200n -0.000318 9.7300n -0.000195 9.7400n -0.000082
+ 9.7500n 0.000023 9.7600n 0.000119 9.7700n 0.000208 9.7800n 0.000289 9.7900n 0.000365 9.8000n 0.000435 9.8100n 0.000502 9.8200n 0.000567 9.8300n 0.000631 9.8400n 0.000695 9.8500n 0.000760 9.8600n 0.000829 9.8700n 0.000901 9.8800n 0.000978 9.8900n 0.001059
+ 9.9000n 0.001146 9.9100n 0.001238 9.9200n 0.001335 9.9300n 0.001436 9.9400n 0.001541 9.9500n 0.001647 9.9600n 0.001755 9.9700n 0.001861 9.9800n 0.001965 9.9900n 0.002065 10.0000n 0.002158 10.0100n 0.002243 10.0200n 0.002317 10.0300n 0.002379 10.0400n 0.002426
+ 10.0500n 0.002458 10.0600n 0.002472 10.0700n 0.002468 10.0800n 0.002445 10.0900n 0.002403 10.1000n 0.002340 10.1100n 0.002259 10.1200n 0.002158 10.1300n 0.002039 10.1400n 0.001904 10.1500n 0.001754 10.1600n 0.001591 10.1700n 0.001418 10.1800n 0.001236 10.1900n 0.001049
+ 10.2000n 0.000860 10.2100n 0.000670 10.2200n 0.000483 10.2300n 0.000301 10.2400n 0.000127 10.2500n -0.000037 10.2600n -0.000188 10.2700n -0.000325 10.2800n -0.000447 10.2900n -0.000553 10.3000n -0.000641 10.3100n -0.000713 10.3200n -0.000767 10.3300n -0.000805 10.3400n -0.000828
+ 10.3500n -0.000838 10.3600n -0.000836 10.3700n -0.000824 10.3800n -0.000805 10.3900n -0.000782 10.4000n -0.000757 10.4100n -0.000733 10.4200n -0.000714 10.4300n -0.000701 10.4400n -0.000697 10.4500n -0.000706 10.4600n -0.000728 10.4700n -0.000766 10.4800n -0.000821 10.4900n -0.000893
+ 10.5000n -0.000985 10.5100n -0.001094 10.5200n -0.001222 10.5300n -0.001366 10.5400n -0.001525 10.5500n -0.001697 10.5600n -0.001880 10.5700n -0.002071 10.5800n -0.002267 10.5900n -0.002464 10.6000n -0.002658 10.6100n -0.002846 10.6200n -0.003024 10.6300n -0.003188 10.6400n -0.003335
+ 10.6500n -0.003460 10.6600n -0.003561 10.6700n -0.003635 10.6800n -0.003680 10.6900n -0.003694 10.7000n -0.003674 10.7100n -0.003622 10.7200n -0.003535 10.7300n -0.003415 10.7400n -0.003263 10.7500n -0.003080 10.7600n -0.002868 10.7700n -0.002631 10.7800n -0.002371 10.7900n -0.002091
+ 10.8000n -0.001797 10.8100n -0.001491 10.8200n -0.001179 10.8300n -0.000865 10.8400n -0.000553 10.8500n -0.000249 10.8600n 0.000044 10.8700n 0.000322 10.8800n 0.000580 10.8900n 0.000816 10.9000n 0.001026 10.9100n 0.001208 10.9200n 0.001360 10.9300n 0.001480 10.9400n 0.001569
+ 10.9500n 0.001625 10.9600n 0.001649 10.9700n 0.001643 10.9800n 0.001608 10.9900n 0.001546 11.0000n 0.001459 11.0100n 0.001351 11.0200n 0.001224 11.0300n 0.001083 11.0400n 0.000931 11.0500n 0.000771 11.0600n 0.000608 11.0700n 0.000446 11.0800n 0.000287 11.0900n 0.000135
+ 11.1000n -0.000007 11.1100n -0.000135 11.1200n -0.000248 11.1300n -0.000343 11.1400n -0.000420 11.1500n -0.000476 11.1600n -0.000512 11.1700n -0.000527 11.1800n -0.000522 11.1900n -0.000498 11.2000n -0.000454 11.2100n -0.000394 11.2200n -0.000319 11.2300n -0.000231 11.2400n -0.000131
+ 11.2500n -0.000024 11.2600n 0.000090 11.2700n 0.000208 11.2800n 0.000327 11.2900n 0.000445 11.3000n 0.000560 11.3100n 0.000671 11.3200n 0.000775 11.3300n 0.000871 11.3400n 0.000959 11.3500n 0.001037 11.3600n 0.001105 11.3700n 0.001164 11.3800n 0.001213 11.3900n 0.001253
+ 11.4000n 0.001284 11.4100n 0.001308 11.4200n 0.001326 11.4300n 0.001338 11.4400n 0.001347 11.4500n 0.001353 11.4600n 0.001359 11.4700n 0.001364 11.4800n 0.001371 11.4900n 0.001380 11.5000n 0.001393 11.5100n 0.001409 11.5200n 0.001429 11.5300n 0.001453 11.5400n 0.001482
+ 11.5500n 0.001513 11.5600n 0.001548 11.5700n 0.001585 11.5800n 0.001622 11.5900n 0.001659 11.6000n 0.001693 11.6100n 0.001725 11.6200n 0.001751 11.6300n 0.001770 11.6400n 0.001781 11.6500n 0.001782 11.6600n 0.001772 11.6700n 0.001751 11.6800n 0.001716 11.6900n 0.001667
+ 11.7000n 0.001604 11.7100n 0.001528 11.7200n 0.001438 11.7300n 0.001335 11.7400n 0.001220 11.7500n 0.001094 11.7600n 0.000959 11.7700n 0.000817 11.7800n 0.000670 11.7900n 0.000520 11.8000n 0.000370 11.8100n 0.000222 11.8200n 0.000079 11.8300n -0.000057 11.8400n -0.000183
+ 11.8500n -0.000297 11.8600n -0.000397 11.8700n -0.000481 11.8800n -0.000547 11.8900n -0.000595 11.9000n -0.000624 11.9100n -0.000633 11.9200n -0.000622 11.9300n -0.000592 11.9400n -0.000543 11.9500n -0.000477 11.9600n -0.000396 11.9700n -0.000301 11.9800n -0.000195 11.9900n -0.000080
+ 12.0000n 0.000041 12.0100n 0.000166 12.0200n 0.000290 12.0300n 0.000411 12.0400n 0.000527 12.0500n 0.000634 12.0600n 0.000729 12.0700n 0.000811 12.0800n 0.000877 12.0900n 0.000925 12.1000n 0.000955 12.1100n 0.000964 12.1200n 0.000953 12.1300n 0.000920 12.1400n 0.000868
+ 12.1500n 0.000796 12.1600n 0.000705 12.1700n 0.000597 12.1800n 0.000474 12.1900n 0.000338 12.2000n 0.000192 12.2100n 0.000038 12.2200n -0.000121 12.2300n -0.000282 12.2400n -0.000443 12.2500n -0.000600 12.2600n -0.000750 12.2700n -0.000892 12.2800n -0.001023 12.2900n -0.001141
+ 12.3000n -0.001244 12.3100n -0.001331 12.3200n -0.001401 12.3300n -0.001454 12.3400n -0.001489 12.3500n -0.001507 12.3600n -0.001507 12.3700n -0.001492 12.3800n -0.001463 12.3900n -0.001420 12.4000n -0.001367 12.4100n -0.001304 12.4200n -0.001235 12.4300n -0.001160 12.4400n -0.001084
+ 12.4500n -0.001006 12.4600n -0.000931 12.4700n -0.000859 12.4800n -0.000793 12.4900n -0.000733 12.5000n -0.000682 12.5100n -0.000639 12.5200n -0.000606 12.5300n -0.000583 12.5400n -0.000569 12.5500n -0.000564 12.5600n -0.000568 12.5700n -0.000579 12.5800n -0.000596 12.5900n -0.000618
+ 12.6000n -0.000642 12.6100n -0.000668 12.6200n -0.000693 12.6300n -0.000715 12.6400n -0.000733 12.6500n -0.000745 12.6600n -0.000749 12.6700n -0.000745 12.6800n -0.000731 12.6900n -0.000705 12.7000n -0.000669 12.7100n -0.000622 12.7200n -0.000563 12.7300n -0.000495 12.7400n -0.000416
+ 12.7500n -0.000330 12.7600n -0.000236 12.7700n -0.000138 12.7800n -0.000037 12.7900n 0.000065 12.8000n 0.000165 12.8100n 0.000261 12.8200n 0.000351 12.8300n 0.000432 12.8400n 0.000502 12.8500n 0.000560 12.8600n 0.000603 12.8700n 0.000630 12.8800n 0.000640 12.8900n 0.000633
+ 12.9000n 0.000607 12.9100n 0.000563 12.9200n 0.000501 12.9300n 0.000423 12.9400n 0.000329 12.9500n 0.000222 12.9600n 0.000103 12.9700n -0.000024 12.9800n -0.000159 12.9900n -0.000297 13.0000n -0.000435 13.0100n -0.000572 13.0200n -0.000703 13.0300n -0.000825 13.0400n -0.000936
+ 13.0500n -0.001033 13.0600n -0.001114 13.0700n -0.001177 13.0800n -0.001219 13.0900n -0.001241 13.1000n -0.001240 13.1100n -0.001218 13.1200n -0.001173 13.1300n -0.001107 13.1400n -0.001020 13.1500n -0.000915 13.1600n -0.000794 13.1700n -0.000659 13.1800n -0.000512 13.1900n -0.000357
+ 13.2000n -0.000197 13.2100n -0.000036 13.2200n 0.000124 13.2300n 0.000278 13.2400n 0.000424 13.2500n 0.000558 13.2600n 0.000678 13.2700n 0.000782 13.2800n 0.000866 13.2900n 0.000930 13.3000n 0.000972 13.3100n 0.000991 13.3200n 0.000988 13.3300n 0.000963 13.3400n 0.000916
+ 13.3500n 0.000850 13.3600n 0.000766 13.3700n 0.000666 13.3800n 0.000554 13.3900n 0.000432 13.4000n 0.000305 13.4100n 0.000174 13.4200n 0.000046 13.4300n -0.000078 13.4400n -0.000194 13.4500n -0.000296 13.4600n -0.000384 13.4700n -0.000452 13.4800n -0.000500 13.4900n -0.000523
+ 13.5000n -0.000522 13.5100n -0.000493 13.5200n -0.000437 13.5300n -0.000354 13.5400n -0.000244 13.5500n -0.000107 13.5600n 0.000054 13.5700n 0.000238 13.5800n 0.000441 13.5900n 0.000662 13.6000n 0.000896 13.6100n 0.001140 13.6200n 0.001390 13.6300n 0.001642 13.6400n 0.001892
+ 13.6500n 0.002136 13.6600n 0.002370 13.6700n 0.002591 13.6800n 0.002794 13.6900n 0.002977 13.7000n 0.003137 13.7100n 0.003272 13.7200n 0.003379 13.7300n 0.003459 13.7400n 0.003508 13.7500n 0.003529 13.7600n 0.003520 13.7700n 0.003483 13.7800n 0.003418 13.7900n 0.003329
+ 13.8000n 0.003216 13.8100n 0.003083 13.8200n 0.002932 13.8300n 0.002766 13.8400n 0.002589 13.8500n 0.002403 13.8600n 0.002212 13.8700n 0.002019 13.8800n 0.001828 13.8900n 0.001640 13.9000n 0.001459 13.9100n 0.001287 13.9200n 0.001125 13.9300n 0.000976 13.9400n 0.000841
+ 13.9500n 0.000720 13.9600n 0.000613 13.9700n 0.000521 13.9800n 0.000443 13.9900n 0.000379 14.0000n 0.000326 14.0100n 0.000285 14.0200n 0.000252 14.0300n 0.000227 14.0400n 0.000207 14.0500n 0.000191 14.0600n 0.000176 14.0700n 0.000161 14.0800n 0.000144 14.0900n 0.000124
+ 14.1000n 0.000098 14.1100n 0.000067 14.1200n 0.000028 14.1300n -0.000017 14.1400n -0.000071 14.1500n -0.000131 14.1600n -0.000198 14.1700n -0.000271 14.1800n -0.000349 14.1900n -0.000431 14.2000n -0.000515 14.2100n -0.000598 14.2200n -0.000680 14.2300n -0.000759 14.2400n -0.000832
+ 14.2500n -0.000898 14.2600n -0.000954 14.2700n -0.001000 14.2800n -0.001033 14.2900n -0.001053 14.3000n -0.001059 14.3100n -0.001050 14.3200n -0.001026 14.3300n -0.000987 14.3400n -0.000934 14.3500n -0.000868 14.3600n -0.000789 14.3700n -0.000701 14.3800n -0.000604 14.3900n -0.000500
+ 14.4000n -0.000393 14.4100n -0.000285 14.4200n -0.000178 14.4300n -0.000075 14.4400n 0.000020 14.4500n 0.000106 14.4600n 0.000179 14.4700n 0.000238 14.4800n 0.000281 14.4900n 0.000305 14.5000n 0.000309 14.5100n 0.000292 14.5200n 0.000254 14.5300n 0.000194 14.5400n 0.000113
+ 14.5500n 0.000012 14.5600n -0.000108 14.5700n -0.000246 14.5800n -0.000399 14.5900n -0.000565 14.6000n -0.000741 14.6100n -0.000924 14.6200n -0.001111 14.6300n -0.001299 14.6400n -0.001483 14.6500n -0.001662 14.6600n -0.001830 14.6700n -0.001986 14.6800n -0.002125 14.6900n -0.002246
+ 14.7000n -0.002345 14.7100n -0.002422 14.7200n -0.002473 14.7300n -0.002498 14.7400n -0.002496 14.7500n -0.002467 14.7600n -0.002412 14.7700n -0.002330 14.7800n -0.002223 14.7900n -0.002093 14.8000n -0.001942 14.8100n -0.001773 14.8200n -0.001587 14.8300n -0.001389 14.8400n -0.001181
+ 14.8500n -0.000967 14.8600n -0.000750 14.8700n -0.000534 14.8800n -0.000322 14.8900n -0.000117 14.9000n 0.000077 14.9100n 0.000258 14.9200n 0.000423 14.9300n 0.000570 14.9400n 0.000698 14.9500n 0.000804 14.9600n 0.000888 14.9700n 0.000950 14.9800n 0.000989 14.9900n 0.001005
+ 15.0000n 0.001000 15.0100n 0.000975 15.0200n 0.000931 15.0300n 0.000869 15.0400n 0.000793 15.0500n 0.000705 15.0600n 0.000606 15.0700n 0.000500 15.0800n 0.000390 15.0900n 0.000278 15.1000n 0.000167 15.1100n 0.000059 15.1200n -0.000042 15.1300n -0.000135 15.1400n -0.000218
+ 15.1500n -0.000289 15.1600n -0.000345 15.1700n -0.000387 15.1800n -0.000413 15.1900n -0.000423 15.2000n -0.000416 15.2100n -0.000393 15.2200n -0.000354 15.2300n -0.000300 15.2400n -0.000231 15.2500n -0.000150 15.2600n -0.000057 15.2700n 0.000046 15.2800n 0.000156 15.2900n 0.000273
+ 15.3000n 0.000394 15.3100n 0.000517 15.3200n 0.000640 15.3300n 0.000761 15.3400n 0.000878 15.3500n 0.000990 15.3600n 0.001094 15.3700n 0.001191 15.3800n 0.001277 15.3900n 0.001352 15.4000n 0.001416 15.4100n 0.001467 15.4200n 0.001506 15.4300n 0.001531 15.4400n 0.001542
+ 15.4500n 0.001541 15.4600n 0.001527 15.4700n 0.001501 15.4800n 0.001463 15.4900n 0.001414 15.5000n 0.001355 15.5100n 0.001287 15.5200n 0.001211 15.5300n 0.001128 15.5400n 0.001039 15.5500n 0.000945 15.5600n 0.000849 15.5700n 0.000749 15.5800n 0.000649 15.5900n 0.000549
+ 15.6000n 0.000449 15.6100n 0.000351 15.6200n 0.000257 15.6300n 0.000166 15.6400n 0.000079 15.6500n -0.000002 15.6600n -0.000078 15.6700n -0.000147 15.6800n -0.000209 15.6900n -0.000264 15.7000n -0.000312 15.7100n -0.000351 15.7200n -0.000383 15.7300n -0.000406 15.7400n -0.000421
+ 15.7500n -0.000428 15.7600n -0.000427 15.7700n -0.000418 15.7800n -0.000401 15.7900n -0.000377 15.8000n -0.000346 15.8100n -0.000309 15.8200n -0.000266 15.8300n -0.000218 15.8400n -0.000166 15.8500n -0.000109 15.8600n -0.000050 15.8700n 0.000012 15.8800n 0.000075 15.8900n 0.000139
+ 15.9000n 0.000203 15.9100n 0.000265 15.9200n 0.000326 15.9300n 0.000384 15.9400n 0.000438 15.9500n 0.000488 15.9600n 0.000533 15.9700n 0.000572 15.9800n 0.000606 15.9900n 0.000633 16.0000n 0.000653 16.0100n 0.000667 16.0200n 0.000674 16.0300n 0.000674 16.0400n 0.000667
+ 16.0500n 0.000655 16.0600n 0.000636 16.0700n 0.000612 16.0800n 0.000584 16.0900n 0.000551 16.1000n 0.000515 16.1100n 0.000477 16.1200n 0.000437 16.1300n 0.000397 16.1400n 0.000357 16.1500n 0.000318 16.1600n 0.000281 16.1700n 0.000246 16.1800n 0.000215 16.1900n 0.000188
+ 16.2000n 0.000164 16.2100n 0.000145 16.2200n 0.000131 16.2300n 0.000122 16.2400n 0.000117 16.2500n 0.000117 16.2600n 0.000121 16.2700n 0.000129 16.2800n 0.000139 16.2900n 0.000152 16.3000n 0.000167 16.3100n 0.000182 16.3200n 0.000198 16.3300n 0.000213 16.3400n 0.000226
+ 16.3500n 0.000236 16.3600n 0.000244 16.3700n 0.000248 16.3800n 0.000248 16.3900n 0.000243 16.4000n 0.000233 16.4100n 0.000219 16.4200n 0.000200 16.4300n 0.000176 16.4400n 0.000148 16.4500n 0.000116 16.4600n 0.000082 16.4700n 0.000045 16.4800n 0.000007 16.4900n -0.000031
+ 16.5000n -0.000068 16.5100n -0.000102 16.5200n -0.000134 16.5300n -0.000161 16.5400n -0.000183 16.5500n -0.000198 16.5600n -0.000206 16.5700n -0.000207 16.5800n -0.000198 16.5900n -0.000182 16.6000n -0.000156 16.6100n -0.000122 16.6200n -0.000080 16.6300n -0.000031 16.6400n 0.000025
+ 16.6500n 0.000087 16.6600n 0.000152 16.6700n 0.000221 16.6800n 0.000290 16.6900n 0.000358 16.7000n 0.000423 16.7100n 0.000484 16.7200n 0.000537 16.7300n 0.000582 16.7400n 0.000616 16.7500n 0.000637 16.7600n 0.000644 16.7700n 0.000636 16.7800n 0.000611 16.7900n 0.000569
+ 16.8000n 0.000508 16.8100n 0.000430 16.8200n 0.000333 16.8300n 0.000219 16.8400n 0.000088 16.8500n -0.000058 16.8600n -0.000218 16.8700n -0.000390 16.8800n -0.000571 16.8900n -0.000760 16.9000n -0.000953 16.9100n -0.001148 16.9200n -0.001341 16.9300n -0.001531 16.9400n -0.001713
+ 16.9500n -0.001885 16.9600n -0.002044 16.9700n -0.002187 16.9800n -0.002312 16.9900n -0.002418 17.0000n -0.002501 17.0100n -0.002561 17.0200n -0.002598 17.0300n -0.002609 17.0400n -0.002596 17.0500n -0.002558 17.0600n -0.002496 17.0700n -0.002413 17.0800n -0.002308 17.0900n -0.002185
+ 17.1000n -0.002045 17.1100n -0.001892 17.1200n -0.001728 17.1300n -0.001557 17.1400n -0.001381 17.1500n -0.001204 17.1600n -0.001029 17.1700n -0.000859 17.1800n -0.000698 17.1900n -0.000548 17.2000n -0.000412 17.2100n -0.000292 17.2200n -0.000190 17.2300n -0.000108 17.2400n -0.000046
+ 17.2500n -0.000006 17.2600n 0.000013 17.2700n 0.000010 17.2800n -0.000013 17.2900n -0.000055 17.3000n -0.000116 17.3100n -0.000193 17.3200n -0.000283 17.3300n -0.000385 17.3400n -0.000496 17.3500n -0.000612 17.3600n -0.000732 17.3700n -0.000851 17.3800n -0.000967 17.3900n -0.001077
+ 17.4000n -0.001179 17.4100n -0.001270 17.4200n -0.001348 17.4300n -0.001410 17.4400n -0.001456 17.4500n -0.001484 17.4600n -0.001494 17.4700n -0.001485 17.4800n -0.001457 17.4900n -0.001411 17.5000n -0.001347 17.5100n -0.001267 17.5200n -0.001172 17.5300n -0.001064 17.5400n -0.000945
+ 17.5500n -0.000817 17.5600n -0.000682 17.5700n -0.000543 17.5800n -0.000402 17.5900n -0.000262 17.6000n -0.000125 17.6100n 0.000007 17.6200n 0.000132 17.6300n 0.000248 17.6400n 0.000354 17.6500n 0.000449 17.6600n 0.000532 17.6700n 0.000602 17.6800n 0.000659 17.6900n 0.000704
+ 17.7000n 0.000736 17.7100n 0.000757 17.7200n 0.000767 17.7300n 0.000768 17.7400n 0.000761 17.7500n 0.000748 17.7600n 0.000729 17.7700n 0.000708 17.7800n 0.000685 17.7900n 0.000663 17.8000n 0.000642 17.8100n 0.000624 17.8200n 0.000610 17.8300n 0.000602 17.8400n 0.000600
+ 17.8500n 0.000604 17.8600n 0.000615 17.8700n 0.000633 17.8800n 0.000657 17.8900n 0.000686 17.9000n 0.000720 17.9100n 0.000758 17.9200n 0.000798 17.9300n 0.000839 17.9400n 0.000879 17.9500n 0.000917 17.9600n 0.000950 17.9700n 0.000978 17.9800n 0.000999 17.9900n 0.001010
+ 18.0000n 0.001011 18.0100n 0.001001 18.0200n 0.000979 18.0300n 0.000943 18.0400n 0.000894 18.0500n 0.000832 18.0600n 0.000757 18.0700n 0.000670 18.0800n 0.000570 18.0900n 0.000461 18.1000n 0.000342 18.1100n 0.000216 18.1200n 0.000084 18.1300n -0.000051 18.1400n -0.000187
+ 18.1500n -0.000322 18.1600n -0.000454 18.1700n -0.000580 18.1800n -0.000699 18.1900n -0.000808 18.2000n -0.000906 18.2100n -0.000990 18.2200n -0.001060 18.2300n -0.001114 18.2400n -0.001152 18.2500n -0.001174 18.2600n -0.001178 18.2700n -0.001166 18.2800n -0.001139 18.2900n -0.001096
+ 18.3000n -0.001039 18.3100n -0.000970 18.3200n -0.000891 18.3300n -0.000803 18.3400n -0.000708 18.3500n -0.000609 18.3600n -0.000508 18.3700n -0.000407 18.3800n -0.000308 18.3900n -0.000213 18.4000n -0.000125 18.4100n -0.000044 18.4200n 0.000027 18.4300n 0.000088 18.4400n 0.000137
+ 18.4500n 0.000175 18.4600n 0.000200 18.4700n 0.000213 18.4800n 0.000213 18.4900n 0.000202 18.5000n 0.000181 18.5100n 0.000151 18.5200n 0.000112 18.5300n 0.000067 18.5400n 0.000017 18.5500n -0.000037 18.5600n -0.000091 18.5700n -0.000145 18.5800n -0.000198 18.5900n -0.000247
+ 18.6000n -0.000291 18.6100n -0.000329 18.6200n -0.000360 18.6300n -0.000383 18.6400n -0.000398 18.6500n -0.000406 18.6600n -0.000405 18.6700n -0.000397 18.6800n -0.000382 18.6900n -0.000362 18.7000n -0.000338 18.7100n -0.000311 18.7200n -0.000283 18.7300n -0.000256 18.7400n -0.000232
+ 18.7500n -0.000213 18.7600n -0.000200 18.7700n -0.000195 18.7800n -0.000200 18.7900n -0.000217 18.8000n -0.000247 18.8100n -0.000291 18.8200n -0.000348 18.8300n -0.000421 18.8400n -0.000508 18.8500n -0.000610 18.8600n -0.000725 18.8700n -0.000853 18.8800n -0.000991 18.8900n -0.001138
+ 18.9000n -0.001292 18.9100n -0.001451 18.9200n -0.001611 18.9300n -0.001770 18.9400n -0.001925 18.9500n -0.002072 18.9600n -0.002210 18.9700n -0.002334 18.9800n -0.002443 18.9900n -0.002533 19.0000n -0.002601 19.0100n -0.002647 19.0200n -0.002667 19.0300n -0.002661 19.0400n -0.002628
+ 19.0500n -0.002566 19.0600n -0.002476 19.0700n -0.002358 19.0800n -0.002212 19.0900n -0.002040 19.1000n -0.001844 19.1100n -0.001625 19.1200n -0.001385 19.1300n -0.001128 19.1400n -0.000856 19.1500n -0.000572 19.1600n -0.000279 19.1700n 0.000019 19.1800n 0.000319 19.1900n 0.000617
+ 19.2000n 0.000911 19.2100n 0.001198 19.2200n 0.001473 19.2300n 0.001735 19.2400n 0.001981 19.2500n 0.002209 19.2600n 0.002418 19.2700n 0.002605 19.2800n 0.002769 19.2900n 0.002910 19.3000n 0.003026 19.3100n 0.003119 19.3200n 0.003188 19.3300n 0.003234 19.3400n 0.003256
+ 19.3500n 0.003257 19.3600n 0.003238 19.3700n 0.003198 19.3800n 0.003141 19.3900n 0.003068 19.4000n 0.002979 19.4100n 0.002877 19.4200n 0.002763 19.4300n 0.002639 19.4400n 0.002505 19.4500n 0.002364 19.4600n 0.002217 19.4700n 0.002064 19.4800n 0.001906 19.4900n 0.001746
+ 19.5000n 0.001582 19.5100n 0.001416 19.5200n 0.001249 19.5300n 0.001081 19.5400n 0.000913 19.5500n 0.000745 19.5600n 0.000577 19.5700n 0.000411 19.5800n 0.000246 19.5900n 0.000083 19.6000n -0.000077 19.6100n -0.000232 19.6200n -0.000384 19.6300n -0.000529 19.6400n -0.000668
+ 19.6500n -0.000799 19.6600n -0.000921 19.6700n -0.001032 19.6800n -0.001132 19.6900n -0.001218 19.7000n -0.001290 19.7100n -0.001346 19.7200n -0.001385 19.7300n -0.001406 19.7400n -0.001407 19.7500n -0.001389 19.7600n -0.001350 19.7700n -0.001291 19.7800n -0.001211 19.7900n -0.001110
+ 19.8000n -0.000990 19.8100n -0.000850 19.8200n -0.000693 19.8300n -0.000519 19.8400n -0.000330 19.8500n -0.000129 19.8600n 0.000083 19.8700n 0.000302 19.8800n 0.000526 19.8900n 0.000753 19.9000n 0.000979 19.9100n 0.001201 19.9200n 0.001417 19.9300n 0.001624 19.9400n 0.001818
+ 19.9500n 0.001998 19.9600n 0.002162 19.9700n 0.002306 19.9800n 0.002430 19.9900n 0.002533 20.0000n 0.002613 20.0100n 0.002669 20.0200n 0.002702 20.0300n 0.002713 20.0400n 0.002701 20.0500n 0.002667 20.0600n 0.002614 20.0700n 0.002543 20.0800n 0.002457 20.0900n 0.002357
+ 20.1000n 0.002246 20.1100n 0.002126 20.1200n 0.002001 20.1300n 0.001874 20.1400n 0.001746 20.1500n 0.001621 20.1600n 0.001501 20.1700n 0.001388 20.1800n 0.001284 20.1900n 0.001191 20.2000n 0.001110 20.2100n 0.001042 20.2200n 0.000987 20.2300n 0.000946 20.2400n 0.000918
+ 20.2500n 0.000902 20.2600n 0.000898 20.2700n 0.000904 20.2800n 0.000919 20.2900n 0.000940 20.3000n 0.000966 20.3100n 0.000993 20.3200n 0.001021 20.3300n 0.001046 20.3400n 0.001066 20.3500n 0.001079 20.3600n 0.001083 20.3700n 0.001076 20.3800n 0.001057 20.3900n 0.001025
+ 20.4000n 0.000979 20.4100n 0.000919 20.4200n 0.000844 20.4300n 0.000755 20.4400n 0.000653 20.4500n 0.000539 20.4600n 0.000415 20.4700n 0.000283 20.4800n 0.000145 20.4900n 0.000005 20.5000n -0.000137 20.5100n -0.000276 20.5200n -0.000409 20.5300n -0.000535 20.5400n -0.000649
+ 20.5500n -0.000749 20.5600n -0.000833 20.5700n -0.000899 20.5800n -0.000944 20.5900n -0.000968 20.6000n -0.000969 20.6100n -0.000947 20.6200n -0.000902 20.6300n -0.000834 20.6400n -0.000744 20.6500n -0.000634 20.6600n -0.000506 20.6700n -0.000362 20.6800n -0.000204 20.6900n -0.000036
+ 20.7000n 0.000138 20.7100n 0.000316 20.7200n 0.000494 20.7300n 0.000667 20.7400n 0.000834 20.7500n 0.000989 20.7600n 0.001130 20.7700n 0.001253 20.7800n 0.001357 20.7900n 0.001439 20.8000n 0.001496 20.8100n 0.001529 20.8200n 0.001536 20.8300n 0.001516 20.8400n 0.001471
+ 20.8500n 0.001401 20.8600n 0.001308 20.8700n 0.001194 20.8800n 0.001061 20.8900n 0.000912 20.9000n 0.000750 20.9100n 0.000579 20.9200n 0.000402 20.9300n 0.000223 20.9400n 0.000046 20.9500n -0.000126 20.9600n -0.000288 20.9700n -0.000438 20.9800n -0.000573 20.9900n -0.000689
+ 21.0000n -0.000785 21.0100n -0.000859 21.0200n -0.000910 21.0300n -0.000937 21.0400n -0.000940 21.0500n -0.000919 21.0600n -0.000876 21.0700n -0.000813 21.0800n -0.000730 21.0900n -0.000632 21.1000n -0.000520 21.1100n -0.000399 21.1200n -0.000271 21.1300n -0.000141 21.1400n -0.000012
+ 21.1500n 0.000113 21.1600n 0.000229 21.1700n 0.000332 21.1800n 0.000421 21.1900n 0.000492 21.2000n 0.000543 21.2100n 0.000571 21.2200n 0.000576 21.2300n 0.000556 21.2400n 0.000512 21.2500n 0.000443 21.2600n 0.000350 21.2700n 0.000236 21.2800n 0.000101 21.2900n -0.000050
+ 21.3000n -0.000216 21.3100n -0.000393 21.3200n -0.000577 21.3300n -0.000765 21.3400n -0.000952 21.3500n -0.001134 21.3600n -0.001308 21.3700n -0.001468 21.3800n -0.001613 21.3900n -0.001737 21.4000n -0.001840 21.4100n -0.001917 21.4200n -0.001967 21.4300n -0.001988 21.4400n -0.001980
+ 21.4500n -0.001943 21.4600n -0.001876 21.4700n -0.001782 21.4800n -0.001661 21.4900n -0.001516 21.5000n -0.001349 21.5100n -0.001165 21.5200n -0.000966 21.5300n -0.000756 21.5400n -0.000539 21.5500n -0.000320 21.5600n -0.000104 21.5700n 0.000107 21.5800n 0.000306 21.5900n 0.000492
+ 21.6000n 0.000659 21.6100n 0.000805 21.6200n 0.000928 21.6300n 0.001024 21.6400n 0.001092 21.6500n 0.001131 21.6600n 0.001140 21.6700n 0.001121 21.6800n 0.001073 21.6900n 0.000998 21.7000n 0.000898 21.7100n 0.000775 21.7200n 0.000633 21.7300n 0.000475 21.7400n 0.000305
+ 21.7500n 0.000126 21.7600n -0.000058 21.7700n -0.000241 21.7800n -0.000420 21.7900n -0.000591 21.8000n -0.000750 21.8100n -0.000892 21.8200n -0.001016 21.8300n -0.001118 21.8400n -0.001195 21.8500n -0.001245 21.8600n -0.001268 21.8700n -0.001263 21.8800n -0.001229 21.8900n -0.001166
+ 21.9000n -0.001076 21.9100n -0.000960 21.9200n -0.000821 21.9300n -0.000660 21.9400n -0.000482 21.9500n -0.000288 21.9600n -0.000082 21.9700n 0.000131 21.9800n 0.000349 21.9900n 0.000566 22.0000n 0.000779 22.0100n 0.000985 22.0200n 0.001180 22.0300n 0.001360 22.0400n 0.001523
+ 22.0500n 0.001666 22.0600n 0.001787 22.0700n 0.001883 22.0800n 0.001955 22.0900n 0.002000 22.1000n 0.002019 22.1100n 0.002012 22.1200n 0.001980 22.1300n 0.001923 22.1400n 0.001843 22.1500n 0.001742 22.1600n 0.001623 22.1700n 0.001487 22.1800n 0.001337 22.1900n 0.001177
+ 22.2000n 0.001009 22.2100n 0.000835 22.2200n 0.000660 22.2300n 0.000485 22.2400n 0.000314 22.2500n 0.000148 22.2600n -0.000009 22.2700n -0.000156 22.2800n -0.000292 22.2900n -0.000414 22.3000n -0.000523 22.3100n -0.000616 22.3200n -0.000694 22.3300n -0.000757 22.3400n -0.000804
+ 22.3500n -0.000837 22.3600n -0.000856 22.3700n -0.000862 22.3800n -0.000857 22.3900n -0.000841 22.4000n -0.000815 22.4100n -0.000782 22.4200n -0.000743 22.4300n -0.000699 22.4400n -0.000652 22.4500n -0.000604 22.4600n -0.000554 22.4700n -0.000505 22.4800n -0.000458 22.4900n -0.000413
+ 22.5000n -0.000371 22.5100n -0.000332 22.5200n -0.000298 22.5300n -0.000268 22.5400n -0.000242 22.5500n -0.000220 22.5600n -0.000202 22.5700n -0.000188 22.5800n -0.000178 22.5900n -0.000170 22.6000n -0.000165 22.6100n -0.000162 22.6200n -0.000161 22.6300n -0.000161 22.6400n -0.000162
+ 22.6500n -0.000164 22.6600n -0.000166 22.6700n -0.000168 22.6800n -0.000170 22.6900n -0.000173 22.7000n -0.000176 22.7100n -0.000179 22.7200n -0.000182 22.7300n -0.000187 22.7400n -0.000192 22.7500n -0.000198 22.7600n -0.000206 22.7700n -0.000216 22.7800n -0.000227 22.7900n -0.000241
+ 22.8000n -0.000257 22.8100n -0.000274 22.8200n -0.000295 22.8300n -0.000317 22.8400n -0.000340 22.8500n -0.000366 22.8600n -0.000392 22.8700n -0.000419 22.8800n -0.000446 22.8900n -0.000472 22.9000n -0.000497 22.9100n -0.000520 22.9200n -0.000540 22.9300n -0.000557 22.9400n -0.000570
+ 22.9500n -0.000579 22.9600n -0.000582 22.9700n -0.000581 22.9800n -0.000573 22.9900n -0.000559 23.0000n -0.000540 23.0100n -0.000514 23.0200n -0.000483 23.0300n -0.000446 23.0400n -0.000404 23.0500n -0.000359 23.0600n -0.000310 23.0700n -0.000258 23.0800n -0.000205 23.0900n -0.000151
+ 23.1000n -0.000098 23.1100n -0.000046 23.1200n 0.000003 23.1300n 0.000048 23.1400n 0.000088 23.1500n 0.000122 23.1600n 0.000149 23.1700n 0.000170 23.1800n 0.000182 23.1900n 0.000185 23.2000n 0.000180 23.2100n 0.000167 23.2200n 0.000144 23.2300n 0.000113 23.2400n 0.000074
+ 23.2500n 0.000028 23.2600n -0.000026 23.2700n -0.000085 23.2800n -0.000149 23.2900n -0.000217 23.3000n -0.000288 23.3100n -0.000361 23.3200n -0.000435 23.3300n -0.000509 23.3400n -0.000581 23.3500n -0.000651 23.3600n -0.000718 23.3700n -0.000781 23.3800n -0.000841 23.3900n -0.000896
+ 23.4000n -0.000946 23.4100n -0.000991 23.4200n -0.001033 23.4300n -0.001070 23.4400n -0.001103 23.4500n -0.001134 23.4600n -0.001162 23.4700n -0.001189 23.4800n -0.001215 23.4900n -0.001242 23.5000n -0.001271 23.5100n -0.001301 23.5200n -0.001335 23.5300n -0.001374 23.5400n -0.001416
+ 23.5500n -0.001464 23.5600n -0.001518 23.5700n -0.001577 23.5800n -0.001642 23.5900n -0.001712 23.6000n -0.001787 23.6100n -0.001866 23.6200n -0.001948 23.6300n -0.002032 23.6400n -0.002117 23.6500n -0.002201 23.6600n -0.002281 23.6700n -0.002358 23.6800n -0.002428 23.6900n -0.002490
+ 23.7000n -0.002541 23.7100n -0.002581 23.7200n -0.002607 23.7300n -0.002618 23.7400n -0.002612 23.7500n -0.002588 23.7600n -0.002545 23.7700n -0.002482 23.7800n -0.002400 23.7900n -0.002297 23.8000n -0.002175 23.8100n -0.002033 23.8200n -0.001873 23.8300n -0.001697 23.8400n -0.001505
+ 23.8500n -0.001299 23.8600n -0.001082 23.8700n -0.000856 23.8800n -0.000623 23.8900n -0.000387 23.9000n -0.000149 23.9100n 0.000086 23.9200n 0.000317 23.9300n 0.000541 23.9400n 0.000754 23.9500n 0.000955 23.9600n 0.001140 23.9700n 0.001309 23.9800n 0.001458 23.9900n 0.001587
+ 24.0000n 0.001695 24.0100n 0.001779 24.0200n 0.001841 24.0300n 0.001879 24.0400n 0.001894 24.0500n 0.001886 24.0600n 0.001857 24.0700n 0.001807 24.0800n 0.001737 24.0900n 0.001651 24.1000n 0.001548 24.1100n 0.001432 24.1200n 0.001304 24.1300n 0.001167 24.1400n 0.001023
+ 24.1500n 0.000875 24.1600n 0.000724 24.1700n 0.000573 24.1800n 0.000423 24.1900n 0.000278 24.2000n 0.000137 24.2100n 0.000004 24.2200n -0.000121 24.2300n -0.000237 24.2400n -0.000343 24.2500n -0.000439 24.2600n -0.000523 24.2700n -0.000596 24.2800n -0.000658 24.2900n -0.000709
+ 24.3000n -0.000749 24.3100n -0.000779 24.3200n -0.000800 24.3300n -0.000813 24.3400n -0.000817 24.3500n -0.000815 24.3600n -0.000806 24.3700n -0.000792 24.3800n -0.000773 24.3900n -0.000750 24.4000n -0.000724 24.4100n -0.000696 24.4200n -0.000665 24.4300n -0.000632 24.4400n -0.000598
+ 24.4500n -0.000563 24.4600n -0.000526 24.4700n -0.000489 24.4800n -0.000450 24.4900n -0.000411 24.5000n -0.000370 24.5100n -0.000329 24.5200n -0.000287 24.5300n -0.000244 24.5400n -0.000201 24.5500n -0.000157 24.5600n -0.000113 24.5700n -0.000069 24.5800n -0.000025 24.5900n 0.000017
+ 24.6000n 0.000057 24.6100n 0.000095 24.6200n 0.000129 24.6300n 0.000159 24.6400n 0.000185 24.6500n 0.000204 24.6600n 0.000217 24.6700n 0.000222 24.6800n 0.000218 24.6900n 0.000206 24.7000n 0.000184 24.7100n 0.000153 24.7200n 0.000111 24.7300n 0.000059 24.7400n -0.000003
+ 24.7500n -0.000075 24.7600n -0.000155 24.7700n -0.000244 24.7800n -0.000340 24.7900n -0.000441 24.8000n -0.000547 24.8100n -0.000655 24.8200n -0.000763 24.8300n -0.000870 24.8400n -0.000973 24.8500n -0.001071 24.8600n -0.001161 24.8700n -0.001240 24.8800n -0.001307 24.8900n -0.001360
+ 24.9000n -0.001397 24.9100n -0.001416 24.9200n -0.001415 24.9300n -0.001395 24.9400n -0.001353 24.9500n -0.001289 24.9600n -0.001204 24.9700n -0.001098 24.9800n -0.000971 24.9900n -0.000823 25.0000n -0.000658 25.0100n -0.000475 25.0200n -0.000278 25.0300n -0.000069 25.0400n 0.000150
+ 25.0500n 0.000376 25.0600n 0.000606 25.0700n 0.000837 25.0800n 0.001066 25.0900n 0.001288 25.1000n 0.001503 25.1100n 0.001705 25.1200n 0.001893 25.1300n 0.002064 25.1400n 0.002216 25.1500n 0.002346 25.1600n 0.002452 25.1700n 0.002534 25.1800n 0.002591 25.1900n 0.002622
+ 25.2000n 0.002627 25.2100n 0.002606 25.2200n 0.002560 25.2300n 0.002491 25.2400n 0.002399 25.2500n 0.002287 25.2600n 0.002158 25.2700n 0.002013 25.2800n 0.001855 25.2900n 0.001687 25.3000n 0.001512 25.3100n 0.001334 25.3200n 0.001154 25.3300n 0.000977 25.3400n 0.000805
+ 25.3500n 0.000641 25.3600n 0.000488 25.3700n 0.000347 25.3800n 0.000220 25.3900n 0.000110 25.4000n 0.000018 25.4100n -0.000055 25.4200n -0.000109 25.4300n -0.000143 25.4400n -0.000157 25.4500n -0.000151 25.4600n -0.000127 25.4700n -0.000085 25.4800n -0.000027 25.4900n 0.000047
+ 25.5000n 0.000134 25.5100n 0.000232 25.5200n 0.000340 25.5300n 0.000456 25.5400n 0.000577 25.5500n 0.000702 25.5600n 0.000829 25.5700n 0.000955 25.5800n 0.001079 25.5900n 0.001198 25.6000n 0.001313 25.6100n 0.001420 25.6200n 0.001520 25.6300n 0.001610 25.6400n 0.001691
+ 25.6500n 0.001761 25.6600n 0.001821 25.6700n 0.001869 25.6800n 0.001907 25.6900n 0.001933 25.7000n 0.001949 25.7100n 0.001955 25.7200n 0.001951 25.7300n 0.001938 25.7400n 0.001916 25.7500n 0.001887 25.7600n 0.001850 25.7700n 0.001806 25.7800n 0.001757 25.7900n 0.001703
+ 25.8000n 0.001644 25.8100n 0.001582 25.8200n 0.001516 25.8300n 0.001448 25.8400n 0.001377 25.8500n 0.001305 25.8600n 0.001232 25.8700n 0.001158 25.8800n 0.001083 25.8900n 0.001009 25.9000n 0.000935 25.9100n 0.000862 25.9200n 0.000791 25.9300n 0.000721 25.9400n 0.000653
+ 25.9500n 0.000588 25.9600n 0.000526 25.9700n 0.000468 25.9800n 0.000413 25.9900n 0.000363 26.0000n 0.000318 26.0100n 0.000279 26.0200n 0.000245 26.0300n 0.000217 26.0400n 0.000196 26.0500n 0.000180 26.0600n 0.000172 26.0700n 0.000170 26.0800n 0.000174 26.0900n 0.000184
+ 26.1000n 0.000200 26.1100n 0.000221 26.1200n 0.000247 26.1300n 0.000276 26.1400n 0.000307 26.1500n 0.000341 26.1600n 0.000375 26.1700n 0.000408 26.1800n 0.000440 26.1900n 0.000469 26.2000n 0.000494 26.2100n 0.000513 26.2200n 0.000526 26.2300n 0.000532 26.2400n 0.000530
+ 26.2500n 0.000520 26.2600n 0.000500 26.2700n 0.000472 26.2800n 0.000434 26.2900n 0.000387 26.3000n 0.000332 26.3100n 0.000270 26.3200n 0.000202 26.3300n 0.000129 26.3400n 0.000052 26.3500n -0.000025 26.3600n -0.000103 26.3700n -0.000177 26.3800n -0.000247 26.3900n -0.000309
+ 26.4000n -0.000362 26.4100n -0.000403 26.4200n -0.000430 26.4300n -0.000441 26.4400n -0.000435 26.4500n -0.000409 26.4600n -0.000362 26.4700n -0.000294 26.4800n -0.000204 26.4900n -0.000093 26.5000n 0.000040 26.5100n 0.000194 26.5200n 0.000367 26.5300n 0.000558 26.5400n 0.000764
+ 26.5500n 0.000984 26.5600n 0.001212 26.5700n 0.001448 26.5800n 0.001686 26.5900n 0.001924 26.6000n 0.002157 26.6100n 0.002381 26.6200n 0.002593 26.6300n 0.002788 26.6400n 0.002962 26.6500n 0.003113 26.6600n 0.003237 26.6700n 0.003332 26.6800n 0.003394 26.6900n 0.003422
+ 26.7000n 0.003416 26.7100n 0.003374 26.7200n 0.003296 26.7300n 0.003184 26.7400n 0.003037 26.7500n 0.002859 26.7600n 0.002652 26.7700n 0.002418 26.7800n 0.002162 26.7900n 0.001888 26.8000n 0.001599 26.8100n 0.001301 26.8200n 0.000998 26.8300n 0.000696 26.8400n 0.000399
+ 26.8500n 0.000113 26.8600n -0.000159 26.8700n -0.000410 26.8800n -0.000638 26.8900n -0.000839 26.9000n -0.001009 26.9100n -0.001146 26.9200n -0.001248 26.9300n -0.001315 26.9400n -0.001344 26.9500n -0.001338 26.9600n -0.001297 26.9700n -0.001222 26.9800n -0.001115 26.9900n -0.000981
+ 27.0000n -0.000822 27.0100n -0.000643 27.0200n -0.000448 27.0300n -0.000241 27.0400n -0.000028 27.0500n 0.000186 27.0600n 0.000396 27.0700n 0.000598 27.0800n 0.000786 27.0900n 0.000956 27.1000n 0.001103 27.1100n 0.001226 27.1200n 0.001319 27.1300n 0.001382 27.1400n 0.001412
+ 27.1500n 0.001408 27.1600n 0.001371 27.1700n 0.001300 27.1800n 0.001198 27.1900n 0.001065 27.2000n 0.000905 27.2100n 0.000720 27.2200n 0.000516 27.2300n 0.000294 27.2400n 0.000061 27.2500n -0.000179 27.2600n -0.000421 27.2700n -0.000660 27.2800n -0.000891 27.2900n -0.001109
+ 27.3000n -0.001310 27.3100n -0.001489 27.3200n -0.001643 27.3300n -0.001768 27.3400n -0.001863 27.3500n -0.001924 27.3600n -0.001951 27.3700n -0.001943 27.3800n -0.001901 27.3900n -0.001824 27.4000n -0.001715 27.4100n -0.001576 27.4200n -0.001410 27.4300n -0.001220 27.4400n -0.001009
+ 27.4500n -0.000783 27.4600n -0.000545 27.4700n -0.000300 27.4800n -0.000053 27.4900n 0.000192 27.5000n 0.000429 27.5100n 0.000655 27.5200n 0.000865 27.5300n 0.001055 27.5400n 0.001223 27.5500n 0.001365 27.5600n 0.001480 27.5700n 0.001565 27.5800n 0.001621 27.5900n 0.001646
+ 27.6000n 0.001640 27.6100n 0.001606 27.6200n 0.001545 27.6300n 0.001458 27.6400n 0.001348 27.6500n 0.001219 27.6600n 0.001074 27.6700n 0.000916 27.6800n 0.000749 27.6900n 0.000578 27.7000n 0.000406 27.7100n 0.000236 27.7200n 0.000074 27.7300n -0.000079 27.7400n -0.000218
+ 27.7500n -0.000341 27.7600n -0.000446 27.7700n -0.000531 27.7800n -0.000595 27.7900n -0.000636 27.8000n -0.000655 27.8100n -0.000651 27.8200n -0.000626 27.8300n -0.000581 27.8400n -0.000518 27.8500n -0.000438 27.8600n -0.000344 27.8700n -0.000239 27.8800n -0.000125 27.8900n -0.000006
+ 27.9000n 0.000116 27.9100n 0.000238 27.9200n 0.000356 27.9300n 0.000468 27.9400n 0.000571 27.9500n 0.000664 27.9600n 0.000744 27.9700n 0.000811 27.9800n 0.000862 27.9900n 0.000897 28.0000n 0.000916 28.0100n 0.000918 28.0200n 0.000906 28.0300n 0.000878 28.0400n 0.000838
+ 28.0500n 0.000785 28.0600n 0.000722 28.0700n 0.000651 28.0800n 0.000574 28.0900n 0.000492 28.1000n 0.000409 28.1100n 0.000326 28.1200n 0.000246 28.1300n 0.000169 28.1400n 0.000098 28.1500n 0.000034 28.1600n -0.000021 28.1700n -0.000067 28.1800n -0.000104 28.1900n -0.000131
+ 28.2000n -0.000149 28.2100n -0.000158 28.2200n -0.000158 28.2300n -0.000152 28.2400n -0.000139 28.2500n -0.000122 28.2600n -0.000103 28.2700n -0.000082 28.2800n -0.000062 28.2900n -0.000044 28.3000n -0.000030 28.3100n -0.000022 28.3200n -0.000020 28.3300n -0.000027 28.3400n -0.000042
+ 28.3500n -0.000067 28.3600n -0.000102 28.3700n -0.000146 28.3800n -0.000199 28.3900n -0.000260 28.4000n -0.000329 28.4100n -0.000404 28.4200n -0.000483 28.4300n -0.000565 28.4400n -0.000647 28.4500n -0.000728 28.4600n -0.000805 28.4700n -0.000876 28.4800n -0.000938 28.4900n -0.000991
+ 28.5000n -0.001031 28.5100n -0.001057 28.5200n -0.001068 28.5300n -0.001062 28.5400n -0.001039 28.5500n -0.000998 28.5600n -0.000940 28.5700n -0.000864 28.5800n -0.000771 28.5900n -0.000663 28.6000n -0.000542 28.6100n -0.000408 28.6200n -0.000264 28.6300n -0.000114 28.6400n 0.000042
+ 28.6500n 0.000199 28.6600n 0.000355 28.6700n 0.000507 28.6800n 0.000652 28.6900n 0.000788 28.7000n 0.000911 28.7100n 0.001019 28.7200n 0.001111 28.7300n 0.001185 28.7400n 0.001238 28.7500n 0.001271 28.7600n 0.001283 28.7700n 0.001273 28.7800n 0.001243 28.7900n 0.001193
+ 28.8000n 0.001124 28.8100n 0.001038 28.8200n 0.000938 28.8300n 0.000825 28.8400n 0.000702 28.8500n 0.000572 28.8600n 0.000439 28.8700n 0.000305 28.8800n 0.000173 28.8900n 0.000046 28.9000n -0.000073 28.9100n -0.000181 28.9200n -0.000276 28.9300n -0.000356 28.9400n -0.000419
+ 28.9500n -0.000464 28.9600n -0.000490 28.9700n -0.000497 28.9800n -0.000485 28.9900n -0.000454 29.0000n -0.000406 29.0100n -0.000341 29.0200n -0.000262 29.0300n -0.000171 29.0400n -0.000069 29.0500n 0.000039 29.0600n 0.000152 29.0700n 0.000266 29.0800n 0.000379 29.0900n 0.000488
+ 29.1000n 0.000589 29.1100n 0.000681 29.1200n 0.000761 29.1300n 0.000827 29.1400n 0.000877 29.1500n 0.000910 29.1600n 0.000926 29.1700n 0.000923 29.1800n 0.000903 29.1900n 0.000865 29.2000n 0.000810 29.2100n 0.000741 29.2200n 0.000658 29.2300n 0.000564 29.2400n 0.000462
+ 29.2500n 0.000354 29.2600n 0.000242 29.2700n 0.000131 29.2800n 0.000023 29.2900n -0.000078 29.3000n -0.000171 29.3100n -0.000252 29.3200n -0.000318 29.3300n -0.000368 29.3400n -0.000400 29.3500n -0.000411 29.3600n -0.000402 29.3700n -0.000371 29.3800n -0.000319 29.3900n -0.000246
+ 29.4000n -0.000152 29.4100n -0.000039 29.4200n 0.000090 29.4300n 0.000235 29.4400n 0.000392 29.4500n 0.000558 29.4600n 0.000731 29.4700n 0.000907 29.4800n 0.001084 29.4900n 0.001256 29.5000n 0.001422 29.5100n 0.001578 29.5200n 0.001722 29.5300n 0.001849 29.5400n 0.001958
+ 29.5500n 0.002047 29.5600n 0.002113 29.5700n 0.002157 29.5800n 0.002176 29.5900n 0.002170 29.6000n 0.002140 29.6100n 0.002087 29.6200n 0.002010 29.6300n 0.001912 29.6400n 0.001794 29.6500n 0.001658 29.6600n 0.001507 29.6700n 0.001344 29.6800n 0.001170 29.6900n 0.000990
+ 29.7000n 0.000806 29.7100n 0.000620 29.7200n 0.000435 29.7300n 0.000255 29.7400n 0.000081 29.7500n -0.000085 29.7600n -0.000240 29.7700n -0.000384 29.7800n -0.000516 29.7900n -0.000634 29.8000n -0.000739 29.8100n -0.000831 29.8200n -0.000910 29.8300n -0.000977 29.8400n -0.001033
+ 29.8500n -0.001080 29.8600n -0.001120 29.8700n -0.001154 29.8800n -0.001185 29.8900n -0.001214 29.9000n -0.001244 29.9100n -0.001276 29.9200n -0.001313 29.9300n -0.001356 29.9400n -0.001407 29.9500n -0.001468 29.9600n -0.001538 29.9700n -0.001618 29.9800n -0.001709 29.9900n -0.001811
+ 30.0000n -0.001922 30.0100n -0.002042 30.0200n -0.002169 30.0300n -0.002301 30.0400n -0.002437 30.0500n -0.002574 30.0600n -0.002710 30.0700n -0.002840 30.0800n -0.002963 30.0900n -0.003076 30.1000n -0.003175 30.1100n -0.003257 30.1200n -0.003319 30.1300n -0.003359 30.1400n -0.003374
+ 30.1500n -0.003362 30.1600n -0.003321 30.1700n -0.003251 30.1800n -0.003149 30.1900n -0.003015 30.2000n -0.002850 30.2100n -0.002654 30.2200n -0.002427 30.2300n -0.002173 30.2400n -0.001891 30.2500n -0.001586 30.2600n -0.001260 30.2700n -0.000916 30.2800n -0.000557 30.2900n -0.000188
+ 30.3000n 0.000187 30.3100n 0.000565 30.3200n 0.000940 30.3300n 0.001308 30.3400n 0.001666 30.3500n 0.002008 30.3600n 0.002331 30.3700n 0.002632 30.3800n 0.002906 30.3900n 0.003150 30.4000n 0.003362 30.4100n 0.003539 30.4200n 0.003679 30.4300n 0.003782 30.4400n 0.003846
+ 30.4500n 0.003870 30.4600n 0.003855 30.4700n 0.003801 30.4800n 0.003710 30.4900n 0.003583 30.5000n 0.003421 30.5100n 0.003228 30.5200n 0.003005 30.5300n 0.002756 30.5400n 0.002485 30.5500n 0.002194 30.5600n 0.001887 30.5700n 0.001568 30.5800n 0.001242 30.5900n 0.000911
+ 30.6000n 0.000581 30.6100n 0.000254 30.6200n -0.000066 30.6300n -0.000375 30.6400n -0.000669 30.6500n -0.000946 30.6600n -0.001203 30.6700n -0.001437 30.6800n -0.001645 30.6900n -0.001826 30.7000n -0.001979 30.7100n -0.002101 30.7200n -0.002192 30.7300n -0.002251 30.7400n -0.002278
+ 30.7500n -0.002273 30.7600n -0.002237 30.7700n -0.002171 30.7800n -0.002074 30.7900n -0.001950 30.8000n -0.001799 30.8100n -0.001623 30.8200n -0.001425 30.8300n -0.001207 30.8400n -0.000972 30.8500n -0.000722 30.8600n -0.000460 30.8700n -0.000189 30.8800n 0.000088 30.8900n 0.000367
+ 30.9000n 0.000647 30.9100n 0.000923 30.9200n 0.001193 30.9300n 0.001454 30.9400n 0.001704 30.9500n 0.001940 30.9600n 0.002160 30.9700n 0.002361 30.9800n 0.002542 30.9900n 0.002701 31.0000n 0.002837 31.0100n 0.002950 31.0200n 0.003038 31.0300n 0.003102 31.0400n 0.003140
+ 31.0500n 0.003155 31.0600n 0.003146 31.0700n 0.003114 31.0800n 0.003062 31.0900n 0.002989 31.1000n 0.002899 31.1100n 0.002794 31.1200n 0.002675 31.1300n 0.002545 31.1400n 0.002407 31.1500n 0.002262 31.1600n 0.002115 31.1700n 0.001967 31.1800n 0.001821 31.1900n 0.001679
+ 31.2000n 0.001544 31.2100n 0.001418 31.2200n 0.001302 31.2300n 0.001198 31.2400n 0.001108 31.2500n 0.001032 31.2600n 0.000971 31.2700n 0.000925 31.2800n 0.000895 31.2900n 0.000879 31.3000n 0.000878 31.3100n 0.000890 31.3200n 0.000914 31.3300n 0.000948 31.3400n 0.000990
+ 31.3500n 0.001039 31.3600n 0.001092 31.3700n 0.001147 31.3800n 0.001202 31.3900n 0.001254 31.4000n 0.001301 31.4100n 0.001341 31.4200n 0.001372 31.4300n 0.001392 31.4400n 0.001400 31.4500n 0.001393 31.4600n 0.001371 31.4700n 0.001334 31.4800n 0.001280 31.4900n 0.001211
+ 31.5000n 0.001125 31.5100n 0.001024 31.5200n 0.000909 31.5300n 0.000781 31.5400n 0.000641 31.5500n 0.000493 31.5600n 0.000337 31.5700n 0.000176 31.5800n 0.000012 31.5900n -0.000152 31.6000n -0.000314 31.6100n -0.000470 31.6200n -0.000620 31.6300n -0.000759 31.6400n -0.000887
+ 31.6500n -0.001002 31.6600n -0.001101 31.6700n -0.001184 31.6800n -0.001249 31.6900n -0.001295 31.7000n -0.001323 31.7100n -0.001332 31.7200n -0.001322 31.7300n -0.001295 31.7400n -0.001251 31.7500n -0.001191 31.7600n -0.001118 31.7700n -0.001032 31.7800n -0.000935 31.7900n -0.000831
+ 31.8000n -0.000720 31.8100n -0.000606 31.8200n -0.000490 31.8300n -0.000374 31.8400n -0.000261 31.8500n -0.000153 31.8600n -0.000050 31.8700n 0.000045 31.8800n 0.000131 31.8900n 0.000207 31.9000n 0.000273 31.9100n 0.000328 31.9200n 0.000373 31.9300n 0.000406 31.9400n 0.000429
+ 31.9500n 0.000443 31.9600n 0.000447 31.9700n 0.000445 31.9800n 0.000436 31.9900n 0.000421 32.0000n 0.000404 32.0100n 0.000384 32.0200n 0.000363 32.0300n 0.000343 32.0400n 0.000324 32.0500n 0.000309 32.0600n 0.000297 32.0700n 0.000290 32.0800n 0.000287 32.0900n 0.000289
+ 32.1000n 0.000297 32.1100n 0.000309 32.1200n 0.000325 32.1300n 0.000345 32.1400n 0.000366 32.1500n 0.000389 32.1600n 0.000412 32.1700n 0.000433 32.1800n 0.000451 32.1900n 0.000464 32.2000n 0.000471 32.2100n 0.000470 32.2200n 0.000460 32.2300n 0.000440 32.2400n 0.000409
+ 32.2500n 0.000366 32.2600n 0.000311 32.2700n 0.000243 32.2800n 0.000163 32.2900n 0.000072 32.3000n -0.000031 32.3100n -0.000143 32.3200n -0.000263 32.3300n -0.000390 32.3400n -0.000521 32.3500n -0.000654 32.3600n -0.000787 32.3700n -0.000917 32.3800n -0.001041 32.3900n -0.001156
+ 32.4000n -0.001261 32.4100n -0.001352 32.4200n -0.001428 32.4300n -0.001485 32.4400n -0.001522 32.4500n -0.001538 32.4600n -0.001531 32.4700n -0.001501 32.4800n -0.001446 32.4900n -0.001368 32.5000n -0.001265 32.5100n -0.001141 32.5200n -0.000995 32.5300n -0.000829 32.5400n -0.000646
+ 32.5500n -0.000448 32.5600n -0.000238 32.5700n -0.000019 32.5800n 0.000206 32.5900n 0.000434 32.6000n 0.000661 32.6100n 0.000883 32.6200n 0.001099 32.6300n 0.001303 32.6400n 0.001494 32.6500n 0.001668 32.6600n 0.001824 32.6700n 0.001959 32.6800n 0.002072 32.6900n 0.002161
+ 32.7000n 0.002226 32.7100n 0.002266 32.7200n 0.002282 32.7300n 0.002274 32.7400n 0.002244 32.7500n 0.002191 32.7600n 0.002120 32.7700n 0.002031 32.7800n 0.001926 32.7900n 0.001810 32.8000n 0.001683 32.8100n 0.001549 32.8200n 0.001411 32.8300n 0.001272 32.8400n 0.001133
+ 32.8500n 0.000999 32.8600n 0.000870 32.8700n 0.000749 32.8800n 0.000638 32.8900n 0.000538 32.9000n 0.000450 32.9100n 0.000375 32.9200n 0.000313 32.9300n 0.000263 32.9400n 0.000226 32.9500n 0.000201 32.9600n 0.000187 32.9700n 0.000182 32.9800n 0.000185 32.9900n 0.000194
+ 33.0000n 0.000208 33.0100n 0.000225 33.0200n 0.000242 33.0300n 0.000259 33.0400n 0.000274 33.0500n 0.000285 33.0600n 0.000291 33.0700n 0.000292 33.0800n 0.000286 33.0900n 0.000273 33.1000n 0.000253 33.1100n 0.000227 33.1200n 0.000195 33.1300n 0.000158 33.1400n 0.000117
+ 33.1500n 0.000074 33.1600n 0.000030 33.1700n -0.000012 33.1800n -0.000051 33.1900n -0.000085 33.2000n -0.000112 33.2100n -0.000129 33.2200n -0.000135 33.2300n -0.000129 33.2400n -0.000108 33.2500n -0.000072 33.2600n -0.000019 33.2700n 0.000050 33.2800n 0.000136 33.2900n 0.000239
+ 33.3000n 0.000357 33.3100n 0.000490 33.3200n 0.000637 33.3300n 0.000794 33.3400n 0.000960 33.3500n 0.001133 33.3600n 0.001309 33.3700n 0.001486 33.3800n 0.001659 33.3900n 0.001827 33.4000n 0.001985 33.4100n 0.002131 33.4200n 0.002262 33.4300n 0.002374 33.4400n 0.002465
+ 33.4500n 0.002533 33.4600n 0.002577 33.4700n 0.002594 33.4800n 0.002585 33.4900n 0.002548 33.5000n 0.002484 33.5100n 0.002393 33.5200n 0.002278 33.5300n 0.002139 33.5400n 0.001980 33.5500n 0.001802 33.5600n 0.001609 33.5700n 0.001404 33.5800n 0.001192 33.5900n 0.000975
+ 33.6000n 0.000759 33.6100n 0.000546 33.6200n 0.000342 33.6300n 0.000150 33.6400n -0.000026 33.6500n -0.000184 33.6600n -0.000319 33.6700n -0.000429 33.6800n -0.000512 33.6900n -0.000567 33.7000n -0.000592 33.7100n -0.000587 33.7200n -0.000552 33.7300n -0.000487 33.7400n -0.000394
+ 33.7500n -0.000275 33.7600n -0.000131 33.7700n 0.000034 33.7800n 0.000217 33.7900n 0.000415 33.8000n 0.000625 33.8100n 0.000842 33.8200n 0.001062 33.8300n 0.001282 33.8400n 0.001496 33.8500n 0.001703 33.8600n 0.001897 33.8700n 0.002076 33.8800n 0.002236 33.8900n 0.002375
+ 33.9000n 0.002491 33.9100n 0.002582 33.9200n 0.002647 33.9300n 0.002685 33.9400n 0.002696 33.9500n 0.002681 33.9600n 0.002639 33.9700n 0.002573 33.9800n 0.002484 33.9900n 0.002374 34.0000n 0.002246 34.0100n 0.002102 34.0200n 0.001944 34.0300n 0.001777 34.0400n 0.001603
+ 34.0500n 0.001424 34.0600n 0.001244 34.0700n 0.001066 34.0800n 0.000892 34.0900n 0.000724 34.1000n 0.000566 34.1100n 0.000418 34.1200n 0.000281 34.1300n 0.000158 34.1400n 0.000049 34.1500n -0.000046 34.1600n -0.000127 34.1700n -0.000193 34.1800n -0.000246 34.1900n -0.000287
+ 34.2000n -0.000315 34.2100n -0.000334 34.2200n -0.000343 34.2300n -0.000344 34.2400n -0.000340 34.2500n -0.000331 34.2600n -0.000319 34.2700n -0.000304 34.2800n -0.000290 34.2900n -0.000276 34.3000n -0.000263 34.3100n -0.000252 34.3200n -0.000243 34.3300n -0.000237 34.3400n -0.000234
+ 34.3500n -0.000233 34.3600n -0.000234 34.3700n -0.000237 34.3800n -0.000240 34.3900n -0.000244 34.4000n -0.000246 34.4100n -0.000246 34.4200n -0.000243 34.4300n -0.000236 34.4400n -0.000225 34.4500n -0.000208 34.4600n -0.000186 34.4700n -0.000157 34.4800n -0.000121 34.4900n -0.000080
+ 34.5000n -0.000032 34.5100n 0.000022 34.5200n 0.000080 34.5300n 0.000142 34.5400n 0.000206 34.5500n 0.000272 34.5600n 0.000338 34.5700n 0.000402 34.5800n 0.000462 34.5900n 0.000517 34.6000n 0.000565 34.6100n 0.000604 34.6200n 0.000634 34.6300n 0.000652 34.6400n 0.000657
+ 34.6500n 0.000649 34.6600n 0.000627 34.6700n 0.000591 34.6800n 0.000540 34.6900n 0.000475 34.7000n 0.000397 34.7100n 0.000306 34.7200n 0.000204 34.7300n 0.000093 34.7400n -0.000027 34.7500n -0.000151 34.7600n -0.000279 34.7700n -0.000408 34.7800n -0.000535 34.7900n -0.000657
+ 34.8000n -0.000773 34.8100n -0.000880 34.8200n -0.000975 34.8300n -0.001056 34.8400n -0.001121 34.8500n -0.001170 34.8600n -0.001200 34.8700n -0.001211 34.8800n -0.001202 34.8900n -0.001174 34.9000n -0.001127 34.9100n -0.001061 34.9200n -0.000977 34.9300n -0.000879 34.9400n -0.000767
+ 34.9500n -0.000643 34.9600n -0.000511 34.9700n -0.000373 34.9800n -0.000232 34.9900n -0.000092 35.0000n 0.000046 35.0100n 0.000177 35.0200n 0.000298 35.0300n 0.000408 35.0400n 0.000502 35.0500n 0.000580 35.0600n 0.000639 35.0700n 0.000677 35.0800n 0.000693 35.0900n 0.000687
+ 35.1000n 0.000659 35.1100n 0.000607 35.1200n 0.000535 35.1300n 0.000441 35.1400n 0.000328 35.1500n 0.000199 35.1600n 0.000054 35.1700n -0.000103 35.1800n -0.000270 35.1900n -0.000443 35.2000n -0.000619 35.2100n -0.000795 35.2200n -0.000969 35.2300n -0.001137 35.2400n -0.001295
+ 35.2500n -0.001442 35.2600n -0.001576 35.2700n -0.001693 35.2800n -0.001792 35.2900n -0.001872 35.3000n -0.001932 35.3100n -0.001972 35.3200n -0.001991 35.3300n -0.001990 35.3400n -0.001969 35.3500n -0.001931 35.3600n -0.001876 35.3700n -0.001806 35.3800n -0.001724 35.3900n -0.001631
+ 35.4000n -0.001531 35.4100n -0.001425 35.4200n -0.001317 35.4300n -0.001209 35.4400n -0.001103 35.4500n -0.001002 35.4600n -0.000908 35.4700n -0.000822 35.4800n -0.000746 35.4900n -0.000682 35.5000n -0.000629 35.5100n -0.000589 35.5200n -0.000561 35.5300n -0.000545 35.5400n -0.000540
+ 35.5500n -0.000545 35.5600n -0.000559 35.5700n -0.000580 35.5800n -0.000606 35.5900n -0.000634 35.6000n -0.000663 35.6100n -0.000690 35.6200n -0.000712 35.6300n -0.000728 35.6400n -0.000735 35.6500n -0.000731 35.6600n -0.000715 35.6700n -0.000684 35.6800n -0.000638 35.6900n -0.000575
+ 35.7000n -0.000495 35.7100n -0.000398 35.7200n -0.000284 35.7300n -0.000154 35.7400n -0.000008 35.7500n 0.000151 35.7600n 0.000322 35.7700n 0.000503 35.7800n 0.000691 35.7900n 0.000885 35.8000n 0.001080 35.8100n 0.001275 35.8200n 0.001465 35.8300n 0.001649 35.8400n 0.001824
+ 35.8500n 0.001985 35.8600n 0.002132 35.8700n 0.002261 35.8800n 0.002370 35.8900n 0.002457 35.9000n 0.002522 35.9100n 0.002561 35.9200n 0.002576 35.9300n 0.002565 35.9400n 0.002528 35.9500n 0.002467 35.9600n 0.002380 35.9700n 0.002270 35.9800n 0.002139 35.9900n 0.001987
+ 36.0000n 0.001817 36.0100n 0.001631 36.0200n 0.001432 36.0300n 0.001221 36.0400n 0.001002 36.0500n 0.000777 36.0600n 0.000549 36.0700n 0.000320 36.0800n 0.000093 36.0900n -0.000129 36.1000n -0.000345 36.1100n -0.000553 36.1200n -0.000750 36.1300n -0.000935 36.1400n -0.001107
+ 36.1500n -0.001264 36.1600n -0.001406 36.1700n -0.001533 36.1800n -0.001642 36.1900n -0.001736 36.2000n -0.001812 36.2100n -0.001872 36.2200n -0.001916 36.2300n -0.001943 36.2400n -0.001956 36.2500n -0.001954 36.2600n -0.001938 36.2700n -0.001908 36.2800n -0.001867 36.2900n -0.001813
+ 36.3000n -0.001749 36.3100n -0.001675 36.3200n -0.001591 36.3300n -0.001499 36.3400n -0.001400 36.3500n -0.001294 36.3600n -0.001181 36.3700n -0.001064 36.3800n -0.000941 36.3900n -0.000816 36.4000n -0.000687 36.4100n -0.000557 36.4200n -0.000426 36.4300n -0.000295 36.4400n -0.000166
+ 36.4500n -0.000038 36.4600n 0.000086 36.4700n 0.000205 36.4800n 0.000319 36.4900n 0.000425 36.5000n 0.000523 36.5100n 0.000612 36.5200n 0.000690 36.5300n 0.000756 36.5400n 0.000809 36.5500n 0.000849 36.5600n 0.000874 36.5700n 0.000885 36.5800n 0.000880 36.5900n 0.000860
+ 36.6000n 0.000824 36.6100n 0.000774 36.6200n 0.000709 36.6300n 0.000631 36.6400n 0.000541 36.6500n 0.000439 36.6600n 0.000329 36.6700n 0.000211 36.6800n 0.000088 36.6900n -0.000038 36.7000n -0.000165 36.7100n -0.000290 36.7200n -0.000411 36.7300n -0.000525 36.7400n -0.000629
+ 36.7500n -0.000722 36.7600n -0.000801 36.7700n -0.000865 36.7800n -0.000911 36.7900n -0.000938 36.8000n -0.000945 36.8100n -0.000932 36.8200n -0.000898 36.8300n -0.000843 36.8400n -0.000768 36.8500n -0.000674 36.8600n -0.000563 36.8700n -0.000435 36.8800n -0.000293 36.8900n -0.000141
+ 36.9000n 0.000020 36.9100n 0.000186 36.9200n 0.000355 36.9300n 0.000522 36.9400n 0.000684 36.9500n 0.000838 36.9600n 0.000980 36.9700n 0.001109 36.9800n 0.001219 36.9900n 0.001310 37.0000n 0.001378 37.0100n 0.001421 37.0200n 0.001440 37.0300n 0.001432 37.0400n 0.001396
+ 37.0500n 0.001335 37.0600n 0.001247 37.0700n 0.001134 37.0800n 0.000999 37.0900n 0.000842 37.1000n 0.000668 37.1100n 0.000479 37.1200n 0.000278 37.1300n 0.000070 37.1400n -0.000143 37.1500n -0.000355 37.1600n -0.000564 37.1700n -0.000764 37.1800n -0.000953 37.1900n -0.001126
+ 37.2000n -0.001280 37.2100n -0.001413 37.2200n -0.001522 37.2300n -0.001604 37.2400n -0.001659 37.2500n -0.001686 37.2600n -0.001683 37.2700n -0.001652 37.2800n -0.001594 37.2900n -0.001510 37.3000n -0.001402 37.3100n -0.001272 37.3200n -0.001124 37.3300n -0.000961 37.3400n -0.000787
+ 37.3500n -0.000606 37.3600n -0.000421 37.3700n -0.000238 37.3800n -0.000060 37.3900n 0.000110 37.4000n 0.000266 37.4100n 0.000405 37.4200n 0.000526 37.4300n 0.000624 37.4400n 0.000697 37.4500n 0.000744 37.4600n 0.000765 37.4700n 0.000758 37.4800n 0.000723 37.4900n 0.000663
+ 37.5000n 0.000577 37.5100n 0.000469 37.5200n 0.000340 37.5300n 0.000195 37.5400n 0.000035 37.5500n -0.000134 37.5600n -0.000309 37.5700n -0.000485 37.5800n -0.000658 37.5900n -0.000824 37.6000n -0.000978 37.6100n -0.001117 37.6200n -0.001237 37.6300n -0.001334 37.6400n -0.001406
+ 37.6500n -0.001450 37.6600n -0.001465 37.6700n -0.001448 37.6800n -0.001401 37.6900n -0.001322 37.7000n -0.001212 37.7100n -0.001074 37.7200n -0.000908 37.7300n -0.000718 37.7400n -0.000506 37.7500n -0.000276 37.7600n -0.000033 37.7700n 0.000221 37.7800n 0.000480 37.7900n 0.000741
+ 37.8000n 0.000997 37.8100n 0.001246 37.8200n 0.001482 37.8300n 0.001703 37.8400n 0.001903 37.8500n 0.002079 37.8600n 0.002230 37.8700n 0.002351 37.8800n 0.002443 37.8900n 0.002503 37.9000n 0.002531 37.9100n 0.002527 37.9200n 0.002491 37.9300n 0.002426 37.9400n 0.002332
+ 37.9500n 0.002213 37.9600n 0.002070 37.9700n 0.001907 37.9800n 0.001728 37.9900n 0.001536 38.0000n 0.001335 38.0100n 0.001129 38.0200n 0.000922 38.0300n 0.000718 38.0400n 0.000520 38.0500n 0.000332 38.0600n 0.000157 38.0700n -0.000003 38.0800n -0.000144 38.0900n -0.000266
+ 38.1000n -0.000366 38.1100n -0.000444 38.1200n -0.000499 38.1300n -0.000532 38.1400n -0.000543 38.1500n -0.000533 38.1600n -0.000503 38.1700n -0.000455 38.1800n -0.000392 38.1900n -0.000315 38.2000n -0.000227 38.2100n -0.000131 38.2200n -0.000030 38.2300n 0.000074 38.2400n 0.000178
+ 38.2500n 0.000280 38.2600n 0.000377 38.2700n 0.000467 38.2800n 0.000548 38.2900n 0.000619 38.3000n 0.000679 38.3100n 0.000726 38.3200n 0.000760 38.3300n 0.000781 38.3400n 0.000789 38.3500n 0.000785 38.3600n 0.000768 38.3700n 0.000741 38.3800n 0.000705 38.3900n 0.000660
+ 38.4000n 0.000609 38.4100n 0.000552 38.4200n 0.000493 38.4300n 0.000431 38.4400n 0.000368 38.4500n 0.000307 38.4600n 0.000247 38.4700n 0.000191 38.4800n 0.000139 38.4900n 0.000091 38.5000n 0.000048 38.5100n 0.000010 38.5200n -0.000024 38.5300n -0.000053 38.5400n -0.000078
+ 38.5500n -0.000100 38.5600n -0.000120 38.5700n -0.000140 38.5800n -0.000159 38.5900n -0.000180 38.6000n -0.000204 38.6100n -0.000231 38.6200n -0.000262 38.6300n -0.000300 38.6400n -0.000343 38.6500n -0.000394 38.6600n -0.000451 38.6700n -0.000515 38.6800n -0.000586 38.6900n -0.000663
+ 38.7000n -0.000745 38.7100n -0.000831 38.7200n -0.000920 38.7300n -0.001010 38.7400n -0.001098 38.7500n -0.001185 38.7600n -0.001266 38.7700n -0.001340 38.7800n -0.001404 38.7900n -0.001457 38.8000n -0.001497 38.8100n -0.001521 38.8200n -0.001527 38.8300n -0.001515 38.8400n -0.001483
+ 38.8500n -0.001431 38.8600n -0.001357 38.8700n -0.001261 38.8800n -0.001145 38.8900n -0.001008 38.9000n -0.000852 38.9100n -0.000679 38.9200n -0.000490 38.9300n -0.000287 38.9400n -0.000074 38.9500n 0.000146 38.9600n 0.000372 38.9700n 0.000598 38.9800n 0.000823 38.9900n 0.001041
+ 39.0000n 0.001251 39.0100n 0.001448 39.0200n 0.001628 39.0300n 0.001790 39.0400n 0.001930 39.0500n 0.002046 39.0600n 0.002136 39.0700n 0.002198 39.0800n 0.002230 39.0900n 0.002232 39.1000n 0.002204 39.1100n 0.002146 39.1200n 0.002059 39.1300n 0.001943 39.1400n 0.001801
+ 39.1500n 0.001634 39.1600n 0.001446 39.1700n 0.001238 39.1800n 0.001014 39.1900n 0.000777 39.2000n 0.000531 39.2100n 0.000279 39.2200n 0.000026 39.2300n -0.000226 39.2400n -0.000473 39.2500n -0.000711 39.2600n -0.000937 39.2700n -0.001149 39.2800n -0.001342 39.2900n -0.001516
+ 39.3000n -0.001668 39.3100n -0.001797 39.3200n -0.001901 39.3300n -0.001979 39.3400n -0.002032 39.3500n -0.002058 39.3600n -0.002060 39.3700n -0.002036 39.3800n -0.001990 39.3900n -0.001921 39.4000n -0.001832 39.4100n -0.001724 39.4200n -0.001600 39.4300n -0.001463 39.4400n -0.001313
+ 39.4500n -0.001154 39.4600n -0.000988 39.4700n -0.000818 39.4800n -0.000645 39.4900n -0.000471 39.5000n -0.000300 39.5100n -0.000132 39.5200n 0.000031 39.5300n 0.000188 39.5400n 0.000337 39.5500n 0.000477 39.5600n 0.000608 39.5700n 0.000729 39.5800n 0.000840 39.5900n 0.000941
+ 39.6000n 0.001031 39.6100n 0.001111 39.6200n 0.001181 39.6300n 0.001242 39.6400n 0.001294 39.6500n 0.001338 39.6600n 0.001374 39.6700n 0.001403 39.6800n 0.001426 39.6900n 0.001443 39.7000n 0.001454 39.7100n 0.001461 39.7200n 0.001463 39.7300n 0.001462 39.7400n 0.001457
+ 39.7500n 0.001448 39.7600n 0.001437 39.7700n 0.001422 39.7800n 0.001405 39.7900n 0.001385 39.8000n 0.001363 39.8100n 0.001338 39.8200n 0.001310 39.8300n 0.001280 39.8400n 0.001247 39.8500n 0.001212 39.8600n 0.001176 39.8700n 0.001137 39.8800n 0.001096 39.8900n 0.001054
+ 39.9000n 0.001011 39.9100n 0.000968 39.9200n 0.000925 39.9300n 0.000881 39.9400n 0.000839 39.9500n 0.000798 39.9600n 0.000760 39.9700n 0.000723 39.9800n 0.000690 39.9900n 0.000660 40.0000n 0.000634 40.0100n 0.000612 40.0200n 0.000595 40.0300n 0.000582 40.0400n 0.000574
+ 40.0500n 0.000570 40.0600n 0.000572 40.0700n 0.000577 40.0800n 0.000587 40.0900n 0.000600 40.1000n 0.000616 40.1100n 0.000635 40.1200n 0.000655 40.1300n 0.000676 40.1400n 0.000698 40.1500n 0.000719 40.1600n 0.000738 40.1700n 0.000756 40.1800n 0.000770 40.1900n 0.000780
+ 40.2000n 0.000786 40.2100n 0.000787 40.2200n 0.000783 40.2300n 0.000773 40.2400n 0.000756 40.2500n 0.000734 40.2600n 0.000705 40.2700n 0.000670 40.2800n 0.000629 40.2900n 0.000583 40.3000n 0.000532 40.3100n 0.000476 40.3200n 0.000416 40.3300n 0.000353 40.3400n 0.000288
+ 40.3500n 0.000221 40.3600n 0.000154 40.3700n 0.000087 40.3800n 0.000021 40.3900n -0.000044 40.4000n -0.000106 40.4100n -0.000164 40.4200n -0.000219 40.4300n -0.000269 40.4400n -0.000315 40.4500n -0.000355 40.4600n -0.000390 40.4700n -0.000419 40.4800n -0.000443 40.4900n -0.000462
+ 40.5000n -0.000475 40.5100n -0.000483 40.5200n -0.000486 40.5300n -0.000485 40.5400n -0.000479 40.5500n -0.000470 40.5600n -0.000458 40.5700n -0.000442 40.5800n -0.000425 40.5900n -0.000405 40.6000n -0.000384 40.6100n -0.000361 40.6200n -0.000337 40.6300n -0.000312 40.6400n -0.000286
+ 40.6500n -0.000260 40.6600n -0.000234 40.6700n -0.000206 40.6800n -0.000179 40.6900n -0.000150 40.7000n -0.000121 40.7100n -0.000092 40.7200n -0.000062 40.7300n -0.000031 40.7400n 0.000001 40.7500n 0.000034 40.7600n 0.000066 40.7700n 0.000100 40.7800n 0.000133 40.7900n 0.000167
+ 40.8000n 0.000200 40.8100n 0.000232 40.8200n 0.000263 40.8300n 0.000292 40.8400n 0.000319 40.8500n 0.000343 40.8600n 0.000363 40.8700n 0.000379 40.8800n 0.000391 40.8900n 0.000397 40.9000n 0.000398 40.9100n 0.000392 40.9200n 0.000381 40.9300n 0.000363 40.9400n 0.000339
+ 40.9500n 0.000309 40.9600n 0.000273 40.9700n 0.000231 40.9800n 0.000185 40.9900n 0.000135 41.0000n 0.000082 41.0100n 0.000027 41.0200n -0.000028 41.0300n -0.000083 41.0400n -0.000135 41.0500n -0.000184 41.0600n -0.000227 41.0700n -0.000264 41.0800n -0.000292 41.0900n -0.000311
+ 41.1000n -0.000318 41.1100n -0.000314 41.1200n -0.000296 41.1300n -0.000264 41.1400n -0.000217 41.1500n -0.000156 41.1600n -0.000080 41.1700n 0.000010 41.1800n 0.000115 41.1900n 0.000232 41.2000n 0.000361 41.2100n 0.000500 41.2200n 0.000647 41.2300n 0.000801 41.2400n 0.000959
+ 41.2500n 0.001118 41.2600n 0.001276 41.2700n 0.001431 41.2800n 0.001578 41.2900n 0.001717 41.3000n 0.001843 41.3100n 0.001954 41.3200n 0.002049 41.3300n 0.002123 41.3400n 0.002176 41.3500n 0.002206 41.3600n 0.002211 41.3700n 0.002190 41.3800n 0.002143 41.3900n 0.002068
+ 41.4000n 0.001968 41.4100n 0.001841 41.4200n 0.001689 41.4300n 0.001513 41.4400n 0.001316 41.4500n 0.001098 41.4600n 0.000863 41.4700n 0.000613 41.4800n 0.000351 41.4900n 0.000080 41.5000n -0.000197 41.5100n -0.000477 41.5200n -0.000756 41.5300n -0.001032 41.5400n -0.001301
+ 41.5500n -0.001561 41.5600n -0.001809 41.5700n -0.002043 41.5800n -0.002261 41.5900n -0.002461 41.6000n -0.002642 41.6100n -0.002803 41.6200n -0.002944 41.6300n -0.003063 41.6400n -0.003163 41.6500n -0.003242 41.6600n -0.003303 41.6700n -0.003346 41.6800n -0.003373 41.6900n -0.003385
+ 41.7000n -0.003384 41.7100n -0.003373 41.7200n -0.003353 41.7300n -0.003327 41.7400n -0.003295 41.7500n -0.003261 41.7600n -0.003226 41.7700n -0.003192 41.7800n -0.003159 41.7900n -0.003130 41.8000n -0.003104 41.8100n -0.003083 41.8200n -0.003066 41.8300n -0.003053 41.8400n -0.003045
+ 41.8500n -0.003040 41.8600n -0.003038 41.8700n -0.003037 41.8800n -0.003037 41.8900n -0.003035 41.9000n -0.003029 41.9100n -0.003020 41.9200n -0.003004 41.9300n -0.002980 41.9400n -0.002946 41.9500n -0.002902 41.9600n -0.002846 41.9700n -0.002777 41.9800n -0.002694 41.9900n -0.002597
+ 42.0000n -0.002486 42.0100n -0.002361 42.0200n -0.002223 42.0300n -0.002072 42.0400n -0.001909 42.0500n -0.001737 42.0600n -0.001557 42.0700n -0.001370 42.0800n -0.001180 42.0900n -0.000988 42.1000n -0.000797 42.1100n -0.000609 42.1200n -0.000427 42.1300n -0.000253 42.1400n -0.000090
+ 42.1500n 0.000061 42.1600n 0.000196 42.1700n 0.000316 42.1800n 0.000418 42.1900n 0.000501 42.2000n 0.000564 42.2100n 0.000608 42.2200n 0.000632 42.2300n 0.000637 42.2400n 0.000623 42.2500n 0.000592 42.2600n 0.000545 42.2700n 0.000484 42.2800n 0.000412 42.2900n 0.000330
+ 42.3000n 0.000240 42.3100n 0.000146 42.3200n 0.000050 42.3300n -0.000045 42.3400n -0.000138 42.3500n -0.000224 42.3600n -0.000303 42.3700n -0.000373 42.3800n -0.000430 42.3900n -0.000475 42.4000n -0.000506 42.4100n -0.000521 42.4200n -0.000522 42.4300n -0.000506 42.4400n -0.000476
+ 42.4500n -0.000432 42.4600n -0.000374 42.4700n -0.000305 42.4800n -0.000225 42.4900n -0.000137 42.5000n -0.000043 42.5100n 0.000056 42.5200n 0.000156 42.5300n 0.000256 42.5400n 0.000353 42.5500n 0.000446 42.5600n 0.000531 42.5700n 0.000607 42.5800n 0.000672 42.5900n 0.000726
+ 42.6000n 0.000766 42.6100n 0.000792 42.6200n 0.000804 42.6300n 0.000802 42.6400n 0.000785 42.6500n 0.000754 42.6600n 0.000711 42.6700n 0.000656 42.6800n 0.000591 42.6900n 0.000518 42.7000n 0.000437 42.7100n 0.000353 42.7200n 0.000266 42.7300n 0.000178 42.7400n 0.000093
+ 42.7500n 0.000011 42.7600n -0.000065 42.7700n -0.000133 42.7800n -0.000193 42.7900n -0.000241 42.8000n -0.000278 42.8100n -0.000303 42.8200n -0.000315 42.8300n -0.000315 42.8400n -0.000301 42.8500n -0.000276 42.8600n -0.000239 42.8700n -0.000192 42.8800n -0.000135 42.8900n -0.000072
+ 42.9000n -0.000003 42.9100n 0.000070 42.9200n 0.000144 42.9300n 0.000219 42.9400n 0.000291 42.9500n 0.000360 42.9600n 0.000422 42.9700n 0.000478 42.9800n 0.000525 42.9900n 0.000562 43.0000n 0.000588 43.0100n 0.000602 43.0200n 0.000606 43.0300n 0.000597 43.0400n 0.000577
+ 43.0500n 0.000547 43.0600n 0.000506 43.0700n 0.000457 43.0800n 0.000401 43.0900n 0.000340 43.1000n 0.000274 43.1100n 0.000207 43.1200n 0.000140 43.1300n 0.000074 43.1400n 0.000013 43.1500n -0.000043 43.1600n -0.000091 43.1700n -0.000130 43.1800n -0.000159 43.1900n -0.000176
+ 43.2000n -0.000181 43.2100n -0.000173 43.2200n -0.000153 43.2300n -0.000119 43.2400n -0.000074 43.2500n -0.000016 43.2600n 0.000051 43.2700n 0.000128 43.2800n 0.000212 43.2900n 0.000301 43.3000n 0.000394 43.3100n 0.000489 43.3200n 0.000582 43.3300n 0.000672 43.3400n 0.000756
+ 43.3500n 0.000833 43.3600n 0.000900 43.3700n 0.000955 43.3800n 0.000996 43.3900n 0.001023 43.4000n 0.001034 43.4100n 0.001027 43.4200n 0.001004 43.4300n 0.000962 43.4400n 0.000903 43.4500n 0.000827 43.4600n 0.000735 43.4700n 0.000629 43.4800n 0.000508 43.4900n 0.000377
+ 43.5000n 0.000235 43.5100n 0.000087 43.5200n -0.000067 43.5300n -0.000223 43.5400n -0.000379 43.5500n -0.000532 43.5600n -0.000680 43.5700n -0.000821 43.5800n -0.000952 43.5900n -0.001070 43.6000n -0.001175 43.6100n -0.001264 43.6200n -0.001336 43.6300n -0.001390 43.6400n -0.001425
+ 43.6500n -0.001440 43.6600n -0.001436 43.6700n -0.001413 43.6800n -0.001371 43.6900n -0.001311 43.7000n -0.001234 43.7100n -0.001142 43.7200n -0.001035 43.7300n -0.000916 43.7400n -0.000787 43.7500n -0.000649 43.7600n -0.000504 43.7700n -0.000355 43.7800n -0.000204 43.7900n -0.000053
+ 43.8000n 0.000097 43.8100n 0.000243 43.8200n 0.000383 43.8300n 0.000516 43.8400n 0.000641 43.8500n 0.000757 43.8600n 0.000861 43.8700n 0.000953 43.8800n 0.001034 43.8900n 0.001101 43.9000n 0.001155 43.9100n 0.001195 43.9200n 0.001223 43.9300n 0.001237 43.9400n 0.001239
+ 43.9500n 0.001228 43.9600n 0.001206 43.9700n 0.001172 43.9800n 0.001129 43.9900n 0.001075 44.0000n 0.001013 44.0100n 0.000943 44.0200n 0.000866 44.0300n 0.000783 44.0400n 0.000695 44.0500n 0.000603 44.0600n 0.000507 44.0700n 0.000408 44.0800n 0.000308 44.0900n 0.000207
+ 44.1000n 0.000106 44.1100n 0.000005 44.1200n -0.000093 44.1300n -0.000189 44.1400n -0.000281 44.1500n -0.000369 44.1600n -0.000452 44.1700n -0.000528 44.1800n -0.000597 44.1900n -0.000659 44.2000n -0.000711 44.2100n -0.000753 44.2200n -0.000785 44.2300n -0.000805 44.2400n -0.000813
+ 44.2500n -0.000808 44.2600n -0.000790 44.2700n -0.000758 44.2800n -0.000711 44.2900n -0.000651 44.3000n -0.000576 44.3100n -0.000487 44.3200n -0.000385 44.3300n -0.000270 44.3400n -0.000142 44.3500n -0.000003 44.3600n 0.000146 44.3700n 0.000304 44.3800n 0.000469 44.3900n 0.000639
+ 44.4000n 0.000814 44.4100n 0.000989 44.4200n 0.001165 44.4300n 0.001337 44.4400n 0.001505 44.4500n 0.001667 44.4600n 0.001819 44.4700n 0.001960 44.4800n 0.002088 44.4900n 0.002202 44.5000n 0.002300 44.5100n 0.002380 44.5200n 0.002441 44.5300n 0.002483 44.5400n 0.002505
+ 44.5500n 0.002506 44.5600n 0.002487 44.5700n 0.002448 44.5800n 0.002389 44.5900n 0.002312 44.6000n 0.002217 44.6100n 0.002106 44.6200n 0.001980 44.6300n 0.001842 44.6400n 0.001692 44.6500n 0.001534 44.6600n 0.001369 44.6700n 0.001199 44.6800n 0.001026 44.6900n 0.000853
+ 44.7000n 0.000681 44.7100n 0.000513 44.7200n 0.000348 44.7300n 0.000190 44.7400n 0.000040 44.7500n -0.000103 44.7600n -0.000237 44.7700n -0.000361 44.7800n -0.000476 44.7900n -0.000582 44.8000n -0.000679 44.8100n -0.000767 44.8200n -0.000848 44.8300n -0.000922 44.8400n -0.000990
+ 44.8500n -0.001054 44.8600n -0.001115 44.8700n -0.001174 44.8800n -0.001232 44.8900n -0.001290 44.9000n -0.001350 44.9100n -0.001413 44.9200n -0.001479 44.9300n -0.001549 44.9400n -0.001623 44.9500n -0.001701 44.9600n -0.001784 44.9700n -0.001870 44.9800n -0.001959 44.9900n -0.002051
+ 45.0000n -0.002143 45.0100n -0.002236 45.0200n -0.002327 45.0300n -0.002414 45.0400n -0.002497 45.0500n -0.002573 45.0600n -0.002640 45.0700n -0.002697 45.0800n -0.002741 45.0900n -0.002773 45.1000n -0.002789 45.1100n -0.002789 45.1200n -0.002772 45.1300n -0.002737 45.1400n -0.002684
+ 45.1500n -0.002612 45.1600n -0.002522 45.1700n -0.002415 45.1800n -0.002292 45.1900n -0.002152 45.2000n -0.001999 45.2100n -0.001834 45.2200n -0.001658 45.2300n -0.001474 45.2400n -0.001284 45.2500n -0.001091 45.2600n -0.000897 45.2700n -0.000705 45.2800n -0.000516 45.2900n -0.000333
+ 45.3000n -0.000158 45.3100n 0.000006 45.3200n 0.000159 45.3300n 0.000299 45.3400n 0.000424 45.3500n 0.000535 45.3600n 0.000630 45.3700n 0.000710 45.3800n 0.000775 45.3900n 0.000825 45.4000n 0.000862 45.4100n 0.000887 45.4200n 0.000901 45.4300n 0.000905 45.4400n 0.000903
+ 45.4500n 0.000896 45.4600n 0.000885 45.4700n 0.000873 45.4800n 0.000863 45.4900n 0.000855 45.5000n 0.000852 45.5100n 0.000856 45.5200n 0.000867 45.5300n 0.000886 45.5400n 0.000915 45.5500n 0.000954 45.5600n 0.001003 45.5700n 0.001061 45.5800n 0.001127 45.5900n 0.001202
+ 45.6000n 0.001282 45.6100n 0.001368 45.6200n 0.001456 45.6300n 0.001545 45.6400n 0.001631 45.6500n 0.001714 45.6600n 0.001790 45.6700n 0.001857 45.6800n 0.001912 45.6900n 0.001953 45.7000n 0.001978 45.7100n 0.001985 45.7200n 0.001973 45.7300n 0.001940 45.7400n 0.001886
+ 45.7500n 0.001809 45.7600n 0.001711 45.7700n 0.001591 45.7800n 0.001451 45.7900n 0.001291 45.8000n 0.001113 45.8100n 0.000920 45.8200n 0.000714 45.8300n 0.000498 45.8400n 0.000274 45.8500n 0.000046 45.8600n -0.000183 45.8700n -0.000409 45.8800n -0.000629 45.8900n -0.000841
+ 45.9000n -0.001040 45.9100n -0.001223 45.9200n -0.001389 45.9300n -0.001534 45.9400n -0.001657 45.9500n -0.001756 45.9600n -0.001831 45.9700n -0.001879 45.9800n -0.001902 45.9900n -0.001900 46.0000n -0.001873 46.0100n -0.001823 46.0200n -0.001751 46.0300n -0.001659 46.0400n -0.001550
+ 46.0500n -0.001427 46.0600n -0.001292 46.0700n -0.001148 46.0800n -0.001000 46.0900n -0.000849 46.1000n -0.000699 46.1100n -0.000554 46.1200n -0.000415 46.1300n -0.000286 46.1400n -0.000169 46.1500n -0.000067 46.1600n 0.000020 46.1700n 0.000090 46.1800n 0.000142 46.1900n 0.000175
+ 46.2000n 0.000191 46.2100n 0.000188 46.2200n 0.000169 46.2300n 0.000135 46.2400n 0.000086 46.2500n 0.000026 46.2600n -0.000044 46.2700n -0.000120 46.2800n -0.000201 46.2900n -0.000284 46.3000n -0.000366 46.3100n -0.000443 46.3200n -0.000515 46.3300n -0.000577 46.3400n -0.000628
+ 46.3500n -0.000666 46.3600n -0.000688 46.3700n -0.000694 46.3800n -0.000682 46.3900n -0.000652 46.4000n -0.000603 46.4100n -0.000536 46.4200n -0.000450 46.4300n -0.000347 46.4400n -0.000228 46.4500n -0.000094 46.4600n 0.000052 46.4700n 0.000210 46.4800n 0.000376 46.4900n 0.000548
+ 46.5000n 0.000725 46.5100n 0.000903 46.5200n 0.001080 46.5300n 0.001253 46.5400n 0.001420 46.5500n 0.001580 46.5600n 0.001729 46.5700n 0.001867 46.5800n 0.001992 46.5900n 0.002102 46.6000n 0.002196 46.6100n 0.002274 46.6200n 0.002336 46.6300n 0.002380 46.6400n 0.002408
+ 46.6500n 0.002419 46.6600n 0.002415 46.6700n 0.002395 46.6800n 0.002362 46.6900n 0.002315 46.7000n 0.002256 46.7100n 0.002187 46.7200n 0.002109 46.7300n 0.002023 46.7400n 0.001930 46.7500n 0.001831 46.7600n 0.001728 46.7700n 0.001622 46.7800n 0.001513 46.7900n 0.001402
+ 46.8000n 0.001291 46.8100n 0.001179 46.8200n 0.001067 46.8300n 0.000956 46.8400n 0.000845 46.8500n 0.000735 46.8600n 0.000625 46.8700n 0.000516 46.8800n 0.000408 46.8900n 0.000301 46.9000n 0.000194 46.9100n 0.000088 46.9200n -0.000017 46.9300n -0.000122 46.9400n -0.000225
+ 46.9500n -0.000327 46.9600n -0.000427 46.9700n -0.000525 46.9800n -0.000619 46.9900n -0.000711 47.0000n -0.000797 47.0100n -0.000878 47.0200n -0.000954 47.0300n -0.001022 47.0400n -0.001082 47.0500n -0.001134 47.0600n -0.001176 47.0700n -0.001208 47.0800n -0.001229 47.0900n -0.001239
+ 47.1000n -0.001237 47.1100n -0.001223 47.1200n -0.001197 47.1300n -0.001160 47.1400n -0.001112 47.1500n -0.001053 47.1600n -0.000984 47.1700n -0.000907 47.1800n -0.000823 47.1900n -0.000732 47.2000n -0.000637 47.2100n -0.000539 47.2200n -0.000439 47.2300n -0.000339 47.2400n -0.000242
+ 47.2500n -0.000148 47.2600n -0.000060 47.2700n 0.000021 47.2800n 0.000095 47.2900n 0.000159 47.3000n 0.000212 47.3100n 0.000254 47.3200n 0.000284 47.3300n 0.000303 47.3400n 0.000308 47.3500n 0.000302 47.3600n 0.000285 47.3700n 0.000256 47.3800n 0.000217 47.3900n 0.000170
+ 47.4000n 0.000115 47.4100n 0.000053 47.4200n -0.000013 47.4300n -0.000081 47.4400n -0.000151 47.4500n -0.000221 47.4600n -0.000288 47.4700n -0.000352 47.4800n -0.000411 47.4900n -0.000463 47.5000n -0.000507 47.5100n -0.000542 47.5200n -0.000568 47.5300n -0.000584 47.5400n -0.000589
+ 47.5500n -0.000584 47.5600n -0.000568 47.5700n -0.000542 47.5800n -0.000506 47.5900n -0.000461 47.6000n -0.000408 47.6100n -0.000347 47.6200n -0.000281 47.6300n -0.000209 47.6400n -0.000133 47.6500n -0.000055 47.6600n 0.000025 47.6700n 0.000106 47.6800n 0.000187 47.6900n 0.000267
+ 47.7000n 0.000345 47.7100n 0.000421 47.7200n 0.000494 47.7300n 0.000565 47.7400n 0.000633 47.7500n 0.000698 47.7600n 0.000760 47.7700n 0.000821 47.7800n 0.000880 47.7900n 0.000938 47.8000n 0.000995 47.8100n 0.001052 47.8200n 0.001110 47.8300n 0.001168 47.8400n 0.001228
+ 47.8500n 0.001289 47.8600n 0.001351 47.8700n 0.001415 47.8800n 0.001479 47.8900n 0.001544 47.9000n 0.001608 47.9100n 0.001670 47.9200n 0.001729 47.9300n 0.001785 47.9400n 0.001834 47.9500n 0.001876 47.9600n 0.001909 47.9700n 0.001930 47.9800n 0.001939 47.9900n 0.001932
+ 48.0000n 0.001909 48.0100n 0.001868 48.0200n 0.001807 48.0300n 0.001726 48.0400n 0.001624 48.0500n 0.001500 48.0600n 0.001354 48.0700n 0.001187 48.0800n 0.001000 48.0900n 0.000794 48.1000n 0.000570 48.1100n 0.000331 48.1200n 0.000080 48.1300n -0.000181 48.1400n -0.000448
+ 48.1500n -0.000717 48.1600n -0.000985 48.1700n -0.001247 48.1800n -0.001500 48.1900n -0.001740 48.2000n -0.001962 48.2100n -0.002162 48.2200n -0.002337 48.2300n -0.002484 48.2400n -0.002600 48.2500n -0.002682 48.2600n -0.002730 48.2700n -0.002741 48.2800n -0.002716 48.2900n -0.002654
+ 48.3000n -0.002557 48.3100n -0.002426 48.3200n -0.002264 48.3300n -0.002073 48.3400n -0.001857 48.3500n -0.001621 48.3600n -0.001370 48.3700n -0.001107 48.3800n -0.000839 48.3900n -0.000572 48.4000n -0.000310 48.4100n -0.000060 48.4200n 0.000174 48.4300n 0.000385 48.4400n 0.000569
+ 48.4500n 0.000721 48.4600n 0.000839 48.4700n 0.000918 48.4800n 0.000957 48.4900n 0.000954 48.5000n 0.000909 48.5100n 0.000821 48.5200n 0.000693 48.5300n 0.000526 48.5400n 0.000323 48.5500n 0.000088 48.5600n -0.000174 48.5700n -0.000458 48.5800n -0.000758 48.5900n -0.001069
+ 48.6000n -0.001382 48.6100n -0.001692 48.6200n -0.001991 48.6300n -0.002272 48.6400n -0.002530 48.6500n -0.002757 48.6600n -0.002948 48.6700n -0.003098 48.6800n -0.003202 48.6900n -0.003257 48.7000n -0.003260 48.7100n -0.003209 48.7200n -0.003104 48.7300n -0.002945 48.7400n -0.002734
+ 48.7500n -0.002472 48.7600n -0.002165 48.7700n -0.001815 48.7800n -0.001428 48.7900n -0.001011 48.8000n -0.000570 48.8100n -0.000112 48.8200n 0.000356 48.8300n 0.000825 48.8400n 0.001288 48.8500n 0.001737 48.8600n 0.002165 48.8700n 0.002564 48.8800n 0.002928 48.8900n 0.003252
+ 48.9000n 0.003530 48.9100n 0.003759 48.9200n 0.003934 48.9300n 0.004055 48.9400n 0.004119 48.9500n 0.004127 48.9600n 0.004081 48.9700n 0.003982 48.9800n 0.003833 48.9900n 0.003640 49.0000n 0.003406 49.0100n 0.003138 49.0200n 0.002841 49.0300n 0.002523 49.0400n 0.002191
+ 49.0500n 0.001852 49.0600n 0.001513 49.0700n 0.001182 49.0800n 0.000866 49.0900n 0.000570 49.1000n 0.000301 49.1100n 0.000063 49.1200n -0.000138 49.1300n -0.000299 49.1400n -0.000417 49.1500n -0.000492 49.1600n -0.000523 49.1700n -0.000509 49.1800n -0.000453 49.1900n -0.000357
+ 49.2000n -0.000224 49.2100n -0.000058 49.2200n 0.000135 49.2300n 0.000351 49.2400n 0.000583 49.2500n 0.000826 49.2600n 0.001073 49.2700n 0.001317 49.2800n 0.001552 49.2900n 0.001773 49.3000n 0.001973 49.3100n 0.002147 49.3200n 0.002291 49.3300n 0.002400 49.3400n 0.002473
+ 49.3500n 0.002506 49.3600n 0.002499 49.3700n 0.002450 49.3800n 0.002361 49.3900n 0.002233 49.4000n 0.002069 49.4100n 0.001871 49.4200n 0.001643 49.4300n 0.001390 49.4400n 0.001117 49.4500n 0.000829 49.4600n 0.000532 49.4700n 0.000232 49.4800n -0.000065 49.4900n -0.000354
+ 49.5000n -0.000629 49.5100n -0.000885 49.5200n -0.001117 49.5300n -0.001321 49.5400n -0.001494 49.5500n -0.001633 49.5600n -0.001736 49.5700n -0.001802 49.5800n -0.001830 49.5900n -0.001821 49.6000n -0.001777 49.6100n -0.001698 49.6200n -0.001589 49.6300n -0.001451 49.6400n -0.001290
+ 49.6500n -0.001109 49.6600n -0.000913 49.6700n -0.000707 49.6800n -0.000495 49.6900n -0.000282 49.7000n -0.000074 49.7100n 0.000126 49.7200n 0.000314 49.7300n 0.000485 49.7400n 0.000637 49.7500n 0.000767 49.7600n 0.000874 49.7700n 0.000956 49.7800n 0.001012 49.7900n 0.001043
+ 49.8000n 0.001050 49.8100n 0.001034 49.8200n 0.000997 49.8300n 0.000942 49.8400n 0.000871 49.8500n 0.000789 49.8600n 0.000698 49.8700n 0.000603 49.8800n 0.000507 49.8900n 0.000414 49.9000n 0.000327 49.9100n 0.000251 49.9200n 0.000188 49.9300n 0.000141 49.9400n 0.000112
+ 49.9500n 0.000102 49.9600n 0.000113 49.9700n 0.000144 49.9800n 0.000196 49.9900n 0.000268 50.0000n 0.000357 50.0100n 0.000463 50.0200n 0.000583 50.0300n 0.000713 50.0400n 0.000851 50.0500n 0.000992 50.0600n 0.001133 50.0700n 0.001270 50.0800n 0.001399 50.0900n 0.001517
+ 50.1000n 0.001619 50.1100n 0.001702 50.1200n 0.001764 50.1300n 0.001802 50.1400n 0.001815 50.1500n 0.001801 50.1600n 0.001759 50.1700n 0.001690 50.1800n 0.001594 50.1900n 0.001473 50.2000n 0.001329 50.2100n 0.001165 50.2200n 0.000983 50.2300n 0.000787 50.2400n 0.000582
+ 50.2500n 0.000371 50.2600n 0.000159 50.2700n -0.000048 50.2800n -0.000247 50.2900n -0.000433 50.3000n -0.000602 50.3100n -0.000749 50.3200n -0.000871 50.3300n -0.000965 50.3400n -0.001028 50.3500n -0.001059 50.3600n -0.001056 50.3700n -0.001019 50.3800n -0.000948 50.3900n -0.000844
+ 50.4000n -0.000709 50.4100n -0.000545 50.4200n -0.000355 50.4300n -0.000143 50.4400n 0.000088 50.4500n 0.000332 50.4600n 0.000585 50.4700n 0.000842 50.4800n 0.001098 50.4900n 0.001348 50.5000n 0.001586 50.5100n 0.001809 50.5200n 0.002011 50.5300n 0.002188 50.5400n 0.002338
+ 50.5500n 0.002456 50.5600n 0.002541 50.5700n 0.002592 50.5800n 0.002606 50.5900n 0.002584 50.6000n 0.002527 50.6100n 0.002435 50.6200n 0.002310 50.6300n 0.002155 50.6400n 0.001973 50.6500n 0.001768 50.6600n 0.001542 50.6700n 0.001301 50.6800n 0.001049 50.6900n 0.000790
+ 50.7000n 0.000529 50.7100n 0.000270 50.7200n 0.000019 50.7300n -0.000222 50.7400n -0.000449 50.7500n -0.000658 50.7600n -0.000846 50.7700n -0.001012 50.7800n -0.001153 50.7900n -0.001268 50.8000n -0.001358 50.8100n -0.001422 50.8200n -0.001460 50.8300n -0.001474 50.8400n -0.001466
+ 50.8500n -0.001438 50.8600n -0.001392 50.8700n -0.001331 50.8800n -0.001258 50.8900n -0.001176 50.9000n -0.001089 50.9100n -0.000998 50.9200n -0.000909 50.9300n -0.000822 50.9400n -0.000741 50.9500n -0.000669 50.9600n -0.000605 50.9700n -0.000553 50.9800n -0.000513 50.9900n -0.000485
+ 51.0000n -0.000470 51.0100n -0.000466 51.0200n -0.000473 51.0300n -0.000490 51.0400n -0.000514 51.0500n -0.000543 51.0600n -0.000575 51.0700n -0.000608 51.0800n -0.000638 51.0900n -0.000663 51.1000n -0.000680 51.1100n -0.000686 51.1200n -0.000680 51.1300n -0.000658 51.1400n -0.000619
+ 51.1500n -0.000561 51.1600n -0.000484 51.1700n -0.000386 51.1800n -0.000268 51.1900n -0.000130 51.2000n 0.000028 51.2100n 0.000204 51.2200n 0.000396 51.2300n 0.000602 51.2400n 0.000819 51.2500n 0.001044 51.2600n 0.001274 51.2700n 0.001506 51.2800n 0.001736 51.2900n 0.001960
+ 51.3000n 0.002175 51.3100n 0.002377 51.3200n 0.002564 51.3300n 0.002731 51.3400n 0.002876 51.3500n 0.002997 51.3600n 0.003092 51.3700n 0.003159 51.3800n 0.003198 51.3900n 0.003209 51.4000n 0.003191 51.4100n 0.003145 51.4200n 0.003072 51.4300n 0.002974 51.4400n 0.002854
+ 51.4500n 0.002714 51.4600n 0.002556 51.4700n 0.002384 51.4800n 0.002202 51.4900n 0.002012 51.5000n 0.001819 51.5100n 0.001626 51.5200n 0.001437 51.5300n 0.001254 51.5400n 0.001082 51.5500n 0.000922 51.5600n 0.000777 51.5700n 0.000649 51.5800n 0.000540 51.5900n 0.000451
+ 51.6000n 0.000382 51.6100n 0.000334 51.6200n 0.000305 51.6300n 0.000297 51.6400n 0.000306 51.6500n 0.000331 51.6600n 0.000371 51.6700n 0.000423 51.6800n 0.000484 51.6900n 0.000551 51.7000n 0.000622 51.7100n 0.000694 51.7200n 0.000763 51.7300n 0.000827 51.7400n 0.000883
+ 51.7500n 0.000929 51.7600n 0.000962 51.7700n 0.000980 51.7800n 0.000981 51.7900n 0.000965 51.8000n 0.000931 51.8100n 0.000878 51.8200n 0.000806 51.8300n 0.000716 51.8400n 0.000608 51.8500n 0.000484 51.8600n 0.000346 51.8700n 0.000194 51.8800n 0.000031 51.8900n -0.000140
+ 51.9000n -0.000317 51.9100n -0.000498 51.9200n -0.000680 51.9300n -0.000860 51.9400n -0.001036 51.9500n -0.001205 51.9600n -0.001366 51.9700n -0.001516 51.9800n -0.001653 51.9900n -0.001776 52.0000n -0.001884 52.0100n -0.001975 52.0200n -0.002050 52.0300n -0.002108 52.0400n -0.002149
+ 52.0500n -0.002173 52.0600n -0.002181 52.0700n -0.002175 52.0800n -0.002154 52.0900n -0.002121 52.1000n -0.002076 52.1100n -0.002022 52.1200n -0.001959 52.1300n -0.001891 52.1400n -0.001817 52.1500n -0.001741 52.1600n -0.001662 52.1700n -0.001584 52.1800n -0.001506 52.1900n -0.001430
+ 52.2000n -0.001356 52.2100n -0.001286 52.2200n -0.001220 52.2300n -0.001157 52.2400n -0.001098 52.2500n -0.001044 52.2600n -0.000992 52.2700n -0.000944 52.2800n -0.000897 52.2900n -0.000853 52.3000n -0.000808 52.3100n -0.000764 52.3200n -0.000718 52.3300n -0.000670 52.3400n -0.000619
+ 52.3500n -0.000565 52.3600n -0.000506 52.3700n -0.000442 52.3800n -0.000372 52.3900n -0.000296 52.4000n -0.000215 52.4100n -0.000127 52.4200n -0.000033 52.4300n 0.000066 52.4400n 0.000170 52.4500n 0.000279 52.4600n 0.000392 52.4700n 0.000507 52.4800n 0.000625 52.4900n 0.000743
+ 52.5000n 0.000861 52.5100n 0.000979 52.5200n 0.001093 52.5300n 0.001205 52.5400n 0.001312 52.5500n 0.001413 52.5600n 0.001509 52.5700n 0.001597 52.5800n 0.001677 52.5900n 0.001748 52.6000n 0.001811 52.6100n 0.001864 52.6200n 0.001908 52.6300n 0.001942 52.6400n 0.001966
+ 52.6500n 0.001980 52.6600n 0.001985 52.6700n 0.001980 52.6800n 0.001967 52.6900n 0.001945 52.7000n 0.001915 52.7100n 0.001877 52.7200n 0.001833 52.7300n 0.001782 52.7400n 0.001725 52.7500n 0.001662 52.7600n 0.001595 52.7700n 0.001524 52.7800n 0.001449 52.7900n 0.001371
+ 52.8000n 0.001290 52.8100n 0.001206 52.8200n 0.001122 52.8300n 0.001036 52.8400n 0.000949 52.8500n 0.000862 52.8600n 0.000775 52.8700n 0.000689 52.8800n 0.000604 52.8900n 0.000522 52.9000n 0.000442 52.9100n 0.000365 52.9200n 0.000293 52.9300n 0.000225 52.9400n 0.000162
+ 52.9500n 0.000106 52.9600n 0.000056 52.9700n 0.000014 52.9800n -0.000020 52.9900n -0.000045 53.0000n -0.000061 53.0100n -0.000067 53.0200n -0.000063 53.0300n -0.000049 53.0400n -0.000024 53.0500n 0.000011 53.0600n 0.000057 53.0700n 0.000112 53.0800n 0.000177 53.0900n 0.000250
+ 53.1000n 0.000330 53.1100n 0.000417 53.1200n 0.000509 53.1300n 0.000605 53.1400n 0.000703 53.1500n 0.000801 53.1600n 0.000898 53.1700n 0.000991 53.1800n 0.001079 53.1900n 0.001160 53.2000n 0.001232 53.2100n 0.001294 53.2200n 0.001342 53.2300n 0.001377 53.2400n 0.001397
+ 53.2500n 0.001400 53.2600n 0.001386 53.2700n 0.001354 53.2800n 0.001303 53.2900n 0.001235 53.3000n 0.001148 53.3100n 0.001044 53.3200n 0.000924 53.3300n 0.000789 53.3400n 0.000640 53.3500n 0.000480 53.3600n 0.000310 53.3700n 0.000133 53.3800n -0.000049 53.3900n -0.000233
+ 53.4000n -0.000417 53.4100n -0.000597 53.4200n -0.000772 53.4300n -0.000937 53.4400n -0.001091 53.4500n -0.001232 53.4600n -0.001357 53.4700n -0.001463 53.4800n -0.001551 53.4900n -0.001617 53.5000n -0.001662 53.5100n -0.001683 53.5200n -0.001683 53.5300n -0.001659 53.5400n -0.001614
+ 53.5500n -0.001547 53.5600n -0.001460 53.5700n -0.001355 53.5800n -0.001234 53.5900n -0.001098 53.6000n -0.000950 53.6100n -0.000794 53.6200n -0.000630 53.6300n -0.000463 53.6400n -0.000295 53.6500n -0.000130 53.6600n 0.000032 53.6700n 0.000185 53.6800n 0.000330 53.6900n 0.000462
+ 53.7000n 0.000580 53.7100n 0.000683 53.7200n 0.000769 53.7300n 0.000837 53.7400n 0.000886 53.7500n 0.000917 53.7600n 0.000929 53.7700n 0.000923 53.7800n 0.000900 53.7900n 0.000860 53.8000n 0.000806 53.8100n 0.000738 53.8200n 0.000659 53.8300n 0.000570 53.8400n 0.000475
+ 53.8500n 0.000374 53.8600n 0.000271 53.8700n 0.000167 53.8800n 0.000065 53.8900n -0.000033 53.9000n -0.000125 53.9100n -0.000209 53.9200n -0.000285 53.9300n -0.000349 53.9400n -0.000403 53.9500n -0.000444 53.9600n -0.000472 53.9700n -0.000487 53.9800n -0.000490 53.9900n -0.000480
+ 54.0000n -0.000458 54.0100n -0.000424 54.0200n -0.000381 54.0300n -0.000329 54.0400n -0.000269 54.0500n -0.000204 54.0600n -0.000134 54.0700n -0.000062 54.0800n 0.000012 54.0900n 0.000085 54.1000n 0.000156 54.1100n 0.000223 54.1200n 0.000286 54.1300n 0.000343 54.1400n 0.000392
+ 54.1500n 0.000433 54.1600n 0.000466 54.1700n 0.000490 54.1800n 0.000505 54.1900n 0.000510 54.2000n 0.000505 54.2100n 0.000492 54.2200n 0.000470 54.2300n 0.000439 54.2400n 0.000402 54.2500n 0.000357 54.2600n 0.000307 54.2700n 0.000252 54.2800n 0.000193 54.2900n 0.000132
+ 54.3000n 0.000068 54.3100n 0.000003 54.3200n -0.000063 54.3300n -0.000127 54.3400n -0.000191 54.3500n -0.000253 54.3600n -0.000313 54.3700n -0.000370 54.3800n -0.000424 54.3900n -0.000474 54.4000n -0.000522 54.4100n -0.000566 54.4200n -0.000606 54.4300n -0.000643 54.4400n -0.000677
+ 54.4500n -0.000708 54.4600n -0.000736 54.4700n -0.000761 54.4800n -0.000783 54.4900n -0.000803 54.5000n -0.000821 54.5100n -0.000837 54.5200n -0.000851 54.5300n -0.000862 54.5400n -0.000871 54.5500n -0.000879 54.5600n -0.000883 54.5700n -0.000886 54.5800n -0.000886 54.5900n -0.000884
+ 54.6000n -0.000879 54.6100n -0.000871 54.6200n -0.000860 54.6300n -0.000846 54.6400n -0.000829 54.6500n -0.000809 54.6600n -0.000786 54.6700n -0.000761 54.6800n -0.000733 54.6900n -0.000703 54.7000n -0.000671 54.7100n -0.000638 54.7200n -0.000605 54.7300n -0.000571 54.7400n -0.000538
+ 54.7500n -0.000507 54.7600n -0.000478 54.7700n -0.000451 54.7800n -0.000428 54.7900n -0.000410 54.8000n -0.000397 54.8100n -0.000389 54.8200n -0.000387 54.8300n -0.000392 54.8400n -0.000404 54.8500n -0.000422 54.8600n -0.000448 54.8700n -0.000481 54.8800n -0.000520 54.8900n -0.000565
+ 54.9000n -0.000616 54.9100n -0.000672 54.9200n -0.000732 54.9300n -0.000795 54.9400n -0.000860 54.9500n -0.000925 54.9600n -0.000991 54.9700n -0.001054 54.9800n -0.001115 54.9900n -0.001172 55.0000n -0.001223 55.0100n -0.001268 55.0200n -0.001305 55.0300n -0.001335 55.0400n -0.001355
+ 55.0500n -0.001365 55.0600n -0.001366 55.0700n -0.001357 55.0800n -0.001337 55.0900n -0.001308 55.1000n -0.001269 55.1100n -0.001222 55.1200n -0.001167 55.1300n -0.001105 55.1400n -0.001037 55.1500n -0.000965 55.1600n -0.000890 55.1700n -0.000813 55.1800n -0.000737 55.1900n -0.000662
+ 55.2000n -0.000590 55.2100n -0.000522 55.2200n -0.000461 55.2300n -0.000407 55.2400n -0.000362 55.2500n -0.000326 55.2600n -0.000300 55.2700n -0.000285 55.2800n -0.000280 55.2900n -0.000287 55.3000n -0.000306 55.3100n -0.000334 55.3200n -0.000373 55.3300n -0.000421 55.3400n -0.000477
+ 55.3500n -0.000541 55.3600n -0.000610 55.3700n -0.000683 55.3800n -0.000759 55.3900n -0.000835 55.4000n -0.000911 55.4100n -0.000984 55.4200n -0.001053 55.4300n -0.001116 55.4400n -0.001172 55.4500n -0.001220 55.4600n -0.001257 55.4700n -0.001283 55.4800n -0.001297 55.4900n -0.001299
+ 55.5000n -0.001288 55.5100n -0.001264 55.5200n -0.001227 55.5300n -0.001177 55.5400n -0.001115 55.5500n -0.001041 55.5600n -0.000956 55.5700n -0.000862 55.5800n -0.000759 55.5900n -0.000649 55.6000n -0.000533 55.6100n -0.000413 55.6200n -0.000291 55.6300n -0.000167 55.6400n -0.000044
+ 55.6500n 0.000077 55.6600n 0.000194 55.6700n 0.000307 55.6800n 0.000414 55.6900n 0.000513 55.7000n 0.000604 55.7100n 0.000687 55.7200n 0.000759 55.7300n 0.000821 55.7400n 0.000872 55.7500n 0.000912 55.7600n 0.000941 55.7700n 0.000959 55.7800n 0.000965 55.7900n 0.000961
+ 55.8000n 0.000946 55.8100n 0.000921 55.8200n 0.000886 55.8300n 0.000842 55.8400n 0.000789 55.8500n 0.000728 55.8600n 0.000659 55.8700n 0.000584 55.8800n 0.000502 55.8900n 0.000414 55.9000n 0.000321 55.9100n 0.000224 55.9200n 0.000122 55.9300n 0.000017 55.9400n -0.000092
+ 55.9500n -0.000203 55.9600n -0.000316 55.9700n -0.000430 55.9800n -0.000545 55.9900n -0.000661 56.0000n -0.000776 56.0100n -0.000889 56.0200n -0.001001 56.0300n -0.001110 56.0400n -0.001216 56.0500n -0.001317 56.0600n -0.001412 56.0700n -0.001501 56.0800n -0.001583 56.0900n -0.001657
+ 56.1000n -0.001721 56.1100n -0.001776 56.1200n -0.001819 56.1300n -0.001850 56.1400n -0.001868 56.1500n -0.001873 56.1600n -0.001863 56.1700n -0.001840 56.1800n -0.001801 56.1900n -0.001748 56.2000n -0.001681 56.2100n -0.001598 56.2200n -0.001502 56.2300n -0.001392 56.2400n -0.001270
+ 56.2500n -0.001137 56.2600n -0.000993 56.2700n -0.000840 56.2800n -0.000680 56.2900n -0.000513 56.3000n -0.000343 56.3100n -0.000170 56.3200n 0.000003 56.3300n 0.000176 56.3400n 0.000346 56.3500n 0.000511 56.3600n 0.000670 56.3700n 0.000822 56.3800n 0.000965 56.3900n 0.001098
+ 56.4000n 0.001221 56.4100n 0.001333 56.4200n 0.001433 56.4300n 0.001521 56.4400n 0.001597 56.4500n 0.001662 56.4600n 0.001716 56.4700n 0.001760 56.4800n 0.001795 56.4900n 0.001821 56.5000n 0.001841 56.5100n 0.001855 56.5200n 0.001865 56.5300n 0.001873 56.5400n 0.001879
+ 56.5500n 0.001885 56.5600n 0.001892 56.5700n 0.001901 56.5800n 0.001914 56.5900n 0.001931 56.6000n 0.001953 56.6100n 0.001979 56.6200n 0.002010 56.6300n 0.002045 56.6400n 0.002084 56.6500n 0.002126 56.6600n 0.002170 56.6700n 0.002215 56.6800n 0.002259 56.6900n 0.002301
+ 56.7000n 0.002338 56.7100n 0.002368 56.7200n 0.002390 56.7300n 0.002402 56.7400n 0.002402 56.7500n 0.002388 56.7600n 0.002358 56.7700n 0.002310 56.7800n 0.002245 56.7900n 0.002160 56.8000n 0.002055 56.8100n 0.001930 56.8200n 0.001785 56.8300n 0.001621 56.8400n 0.001439
+ 56.8500n 0.001240 56.8600n 0.001026 56.8700n 0.000798 56.8800n 0.000561 56.8900n 0.000316 56.9000n 0.000066 56.9100n -0.000185 56.9200n -0.000434 56.9300n -0.000677 56.9400n -0.000911 56.9500n -0.001133 56.9600n -0.001338 56.9700n -0.001524 56.9800n -0.001688 56.9900n -0.001828
+ 57.0000n -0.001941 57.0100n -0.002025 57.0200n -0.002080 57.0300n -0.002104 57.0400n -0.002096 57.0500n -0.002059 57.0600n -0.001991 57.0700n -0.001895 57.0800n -0.001773 57.0900n -0.001626 57.1000n -0.001458 57.1100n -0.001272 57.1200n -0.001071 57.1300n -0.000860 57.1400n -0.000642
+ 57.1500n -0.000422 57.1600n -0.000204 57.1700n 0.000008 57.1800n 0.000210 57.1900n 0.000397 57.2000n 0.000567 57.2100n 0.000715 57.2200n 0.000840 57.2300n 0.000937 57.2400n 0.001006 57.2500n 0.001045 57.2600n 0.001054 57.2700n 0.001030 57.2800n 0.000977 57.2900n 0.000893
+ 57.3000n 0.000781 57.3100n 0.000642 57.3200n 0.000480 57.3300n 0.000297 57.3400n 0.000096 57.3500n -0.000118 57.3600n -0.000343 57.3700n -0.000573 57.3800n -0.000804 57.3900n -0.001033 57.4000n -0.001255 57.4100n -0.001465 57.4200n -0.001661 57.4300n -0.001839 57.4400n -0.001996
+ 57.4500n -0.002128 57.4600n -0.002234 57.4700n -0.002311 57.4800n -0.002360 57.4900n -0.002378 57.5000n -0.002367 57.5100n -0.002326 57.5200n -0.002256 57.5300n -0.002159 57.5400n -0.002037 57.5500n -0.001893 57.5600n -0.001728 57.5700n -0.001548 57.5800n -0.001354 57.5900n -0.001150
+ 57.6000n -0.000941 57.6100n -0.000730 57.6200n -0.000521 57.6300n -0.000318 57.6400n -0.000123 57.6500n 0.000058 57.6600n 0.000224 57.6700n 0.000372 57.6800n 0.000498 57.6900n 0.000602 57.7000n 0.000682 57.7100n 0.000736 57.7200n 0.000765 57.7300n 0.000766 57.7400n 0.000742
+ 57.7500n 0.000693 57.7600n 0.000619 57.7700n 0.000523 57.7800n 0.000406 57.7900n 0.000270 57.8000n 0.000118 57.8100n -0.000048 57.8200n -0.000226 57.8300n -0.000411 57.8400n -0.000602 57.8500n -0.000796 57.8600n -0.000990 57.8700n -0.001181 57.8800n -0.001366 57.8900n -0.001544
+ 57.9000n -0.001712 57.9100n -0.001869 57.9200n -0.002012 57.9300n -0.002141 57.9400n -0.002255 57.9500n -0.002352 57.9600n -0.002432 57.9700n -0.002496 57.9800n -0.002543 57.9900n -0.002574 58.0000n -0.002589 58.0100n -0.002588 58.0200n -0.002574 58.0300n -0.002547 58.0400n -0.002508
+ 58.0500n -0.002459 58.0600n -0.002400 58.0700n -0.002334 58.0800n -0.002262 58.0900n -0.002184 58.1000n -0.002103 58.1100n -0.002020 58.1200n -0.001935 58.1300n -0.001850 58.1400n -0.001765 58.1500n -0.001682 58.1600n -0.001601 58.1700n -0.001522 58.1800n -0.001446 58.1900n -0.001374
+ 58.2000n -0.001304 58.2100n -0.001239 58.2200n -0.001176 58.2300n -0.001116 58.2400n -0.001060 58.2500n -0.001005 58.2600n -0.000953 58.2700n -0.000902 58.2800n -0.000852 58.2900n -0.000803 58.3000n -0.000754 58.3100n -0.000705 58.3200n -0.000654 58.3300n -0.000602 58.3400n -0.000548
+ 58.3500n -0.000492 58.3600n -0.000433 58.3700n -0.000371 58.3800n -0.000306 58.3900n -0.000238 58.4000n -0.000165 58.4100n -0.000090 58.4200n -0.000010 58.4300n 0.000072 58.4400n 0.000158 58.4500n 0.000246 58.4600n 0.000337 58.4700n 0.000430 58.4800n 0.000525 58.4900n 0.000619
+ 58.5000n 0.000714 58.5100n 0.000807 58.5200n 0.000899 58.5300n 0.000987 58.5400n 0.001072 58.5500n 0.001151 58.5600n 0.001223 58.5700n 0.001288 58.5800n 0.001344 58.5900n 0.001389 58.6000n 0.001424 58.6100n 0.001446 58.6200n 0.001454 58.6300n 0.001448 58.6400n 0.001427
+ 58.6500n 0.001390 58.6600n 0.001337 58.6700n 0.001267 58.6800n 0.001180 58.6900n 0.001076 58.7000n 0.000955 58.7100n 0.000820 58.7200n 0.000669 58.7300n 0.000504 58.7400n 0.000327 58.7500n 0.000139 58.7600n -0.000058 58.7700n -0.000261 58.7800n -0.000469 58.7900n -0.000679
+ 58.8000n -0.000889 58.8100n -0.001095 58.8200n -0.001296 58.8300n -0.001487 58.8400n -0.001668 58.8500n -0.001834 58.8600n -0.001984 58.8700n -0.002115 58.8800n -0.002226 58.8900n -0.002313 58.9000n -0.002377 58.9100n -0.002415 58.9200n -0.002428 58.9300n -0.002414 58.9400n -0.002374
+ 58.9500n -0.002309 58.9600n -0.002220 58.9700n -0.002107 58.9800n -0.001974 58.9900n -0.001822 59.0000n -0.001654 59.0100n -0.001472 59.0200n -0.001282 59.0300n -0.001084 59.0400n -0.000885 59.0500n -0.000686 59.0600n -0.000493 59.0700n -0.000308 59.0800n -0.000135 59.0900n 0.000022
+ 59.1000n 0.000160 59.1100n 0.000276 59.1200n 0.000369 59.1300n 0.000435 59.1400n 0.000474 59.1500n 0.000485 59.1600n 0.000467 59.1700n 0.000420 59.1800n 0.000346 59.1900n 0.000246 59.2000n 0.000121 59.2100n -0.000025 59.2200n -0.000191 59.2300n -0.000371 59.2400n -0.000564
+ 59.2500n -0.000764 59.2600n -0.000968 59.2700n -0.001171 59.2800n -0.001368 59.2900n -0.001555 59.3000n -0.001729 59.3100n -0.001884 59.3200n -0.002018 59.3300n -0.002127 59.3400n -0.002207 59.3500n -0.002258 59.3600n -0.002277 59.3700n -0.002263 59.3800n -0.002216 59.3900n -0.002135
+ 59.4000n -0.002023 59.4100n -0.001880 59.4200n -0.001709 59.4300n -0.001512 59.4400n -0.001294 59.4500n -0.001057 59.4600n -0.000807 59.4700n -0.000547 59.4800n -0.000283 59.4900n -0.000019 59.5000n 0.000239 59.5100n 0.000487 59.5200n 0.000720 59.5300n 0.000933 59.5400n 0.001124
+ 59.5500n 0.001287 59.5600n 0.001421 59.5700n 0.001523 59.5800n 0.001591 59.5900n 0.001623 59.6000n 0.001621 59.6100n 0.001584 59.6200n 0.001513 59.6300n 0.001411 59.6400n 0.001280 59.6500n 0.001123 59.6600n 0.000943 59.6700n 0.000746 59.6800n 0.000535 59.6900n 0.000315
+ 59.7000n 0.000091 59.7100n -0.000131 59.7200n -0.000346 59.7300n -0.000551 59.7400n -0.000740 59.7500n -0.000908 59.7600n -0.001053 59.7700n -0.001170 59.7800n -0.001258 59.7900n -0.001315 59.8000n -0.001338 59.8100n -0.001328 59.8200n -0.001284 59.8300n -0.001208 59.8400n -0.001102
+ 59.8500n -0.000968 59.8600n -0.000809 59.8700n -0.000628 59.8800n -0.000430 59.8900n -0.000220 59.9000n -0.000001 59.9100n 0.000220 59.9200n 0.000440 59.9300n 0.000652 59.9400n 0.000852 59.9500n 0.001036 59.9600n 0.001199 59.9700n 0.001336 59.9800n 0.001446 59.9900n 0.001525
+ 60.0000n 0.001571 60.0100n 0.001583 60.0200n 0.001560 60.0300n 0.001503 60.0400n 0.001413 60.0500n 0.001291 60.0600n 0.001141 60.0700n 0.000964 60.0800n 0.000766 60.0900n 0.000550 60.1000n 0.000320 60.1100n 0.000082 60.1200n -0.000159 60.1300n -0.000398 60.1400n -0.000629
+ 60.1500n -0.000848 60.1600n -0.001049 60.1700n -0.001228 60.1800n -0.001381 60.1900n -0.001505 60.2000n -0.001596 60.2100n -0.001651 60.2200n -0.001671 60.2300n -0.001653 60.2400n -0.001597 60.2500n -0.001505 60.2600n -0.001378 60.2700n -0.001217 60.2800n -0.001026 60.2900n -0.000808
+ 60.3000n -0.000568 60.3100n -0.000308 60.3200n -0.000035 60.3300n 0.000247 60.3400n 0.000533 60.3500n 0.000817 60.3600n 0.001096 60.3700n 0.001363 60.3800n 0.001614 60.3900n 0.001846 60.4000n 0.002054 60.4100n 0.002235 60.4200n 0.002386 60.4300n 0.002507 60.4400n 0.002594
+ 60.4500n 0.002648 60.4600n 0.002670 60.4700n 0.002658 60.4800n 0.002616 60.4900n 0.002544 60.5000n 0.002445 60.5100n 0.002323 60.5200n 0.002181 60.5300n 0.002021 60.5400n 0.001849 60.5500n 0.001667 60.5600n 0.001481 60.5700n 0.001293 60.5800n 0.001108 60.5900n 0.000929
+ 60.6000n 0.000760 60.6100n 0.000603 60.6200n 0.000460 60.6300n 0.000334 60.6400n 0.000226 60.6500n 0.000137 60.6600n 0.000066 60.6700n 0.000015 60.6800n -0.000019 60.6900n -0.000036 60.7000n -0.000038 60.7100n -0.000027 60.7200n -0.000005 60.7300n 0.000025 60.7400n 0.000060
+ 60.7500n 0.000098 60.7600n 0.000135 60.7700n 0.000169 60.7800n 0.000197 60.7900n 0.000218 60.8000n 0.000228 60.8100n 0.000226 60.8200n 0.000211 60.8300n 0.000181 60.8400n 0.000137 60.8500n 0.000079 60.8600n 0.000006 60.8700n -0.000079 60.8800n -0.000176 60.8900n -0.000283
+ 60.9000n -0.000397 60.9100n -0.000517 60.9200n -0.000638 60.9300n -0.000759 60.9400n -0.000875 60.9500n -0.000985 60.9600n -0.001085 60.9700n -0.001171 60.9800n -0.001243 60.9900n -0.001296 61.0000n -0.001328 61.0100n -0.001339 61.0200n -0.001327 61.0300n -0.001291 61.0400n -0.001230
+ 61.0500n -0.001146 61.0600n -0.001038 61.0700n -0.000908 61.0800n -0.000757 61.0900n -0.000588 61.1000n -0.000404 61.1100n -0.000206 61.1200n 0.000001 61.1300n 0.000215 61.1400n 0.000432 61.1500n 0.000648 61.1600n 0.000860 61.1700n 0.001065 61.1800n 0.001258 61.1900n 0.001438
+ 61.2000n 0.001601 61.2100n 0.001745 61.2200n 0.001868 61.2300n 0.001968 61.2400n 0.002045 61.2500n 0.002098 61.2600n 0.002127 61.2700n 0.002132 61.2800n 0.002115 61.2900n 0.002076 61.3000n 0.002018 61.3100n 0.001943 61.3200n 0.001853 61.3300n 0.001751 61.3400n 0.001639
+ 61.3500n 0.001522 61.3600n 0.001401 61.3700n 0.001280 61.3800n 0.001162 61.3900n 0.001050 61.4000n 0.000945 61.4100n 0.000851 61.4200n 0.000769 61.4300n 0.000701 61.4400n 0.000647 61.4500n 0.000609 61.4600n 0.000587 61.4700n 0.000580 61.4800n 0.000588 61.4900n 0.000611
+ 61.5000n 0.000645 61.5100n 0.000691 61.5200n 0.000746 61.5300n 0.000808 61.5400n 0.000874 61.5500n 0.000942 61.5600n 0.001011 61.5700n 0.001076 61.5800n 0.001137 61.5900n 0.001190 61.6000n 0.001235 61.6100n 0.001268 61.6200n 0.001289 61.6300n 0.001297 61.6400n 0.001290
+ 61.6500n 0.001269 61.6600n 0.001234 61.6700n 0.001184 61.6800n 0.001120 61.6900n 0.001045 61.7000n 0.000958 61.7100n 0.000861 61.7200n 0.000757 61.7300n 0.000647 61.7400n 0.000534 61.7500n 0.000420 61.7600n 0.000306 61.7700n 0.000196 61.7800n 0.000091 61.7900n -0.000006
+ 61.8000n -0.000094 61.8100n -0.000172 61.8200n -0.000238 61.8300n -0.000291 61.8400n -0.000330 61.8500n -0.000356 61.8600n -0.000368 61.8700n -0.000367 61.8800n -0.000353 61.8900n -0.000328 61.9000n -0.000292 61.9100n -0.000247 61.9200n -0.000195 61.9300n -0.000138 61.9400n -0.000078
+ 61.9500n -0.000016 61.9600n 0.000045 61.9700n 0.000103 61.9800n 0.000156 61.9900n 0.000202 62.0000n 0.000241 62.0100n 0.000270 62.0200n 0.000288 62.0300n 0.000294 62.0400n 0.000288 62.0500n 0.000269 62.0600n 0.000237 62.0700n 0.000193 62.0800n 0.000137 62.0900n 0.000069
+ 62.1000n -0.000009 62.1100n -0.000096 62.1200n -0.000191 62.1300n -0.000292 62.1400n -0.000398 62.1500n -0.000508 62.1600n -0.000619 62.1700n -0.000731 62.1800n -0.000841 62.1900n -0.000949 62.2000n -0.001053 62.2100n -0.001151 62.2200n -0.001245 62.2300n -0.001331 62.2400n -0.001411
+ 62.2500n -0.001483 62.2600n -0.001548 62.2700n -0.001605 62.2800n -0.001656 62.2900n -0.001700 62.3000n -0.001738 62.3100n -0.001770 62.3200n -0.001798 62.3300n -0.001822 62.3400n -0.001842 62.3500n -0.001859 62.3600n -0.001874 62.3700n -0.001887 62.3800n -0.001899 62.3900n -0.001909
+ 62.4000n -0.001918 62.4100n -0.001926 62.4200n -0.001932 62.4300n -0.001935 62.4400n -0.001936 62.4500n -0.001933 62.4600n -0.001925 62.4700n -0.001911 62.4800n -0.001890 62.4900n -0.001861 62.5000n -0.001824 62.5100n -0.001776 62.5200n -0.001716 62.5300n -0.001645 62.5400n -0.001561
+ 62.5500n -0.001464 62.5600n -0.001354 62.5700n -0.001230 62.5800n -0.001093 62.5900n -0.000944 62.6000n -0.000784 62.6100n -0.000613 62.6200n -0.000433 62.6300n -0.000247 62.6400n -0.000056 62.6500n 0.000138 62.6600n 0.000332 62.6700n 0.000523 62.6800n 0.000709 62.6900n 0.000887
+ 62.7000n 0.001054 62.7100n 0.001208 62.7200n 0.001346 62.7300n 0.001466 62.7400n 0.001565 62.7500n 0.001643 62.7600n 0.001698 62.7700n 0.001728 62.7800n 0.001734 62.7900n 0.001714 62.8000n 0.001670 62.8100n 0.001603 62.8200n 0.001512 62.8300n 0.001401 62.8400n 0.001270
+ 62.8500n 0.001124 62.8600n 0.000963 62.8700n 0.000792 62.8800n 0.000613 62.8900n 0.000430 62.9000n 0.000247 62.9100n 0.000066 62.9200n -0.000108 62.9300n -0.000273 62.9400n -0.000425 62.9500n -0.000562 62.9600n -0.000681 62.9700n -0.000779 62.9800n -0.000857 62.9900n -0.000911
+ 63.0000n -0.000941 63.0100n -0.000948 63.0200n -0.000930 63.0300n -0.000890 63.0400n -0.000827 63.0500n -0.000745 63.0600n -0.000644 63.0700n -0.000527 63.0800n -0.000397 63.0900n -0.000257 63.1000n -0.000110 63.1100n 0.000042 63.1200n 0.000195 63.1300n 0.000345 63.1400n 0.000490
+ 63.1500n 0.000627 63.1600n 0.000753 63.1700n 0.000866 63.1800n 0.000964 63.1900n 0.001046 63.2000n 0.001110 63.2100n 0.001156 63.2200n 0.001184 63.2300n 0.001193 63.2400n 0.001184 63.2500n 0.001159 63.2600n 0.001119 63.2700n 0.001065 63.2800n 0.001000 63.2900n 0.000926
+ 63.3000n 0.000845 63.3100n 0.000760 63.3200n 0.000673 63.3300n 0.000587 63.3400n 0.000505 63.3500n 0.000428 63.3600n 0.000359 63.3700n 0.000299 63.3800n 0.000249 63.3900n 0.000212 63.4000n 0.000187 63.4100n 0.000174 63.4200n 0.000174 63.4300n 0.000186 63.4400n 0.000208
+ 63.4500n 0.000241 63.4600n 0.000281 63.4700n 0.000327 63.4800n 0.000377 63.4900n 0.000429 63.5000n 0.000480 63.5100n 0.000528 63.5200n 0.000570 63.5300n 0.000604 63.5400n 0.000628 63.5500n 0.000641 63.5600n 0.000640 63.5700n 0.000624 63.5800n 0.000593 63.5900n 0.000546
+ 63.6000n 0.000483 63.6100n 0.000404 63.6200n 0.000311 63.6300n 0.000205 63.6400n 0.000087 63.6500n -0.000040 63.6600n -0.000173 63.6700n -0.000310 63.6800n -0.000449 63.6900n -0.000585 63.7000n -0.000716 63.7100n -0.000838 63.7200n -0.000948 63.7300n -0.001044 63.7400n -0.001123
+ 63.7500n -0.001182 63.7600n -0.001219 63.7700n -0.001233 63.7800n -0.001223 63.7900n -0.001188 63.8000n -0.001129 63.8100n -0.001045 63.8200n -0.000938 63.8300n -0.000811 63.8400n -0.000664 63.8500n -0.000501 63.8600n -0.000325 63.8700n -0.000140 63.8800n 0.000052 63.8900n 0.000244
+ 63.9000n 0.000434 63.9100n 0.000617 63.9200n 0.000789 63.9300n 0.000945 63.9400n 0.001083 63.9500n 0.001198 63.9600n 0.001287 63.9700n 0.001347 63.9800n 0.001377 63.9900n 0.001375 64.0000n 0.001341 64.0100n 0.001273 64.0200n 0.001172 64.0300n 0.001040 64.0400n 0.000879
+ 64.0500n 0.000690 64.0600n 0.000476 64.0700n 0.000243 64.0800n -0.000008 64.0900n -0.000271 64.1000n -0.000541 64.1100n -0.000814 64.1200n -0.001085 64.1300n -0.001349 64.1400n -0.001601 64.1500n -0.001836 64.1600n -0.002051 64.1700n -0.002240 64.1800n -0.002401 64.1900n -0.002531
+ 64.2000n -0.002627 64.2100n -0.002688 64.2200n -0.002713 64.2300n -0.002701 64.2400n -0.002653 64.2500n -0.002570 64.2600n -0.002454 64.2700n -0.002307 64.2800n -0.002133 64.2900n -0.001934 64.3000n -0.001715 64.3100n -0.001480 64.3200n -0.001233 64.3300n -0.000980 64.3400n -0.000724
+ 64.3500n -0.000471 64.3600n -0.000224 64.3700n 0.000011 64.3800n 0.000231 64.3900n 0.000432 64.4000n 0.000611 64.4100n 0.000765 64.4200n 0.000893 64.4300n 0.000993 64.4400n 0.001064 64.4500n 0.001106 64.4600n 0.001121 64.4700n 0.001107 64.4800n 0.001068 64.4900n 0.001006
+ 64.5000n 0.000922 64.5100n 0.000821 64.5200n 0.000705 64.5300n 0.000577 64.5400n 0.000442 64.5500n 0.000303 64.5600n 0.000164 64.5700n 0.000027 64.5800n -0.000103 64.5900n -0.000224 64.6000n -0.000333 64.6100n -0.000428 64.6200n -0.000507 64.6300n -0.000569 64.6400n -0.000614
+ 64.6500n -0.000640 64.6600n -0.000649 64.6700n -0.000642 64.6800n -0.000619 64.6900n -0.000583 64.7000n -0.000536 64.7100n -0.000480 64.7200n -0.000418 64.7300n -0.000353 64.7400n -0.000289 64.7500n -0.000228 64.7600n -0.000174 64.7700n -0.000129 64.7800n -0.000097 64.7900n -0.000080
+ 64.8000n -0.000079 64.8100n -0.000097 64.8200n -0.000135 64.8300n -0.000194 64.8400n -0.000274 64.8500n -0.000374 64.8600n -0.000495 64.8700n -0.000633 64.8800n -0.000789 64.8900n -0.000959 64.9000n -0.001141 64.9100n -0.001331 64.9200n -0.001527 64.9300n -0.001724 64.9400n -0.001920
+ 64.9500n -0.002109 64.9600n -0.002288 64.9700n -0.002454 64.9800n -0.002603 64.9900n -0.002731 65.0000n -0.002837 65.0100n -0.002916 65.0200n -0.002967 65.0300n -0.002988 65.0400n -0.002978 65.0500n -0.002937 65.0600n -0.002864 65.0700n -0.002760 65.0800n -0.002626 65.0900n -0.002464
+ 65.1000n -0.002275 65.1100n -0.002064 65.1200n -0.001832 65.1300n -0.001582 65.1400n -0.001320 65.1500n -0.001047 65.1600n -0.000770 65.1700n -0.000491 65.1800n -0.000214 65.1900n 0.000055 65.2000n 0.000314 65.2100n 0.000559 65.2200n 0.000787 65.2300n 0.000995 65.2400n 0.001179
+ 65.2500n 0.001339 65.2600n 0.001472 65.2700n 0.001578 65.2800n 0.001656 65.2900n 0.001705 65.3000n 0.001727 65.3100n 0.001722 65.3200n 0.001691 65.3300n 0.001637 65.3400n 0.001561 65.3500n 0.001465 65.3600n 0.001353 65.3700n 0.001228 65.3800n 0.001092 65.3900n 0.000949
+ 65.4000n 0.000801 65.4100n 0.000652 65.4200n 0.000505 65.4300n 0.000363 65.4400n 0.000228 65.4500n 0.000102 65.4600n -0.000012 65.4700n -0.000112 65.4800n -0.000197 65.4900n -0.000267 65.5000n -0.000320 65.5100n -0.000356 65.5200n -0.000375 65.5300n -0.000377 65.5400n -0.000364
+ 65.5500n -0.000336 65.5600n -0.000294 65.5700n -0.000240 65.5800n -0.000175 65.5900n -0.000102 65.6000n -0.000021 65.6100n 0.000064 65.6200n 0.000151 65.6300n 0.000240 65.6400n 0.000328 65.6500n 0.000413 65.6600n 0.000494 65.6700n 0.000569 65.6800n 0.000636 65.6900n 0.000696
+ 65.7000n 0.000746 65.7100n 0.000786 65.7200n 0.000816 65.7300n 0.000835 65.7400n 0.000843 65.7500n 0.000842 65.7600n 0.000830 65.7700n 0.000809 65.7800n 0.000779 65.7900n 0.000741 65.8000n 0.000697 65.8100n 0.000647 65.8200n 0.000592 65.8300n 0.000534 65.8400n 0.000474
+ 65.8500n 0.000413 65.8600n 0.000352 65.8700n 0.000292 65.8800n 0.000235 65.8900n 0.000181 65.9000n 0.000132 65.9100n 0.000087 65.9200n 0.000048 65.9300n 0.000015 65.9400n -0.000011 65.9500n -0.000030 65.9600n -0.000043 65.9700n -0.000049 65.9800n -0.000048 65.9900n -0.000040
+ 66.0000n -0.000027 66.0100n -0.000007 66.0200n 0.000017 66.0300n 0.000045 66.0400n 0.000078 66.0500n 0.000113 66.0600n 0.000149 66.0700n 0.000187 66.0800n 0.000225 66.0900n 0.000262 66.1000n 0.000298 66.1100n 0.000330 66.1200n 0.000359 66.1300n 0.000383 66.1400n 0.000402
+ 66.1500n 0.000414 66.1600n 0.000420 66.1700n 0.000418 66.1800n 0.000408 66.1900n 0.000389 66.2000n 0.000362 66.2100n 0.000325 66.2200n 0.000280 66.2300n 0.000225 66.2400n 0.000162 66.2500n 0.000090 66.2600n 0.000011 66.2700n -0.000076 66.2800n -0.000169 66.2900n -0.000267
+ 66.3000n -0.000369 66.3100n -0.000475 66.3200n -0.000581 66.3300n -0.000688 66.3400n -0.000793 66.3500n -0.000895 66.3600n -0.000991 66.3700n -0.001081 66.3800n -0.001163 66.3900n -0.001235 66.4000n -0.001294 66.4100n -0.001341 66.4200n -0.001372 66.4300n -0.001388 66.4400n -0.001386
+ 66.4500n -0.001367 66.4600n -0.001328 66.4700n -0.001270 66.4800n -0.001193 66.4900n -0.001096 66.5000n -0.000979 66.5100n -0.000844 66.5200n -0.000692 66.5300n -0.000522 66.5400n -0.000337 66.5500n -0.000139 66.5600n 0.000072 66.5700n 0.000292 66.5800n 0.000520 66.5900n 0.000752
+ 66.6000n 0.000988 66.6100n 0.001224 66.6200n 0.001457 66.6300n 0.001686 66.6400n 0.001907 66.6500n 0.002118 66.6600n 0.002318 66.6700n 0.002503 66.6800n 0.002672 66.6900n 0.002824 66.7000n 0.002957 66.7100n 0.003070 66.7200n 0.003162 66.7300n 0.003233 66.7400n 0.003283
+ 66.7500n 0.003312 66.7600n 0.003321 66.7700n 0.003310 66.7800n 0.003280 66.7900n 0.003233 66.8000n 0.003171 66.8100n 0.003095 66.8200n 0.003007 66.8300n 0.002909 66.8400n 0.002803 66.8500n 0.002692 66.8600n 0.002578 66.8700n 0.002461 66.8800n 0.002345 66.8900n 0.002232
+ 66.9000n 0.002122 66.9100n 0.002018 66.9200n 0.001920 66.9300n 0.001830 66.9400n 0.001748 66.9500n 0.001674 66.9600n 0.001610 66.9700n 0.001554 66.9800n 0.001507 66.9900n 0.001469 67.0000n 0.001437 67.0100n 0.001413 67.0200n 0.001394 67.0300n 0.001380 67.0400n 0.001369
+ 67.0500n 0.001360 67.0600n 0.001353 67.0700n 0.001346 67.0800n 0.001339 67.0900n 0.001329 67.1000n 0.001318 67.1100n 0.001303 67.1200n 0.001285 67.1300n 0.001264 67.1400n 0.001240 67.1500n 0.001212 67.1600n 0.001182 67.1700n 0.001150 67.1800n 0.001116 67.1900n 0.001083
+ 67.2000n 0.001050 67.2100n 0.001020 67.2200n 0.000993 67.2300n 0.000970 67.2400n 0.000953 67.2500n 0.000943 67.2600n 0.000941 67.2700n 0.000947 67.2800n 0.000963 67.2900n 0.000988 67.3000n 0.001024 67.3100n 0.001069 67.3200n 0.001124 67.3300n 0.001188 67.3400n 0.001261
+ 67.3500n 0.001340 67.3600n 0.001425 67.3700n 0.001514 67.3800n 0.001606 67.3900n 0.001697 67.4000n 0.001787 67.4100n 0.001873 67.4200n 0.001952 67.4300n 0.002023 67.4400n 0.002084 67.4500n 0.002132 67.4600n 0.002166 67.4700n 0.002184 67.4800n 0.002185 67.4900n 0.002168
+ 67.5000n 0.002133 67.5100n 0.002079 67.5200n 0.002006 67.5300n 0.001916 67.5400n 0.001808 67.5500n 0.001685 67.5600n 0.001547 67.5700n 0.001398 67.5800n 0.001240 67.5900n 0.001074 67.6000n 0.000905 67.6100n 0.000735 67.6200n 0.000567 67.6300n 0.000404 67.6400n 0.000249
+ 67.6500n 0.000106 67.6600n -0.000023 67.6700n -0.000135 67.6800n -0.000229 67.6900n -0.000302 67.7000n -0.000352 67.7100n -0.000380 67.7200n -0.000384 67.7300n -0.000365 67.7400n -0.000322 67.7500n -0.000257 67.7600n -0.000172 67.7700n -0.000068 67.7800n 0.000052 67.7900n 0.000186
+ 67.8000n 0.000329 67.8100n 0.000480 67.8200n 0.000634 67.8300n 0.000788 67.8400n 0.000937 67.8500n 0.001078 67.8600n 0.001208 67.8700n 0.001322 67.8800n 0.001419 67.8900n 0.001494 67.9000n 0.001546 67.9100n 0.001572 67.9200n 0.001572 67.9300n 0.001544 67.9400n 0.001487
+ 67.9500n 0.001403 67.9600n 0.001292 67.9700n 0.001155 67.9800n 0.000995 67.9900n 0.000813 68.0000n 0.000613 68.0100n 0.000398 68.0200n 0.000172 68.0300n -0.000062 68.0400n -0.000299 68.0500n -0.000535 68.0600n -0.000766 68.0700n -0.000987 68.0800n -0.001195 68.0900n -0.001387
+ 68.1000n -0.001558 68.1100n -0.001705 68.1200n -0.001827 68.1300n -0.001920 68.1400n -0.001985 68.1500n -0.002019 68.1600n -0.002022 68.1700n -0.001995 68.1800n -0.001938 68.1900n -0.001853 68.2000n -0.001743 68.2100n -0.001608 68.2200n -0.001453 68.2300n -0.001281 68.2400n -0.001094
+ 68.2500n -0.000898 68.2600n -0.000695 68.2700n -0.000490 68.2800n -0.000287 68.2900n -0.000090 68.3000n 0.000099 68.3100n 0.000275 68.3200n 0.000435 68.3300n 0.000578 68.3400n 0.000701 68.3500n 0.000801 68.3600n 0.000879 68.3700n 0.000934 68.3800n 0.000965 68.3900n 0.000974
+ 68.4000n 0.000960 68.4100n 0.000926 68.4200n 0.000874 68.4300n 0.000805 68.4400n 0.000723 68.4500n 0.000630 68.4600n 0.000530 68.4700n 0.000425 68.4800n 0.000318 68.4900n 0.000214 68.5000n 0.000114 68.5100n 0.000021 68.5200n -0.000061 68.5300n -0.000132 68.5400n -0.000188
+ 68.5500n -0.000230 68.5600n -0.000256 68.5700n -0.000265 68.5800n -0.000258 68.5900n -0.000235 68.6000n -0.000198 68.6100n -0.000148 68.6200n -0.000087 68.6300n -0.000016 68.6400n 0.000060 68.6500n 0.000141 68.6600n 0.000222 68.6700n 0.000301 68.6800n 0.000374 68.6900n 0.000440
+ 68.7000n 0.000494 68.7100n 0.000534 68.7200n 0.000559 68.7300n 0.000565 68.7400n 0.000552 68.7500n 0.000518 68.7600n 0.000462 68.7700n 0.000385 68.7800n 0.000286 68.7900n 0.000167 68.8000n 0.000028 68.8100n -0.000128 68.8200n -0.000300 68.8300n -0.000484 68.8400n -0.000679
+ 68.8500n -0.000880 68.8600n -0.001084 68.8700n -0.001288 68.8800n -0.001488 68.8900n -0.001680 68.9000n -0.001861 68.9100n -0.002028 68.9200n -0.002177 68.9300n -0.002306 68.9400n -0.002411 68.9500n -0.002491 68.9600n -0.002545 68.9700n -0.002570 68.9800n -0.002567 68.9900n -0.002535
+ 69.0000n -0.002475 69.0100n -0.002387 69.0200n -0.002273 69.0300n -0.002134 69.0400n -0.001973 69.0500n -0.001792 69.0600n -0.001595 69.0700n -0.001384 69.0800n -0.001162 69.0900n -0.000933 69.1000n -0.000701 69.1100n -0.000469 69.1200n -0.000240 69.1300n -0.000017 69.1400n 0.000195
+ 69.1500n 0.000396 69.1600n 0.000582 69.1700n 0.000750 69.1800n 0.000901 69.1900n 0.001031 69.2000n 0.001140 69.2100n 0.001228 69.2200n 0.001295 69.2300n 0.001340 69.2400n 0.001365 69.2500n 0.001370 69.2600n 0.001356 69.2700n 0.001326 69.2800n 0.001280 69.2900n 0.001222
+ 69.3000n 0.001151 69.3100n 0.001072 69.3200n 0.000985 69.3300n 0.000893 69.3400n 0.000798 69.3500n 0.000702 69.3600n 0.000605 69.3700n 0.000511 69.3800n 0.000419 69.3900n 0.000331 69.4000n 0.000247 69.4100n 0.000169 69.4200n 0.000096 69.4300n 0.000029 69.4400n -0.000033
+ 69.4500n -0.000089 69.4600n -0.000142 69.4700n -0.000190 69.4800n -0.000235 69.4900n -0.000278 69.5000n -0.000319 69.5100n -0.000359 69.5200n -0.000399 69.5300n -0.000440 69.5400n -0.000482 69.5500n -0.000526 69.5600n -0.000572 69.5700n -0.000620 69.5800n -0.000670 69.5900n -0.000722
+ 69.6000n -0.000776 69.6100n -0.000830 69.6200n -0.000885 69.6300n -0.000939 69.6400n -0.000992 69.6500n -0.001042 69.6600n -0.001088 69.6700n -0.001130 69.6800n -0.001166 69.6900n -0.001194 69.7000n -0.001215 69.7100n -0.001227 69.7200n -0.001229 69.7300n -0.001220 69.7400n -0.001200
+ 69.7500n -0.001170 69.7600n -0.001127 69.7700n -0.001074 69.7800n -0.001009 69.7900n -0.000934 69.8000n -0.000850 69.8100n -0.000756 69.8200n -0.000655 69.8300n -0.000547 69.8400n -0.000433 69.8500n -0.000316 69.8600n -0.000196 69.8700n -0.000075 69.8800n 0.000046 69.8900n 0.000165
+ 69.9000n 0.000282 69.9100n 0.000394 69.9200n 0.000501 69.9300n 0.000601 69.9400n 0.000695 69.9500n 0.000781 69.9600n 0.000860 69.9700n 0.000931 69.9800n 0.000994 69.9900n 0.001049 70.0000n 0.001097 70.0100n 0.001138 70.0200n 0.001174 70.0300n 0.001204 70.0400n 0.001230
+ 70.0500n 0.001253 70.0600n 0.001273 70.0700n 0.001292 70.0800n 0.001310 70.0900n 0.001329 70.1000n 0.001349 70.1100n 0.001371 70.1200n 0.001395 70.1300n 0.001422 70.1400n 0.001452 70.1500n 0.001484 70.1600n 0.001520 70.1700n 0.001557 70.1800n 0.001597 70.1900n 0.001638
+ 70.2000n 0.001679 70.2100n 0.001719 70.2200n 0.001758 70.2300n 0.001794 70.2400n 0.001827 70.2500n 0.001854 70.2600n 0.001876 70.2700n 0.001891 70.2800n 0.001899 70.2900n 0.001898 70.3000n 0.001888 70.3100n 0.001868 70.3200n 0.001838 70.3300n 0.001799 70.3400n 0.001750
+ 70.3500n 0.001692 70.3600n 0.001626 70.3700n 0.001551 70.3800n 0.001470 70.3900n 0.001383 70.4000n 0.001291 70.4100n 0.001197 70.4200n 0.001101 70.4300n 0.001004 70.4400n 0.000910 70.4500n 0.000818 70.4600n 0.000731 70.4700n 0.000650 70.4800n 0.000575 70.4900n 0.000509
+ 70.5000n 0.000452 70.5100n 0.000404 70.5200n 0.000366 70.5300n 0.000339 70.5400n 0.000322 70.5500n 0.000315 70.5600n 0.000317 70.5700n 0.000328 70.5800n 0.000346 70.5900n 0.000371 70.6000n 0.000401 70.6100n 0.000434 70.6200n 0.000470 70.6300n 0.000506 70.6400n 0.000541
+ 70.6500n 0.000573 70.6600n 0.000600 70.6700n 0.000622 70.6800n 0.000637 70.6900n 0.000643 70.7000n 0.000640 70.7100n 0.000626 70.7200n 0.000602 70.7300n 0.000567 70.7400n 0.000521 70.7500n 0.000464 70.7600n 0.000396 70.7700n 0.000318 70.7800n 0.000232 70.7900n 0.000137
+ 70.8000n 0.000036 70.8100n -0.000071 70.8200n -0.000181 70.8300n -0.000294 70.8400n -0.000407 70.8500n -0.000520 70.8600n -0.000630 70.8700n -0.000736 70.8800n -0.000838 70.8900n -0.000933 70.9000n -0.001021 70.9100n -0.001100 70.9200n -0.001171 70.9300n -0.001232 70.9400n -0.001285
+ 70.9500n -0.001327 70.9600n -0.001361 70.9700n -0.001386 70.9800n -0.001403 70.9900n -0.001412 71.0000n -0.001415 71.0100n -0.001411 71.0200n -0.001404 71.0300n -0.001392 71.0400n -0.001379 71.0500n -0.001363 71.0600n -0.001347 71.0700n -0.001330 71.0800n -0.001315 71.0900n -0.001300
+ 71.1000n -0.001288 71.1100n -0.001277 71.1200n -0.001267 71.1300n -0.001259 71.1400n -0.001252 71.1500n -0.001245 71.1600n -0.001239 71.1700n -0.001230 71.1800n -0.001220 71.1900n -0.001206 71.2000n -0.001188 71.2100n -0.001165 71.2200n -0.001135 71.2300n -0.001097 71.2400n -0.001052
+ 71.2500n -0.000997 71.2600n -0.000932 71.2700n -0.000858 71.2800n -0.000774 71.2900n -0.000680 71.3000n -0.000576 71.3100n -0.000464 71.3200n -0.000345 71.3300n -0.000219 71.3400n -0.000089 71.3500n 0.000044 71.3600n 0.000178 71.3700n 0.000310 71.3800n 0.000440 71.3900n 0.000563
+ 71.4000n 0.000678 71.4100n 0.000782 71.4200n 0.000874 71.4300n 0.000950 71.4400n 0.001010 71.4500n 0.001051 71.4600n 0.001072 71.4700n 0.001072 71.4800n 0.001050 71.4900n 0.001005 71.5000n 0.000939 71.5100n 0.000851 71.5200n 0.000742 71.5300n 0.000614 71.5400n 0.000468
+ 71.5500n 0.000306 71.5600n 0.000131 71.5700n -0.000055 71.5800n -0.000248 71.5900n -0.000446 71.6000n -0.000645 71.6100n -0.000841 71.6200n -0.001032 71.6300n -0.001215 71.6400n -0.001385 71.6500n -0.001540 71.6600n -0.001677 71.6700n -0.001795 71.6800n -0.001890 71.6900n -0.001961
+ 71.7000n -0.002008 71.7100n -0.002028 71.7200n -0.002023 71.7300n -0.001992 71.7400n -0.001935 71.7500n -0.001855 71.7600n -0.001753 71.7700n -0.001630 71.7800n -0.001490 71.7900n -0.001334 71.8000n -0.001166 71.8100n -0.000989 71.8200n -0.000806 71.8300n -0.000620 71.8400n -0.000435
+ 71.8500n -0.000254 71.8600n -0.000080 71.8700n 0.000085 71.8800n 0.000237 71.8900n 0.000376 71.9000n 0.000498 71.9100n 0.000602 71.9200n 0.000688 71.9300n 0.000754 71.9400n 0.000802 71.9500n 0.000830 71.9600n 0.000841 71.9700n 0.000835 71.9800n 0.000813 71.9900n 0.000779
+ 72.0000n 0.000733 72.0100n 0.000679 72.0200n 0.000619 72.0300n 0.000556 72.0400n 0.000493 72.0500n 0.000431 72.0600n 0.000375 72.0700n 0.000326 72.0800n 0.000286 72.0900n 0.000258 72.1000n 0.000244 72.1100n 0.000244 72.1200n 0.000259 72.1300n 0.000290 72.1400n 0.000337
+ 72.1500n 0.000399 72.1600n 0.000476 72.1700n 0.000567 72.1800n 0.000669 72.1900n 0.000782 72.2000n 0.000902 72.2100n 0.001028 72.2200n 0.001156 72.2300n 0.001285 72.2400n 0.001410 72.2500n 0.001530 72.2600n 0.001642 72.2700n 0.001742 72.2800n 0.001829 72.2900n 0.001900
+ 72.3000n 0.001954 72.3100n 0.001988 72.3200n 0.002002 72.3300n 0.001994 72.3400n 0.001965 72.3500n 0.001914 72.3600n 0.001842 72.3700n 0.001750 72.3800n 0.001638 72.3900n 0.001508 72.4000n 0.001363 72.4100n 0.001203 72.4200n 0.001033 72.4300n 0.000853 72.4400n 0.000668
+ 72.4500n 0.000479 72.4600n 0.000290 72.4700n 0.000102 72.4800n -0.000081 72.4900n -0.000256 72.5000n -0.000422 72.5100n -0.000577 72.5200n -0.000719 72.5300n -0.000846 72.5400n -0.000958 72.5500n -0.001053 72.5600n -0.001131 72.5700n -0.001193 72.5800n -0.001238 72.5900n -0.001266
+ 72.6000n -0.001280 72.6100n -0.001279 72.6200n -0.001265 72.6300n -0.001239 72.6400n -0.001204 72.6500n -0.001160 72.6600n -0.001109 72.6700n -0.001053 72.6800n -0.000993 72.6900n -0.000932 72.7000n -0.000869 72.7100n -0.000807 72.7200n -0.000746 72.7300n -0.000688 72.7400n -0.000632
+ 72.7500n -0.000579 72.7600n -0.000529 72.7700n -0.000482 72.7800n -0.000437 72.7900n -0.000394 72.8000n -0.000353 72.8100n -0.000312 72.8200n -0.000270 72.8300n -0.000227 72.8400n -0.000181 72.8500n -0.000132 72.8600n -0.000077 72.8700n -0.000018 72.8800n 0.000048 72.8900n 0.000121
+ 72.9000n 0.000201 72.9100n 0.000289 72.9200n 0.000385 72.9300n 0.000487 72.9400n 0.000596 72.9500n 0.000712 72.9600n 0.000832 72.9700n 0.000957 72.9800n 0.001083 72.9900n 0.001211 73.0000n 0.001338 73.0100n 0.001462 73.0200n 0.001582 73.0300n 0.001696 73.0400n 0.001801
+ 73.0500n 0.001897 73.0600n 0.001981 73.0700n 0.002051 73.0800n 0.002106 73.0900n 0.002146 73.1000n 0.002168 73.1100n 0.002173 73.1200n 0.002159 73.1300n 0.002127 73.1400n 0.002076 73.1500n 0.002008 73.1600n 0.001922 73.1700n 0.001820 73.1800n 0.001703 73.1900n 0.001572
+ 73.2000n 0.001429 73.2100n 0.001275 73.2200n 0.001113 73.2300n 0.000944 73.2400n 0.000771 73.2500n 0.000595 73.2600n 0.000419 73.2700n 0.000244 73.2800n 0.000072 73.2900n -0.000095 73.3000n -0.000256 73.3100n -0.000409 73.3200n -0.000553 73.3300n -0.000688 73.3400n -0.000811
+ 73.3500n -0.000924 73.3600n -0.001026 73.3700n -0.001116 73.3800n -0.001195 73.3900n -0.001263 73.4000n -0.001321 73.4100n -0.001369 73.4200n -0.001408 73.4300n -0.001438 73.4400n -0.001462 73.4500n -0.001478 73.4600n -0.001489 73.4700n -0.001496 73.4800n -0.001498 73.4900n -0.001497
+ 73.5000n -0.001493 73.5100n -0.001487 73.5200n -0.001479 73.5300n -0.001469 73.5400n -0.001459 73.5500n -0.001446 73.5600n -0.001433 73.5700n -0.001418 73.5800n -0.001401 73.5900n -0.001383 73.6000n -0.001362 73.6100n -0.001338 73.6200n -0.001311 73.6300n -0.001281 73.6400n -0.001247
+ 73.6500n -0.001210 73.6600n -0.001168 73.6700n -0.001122 73.6800n -0.001072 73.6900n -0.001019 73.7000n -0.000962 73.7100n -0.000901 73.7200n -0.000838 73.7300n -0.000773 73.7400n -0.000706 73.7500n -0.000639 73.7600n -0.000572 73.7700n -0.000505 73.7800n -0.000441 73.7900n -0.000378
+ 73.8000n -0.000320 73.8100n -0.000265 73.8200n -0.000215 73.8300n -0.000170 73.8400n -0.000130 73.8500n -0.000096 73.8600n -0.000068 73.8700n -0.000046 73.8800n -0.000029 73.8900n -0.000017 73.9000n -0.000010 73.9100n -0.000007 73.9200n -0.000007 73.9300n -0.000009 73.9400n -0.000013
+ 73.9500n -0.000017 73.9600n -0.000020 73.9700n -0.000022 73.9800n -0.000021 73.9900n -0.000018 74.0000n -0.000010 74.0100n 0.000002 74.0200n 0.000018 74.0300n 0.000039 74.0400n 0.000065 74.0500n 0.000095 74.0600n 0.000128 74.0700n 0.000164 74.0800n 0.000201 74.0900n 0.000239
+ 74.1000n 0.000275 74.1100n 0.000307 74.1200n 0.000335 74.1300n 0.000355 74.1400n 0.000367 74.1500n 0.000367 74.1600n 0.000355 74.1700n 0.000327 74.1800n 0.000283 74.1900n 0.000221 74.2000n 0.000139 74.2100n 0.000038 74.2200n -0.000085 74.2300n -0.000228 74.2400n -0.000392
+ 74.2500n -0.000576 74.2600n -0.000779 74.2700n -0.000999 74.2800n -0.001235 74.2900n -0.001483 74.3000n -0.001741 74.3100n -0.002005 74.3200n -0.002272 74.3300n -0.002539 74.3400n -0.002801 74.3500n -0.003055 74.3600n -0.003295 74.3700n -0.003518 74.3800n -0.003721 74.3900n -0.003898
+ 74.4000n -0.004047 74.4100n -0.004165 74.4200n -0.004248 74.4300n -0.004295 74.4400n -0.004304 74.4500n -0.004273 74.4600n -0.004203 74.4700n -0.004093 74.4800n -0.003944 74.4900n -0.003759 74.5000n -0.003538 74.5100n -0.003284 74.5200n -0.003002 74.5300n -0.002695 74.5400n -0.002366
+ 74.5500n -0.002022 74.5600n -0.001666 74.5700n -0.001305 74.5800n -0.000943 74.5900n -0.000585 74.6000n -0.000238 74.6100n 0.000095 74.6200n 0.000408 74.6300n 0.000696 74.6400n 0.000957 74.6500n 0.001185 74.6600n 0.001380 74.6700n 0.001537 74.6800n 0.001657 74.6900n 0.001737
+ 74.7000n 0.001779 74.7100n 0.001782 74.7200n 0.001748 74.7300n 0.001679 74.7400n 0.001578 74.7500n 0.001448 74.7600n 0.001293 74.7700n 0.001116 74.7800n 0.000923 74.7900n 0.000718 74.8000n 0.000506 74.8100n 0.000292 74.8200n 0.000081 74.8300n -0.000122 74.8400n -0.000313
+ 74.8500n -0.000488 74.8600n -0.000644 74.8700n -0.000776 74.8800n -0.000883 74.8900n -0.000962 74.9000n -0.001013 74.9100n -0.001034 74.9200n -0.001025 74.9300n -0.000988 74.9400n -0.000923 74.9500n -0.000833 74.9600n -0.000719 74.9700n -0.000586 74.9800n -0.000437 74.9900n -0.000275
+ 75.0000n -0.000104 75.0100n 0.000070 75.0200n 0.000245 75.0300n 0.000415 75.0400n 0.000576 75.0500n 0.000724 75.0600n 0.000856 75.0700n 0.000968 75.0800n 0.001057 75.0900n 0.001121 75.1000n 0.001158 75.1100n 0.001166 75.1200n 0.001145 75.1300n 0.001095 75.1400n 0.001016
+ 75.1500n 0.000909 75.1600n 0.000777 75.1700n 0.000622 75.1800n 0.000445 75.1900n 0.000251 75.2000n 0.000042 75.2100n -0.000177 75.2200n -0.000402 75.2300n -0.000630 75.2400n -0.000856 75.2500n -0.001077 75.2600n -0.001288 75.2700n -0.001487 75.2800n -0.001669 75.2900n -0.001832
+ 75.3000n -0.001974 75.3100n -0.002093 75.3200n -0.002187 75.3300n -0.002255 75.3400n -0.002297 75.3500n -0.002313 75.3600n -0.002304 75.3700n -0.002271 75.3800n -0.002215 75.3900n -0.002140 75.4000n -0.002047 75.4100n -0.001939 75.4200n -0.001820 75.4300n -0.001692 75.4400n -0.001559
+ 75.4500n -0.001424 75.4600n -0.001291 75.4700n -0.001163 75.4800n -0.001043 75.4900n -0.000933 75.5000n -0.000837 75.5100n -0.000756 75.5200n -0.000693 75.5300n -0.000648 75.5400n -0.000622 75.5500n -0.000616 75.5600n -0.000631 75.5700n -0.000665 75.5800n -0.000718 75.5900n -0.000789
+ 75.6000n -0.000876 75.6100n -0.000978 75.6200n -0.001092 75.6300n -0.001216 75.6400n -0.001347 75.6500n -0.001484 75.6600n -0.001623 75.6700n -0.001763 75.6800n -0.001900 75.6900n -0.002033 75.7000n -0.002159 75.7100n -0.002277 75.7200n -0.002384 75.7300n -0.002479 75.7400n -0.002562
+ 75.7500n -0.002632 75.7600n -0.002688 75.7700n -0.002729 75.7800n -0.002757 75.7900n -0.002771 75.8000n -0.002772 75.8100n -0.002762 75.8200n -0.002740 75.8300n -0.002709 75.8400n -0.002669 75.8500n -0.002623 75.8600n -0.002571 75.8700n -0.002515 75.8800n -0.002456 75.8900n -0.002395
+ 75.9000n -0.002334 75.9100n -0.002274 75.9200n -0.002216 75.9300n -0.002159 75.9400n -0.002105 75.9500n -0.002054 75.9600n -0.002006 75.9700n -0.001961 75.9800n -0.001918 75.9900n -0.001876 76.0000n -0.001837 76.0100n -0.001797 76.0200n -0.001758 76.0300n -0.001718 76.0400n -0.001675
+ 76.0500n -0.001630 76.0600n -0.001581 76.0700n -0.001528 76.0800n -0.001470 76.0900n -0.001407 76.1000n -0.001337 76.1100n -0.001262 76.1200n -0.001180 76.1300n -0.001093 76.1400n -0.000999 76.1500n -0.000901 76.1600n -0.000799 76.1700n -0.000693 76.1800n -0.000585 76.1900n -0.000475
+ 76.2000n -0.000366 76.2100n -0.000258 76.2200n -0.000152 76.2300n -0.000050 76.2400n 0.000046 76.2500n 0.000135 76.2600n 0.000217 76.2700n 0.000290 76.2800n 0.000352 76.2900n 0.000404 76.3000n 0.000444 76.3100n 0.000473 76.3200n 0.000489 76.3300n 0.000492 76.3400n 0.000484
+ 76.3500n 0.000463 76.3600n 0.000431 76.3700n 0.000387 76.3800n 0.000334 76.3900n 0.000271 76.4000n 0.000200 76.4100n 0.000122 76.4200n 0.000037 76.4300n -0.000052 76.4400n -0.000145 76.4500n -0.000240 76.4600n -0.000337 76.4700n -0.000434 76.4800n -0.000530 76.4900n -0.000625
+ 76.5000n -0.000717 76.5100n -0.000806 76.5200n -0.000892 76.5300n -0.000973 76.5400n -0.001050 76.5500n -0.001123 76.5600n -0.001190 76.5700n -0.001253 76.5800n -0.001311 76.5900n -0.001364 76.6000n -0.001413 76.6100n -0.001457 76.6200n -0.001497 76.6300n -0.001532 76.6400n -0.001564
+ 76.6500n -0.001591 76.6600n -0.001615 76.6700n -0.001634 76.6800n -0.001649 76.6900n -0.001659 76.7000n -0.001665 76.7100n -0.001665 76.7200n -0.001659 76.7300n -0.001647 76.7400n -0.001629 76.7500n -0.001603 76.7600n -0.001569 76.7700n -0.001527 76.7800n -0.001476 76.7900n -0.001416
+ 76.8000n -0.001346 76.8100n -0.001267 76.8200n -0.001177 76.8300n -0.001078 76.8400n -0.000969 76.8500n -0.000851 76.8600n -0.000724 76.8700n -0.000590 76.8800n -0.000449 76.8900n -0.000302 76.9000n -0.000150 76.9100n 0.000004 76.9200n 0.000159 76.9300n 0.000314 76.9400n 0.000467
+ 76.9500n 0.000615 76.9600n 0.000758 76.9700n 0.000893 76.9800n 0.001019 76.9900n 0.001133 77.0000n 0.001235 77.0100n 0.001322 77.0200n 0.001394 77.0300n 0.001450 77.0400n 0.001489 77.0500n 0.001510 77.0600n 0.001513 77.0700n 0.001498 77.0800n 0.001466 77.0900n 0.001418
+ 77.1000n 0.001353 77.1100n 0.001274 77.1200n 0.001181 77.1300n 0.001077 77.1400n 0.000963 77.1500n 0.000841 77.1600n 0.000714 77.1700n 0.000582 77.1800n 0.000450 77.1900n 0.000318 77.2000n 0.000189 77.2100n 0.000064 77.2200n -0.000053 77.2300n -0.000162 77.2400n -0.000261
+ 77.2500n -0.000348 77.2600n -0.000424 77.2700n -0.000486 77.2800n -0.000534 77.2900n -0.000569 77.3000n -0.000590 77.3100n -0.000597 77.3200n -0.000592 77.3300n -0.000575 77.3400n -0.000546 77.3500n -0.000509 77.3600n -0.000463 77.3700n -0.000411 77.3800n -0.000354 77.3900n -0.000293
+ 77.4000n -0.000231 77.4100n -0.000170 77.4200n -0.000110 77.4300n -0.000053 77.4400n -0.000001 77.4500n 0.000045 77.4600n 0.000085 77.4700n 0.000117 77.4800n 0.000141 77.4900n 0.000156 77.5000n 0.000163 77.5100n 0.000162 77.5200n 0.000152 77.5300n 0.000135 77.5400n 0.000112
+ 77.5500n 0.000083 77.5600n 0.000049 77.5700n 0.000012 77.5800n -0.000027 77.5900n -0.000067 77.6000n -0.000107 77.6100n -0.000145 77.6200n -0.000180 77.6300n -0.000210 77.6400n -0.000236 77.6500n -0.000256 77.6600n -0.000268 77.6700n -0.000274 77.6800n -0.000272 77.6900n -0.000263
+ 77.7000n -0.000246 77.7100n -0.000222 77.7200n -0.000191 77.7300n -0.000155 77.7400n -0.000113 77.7500n -0.000067 77.7600n -0.000018 77.7700n 0.000033 77.7800n 0.000085 77.7900n 0.000136 77.8000n 0.000185 77.8100n 0.000231 77.8200n 0.000273 77.8300n 0.000309 77.8400n 0.000339
+ 77.8500n 0.000362 77.8600n 0.000378 77.8700n 0.000386 77.8800n 0.000386 77.8900n 0.000377 77.9000n 0.000361 77.9100n 0.000337 77.9200n 0.000306 77.9300n 0.000269 77.9400n 0.000226 77.9500n 0.000180 77.9600n 0.000131 77.9700n 0.000080 77.9800n 0.000029 77.9900n -0.000021
+ 78.0000n -0.000069 78.0100n -0.000113 78.0200n -0.000152 78.0300n -0.000184 78.0400n -0.000210 78.0500n -0.000226 78.0600n -0.000234 78.0700n -0.000232 78.0800n -0.000220 78.0900n -0.000198 78.1000n -0.000165 78.1100n -0.000122 78.1200n -0.000069 78.1300n -0.000007 78.1400n 0.000064
+ 78.1500n 0.000143 78.1600n 0.000229 78.1700n 0.000320 78.1800n 0.000416 78.1900n 0.000515 78.2000n 0.000616 78.2100n 0.000718 78.2200n 0.000819 78.2300n 0.000918 78.2400n 0.001014 78.2500n 0.001106 78.2600n 0.001192 78.2700n 0.001272 78.2800n 0.001344 78.2900n 0.001409
+ 78.3000n 0.001465 78.3100n 0.001512 78.3200n 0.001549 78.3300n 0.001577 78.3400n 0.001595 78.3500n 0.001603 78.3600n 0.001601 78.3700n 0.001591 78.3800n 0.001571 78.3900n 0.001542 78.4000n 0.001504 78.4100n 0.001459 78.4200n 0.001406 78.4300n 0.001346 78.4400n 0.001280
+ 78.4500n 0.001207 78.4600n 0.001129 78.4700n 0.001046 78.4800n 0.000958 78.4900n 0.000866 78.5000n 0.000771 78.5100n 0.000672 78.5200n 0.000570 78.5300n 0.000466 78.5400n 0.000360 78.5500n 0.000252 78.5600n 0.000144 78.5700n 0.000035 78.5800n -0.000074 78.5900n -0.000182
+ 78.6000n -0.000289 78.6100n -0.000394 78.6200n -0.000496 78.6300n -0.000596 78.6400n -0.000691 78.6500n -0.000781 78.6600n -0.000866 78.6700n -0.000944 78.6800n -0.001016 78.6900n -0.001079 78.7000n -0.001134 78.7100n -0.001180 78.7200n -0.001216 78.7300n -0.001242 78.7400n -0.001258
+ 78.7500n -0.001262 78.7600n -0.001256 78.7700n -0.001239 78.7800n -0.001212 78.7900n -0.001174 78.8000n -0.001127 78.8100n -0.001070 78.8200n -0.001005 78.8300n -0.000933 78.8400n -0.000854 78.8500n -0.000770 78.8600n -0.000682 78.8700n -0.000592 78.8800n -0.000501 78.8900n -0.000410
+ 78.9000n -0.000321 78.9100n -0.000235 78.9200n -0.000153 78.9300n -0.000077 78.9400n -0.000008 78.9500n 0.000053 78.9600n 0.000106 78.9700n 0.000149 78.9800n 0.000183 78.9900n 0.000206 79.0000n 0.000220 79.0100n 0.000224 79.0200n 0.000218 79.0300n 0.000203 79.0400n 0.000180
+ 79.0500n 0.000150 79.0600n 0.000113 79.0700n 0.000072 79.0800n 0.000026 79.0900n -0.000021 79.1000n -0.000070 79.1100n -0.000118 79.1200n -0.000164 79.1300n -0.000208 79.1400n -0.000246 79.1500n -0.000280 79.1600n -0.000307 79.1700n -0.000327 79.1800n -0.000339 79.1900n -0.000342
+ 79.2000n -0.000338 79.2100n -0.000325 79.2200n -0.000304 79.2300n -0.000276 79.2400n -0.000240 79.2500n -0.000199 79.2600n -0.000152 79.2700n -0.000101 79.2800n -0.000048 79.2900n 0.000007 79.3000n 0.000062 79.3100n 0.000116 79.3200n 0.000167 79.3300n 0.000215 79.3400n 0.000257
+ 79.3500n 0.000294 79.3600n 0.000324 79.3700n 0.000347 79.3800n 0.000362 79.3900n 0.000368 79.4000n 0.000367 79.4100n 0.000357 79.4200n 0.000340 79.4300n 0.000316 79.4400n 0.000285 79.4500n 0.000249 79.4600n 0.000209 79.4700n 0.000166 79.4800n 0.000122 79.4900n 0.000077
+ 79.5000n 0.000033 79.5100n -0.000008 79.5200n -0.000045 79.5300n -0.000078 79.5400n -0.000104 79.5500n -0.000123 79.5600n -0.000134 79.5700n -0.000137 79.5800n -0.000131 79.5900n -0.000116 79.6000n -0.000093 79.6100n -0.000061 79.6200n -0.000021 79.6300n 0.000025 79.6400n 0.000077
+ 79.6500n 0.000134 79.6600n 0.000194 79.6700n 0.000256 79.6800n 0.000318 79.6900n 0.000379 79.7000n 0.000437 79.7100n 0.000491 79.7200n 0.000540 79.7300n 0.000582 79.7400n 0.000616 79.7500n 0.000642 79.7600n 0.000658 79.7700n 0.000665 79.7800n 0.000662 79.7900n 0.000649
+ 79.8000n 0.000627 79.8100n 0.000597 79.8200n 0.000560 79.8300n 0.000516 79.8400n 0.000467 79.8500n 0.000416 79.8600n 0.000363 79.8700n 0.000310 79.8800n 0.000260 79.8900n 0.000214 79.9000n 0.000174 79.9100n 0.000142 79.9200n 0.000119 79.9300n 0.000107 79.9400n 0.000107
+ 79.9500n 0.000119 79.9600n 0.000145 79.9700n 0.000184 79.9800n 0.000237 79.9900n 0.000302 80.0000n 0.000380 80.0100n 0.000469 80.0200n 0.000568 80.0300n 0.000675 80.0400n 0.000787 80.0500n 0.000903 80.0600n 0.001021 80.0700n 0.001137 80.0800n 0.001250 80.0900n 0.001356
+ 80.1000n 0.001454 80.1100n 0.001541 80.1200n 0.001615 80.1300n 0.001674 80.1400n 0.001716 80.1500n 0.001741 80.1600n 0.001747 80.1700n 0.001734 80.1800n 0.001702 80.1900n 0.001651 80.2000n 0.001582 80.2100n 0.001497 80.2200n 0.001397 80.2300n 0.001284 80.2400n 0.001160
+ 80.2500n 0.001029 80.2600n 0.000893 80.2700n 0.000755 80.2800n 0.000618 80.2900n 0.000486 80.3000n 0.000361 80.3100n 0.000247 80.3200n 0.000146 80.3300n 0.000060 80.3400n -0.000007 80.3500n -0.000056 80.3600n -0.000083 80.3700n -0.000089 80.3800n -0.000073 80.3900n -0.000036
+ 80.4000n 0.000023 80.4100n 0.000101 80.4200n 0.000196 80.4300n 0.000307 80.4400n 0.000431 80.4500n 0.000565 80.4600n 0.000704 80.4700n 0.000846 80.4800n 0.000988 80.4900n 0.001124 80.5000n 0.001251 80.5100n 0.001365 80.5200n 0.001464 80.5300n 0.001543 80.5400n 0.001600
+ 80.5500n 0.001632 80.5600n 0.001638 80.5700n 0.001616 80.5800n 0.001566 80.5900n 0.001486 80.6000n 0.001379 80.6100n 0.001244 80.6200n 0.001084 80.6300n 0.000901 80.6400n 0.000699 80.6500n 0.000480 80.6600n 0.000249 80.6700n 0.000009 80.6800n -0.000233 80.6900n -0.000475
+ 80.7000n -0.000710 80.7100n -0.000933 80.7200n -0.001141 80.7300n -0.001329 80.7400n -0.001491 80.7500n -0.001626 80.7600n -0.001728 80.7700n -0.001796 80.7800n -0.001827 80.7900n -0.001821 80.8000n -0.001775 80.8100n -0.001692 80.8200n -0.001570 80.8300n -0.001413 80.8400n -0.001222
+ 80.8500n -0.001000 80.8600n -0.000752 80.8700n -0.000480 80.8800n -0.000191 80.8900n 0.000112 80.9000n 0.000422 80.9100n 0.000734 80.9200n 0.001042 80.9300n 0.001342 80.9400n 0.001626 80.9500n 0.001891 80.9600n 0.002132 80.9700n 0.002343 80.9800n 0.002522 80.9900n 0.002665
+ 81.0000n 0.002769 81.0100n 0.002833 81.0200n 0.002856 81.0300n 0.002837 81.0400n 0.002777 81.0500n 0.002678 81.0600n 0.002540 81.0700n 0.002368 81.0800n 0.002163 81.0900n 0.001931 81.1000n 0.001674 81.1100n 0.001398 81.1200n 0.001108 81.1300n 0.000808 81.1400n 0.000505
+ 81.1500n 0.000202 81.1600n -0.000095 81.1700n -0.000381 81.1800n -0.000653 81.1900n -0.000906 81.2000n -0.001136 81.2100n -0.001341 81.2200n -0.001519 81.2300n -0.001667 81.2400n -0.001784 81.2500n -0.001871 81.2600n -0.001927 81.2700n -0.001952 81.2800n -0.001949 81.2900n -0.001919
+ 81.3000n -0.001864 81.3100n -0.001788 81.3200n -0.001692 81.3300n -0.001581 81.3400n -0.001457 81.3500n -0.001324 81.3600n -0.001186 81.3700n -0.001045 81.3800n -0.000906 81.3900n -0.000770 81.4000n -0.000641 81.4100n -0.000521 81.4200n -0.000411 81.4300n -0.000314 81.4400n -0.000229
+ 81.4500n -0.000159 81.4600n -0.000102 81.4700n -0.000058 81.4800n -0.000028 81.4900n -0.000009 81.5000n -0.000001 81.5100n -0.000002 81.5200n -0.000010 81.5300n -0.000023 81.5400n -0.000040 81.5500n -0.000058 81.5600n -0.000076 81.5700n -0.000091 81.5800n -0.000102 81.5900n -0.000108
+ 81.6000n -0.000108 81.6100n -0.000100 81.6200n -0.000085 81.6300n -0.000063 81.6400n -0.000032 81.6500n 0.000004 81.6600n 0.000047 81.6700n 0.000095 81.6800n 0.000145 81.6900n 0.000198 81.7000n 0.000250 81.7100n 0.000300 81.7200n 0.000346 81.7300n 0.000386 81.7400n 0.000418
+ 81.7500n 0.000440 81.7600n 0.000451 81.7700n 0.000450 81.7800n 0.000435 81.7900n 0.000407 81.8000n 0.000364 81.8100n 0.000307 81.8200n 0.000236 81.8300n 0.000153 81.8400n 0.000058 81.8500n -0.000046 81.8600n -0.000158 81.8700n -0.000276 81.8800n -0.000396 81.8900n -0.000517
+ 81.9000n -0.000635 81.9100n -0.000748 81.9200n -0.000852 81.9300n -0.000945 81.9400n -0.001025 81.9500n -0.001090 81.9600n -0.001136 81.9700n -0.001163 81.9800n -0.001170 81.9900n -0.001155 82.0000n -0.001119 82.0100n -0.001062 82.0200n -0.000983 82.0300n -0.000886 82.0400n -0.000771
+ 82.0500n -0.000640 82.0600n -0.000497 82.0700n -0.000344 82.0800n -0.000184 82.0900n -0.000021 82.1000n 0.000141 82.1100n 0.000300 82.1200n 0.000450 82.1300n 0.000590 82.1400n 0.000714 82.1500n 0.000821 82.1600n 0.000908 82.1700n 0.000971 82.1800n 0.001010 82.1900n 0.001023
+ 82.2000n 0.001008 82.2100n 0.000967 82.2200n 0.000899 82.2300n 0.000806 82.2400n 0.000688 82.2500n 0.000549 82.2600n 0.000390 82.2700n 0.000216 82.2800n 0.000028 82.2900n -0.000168 82.3000n -0.000369 82.3100n -0.000570 82.3200n -0.000768 82.3300n -0.000958 82.3400n -0.001135
+ 82.3500n -0.001297 82.3600n -0.001440 82.3700n -0.001560 82.3800n -0.001654 82.3900n -0.001721 82.4000n -0.001759 82.4100n -0.001767 82.4200n -0.001744 82.4300n -0.001691 82.4400n -0.001608 82.4500n -0.001498 82.4600n -0.001362 82.4700n -0.001202 82.4800n -0.001023 82.4900n -0.000827
+ 82.5000n -0.000618 82.5100n -0.000400 82.5200n -0.000178 82.5300n 0.000044 82.5400n 0.000263 82.5500n 0.000473 82.5600n 0.000671 82.5700n 0.000854 82.5800n 0.001018 82.5900n 0.001161 82.6000n 0.001279 82.6100n 0.001372 82.6200n 0.001439 82.6300n 0.001478 82.6400n 0.001490
+ 82.6500n 0.001476 82.6600n 0.001436 82.6700n 0.001372 82.6800n 0.001287 82.6900n 0.001183 82.7000n 0.001064 82.7100n 0.000931 82.7200n 0.000790 82.7300n 0.000642 82.7400n 0.000493 82.7500n 0.000344 82.7600n 0.000200 82.7700n 0.000063 82.7800n -0.000063 82.7900n -0.000177
+ 82.8000n -0.000277 82.8100n -0.000360 82.8200n -0.000427 82.8300n -0.000476 82.8400n -0.000507 82.8500n -0.000522 82.8600n -0.000521 82.8700n -0.000506 82.8800n -0.000478 82.8900n -0.000439 82.9000n -0.000393 82.9100n -0.000341 82.9200n -0.000286 82.9300n -0.000232 82.9400n -0.000181
+ 82.9500n -0.000135 82.9600n -0.000097 82.9700n -0.000069 82.9800n -0.000053 82.9900n -0.000049 83.0000n -0.000060 83.0100n -0.000085 83.0200n -0.000124 83.0300n -0.000177 83.0400n -0.000242 83.0500n -0.000319 83.0600n -0.000404 83.0700n -0.000495 83.0800n -0.000590 83.0900n -0.000685
+ 83.1000n -0.000777 83.1100n -0.000863 83.1200n -0.000939 83.1300n -0.001002 83.1400n -0.001048 83.1500n -0.001074 83.1600n -0.001078 83.1700n -0.001058 83.1800n -0.001010 83.1900n -0.000935 83.2000n -0.000831 83.2100n -0.000698 83.2200n -0.000537 83.2300n -0.000349 83.2400n -0.000135
+ 83.2500n 0.000101 83.2600n 0.000358 83.2700n 0.000631 83.2800n 0.000917 83.2900n 0.001210 83.3000n 0.001507 83.3100n 0.001803 83.3200n 0.002091 83.3300n 0.002368 83.3400n 0.002629 83.3500n 0.002868 83.3600n 0.003081 83.3700n 0.003264 83.3800n 0.003413 83.3900n 0.003526
+ 83.4000n 0.003601 83.4100n 0.003634 83.4200n 0.003626 83.4300n 0.003577 83.4400n 0.003486 83.4500n 0.003355 83.4600n 0.003186 83.4700n 0.002982 83.4800n 0.002747 83.4900n 0.002483 83.5000n 0.002196 83.5100n 0.001890 83.5200n 0.001571 83.5300n 0.001244 83.5400n 0.000914
+ 83.5500n 0.000587 83.5600n 0.000268 83.5700n -0.000038 83.5800n -0.000326 83.5900n -0.000592 83.6000n -0.000831 83.6100n -0.001042 83.6200n -0.001220 83.6300n -0.001364 83.6400n -0.001473 83.6500n -0.001546 83.6600n -0.001583 83.6700n -0.001585 83.6800n -0.001554 83.6900n -0.001491
+ 83.7000n -0.001399 83.7100n -0.001281 83.7200n -0.001142 83.7300n -0.000983 83.7400n -0.000811 83.7500n -0.000627 83.7600n -0.000438 83.7700n -0.000247 83.7800n -0.000057 83.7900n 0.000126 83.8000n 0.000301 83.8100n 0.000464 83.8200n 0.000613 83.8300n 0.000745 83.8400n 0.000859
+ 83.8500n 0.000953 83.8600n 0.001029 83.8700n 0.001085 83.8800n 0.001122 83.8900n 0.001142 83.9000n 0.001145 83.9100n 0.001135 83.9200n 0.001113 83.9300n 0.001081 83.9400n 0.001042 83.9500n 0.000999 83.9600n 0.000955 83.9700n 0.000912 83.9800n 0.000873 83.9900n 0.000840
+ 84.0000n 0.000814 84.0100n 0.000798 84.0200n 0.000792 84.0300n 0.000798 84.0400n 0.000815 84.0500n 0.000843 84.0600n 0.000882 84.0700n 0.000930 84.0800n 0.000987 84.0900n 0.001048 84.1000n 0.001114 84.1100n 0.001180 84.1200n 0.001244 84.1300n 0.001303 84.1400n 0.001353
+ 84.1500n 0.001393 84.1600n 0.001419 84.1700n 0.001428 84.1800n 0.001417 84.1900n 0.001385 84.2000n 0.001330 84.2100n 0.001250 84.2200n 0.001145 84.2300n 0.001014 84.2400n 0.000858 84.2500n 0.000678 84.2600n 0.000474 84.2700n 0.000250 84.2800n 0.000007 84.2900n -0.000252
+ 84.3000n -0.000523 84.3100n -0.000803 84.3200n -0.001087 84.3300n -0.001371 84.3400n -0.001652 84.3500n -0.001923 84.3600n -0.002182 84.3700n -0.002424 84.3800n -0.002645 84.3900n -0.002841 84.4000n -0.003009 84.4100n -0.003147 84.4200n -0.003251 84.4300n -0.003321 84.4400n -0.003356
+ 84.4500n -0.003354 84.4600n -0.003316 84.4700n -0.003243 84.4800n -0.003135 84.4900n -0.002997 84.5000n -0.002828 84.5100n -0.002634 84.5200n -0.002416 84.5300n -0.002179 84.5400n -0.001928 84.5500n -0.001665 84.5600n -0.001396 84.5700n -0.001124 84.5800n -0.000855 84.5900n -0.000592
+ 84.6000n -0.000339 84.6100n -0.000100 84.6200n 0.000122 84.6300n 0.000325 84.6400n 0.000506 84.6500n 0.000663 84.6600n 0.000795 84.6700n 0.000902 84.6800n 0.000982 84.6900n 0.001038 84.7000n 0.001068 84.7100n 0.001076 84.7200n 0.001062 84.7300n 0.001029 84.7400n 0.000979
+ 84.7500n 0.000915 84.7600n 0.000840 84.7700n 0.000756 84.7800n 0.000666 84.7900n 0.000574 84.8000n 0.000483 84.8100n 0.000393 84.8200n 0.000309 84.8300n 0.000232 84.8400n 0.000163 84.8500n 0.000104 84.8600n 0.000056 84.8700n 0.000020 84.8800n -0.000006 84.8900n -0.000021
+ 84.9000n -0.000026 84.9100n -0.000022 84.9200n -0.000010 84.9300n 0.000007 84.9400n 0.000028 84.9500n 0.000051 84.9600n 0.000073 84.9700n 0.000093 84.9800n 0.000107 84.9900n 0.000114 85.0000n 0.000112 85.0100n 0.000099 85.0200n 0.000074 85.0300n 0.000035 85.0400n -0.000018
+ 85.0500n -0.000086 85.0600n -0.000169 85.0700n -0.000267 85.0800n -0.000378 85.0900n -0.000502 85.1000n -0.000637 85.1100n -0.000782 85.1200n -0.000933 85.1300n -0.001090 85.1400n -0.001248 85.1500n -0.001405 85.1600n -0.001558 85.1700n -0.001705 85.1800n -0.001842 85.1900n -0.001967
+ 85.2000n -0.002077 85.2100n -0.002169 85.2200n -0.002242 85.2300n -0.002294 85.2400n -0.002323 85.2500n -0.002328 85.2600n -0.002310 85.2700n -0.002267 85.2800n -0.002200 85.2900n -0.002111 85.3000n -0.002000 85.3100n -0.001870 85.3200n -0.001722 85.3300n -0.001558 85.3400n -0.001383
+ 85.3500n -0.001198 85.3600n -0.001007 85.3700n -0.000814 85.3800n -0.000621 85.3900n -0.000433 85.4000n -0.000252 85.4100n -0.000083 85.4200n 0.000073 85.4300n 0.000212 85.4400n 0.000331 85.4500n 0.000429 85.4600n 0.000503 85.4700n 0.000553 85.4800n 0.000577 85.4900n 0.000576
+ 85.5000n 0.000548 85.5100n 0.000495 85.5200n 0.000418 85.5300n 0.000318 85.5400n 0.000197 85.5500n 0.000056 85.5600n -0.000101 85.5700n -0.000271 85.5800n -0.000453 85.5900n -0.000642 85.6000n -0.000835 85.6100n -0.001030 85.6200n -0.001222 85.6300n -0.001408 85.6400n -0.001586
+ 85.6500n -0.001752 85.6600n -0.001904 85.6700n -0.002039 85.6800n -0.002155 85.6900n -0.002250 85.7000n -0.002323 85.7100n -0.002372 85.7200n -0.002397 85.7300n -0.002397 85.7400n -0.002373 85.7500n -0.002325 85.7600n -0.002254 85.7700n -0.002160 85.7800n -0.002046 85.7900n -0.001913
+ 85.8000n -0.001762 85.8100n -0.001596 85.8200n -0.001418 85.8300n -0.001229 85.8400n -0.001033 85.8500n -0.000831 85.8600n -0.000627 85.8700n -0.000422 85.8800n -0.000220 85.8900n -0.000022 85.9000n 0.000169 85.9100n 0.000351 85.9200n 0.000523 85.9300n 0.000682 85.9400n 0.000827
+ 85.9500n 0.000958 85.9600n 0.001073 85.9700n 0.001171 85.9800n 0.001252 85.9900n 0.001316 86.0000n 0.001362 86.0100n 0.001391 86.0200n 0.001403 86.0300n 0.001399 86.0400n 0.001379 86.0500n 0.001344 86.0600n 0.001296 86.0700n 0.001235 86.0800n 0.001163 86.0900n 0.001080
+ 86.1000n 0.000988 86.1100n 0.000889 86.1200n 0.000783 86.1300n 0.000672 86.1400n 0.000558 86.1500n 0.000441 86.1600n 0.000322 86.1700n 0.000204 86.1800n 0.000087 86.1900n -0.000028 86.2000n -0.000140 86.2100n -0.000248 86.2200n -0.000351 86.2300n -0.000449 86.2400n -0.000541
+ 86.2500n -0.000626 86.2600n -0.000705 86.2700n -0.000777 86.2800n -0.000841 86.2900n -0.000898 86.3000n -0.000947 86.3100n -0.000989 86.3200n -0.001024 86.3300n -0.001051 86.3400n -0.001071 86.3500n -0.001085 86.3600n -0.001092 86.3700n -0.001094 86.3800n -0.001089 86.3900n -0.001080
+ 86.4000n -0.001065 86.4100n -0.001047 86.4200n -0.001024 86.4300n -0.000997 86.4400n -0.000968 86.4500n -0.000935 86.4600n -0.000900 86.4700n -0.000863 86.4800n -0.000823 86.4900n -0.000782 86.5000n -0.000739 86.5100n -0.000694 86.5200n -0.000648 86.5300n -0.000600 86.5400n -0.000550
+ 86.5500n -0.000499 86.5600n -0.000446 86.5700n -0.000391 86.5800n -0.000335 86.5900n -0.000276 86.6000n -0.000214 86.6100n -0.000151 86.6200n -0.000085 86.6300n -0.000016 86.6400n 0.000055 86.6500n 0.000128 86.6600n 0.000204 86.6700n 0.000282 86.6800n 0.000363 86.6900n 0.000445
+ 86.7000n 0.000528 86.7100n 0.000612 86.7200n 0.000696 86.7300n 0.000781 86.7400n 0.000864 86.7500n 0.000946 86.7600n 0.001025 86.7700n 0.001101 86.7800n 0.001172 86.7900n 0.001239 86.8000n 0.001300 86.8100n 0.001355 86.8200n 0.001402 86.8300n 0.001440 86.8400n 0.001471
+ 86.8500n 0.001491 86.8600n 0.001502 86.8700n 0.001502 86.8800n 0.001493 86.8900n 0.001472 86.9000n 0.001441 86.9100n 0.001399 86.9200n 0.001348 86.9300n 0.001287 86.9400n 0.001216 86.9500n 0.001138 86.9600n 0.001052 86.9700n 0.000960 86.9800n 0.000862 86.9900n 0.000760
+ 87.0000n 0.000654 87.0100n 0.000547 87.0200n 0.000439 87.0300n 0.000332 87.0400n 0.000227 87.0500n 0.000124 87.0600n 0.000026 87.0700n -0.000067 87.0800n -0.000153 87.0900n -0.000233 87.1000n -0.000306 87.1100n -0.000370 87.1200n -0.000425 87.1300n -0.000471 87.1400n -0.000508
+ 87.1500n -0.000536 87.1600n -0.000555 87.1700n -0.000565 87.1800n -0.000567 87.1900n -0.000561 87.2000n -0.000547 87.2100n -0.000527 87.2200n -0.000500 87.2300n -0.000467 87.2400n -0.000430 87.2500n -0.000389 87.2600n -0.000344 87.2700n -0.000296 87.2800n -0.000246 87.2900n -0.000195
+ 87.3000n -0.000142 87.3100n -0.000089 87.3200n -0.000035 87.3300n 0.000019 87.3400n 0.000072 87.3500n 0.000126 87.3600n 0.000179 87.3700n 0.000231 87.3800n 0.000283 87.3900n 0.000335 87.4000n 0.000386 87.4100n 0.000436 87.4200n 0.000486 87.4300n 0.000534 87.4400n 0.000581
+ 87.4500n 0.000627 87.4600n 0.000671 87.4700n 0.000713 87.4800n 0.000752 87.4900n 0.000788 87.5000n 0.000819 87.5100n 0.000845 87.5200n 0.000865 87.5300n 0.000878 87.5400n 0.000883 87.5500n 0.000880 87.5600n 0.000866 87.5700n 0.000842 87.5800n 0.000805 87.5900n 0.000756
+ 87.6000n 0.000694 87.6100n 0.000618 87.6200n 0.000527 87.6300n 0.000422 87.6400n 0.000303 87.6500n 0.000170 87.6600n 0.000024 87.6700n -0.000136 87.6800n -0.000306 87.6900n -0.000487 87.7000n -0.000677 87.7100n -0.000873 87.7200n -0.001074 87.7300n -0.001277 87.7400n -0.001481
+ 87.7500n -0.001682 87.7600n -0.001877 87.7700n -0.002065 87.7800n -0.002243 87.7900n -0.002408 87.8000n -0.002557 87.8100n -0.002689 87.8200n -0.002801 87.8300n -0.002892 87.8400n -0.002961 87.8500n -0.003005 87.8600n -0.003025 87.8700n -0.003019 87.8800n -0.002989 87.8900n -0.002935
+ 87.9000n -0.002857 87.9100n -0.002758 87.9200n -0.002639 87.9300n -0.002502 87.9400n -0.002349 87.9500n -0.002184 87.9600n -0.002010 87.9700n -0.001830 87.9800n -0.001647 87.9900n -0.001466 88.0000n -0.001289 88.0100n -0.001120 88.0200n -0.000962 88.0300n -0.000819 88.0400n -0.000693
+ 88.0500n -0.000587 88.0600n -0.000502 88.0700n -0.000442 88.0800n -0.000406 88.0900n -0.000396 88.1000n -0.000412 88.1100n -0.000454 88.1200n -0.000520 88.1300n -0.000609 88.1400n -0.000720 88.1500n -0.000850 88.1600n -0.000996 88.1700n -0.001156 88.1800n -0.001325 88.1900n -0.001501
+ 88.2000n -0.001678 88.2100n -0.001855 88.2200n -0.002026 88.2300n -0.002188 88.2400n -0.002337 88.2500n -0.002470 88.2600n -0.002583 88.2700n -0.002675 88.2800n -0.002743 88.2900n -0.002784 88.3000n -0.002799 88.3100n -0.002785 88.3200n -0.002744 88.3300n -0.002675 88.3400n -0.002579
+ 88.3500n -0.002459 88.3600n -0.002316 88.3700n -0.002152 88.3800n -0.001971 88.3900n -0.001776 88.4000n -0.001571 88.4100n -0.001359 88.4200n -0.001145 88.4300n -0.000932 88.4400n -0.000724 88.4500n -0.000526 88.4600n -0.000340 88.4700n -0.000171 88.4800n -0.000020 88.4900n 0.000109
+ 88.5000n 0.000214 88.5100n 0.000294 88.5200n 0.000348 88.5300n 0.000376 88.5400n 0.000378 88.5500n 0.000354 88.5600n 0.000306 88.5700n 0.000236 88.5800n 0.000146 88.5900n 0.000039 88.6000n -0.000081 88.6100n -0.000212 88.6200n -0.000350 88.6300n -0.000490 88.6400n -0.000629
+ 88.6500n -0.000764 88.6600n -0.000889 88.6700n -0.001003 88.6800n -0.001101 88.6900n -0.001180 88.7000n -0.001239 88.7100n -0.001276 88.7200n -0.001288 88.7300n -0.001275 88.7400n -0.001237 88.7500n -0.001174 88.7600n -0.001087 88.7700n -0.000977 88.7800n -0.000846 88.7900n -0.000698
+ 88.8000n -0.000534 88.8100n -0.000358 88.8200n -0.000173 88.8300n 0.000016 88.8400n 0.000206 88.8500n 0.000393 88.8600n 0.000573 88.8700n 0.000742 88.8800n 0.000897 88.8900n 0.001033 88.9000n 0.001150 88.9100n 0.001242 88.9200n 0.001310 88.9300n 0.001351 88.9400n 0.001365
+ 88.9500n 0.001350 88.9600n 0.001309 88.9700n 0.001240 88.9800n 0.001146 88.9900n 0.001028 89.0000n 0.000890 89.0100n 0.000734 89.0200n 0.000563 89.0300n 0.000381 89.0400n 0.000192 89.0500n 0.000000 89.0600n -0.000191 89.0700n -0.000377 89.0800n -0.000555 89.0900n -0.000720
+ 89.1000n -0.000868 89.1100n -0.000997 89.1200n -0.001104 89.1300n -0.001187 89.1400n -0.001243 89.1500n -0.001272 89.1600n -0.001273 89.1700n -0.001245 89.1800n -0.001189 89.1900n -0.001107 89.2000n -0.000999 89.2100n -0.000868 89.2200n -0.000716 89.2300n -0.000546 89.2400n -0.000361
+ 89.2500n -0.000166 89.2600n 0.000038 89.2700n 0.000245 89.2800n 0.000452 89.2900n 0.000655 89.3000n 0.000850 89.3100n 0.001034 89.3200n 0.001204 89.3300n 0.001357 89.3400n 0.001489 89.3500n 0.001600 89.3600n 0.001686 89.3700n 0.001748 89.3800n 0.001783 89.3900n 0.001792
+ 89.4000n 0.001776 89.4100n 0.001734 89.4200n 0.001667 89.4300n 0.001578 89.4400n 0.001468 89.4500n 0.001340 89.4600n 0.001195 89.4700n 0.001036 89.4800n 0.000867 89.4900n 0.000689 89.5000n 0.000507 89.5100n 0.000323 89.5200n 0.000139 89.5300n -0.000041 89.5400n -0.000215
+ 89.5500n -0.000380 89.5600n -0.000535 89.5700n -0.000677 89.5800n -0.000806 89.5900n -0.000919 89.6000n -0.001017 89.6100n -0.001097 89.6200n -0.001161 89.6300n -0.001207 89.6400n -0.001236 89.6500n -0.001249 89.6600n -0.001246 89.6700n -0.001228 89.6800n -0.001195 89.6900n -0.001149
+ 89.7000n -0.001090 89.7100n -0.001020 89.7200n -0.000940 89.7300n -0.000851 89.7400n -0.000754 89.7500n -0.000650 89.7600n -0.000539 89.7700n -0.000423 89.7800n -0.000302 89.7900n -0.000176 89.8000n -0.000047 89.8100n 0.000086 89.8200n 0.000221 89.8300n 0.000360 89.8400n 0.000501
+ 89.8500n 0.000645 89.8600n 0.000790 89.8700n 0.000938 89.8800n 0.001086 89.8900n 0.001236 89.9000n 0.001385 89.9100n 0.001535 89.9200n 0.001683 89.9300n 0.001830 89.9400n 0.001973 89.9500n 0.002112 89.9600n 0.002246 89.9700n 0.002374 89.9800n 0.002493 89.9900n 0.002603
+ 90.0000n 0.002702 90.0100n 0.002789 90.0200n 0.002861 90.0300n 0.002919 90.0400n 0.002960 90.0500n 0.002984 90.0600n 0.002990 90.0700n 0.002976 90.0800n 0.002944 90.0900n 0.002891 90.1000n 0.002819 90.1100n 0.002729 90.1200n 0.002620 90.1300n 0.002493 90.1400n 0.002351
+ 90.1500n 0.002195 90.1600n 0.002026 90.1700n 0.001847 90.1800n 0.001661 90.1900n 0.001469 90.2000n 0.001275 90.2100n 0.001081 90.2200n 0.000890 90.2300n 0.000705 90.2400n 0.000530 90.2500n 0.000365 90.2600n 0.000214 90.2700n 0.000080 90.2800n -0.000036 90.2900n -0.000133
+ 90.3000n -0.000208 90.3100n -0.000260 90.3200n -0.000290 90.3300n -0.000297 90.3400n -0.000280 90.3500n -0.000242 90.3600n -0.000181 90.3700n -0.000101 90.3800n -0.000002 90.3900n 0.000114 90.4000n 0.000244 90.4100n 0.000386 90.4200n 0.000536 90.4300n 0.000694 90.4400n 0.000855
+ 90.4500n 0.001016 90.4600n 0.001175 90.4700n 0.001329 90.4800n 0.001476 90.4900n 0.001613 90.5000n 0.001737 90.5100n 0.001847 90.5200n 0.001942 90.5300n 0.002019 90.5400n 0.002078 90.5500n 0.002118 90.5600n 0.002140 90.5700n 0.002143 90.5800n 0.002127 90.5900n 0.002093
+ 90.6000n 0.002042 90.6100n 0.001976 90.6200n 0.001896 90.6300n 0.001804 90.6400n 0.001701 90.6500n 0.001589 90.6600n 0.001470 90.6700n 0.001347 90.6800n 0.001221 90.6900n 0.001095 90.7000n 0.000968 90.7100n 0.000845 90.7200n 0.000725 90.7300n 0.000611 90.7400n 0.000503
+ 90.7500n 0.000402 90.7600n 0.000309 90.7700n 0.000225 90.7800n 0.000148 90.7900n 0.000081 90.8000n 0.000022 90.8100n -0.000029 90.8200n -0.000072 90.8300n -0.000108 90.8400n -0.000136 90.8500n -0.000159 90.8600n -0.000176 90.8700n -0.000188 90.8800n -0.000196 90.8900n -0.000200
+ 90.9000n -0.000201 90.9100n -0.000198 90.9200n -0.000192 90.9300n -0.000184 90.9400n -0.000173 90.9500n -0.000159 90.9600n -0.000142 90.9700n -0.000121 90.9800n -0.000097 90.9900n -0.000068 91.0000n -0.000035 91.0100n 0.000004 91.0200n 0.000048 91.0300n 0.000098 91.0400n 0.000154
+ 91.0500n 0.000217 91.0600n 0.000287 91.0700n 0.000364 91.0800n 0.000447 91.0900n 0.000536 91.1000n 0.000630 91.1100n 0.000730 91.1200n 0.000833 91.1300n 0.000940 91.1400n 0.001048 91.1500n 0.001157 91.1600n 0.001265 91.1700n 0.001370 91.1800n 0.001471 91.1900n 0.001567
+ 91.2000n 0.001656 91.2100n 0.001736 91.2200n 0.001806 91.2300n 0.001864 91.2400n 0.001911 91.2500n 0.001944 91.2600n 0.001964 91.2700n 0.001969 91.2800n 0.001960 91.2900n 0.001937 91.3000n 0.001899 91.3100n 0.001849 91.3200n 0.001787 91.3300n 0.001713 91.3400n 0.001630
+ 91.3500n 0.001539 91.3600n 0.001442 91.3700n 0.001341 91.3800n 0.001238 91.3900n 0.001135 91.4000n 0.001034 91.4100n 0.000938 91.4200n 0.000848 91.4300n 0.000765 91.4400n 0.000692 91.4500n 0.000631 91.4600n 0.000581 91.4700n 0.000545 91.4800n 0.000522 91.4900n 0.000514
+ 91.5000n 0.000519 91.5100n 0.000537 91.5200n 0.000569 91.5300n 0.000612 91.5400n 0.000665 91.5500n 0.000727 91.5600n 0.000797 91.5700n 0.000871 91.5800n 0.000948 91.5900n 0.001026 91.6000n 0.001103 91.6100n 0.001176 91.6200n 0.001243 91.6300n 0.001303 91.6400n 0.001353
+ 91.6500n 0.001393 91.6600n 0.001419 91.6700n 0.001433 91.6800n 0.001432 91.6900n 0.001416 91.7000n 0.001386 91.7100n 0.001341 91.7200n 0.001282 91.7300n 0.001210 91.7400n 0.001126 91.7500n 0.001031 91.7600n 0.000928 91.7700n 0.000818 91.7800n 0.000703 91.7900n 0.000584
+ 91.8000n 0.000465 91.8100n 0.000347 91.8200n 0.000233 91.8300n 0.000123 91.8400n 0.000020 91.8500n -0.000074 91.8600n -0.000159 91.8700n -0.000234 91.8800n -0.000297 91.8900n -0.000348 91.9000n -0.000388 91.9100n -0.000416 91.9200n -0.000434 91.9300n -0.000441 91.9400n -0.000440
+ 91.9500n -0.000430 91.9600n -0.000415 91.9700n -0.000396 91.9800n -0.000373 91.9900n -0.000350 92.0000n -0.000327 92.0100n -0.000308 92.0200n -0.000292 92.0300n -0.000282 92.0400n -0.000278 92.0500n -0.000283 92.0600n -0.000295 92.0700n -0.000317 92.0800n -0.000347 92.0900n -0.000386
+ 92.1000n -0.000432 92.1100n -0.000486 92.1200n -0.000545 92.1300n -0.000609 92.1400n -0.000675 92.1500n -0.000742 92.1600n -0.000807 92.1700n -0.000869 92.1800n -0.000925 92.1900n -0.000974 92.2000n -0.001013 92.2100n -0.001041 92.2200n -0.001056 92.2300n -0.001057 92.2400n -0.001043
+ 92.2500n -0.001013 92.2600n -0.000968 92.2700n -0.000907 92.2800n -0.000832 92.2900n -0.000743 92.3000n -0.000642 92.3100n -0.000530 92.3200n -0.000412 92.3300n -0.000288 92.3400n -0.000162 92.3500n -0.000037 92.3600n 0.000084 92.3700n 0.000198 92.3800n 0.000300 92.3900n 0.000389
+ 92.4000n 0.000460 92.4100n 0.000512 92.4200n 0.000541 92.4300n 0.000547 92.4400n 0.000526 92.4500n 0.000479 92.4600n 0.000405 92.4700n 0.000304 92.4800n 0.000177 92.4900n 0.000025 92.5000n -0.000150 92.5100n -0.000345 92.5200n -0.000558 92.5300n -0.000784 92.5400n -0.001020
+ 92.5500n -0.001261 92.5600n -0.001502 92.5700n -0.001740 92.5800n -0.001969 92.5900n -0.002184 92.6000n -0.002381 92.6100n -0.002556 92.6200n -0.002704 92.6300n -0.002821 92.6400n -0.002906 92.6500n -0.002955 92.6600n -0.002966 92.6700n -0.002939 92.6800n -0.002873 92.6900n -0.002769
+ 92.7000n -0.002629 92.7100n -0.002453 92.7200n -0.002245 92.7300n -0.002008 92.7400n -0.001747 92.7500n -0.001466 92.7600n -0.001170 92.7700n -0.000865 92.7800n -0.000557 92.7900n -0.000250 92.8000n 0.000049 92.8100n 0.000333 92.8200n 0.000599 92.8300n 0.000840 92.8400n 0.001053
+ 92.8500n 0.001232 92.8600n 0.001375 92.8700n 0.001479 92.8800n 0.001542 92.8900n 0.001563 92.9000n 0.001542 92.9100n 0.001480 92.9200n 0.001378 92.9300n 0.001239 92.9400n 0.001067 92.9500n 0.000864 92.9600n 0.000636 92.9700n 0.000389 92.9800n 0.000127 92.9900n -0.000143
+ 93.0000n -0.000416 93.0100n -0.000684 93.0200n -0.000942 93.0300n -0.001183 93.0400n -0.001403 93.0500n -0.001595 93.0600n -0.001755 93.0700n -0.001880 93.0800n -0.001966 93.0900n -0.002010 93.1000n -0.002011 93.1100n -0.001969 93.1200n -0.001883 93.1300n -0.001755 93.1400n -0.001588
+ 93.1500n -0.001383 93.1600n -0.001145 93.1700n -0.000878 93.1800n -0.000587 93.1900n -0.000279 93.2000n 0.000042 93.2100n 0.000369 93.2200n 0.000695 93.2300n 0.001015 93.2400n 0.001322 93.2500n 0.001609 93.2600n 0.001872 93.2700n 0.002106 93.2800n 0.002306 93.2900n 0.002468
+ 93.3000n 0.002589 93.3100n 0.002668 93.3200n 0.002703 93.3300n 0.002694 93.3400n 0.002642 93.3500n 0.002548 93.3600n 0.002413 93.3700n 0.002243 93.3800n 0.002040 93.3900n 0.001808 93.4000n 0.001553 93.4100n 0.001281 93.4200n 0.000996 93.4300n 0.000706 93.4400n 0.000414
+ 93.4500n 0.000129 93.4600n -0.000146 93.4700n -0.000404 93.4800n -0.000640 93.4900n -0.000852 93.5000n -0.001034 93.5100n -0.001183 93.5200n -0.001299 93.5300n -0.001378 93.5400n -0.001421 93.5500n -0.001428 93.5600n -0.001400 93.5700n -0.001338 93.5800n -0.001245 93.5900n -0.001125
+ 93.6000n -0.000980 93.6100n -0.000816 93.6200n -0.000636 93.6300n -0.000446 93.6400n -0.000251 93.6500n -0.000055 93.6600n 0.000136 93.6700n 0.000318 93.6800n 0.000486 93.6900n 0.000635 93.7000n 0.000763 93.7100n 0.000866 93.7200n 0.000942 93.7300n 0.000988 93.7400n 0.001004
+ 93.7500n 0.000990 93.7600n 0.000945 93.7700n 0.000871 93.7800n 0.000769 93.7900n 0.000641 93.8000n 0.000491 93.8100n 0.000321 93.8200n 0.000136 93.8300n -0.000061 93.8400n -0.000266 93.8500n -0.000473 93.8600n -0.000680 93.8700n -0.000881 93.8800n -0.001072 93.8900n -0.001251
+ 93.9000n -0.001412 93.9100n -0.001554 93.9200n -0.001673 93.9300n -0.001768 93.9400n -0.001837 93.9500n -0.001880 93.9600n -0.001896 93.9700n -0.001885 93.9800n -0.001848 93.9900n -0.001787 94.0000n -0.001703 94.0100n -0.001600 94.0200n -0.001479 94.0300n -0.001344 94.0400n -0.001197
+ 94.0500n -0.001043 94.0600n -0.000884 94.0700n -0.000724 94.0800n -0.000567 94.0900n -0.000414 94.1000n -0.000269 94.1100n -0.000134 94.1200n -0.000012 94.1300n 0.000097 94.1400n 0.000190 94.1500n 0.000267 94.1600n 0.000327 94.1700n 0.000372 94.1800n 0.000400 94.1900n 0.000415
+ 94.2000n 0.000415 94.2100n 0.000405 94.2200n 0.000384 94.2300n 0.000356 94.2400n 0.000322 94.2500n 0.000285 94.2600n 0.000246 94.2700n 0.000209 94.2800n 0.000175 94.2900n 0.000146 94.3000n 0.000123 94.3100n 0.000108 94.3200n 0.000100 94.3300n 0.000102 94.3400n 0.000112
+ 94.3500n 0.000130 94.3600n 0.000156 94.3700n 0.000188 94.3800n 0.000225 94.3900n 0.000265 94.4000n 0.000305 94.4100n 0.000345 94.4200n 0.000380 94.4300n 0.000408 94.4400n 0.000428 94.4500n 0.000436 94.4600n 0.000431 94.4700n 0.000409 94.4800n 0.000370 94.4900n 0.000312
+ 94.5000n 0.000233 94.5100n 0.000134 94.5200n 0.000013 94.5300n -0.000128 94.5400n -0.000288 94.5500n -0.000467 94.5600n -0.000663 94.5700n -0.000872 94.5800n -0.001093 94.5900n -0.001322 94.6000n -0.001555 94.6100n -0.001789 94.6200n -0.002019 94.6300n -0.002243 94.6400n -0.002454
+ 94.6500n -0.002649 94.6600n -0.002825 94.6700n -0.002978 94.6800n -0.003103 94.6900n -0.003198 94.7000n -0.003261 94.7100n -0.003288 94.7200n -0.003280 94.7300n -0.003234 94.7400n -0.003150 94.7500n -0.003029 94.7600n -0.002872 94.7700n -0.002680 94.7800n -0.002456 94.7900n -0.002202
+ 94.8000n -0.001921 94.8100n -0.001618 94.8200n -0.001297 94.8300n -0.000961 94.8400n -0.000617 94.8500n -0.000268 94.8600n 0.000080 94.8700n 0.000423 94.8800n 0.000755 94.8900n 0.001071 94.9000n 0.001369 94.9100n 0.001642 94.9200n 0.001888 94.9300n 0.002104 94.9400n 0.002288
+ 94.9500n 0.002436 94.9600n 0.002548 94.9700n 0.002623 94.9800n 0.002661 94.9900n 0.002662 95.0000n 0.002627 95.0100n 0.002559 95.0200n 0.002458 95.0300n 0.002328 95.0400n 0.002171 95.0500n 0.001992 95.0600n 0.001793 95.0700n 0.001578 95.0800n 0.001352 95.0900n 0.001118
+ 95.1000n 0.000881 95.1100n 0.000644 95.1200n 0.000412 95.1300n 0.000187 95.1400n -0.000027 95.1500n -0.000226 95.1600n -0.000409 95.1700n -0.000574 95.1800n -0.000717 95.1900n -0.000839 95.2000n -0.000937 95.2100n -0.001012 95.2200n -0.001064 95.2300n -0.001092 95.2400n -0.001098
+ 95.2500n -0.001083 95.2600n -0.001048 95.2700n -0.000994 95.2800n -0.000924 95.2900n -0.000839 95.3000n -0.000743 95.3100n -0.000636 95.3200n -0.000522 95.3300n -0.000403 95.3400n -0.000281 95.3500n -0.000158 95.3600n -0.000037 95.3700n 0.000081 95.3800n 0.000194 95.3900n 0.000300
+ 95.4000n 0.000398 95.4100n 0.000486 95.4200n 0.000564 95.4300n 0.000630 95.4400n 0.000685 95.4500n 0.000727 95.4600n 0.000757 95.4700n 0.000774 95.4800n 0.000779 95.4900n 0.000771 95.5000n 0.000752 95.5100n 0.000722 95.5200n 0.000681 95.5300n 0.000631 95.5400n 0.000571
+ 95.5500n 0.000502 95.5600n 0.000426 95.5700n 0.000343 95.5800n 0.000255 95.5900n 0.000162 95.6000n 0.000064 95.6100n -0.000037 95.6200n -0.000139 95.6300n -0.000243 95.6400n -0.000348 95.6500n -0.000451 95.6600n -0.000553 95.6700n -0.000653 95.6800n -0.000749 95.6900n -0.000841
+ 95.7000n -0.000928 95.7100n -0.001008 95.7200n -0.001081 95.7300n -0.001147 95.7400n -0.001203 95.7500n -0.001251 95.7600n -0.001288 95.7700n -0.001314 95.7800n -0.001329 95.7900n -0.001332 95.8000n -0.001323 95.8100n -0.001303 95.8200n -0.001270 95.8300n -0.001225 95.8400n -0.001169
+ 95.8500n -0.001102 95.8600n -0.001025 95.8700n -0.000939 95.8800n -0.000844 95.8900n -0.000743 95.9000n -0.000636 95.9100n -0.000525 95.9200n -0.000412 95.9300n -0.000298 95.9400n -0.000185 95.9500n -0.000075 95.9600n 0.000029 95.9700n 0.000127 95.9800n 0.000217 95.9900n 0.000296
+ 96.0000n 0.000363 96.0100n 0.000417 96.0200n 0.000457 96.0300n 0.000481 96.0400n 0.000490 96.0500n 0.000482 96.0600n 0.000457 96.0700n 0.000415 96.0800n 0.000357 96.0900n 0.000283 96.1000n 0.000195 96.1100n 0.000093 96.1200n -0.000021 96.1300n -0.000146 96.1400n -0.000278
+ 96.1500n -0.000418 96.1600n -0.000561 96.1700n -0.000707 96.1800n -0.000852 96.1900n -0.000995 96.2000n -0.001133 96.2100n -0.001264 96.2200n -0.001387 96.2300n -0.001498 96.2400n -0.001597 96.2500n -0.001682 96.2600n -0.001751 96.2700n -0.001805 96.2800n -0.001843 96.2900n -0.001863
+ 96.3000n -0.001867 96.3100n -0.001854 96.3200n -0.001825 96.3300n -0.001781 96.3400n -0.001723 96.3500n -0.001653 96.3600n -0.001572 96.3700n -0.001481 96.3800n -0.001383 96.3900n -0.001279 96.4000n -0.001172 96.4100n -0.001062 96.4200n -0.000953 96.4300n -0.000845 96.4400n -0.000740
+ 96.4500n -0.000640 96.4600n -0.000546 96.4700n -0.000459 96.4800n -0.000379 96.4900n -0.000308 96.5000n -0.000246 96.5100n -0.000191 96.5200n -0.000146 96.5300n -0.000108 96.5400n -0.000078 96.5500n -0.000055 96.5600n -0.000037 96.5700n -0.000023 96.5800n -0.000013 96.5900n -0.000006
+ 96.6000n 0.000000 96.6100n 0.000007 96.6200n 0.000015 96.6300n 0.000025 96.6400n 0.000037 96.6500n 0.000054 96.6600n 0.000075 96.6700n 0.000100 96.6800n 0.000131 96.6900n 0.000165 96.7000n 0.000204 96.7100n 0.000247 96.7200n 0.000293 96.7300n 0.000341 96.7400n 0.000390
+ 96.7500n 0.000439 96.7600n 0.000486 96.7700n 0.000531 96.7800n 0.000572 96.7900n 0.000608 96.8000n 0.000637 96.8100n 0.000658 96.8200n 0.000671 96.8300n 0.000674 96.8400n 0.000667 96.8500n 0.000649 96.8600n 0.000620 96.8700n 0.000581 96.8800n 0.000531 96.8900n 0.000471
+ 96.9000n 0.000402 96.9100n 0.000325 96.9200n 0.000241 96.9300n 0.000152 96.9400n 0.000059 96.9500n -0.000035 96.9600n -0.000130 96.9700n -0.000223 96.9800n -0.000312 96.9900n -0.000396 97.0000n -0.000473 97.0100n -0.000541 97.0200n -0.000599 97.0300n -0.000646 97.0400n -0.000681
+ 97.0500n -0.000704 97.0600n -0.000713 97.0700n -0.000710 97.0800n -0.000694 97.0900n -0.000666 97.1000n -0.000628 97.1100n -0.000580 97.1200n -0.000525 97.1300n -0.000463 97.1400n -0.000397 97.1500n -0.000329 97.1600n -0.000261 97.1700n -0.000196 97.1800n -0.000136 97.1900n -0.000083
+ 97.2000n -0.000038 97.2100n -0.000005 97.2200n 0.000015 97.2300n 0.000021 97.2400n 0.000012 97.2500n -0.000013 97.2600n -0.000055 97.2700n -0.000112 97.2800n -0.000186 97.2900n -0.000275 97.3000n -0.000377 97.3100n -0.000491 97.3200n -0.000615 97.3300n -0.000747 97.3400n -0.000884
+ 97.3500n -0.001023 97.3600n -0.001161 97.3700n -0.001295 97.3800n -0.001422 97.3900n -0.001538 97.4000n -0.001641 97.4100n -0.001727 97.4200n -0.001794 97.4300n -0.001839 97.4400n -0.001861 97.4500n -0.001857 97.4600n -0.001827 97.4700n -0.001770 97.4800n -0.001684 97.4900n -0.001572
+ 97.5000n -0.001433 97.5100n -0.001269 97.5200n -0.001081 97.5300n -0.000873 97.5400n -0.000646 97.5500n -0.000404 97.5600n -0.000150 97.5700n 0.000111 97.5800n 0.000377 97.5900n 0.000642 97.6000n 0.000904 97.6100n 0.001157 97.6200n 0.001397 97.6300n 0.001621 97.6400n 0.001825
+ 97.6500n 0.002006 97.6600n 0.002161 97.6700n 0.002287 97.6800n 0.002383 97.6900n 0.002446 97.7000n 0.002476 97.7100n 0.002473 97.7200n 0.002436 97.7300n 0.002367 97.7400n 0.002266 97.7500n 0.002136 97.7600n 0.001979 97.7700n 0.001797 97.7800n 0.001594 97.7900n 0.001373
+ 97.8000n 0.001137 97.8100n 0.000891 97.8200n 0.000639 97.8300n 0.000385 97.8400n 0.000132 97.8500n -0.000115 97.8600n -0.000353 97.8700n -0.000578 97.8800n -0.000788 97.8900n -0.000978 97.9000n -0.001148 97.9100n -0.001295 97.9200n -0.001418 97.9300n -0.001516 97.9400n -0.001587
+ 97.9500n -0.001633 97.9600n -0.001654 97.9700n -0.001651 97.9800n -0.001625 97.9900n -0.001579 98.0000n -0.001513 98.0100n -0.001432 98.0200n -0.001336 98.0300n -0.001230 98.0400n -0.001117 98.0500n -0.000999 98.0600n -0.000879 98.0700n -0.000761 98.0800n -0.000648 98.0900n -0.000541
+ 98.1000n -0.000444 98.1100n -0.000358 98.1200n -0.000286 98.1300n -0.000229 98.1400n -0.000188 98.1500n -0.000164 98.1600n -0.000158 98.1700n -0.000168 98.1800n -0.000196 98.1900n -0.000239 98.2000n -0.000298 98.2100n -0.000370 98.2200n -0.000454 98.2300n -0.000547 98.2400n -0.000649
+ 98.2500n -0.000756 98.2600n -0.000866 98.2700n -0.000977 98.2800n -0.001087 98.2900n -0.001192 98.3000n -0.001291 98.3100n -0.001382 98.3200n -0.001463 98.3300n -0.001532 98.3400n -0.001587 98.3500n -0.001628 98.3600n -0.001653 98.3700n -0.001662 98.3800n -0.001654 98.3900n -0.001630
+ 98.4000n -0.001590 98.4100n -0.001534 98.4200n -0.001463 98.4300n -0.001378 98.4400n -0.001282 98.4500n -0.001174 98.4600n -0.001057 98.4700n -0.000933 98.4800n -0.000803 98.4900n -0.000670 98.5000n -0.000536 98.5100n -0.000402 98.5200n -0.000270 98.5300n -0.000144 98.5400n -0.000023
+ 98.5500n 0.000090 98.5600n 0.000194 98.5700n 0.000287 98.5800n 0.000368 98.5900n 0.000437 98.6000n 0.000493 98.6100n 0.000535 98.6200n 0.000563 98.6300n 0.000577 98.6400n 0.000578 98.6500n 0.000567 98.6600n 0.000542 98.6700n 0.000507 98.6800n 0.000461 98.6900n 0.000407
+ 98.7000n 0.000344 98.7100n 0.000276 98.7200n 0.000202 98.7300n 0.000126 98.7400n 0.000049 98.7500n -0.000028 98.7600n -0.000104 98.7700n -0.000175 98.7800n -0.000242 98.7900n -0.000302 98.8000n -0.000354 98.8100n -0.000397 98.8200n -0.000429 98.8300n -0.000450 98.8400n -0.000460
+ 98.8500n -0.000457 98.8600n -0.000440 98.8700n -0.000411 98.8800n -0.000369 98.8900n -0.000314 98.9000n -0.000246 98.9100n -0.000167 98.9200n -0.000076 98.9300n 0.000024 98.9400n 0.000134 98.9500n 0.000252 98.9600n 0.000376 98.9700n 0.000505 98.9800n 0.000638 98.9900n 0.000772
+ 99.0000n 0.000907 99.0100n 0.001040 99.0200n 0.001170 99.0300n 0.001295 99.0400n 0.001414 99.0500n 0.001526 99.0600n 0.001628 99.0700n 0.001721 99.0800n 0.001802 99.0900n 0.001871 99.1000n 0.001927 99.1100n 0.001970 99.1200n 0.001999 99.1300n 0.002014 99.1400n 0.002016
+ 99.1500n 0.002005 99.1600n 0.001981 99.1700n 0.001945 99.1800n 0.001898 99.1900n 0.001841 99.2000n 0.001776 99.2100n 0.001703 99.2200n 0.001624 99.2300n 0.001542 99.2400n 0.001456 99.2500n 0.001369 99.2600n 0.001283 99.2700n 0.001199 99.2800n 0.001118 99.2900n 0.001043
+ 99.3000n 0.000974 99.3100n 0.000912 99.3200n 0.000858 99.3300n 0.000813 99.3400n 0.000778 99.3500n 0.000753 99.3600n 0.000738 99.3700n 0.000734 99.3800n 0.000739 99.3900n 0.000753 99.4000n 0.000776 99.4100n 0.000806 99.4200n 0.000844 99.4300n 0.000886 99.4400n 0.000934
+ 99.4500n 0.000984 99.4600n 0.001036 99.4700n 0.001088 99.4800n 0.001139 99.4900n 0.001188 99.5000n 0.001233 99.5100n 0.001273 99.5200n 0.001308 99.5300n 0.001336 99.5400n 0.001357 99.5500n 0.001371 99.5600n 0.001377 99.5700n 0.001375 99.5800n 0.001366 99.5900n 0.001349
+ 99.6000n 0.001326 99.6100n 0.001297 99.6200n 0.001263 99.6300n 0.001226 99.6400n 0.001186 99.6500n 0.001144 99.6600n 0.001102 99.6700n 0.001061 99.6800n 0.001023 99.6900n 0.000988 99.7000n 0.000958 99.7100n 0.000934 99.7200n 0.000916 99.7300n 0.000905 99.7400n 0.000902
+ 99.7500n 0.000906 99.7600n 0.000917 99.7700n 0.000936 99.7800n 0.000961 99.7900n 0.000992 99.8000n 0.001028 99.8100n 0.001068 99.8200n 0.001109 99.8300n 0.001152 99.8400n 0.001193 99.8500n 0.001231 99.8600n 0.001265 99.8700n 0.001292 99.8800n 0.001311 99.8900n 0.001320
+ 99.9000n 0.001317 99.9100n 0.001302 99.9200n 0.001272 99.9300n 0.001228 99.9400n 0.001168 99.9500n 0.001091 99.9600n 0.000999 99.9700n 0.000891 99.9800n 0.000767 99.9900n 0.000630 100.0000n 0.000478 100.0100n 0.000315 100.0200n 0.000142 100.0300n -0.000039 100.0400n -0.000226
+ 100.0500n -0.000417 100.0600n -0.000609 100.0700n -0.000800 100.0800n -0.000988 100.0900n -0.001169 100.1000n -0.001342 100.1100n -0.001505 100.1200n -0.001655 100.1300n -0.001791 100.1400n -0.001912 100.1500n -0.002015 100.1600n -0.002101 100.1700n -0.002169 100.1800n -0.002218 100.1900n -0.002249
+ 100.2000n -0.002262 100.2100n -0.002258 100.2200n -0.002238 100.2300n -0.002203 100.2400n -0.002156 100.2500n -0.002097 100.2600n -0.002028 100.2700n -0.001953 100.2800n -0.001871 100.2900n -0.001787 100.3000n -0.001700 100.3100n -0.001614 100.3200n -0.001530 100.3300n -0.001450 100.3400n -0.001373
+ 100.3500n -0.001302 100.3600n -0.001238 100.3700n -0.001179 100.3800n -0.001127 100.3900n -0.001081 100.4000n -0.001041 100.4100n -0.001005 100.4200n -0.000972 100.4300n -0.000941 100.4400n -0.000911 100.4500n -0.000880 100.4600n -0.000846 100.4700n -0.000807 100.4800n -0.000762 100.4900n -0.000709
+ 100.5000n -0.000646 100.5100n -0.000573 100.5200n -0.000489 100.5300n -0.000392 100.5400n -0.000283 100.5500n -0.000161 100.5600n -0.000027 100.5700n 0.000117 100.5800n 0.000272 100.5900n 0.000435 100.6000n 0.000605 100.6100n 0.000778 100.6200n 0.000953 100.6300n 0.001127 100.6400n 0.001295
+ 100.6500n 0.001456 100.6600n 0.001607 100.6700n 0.001743 100.6800n 0.001861 100.6900n 0.001960 100.7000n 0.002036 100.7100n 0.002087 100.7200n 0.002111 100.7300n 0.002107 100.7400n 0.002073 100.7500n 0.002010 100.7600n 0.001917 100.7700n 0.001796 100.7800n 0.001647 100.7900n 0.001472
+ 100.8000n 0.001275 100.8100n 0.001058 100.8200n 0.000824 100.8300n 0.000579 100.8400n 0.000325 100.8500n 0.000068 100.8600n -0.000188 100.8700n -0.000437 100.8800n -0.000676 100.8900n -0.000898 100.9000n -0.001101 100.9100n -0.001279 100.9200n -0.001428 100.9300n -0.001546 100.9400n -0.001630
+ 100.9500n -0.001678 100.9600n -0.001688 100.9700n -0.001661 100.9800n -0.001595 100.9900n -0.001492 101.0000n -0.001353 101.0100n -0.001182 101.0200n -0.000981 101.0300n -0.000754 101.0400n -0.000506 101.0500n -0.000241 101.0600n 0.000036 101.0700n 0.000318 101.0800n 0.000600 101.0900n 0.000876
+ 101.1000n 0.001141 101.1100n 0.001388 101.1200n 0.001613 101.1300n 0.001811 101.1400n 0.001976 101.1500n 0.002106 101.1600n 0.002197 101.1700n 0.002246 101.1800n 0.002253 101.1900n 0.002216 101.2000n 0.002137 101.2100n 0.002014 101.2200n 0.001852 101.2300n 0.001652 101.2400n 0.001418
+ 101.2500n 0.001154 101.2600n 0.000865 101.2700n 0.000556 101.2800n 0.000234 101.2900n -0.000097 101.3000n -0.000429 101.3100n -0.000757 101.3200n -0.001074 101.3300n -0.001374 101.3400n -0.001652 101.3500n -0.001902 101.3600n -0.002120 101.3700n -0.002303 101.3800n -0.002446 101.3900n -0.002547
+ 101.4000n -0.002605 101.4100n -0.002620 101.4200n -0.002591 101.4300n -0.002519 101.4400n -0.002407 101.4500n -0.002257 101.4600n -0.002073 101.4700n -0.001859 101.4800n -0.001620 101.4900n -0.001362 101.5000n -0.001089 101.5100n -0.000807 101.5200n -0.000524 101.5300n -0.000244 101.5400n 0.000027
+ 101.5500n 0.000282 101.5600n 0.000516 101.5700n 0.000726 101.5800n 0.000906 101.5900n 0.001053 101.6000n 0.001164 101.6100n 0.001237 101.6200n 0.001272 101.6300n 0.001267 101.6400n 0.001223 101.6500n 0.001141 101.6600n 0.001023 101.6700n 0.000872 101.6800n 0.000692 101.6900n 0.000486
+ 101.7000n 0.000258 101.7100n 0.000013 101.7200n -0.000243 101.7300n -0.000506 101.7400n -0.000771 101.7500n -0.001032 101.7600n -0.001285 101.7700n -0.001526 101.7800n -0.001749 101.7900n -0.001952 101.8000n -0.002132 101.8100n -0.002285 101.8200n -0.002411 101.8300n -0.002508 101.8400n -0.002576
+ 101.8500n -0.002616 101.8600n -0.002627 101.8700n -0.002612 101.8800n -0.002573 101.8900n -0.002513 101.9000n -0.002435 101.9100n -0.002342 101.9200n -0.002239 101.9300n -0.002128 101.9400n -0.002014 101.9500n -0.001901 101.9600n -0.001792 101.9700n -0.001691 101.9800n -0.001602 101.9900n -0.001526
+ 102.0000n -0.001466 102.0100n -0.001423 102.0200n -0.001399 102.0300n -0.001395 102.0400n -0.001409 102.0500n -0.001441 102.0600n -0.001490 102.0700n -0.001554 102.0800n -0.001631 102.0900n -0.001717 102.1000n -0.001809 102.1100n -0.001904 102.1200n -0.001998 102.1300n -0.002086 102.1400n -0.002167
+ 102.1500n -0.002234 102.1600n -0.002286 102.1700n -0.002318 102.1800n -0.002327 102.1900n -0.002312 102.2000n -0.002271 102.2100n -0.002201 102.2200n -0.002102 102.2300n -0.001974 102.2400n -0.001818 102.2500n -0.001635 102.2600n -0.001426 102.2700n -0.001194 102.2800n -0.000942 102.2900n -0.000673
+ 102.3000n -0.000391 102.3100n -0.000101 102.3200n 0.000193 102.3300n 0.000487 102.3400n 0.000776 102.3500n 0.001055 102.3600n 0.001321 102.3700n 0.001568 102.3800n 0.001793 102.3900n 0.001993 102.4000n 0.002165 102.4100n 0.002306 102.4200n 0.002414 102.4300n 0.002490 102.4400n 0.002531
+ 102.4500n 0.002539 102.4600n 0.002515 102.4700n 0.002459 102.4800n 0.002374 102.4900n 0.002264 102.5000n 0.002130 102.5100n 0.001977 102.5200n 0.001808 102.5300n 0.001628 102.5400n 0.001441 102.5500n 0.001252 102.5600n 0.001064 102.5700n 0.000882 102.5800n 0.000710 102.5900n 0.000551
+ 102.6000n 0.000409 102.6100n 0.000286 102.6200n 0.000184 102.6300n 0.000106 102.6400n 0.000052 102.6500n 0.000023 102.6600n 0.000018 102.6700n 0.000038 102.6800n 0.000080 102.6900n 0.000143 102.7000n 0.000225 102.7100n 0.000323 102.7200n 0.000433 102.7300n 0.000554 102.7400n 0.000681
+ 102.7500n 0.000812 102.7600n 0.000942 102.7700n 0.001068 102.7800n 0.001187 102.7900n 0.001296 102.8000n 0.001392 102.8100n 0.001474 102.8200n 0.001539 102.8300n 0.001586 102.8400n 0.001615 102.8500n 0.001624 102.8600n 0.001615 102.8700n 0.001588 102.8800n 0.001544 102.8900n 0.001485
+ 102.9000n 0.001412 102.9100n 0.001329 102.9200n 0.001238 102.9300n 0.001142 102.9400n 0.001043 102.9500n 0.000946 102.9600n 0.000852 102.9700n 0.000765 102.9800n 0.000687 102.9900n 0.000621 103.0000n 0.000570 103.0100n 0.000533 103.0200n 0.000514 103.0300n 0.000512 103.0400n 0.000528
+ 103.0500n 0.000562 103.0600n 0.000613 103.0700n 0.000679 103.0800n 0.000760 103.0900n 0.000853 103.1000n 0.000955 103.1100n 0.001063 103.1200n 0.001176 103.1300n 0.001288 103.1400n 0.001398 103.1500n 0.001501 103.1600n 0.001594 103.1700n 0.001674 103.1800n 0.001738 103.1900n 0.001784
+ 103.2000n 0.001809 103.2100n 0.001812 103.2200n 0.001790 103.2300n 0.001743 103.2400n 0.001672 103.2500n 0.001575 103.2600n 0.001454 103.2700n 0.001309 103.2800n 0.001144 103.2900n 0.000961 103.3000n 0.000761 103.3100n 0.000548 103.3200n 0.000327 103.3300n 0.000099 103.3400n -0.000129
+ 103.3500n -0.000356 103.3600n -0.000576 103.3700n -0.000786 103.3800n -0.000983 103.3900n -0.001161 103.4000n -0.001320 103.4100n -0.001455 103.4200n -0.001565 103.4300n -0.001648 103.4400n -0.001703 103.4500n -0.001729 103.4600n -0.001726 103.4700n -0.001695 103.4800n -0.001637 103.4900n -0.001553
+ 103.5000n -0.001446 103.5100n -0.001319 103.5200n -0.001174 103.5300n -0.001016 103.5400n -0.000847 103.5500n -0.000672 103.5600n -0.000494 103.5700n -0.000318 103.5800n -0.000148 103.5900n 0.000013 103.6000n 0.000161 103.6100n 0.000292 103.6200n 0.000404 103.6300n 0.000495 103.6400n 0.000562
+ 103.6500n 0.000604 103.6600n 0.000620 103.6700n 0.000609 103.6800n 0.000572 103.6900n 0.000510 103.7000n 0.000424 103.7100n 0.000315 103.7200n 0.000187 103.7300n 0.000042 103.7400n -0.000117 103.7500n -0.000287 103.7600n -0.000463 103.7700n -0.000643 103.7800n -0.000821 103.7900n -0.000995
+ 103.8000n -0.001160 103.8100n -0.001312 103.8200n -0.001448 103.8300n -0.001566 103.8400n -0.001661 103.8500n -0.001732 103.8600n -0.001776 103.8700n -0.001792 103.8800n -0.001780 103.8900n -0.001737 103.9000n -0.001665 103.9100n -0.001563 103.9200n -0.001433 103.9300n -0.001277 103.9400n -0.001095
+ 103.9500n -0.000890 103.9600n -0.000666 103.9700n -0.000424 103.9800n -0.000168 103.9900n 0.000099 104.0000n 0.000373 104.0100n 0.000651 104.0200n 0.000928 104.0300n 0.001203 104.0400n 0.001470 104.0500n 0.001728 104.0600n 0.001972 104.0700n 0.002200 104.0800n 0.002409 104.0900n 0.002598
+ 104.1000n 0.002763 104.1100n 0.002904 104.1200n 0.003018 104.1300n 0.003106 104.1400n 0.003166 104.1500n 0.003199 104.1600n 0.003203 104.1700n 0.003180 104.1800n 0.003129 104.1900n 0.003053 104.2000n 0.002951 104.2100n 0.002826 104.2200n 0.002678 104.2300n 0.002509 104.2400n 0.002322
+ 104.2500n 0.002117 104.2600n 0.001898 104.2700n 0.001665 104.2800n 0.001421 104.2900n 0.001168 104.3000n 0.000908 104.3100n 0.000643 104.3200n 0.000376 104.3300n 0.000108 104.3400n -0.000159 104.3500n -0.000423 104.3600n -0.000681 104.3700n -0.000933 104.3800n -0.001175 104.3900n -0.001406
+ 104.4000n -0.001625 104.4100n -0.001830 104.4200n -0.002019 104.4300n -0.002190 104.4400n -0.002343 104.4500n -0.002476 104.4600n -0.002587 104.4700n -0.002677 104.4800n -0.002743 104.4900n -0.002785 104.5000n -0.002803 104.5100n -0.002796 104.5200n -0.002763 104.5300n -0.002706 104.5400n -0.002625
+ 104.5500n -0.002519 104.5600n -0.002390 104.5700n -0.002239 104.5800n -0.002067 104.5900n -0.001876 104.6000n -0.001667 104.6100n -0.001443 104.6200n -0.001205 104.6300n -0.000957 104.6400n -0.000702 104.6500n -0.000441 104.6600n -0.000177 104.6700n 0.000085 104.6800n 0.000343 104.6900n 0.000595
+ 104.7000n 0.000836 104.7100n 0.001065 104.7200n 0.001278 104.7300n 0.001472 104.7400n 0.001646 104.7500n 0.001796 104.7600n 0.001922 104.7700n 0.002021 104.7800n 0.002093 104.7900n 0.002136 104.8000n 0.002150 104.8100n 0.002134 104.8200n 0.002090 104.8300n 0.002017 104.8400n 0.001917
+ 104.8500n 0.001792 104.8600n 0.001642 104.8700n 0.001471 104.8800n 0.001280 104.8900n 0.001072 104.9000n 0.000850 104.9100n 0.000617 104.9200n 0.000377 104.9300n 0.000132 104.9400n -0.000115 104.9500n -0.000359 104.9600n -0.000599 104.9700n -0.000830 104.9800n -0.001050 104.9900n -0.001256
+ 105.0000n -0.001446 105.0100n -0.001618 105.0200n -0.001769 105.0300n -0.001898 105.0400n -0.002004 105.0500n -0.002085 105.0600n -0.002142 105.0700n -0.002173 105.0800n -0.002179 105.0900n -0.002161 105.1000n -0.002118 105.1100n -0.002052 105.1200n -0.001964 105.1300n -0.001855 105.1400n -0.001728
+ 105.1500n -0.001583 105.1600n -0.001423 105.1700n -0.001250 105.1800n -0.001065 105.1900n -0.000872 105.2000n -0.000671 105.2100n -0.000466 105.2200n -0.000258 105.2300n -0.000049 105.2400n 0.000158 105.2500n 0.000363 105.2600n 0.000563 105.2700n 0.000757 105.2800n 0.000944 105.2900n 0.001121
+ 105.3000n 0.001289 105.3100n 0.001446 105.3200n 0.001591 105.3300n 0.001724 105.3400n 0.001844 105.3500n 0.001950 105.3600n 0.002044 105.3700n 0.002123 105.3800n 0.002189 105.3900n 0.002242 105.4000n 0.002281 105.4100n 0.002307 105.4200n 0.002320 105.4300n 0.002321 105.4400n 0.002310
+ 105.4500n 0.002288 105.4600n 0.002255 105.4700n 0.002212 105.4800n 0.002160 105.4900n 0.002100 105.5000n 0.002033 105.5100n 0.001958 105.5200n 0.001879 105.5300n 0.001794 105.5400n 0.001707 105.5500n 0.001617 105.5600n 0.001525 105.5700n 0.001434 105.5800n 0.001343 105.5900n 0.001254
+ 105.6000n 0.001169 105.6100n 0.001088 105.6200n 0.001011 105.6300n 0.000941 105.6400n 0.000878 105.6500n 0.000823 105.6600n 0.000776 105.6700n 0.000738 105.6800n 0.000709 105.6900n 0.000690 105.7000n 0.000680 105.7100n 0.000680 105.7200n 0.000689 105.7300n 0.000707 105.7400n 0.000733
+ 105.7500n 0.000767 105.7600n 0.000808 105.7700n 0.000854 105.7800n 0.000906 105.7900n 0.000960 105.8000n 0.001016 105.8100n 0.001074 105.8200n 0.001130 105.8300n 0.001184 105.8400n 0.001235 105.8500n 0.001281 105.8600n 0.001320 105.8700n 0.001352 105.8800n 0.001375 105.8900n 0.001389
+ 105.9000n 0.001393 105.9100n 0.001386 105.9200n 0.001368 105.9300n 0.001339 105.9400n 0.001298 105.9500n 0.001247 105.9600n 0.001185 105.9700n 0.001113 105.9800n 0.001032 105.9900n 0.000944 106.0000n 0.000849 106.0100n 0.000749 106.0200n 0.000645 106.0300n 0.000538 106.0400n 0.000431
+ 106.0500n 0.000325 106.0600n 0.000222 106.0700n 0.000122 106.0800n 0.000028 106.0900n -0.000059 106.1000n -0.000138 106.1100n -0.000208 106.1200n -0.000268 106.1300n -0.000317 106.1400n -0.000355 106.1500n -0.000382 106.1600n -0.000397 106.1700n -0.000402 106.1800n -0.000395 106.1900n -0.000378
+ 106.2000n -0.000352 106.2100n -0.000317 106.2200n -0.000275 106.2300n -0.000227 106.2400n -0.000173 106.2500n -0.000116 106.2600n -0.000057 106.2700n 0.000004 106.2800n 0.000064 106.2900n 0.000122 106.3000n 0.000178 106.3100n 0.000230 106.3200n 0.000278 106.3300n 0.000320 106.3400n 0.000356
+ 106.3500n 0.000385 106.3600n 0.000408 106.3700n 0.000423 106.3800n 0.000432 106.3900n 0.000434 106.4000n 0.000430 106.4100n 0.000420 106.4200n 0.000404 106.4300n 0.000384 106.4400n 0.000359 106.4500n 0.000330 106.4600n 0.000299 106.4700n 0.000265 106.4800n 0.000229 106.4900n 0.000192
+ 106.5000n 0.000155 106.5100n 0.000116 106.5200n 0.000077 106.5300n 0.000037 106.5400n -0.000003 106.5500n -0.000043 106.5600n -0.000085 106.5700n -0.000128 106.5800n -0.000173 106.5900n -0.000220 106.6000n -0.000270 106.6100n -0.000324 106.6200n -0.000382 106.6300n -0.000444 106.6400n -0.000512
+ 106.6500n -0.000585 106.6600n -0.000664 106.6700n -0.000749 106.6800n -0.000840 106.6900n -0.000936 106.7000n -0.001037 106.7100n -0.001142 106.7200n -0.001251 106.7300n -0.001363 106.7400n -0.001475 106.7500n -0.001587 106.7600n -0.001698 106.7700n -0.001804 106.7800n -0.001906 106.7900n -0.001999
+ 106.8000n -0.002084 106.8100n -0.002158 106.8200n -0.002218 106.8300n -0.002264 106.8400n -0.002294 106.8500n -0.002306 106.8600n -0.002300 106.8700n -0.002274 106.8800n -0.002228 106.8900n -0.002162 106.9000n -0.002077 106.9100n -0.001971 106.9200n -0.001847 106.9300n -0.001706 106.9400n -0.001550
+ 106.9500n -0.001379 106.9600n -0.001198 106.9700n -0.001007 106.9800n -0.000810 106.9900n -0.000610 107.0000n -0.000410 107.0100n -0.000213 107.0200n -0.000022 107.0300n 0.000160 107.0400n 0.000329 107.0500n 0.000484 107.0600n 0.000621 107.0700n 0.000739 107.0800n 0.000835 107.0900n 0.000908
+ 107.1000n 0.000957 107.1100n 0.000982 107.1200n 0.000982 107.1300n 0.000957 107.1400n 0.000909 107.1500n 0.000839 107.1600n 0.000748 107.1700n 0.000639 107.1800n 0.000514 107.1900n 0.000377 107.2000n 0.000230 107.2100n 0.000077 107.2200n -0.000079 107.2300n -0.000234 107.2400n -0.000385
+ 107.2500n -0.000527 107.2600n -0.000659 107.2700n -0.000776 107.2800n -0.000875 107.2900n -0.000955 107.3000n -0.001014 107.3100n -0.001048 107.3200n -0.001059 107.3300n -0.001044 107.3400n -0.001003 107.3500n -0.000938 107.3600n -0.000849 107.3700n -0.000737 107.3800n -0.000605 107.3900n -0.000454
+ 107.4000n -0.000288 107.4100n -0.000109 107.4200n 0.000079 107.4300n 0.000273 107.4400n 0.000468 107.4500n 0.000662 107.4600n 0.000851 107.4700n 0.001031 107.4800n 0.001199 107.4900n 0.001351 107.5000n 0.001484 107.5100n 0.001597 107.5200n 0.001687 107.5300n 0.001752 107.5400n 0.001792
+ 107.5500n 0.001805 107.5600n 0.001791 107.5700n 0.001751 107.5800n 0.001686 107.5900n 0.001596 107.6000n 0.001483 107.6100n 0.001350 107.6200n 0.001198 107.6300n 0.001030 107.6400n 0.000849 107.6500n 0.000659 107.6600n 0.000461 107.6700n 0.000260 107.6800n 0.000058 107.6900n -0.000142
+ 107.7000n -0.000338 107.7100n -0.000526 107.7200n -0.000705 107.7300n -0.000873 107.7400n -0.001028 107.7500n -0.001169 107.7600n -0.001295 107.7700n -0.001406 107.7800n -0.001502 107.7900n -0.001582 107.8000n -0.001648 107.8100n -0.001701 107.8200n -0.001742 107.8300n -0.001771 107.8400n -0.001792
+ 107.8500n -0.001804 107.8600n -0.001810 107.8700n -0.001812 107.8800n -0.001811 107.8900n -0.001809 107.9000n -0.001807 107.9100n -0.001807 107.9200n -0.001808 107.9300n -0.001812 107.9400n -0.001820 107.9500n -0.001831 107.9600n -0.001845 107.9700n -0.001861 107.9800n -0.001880 107.9900n -0.001899
+ 108.0000n -0.001918 108.0100n -0.001935 108.0200n -0.001949 108.0300n -0.001957 108.0400n -0.001959 108.0500n -0.001952 108.0600n -0.001936 108.0700n -0.001907 108.0800n -0.001866 108.0900n -0.001810 108.1000n -0.001740 108.1100n -0.001654 108.1200n -0.001552 108.1300n -0.001434 108.1400n -0.001300
+ 108.1500n -0.001152 108.1600n -0.000990 108.1700n -0.000815 108.1800n -0.000630 108.1900n -0.000436 108.2000n -0.000236 108.2100n -0.000031 108.2200n 0.000175 108.2300n 0.000380 108.2400n 0.000581 108.2500n 0.000777 108.2600n 0.000963 108.2700n 0.001138 108.2800n 0.001300 108.2900n 0.001447
+ 108.3000n 0.001577 108.3100n 0.001689 108.3200n 0.001782 108.3300n 0.001856 108.3400n 0.001910 108.3500n 0.001945 108.3600n 0.001961 108.3700n 0.001959 108.3800n 0.001942 108.3900n 0.001910 108.4000n 0.001866 108.4100n 0.001811 108.4200n 0.001749 108.4300n 0.001681 108.4400n 0.001610
+ 108.4500n 0.001539 108.4600n 0.001470 108.4700n 0.001405 108.4800n 0.001347 108.4900n 0.001298 108.5000n 0.001258 108.5100n 0.001229 108.5200n 0.001213 108.5300n 0.001209 108.5400n 0.001218 108.5500n 0.001239 108.5600n 0.001272 108.5700n 0.001315 108.5800n 0.001367 108.5900n 0.001427
+ 108.6000n 0.001493 108.6100n 0.001562 108.6200n 0.001632 108.6300n 0.001700 108.6400n 0.001765 108.6500n 0.001823 108.6600n 0.001873 108.6700n 0.001912 108.6800n 0.001938 108.6900n 0.001950 108.7000n 0.001946 108.7100n 0.001926 108.7200n 0.001888 108.7300n 0.001832 108.7400n 0.001759
+ 108.7500n 0.001669 108.7600n 0.001564 108.7700n 0.001444 108.7800n 0.001312 108.7900n 0.001170 108.8000n 0.001020 108.8100n 0.000864 108.8200n 0.000706 108.8300n 0.000548 108.8400n 0.000393 108.8500n 0.000245 108.8600n 0.000105 108.8700n -0.000023 108.8800n -0.000138 108.8900n -0.000237
+ 108.9000n -0.000318 108.9100n -0.000380 108.9200n -0.000423 108.9300n -0.000445 108.9400n -0.000447 108.9500n -0.000429 108.9600n -0.000392 108.9700n -0.000337 108.9800n -0.000265 108.9900n -0.000179 109.0000n -0.000081 109.0100n 0.000027 109.0200n 0.000142 109.0300n 0.000261 109.0400n 0.000382
+ 109.0500n 0.000502 109.0600n 0.000618 109.0700n 0.000728 109.0800n 0.000829 109.0900n 0.000920 109.1000n 0.000998 109.1100n 0.001063 109.1200n 0.001113 109.1300n 0.001149 109.1400n 0.001169 109.1500n 0.001174 109.1600n 0.001166 109.1700n 0.001144 109.1800n 0.001112 109.1900n 0.001069
+ 109.2000n 0.001020 109.2100n 0.000965 109.2200n 0.000907 109.2300n 0.000849 109.2400n 0.000794 109.2500n 0.000742 109.2600n 0.000698 109.2700n 0.000663 109.2800n 0.000638 109.2900n 0.000625 109.3000n 0.000626 109.3100n 0.000641 109.3200n 0.000670 109.3300n 0.000714 109.3400n 0.000771
+ 109.3500n 0.000841 109.3600n 0.000921 109.3700n 0.001011 109.3800n 0.001108 109.3900n 0.001210 109.4000n 0.001314 109.4100n 0.001416 109.4200n 0.001515 109.4300n 0.001607 109.4400n 0.001689 109.4500n 0.001758 109.4600n 0.001811 109.4700n 0.001847 109.4800n 0.001864 109.4900n 0.001859
+ 109.5000n 0.001832 109.5100n 0.001781 109.5200n 0.001708 109.5300n 0.001612 109.5400n 0.001495 109.5500n 0.001357 109.5600n 0.001202 109.5700n 0.001031 109.5800n 0.000847 109.5900n 0.000653 109.6000n 0.000454 109.6100n 0.000253 109.6200n 0.000054 109.6300n -0.000140 109.6400n -0.000323
+ 109.6500n -0.000493 109.6600n -0.000646 109.6700n -0.000779 109.6800n -0.000888 109.6900n -0.000972 109.7000n -0.001028 109.7100n -0.001056 109.7200n -0.001053 109.7300n -0.001022 109.7400n -0.000960 109.7500n -0.000871 109.7600n -0.000756 109.7700n -0.000617 109.7800n -0.000456 109.7900n -0.000278
+ 109.8000n -0.000087 109.8100n 0.000115 109.8200n 0.000322 109.8300n 0.000530 109.8400n 0.000735 109.8500n 0.000931 109.8600n 0.001116 109.8700n 0.001285 109.8800n 0.001434 109.8900n 0.001560 109.9000n 0.001661 109.9100n 0.001733 109.9200n 0.001777 109.9300n 0.001791 109.9400n 0.001775
+ 109.9500n 0.001729 109.9600n 0.001654 109.9700n 0.001553 109.9800n 0.001428 109.9900n 0.001282 110.0000n 0.001118 110.0100n 0.000941 110.0200n 0.000754 110.0300n 0.000563 110.0400n 0.000371 110.0500n 0.000183 110.0600n 0.000005 110.0700n -0.000160 110.0800n -0.000308 110.0900n -0.000435
+ 110.1000n -0.000538 110.1100n -0.000614 110.1200n -0.000660 110.1300n -0.000676 110.1400n -0.000661 110.1500n -0.000614 110.1600n -0.000537 110.1700n -0.000430 110.1800n -0.000296 110.1900n -0.000137 110.2000n 0.000043 110.2100n 0.000241 110.2200n 0.000453 110.2300n 0.000674 110.2400n 0.000900
+ 110.2500n 0.001125 110.2600n 0.001345 110.2700n 0.001556 110.2800n 0.001752 110.2900n 0.001929 110.3000n 0.002083 110.3100n 0.002211 110.3200n 0.002309 110.3300n 0.002376 110.3400n 0.002410 110.3500n 0.002409 110.3600n 0.002374 110.3700n 0.002303 110.3800n 0.002200 110.3900n 0.002064
+ 110.4000n 0.001898 110.4100n 0.001706 110.4200n 0.001490 110.4300n 0.001254 110.4400n 0.001002 110.4500n 0.000739 110.4600n 0.000468 110.4700n 0.000195 110.4800n -0.000075 110.4900n -0.000340 110.5000n -0.000594 110.5100n -0.000833 110.5200n -0.001055 110.5300n -0.001255 110.5400n -0.001432
+ 110.5500n -0.001583 110.5600n -0.001707 110.5700n -0.001803 110.5800n -0.001870 110.5900n -0.001908 110.6000n -0.001919 110.6100n -0.001904 110.6200n -0.001863 110.6300n -0.001800 110.6400n -0.001716 110.6500n -0.001615 110.6600n -0.001498 110.6700n -0.001370 110.6800n -0.001232 110.6900n -0.001088
+ 110.7000n -0.000941 110.7100n -0.000793 110.7200n -0.000647 110.7300n -0.000505 110.7400n -0.000369 110.7500n -0.000240 110.7600n -0.000120 110.7700n -0.000008 110.7800n 0.000094 110.7900n 0.000186 110.8000n 0.000269 110.8100n 0.000344 110.8200n 0.000411 110.8300n 0.000472 110.8400n 0.000528
+ 110.8500n 0.000580 110.8600n 0.000631 110.8700n 0.000681 110.8800n 0.000732 110.8900n 0.000785 110.9000n 0.000841 110.9100n 0.000902 110.9200n 0.000969 110.9300n 0.001040 110.9400n 0.001118 110.9500n 0.001200 110.9600n 0.001288 110.9700n 0.001379 110.9800n 0.001474 110.9900n 0.001569
+ 111.0000n 0.001665 111.0100n 0.001758 111.0200n 0.001847 111.0300n 0.001930 111.0400n 0.002005 111.0500n 0.002069 111.0600n 0.002120 111.0700n 0.002158 111.0800n 0.002179 111.0900n 0.002183 111.1000n 0.002169 111.1100n 0.002136 111.1200n 0.002084 111.1300n 0.002012 111.1400n 0.001922
+ 111.1500n 0.001814 111.1600n 0.001690 111.1700n 0.001550 111.1800n 0.001399 111.1900n 0.001237 111.2000n 0.001067 111.2100n 0.000893 111.2200n 0.000716 111.2300n 0.000541 111.2400n 0.000371 111.2500n 0.000207 111.2600n 0.000053 111.2700n -0.000088 111.2800n -0.000214 111.2900n -0.000323
+ 111.3000n -0.000414 111.3100n -0.000486 111.3200n -0.000537 111.3300n -0.000568 111.3400n -0.000579 111.3500n -0.000571 111.3600n -0.000545 111.3700n -0.000502 111.3800n -0.000446 111.3900n -0.000379 111.4000n -0.000303 111.4100n -0.000222 111.4200n -0.000139 111.4300n -0.000056 111.4400n 0.000021
+ 111.4500n 0.000091 111.4600n 0.000149 111.4700n 0.000194 111.4800n 0.000223 111.4900n 0.000233 111.5000n 0.000223 111.5100n 0.000191 111.5200n 0.000138 111.5300n 0.000062 111.5400n -0.000036 111.5500n -0.000154 111.5600n -0.000291 111.5700n -0.000446 111.5800n -0.000615 111.5900n -0.000795
+ 111.6000n -0.000983 111.6100n -0.001175 111.6200n -0.001368 111.6300n -0.001556 111.6400n -0.001738 111.6500n -0.001907 111.6600n -0.002060 111.6700n -0.002195 111.6800n -0.002306 111.6900n -0.002393 111.7000n -0.002451 111.7100n -0.002480 111.7200n -0.002479 111.7300n -0.002445 111.7400n -0.002381
+ 111.7500n -0.002286 111.7600n -0.002161 111.7700n -0.002009 111.7800n -0.001832 111.7900n -0.001634 111.8000n -0.001417 111.8100n -0.001187 111.8200n -0.000946 111.8300n -0.000701 111.8400n -0.000454 111.8500n -0.000212 111.8600n 0.000022 111.8700n 0.000243 111.8800n 0.000446 111.8900n 0.000629
+ 111.9000n 0.000788 111.9100n 0.000920 111.9200n 0.001023 111.9300n 0.001095 111.9400n 0.001135 111.9500n 0.001144 111.9600n 0.001121 111.9700n 0.001068 111.9800n 0.000986 111.9900n 0.000879 112.0000n 0.000748 112.0100n 0.000598 112.0200n 0.000431 112.0300n 0.000253 112.0400n 0.000068
+ 112.0500n -0.000120 112.0600n -0.000307 112.0700n -0.000488 112.0800n -0.000659 112.0900n -0.000816 112.1000n -0.000956 112.1100n -0.001074 112.1200n -0.001170 112.1300n -0.001240 112.1400n -0.001284 112.1500n -0.001301 112.1600n -0.001290 112.1700n -0.001253 112.1800n -0.001190 112.1900n -0.001104
+ 112.2000n -0.000997 112.2100n -0.000871 112.2200n -0.000731 112.2300n -0.000579 112.2400n -0.000421 112.2500n -0.000260 112.2600n -0.000100 112.2700n 0.000055 112.2800n 0.000200 112.2900n 0.000332 112.3000n 0.000447 112.3100n 0.000542 112.3200n 0.000615 112.3300n 0.000664 112.3400n 0.000686
+ 112.3500n 0.000682 112.3600n 0.000651 112.3700n 0.000593 112.3800n 0.000510 112.3900n 0.000404 112.4000n 0.000276 112.4100n 0.000131 112.4200n -0.000030 112.4300n -0.000202 112.4400n -0.000381 112.4500n -0.000563 112.4600n -0.000744 112.4700n -0.000919 112.4800n -0.001084 112.4900n -0.001234
+ 112.5000n -0.001367 112.5100n -0.001478 112.5200n -0.001565 112.5300n -0.001625 112.5400n -0.001656 112.5500n -0.001657 112.5600n -0.001628 112.5700n -0.001567 112.5800n -0.001477 112.5900n -0.001358 112.6000n -0.001212 112.6100n -0.001042 112.6200n -0.000851 112.6300n -0.000642 112.6400n -0.000420
+ 112.6500n -0.000188 112.6600n 0.000049 112.6700n 0.000286 112.6800n 0.000520 112.6900n 0.000744 112.7000n 0.000956 112.7100n 0.001151 112.7200n 0.001325 112.7300n 0.001476 112.7400n 0.001600 112.7500n 0.001694 112.7600n 0.001759 112.7700n 0.001791 112.7800n 0.001792 112.7900n 0.001761
+ 112.8000n 0.001698 112.8100n 0.001606 112.8200n 0.001486 112.8300n 0.001341 112.8400n 0.001174 112.8500n 0.000987 112.8600n 0.000784 112.8700n 0.000570 112.8800n 0.000347 112.8900n 0.000120 112.9000n -0.000107 112.9100n -0.000331 112.9200n -0.000548 112.9300n -0.000754 112.9400n -0.000948
+ 112.9500n -0.001126 112.9600n -0.001286 112.9700n -0.001427 112.9800n -0.001547 112.9900n -0.001646 113.0000n -0.001724 113.0100n -0.001781 113.0200n -0.001817 113.0300n -0.001834 113.0400n -0.001833 113.0500n -0.001817 113.0600n -0.001787 113.0700n -0.001745 113.0800n -0.001694 113.0900n -0.001637
+ 113.1000n -0.001576 113.1100n -0.001512 113.1200n -0.001450 113.1300n -0.001389 113.1400n -0.001333 113.1500n -0.001283 113.1600n -0.001240 113.1700n -0.001204 113.1800n -0.001177 113.1900n -0.001158 113.2000n -0.001147 113.2100n -0.001143 113.2200n -0.001146 113.2300n -0.001155 113.2400n -0.001167
+ 113.2500n -0.001182 113.2600n -0.001198 113.2700n -0.001212 113.2800n -0.001223 113.2900n -0.001230 113.3000n -0.001230 113.3100n -0.001222 113.3200n -0.001204 113.3300n -0.001176 113.3400n -0.001137 113.3500n -0.001086 113.3600n -0.001023 113.3700n -0.000949 113.3800n -0.000864 113.3900n -0.000768
+ 113.4000n -0.000664 113.4100n -0.000553 113.4200n -0.000437 113.4300n -0.000318 113.4400n -0.000198 113.4500n -0.000081 113.4600n 0.000033 113.4700n 0.000139 113.4800n 0.000235 113.4900n 0.000320 113.5000n 0.000389 113.5100n 0.000443 113.5200n 0.000478 113.5300n 0.000493 113.5400n 0.000487
+ 113.5500n 0.000460 113.5600n 0.000411 113.5700n 0.000340 113.5800n 0.000249 113.5900n 0.000137 113.6000n 0.000006 113.6100n -0.000141 113.6200n -0.000303 113.6300n -0.000477 113.6400n -0.000660 113.6500n -0.000849 113.6600n -0.001042 113.6700n -0.001235 113.6800n -0.001424 113.6900n -0.001607
+ 113.7000n -0.001781 113.7100n -0.001942 113.7200n -0.002088 113.7300n -0.002217 113.7400n -0.002327 113.7500n -0.002416 113.7600n -0.002483 113.7700n -0.002528 113.7800n -0.002550 113.7900n -0.002548 113.8000n -0.002525 113.8100n -0.002481 113.8200n -0.002416 113.8300n -0.002334 113.8400n -0.002237
+ 113.8500n -0.002125 113.8600n -0.002003 113.8700n -0.001873 113.8800n -0.001738 113.8900n -0.001600 113.9000n -0.001462 113.9100n -0.001327 113.9200n -0.001198 113.9300n -0.001077 113.9400n -0.000965 113.9500n -0.000866 113.9600n -0.000779 113.9700n -0.000706 113.9800n -0.000647 113.9900n -0.000603
+ 114.0000n -0.000574 114.0100n -0.000559 114.0200n -0.000557 114.0300n -0.000567 114.0400n -0.000587 114.0500n -0.000615 114.0600n -0.000651 114.0700n -0.000690 114.0800n -0.000731 114.0900n -0.000773 114.1000n -0.000812 114.1100n -0.000846 114.1200n -0.000873 114.1300n -0.000892 114.1400n -0.000901
+ 114.1500n -0.000899 114.1600n -0.000884 114.1700n -0.000856 114.1800n -0.000815 114.1900n -0.000760 114.2000n -0.000692 114.2100n -0.000612 114.2200n -0.000521 114.2300n -0.000420 114.2400n -0.000311 114.2500n -0.000196 114.2600n -0.000078 114.2700n 0.000043 114.2800n 0.000162 114.2900n 0.000278
+ 114.3000n 0.000388 114.3100n 0.000490 114.3200n 0.000582 114.3300n 0.000662 114.3400n 0.000728 114.3500n 0.000778 114.3600n 0.000812 114.3700n 0.000827 114.3800n 0.000825 114.3900n 0.000805 114.4000n 0.000767 114.4100n 0.000711 114.4200n 0.000640 114.4300n 0.000553 114.4400n 0.000454
+ 114.4500n 0.000343 114.4600n 0.000223 114.4700n 0.000097 114.4800n -0.000034 114.4900n -0.000165 114.5000n -0.000296 114.5100n -0.000423 114.5200n -0.000543 114.5300n -0.000655 114.5400n -0.000756 114.5500n -0.000844 114.5600n -0.000917 114.5700n -0.000975 114.5800n -0.001016 114.5900n -0.001040
+ 114.6000n -0.001046 114.6100n -0.001035 114.6200n -0.001008 114.6300n -0.000965 114.6400n -0.000907 114.6500n -0.000837 114.6600n -0.000756 114.6700n -0.000667 114.6800n -0.000572 114.6900n -0.000474 114.7000n -0.000375 114.7100n -0.000278 114.7200n -0.000187 114.7300n -0.000103 114.7400n -0.000030
+ 114.7500n 0.000030 114.7600n 0.000076 114.7700n 0.000105 114.7800n 0.000116 114.7900n 0.000107 114.8000n 0.000078 114.8100n 0.000028 114.8200n -0.000043 114.8300n -0.000133 114.8400n -0.000243 114.8500n -0.000371 114.8600n -0.000515 114.8700n -0.000673 114.8800n -0.000844 114.8900n -0.001023
+ 114.9000n -0.001209 114.9100n -0.001398 114.9200n -0.001587 114.9300n -0.001772 114.9400n -0.001951 114.9500n -0.002121 114.9600n -0.002277 114.9700n -0.002418 114.9800n -0.002540 114.9900n -0.002640 115.0000n -0.002718 115.0100n -0.002771 115.0200n -0.002797 115.0300n -0.002797 115.0400n -0.002768
+ 115.0500n -0.002711 115.0600n -0.002628 115.0700n -0.002517 115.0800n -0.002382 115.0900n -0.002222 115.1000n -0.002042 115.1100n -0.001842 115.1200n -0.001627 115.1300n -0.001398 115.1400n -0.001160 115.1500n -0.000915 115.1600n -0.000668 115.1700n -0.000422 115.1800n -0.000180 115.1900n 0.000053
+ 115.2000n 0.000275 115.2100n 0.000482 115.2200n 0.000671 115.2300n 0.000840 115.2400n 0.000986 115.2500n 0.001106 115.2600n 0.001201 115.2700n 0.001267 115.2800n 0.001306 115.2900n 0.001315 115.3000n 0.001296 115.3100n 0.001250 115.3200n 0.001177 115.3300n 0.001078 115.3400n 0.000957
+ 115.3500n 0.000815 115.3600n 0.000655 115.3700n 0.000480 115.3800n 0.000294 115.3900n 0.000099 115.4000n -0.000102 115.4100n -0.000303 115.4200n -0.000502 115.4300n -0.000695 115.4400n -0.000879 115.4500n -0.001051 115.4600n -0.001206 115.4700n -0.001344 115.4800n -0.001461 115.4900n -0.001555
+ 115.5000n -0.001624 115.5100n -0.001667 115.5200n -0.001684 115.5300n -0.001675 115.5400n -0.001638 115.5500n -0.001575 115.5600n -0.001488 115.5700n -0.001377 115.5800n -0.001244 115.5900n -0.001092 115.6000n -0.000924 115.6100n -0.000742 115.6200n -0.000551 115.6300n -0.000352 115.6400n -0.000150
+ 115.6500n 0.000052 115.6600n 0.000250 115.6700n 0.000440 115.6800n 0.000619 115.6900n 0.000783 115.7000n 0.000930 115.7100n 0.001057 115.7200n 0.001162 115.7300n 0.001241 115.7400n 0.001295 115.7500n 0.001321 115.7600n 0.001319 115.7700n 0.001289 115.7800n 0.001230 115.7900n 0.001145
+ 115.8000n 0.001034 115.8100n 0.000899 115.8200n 0.000741 115.8300n 0.000565 115.8400n 0.000372 115.8500n 0.000165 115.8600n -0.000051 115.8700n -0.000273 115.8800n -0.000498 115.8900n -0.000721 115.9000n -0.000939 115.9100n -0.001149 115.9200n -0.001346 115.9300n -0.001527 115.9400n -0.001690
+ 115.9500n -0.001831 115.9600n -0.001949 115.9700n -0.002040 115.9800n -0.002105 115.9900n -0.002142 116.0000n -0.002150 116.0100n -0.002130 116.0200n -0.002082 116.0300n -0.002007 116.0400n -0.001906 116.0500n -0.001782 116.0600n -0.001637 116.0700n -0.001473 116.0800n -0.001294 116.0900n -0.001103
+ 116.1000n -0.000903 116.1100n -0.000698 116.1200n -0.000492 116.1300n -0.000287 116.1400n -0.000088 116.1500n 0.000102 116.1600n 0.000280 116.1700n 0.000442 116.1800n 0.000587 116.1900n 0.000713 116.2000n 0.000816 116.2100n 0.000896 116.2200n 0.000952 116.2300n 0.000984 116.2400n 0.000991
+ 116.2500n 0.000973 116.2600n 0.000932 116.2700n 0.000868 116.2800n 0.000784 116.2900n 0.000681 116.3000n 0.000562 116.3100n 0.000429 116.3200n 0.000285 116.3300n 0.000132 116.3400n -0.000027 116.3500n -0.000188 116.3600n -0.000349 116.3700n -0.000507 116.3800n -0.000659 116.3900n -0.000804
+ 116.4000n -0.000938 116.4100n -0.001061 116.4200n -0.001171 116.4300n -0.001266 116.4400n -0.001346 116.4500n -0.001410 116.4600n -0.001459 116.4700n -0.001492 116.4800n -0.001510 116.4900n -0.001514 116.5000n -0.001504 116.5100n -0.001484 116.5200n -0.001453 116.5300n -0.001414 116.5400n -0.001369
+ 116.5500n -0.001319 116.5600n -0.001267 116.5700n -0.001213 116.5800n -0.001160 116.5900n -0.001109 116.6000n -0.001061 116.6100n -0.001018 116.6200n -0.000980 116.6300n -0.000949 116.6400n -0.000923 116.6500n -0.000904 116.6600n -0.000891 116.6700n -0.000883 116.6800n -0.000880 116.6900n -0.000880
+ 116.7000n -0.000883 116.7100n -0.000886 116.7200n -0.000889 116.7300n -0.000890 116.7400n -0.000887 116.7500n -0.000879 116.7600n -0.000863 116.7700n -0.000839 116.7800n -0.000806 116.7900n -0.000761 116.8000n -0.000706 116.8100n -0.000638 116.8200n -0.000557 116.8300n -0.000465 116.8400n -0.000360
+ 116.8500n -0.000244 116.8600n -0.000118 116.8700n 0.000016 116.8800n 0.000158 116.8900n 0.000305 116.9000n 0.000456 116.9100n 0.000607 116.9200n 0.000757 116.9300n 0.000903 116.9400n 0.001042 116.9500n 0.001172 116.9600n 0.001291 116.9700n 0.001396 116.9800n 0.001485 116.9900n 0.001556
+ 117.0000n 0.001608 117.0100n 0.001640 117.0200n 0.001650 117.0300n 0.001637 117.0400n 0.001602 117.0500n 0.001546 117.0600n 0.001468 117.0700n 0.001369 117.0800n 0.001251 117.0900n 0.001116 117.1000n 0.000966 117.1100n 0.000803 117.1200n 0.000629 117.1300n 0.000447 117.1400n 0.000261
+ 117.1500n 0.000072 117.1600n -0.000116 117.1700n -0.000300 117.1800n -0.000478 117.1900n -0.000647 117.2000n -0.000805 117.2100n -0.000949 117.2200n -0.001079 117.2300n -0.001192 117.2400n -0.001288 117.2500n -0.001366 117.2600n -0.001425 117.2700n -0.001465 117.2800n -0.001488 117.2900n -0.001493
+ 117.3000n -0.001483 117.3100n -0.001457 117.3200n -0.001419 117.3300n -0.001369 117.3400n -0.001310 117.3500n -0.001244 117.3600n -0.001174 117.3700n -0.001101 117.3800n -0.001027 117.3900n -0.000955 117.4000n -0.000886 117.4100n -0.000823 117.4200n -0.000766 117.4300n -0.000717 117.4400n -0.000676
+ 117.4500n -0.000645 117.4600n -0.000623 117.4700n -0.000610 117.4800n -0.000606 117.4900n -0.000610 117.5000n -0.000622 117.5100n -0.000639 117.5200n -0.000660 117.5300n -0.000684 117.5400n -0.000708 117.5500n -0.000732 117.5600n -0.000752 117.5700n -0.000767 117.5800n -0.000776 117.5900n -0.000776
+ 117.6000n -0.000766 117.6100n -0.000745 117.6200n -0.000711 117.6300n -0.000664 117.6400n -0.000604 117.6500n -0.000529 117.6600n -0.000441 117.6700n -0.000340 117.6800n -0.000227 117.6900n -0.000103 117.7000n 0.000030 117.7100n 0.000171 117.7200n 0.000317 117.7300n 0.000466 117.7400n 0.000616
+ 117.7500n 0.000764 117.7600n 0.000908 117.7700n 0.001045 117.7800n 0.001171 117.7900n 0.001286 117.8000n 0.001387 117.8100n 0.001471 117.8200n 0.001537 117.8300n 0.001584 117.8400n 0.001609 117.8500n 0.001613 117.8600n 0.001595 117.8700n 0.001555 117.8800n 0.001492 117.8900n 0.001409
+ 117.9000n 0.001305 117.9100n 0.001183 117.9200n 0.001044 117.9300n 0.000890 117.9400n 0.000723 117.9500n 0.000545 117.9600n 0.000360 117.9700n 0.000171 117.9800n -0.000021 117.9900n -0.000213 118.0000n -0.000401 118.0100n -0.000583 118.0200n -0.000756 118.0300n -0.000919 118.0400n -0.001069
+ 118.0500n -0.001205 118.0600n -0.001324 118.0700n -0.001426 118.0800n -0.001509 118.0900n -0.001574 118.1000n -0.001620 118.1100n -0.001647 118.1200n -0.001655 118.1300n -0.001645 118.1400n -0.001619 118.1500n -0.001576 118.1600n -0.001519 118.1700n -0.001449 118.1800n -0.001368 118.1900n -0.001278
+ 118.2000n -0.001180 118.2100n -0.001076 118.2200n -0.000968 118.2300n -0.000858 118.2400n -0.000747 118.2500n -0.000638 118.2600n -0.000531 118.2700n -0.000428 118.2800n -0.000330 118.2900n -0.000238 118.3000n -0.000153 118.3100n -0.000075 118.3200n -0.000005 118.3300n 0.000058 118.3400n 0.000112
+ 118.3500n 0.000158 118.3600n 0.000197 118.3700n 0.000228 118.3800n 0.000252 118.3900n 0.000270 118.4000n 0.000282 118.4100n 0.000288 118.4200n 0.000290 118.4300n 0.000288 118.4400n 0.000283 118.4500n 0.000275 118.4600n 0.000265 118.4700n 0.000253 118.4800n 0.000241 118.4900n 0.000228
+ 118.5000n 0.000214 118.5100n 0.000201 118.5200n 0.000189 118.5300n 0.000177 118.5400n 0.000167 118.5500n 0.000158 118.5600n 0.000151 118.5700n 0.000146 118.5800n 0.000143 118.5900n 0.000142 118.6000n 0.000144 118.6100n 0.000149 118.6200n 0.000157 118.6300n 0.000169 118.6400n 0.000184
+ 118.6500n 0.000203 118.6600n 0.000225 118.6700n 0.000252 118.6800n 0.000284 118.6900n 0.000319 118.7000n 0.000359 118.7100n 0.000403 118.7200n 0.000452 118.7300n 0.000504 118.7400n 0.000559 118.7500n 0.000617 118.7600n 0.000678 118.7700n 0.000740 118.7800n 0.000803 118.7900n 0.000865
+ 118.8000n 0.000926 118.8100n 0.000984 118.8200n 0.001038 118.8300n 0.001087 118.8400n 0.001129 118.8500n 0.001163 118.8600n 0.001188 118.8700n 0.001203 118.8800n 0.001206 118.8900n 0.001196 118.9000n 0.001173 118.9100n 0.001135 118.9200n 0.001083 118.9300n 0.001017 118.9400n 0.000935
+ 118.9500n 0.000840 118.9600n 0.000731 118.9700n 0.000610 118.9800n 0.000478 118.9900n 0.000336 119.0000n 0.000187 119.0100n 0.000033 119.0200n -0.000124 119.0300n -0.000281 119.0400n -0.000435 119.0500n -0.000583 119.0600n -0.000723 119.0700n -0.000851 119.0800n -0.000965 119.0900n -0.001061
+ 119.1000n -0.001137 119.1100n -0.001191 119.1200n -0.001220 119.1300n -0.001223 119.1400n -0.001198 119.1500n -0.001145 119.1600n -0.001062 119.1700n -0.000951 119.1800n -0.000811 119.1900n -0.000644 119.2000n -0.000452 119.2100n -0.000236 119.2200n 0.000001 119.2300n 0.000256 119.2400n 0.000525
+ 119.2500n 0.000804 119.2600n 0.001089 119.2700n 0.001377 119.2800n 0.001662 119.2900n 0.001940 119.3000n 0.002206 119.3100n 0.002456 119.3200n 0.002686 119.3300n 0.002891 119.3400n 0.003068 119.3500n 0.003214 119.3600n 0.003325 119.3700n 0.003400 119.3800n 0.003437 119.3900n 0.003435
+ 119.4000n 0.003393 119.4100n 0.003311 119.4200n 0.003191 119.4300n 0.003034 119.4400n 0.002842 119.4500n 0.002617 119.4600n 0.002364 119.4700n 0.002085 119.4800n 0.001785 119.4900n 0.001467 119.5000n 0.001138 119.5100n 0.000801 119.5200n 0.000461 119.5300n 0.000123 119.5400n -0.000208
+ 119.5500n -0.000528 119.5600n -0.000831 119.5700n -0.001116 119.5800n -0.001377 119.5900n -0.001613 119.6000n -0.001820 119.6100n -0.001997 119.6200n -0.002142 119.6300n -0.002255 119.6400n -0.002335 119.6500n -0.002382 119.6600n -0.002399 119.6700n -0.002386 119.6800n -0.002345 119.6900n -0.002278
+ 119.7000n -0.002189 119.7100n -0.002080 119.7200n -0.001954 119.7300n -0.001815 119.7400n -0.001665 119.7500n -0.001509 119.7600n -0.001348 119.7700n -0.001187 119.7800n -0.001028 119.7900n -0.000874 119.8000n -0.000726 119.8100n -0.000586 119.8200n -0.000456 119.8300n -0.000336 119.8400n -0.000227
+ 119.8500n -0.000129 119.8600n -0.000041 119.8700n 0.000036 119.8800n 0.000105 119.8900n 0.000166 119.9000n 0.000221 119.9100n 0.000272 119.9200n 0.000321 119.9300n 0.000368 119.9400n 0.000417 119.9500n 0.000469 119.9600n 0.000525 119.9700n 0.000586 119.9800n 0.000654 119.9900n 0.000730
+ 120.0000n 0.000813 120.0100n 0.000904 120.0200n 0.001002 120.0300n 0.001107 120.0400n 0.001216 120.0500n 0.001330 120.0600n 0.001445 120.0700n 0.001559 120.0800n 0.001670 120.0900n 0.001775 120.1000n 0.001871 120.1100n 0.001956 120.1200n 0.002026 120.1300n 0.002079 120.1400n 0.002112
+ 120.1500n 0.002123 120.1600n 0.002110 120.1700n 0.002070 120.1800n 0.002003 120.1900n 0.001909 120.2000n 0.001786 120.2100n 0.001635 120.2200n 0.001457 120.2300n 0.001254 120.2400n 0.001027 120.2500n 0.000780 120.2600n 0.000515 120.2700n 0.000235 120.2800n -0.000054 120.2900n -0.000349
+ 120.3000n -0.000645 120.3100n -0.000937 120.3200n -0.001221 120.3300n -0.001492 120.3400n -0.001745 120.3500n -0.001976 120.3600n -0.002180 120.3700n -0.002353 120.3800n -0.002493 120.3900n -0.002596 120.4000n -0.002660 120.4100n -0.002684 120.4200n -0.002666 120.4300n -0.002607 120.4400n -0.002507
+ 120.4500n -0.002367 120.4600n -0.002189 120.4700n -0.001975 120.4800n -0.001730 120.4900n -0.001456 120.5000n -0.001158 120.5100n -0.000840 120.5200n -0.000508 120.5300n -0.000166 120.5400n 0.000179 120.5500n 0.000524 120.5600n 0.000862 120.5700n 0.001189 120.5800n 0.001500 120.5900n 0.001790
+ 120.6000n 0.002056 120.6100n 0.002293 120.6200n 0.002499 120.6300n 0.002673 120.6400n 0.002811 120.6500n 0.002913 120.6600n 0.002979 120.6700n 0.003009 120.6800n 0.003004 120.6900n 0.002966 120.7000n 0.002897 120.7100n 0.002799 120.7200n 0.002676 120.7300n 0.002530 120.7400n 0.002367
+ 120.7500n 0.002189 120.7600n 0.002000 120.7700n 0.001805 120.7800n 0.001608 120.7900n 0.001413 120.8000n 0.001222 120.8100n 0.001040 120.8200n 0.000869 120.8300n 0.000712 120.8400n 0.000570 120.8500n 0.000446 120.8600n 0.000341 120.8700n 0.000254 120.8800n 0.000186 120.8900n 0.000137
+ 120.9000n 0.000106 120.9100n 0.000090 120.9200n 0.000090 120.9300n 0.000102 120.9400n 0.000124 120.9500n 0.000154 120.9600n 0.000189 120.9700n 0.000227 120.9800n 0.000264 120.9900n 0.000299 121.0000n 0.000329 121.0100n 0.000351 121.0200n 0.000365 121.0300n 0.000367 121.0400n 0.000358
+ 121.0500n 0.000336 121.0600n 0.000300 121.0700n 0.000252 121.0800n 0.000190 121.0900n 0.000116 121.1000n 0.000031 121.1100n -0.000063 121.1200n -0.000166 121.1300n -0.000274 121.1400n -0.000386 121.1500n -0.000499 121.1600n -0.000611 121.1700n -0.000719 121.1800n -0.000821 121.1900n -0.000915
+ 121.2000n -0.000998 121.2100n -0.001068 121.2200n -0.001124 121.2300n -0.001163 121.2400n -0.001186 121.2500n -0.001192 121.2600n -0.001179 121.2700n -0.001148 121.2800n -0.001100 121.2900n -0.001034 121.3000n -0.000953 121.3100n -0.000858 121.3200n -0.000751 121.3300n -0.000633 121.3400n -0.000507
+ 121.3500n -0.000376 121.3600n -0.000242 121.3700n -0.000108 121.3800n 0.000023 121.3900n 0.000150 121.4000n 0.000268 121.4100n 0.000376 121.4200n 0.000472 121.4300n 0.000553 121.4400n 0.000618 121.4500n 0.000664 121.4600n 0.000691 121.4700n 0.000699 121.4800n 0.000685 121.4900n 0.000651
+ 121.5000n 0.000596 121.5100n 0.000521 121.5200n 0.000426 121.5300n 0.000313 121.5400n 0.000183 121.5500n 0.000037 121.5600n -0.000123 121.5700n -0.000295 121.5800n -0.000478 121.5900n -0.000668 121.6000n -0.000864 121.6100n -0.001064 121.6200n -0.001265 121.6300n -0.001465 121.6400n -0.001663
+ 121.6500n -0.001856 121.6600n -0.002043 121.6700n -0.002221 121.6800n -0.002390 121.6900n -0.002548 121.7000n -0.002693 121.7100n -0.002824 121.7200n -0.002941 121.7300n -0.003042 121.7400n -0.003127 121.7500n -0.003195 121.7600n -0.003247 121.7700n -0.003280 121.7800n -0.003296 121.7900n -0.003294
+ 121.8000n -0.003274 121.8100n -0.003236 121.8200n -0.003180 121.8300n -0.003107 121.8400n -0.003016 121.8500n -0.002909 121.8600n -0.002785 121.8700n -0.002645 121.8800n -0.002490 121.8900n -0.002320 121.9000n -0.002137 121.9100n -0.001941 121.9200n -0.001733 121.9300n -0.001516 121.9400n -0.001289
+ 121.9500n -0.001056 121.9600n -0.000817 121.9700n -0.000574 121.9800n -0.000329 121.9900n -0.000085 122.0000n 0.000156 122.0100n 0.000393 122.0200n 0.000623 122.0300n 0.000843 122.0400n 0.001052 122.0500n 0.001246 122.0600n 0.001424 122.0700n 0.001584 122.0800n 0.001724 122.0900n 0.001842
+ 122.1000n 0.001937 122.1100n 0.002007 122.1200n 0.002052 122.1300n 0.002071 122.1400n 0.002064 122.1500n 0.002031 122.1600n 0.001973 122.1700n 0.001891 122.1800n 0.001786 122.1900n 0.001660 122.2000n 0.001515 122.2100n 0.001354 122.2200n 0.001180 122.2300n 0.000995 122.2400n 0.000804
+ 122.2500n 0.000609 122.2600n 0.000414 122.2700n 0.000224 122.2800n 0.000041 122.2900n -0.000131 122.3000n -0.000288 122.3100n -0.000427 122.3200n -0.000545 122.3300n -0.000640 122.3400n -0.000708 122.3500n -0.000748 122.3600n -0.000759 122.3700n -0.000740 122.3800n -0.000690 122.3900n -0.000610
+ 122.4000n -0.000499 122.4100n -0.000360 122.4200n -0.000194 122.4300n -0.000003 122.4400n 0.000210 122.4500n 0.000442 122.4600n 0.000691 122.4700n 0.000951 122.4800n 0.001220 122.4900n 0.001494 122.5000n 0.001768 122.5100n 0.002039 122.5200n 0.002301 122.5300n 0.002553 122.5400n 0.002790
+ 122.5500n 0.003008 122.5600n 0.003205 122.5700n 0.003378 122.5800n 0.003525 122.5900n 0.003645 122.6000n 0.003735 122.6100n 0.003796 122.6200n 0.003827 122.6300n 0.003829 122.6400n 0.003803 122.6500n 0.003748 122.6600n 0.003668 122.6700n 0.003565 122.6800n 0.003440 122.6900n 0.003296
+ 122.7000n 0.003136 122.7100n 0.002963 122.7200n 0.002780 122.7300n 0.002590 122.7400n 0.002395 122.7500n 0.002200 122.7600n 0.002006 122.7700n 0.001816 122.7800n 0.001631 122.7900n 0.001455 122.8000n 0.001288 122.8100n 0.001131 122.8200n 0.000985 122.8300n 0.000852 122.8400n 0.000730
+ 122.8500n 0.000620 122.8600n 0.000521 122.8700n 0.000432 122.8800n 0.000352 122.8900n 0.000280 122.9000n 0.000215 122.9100n 0.000156 122.9200n 0.000099 122.9300n 0.000046 122.9400n -0.000007 122.9500n -0.000061 122.9600n -0.000116 122.9700n -0.000173 122.9800n -0.000233 122.9900n -0.000297
+ 123.0000n -0.000364 123.0100n -0.000434 123.0200n -0.000507 123.0300n -0.000583 123.0400n -0.000659 123.0500n -0.000735 123.0600n -0.000810 123.0700n -0.000881 123.0800n -0.000947 123.0900n -0.001006 123.1000n -0.001056 123.1100n -0.001095 123.1200n -0.001122 123.1300n -0.001135 123.1400n -0.001132
+ 123.1500n -0.001112 123.1600n -0.001074 123.1700n -0.001018 123.1800n -0.000943 123.1900n -0.000849 123.2000n -0.000736 123.2100n -0.000606 123.2200n -0.000460 123.2300n -0.000298 123.2400n -0.000124 123.2500n 0.000062 123.2600n 0.000256 123.2700n 0.000456 123.2800n 0.000659 123.2900n 0.000862
+ 123.3000n 0.001062 123.3100n 0.001256 123.3200n 0.001440 123.3300n 0.001613 123.3400n 0.001772 123.3500n 0.001913 123.3600n 0.002035 123.3700n 0.002136 123.3800n 0.002214 123.3900n 0.002269 123.4000n 0.002298 123.4100n 0.002303 123.4200n 0.002284 123.4300n 0.002240 123.4400n 0.002173
+ 123.4500n 0.002083 123.4600n 0.001974 123.4700n 0.001846 123.4800n 0.001702 123.4900n 0.001544 123.5000n 0.001375 123.5100n 0.001198 123.5200n 0.001015 123.5300n 0.000829 123.5400n 0.000643 123.5500n 0.000459 123.5600n 0.000281 123.5700n 0.000109 123.5800n -0.000053 123.5900n -0.000204
+ 123.6000n -0.000343 123.6100n -0.000468 123.6200n -0.000579 123.6300n -0.000675 123.6400n -0.000755 123.6500n -0.000821 123.6600n -0.000871 123.6700n -0.000907 123.6800n -0.000929 123.6900n -0.000939 123.7000n -0.000937 123.7100n -0.000925 123.7200n -0.000904 123.7300n -0.000875 123.7400n -0.000840
+ 123.7500n -0.000799 123.7600n -0.000754 123.7700n -0.000706 123.7800n -0.000655 123.7900n -0.000604 123.8000n -0.000551 123.8100n -0.000497 123.8200n -0.000443 123.8300n -0.000389 123.8400n -0.000335 123.8500n -0.000281 123.8600n -0.000225 123.8700n -0.000169 123.8800n -0.000111 123.8900n -0.000052
+ 123.9000n 0.000010 123.9100n 0.000074 123.9200n 0.000141 123.9300n 0.000211 123.9400n 0.000283 123.9500n 0.000358 123.9600n 0.000435 123.9700n 0.000514 123.9800n 0.000594 123.9900n 0.000674 124.0000n 0.000753 124.0100n 0.000830 124.0200n 0.000904 124.0300n 0.000972 124.0400n 0.001035
+ 124.0500n 0.001089 124.0600n 0.001134 124.0700n 0.001169 124.0800n 0.001191 124.0900n 0.001200 124.1000n 0.001194 124.1100n 0.001174 124.1200n 0.001137 124.1300n 0.001085 124.1400n 0.001017 124.1500n 0.000933 124.1600n 0.000835 124.1700n 0.000723 124.1800n 0.000599 124.1900n 0.000464
+ 124.2000n 0.000321 124.2100n 0.000172 124.2200n 0.000019 124.2300n -0.000136 124.2400n -0.000289 124.2500n -0.000437 124.2600n -0.000578 124.2700n -0.000709 124.2800n -0.000828 124.2900n -0.000932 124.3000n -0.001018 124.3100n -0.001086 124.3200n -0.001133 124.3300n -0.001159 124.3400n -0.001163
+ 124.3500n -0.001144 124.3600n -0.001103 124.3700n -0.001041 124.3800n -0.000960 124.3900n -0.000860 124.4000n -0.000744 124.4100n -0.000615 124.4200n -0.000475 124.4300n -0.000328 124.4400n -0.000177 124.4500n -0.000026 124.4600n 0.000122 124.4700n 0.000263 124.4800n 0.000393 124.4900n 0.000508
+ 124.5000n 0.000607 124.5100n 0.000685 124.5200n 0.000740 124.5300n 0.000771 124.5400n 0.000775 124.5500n 0.000752 124.5600n 0.000701 124.5700n 0.000622 124.5800n 0.000517 124.5900n 0.000385 124.6000n 0.000230 124.6100n 0.000053 124.6200n -0.000143 124.6300n -0.000354 124.6400n -0.000577
+ 124.6500n -0.000807 124.6600n -0.001041 124.6700n -0.001275 124.6800n -0.001503 124.6900n -0.001722 124.7000n -0.001928 124.7100n -0.002117 124.7200n -0.002285 124.7300n -0.002429 124.7400n -0.002547 124.7500n -0.002635 124.7600n -0.002693 124.7700n -0.002720 124.7800n -0.002715 124.7900n -0.002678
+ 124.8000n -0.002610 124.8100n -0.002512 124.8200n -0.002386 124.8300n -0.002235 124.8400n -0.002061 124.8500n -0.001868 124.8600n -0.001659 124.8700n -0.001439 124.8800n -0.001210 124.8900n -0.000977 124.9000n -0.000744 124.9100n -0.000514 124.9200n -0.000292 124.9300n -0.000080 124.9400n 0.000118
+ 124.9500n 0.000300 124.9600n 0.000464 124.9700n 0.000608 124.9800n 0.000731 124.9900n 0.000832 125.0000n 0.000912 125.0100n 0.000971 125.0200n 0.001009 125.0300n 0.001029 125.0400n 0.001031 125.0500n 0.001019 125.0600n 0.000994 125.0700n 0.000959 125.0800n 0.000917 125.0900n 0.000871
+ 125.1000n 0.000823 125.1100n 0.000776 125.1200n 0.000732 125.1300n 0.000694 125.1400n 0.000664 125.1500n 0.000642 125.1600n 0.000630 125.1700n 0.000629 125.1800n 0.000638 125.1900n 0.000657 125.2000n 0.000685 125.2100n 0.000722 125.2200n 0.000764 125.2300n 0.000811 125.2400n 0.000860
+ 125.2500n 0.000908 125.2600n 0.000952 125.2700n 0.000990 125.2800n 0.001019 125.2900n 0.001035 125.3000n 0.001037 125.3100n 0.001021 125.3200n 0.000986 125.3300n 0.000931 125.3400n 0.000853 125.3500n 0.000752 125.3600n 0.000628 125.3700n 0.000481 125.3800n 0.000313 125.3900n 0.000124
+ 125.4000n -0.000082 125.4100n -0.000304 125.4200n -0.000538 125.4300n -0.000781 125.4400n -0.001028 125.4500n -0.001275 125.4600n -0.001519 125.4700n -0.001753 125.4800n -0.001974 125.4900n -0.002178 125.5000n -0.002360 125.5100n -0.002515 125.5200n -0.002641 125.5300n -0.002734 125.5400n -0.002793
+ 125.5500n -0.002814 125.5600n -0.002797 125.5700n -0.002741 125.5800n -0.002646 125.5900n -0.002514 125.6000n -0.002346 125.6100n -0.002145 125.6200n -0.001913 125.6300n -0.001654 125.6400n -0.001373 125.6500n -0.001075 125.6600n -0.000764 125.6700n -0.000445 125.6800n -0.000125 125.6900n 0.000191
+ 125.7000n 0.000498 125.7100n 0.000791 125.7200n 0.001064 125.7300n 0.001313 125.7400n 0.001533 125.7500n 0.001722 125.7600n 0.001877 125.7700n 0.001995 125.7800n 0.002075 125.7900n 0.002117 125.8000n 0.002120 125.8100n 0.002086 125.8200n 0.002017 125.8300n 0.001915 125.8400n 0.001783
+ 125.8500n 0.001624 125.8600n 0.001445 125.8700n 0.001247 125.8800n 0.001038 125.8900n 0.000822 125.9000n 0.000604 125.9100n 0.000389 125.9200n 0.000182 125.9300n -0.000011 125.9400n -0.000187 125.9500n -0.000342 125.9600n -0.000472 125.9700n -0.000574 125.9800n -0.000647 125.9900n -0.000689
+ 126.0000n -0.000700 126.0100n -0.000679 126.0200n -0.000628 126.0300n -0.000548 126.0400n -0.000442 126.0500n -0.000312 126.0600n -0.000162 126.0700n 0.000004 126.0800n 0.000183 126.0900n 0.000369 126.1000n 0.000557 126.1100n 0.000744 126.1200n 0.000924 126.1300n 0.001093 126.1400n 0.001246
+ 126.1500n 0.001380 126.1600n 0.001492 126.1700n 0.001578 126.1800n 0.001636 126.1900n 0.001665 126.2000n 0.001663 126.2100n 0.001630 126.2200n 0.001567 126.2300n 0.001475 126.2400n 0.001355 126.2500n 0.001209 126.2600n 0.001041 126.2700n 0.000853 126.2800n 0.000650 126.2900n 0.000435
+ 126.3000n 0.000212 126.3100n -0.000014 126.3200n -0.000239 126.3300n -0.000460 126.3400n -0.000672 126.3500n -0.000871 126.3600n -0.001054 126.3700n -0.001219 126.3800n -0.001363 126.3900n -0.001485 126.4000n -0.001583 126.4100n -0.001656 126.4200n -0.001705 126.4300n -0.001730 126.4400n -0.001733
+ 126.4500n -0.001714 126.4600n -0.001677 126.4700n -0.001623 126.4800n -0.001556 126.4900n -0.001478 126.5000n -0.001393 126.5100n -0.001305 126.5200n -0.001216 126.5300n -0.001129 126.5400n -0.001048 126.5500n -0.000975 126.5600n -0.000913 126.5700n -0.000863 126.5800n -0.000827 126.5900n -0.000805
+ 126.6000n -0.000798 126.6100n -0.000806 126.6200n -0.000827 126.6300n -0.000861 126.6400n -0.000906 126.6500n -0.000959 126.6600n -0.001018 126.6700n -0.001079 126.6800n -0.001139 126.6900n -0.001196 126.7000n -0.001244 126.7100n -0.001282 126.7200n -0.001305 126.7300n -0.001310 126.7400n -0.001295
+ 126.7500n -0.001257 126.7600n -0.001193 126.7700n -0.001104 126.7800n -0.000986 126.7900n -0.000841 126.8000n -0.000669 126.8100n -0.000471 126.8200n -0.000248 126.8300n -0.000003 126.8400n 0.000261 126.8500n 0.000541 126.8600n 0.000832 126.8700n 0.001130 126.8800n 0.001431 126.8900n 0.001729
+ 126.9000n 0.002020 126.9100n 0.002297 126.9200n 0.002557 126.9300n 0.002794 126.9400n 0.003003 126.9500n 0.003180 126.9600n 0.003322 126.9700n 0.003425 126.9800n 0.003488 126.9900n 0.003507 127.0000n 0.003482 127.0100n 0.003413 127.0200n 0.003301 127.0300n 0.003145 127.0400n 0.002949
+ 127.0500n 0.002716 127.0600n 0.002447 127.0700n 0.002149 127.0800n 0.001825 127.0900n 0.001480 127.1000n 0.001119 127.1100n 0.000749 127.1200n 0.000375 127.1300n 0.000002 127.1400n -0.000363 127.1500n -0.000716 127.1600n -0.001050 127.1700n -0.001362 127.1800n -0.001647 127.1900n -0.001901
+ 127.2000n -0.002121 127.2100n -0.002304 127.2200n -0.002449 127.2300n -0.002555 127.2400n -0.002621 127.2500n -0.002648 127.2600n -0.002636 127.2700n -0.002587 127.2800n -0.002504 127.2900n -0.002390 127.3000n -0.002247 127.3100n -0.002080 127.3200n -0.001891 127.3300n -0.001686 127.3400n -0.001468
+ 127.3500n -0.001242 127.3600n -0.001012 127.3700n -0.000782 127.3800n -0.000554 127.3900n -0.000334 127.4000n -0.000124 127.4100n 0.000075 127.4200n 0.000259 127.4300n 0.000427 127.4400n 0.000578 127.4500n 0.000712 127.4600n 0.000829 127.4700n 0.000928 127.4800n 0.001012 127.4900n 0.001081
+ 127.5000n 0.001138 127.5100n 0.001183 127.5200n 0.001220 127.5300n 0.001250 127.5400n 0.001277 127.5500n 0.001302 127.5600n 0.001328 127.5700n 0.001357 127.5800n 0.001391 127.5900n 0.001432 127.6000n 0.001481 127.6100n 0.001538 127.6200n 0.001606 127.6300n 0.001683 127.6400n 0.001770
+ 127.6500n 0.001866 127.6600n 0.001969 127.6700n 0.002079 127.6800n 0.002193 127.6900n 0.002310 127.7000n 0.002426 127.7100n 0.002539 127.7200n 0.002647 127.7300n 0.002746 127.7400n 0.002833 127.7500n 0.002907 127.7600n 0.002964 127.7700n 0.003001 127.7800n 0.003017 127.7900n 0.003010
+ 127.8000n 0.002978 127.8100n 0.002920 127.8200n 0.002835 127.8300n 0.002725 127.8400n 0.002588 127.8500n 0.002425 127.8600n 0.002239 127.8700n 0.002031 127.8800n 0.001802 127.8900n 0.001556 127.9000n 0.001295 127.9100n 0.001024 127.9200n 0.000744 127.9300n 0.000460 127.9400n 0.000175
+ 127.9500n -0.000106 127.9600n -0.000381 127.9700n -0.000645 127.9800n -0.000895 127.9900n -0.001128 128.0000n -0.001342 128.0100n -0.001533 128.0200n -0.001700 128.0300n -0.001841 128.0400n -0.001954 128.0500n -0.002040 128.0600n -0.002096 128.0700n -0.002125 128.0800n -0.002125 128.0900n -0.002099
+ 128.1000n -0.002047 128.1100n -0.001972 128.1200n -0.001875 128.1300n -0.001758 128.1400n -0.001625 128.1500n -0.001479 128.1600n -0.001321 128.1700n -0.001155 128.1800n -0.000984 128.1900n -0.000810 128.2000n -0.000637 128.2100n -0.000468 128.2200n -0.000303 128.2300n -0.000147 128.2400n -0.000000
+ 128.2500n 0.000134 128.2600n 0.000256 128.2700n 0.000364 128.2800n 0.000457 128.2900n 0.000534 128.3000n 0.000595 128.3100n 0.000640 128.3200n 0.000670 128.3300n 0.000685 128.3400n 0.000685 128.3500n 0.000672 128.3600n 0.000646 128.3700n 0.000609 128.3800n 0.000561 128.3900n 0.000505
+ 128.4000n 0.000441 128.4100n 0.000370 128.4200n 0.000295 128.4300n 0.000216 128.4400n 0.000134 128.4500n 0.000050 128.4600n -0.000034 128.4700n -0.000118 128.4800n -0.000201 128.4900n -0.000282 128.5000n -0.000360 128.5100n -0.000435 128.5200n -0.000507 128.5300n -0.000575 128.5400n -0.000639
+ 128.5500n -0.000698 128.5600n -0.000753 128.5700n -0.000803 128.5800n -0.000847 128.5900n -0.000887 128.6000n -0.000920 128.6100n -0.000948 128.6200n -0.000970 128.6300n -0.000986 128.6400n -0.000995 128.6500n -0.000997 128.6600n -0.000993 128.6700n -0.000981 128.6800n -0.000962 128.6900n -0.000936
+ 128.7000n -0.000901 128.7100n -0.000859 128.7200n -0.000809 128.7300n -0.000751 128.7400n -0.000685 128.7500n -0.000612 128.7600n -0.000531 128.7700n -0.000443 128.7800n -0.000349 128.7900n -0.000249 128.8000n -0.000143 128.8100n -0.000034 128.8200n 0.000080 128.8300n 0.000196 128.8400n 0.000315
+ 128.8500n 0.000434 128.8600n 0.000552 128.8700n 0.000670 128.8800n 0.000785 128.8900n 0.000898 128.9000n 0.001006 128.9100n 0.001109 128.9200n 0.001206 128.9300n 0.001297 128.9400n 0.001381 128.9500n 0.001457 128.9600n 0.001526 128.9700n 0.001586 128.9800n 0.001638 128.9900n 0.001682
+ 129.0000n 0.001718 129.0100n 0.001747 129.0200n 0.001768 129.0300n 0.001782 129.0400n 0.001790 129.0500n 0.001792 129.0600n 0.001789 129.0700n 0.001780 129.0800n 0.001768 129.0900n 0.001752 129.1000n 0.001732 129.1100n 0.001710 129.1200n 0.001684 129.1300n 0.001656 129.1400n 0.001626
+ 129.1500n 0.001593 129.1600n 0.001557 129.1700n 0.001517 129.1800n 0.001474 129.1900n 0.001427 129.2000n 0.001374 129.2100n 0.001316 129.2200n 0.001252 129.2300n 0.001180 129.2400n 0.001100 129.2500n 0.001011 129.2600n 0.000912 129.2700n 0.000803 129.2800n 0.000683 129.2900n 0.000552
+ 129.3000n 0.000409 129.3100n 0.000254 129.3200n 0.000089 129.3300n -0.000089 129.3400n -0.000276 129.3500n -0.000473 129.3600n -0.000679 129.3700n -0.000893 129.3800n -0.001112 129.3900n -0.001336 129.4000n -0.001561 129.4100n -0.001787 129.4200n -0.002011 129.4300n -0.002231 129.4400n -0.002444
+ 129.4500n -0.002649 129.4600n -0.002842 129.4700n -0.003021 129.4800n -0.003186 129.4900n -0.003332 129.5000n -0.003459 129.5100n -0.003564 129.5200n -0.003648 129.5300n -0.003707 129.5400n -0.003742 129.5500n -0.003752 129.5600n -0.003737 129.5700n -0.003698 129.5800n -0.003633 129.5900n -0.003545
+ 129.6000n -0.003435 129.6100n -0.003303 129.6200n -0.003152 129.6300n -0.002984 129.6400n -0.002800 129.6500n -0.002603 129.6600n -0.002396 129.6700n -0.002180 129.6800n -0.001959 129.6900n -0.001735 129.7000n -0.001510 129.7100n -0.001288 129.7200n -0.001070 129.7300n -0.000858 129.7400n -0.000656
+ 129.7500n -0.000464 129.7600n -0.000284 129.7700n -0.000118 129.7800n 0.000034 129.7900n 0.000169 129.8000n 0.000289 129.8100n 0.000392 129.8200n 0.000478 129.8300n 0.000548 129.8400n 0.000601 129.8500n 0.000639 129.8600n 0.000662 129.8700n 0.000670 129.8800n 0.000665 129.8900n 0.000648
+ 129.9000n 0.000621 129.9100n 0.000583 129.9200n 0.000537 129.9300n 0.000484 129.9400n 0.000424 129.9500n 0.000360 129.9600n 0.000292 129.9700n 0.000221 129.9800n 0.000149 129.9900n 0.000076 130.0000n 0.000003 130.0100n -0.000068 130.0200n -0.000138 130.0300n -0.000206 130.0400n -0.000270
+ 130.0500n -0.000331 130.0600n -0.000387 130.0700n -0.000438 130.0800n -0.000484 130.0900n -0.000525 130.1000n -0.000558 130.1100n -0.000585 130.1200n -0.000604 130.1300n -0.000616 130.1400n -0.000619 130.1500n -0.000612 130.1600n -0.000596 130.1700n -0.000571 130.1800n -0.000534 130.1900n -0.000487
+ 130.2000n -0.000429 130.2100n -0.000359 130.2200n -0.000278 130.2300n -0.000186 130.2400n -0.000083 130.2500n 0.000031 130.2600n 0.000154 130.2700n 0.000287 130.2800n 0.000428 130.2900n 0.000576 130.3000n 0.000729 130.3100n 0.000886 130.3200n 0.001044 130.3300n 0.001203 130.3400n 0.001358
+ 130.3500n 0.001509 130.3600n 0.001652 130.3700n 0.001786 130.3800n 0.001907 130.3900n 0.002012 130.4000n 0.002100 130.4100n 0.002169 130.4200n 0.002215 130.4300n 0.002237 130.4400n 0.002233 130.4500n 0.002202 130.4600n 0.002142 130.4700n 0.002054 130.4800n 0.001937 130.4900n 0.001790
+ 130.5000n 0.001616 130.5100n 0.001414 130.5200n 0.001187 130.5300n 0.000937 130.5400n 0.000665 130.5500n 0.000376 130.5600n 0.000072 130.5700n -0.000242 130.5800n -0.000563 130.5900n -0.000887 130.6000n -0.001210 130.6100n -0.001526 130.6200n -0.001831 130.6300n -0.002121 130.6400n -0.002392
+ 130.6500n -0.002639 130.6600n -0.002859 130.6700n -0.003048 130.6800n -0.003203 130.6900n -0.003321 130.7000n -0.003401 130.7100n -0.003441 130.7200n -0.003440 130.7300n -0.003397 130.7400n -0.003313 130.7500n -0.003189 130.7600n -0.003027 130.7700n -0.002828 130.7800n -0.002595 130.7900n -0.002332
+ 130.8000n -0.002043 130.8100n -0.001730 130.8200n -0.001399 130.8300n -0.001054 130.8400n -0.000701 130.8500n -0.000343 130.8600n 0.000013 130.8700n 0.000364 130.8800n 0.000704 130.8900n 0.001030 130.9000n 0.001336 130.9100n 0.001619 130.9200n 0.001876 130.9300n 0.002105 130.9400n 0.002301
+ 130.9500n 0.002465 130.9600n 0.002595 130.9700n 0.002689 130.9800n 0.002749 130.9900n 0.002775 131.0000n 0.002767 131.0100n 0.002728 131.0200n 0.002660 131.0300n 0.002565 131.0400n 0.002445 131.0500n 0.002305 131.0600n 0.002148 131.0700n 0.001977 131.0800n 0.001795 131.0900n 0.001607
+ 131.1000n 0.001417 131.1100n 0.001227 131.1200n 0.001041 131.1300n 0.000862 131.1400n 0.000694 131.1500n 0.000538 131.1600n 0.000396 131.1700n 0.000270 131.1800n 0.000163 131.1900n 0.000073 131.2000n 0.000003 131.2100n -0.000049 131.2200n -0.000082 131.2300n -0.000096 131.2400n -0.000094
+ 131.2500n -0.000077 131.2600n -0.000045 131.2700n -0.000001 131.2800n 0.000053 131.2900n 0.000116 131.3000n 0.000184 131.3100n 0.000257 131.3200n 0.000332 131.3300n 0.000407 131.3400n 0.000480 131.3500n 0.000550 131.3600n 0.000615 131.3700n 0.000674 131.3800n 0.000725 131.3900n 0.000769
+ 131.4000n 0.000804 131.4100n 0.000831 131.4200n 0.000848 131.4300n 0.000857 131.4400n 0.000858 131.4500n 0.000852 131.4600n 0.000838 131.4700n 0.000819 131.4800n 0.000794 131.4900n 0.000766 131.5000n 0.000735 131.5100n 0.000701 131.5200n 0.000667 131.5300n 0.000633 131.5400n 0.000600
+ 131.5500n 0.000569 131.5600n 0.000540 131.5700n 0.000514 131.5800n 0.000491 131.5900n 0.000472 131.6000n 0.000456 131.6100n 0.000443 131.6200n 0.000434 131.6300n 0.000427 131.6400n 0.000423 131.6500n 0.000420 131.6600n 0.000419 131.6700n 0.000418 131.6800n 0.000418 131.6900n 0.000417
+ 131.7000n 0.000414 131.7100n 0.000410 131.7200n 0.000404 131.7300n 0.000395 131.7400n 0.000384 131.7500n 0.000370 131.7600n 0.000353 131.7700n 0.000333 131.7800n 0.000310 131.7900n 0.000286 131.8000n 0.000260 131.8100n 0.000232 131.8200n 0.000205 131.8300n 0.000177 131.8400n 0.000151
+ 131.8500n 0.000126 131.8600n 0.000103 131.8700n 0.000084 131.8800n 0.000069 131.8900n 0.000058 131.9000n 0.000052 131.9100n 0.000051 131.9200n 0.000055 131.9300n 0.000065 131.9400n 0.000080 131.9500n 0.000100 131.9600n 0.000125 131.9700n 0.000154 131.9800n 0.000187 131.9900n 0.000223
+ 132.0000n 0.000260 132.0100n 0.000298 132.0200n 0.000336 132.0300n 0.000373 132.0400n 0.000407 132.0500n 0.000438 132.0600n 0.000464 132.0700n 0.000485 132.0800n 0.000500 132.0900n 0.000507 132.1000n 0.000506 132.1100n 0.000497 132.1200n 0.000480 132.1300n 0.000454 132.1400n 0.000420
+ 132.1500n 0.000377 132.1600n 0.000327 132.1700n 0.000270 132.1800n 0.000206 132.1900n 0.000138 132.2000n 0.000065 132.2100n -0.000010 132.2200n -0.000087 132.2300n -0.000164 132.2400n -0.000240 132.2500n -0.000313 132.2600n -0.000381 132.2700n -0.000445 132.2800n -0.000501 132.2900n -0.000550
+ 132.3000n -0.000590 132.3100n -0.000621 132.3200n -0.000642 132.3300n -0.000652 132.3400n -0.000652 132.3500n -0.000641 132.3600n -0.000620 132.3700n -0.000589 132.3800n -0.000548 132.3900n -0.000500 132.4000n -0.000444 132.4100n -0.000382 132.4200n -0.000315 132.4300n -0.000244 132.4400n -0.000172
+ 132.4500n -0.000099 132.4600n -0.000026 132.4700n 0.000044 132.4800n 0.000111 132.4900n 0.000172 132.5000n 0.000228 132.5100n 0.000277 132.5200n 0.000318 132.5300n 0.000351 132.5400n 0.000374 132.5500n 0.000388 132.5600n 0.000393 132.5700n 0.000389 132.5800n 0.000376 132.5900n 0.000354
+ 132.6000n 0.000325 132.6100n 0.000289 132.6200n 0.000247 132.6300n 0.000200 132.6400n 0.000149 132.6500n 0.000095 132.6600n 0.000041 132.6700n -0.000014 132.6800n -0.000067 132.6900n -0.000118 132.7000n -0.000166 132.7100n -0.000208 132.7200n -0.000246 132.7300n -0.000277 132.7400n -0.000301
+ 132.7500n -0.000317 132.7600n -0.000326 132.7700n -0.000326 132.7800n -0.000318 132.7900n -0.000302 132.8000n -0.000278 132.8100n -0.000247 132.8200n -0.000208 132.8300n -0.000163 132.8400n -0.000112 132.8500n -0.000056 132.8600n 0.000004 132.8700n 0.000068 132.8800n 0.000135 132.8900n 0.000204
+ 132.9000n 0.000273 132.9100n 0.000343 132.9200n 0.000413 132.9300n 0.000482 132.9400n 0.000549 132.9500n 0.000614 132.9600n 0.000676 132.9700n 0.000735 132.9800n 0.000792 132.9900n 0.000844 133.0000n 0.000894 133.0100n 0.000939 133.0200n 0.000981 133.0300n 0.001020 133.0400n 0.001055
+ 133.0500n 0.001087 133.0600n 0.001116 133.0700n 0.001142 133.0800n 0.001165 133.0900n 0.001185 133.1000n 0.001204 133.1100n 0.001220 133.1200n 0.001234 133.1300n 0.001246 133.1400n 0.001256 133.1500n 0.001265 133.1600n 0.001272 133.1700n 0.001278 133.1800n 0.001282 133.1900n 0.001285
+ 133.2000n 0.001287 133.2100n 0.001287 133.2200n 0.001286 133.2300n 0.001284 133.2400n 0.001281 133.2500n 0.001277 133.2600n 0.001272 133.2700n 0.001266 133.2800n 0.001260 133.2900n 0.001253 133.3000n 0.001246 133.3100n 0.001239 133.3200n 0.001232 133.3300n 0.001225 133.3400n 0.001218
+ 133.3500n 0.001212 133.3600n 0.001207 133.3700n 0.001203 133.3800n 0.001199 133.3900n 0.001196 133.4000n 0.001194 133.4100n 0.001193 133.4200n 0.001193 133.4300n 0.001193 133.4400n 0.001193 133.4500n 0.001193 133.4600n 0.001192 133.4700n 0.001191 133.4800n 0.001189 133.4900n 0.001184
+ 133.5000n 0.001178 133.5100n 0.001169 133.5200n 0.001158 133.5300n 0.001143 133.5400n 0.001124 133.5500n 0.001101 133.5600n 0.001075 133.5700n 0.001044 133.5800n 0.001010 133.5900n 0.000971 133.6000n 0.000930 133.6100n 0.000885 133.6200n 0.000837 133.6300n 0.000788 133.6400n 0.000738
+ 133.6500n 0.000689 133.6600n 0.000640 133.6700n 0.000593 133.6800n 0.000551 133.6900n 0.000512 133.7000n 0.000480 133.7100n 0.000455 133.7200n 0.000438 133.7300n 0.000430 133.7400n 0.000433 133.7500n 0.000447 133.7600n 0.000473 133.7700n 0.000510 133.7800n 0.000561 133.7900n 0.000624
+ 133.8000n 0.000699 133.8100n 0.000785 133.8200n 0.000882 133.8300n 0.000989 133.8400n 0.001104 133.8500n 0.001226 133.8600n 0.001352 133.8700n 0.001481 133.8800n 0.001611 133.8900n 0.001739 133.9000n 0.001863 133.9100n 0.001980 133.9200n 0.002088 133.9300n 0.002185 133.9400n 0.002268
+ 133.9500n 0.002335 133.9600n 0.002384 133.9700n 0.002415 133.9800n 0.002424 133.9900n 0.002412 134.0000n 0.002379 134.0100n 0.002323 134.0200n 0.002245 134.0300n 0.002146 134.0400n 0.002027 134.0500n 0.001890 134.0600n 0.001736 134.0700n 0.001568 134.0800n 0.001390 134.0900n 0.001202
+ 134.1000n 0.001011 134.1100n 0.000817 134.1200n 0.000626 134.1300n 0.000441 134.1400n 0.000266 134.1500n 0.000103 134.1600n -0.000042 134.1700n -0.000168 134.1800n -0.000271 134.1900n -0.000349 134.2000n -0.000399 134.2100n -0.000421 134.2200n -0.000412 134.2300n -0.000372 134.2400n -0.000301
+ 134.2500n -0.000200 134.2600n -0.000070 134.2700n 0.000088 134.2800n 0.000271 134.2900n 0.000477 134.3000n 0.000702 134.3100n 0.000943 134.3200n 0.001196 134.3300n 0.001456 134.3400n 0.001720 134.3500n 0.001982 134.3600n 0.002239 134.3700n 0.002486 134.3800n 0.002718 134.3900n 0.002932
+ 134.4000n 0.003124 134.4100n 0.003291 134.4200n 0.003429 134.4300n 0.003537 134.4400n 0.003612 134.4500n 0.003655 134.4600n 0.003663 134.4700n 0.003637 134.4800n 0.003578 134.4900n 0.003488 134.5000n 0.003367 134.5100n 0.003220 134.5200n 0.003047 134.5300n 0.002854 134.5400n 0.002644
+ 134.5500n 0.002420 134.5600n 0.002188 134.5700n 0.001951 134.5800n 0.001714 134.5900n 0.001481 134.6000n 0.001256 134.6100n 0.001043 134.6200n 0.000846 134.6300n 0.000668 134.6400n 0.000511 134.6500n 0.000378 134.6600n 0.000271 134.6700n 0.000190 134.6800n 0.000136 134.6900n 0.000109
+ 134.7000n 0.000108 134.7100n 0.000133 134.7200n 0.000180 134.7300n 0.000248 134.7400n 0.000335 134.7500n 0.000437 134.7600n 0.000551 134.7700n 0.000673 134.7800n 0.000801 134.7900n 0.000929 134.8000n 0.001055 134.8100n 0.001174 134.8200n 0.001285 134.8300n 0.001383 134.8400n 0.001466
+ 134.8500n 0.001532 134.8600n 0.001579 134.8700n 0.001606 134.8800n 0.001612 134.8900n 0.001596 134.9000n 0.001559 134.9100n 0.001502 134.9200n 0.001425 134.9300n 0.001332 134.9400n 0.001222 134.9500n 0.001100 134.9600n 0.000968 134.9700n 0.000829 134.9800n 0.000685 134.9900n 0.000541
+ 135.0000n 0.000398 135.0100n 0.000261 135.0200n 0.000131 135.0300n 0.000012 135.0400n -0.000094 135.0500n -0.000186 135.0600n -0.000261 135.0700n -0.000319 135.0800n -0.000359 135.0900n -0.000381 135.1000n -0.000385 135.1100n -0.000373 135.1200n -0.000345 135.1300n -0.000303 135.1400n -0.000249
+ 135.1500n -0.000186 135.1600n -0.000117 135.1700n -0.000043 135.1800n 0.000032 135.1900n 0.000104 135.2000n 0.000172 135.2100n 0.000231 135.2200n 0.000281 135.2300n 0.000317 135.2400n 0.000339 135.2500n 0.000344 135.2600n 0.000331 135.2700n 0.000299 135.2800n 0.000249 135.2900n 0.000180
+ 135.3000n 0.000094 135.3100n -0.000009 135.3200n -0.000127 135.3300n -0.000258 135.3400n -0.000399 135.3500n -0.000547 135.3600n -0.000699 135.3700n -0.000852 135.3800n -0.001001 135.3900n -0.001144 135.4000n -0.001277 135.4100n -0.001396 135.4200n -0.001498 135.4300n -0.001581 135.4400n -0.001640
+ 135.4500n -0.001675 135.4600n -0.001684 135.4700n -0.001664 135.4800n -0.001616 135.4900n -0.001538 135.5000n -0.001432 135.5100n -0.001299 135.5200n -0.001139 135.5300n -0.000956 135.5400n -0.000750 135.5500n -0.000527 135.5600n -0.000288 135.5700n -0.000037 135.5800n 0.000221 135.5900n 0.000484
+ 135.6000n 0.000745 135.6100n 0.001002 135.6200n 0.001251 135.6300n 0.001487 135.6400n 0.001706 135.6500n 0.001907 135.6600n 0.002085 135.6700n 0.002239 135.6800n 0.002366 135.6900n 0.002465 135.7000n 0.002535 135.7100n 0.002575 135.7200n 0.002587 135.7300n 0.002570 135.7400n 0.002526
+ 135.7500n 0.002457 135.7600n 0.002364 135.7700n 0.002251 135.7800n 0.002121 135.7900n 0.001976 135.8000n 0.001819 135.8100n 0.001655 135.8200n 0.001486 135.8300n 0.001316 135.8400n 0.001148 135.8500n 0.000986 135.8600n 0.000831 135.8700n 0.000686 135.8800n 0.000554 135.8900n 0.000435
+ 135.9000n 0.000332 135.9100n 0.000245 135.9200n 0.000174 135.9300n 0.000119 135.9400n 0.000079 135.9500n 0.000054 135.9600n 0.000042 135.9700n 0.000041 135.9800n 0.000050 135.9900n 0.000066 136.0000n 0.000087 136.0100n 0.000110 136.0200n 0.000134 136.0300n 0.000155 136.0400n 0.000171
+ 136.0500n 0.000181 136.0600n 0.000182 136.0700n 0.000172 136.0800n 0.000152 136.0900n 0.000118 136.1000n 0.000072 136.1100n 0.000012 136.1200n -0.000060 136.1300n -0.000144 136.1400n -0.000240 136.1500n -0.000345 136.1600n -0.000459 136.1700n -0.000578 136.1800n -0.000701 136.1900n -0.000825
+ 136.2000n -0.000948 136.2100n -0.001068 136.2200n -0.001181 136.2300n -0.001285 136.2400n -0.001377 136.2500n -0.001456 136.2600n -0.001520 136.2700n -0.001567 136.2800n -0.001596 136.2900n -0.001605 136.3000n -0.001594 136.3100n -0.001564 136.3200n -0.001514 136.3300n -0.001445 136.3400n -0.001358
+ 136.3500n -0.001255 136.3600n -0.001137 136.3700n -0.001007 136.3800n -0.000868 136.3900n -0.000721 136.4000n -0.000569 136.4100n -0.000415 136.4200n -0.000263 136.4300n -0.000114 136.4400n 0.000028 136.4500n 0.000161 136.4600n 0.000283 136.4700n 0.000391 136.4800n 0.000484 136.4900n 0.000560
+ 136.5000n 0.000619 136.5100n 0.000660 136.5200n 0.000682 136.5300n 0.000686 136.5400n 0.000672 136.5500n 0.000642 136.5600n 0.000597 136.5700n 0.000537 136.5800n 0.000467 136.5900n 0.000386 136.6000n 0.000298 136.6100n 0.000206 136.6200n 0.000112 136.6300n 0.000018 136.6400n -0.000073
+ 136.6500n -0.000159 136.6600n -0.000237 136.6700n -0.000305 136.6800n -0.000362 136.6900n -0.000406 136.7000n -0.000436 136.7100n -0.000451 136.7200n -0.000450 136.7300n -0.000434 136.7400n -0.000403 136.7500n -0.000357 136.7600n -0.000298 136.7700n -0.000226 136.7800n -0.000143 136.7900n -0.000051
+ 136.8000n 0.000047 136.8100n 0.000151 136.8200n 0.000257 136.8300n 0.000364 136.8400n 0.000469 136.8500n 0.000569 136.8600n 0.000664 136.8700n 0.000750 136.8800n 0.000826 136.8900n 0.000891 136.9000n 0.000942 136.9100n 0.000980 136.9200n 0.001004 136.9300n 0.001013 136.9400n 0.001007
+ 136.9500n 0.000986 136.9600n 0.000951 136.9700n 0.000904 136.9800n 0.000844 136.9900n 0.000774 137.0000n 0.000695 137.0100n 0.000608 137.0200n 0.000517 137.0300n 0.000421 137.0400n 0.000325 137.0500n 0.000229 137.0600n 0.000135 137.0700n 0.000045 137.0800n -0.000039 137.0900n -0.000116
+ 137.1000n -0.000184 137.1100n -0.000243 137.1200n -0.000292 137.1300n -0.000330 137.1400n -0.000357 137.1500n -0.000373 137.1600n -0.000379 137.1700n -0.000374 137.1800n -0.000360 137.1900n -0.000339 137.2000n -0.000310 137.2100n -0.000276 137.2200n -0.000238 137.2300n -0.000198 137.2400n -0.000158
+ 137.2500n -0.000118 137.2600n -0.000082 137.2700n -0.000050 137.2800n -0.000025 137.2900n -0.000007 137.3000n 0.000002 137.3100n 0.000001 137.3200n -0.000012 137.3300n -0.000036 137.3400n -0.000072 137.3500n -0.000122 137.3600n -0.000184 137.3700n -0.000258 137.3800n -0.000345 137.3900n -0.000442
+ 137.4000n -0.000551 137.4100n -0.000669 137.4200n -0.000795 137.4300n -0.000928 137.4400n -0.001067 137.4500n -0.001209 137.4600n -0.001353 137.4700n -0.001498 137.4800n -0.001641 137.4900n -0.001781 137.5000n -0.001916 137.5100n -0.002045 137.5200n -0.002166 137.5300n -0.002277 137.5400n -0.002377
+ 137.5500n -0.002466 137.5600n -0.002541 137.5700n -0.002602 137.5800n -0.002648 137.5900n -0.002679 137.6000n -0.002694 137.6100n -0.002693 137.6200n -0.002675 137.6300n -0.002642 137.6400n -0.002594 137.6500n -0.002530 137.6600n -0.002451 137.6700n -0.002359 137.6800n -0.002254 137.6900n -0.002137
+ 137.7000n -0.002010 137.7100n -0.001874 137.7200n -0.001730 137.7300n -0.001579 137.7400n -0.001424 137.7500n -0.001265 137.7600n -0.001106 137.7700n -0.000947 137.7800n -0.000789 137.7900n -0.000636 137.8000n -0.000489 137.8100n -0.000349 137.8200n -0.000218 137.8300n -0.000098 137.8400n 0.000011
+ 137.8500n 0.000105 137.8600n 0.000185 137.8700n 0.000248 137.8800n 0.000295 137.8900n 0.000323 137.9000n 0.000334 137.9100n 0.000326 137.9200n 0.000299 137.9300n 0.000253 137.9400n 0.000189 137.9500n 0.000108 137.9600n 0.000009 137.9700n -0.000104 137.9800n -0.000232 137.9900n -0.000372
+ 138.0000n -0.000523 138.0100n -0.000682 138.0200n -0.000848 138.0300n -0.001017 138.0400n -0.001186 138.0500n -0.001355 138.0600n -0.001518 138.0700n -0.001675 138.0800n -0.001821 138.0900n -0.001955 138.1000n -0.002073 138.1100n -0.002173 138.1200n -0.002253 138.1300n -0.002312 138.1400n -0.002346
+ 138.1500n -0.002355 138.1600n -0.002338 138.1700n -0.002293 138.1800n -0.002222 138.1900n -0.002122 138.2000n -0.001996 138.2100n -0.001845 138.2200n -0.001668 138.2300n -0.001468 138.2400n -0.001248 138.2500n -0.001009 138.2600n -0.000754 138.2700n -0.000486 138.2800n -0.000209 138.2900n 0.000074
+ 138.3000n 0.000360 138.3100n 0.000645 138.3200n 0.000925 138.3300n 0.001197 138.3400n 0.001457 138.3500n 0.001702 138.3600n 0.001929 138.3700n 0.002134 138.3800n 0.002316 138.3900n 0.002472 138.4000n 0.002601 138.4100n 0.002700 138.4200n 0.002770 138.4300n 0.002808 138.4400n 0.002816
+ 138.4500n 0.002794 138.4600n 0.002742 138.4700n 0.002661 138.4800n 0.002554 138.4900n 0.002422 138.5000n 0.002268 138.5100n 0.002093 138.5200n 0.001901 138.5300n 0.001695 138.5400n 0.001478 138.5500n 0.001252 138.5600n 0.001021 138.5700n 0.000789 138.5800n 0.000557 138.5900n 0.000329
+ 138.6000n 0.000108 138.6100n -0.000104 138.6200n -0.000304 138.6300n -0.000492 138.6400n -0.000665 138.6500n -0.000821 138.6600n -0.000961 138.6700n -0.001083 138.6800n -0.001187 138.6900n -0.001272 138.7000n -0.001340 138.7100n -0.001391 138.7200n -0.001424 138.7300n -0.001443 138.7400n -0.001447
+ 138.7500n -0.001437 138.7600n -0.001416 138.7700n -0.001385 138.7800n -0.001344 138.7900n -0.001296 138.8000n -0.001242 138.8100n -0.001183 138.8200n -0.001121 138.8300n -0.001057 138.8400n -0.000991 138.8500n -0.000925 138.8600n -0.000859 138.8700n -0.000794 138.8800n -0.000731 138.8900n -0.000669
+ 138.9000n -0.000609 138.9100n -0.000551 138.9200n -0.000496 138.9300n -0.000442 138.9400n -0.000390 138.9500n -0.000340 138.9600n -0.000292 138.9700n -0.000245 138.9800n -0.000199 138.9900n -0.000155 139.0000n -0.000112 139.0100n -0.000070 139.0200n -0.000031 139.0300n 0.000007 139.0400n 0.000043
+ 139.0500n 0.000076 139.0600n 0.000105 139.0700n 0.000132 139.0800n 0.000153 139.0900n 0.000170 139.1000n 0.000182 139.1100n 0.000187 139.1200n 0.000186 139.1300n 0.000178 139.1400n 0.000162 139.1500n 0.000139 139.1600n 0.000108 139.1700n 0.000069 139.1800n 0.000022 139.1900n -0.000031
+ 139.2000n -0.000092 139.2100n -0.000158 139.2200n -0.000230 139.2300n -0.000305 139.2400n -0.000384 139.2500n -0.000465 139.2600n -0.000546 139.2700n -0.000626 139.2800n -0.000703 139.2900n -0.000777 139.3000n -0.000845 139.3100n -0.000906 139.3200n -0.000960 139.3300n -0.001004 139.3400n -0.001038
+ 139.3500n -0.001062 139.3600n -0.001074 139.3700n -0.001074 139.3800n -0.001062 139.3900n -0.001039 139.4000n -0.001005 139.4100n -0.000960 139.4200n -0.000906 139.4300n -0.000843 139.4400n -0.000774 139.4500n -0.000699 139.4600n -0.000621 139.4700n -0.000541 139.4800n -0.000460 139.4900n -0.000382
+ 139.5000n -0.000308 139.5100n -0.000239 139.5200n -0.000177 139.5300n -0.000123 139.5400n -0.000080 139.5500n -0.000048 139.5600n -0.000027 139.5700n -0.000018 139.5800n -0.000022 139.5900n -0.000037 139.6000n -0.000063 139.6100n -0.000100 139.6200n -0.000147 139.6300n -0.000200 139.6400n -0.000260
+ 139.6500n -0.000323 139.6600n -0.000388 139.6700n -0.000452 139.6800n -0.000513 139.6900n -0.000568 139.7000n -0.000614 139.7100n -0.000650 139.7200n -0.000673 139.7300n -0.000682 139.7400n -0.000673 139.7500n -0.000646 139.7600n -0.000600 139.7700n -0.000534 139.7800n -0.000448 139.7900n -0.000342
+ 139.8000n -0.000216 139.8100n -0.000073 139.8200n 0.000088 139.8300n 0.000264 139.8400n 0.000452 139.8500n 0.000650 139.8600n 0.000856 139.8700n 0.001064 139.8800n 0.001274 139.8900n 0.001480 139.9000n 0.001679 139.9100n 0.001867 139.9200n 0.002042 139.9300n 0.002200 139.9400n 0.002338
+ 139.9500n 0.002454 139.9600n 0.002544 139.9700n 0.002607 139.9800n 0.002642 139.9900n 0.002648 140.0000n 0.002624 140.0100n 0.002571 140.0200n 0.002489 140.0300n 0.002381 140.0400n 0.002246 140.0500n 0.002089 140.0600n 0.001911 140.0700n 0.001717 140.0800n 0.001508 140.0900n 0.001290
+ 140.1000n 0.001067 140.1100n 0.000842 140.1200n 0.000619 140.1300n 0.000403 140.1400n 0.000198 140.1500n 0.000008 140.1600n -0.000164 140.1700n -0.000315 140.1800n -0.000442 140.1900n -0.000543 140.2000n -0.000615 140.2100n -0.000658 140.2200n -0.000671 140.2300n -0.000654 140.2400n -0.000606
+ 140.2500n -0.000530 140.2600n -0.000427 140.2700n -0.000298 140.2800n -0.000146 140.2900n 0.000025 140.3000n 0.000214 140.3100n 0.000415 140.3200n 0.000627 140.3300n 0.000844 140.3400n 0.001064 140.3500n 0.001282 140.3600n 0.001495 140.3700n 0.001699 140.3800n 0.001892 140.3900n 0.002069
+ 140.4000n 0.002230 140.4100n 0.002371 140.4200n 0.002491 140.4300n 0.002588 140.4400n 0.002663 140.4500n 0.002714 140.4600n 0.002741 140.4700n 0.002746 140.4800n 0.002730 140.4900n 0.002692 140.5000n 0.002637 140.5100n 0.002564 140.5200n 0.002477 140.5300n 0.002377 140.5400n 0.002268
+ 140.5500n 0.002151 140.5600n 0.002029 140.5700n 0.001905 140.5800n 0.001780 140.5900n 0.001657 140.6000n 0.001537 140.6100n 0.001423 140.6200n 0.001314 140.6300n 0.001213 140.6400n 0.001120 140.6500n 0.001035 140.6600n 0.000959 140.6700n 0.000890 140.6800n 0.000830 140.6900n 0.000776
+ 140.7000n 0.000728 140.7100n 0.000685 140.7200n 0.000646 140.7300n 0.000610 140.7400n 0.000575 140.7500n 0.000540 140.7600n 0.000504 140.7700n 0.000466 140.7800n 0.000426 140.7900n 0.000382 140.8000n 0.000334 140.8100n 0.000282 140.8200n 0.000226 140.8300n 0.000166 140.8400n 0.000104
+ 140.8500n 0.000039 140.8600n -0.000027 140.8700n -0.000094 140.8800n -0.000159 140.8900n -0.000222 140.9000n -0.000281 140.9100n -0.000334 140.9200n -0.000380 140.9300n -0.000418 140.9400n -0.000446 140.9500n -0.000464 140.9600n -0.000470 140.9700n -0.000463 140.9800n -0.000444 140.9900n -0.000413
+ 141.0000n -0.000369 141.0100n -0.000314 141.0200n -0.000248 141.0300n -0.000173 141.0400n -0.000089 141.0500n -0.000000 141.0600n 0.000093 141.0700n 0.000187 141.0800n 0.000281 141.0900n 0.000371 141.1000n 0.000456 141.1100n 0.000532 141.1200n 0.000597 141.1300n 0.000649 141.1400n 0.000686
+ 141.1500n 0.000706 141.1600n 0.000707 141.1700n 0.000689 141.1800n 0.000650 141.1900n 0.000590 141.2000n 0.000510 141.2100n 0.000410 141.2200n 0.000290 141.2300n 0.000154 141.2400n 0.000001 141.2500n -0.000165 141.2600n -0.000341 141.2700n -0.000526 141.2800n -0.000715 141.2900n -0.000905
+ 141.3000n -0.001094 141.3100n -0.001276 141.3200n -0.001450 141.3300n -0.001612 141.3400n -0.001759 141.3500n -0.001887 141.3600n -0.001994 141.3700n -0.002079 141.3800n -0.002139 141.3900n -0.002173 141.4000n -0.002180 141.4100n -0.002160 141.4200n -0.002113 141.4300n -0.002041 141.4400n -0.001943
+ 141.4500n -0.001823 141.4600n -0.001682 141.4700n -0.001523 141.4800n -0.001348 141.4900n -0.001162 141.5000n -0.000967 141.5100n -0.000767 141.5200n -0.000566 141.5300n -0.000367 141.5400n -0.000174 141.5500n 0.000009 141.5600n 0.000180 141.5700n 0.000335 141.5800n 0.000471 141.5900n 0.000588
+ 141.6000n 0.000682 141.6100n 0.000753 141.6200n 0.000800 141.6300n 0.000822 141.6400n 0.000819 141.6500n 0.000793 141.6600n 0.000745 141.6700n 0.000675 141.6800n 0.000586 141.6900n 0.000480 141.7000n 0.000360 141.7100n 0.000228 141.7200n 0.000087 141.7300n -0.000059 141.7400n -0.000209
+ 141.7500n -0.000359 141.7600n -0.000506 141.7700n -0.000647 141.7800n -0.000781 141.7900n -0.000906 141.8000n -0.001018 141.8100n -0.001118 141.8200n -0.001204 141.8300n -0.001275 141.8400n -0.001331 141.8500n -0.001372 141.8600n -0.001399 141.8700n -0.001412 141.8800n -0.001412 141.8900n -0.001400
+ 141.9000n -0.001379 141.9100n -0.001349 141.9200n -0.001313 141.9300n -0.001271 141.9400n -0.001227 141.9500n -0.001181 141.9600n -0.001135 141.9700n -0.001091 141.9800n -0.001049 141.9900n -0.001012 142.0000n -0.000978 142.0100n -0.000950 142.0200n -0.000926 142.0300n -0.000907 142.0400n -0.000893
+ 142.0500n -0.000883 142.0600n -0.000875 142.0700n -0.000868 142.0800n -0.000862 142.0900n -0.000855 142.1000n -0.000846 142.1100n -0.000832 142.1200n -0.000812 142.1300n -0.000785 142.1400n -0.000750 142.1500n -0.000705 142.1600n -0.000650 142.1700n -0.000584 142.1800n -0.000507 142.1900n -0.000418
+ 142.2000n -0.000318 142.2100n -0.000208 142.2200n -0.000089 142.2300n 0.000038 142.2400n 0.000172 142.2500n 0.000310 142.2600n 0.000450 142.2700n 0.000591 142.2800n 0.000728 142.2900n 0.000861 142.3000n 0.000986 142.3100n 0.001100 142.3200n 0.001202 142.3300n 0.001289 142.3400n 0.001359
+ 142.3500n 0.001410 142.3600n 0.001441 142.3700n 0.001451 142.3800n 0.001438 142.3900n 0.001404 142.4000n 0.001347 142.4100n 0.001269 142.4200n 0.001171 142.4300n 0.001054 142.4400n 0.000920 142.4500n 0.000772 142.4600n 0.000612 142.4700n 0.000443 142.4800n 0.000268 142.4900n 0.000090
+ 142.5000n -0.000086 142.5100n -0.000259 142.5200n -0.000424 142.5300n -0.000578 142.5400n -0.000719 142.5500n -0.000843 142.5600n -0.000949 142.5700n -0.001034 142.5800n -0.001097 142.5900n -0.001137 142.6000n -0.001153 142.6100n -0.001145 142.6200n -0.001113 142.6300n -0.001058 142.6400n -0.000982
+ 142.6500n -0.000886 142.6600n -0.000772 142.6700n -0.000644 142.6800n -0.000503 142.6900n -0.000352 142.7000n -0.000196 142.7100n -0.000036 142.7200n 0.000122 142.7300n 0.000278 142.7400n 0.000426 142.7500n 0.000565 142.7600n 0.000691 142.7700n 0.000803 142.7800n 0.000898 142.7900n 0.000975
+ 142.8000n 0.001032 142.8100n 0.001069 142.8200n 0.001086 142.8300n 0.001082 142.8400n 0.001058 142.8500n 0.001016 142.8600n 0.000956 142.8700n 0.000881 142.8800n 0.000792 142.8900n 0.000691 142.9000n 0.000582 142.9100n 0.000466 142.9200n 0.000346 142.9300n 0.000225 142.9400n 0.000105
+ 142.9500n -0.000012 142.9600n -0.000123 142.9700n -0.000226 142.9800n -0.000320 142.9900n -0.000403 143.0000n -0.000475 143.0100n -0.000535 143.0200n -0.000582 143.0300n -0.000618 143.0400n -0.000641 143.0500n -0.000653 143.0600n -0.000655 143.0700n -0.000649 143.0800n -0.000636 143.0900n -0.000617
+ 143.1000n -0.000595 143.1100n -0.000571 143.1200n -0.000547 143.1300n -0.000525 143.1400n -0.000507 143.1500n -0.000494 143.1600n -0.000488 143.1700n -0.000490 143.1800n -0.000500 143.1900n -0.000519 143.2000n -0.000548 143.2100n -0.000586 143.2200n -0.000633 143.2300n -0.000689 143.2400n -0.000751
+ 143.2500n -0.000820 143.2600n -0.000893 143.2700n -0.000969 143.2800n -0.001046 143.2900n -0.001123 143.3000n -0.001198 143.3100n -0.001268 143.3200n -0.001333 143.3300n -0.001390 143.3400n -0.001438 143.3500n -0.001476 143.3600n -0.001502 143.3700n -0.001517 143.3800n -0.001520 143.3900n -0.001510
+ 143.4000n -0.001489 143.4100n -0.001456 143.4200n -0.001412 143.4300n -0.001358 143.4400n -0.001296 143.4500n -0.001227 143.4600n -0.001153 143.4700n -0.001076 143.4800n -0.000996 143.4900n -0.000916 143.5000n -0.000838 143.5100n -0.000763 143.5200n -0.000692 143.5300n -0.000627 143.5400n -0.000568
+ 143.5500n -0.000516 143.5600n -0.000471 143.5700n -0.000432 143.5800n -0.000400 143.5900n -0.000373 143.6000n -0.000350 143.6100n -0.000330 143.6200n -0.000311 143.6300n -0.000291 143.6400n -0.000268 143.6500n -0.000239 143.6600n -0.000202 143.6700n -0.000155 143.6800n -0.000095 143.6900n -0.000022
+ 143.7000n 0.000069 143.7100n 0.000176 143.7200n 0.000303 143.7300n 0.000449 143.7400n 0.000615 143.7500n 0.000800 143.7600n 0.001003 143.7700n 0.001223 143.7800n 0.001459 143.7900n 0.001707 143.8000n 0.001964 143.8100n 0.002228 143.8200n 0.002493 143.8300n 0.002757 143.8400n 0.003014
+ 143.8500n 0.003260 143.8600n 0.003490 143.8700n 0.003700 143.8800n 0.003884 143.8900n 0.004039 143.9000n 0.004161 143.9100n 0.004245 143.9200n 0.004290 143.9300n 0.004293 143.9400n 0.004251 143.9500n 0.004165 143.9600n 0.004033 143.9700n 0.003857 143.9800n 0.003638 143.9900n 0.003379
+ 144.0000n 0.003082 144.0100n 0.002751 144.0200n 0.002391 144.0300n 0.002008 144.0400n 0.001607 144.0500n 0.001194 144.0600n 0.000775 144.0700n 0.000358 144.0800n -0.000051 144.0900n -0.000445 144.1000n -0.000818 144.1100n -0.001163 144.1200n -0.001476 144.1300n -0.001750 144.1400n -0.001982
+ 144.1500n -0.002167 144.1600n -0.002304 144.1700n -0.002390 144.1800n -0.002425 144.1900n -0.002409 144.2000n -0.002343 144.2100n -0.002229 144.2200n -0.002070 144.2300n -0.001870 144.2400n -0.001635 144.2500n -0.001369 144.2600n -0.001079 144.2700n -0.000772 144.2800n -0.000454 144.2900n -0.000132
+ 144.3000n 0.000186 144.3100n 0.000493 144.3200n 0.000783 144.3300n 0.001048 144.3400n 0.001284 144.3500n 0.001485 144.3600n 0.001647 144.3700n 0.001765 144.3800n 0.001838 144.3900n 0.001864 144.4000n 0.001841 144.4100n 0.001771 144.4200n 0.001655 144.4300n 0.001495 144.4400n 0.001295
+ 144.4500n 0.001059 144.4600n 0.000792 144.4700n 0.000499 144.4800n 0.000188 144.4900n -0.000136 144.5000n -0.000466 144.5100n -0.000795 144.5200n -0.001115 144.5300n -0.001420 144.5400n -0.001704 144.5500n -0.001961 144.5600n -0.002185 144.5700n -0.002373 144.5800n -0.002519 144.5900n -0.002622
+ 144.6000n -0.002679 144.6100n -0.002691 144.6200n -0.002656 144.6300n -0.002576 144.6400n -0.002453 144.6500n -0.002291 144.6600n -0.002093 144.6700n -0.001865 144.6800n -0.001611 144.6900n -0.001337 144.7000n -0.001050 144.7100n -0.000756 144.7200n -0.000463 144.7300n -0.000176 144.7400n 0.000097
+ 144.7500n 0.000351 144.7600n 0.000579 144.7700n 0.000777 144.7800n 0.000940 144.7900n 0.001064 144.8000n 0.001146 144.8100n 0.001186 144.8200n 0.001180 144.8300n 0.001131 144.8400n 0.001038 144.8500n 0.000903 144.8600n 0.000731 144.8700n 0.000523 144.8800n 0.000285 144.8900n 0.000021
+ 144.9000n -0.000262 144.9100n -0.000559 144.9200n -0.000864 144.9300n -0.001170 144.9400n -0.001471 144.9500n -0.001761 144.9600n -0.002034 144.9700n -0.002284 144.9800n -0.002507 144.9900n -0.002697 145.0000n -0.002852 145.0100n -0.002969 145.0200n -0.003047 145.0300n -0.003082 145.0400n -0.003077
+ 145.0500n -0.003031 145.0600n -0.002947 145.0700n -0.002826 145.0800n -0.002672 145.0900n -0.002488 145.1000n -0.002280 145.1100n -0.002051 145.1200n -0.001809 145.1300n -0.001557 145.1400n -0.001301 145.1500n -0.001047 145.1600n -0.000801 145.1700n -0.000568 145.1800n -0.000352 145.1900n -0.000158
+ 145.2000n 0.000011 145.2100n 0.000152 145.2200n 0.000261 145.2300n 0.000338 145.2400n 0.000382 145.2500n 0.000392 145.2600n 0.000370 145.2700n 0.000317 145.2800n 0.000234 145.2900n 0.000126 145.3000n -0.000006 145.3100n -0.000157 145.3200n -0.000322 145.3300n -0.000499 145.3400n -0.000681
+ 145.3500n -0.000865 145.3600n -0.001045 145.3700n -0.001219 145.3800n -0.001381 145.3900n -0.001528 145.4000n -0.001657 145.4100n -0.001766 145.4200n -0.001851 145.4300n -0.001912 145.4400n -0.001949 145.4500n -0.001960 145.4600n -0.001948 145.4700n -0.001912 145.4800n -0.001854 145.4900n -0.001778
+ 145.5000n -0.001686 145.5100n -0.001581 145.5200n -0.001467 145.5300n -0.001347 145.5400n -0.001226 145.5500n -0.001106 145.5600n -0.000993 145.5700n -0.000889 145.5800n -0.000799 145.5900n -0.000723 145.6000n -0.000666 145.6100n -0.000630 145.6200n -0.000614 145.6300n -0.000621 145.6400n -0.000651
+ 145.6500n -0.000702 145.6600n -0.000774 145.6700n -0.000865 145.6800n -0.000973 145.6900n -0.001094 145.7000n -0.001226 145.7100n -0.001366 145.7200n -0.001508 145.7300n -0.001650 145.7400n -0.001787 145.7500n -0.001914 145.7600n -0.002029 145.7700n -0.002126 145.7800n -0.002203 145.7900n -0.002256
+ 145.8000n -0.002284 145.8100n -0.002283 145.8200n -0.002253 145.8300n -0.002193 145.8400n -0.002102 145.8500n -0.001981 145.8600n -0.001832 145.8700n -0.001656 145.8800n -0.001456 145.8900n -0.001235 145.9000n -0.000997 145.9100n -0.000746 145.9200n -0.000486 145.9300n -0.000221 145.9400n 0.000042
+ 145.9500n 0.000300 145.9600n 0.000548 145.9700n 0.000781 145.9800n 0.000994 145.9900n 0.001183 146.0000n 0.001345 146.0100n 0.001477 146.0200n 0.001576 146.0300n 0.001640 146.0400n 0.001668 146.0500n 0.001659 146.0600n 0.001614 146.0700n 0.001533 146.0800n 0.001419 146.0900n 0.001273
+ 146.1000n 0.001098 146.1100n 0.000898 146.1200n 0.000676 146.1300n 0.000437 146.1400n 0.000186 146.1500n -0.000073 146.1600n -0.000335 146.1700n -0.000595 146.1800n -0.000848 146.1900n -0.001089 146.2000n -0.001314 146.2100n -0.001519 146.2200n -0.001700 146.2300n -0.001854 146.2400n -0.001978
+ 146.2500n -0.002071 146.2600n -0.002131 146.2700n -0.002158 146.2800n -0.002151 146.2900n -0.002111 146.3000n -0.002039 146.3100n -0.001937 146.3200n -0.001807 146.3300n -0.001652 146.3400n -0.001475 146.3500n -0.001280 146.3600n -0.001070 146.3700n -0.000849 146.3800n -0.000621 146.3900n -0.000390
+ 146.4000n -0.000160 146.4100n 0.000065 146.4200n 0.000282 146.4300n 0.000488 146.4400n 0.000679 146.4500n 0.000854 146.4600n 0.001010 146.4700n 0.001146 146.4800n 0.001260 146.4900n 0.001353 146.5000n 0.001424 146.5100n 0.001473 146.5200n 0.001502 146.5300n 0.001511 146.5400n 0.001503
+ 146.5500n 0.001478 146.5600n 0.001440 146.5700n 0.001391 146.5800n 0.001333 146.5900n 0.001270 146.6000n 0.001203 146.6100n 0.001135 146.6200n 0.001069 146.6300n 0.001007 146.6400n 0.000952 146.6500n 0.000905 146.6600n 0.000869 146.6700n 0.000843 146.6800n 0.000831 146.6900n 0.000831
+ 146.7000n 0.000845 146.7100n 0.000872 146.7200n 0.000913 146.7300n 0.000966 146.7400n 0.001031 146.7500n 0.001107 146.7600n 0.001192 146.7700n 0.001284 146.7800n 0.001382 146.7900n 0.001485 146.8000n 0.001589 146.8100n 0.001694 146.8200n 0.001796 146.8300n 0.001896 146.8400n 0.001989
+ 146.8500n 0.002076 146.8600n 0.002155 146.8700n 0.002223 146.8800n 0.002280 146.8900n 0.002326 146.9000n 0.002358 146.9100n 0.002377 146.9200n 0.002383 146.9300n 0.002375 146.9400n 0.002353 146.9500n 0.002318 146.9600n 0.002269 146.9700n 0.002209 146.9800n 0.002136 146.9900n 0.002053
+ 147.0000n 0.001959 147.0100n 0.001856 147.0200n 0.001745 147.0300n 0.001628 147.0400n 0.001504 147.0500n 0.001376 147.0600n 0.001244 147.0700n 0.001109 147.0800n 0.000973 147.0900n 0.000837 147.1000n 0.000701 147.1100n 0.000567 147.1200n 0.000436 147.1300n 0.000308 147.1400n 0.000185
+ 147.1500n 0.000068 147.1600n -0.000043 147.1700n -0.000147 147.1800n -0.000243 147.1900n -0.000329 147.2000n -0.000406 147.2100n -0.000471 147.2200n -0.000526 147.2300n -0.000567 147.2400n -0.000596 147.2500n -0.000612 147.2600n -0.000613 147.2700n -0.000599 147.2800n -0.000571 147.2900n -0.000527
+ 147.3000n -0.000468 147.3100n -0.000393 147.3200n -0.000303 147.3300n -0.000199 147.3400n -0.000080 147.3500n 0.000052 147.3600n 0.000197 147.3700n 0.000352 147.3800n 0.000518 147.3900n 0.000692 147.4000n 0.000873 147.4100n 0.001059 147.4200n 0.001247 147.4300n 0.001435 147.4400n 0.001622
+ 147.4500n 0.001805 147.4600n 0.001982 147.4700n 0.002150 147.4800n 0.002307 147.4900n 0.002450 147.5000n 0.002579 147.5100n 0.002691 147.5200n 0.002784 147.5300n 0.002858 147.5400n 0.002910 147.5500n 0.002940 147.5600n 0.002948 147.5700n 0.002933 147.5800n 0.002896 147.5900n 0.002838
+ 147.6000n 0.002758 147.6100n 0.002658 147.6200n 0.002540 147.6300n 0.002406 147.6400n 0.002258 147.6500n 0.002098 147.6600n 0.001929 147.6700n 0.001754 147.6800n 0.001574 147.6900n 0.001394 147.7000n 0.001216 147.7100n 0.001043 147.7200n 0.000877 147.7300n 0.000721 147.7400n 0.000578
+ 147.7500n 0.000449 147.7600n 0.000336 147.7700n 0.000240 147.7800n 0.000163 147.7900n 0.000106 147.8000n 0.000068 147.8100n 0.000050 147.8200n 0.000051 147.8300n 0.000069 147.8400n 0.000105 147.8500n 0.000155 147.8600n 0.000219 147.8700n 0.000294 147.8800n 0.000378 147.8900n 0.000467
+ 147.9000n 0.000560 147.9100n 0.000653 147.9200n 0.000744 147.9300n 0.000830 147.9400n 0.000908 147.9500n 0.000976 147.9600n 0.001032 147.9700n 0.001073 147.9800n 0.001097 147.9900n 0.001104 148.0000n 0.001093 148.0100n 0.001062 148.0200n 0.001013 148.0300n 0.000944 148.0400n 0.000856
+ 148.0500n 0.000751 148.0600n 0.000630 148.0700n 0.000494 148.0800n 0.000347 148.0900n 0.000189 148.1000n 0.000025 148.1100n -0.000144 148.1200n -0.000315 148.1300n -0.000484 148.1400n -0.000648 148.1500n -0.000805 148.1600n -0.000952 148.1700n -0.001085 148.1800n -0.001203 148.1900n -0.001303
+ 148.2000n -0.001382 148.2100n -0.001440 148.2200n -0.001474 148.2300n -0.001485 148.2400n -0.001471 148.2500n -0.001432 148.2600n -0.001368 148.2700n -0.001280 148.2800n -0.001170 148.2900n -0.001038 148.3000n -0.000886 148.3100n -0.000716 148.3200n -0.000531 148.3300n -0.000333 148.3400n -0.000124
+ 148.3500n 0.000092 148.3600n 0.000313 148.3700n 0.000535 148.3800n 0.000756 148.3900n 0.000973 148.4000n 0.001183 148.4100n 0.001384 148.4200n 0.001572 148.4300n 0.001747 148.4400n 0.001906 148.4500n 0.002047 148.4600n 0.002169 148.4700n 0.002272 148.4800n 0.002354 148.4900n 0.002415
+ 148.5000n 0.002455 148.5100n 0.002474 148.5200n 0.002474 148.5300n 0.002455 148.5400n 0.002417 148.5500n 0.002364 148.5600n 0.002295 148.5700n 0.002213 148.5800n 0.002120 148.5900n 0.002017 148.6000n 0.001907 148.6100n 0.001792 148.6200n 0.001674 148.6300n 0.001555 148.6400n 0.001436
+ 148.6500n 0.001320 148.6600n 0.001209 148.6700n 0.001103 148.6800n 0.001004 148.6900n 0.000914 148.7000n 0.000833 148.7100n 0.000761 148.7200n 0.000700 148.7300n 0.000649 148.7400n 0.000609 148.7500n 0.000579 148.7600n 0.000558 148.7700n 0.000546 148.7800n 0.000542 148.7900n 0.000545
+ 148.8000n 0.000554 148.8100n 0.000567 148.8200n 0.000583 148.8300n 0.000600 148.8400n 0.000616 148.8500n 0.000630 148.8600n 0.000641 148.8700n 0.000646 148.8800n 0.000644 148.8900n 0.000634 148.9000n 0.000614 148.9100n 0.000583 148.9200n 0.000540 148.9300n 0.000485 148.9400n 0.000415
+ 148.9500n 0.000332 148.9600n 0.000235 148.9700n 0.000124 148.9800n -0.000001 148.9900n -0.000139 149.0000n -0.000289 149.0100n -0.000450 149.0200n -0.000621 149.0300n -0.000800 149.0400n -0.000985 149.0500n -0.001175 149.0600n -0.001367 149.0700n -0.001559 149.0800n -0.001748 149.0900n -0.001933
+ 149.1000n -0.002109 149.1100n -0.002276 149.1200n -0.002430 149.1300n -0.002570 149.1400n -0.002692 149.1500n -0.002795 149.1600n -0.002877 149.1700n -0.002935 149.1800n -0.002970 149.1900n -0.002979 149.2000n -0.002963 149.2100n -0.002920 149.2200n -0.002851 149.2300n -0.002755 149.2400n -0.002635
+ 149.2500n -0.002491 149.2600n -0.002324 149.2700n -0.002137 149.2800n -0.001932 149.2900n -0.001712 149.3000n -0.001480 149.3100n -0.001238 149.3200n -0.000990 149.3300n -0.000741 149.3400n -0.000493 149.3500n -0.000250 149.3600n -0.000016 149.3700n 0.000205 149.3800n 0.000410 149.3900n 0.000595
+ 149.4000n 0.000757 149.4100n 0.000894 149.4200n 0.001003 149.4300n 0.001083 149.4400n 0.001131 149.4500n 0.001147 149.4600n 0.001129 149.4700n 0.001079 149.4800n 0.000996 149.4900n 0.000882 149.5000n 0.000739 149.5100n 0.000567 149.5200n 0.000371 149.5300n 0.000153 149.5400n -0.000084
+ 149.5500n -0.000336 149.5600n -0.000599 149.5700n -0.000868 149.5800n -0.001140 149.5900n -0.001409 149.6000n -0.001671 149.6100n -0.001923 149.6200n -0.002158 149.6300n -0.002375 149.6400n -0.002569 149.6500n -0.002736 149.6600n -0.002875 149.6700n -0.002981 149.6800n -0.003055 149.6900n -0.003093
+ 149.7000n -0.003096 149.7100n -0.003064 149.7200n -0.002995 149.7300n -0.002893 149.7400n -0.002758 149.7500n -0.002591 149.7600n -0.002397 149.7700n -0.002177 149.7800n -0.001934 149.7900n -0.001674 149.8000n -0.001398 149.8100n -0.001113 149.8200n -0.000820 149.8300n -0.000526 149.8400n -0.000233
+ 149.8500n 0.000054 149.8600n 0.000332 149.8700n 0.000596 149.8800n 0.000845 149.8900n 0.001075 149.9000n 0.001283 149.9100n 0.001469 149.9200n 0.001630 149.9300n 0.001765 149.9400n 0.001875 149.9500n 0.001958 149.9600n 0.002016 149.9700n 0.002050 149.9800n 0.002061 149.9900n 0.002050
+ 150.0000n 0.002021 150.0100n 0.001973 150.0200n 0.001912 150.0300n 0.001838 150.0400n 0.001755 150.0500n 0.001665 150.0600n 0.001571 150.0700n 0.001476 150.0800n 0.001380 150.0900n 0.001288 150.1000n 0.001200 150.1100n 0.001117 150.1200n 0.001042 150.1300n 0.000974 150.1400n 0.000915
+ 150.1500n 0.000864 150.1600n 0.000820 150.1700n 0.000784 150.1800n 0.000754 150.1900n 0.000729 150.2000n 0.000708 150.2100n 0.000689 150.2200n 0.000670 150.2300n 0.000649 150.2400n 0.000625 150.2500n 0.000596 150.2600n 0.000560 150.2700n 0.000516 150.2800n 0.000462 150.2900n 0.000397
+ 150.3000n 0.000321 150.3100n 0.000232 150.3200n 0.000131 150.3300n 0.000018 150.3400n -0.000106 150.3500n -0.000241 150.3600n -0.000386 150.3700n -0.000538 150.3800n -0.000696 150.3900n -0.000859 150.4000n -0.001023 150.4100n -0.001186 150.4200n -0.001346 150.4300n -0.001500 150.4400n -0.001645
+ 150.4500n -0.001780 150.4600n -0.001901 150.4700n -0.002007 150.4800n -0.002095 150.4900n -0.002165 150.5000n -0.002215 150.5100n -0.002244 150.5200n -0.002251 150.5300n -0.002237 150.5400n -0.002202 150.5500n -0.002147 150.5600n -0.002072 150.5700n -0.001980 150.5800n -0.001872 150.5900n -0.001750
+ 150.6000n -0.001617 150.6100n -0.001476 150.6200n -0.001329 150.6300n -0.001180 150.6400n -0.001030 150.6500n -0.000884 150.6600n -0.000743 150.6700n -0.000611 150.6800n -0.000490 150.6900n -0.000381 150.7000n -0.000287 150.7100n -0.000209 150.7200n -0.000148 150.7300n -0.000105 150.7400n -0.000079
+ 150.7500n -0.000070 150.7600n -0.000078 150.7700n -0.000101 150.7800n -0.000138 150.7900n -0.000187 150.8000n -0.000246 150.8100n -0.000312 150.8200n -0.000383 150.8300n -0.000455 150.8400n -0.000527 150.8500n -0.000595 150.8600n -0.000656 150.8700n -0.000708 150.8800n -0.000749 150.8900n -0.000776
+ 150.9000n -0.000788 150.9100n -0.000783 150.9200n -0.000760 150.9300n -0.000718 150.9400n -0.000658 150.9500n -0.000580 150.9600n -0.000484 150.9700n -0.000372 150.9800n -0.000245 150.9900n -0.000106 151.0000n 0.000042 151.0100n 0.000198 151.0200n 0.000358 151.0300n 0.000518 151.0400n 0.000676
+ 151.0500n 0.000828 151.0600n 0.000970 151.0700n 0.001099 151.0800n 0.001213 151.0900n 0.001307 151.1000n 0.001379 151.1100n 0.001428 151.1200n 0.001450 151.1300n 0.001446 151.1400n 0.001412 151.1500n 0.001350 151.1600n 0.001258 151.1700n 0.001138 151.1800n 0.000991 151.1900n 0.000817
+ 151.2000n 0.000619 151.2100n 0.000400 151.2200n 0.000162 151.2300n -0.000092 151.2400n -0.000358 151.2500n -0.000633 151.2600n -0.000913 151.2700n -0.001194 151.2800n -0.001473 151.2900n -0.001745 151.3000n -0.002007 151.3100n -0.002255 151.3200n -0.002487 151.3300n -0.002699 151.3400n -0.002888
+ 151.3500n -0.003054 151.3600n -0.003193 151.3700n -0.003304 151.3800n -0.003388 151.3900n -0.003443 151.4000n -0.003469 151.4100n -0.003466 151.4200n -0.003437 151.4300n -0.003381 151.4400n -0.003301 151.4500n -0.003199 151.4600n -0.003076 151.4700n -0.002935 151.4800n -0.002779 151.4900n -0.002611
+ 151.5000n -0.002432 151.5100n -0.002246 151.5200n -0.002056 151.5300n -0.001864 151.5400n -0.001672 151.5500n -0.001483 151.5600n -0.001300 151.5700n -0.001123 151.5800n -0.000955 151.5900n -0.000797 151.6000n -0.000651 151.6100n -0.000516 151.6200n -0.000395 151.6300n -0.000286 151.6400n -0.000191
+ 151.6500n -0.000110 151.6600n -0.000042 151.6700n 0.000013 151.6800n 0.000055 151.6900n 0.000086 151.7000n 0.000105 151.7100n 0.000113 151.7200n 0.000111 151.7300n 0.000100 151.7400n 0.000080 151.7500n 0.000052 151.7600n 0.000016 151.7700n -0.000026 151.7800n -0.000075 151.7900n -0.000130
+ 151.8000n -0.000191 151.8100n -0.000257 151.8200n -0.000328 151.8300n -0.000405 151.8400n -0.000486 151.8500n -0.000571 151.8600n -0.000661 151.8700n -0.000755 151.8800n -0.000852 151.8900n -0.000952 151.9000n -0.001055 151.9100n -0.001160 151.9200n -0.001267 151.9300n -0.001374 151.9400n -0.001481
+ 151.9500n -0.001586 151.9600n -0.001689 151.9700n -0.001788 151.9800n -0.001882 151.9900n -0.001970 152.0000n -0.002050 152.0100n -0.002120 152.0200n -0.002181 152.0300n -0.002229 152.0400n -0.002265 152.0500n -0.002286 152.0600n -0.002292 152.0700n -0.002282 152.0800n -0.002255 152.0900n -0.002212
+ 152.1000n -0.002151 152.1100n -0.002073 152.1200n -0.001978 152.1300n -0.001867 152.1400n -0.001740 152.1500n -0.001599 152.1600n -0.001444 152.1700n -0.001279 152.1800n -0.001103 152.1900n -0.000920 152.2000n -0.000731 152.2100n -0.000538 152.2200n -0.000344 152.2300n -0.000152 152.2400n 0.000037
+ 152.2500n 0.000220 152.2600n 0.000395 152.2700n 0.000560 152.2800n 0.000712 152.2900n 0.000851 152.3000n 0.000974 152.3100n 0.001080 152.3200n 0.001168 152.3300n 0.001237 152.3400n 0.001287 152.3500n 0.001318 152.3600n 0.001330 152.3700n 0.001322 152.3800n 0.001297 152.3900n 0.001254
+ 152.4000n 0.001196 152.4100n 0.001123 152.4200n 0.001037 152.4300n 0.000940 152.4400n 0.000834 152.4500n 0.000721 152.4600n 0.000603 152.4700n 0.000481 152.4800n 0.000359 152.4900n 0.000238 152.5000n 0.000119 152.5100n 0.000006 152.5200n -0.000102 152.5300n -0.000201 152.5400n -0.000292
+ 152.5500n -0.000373 152.5600n -0.000442 152.5700n -0.000501 152.5800n -0.000547 152.5900n -0.000580 152.6000n -0.000602 152.6100n -0.000612 152.6200n -0.000609 152.6300n -0.000596 152.6400n -0.000571 152.6500n -0.000537 152.6600n -0.000494 152.6700n -0.000442 152.6800n -0.000383 152.6900n -0.000318
+ 152.7000n -0.000247 152.7100n -0.000171 152.7200n -0.000092 152.7300n -0.000010 152.7400n 0.000074 152.7500n 0.000159 152.7600n 0.000245 152.7700n 0.000331 152.7800n 0.000417 152.7900n 0.000502 152.8000n 0.000586 152.8100n 0.000668 152.8200n 0.000748 152.8300n 0.000825 152.8400n 0.000901
+ 152.8500n 0.000974 152.8600n 0.001043 152.8700n 0.001110 152.8800n 0.001173 152.8900n 0.001233 152.9000n 0.001288 152.9100n 0.001339 152.9200n 0.001385 152.9300n 0.001426 152.9400n 0.001461 152.9500n 0.001490 152.9600n 0.001513 152.9700n 0.001528 152.9800n 0.001537 152.9900n 0.001537
+ 153.0000n 0.001530 153.0100n 0.001514 153.0200n 0.001490 153.0300n 0.001458 153.0400n 0.001418 153.0500n 0.001369 153.0600n 0.001313 153.0700n 0.001249 153.0800n 0.001179 153.0900n 0.001103 153.1000n 0.001022 153.1100n 0.000938 153.1200n 0.000850 153.1300n 0.000762 153.1400n 0.000673
+ 153.1500n 0.000586 153.1600n 0.000501 153.1700n 0.000421 153.1800n 0.000347 153.1900n 0.000280 153.2000n 0.000221 153.2100n 0.000172 153.2200n 0.000134 153.2300n 0.000107 153.2400n 0.000092 153.2500n 0.000089 153.2600n 0.000100 153.2700n 0.000123 153.2800n 0.000158 153.2900n 0.000206
+ 153.3000n 0.000264 153.3100n 0.000332 153.3200n 0.000408 153.3300n 0.000492 153.3400n 0.000580 153.3500n 0.000672 153.3600n 0.000765 153.3700n 0.000857 153.3800n 0.000945 153.3900n 0.001028 153.4000n 0.001104 153.4100n 0.001169 153.4200n 0.001223 153.4300n 0.001262 153.4400n 0.001287
+ 153.4500n 0.001294 153.4600n 0.001284 153.4700n 0.001255 153.4800n 0.001207 153.4900n 0.001139 153.5000n 0.001052 153.5100n 0.000946 153.5200n 0.000822 153.5300n 0.000682 153.5400n 0.000527 153.5500n 0.000359 153.5600n 0.000180 153.5700n -0.000008 153.5800n -0.000202 153.5900n -0.000398
+ 153.6000n -0.000596 153.6100n -0.000790 153.6200n -0.000979 153.6300n -0.001160 153.6400n -0.001330 153.6500n -0.001486 153.6600n -0.001625 153.6700n -0.001746 153.6800n -0.001847 153.6900n -0.001925 153.7000n -0.001980 153.7100n -0.002011 153.7200n -0.002017 153.7300n -0.001998 153.7400n -0.001954
+ 153.7500n -0.001885 153.7600n -0.001794 153.7700n -0.001680 153.7800n -0.001546 153.7900n -0.001394 153.8000n -0.001225 153.8100n -0.001042 153.8200n -0.000848 153.8300n -0.000646 153.8400n -0.000438 153.8500n -0.000227 153.8600n -0.000016 153.8700n 0.000192 153.8800n 0.000394 153.8900n 0.000587
+ 153.9000n 0.000770 153.9100n 0.000940 153.9200n 0.001095 153.9300n 0.001233 153.9400n 0.001352 153.9500n 0.001452 153.9600n 0.001531 153.9700n 0.001589 153.9800n 0.001626 153.9900n 0.001640 154.0000n 0.001634 154.0100n 0.001606 154.0200n 0.001559 154.0300n 0.001492 154.0400n 0.001407
+ 154.0500n 0.001306 154.0600n 0.001190 154.0700n 0.001061 154.0800n 0.000920 154.0900n 0.000769 154.1000n 0.000611 154.1100n 0.000446 154.1200n 0.000278 154.1300n 0.000107 154.1400n -0.000064 154.1500n -0.000233 154.1600n -0.000400 154.1700n -0.000562 154.1800n -0.000717 154.1900n -0.000865
+ 154.2000n -0.001005 154.2100n -0.001134 154.2200n -0.001253 154.2300n -0.001360 154.2400n -0.001455 154.2500n -0.001537 154.2600n -0.001605 154.2700n -0.001660 154.2800n -0.001701 154.2900n -0.001729 154.3000n -0.001742 154.3100n -0.001742 154.3200n -0.001728 154.3300n -0.001702 154.3400n -0.001663
+ 154.3500n -0.001612 154.3600n -0.001551 154.3700n -0.001479 154.3800n -0.001397 154.3900n -0.001307 154.4000n -0.001209 154.4100n -0.001105 154.4200n -0.000996 154.4300n -0.000882 154.4400n -0.000765 154.4500n -0.000647 154.4600n -0.000528 154.4700n -0.000410 154.4800n -0.000294 154.4900n -0.000181
+ 154.5000n -0.000072 154.5100n 0.000032 154.5200n 0.000129 154.5300n 0.000219 154.5400n 0.000301 154.5500n 0.000374 154.5600n 0.000438 154.5700n 0.000493 154.5800n 0.000537 154.5900n 0.000572 154.6000n 0.000596 154.6100n 0.000611 154.6200n 0.000616 154.6300n 0.000612 154.6400n 0.000600
+ 154.6500n 0.000579 154.6600n 0.000552 154.6700n 0.000519 154.6800n 0.000481 154.6900n 0.000439 154.7000n 0.000393 154.7100n 0.000346 154.7200n 0.000299 154.7300n 0.000251 154.7400n 0.000204 154.7500n 0.000160 154.7600n 0.000118 154.7700n 0.000079 154.7800n 0.000044 154.7900n 0.000013
+ 154.8000n -0.000013 154.8100n -0.000036 154.8200n -0.000054 154.8300n -0.000068 154.8400n -0.000079 154.8500n -0.000087 154.8600n -0.000093 154.8700n -0.000098 154.8800n -0.000102 154.8900n -0.000107 154.9000n -0.000114 154.9100n -0.000123 154.9200n -0.000135 154.9300n -0.000152 154.9400n -0.000174
+ 154.9500n -0.000202 154.9600n -0.000235 154.9700n -0.000275 154.9800n -0.000322 154.9900n -0.000376 155.0000n -0.000435 155.0100n -0.000501 155.0200n -0.000571 155.0300n -0.000646 155.0400n -0.000724 155.0500n -0.000804 155.0600n -0.000884 155.0700n -0.000963 155.0800n -0.001039 155.0900n -0.001111
+ 155.1000n -0.001177 155.1100n -0.001234 155.1200n -0.001282 155.1300n -0.001319 155.1400n -0.001344 155.1500n -0.001354 155.1600n -0.001350 155.1700n -0.001330 155.1800n -0.001295 155.1900n -0.001242 155.2000n -0.001174 155.2100n -0.001089 155.2200n -0.000989 155.2300n -0.000875 155.2400n -0.000748
+ 155.2500n -0.000610 155.2600n -0.000462 155.2700n -0.000306 155.2800n -0.000145 155.2900n 0.000019 155.3000n 0.000184 155.3100n 0.000347 155.3200n 0.000506 155.3300n 0.000658 155.3400n 0.000802 155.3500n 0.000935 155.3600n 0.001055 155.3700n 0.001160 155.3800n 0.001250 155.3900n 0.001323
+ 155.4000n 0.001379 155.4100n 0.001417 155.4200n 0.001437 155.4300n 0.001440 155.4400n 0.001427 155.4500n 0.001398 155.4600n 0.001355 155.4700n 0.001300 155.4800n 0.001235 155.4900n 0.001161 155.5000n 0.001081 155.5100n 0.000997 155.5200n 0.000911 155.5300n 0.000827 155.5400n 0.000745
+ 155.5500n 0.000669 155.5600n 0.000599 155.5700n 0.000538 155.5800n 0.000487 155.5900n 0.000447 155.6000n 0.000418 155.6100n 0.000400 155.6200n 0.000394 155.6300n 0.000400 155.6400n 0.000415 155.6500n 0.000438 155.6600n 0.000469 155.6700n 0.000506 155.6800n 0.000545 155.6900n 0.000585
+ 155.7000n 0.000624 155.7100n 0.000659 155.7200n 0.000687 155.7300n 0.000705 155.7400n 0.000713 155.7500n 0.000707 155.7600n 0.000685 155.7700n 0.000647 155.7800n 0.000591 155.7900n 0.000516 155.8000n 0.000423 155.8100n 0.000311 155.8200n 0.000181 155.8300n 0.000034 155.8400n -0.000128
+ 155.8500n -0.000302 155.8600n -0.000487 155.8700n -0.000678 155.8800n -0.000873 155.8900n -0.001069 155.9000n -0.001261 155.9100n -0.001446 155.9200n -0.001619 155.9300n -0.001777 155.9400n -0.001915 155.9500n -0.002032 155.9600n -0.002123 155.9700n -0.002185 155.9800n -0.002217 155.9900n -0.002217
+ 156.0000n -0.002182 156.0100n -0.002114 156.0200n -0.002011 156.0300n -0.001876 156.0400n -0.001708 156.0500n -0.001511 156.0600n -0.001286 156.0700n -0.001038 156.0800n -0.000770 156.0900n -0.000487 156.1000n -0.000192 156.1100n 0.000108 156.1200n 0.000409 156.1300n 0.000705 156.1400n 0.000991
+ 156.1500n 0.001262 156.1600n 0.001513 156.1700n 0.001740 156.1800n 0.001937 156.1900n 0.002101 156.2000n 0.002230 156.2100n 0.002320 156.2200n 0.002369 156.2300n 0.002378 156.2400n 0.002345 156.2500n 0.002271 156.2600n 0.002157 156.2700n 0.002005 156.2800n 0.001819 156.2900n 0.001600
+ 156.3000n 0.001355 156.3100n 0.001086 156.3200n 0.000799 156.3300n 0.000500 156.3400n 0.000193 156.3500n -0.000115 156.3600n -0.000419 156.3700n -0.000714 156.3800n -0.000993 156.3900n -0.001253 156.4000n -0.001488 156.4100n -0.001695 156.4200n -0.001870 156.4300n -0.002010 156.4400n -0.002113
+ 156.4500n -0.002178 156.4600n -0.002205 156.4700n -0.002193 156.4800n -0.002144 156.4900n -0.002059 156.5000n -0.001941 156.5100n -0.001793 156.5200n -0.001618 156.5300n -0.001421 156.5400n -0.001207 156.5500n -0.000979 156.5600n -0.000743 156.5700n -0.000504 156.5800n -0.000267 156.5900n -0.000037
+ 156.6000n 0.000181 156.6100n 0.000383 156.6200n 0.000566 156.6300n 0.000725 156.6400n 0.000859 156.6500n 0.000964 156.6600n 0.001038 156.6700n 0.001083 156.6800n 0.001095 156.6900n 0.001078 156.7000n 0.001031 156.7100n 0.000955 156.7200n 0.000855 156.7300n 0.000732 156.7400n 0.000589
+ 156.7500n 0.000430 156.7600n 0.000259 156.7700n 0.000080 156.7800n -0.000103 156.7900n -0.000285 156.8000n -0.000463 156.8100n -0.000634 156.8200n -0.000792 156.8300n -0.000936 156.8400n -0.001062 156.8500n -0.001169 156.8600n -0.001253 156.8700n -0.001315 156.8800n -0.001353 156.8900n -0.001367
+ 156.9000n -0.001358 156.9100n -0.001327 156.9200n -0.001274 156.9300n -0.001203 156.9400n -0.001115 156.9500n -0.001013 156.9600n -0.000900 156.9700n -0.000778 156.9800n -0.000652 156.9900n -0.000525 157.0000n -0.000399 157.0100n -0.000278 157.0200n -0.000165 157.0300n -0.000062 157.0400n 0.000029
+ 157.0500n 0.000105 157.0600n 0.000164 157.0700n 0.000207 157.0800n 0.000232 157.0900n 0.000239 157.1000n 0.000228 157.1100n 0.000200 157.1200n 0.000156 157.1300n 0.000097 157.1400n 0.000026 157.1500n -0.000056 157.1600n -0.000146 157.1700n -0.000241 157.1800n -0.000340 157.1900n -0.000440
+ 157.2000n -0.000538 157.2100n -0.000631 157.2200n -0.000718 157.2300n -0.000797 157.2400n -0.000866 157.2500n -0.000922 157.2600n -0.000966 157.2700n -0.000997 157.2800n -0.001013 157.2900n -0.001016 157.3000n -0.001005 157.3100n -0.000982 157.3200n -0.000946 157.3300n -0.000900 157.3400n -0.000846
+ 157.3500n -0.000784 157.3600n -0.000717 157.3700n -0.000646 157.3800n -0.000574 157.3900n -0.000503 157.4000n -0.000435 157.4100n -0.000370 157.4200n -0.000312 157.4300n -0.000260 157.4400n -0.000217 157.4500n -0.000182 157.4600n -0.000157 157.4700n -0.000141 157.4800n -0.000134 157.4900n -0.000135
+ 157.5000n -0.000145 157.5100n -0.000160 157.5200n -0.000181 157.5300n -0.000205 157.5400n -0.000231 157.5500n -0.000257 157.5600n -0.000280 157.5700n -0.000300 157.5800n -0.000314 157.5900n -0.000320 157.6000n -0.000316 157.6100n -0.000302 157.6200n -0.000277 157.6300n -0.000238 157.6400n -0.000187
+ 157.6500n -0.000122 157.6600n -0.000045 157.6700n 0.000045 157.6800n 0.000147 157.6900n 0.000259 157.7000n 0.000379 157.7100n 0.000506 157.7200n 0.000639 157.7300n 0.000773 157.7400n 0.000908 157.7500n 0.001040 157.7600n 0.001167 157.7700n 0.001286 157.7800n 0.001396 157.7900n 0.001494
+ 157.8000n 0.001578 157.8100n 0.001646 157.8200n 0.001697 157.8300n 0.001730 157.8400n 0.001745 157.8500n 0.001740 157.8600n 0.001716 157.8700n 0.001674 157.8800n 0.001615 157.8900n 0.001540 157.9000n 0.001451 157.9100n 0.001350 157.9200n 0.001239 157.9300n 0.001120 157.9400n 0.000998
+ 157.9500n 0.000873 157.9600n 0.000750 157.9700n 0.000631 157.9800n 0.000519 157.9900n 0.000417 158.0000n 0.000327 158.0100n 0.000250 158.0200n 0.000190 158.0300n 0.000147 158.0400n 0.000122 158.0500n 0.000117 158.0600n 0.000131 158.0700n 0.000164 158.0800n 0.000216 158.0900n 0.000285
+ 158.1000n 0.000371 158.1100n 0.000471 158.1200n 0.000583 158.1300n 0.000705 158.1400n 0.000835 158.1500n 0.000970 158.1600n 0.001107 158.1700n 0.001243 158.1800n 0.001376 158.1900n 0.001503 158.2000n 0.001622 158.2100n 0.001730 158.2200n 0.001826 158.2300n 0.001908 158.2400n 0.001974
+ 158.2500n 0.002024 158.2600n 0.002057 158.2700n 0.002073 158.2800n 0.002073 158.2900n 0.002056 158.3000n 0.002024 158.3100n 0.001979 158.3200n 0.001921 158.3300n 0.001852 158.3400n 0.001775 158.3500n 0.001691 158.3600n 0.001603 158.3700n 0.001513 158.3800n 0.001422 158.3900n 0.001333
+ 158.4000n 0.001248 158.4100n 0.001168 158.4200n 0.001094 158.4300n 0.001028 158.4400n 0.000971 158.4500n 0.000922 158.4600n 0.000883 158.4700n 0.000852 158.4800n 0.000830 158.4900n 0.000815 158.5000n 0.000807 158.5100n 0.000804 158.5200n 0.000804 158.5300n 0.000806 158.5400n 0.000808
+ 158.5500n 0.000808 158.5600n 0.000805 158.5700n 0.000796 158.5800n 0.000780 158.5900n 0.000755 158.6000n 0.000720 158.6100n 0.000674 158.6200n 0.000617 158.6300n 0.000548 158.6400n 0.000466 158.6500n 0.000373 158.6600n 0.000268 158.6700n 0.000153 158.6800n 0.000030 158.6900n -0.000102
+ 158.7000n -0.000239 158.7100n -0.000379 158.7200n -0.000521 158.7300n -0.000661 158.7400n -0.000798 158.7500n -0.000930 158.7600n -0.001053 158.7700n -0.001166 158.7800n -0.001267 158.7900n -0.001353 158.8000n -0.001424 158.8100n -0.001478 158.8200n -0.001515 158.8300n -0.001534 158.8400n -0.001535
+ 158.8500n -0.001518 158.8600n -0.001485 158.8700n -0.001437 158.8800n -0.001374 158.8900n -0.001300 158.9000n -0.001215 158.9100n -0.001124 158.9200n -0.001028 158.9300n -0.000930 158.9400n -0.000833 158.9500n -0.000740 158.9600n -0.000653 158.9700n -0.000575 158.9800n -0.000510 158.9900n -0.000457
+ 159.0000n -0.000421 159.0100n -0.000401 159.0200n -0.000400 159.0300n -0.000417 159.0400n -0.000453 159.0500n -0.000508 159.0600n -0.000580 159.0700n -0.000670 159.0800n -0.000774 159.0900n -0.000891 159.1000n -0.001019 159.1100n -0.001155 159.1200n -0.001296 159.1300n -0.001440 159.1400n -0.001582
+ 159.1500n -0.001720 159.1600n -0.001851 159.1700n -0.001972 159.1800n -0.002080 159.1900n -0.002172 159.2000n -0.002246 159.2100n -0.002300 159.2200n -0.002333 159.2300n -0.002344 159.2400n -0.002331 159.2500n -0.002296 159.2600n -0.002238 159.2700n -0.002157 159.2800n -0.002057 159.2900n -0.001937
+ 159.3000n -0.001800 159.3100n -0.001649 159.3200n -0.001487 159.3300n -0.001315 159.3400n -0.001137 159.3500n -0.000957 159.3600n -0.000777 159.3700n -0.000601 159.3800n -0.000431 159.3900n -0.000269 159.4000n -0.000120 159.4100n 0.000016 159.4200n 0.000136 159.4300n 0.000240 159.4400n 0.000326
+ 159.4500n 0.000393 159.4600n 0.000441 159.4700n 0.000472 159.4800n 0.000485 159.4900n 0.000481 159.5000n 0.000462 159.5100n 0.000430 159.5200n 0.000387 159.5300n 0.000334 159.5400n 0.000275 159.5500n 0.000211 159.5600n 0.000145 159.5700n 0.000079 159.5800n 0.000016 159.5900n -0.000042
+ 159.6000n -0.000095 159.6100n -0.000140 159.6200n -0.000176 159.6300n -0.000202 159.6400n -0.000218 159.6500n -0.000224 159.6600n -0.000220 159.6700n -0.000207 159.6800n -0.000187 159.6900n -0.000159 159.7000n -0.000126 159.7100n -0.000091 159.7200n -0.000054 159.7300n -0.000018 159.7400n 0.000014
+ 159.7500n 0.000041 159.7600n 0.000060 159.7700n 0.000070 159.7800n 0.000068 159.7900n 0.000053 159.8000n 0.000024 159.8100n -0.000020 159.8200n -0.000080 159.8300n -0.000155 159.8400n -0.000245 159.8500n -0.000351 159.8600n -0.000469 159.8700n -0.000600 159.8800n -0.000740 159.8900n -0.000887
+ 159.9000n -0.001040 159.9100n -0.001195 159.9200n -0.001350 159.9300n -0.001500 159.9400n -0.001644 159.9500n -0.001778 159.9600n -0.001900 159.9700n -0.002006 159.9800n -0.002094 159.9900n -0.002162 160.0000n -0.002208 160.0100n -0.002231 160.0200n -0.002229 160.0300n -0.002203 160.0400n -0.002153
+ 160.0500n -0.002079 160.0600n -0.001982 160.0700n -0.001863 160.0800n -0.001725 160.0900n -0.001569 160.1000n -0.001399 160.1100n -0.001218 160.1200n -0.001028 160.1300n -0.000833 160.1400n -0.000636 160.1500n -0.000441 160.1600n -0.000251 160.1700n -0.000070 160.1800n 0.000100 160.1900n 0.000257
+ 160.2000n 0.000397 160.2100n 0.000519 160.2200n 0.000622 160.2300n 0.000704 160.2400n 0.000765 160.2500n 0.000805 160.2600n 0.000824 160.2700n 0.000823 160.2800n 0.000805 160.2900n 0.000769 160.3000n 0.000720 160.3100n 0.000658 160.3200n 0.000587 160.3300n 0.000509 160.3400n 0.000428
+ 160.3500n 0.000347 160.3600n 0.000267 160.3700n 0.000193 160.3800n 0.000126 160.3900n 0.000069 160.4000n 0.000024 160.4100n -0.000009 160.4200n -0.000027 160.4300n -0.000030 160.4400n -0.000018 160.4500n 0.000009 160.4600n 0.000050 160.4700n 0.000104 160.4800n 0.000169 160.4900n 0.000244
+ 160.5000n 0.000325 160.5100n 0.000410 160.5200n 0.000497 160.5300n 0.000582 160.5400n 0.000663 160.5500n 0.000736 160.5600n 0.000799 160.5700n 0.000849 160.5800n 0.000883 160.5900n 0.000900 160.6000n 0.000898 160.6100n 0.000875 160.6200n 0.000830 160.6300n 0.000764 160.6400n 0.000677
+ 160.6500n 0.000568 160.6600n 0.000441 160.6700n 0.000296 160.6800n 0.000135 160.6900n -0.000038 160.7000n -0.000221 160.7100n -0.000410 160.7200n -0.000601 160.7300n -0.000792 160.7400n -0.000978 160.7500n -0.001155 160.7600n -0.001319 160.7700n -0.001468 160.7800n -0.001597 160.7900n -0.001704
+ 160.8000n -0.001787 160.8100n -0.001843 160.8200n -0.001870 160.8300n -0.001869 160.8400n -0.001838 160.8500n -0.001777 160.8600n -0.001688 160.8700n -0.001572 160.8800n -0.001431 160.8900n -0.001267 160.9000n -0.001083 160.9100n -0.000883 160.9200n -0.000669 160.9300n -0.000447 160.9400n -0.000220
+ 160.9500n 0.000008 160.9600n 0.000233 160.9700n 0.000450 160.9800n 0.000656 160.9900n 0.000847 161.0000n 0.001020 161.0100n 0.001171 161.0200n 0.001299 161.0300n 0.001401 161.0400n 0.001477 161.0500n 0.001524 161.0600n 0.001544 161.0700n 0.001536 161.0800n 0.001501 161.0900n 0.001441
+ 161.1000n 0.001358 161.1100n 0.001253 161.1200n 0.001129 161.1300n 0.000991 161.1400n 0.000840 161.1500n 0.000680 161.1600n 0.000515 161.1700n 0.000348 161.1800n 0.000183 161.1900n 0.000022 161.2000n -0.000130 161.2100n -0.000272 161.2200n -0.000400 161.2300n -0.000514 161.2400n -0.000610
+ 161.2500n -0.000689 161.2600n -0.000749 161.2700n -0.000791 161.2800n -0.000814 161.2900n -0.000819 161.3000n -0.000808 161.3100n -0.000781 161.3200n -0.000741 161.3300n -0.000689 161.3400n -0.000628 161.3500n -0.000560 161.3600n -0.000488 161.3700n -0.000414 161.3800n -0.000339 161.3900n -0.000268
+ 161.4000n -0.000201 161.4100n -0.000140 161.4200n -0.000087 161.4300n -0.000043 161.4400n -0.000008 161.4500n 0.000016 161.4600n 0.000030 161.4700n 0.000035 161.4800n 0.000030 161.4900n 0.000017 161.5000n -0.000002 161.5100n -0.000027 161.5200n -0.000055 161.5300n -0.000084 161.5400n -0.000113
+ 161.5500n -0.000139 161.5600n -0.000161 161.5700n -0.000176 161.5800n -0.000183 161.5900n -0.000180 161.6000n -0.000165 161.6100n -0.000139 161.6200n -0.000101 161.6300n -0.000050 161.6400n 0.000014 161.6500n 0.000090 161.6600n 0.000177 161.6700n 0.000273 161.6800n 0.000377 161.6900n 0.000487
+ 161.7000n 0.000600 161.7100n 0.000714 161.7200n 0.000826 161.7300n 0.000933 161.7400n 0.001033 161.7500n 0.001122 161.7600n 0.001199 161.7700n 0.001259 161.7800n 0.001302 161.7900n 0.001326 161.8000n 0.001328 161.8100n 0.001307 161.8200n 0.001263 161.8300n 0.001196 161.8400n 0.001106
+ 161.8500n 0.000993 161.8600n 0.000860 161.8700n 0.000707 161.8800n 0.000537 161.8900n 0.000353 161.9000n 0.000158 161.9100n -0.000045 161.9200n -0.000252 161.9300n -0.000460 161.9400n -0.000665 161.9500n -0.000862 161.9600n -0.001049 161.9700n -0.001221 161.9800n -0.001375 161.9900n -0.001508
+ 162.0000n -0.001617 162.0100n -0.001700 162.0200n -0.001755 162.0300n -0.001781 162.0400n -0.001776 162.0500n -0.001741 162.0600n -0.001675 162.0700n -0.001580 162.0800n -0.001457 162.0900n -0.001308 162.1000n -0.001135 162.1100n -0.000941 162.1200n -0.000729 162.1300n -0.000502 162.1400n -0.000264
+ 162.1500n -0.000019 162.1600n 0.000230 162.1700n 0.000479 162.1800n 0.000724 162.1900n 0.000962 162.2000n 0.001190 162.2100n 0.001404 162.2200n 0.001602 162.2300n 0.001783 162.2400n 0.001943 162.2500n 0.002082 162.2600n 0.002199 162.2700n 0.002294 162.2800n 0.002366 162.2900n 0.002417
+ 162.3000n 0.002446 162.3100n 0.002456 162.3200n 0.002447 162.3300n 0.002422 162.3400n 0.002383 162.3500n 0.002332 162.3600n 0.002270 162.3700n 0.002201 162.3800n 0.002127 162.3900n 0.002049 162.4000n 0.001969 162.4100n 0.001890 162.4200n 0.001812 162.4300n 0.001737 162.4400n 0.001665
+ 162.4500n 0.001597 162.4600n 0.001533 162.4700n 0.001473 162.4800n 0.001416 162.4900n 0.001362 162.5000n 0.001309 162.5100n 0.001256 162.5200n 0.001202 162.5300n 0.001145 162.5400n 0.001083 162.5500n 0.001016 162.5600n 0.000940 162.5700n 0.000855 162.5800n 0.000760 162.5900n 0.000653
+ 162.6000n 0.000534 162.6100n 0.000403 162.6200n 0.000259 162.6300n 0.000102 162.6400n -0.000066 162.6500n -0.000245 162.6600n -0.000433 162.6700n -0.000628 162.6800n -0.000828 162.6900n -0.001030 162.7000n -0.001233 162.7100n -0.001431 162.7200n -0.001624 162.7300n -0.001807 162.7400n -0.001978
+ 162.7500n -0.002132 162.7600n -0.002268 162.7700n -0.002383 162.7800n -0.002473 162.7900n -0.002537 162.8000n -0.002574 162.8100n -0.002582 162.8200n -0.002560 162.8300n -0.002508 162.8400n -0.002426 162.8500n -0.002316 162.8600n -0.002178 162.8700n -0.002015 162.8800n -0.001828 162.8900n -0.001622
+ 162.9000n -0.001398 162.9100n -0.001162 162.9200n -0.000916 162.9300n -0.000665 162.9400n -0.000412 162.9500n -0.000163 162.9600n 0.000078 162.9700n 0.000309 162.9800n 0.000523 162.9900n 0.000720 163.0000n 0.000894 163.0100n 0.001043 163.0200n 0.001165 163.0300n 0.001259 163.0400n 0.001322
+ 163.0500n 0.001356 163.0600n 0.001359 163.0700n 0.001332 163.0800n 0.001277 163.0900n 0.001195 163.1000n 0.001089 163.1100n 0.000961 163.1200n 0.000815 163.1300n 0.000655 163.1400n 0.000483 163.1500n 0.000305 163.1600n 0.000123 163.1700n -0.000057 163.1800n -0.000231 163.1900n -0.000397
+ 163.2000n -0.000550 163.2100n -0.000687 163.2200n -0.000804 163.2300n -0.000901 163.2400n -0.000974 163.2500n -0.001022 163.2600n -0.001045 163.2700n -0.001041 163.2800n -0.001012 163.2900n -0.000958 163.3000n -0.000881 163.3100n -0.000782 163.3200n -0.000665 163.3300n -0.000531 163.3400n -0.000384
+ 163.3500n -0.000228 163.3600n -0.000066 163.3700n 0.000098 163.3800n 0.000260 163.3900n 0.000416 163.4000n 0.000563 163.4100n 0.000696 163.4200n 0.000814 163.4300n 0.000912 163.4400n 0.000988 163.4500n 0.001040 163.4600n 0.001067 163.4700n 0.001067 163.4800n 0.001040 163.4900n 0.000986
+ 163.5000n 0.000906 163.5100n 0.000799 163.5200n 0.000670 163.5300n 0.000518 163.5400n 0.000347 163.5500n 0.000160 163.5600n -0.000040 163.5700n -0.000250 163.5800n -0.000465 163.5900n -0.000682 163.6000n -0.000896 163.6100n -0.001105 163.6200n -0.001304 163.6300n -0.001489 163.6400n -0.001657
+ 163.6500n -0.001805 163.6600n -0.001930 163.6700n -0.002030 163.6800n -0.002103 163.6900n -0.002146 163.7000n -0.002159 163.7100n -0.002142 163.7200n -0.002095 163.7300n -0.002017 163.7400n -0.001909 163.7500n -0.001774 163.7600n -0.001613 163.7700n -0.001428 163.7800n -0.001222 163.7900n -0.000997
+ 163.8000n -0.000757 163.8100n -0.000504 163.8200n -0.000243 163.8300n 0.000022 163.8400n 0.000289 163.8500n 0.000554 163.8600n 0.000813 163.8700n 0.001063 163.8800n 0.001300 163.8900n 0.001522 163.9000n 0.001725 163.9100n 0.001908 163.9200n 0.002067 163.9300n 0.002201 163.9400n 0.002309
+ 163.9500n 0.002389 163.9600n 0.002441 163.9700n 0.002463 163.9800n 0.002457 163.9900n 0.002421 164.0000n 0.002358 164.0100n 0.002267 164.0200n 0.002150 164.0300n 0.002008 164.0400n 0.001844 164.0500n 0.001659 164.0600n 0.001456 164.0700n 0.001237 164.0800n 0.001004 164.0900n 0.000760
+ 164.1000n 0.000509 164.1100n 0.000252 164.1200n -0.000007 164.1300n -0.000265 164.1400n -0.000520 164.1500n -0.000769 164.1600n -0.001010 164.1700n -0.001239 164.1800n -0.001454 164.1900n -0.001654 164.2000n -0.001836 164.2100n -0.001998 164.2200n -0.002139 164.2300n -0.002258 164.2400n -0.002353
+ 164.2500n -0.002423 164.2600n -0.002469 164.2700n -0.002490 164.2800n -0.002486 164.2900n -0.002457 164.3000n -0.002404 164.3100n -0.002328 164.3200n -0.002231 164.3300n -0.002113 164.3400n -0.001977 164.3500n -0.001824 164.3600n -0.001656 164.3700n -0.001476 164.3800n -0.001287 164.3900n -0.001090
+ 164.4000n -0.000888 164.4100n -0.000684 164.4200n -0.000480 164.4300n -0.000280 164.4400n -0.000084 164.4500n 0.000103 164.4600n 0.000281 164.4700n 0.000447 164.4800n 0.000600 164.4900n 0.000738 164.5000n 0.000860 164.5100n 0.000965 164.5200n 0.001052 164.5300n 0.001122 164.5400n 0.001174
+ 164.5500n 0.001209 164.5600n 0.001228 164.5700n 0.001232 164.5800n 0.001222 164.5900n 0.001199 164.6000n 0.001166 164.6100n 0.001124 164.6200n 0.001076 164.6300n 0.001023 164.6400n 0.000968 164.6500n 0.000913 164.6600n 0.000861 164.6700n 0.000813 164.6800n 0.000771 164.6900n 0.000737
+ 164.7000n 0.000713 164.7100n 0.000699 164.7200n 0.000696 164.7300n 0.000706 164.7400n 0.000727 164.7500n 0.000761 164.7600n 0.000806 164.7700n 0.000862 164.7800n 0.000927 164.7900n 0.001001 164.8000n 0.001080 164.8100n 0.001163 164.8200n 0.001249 164.8300n 0.001334 164.8400n 0.001415
+ 164.8500n 0.001492 164.8600n 0.001560 164.8700n 0.001618 164.8800n 0.001662 164.8900n 0.001692 164.9000n 0.001706 164.9100n 0.001700 164.9200n 0.001675 164.9300n 0.001630 164.9400n 0.001564 164.9500n 0.001476 164.9600n 0.001368 164.9700n 0.001240 164.9800n 0.001093 164.9900n 0.000929
+ 165.0000n 0.000751 165.0100n 0.000559 165.0200n 0.000358 165.0300n 0.000150 165.0400n -0.000063 165.0500n -0.000275 165.0600n -0.000486 165.0700n -0.000690 165.0800n -0.000885 165.0900n -0.001067 165.1000n -0.001235 165.1100n -0.001384 165.1200n -0.001513 165.1300n -0.001620 165.1400n -0.001704
+ 165.1500n -0.001762 165.1600n -0.001795 165.1700n -0.001803 165.1800n -0.001786 165.1900n -0.001744 165.2000n -0.001679 165.2100n -0.001594 165.2200n -0.001489 165.2300n -0.001367 165.2400n -0.001232 165.2500n -0.001086 165.2600n -0.000933 165.2700n -0.000775 165.2800n -0.000617 165.2900n -0.000460
+ 165.3000n -0.000309 165.3100n -0.000167 165.3200n -0.000035 165.3300n 0.000083 165.3400n 0.000186 165.3500n 0.000272 165.3600n 0.000341 165.3700n 0.000391 165.3800n 0.000422 165.3900n 0.000435 165.4000n 0.000431 165.4100n 0.000411 165.4200n 0.000377 165.4300n 0.000331 165.4400n 0.000275
+ 165.4500n 0.000212 165.4600n 0.000145 165.4700n 0.000078 165.4800n 0.000012 165.4900n -0.000048 165.5000n -0.000100 165.5100n -0.000140 165.5200n -0.000168 165.5300n -0.000179 165.5400n -0.000172 165.5500n -0.000146 165.5600n -0.000101 165.5700n -0.000034 165.5800n 0.000053 165.5900n 0.000161
+ 165.6000n 0.000287 165.6100n 0.000430 165.6200n 0.000589 165.6300n 0.000761 165.6400n 0.000943 165.6500n 0.001132 165.6600n 0.001324 165.6700n 0.001516 165.6800n 0.001704 165.6900n 0.001884 165.7000n 0.002053 165.7100n 0.002207 165.7200n 0.002343 165.7300n 0.002458 165.7400n 0.002549
+ 165.7500n 0.002614 165.7600n 0.002652 165.7700n 0.002661 165.7800n 0.002640 165.7900n 0.002590 165.8000n 0.002511 165.8100n 0.002404 165.8200n 0.002270 165.8300n 0.002113 165.8400n 0.001934 165.8500n 0.001736 165.8600n 0.001523 165.8700n 0.001298 165.8800n 0.001065 165.8900n 0.000828
+ 165.9000n 0.000591 165.9100n 0.000358 165.9200n 0.000132 165.9300n -0.000083 165.9400n -0.000284 165.9500n -0.000469 165.9600n -0.000633 165.9700n -0.000777 165.9800n -0.000898 165.9900n -0.000996 166.0000n -0.001070 166.0100n -0.001120 166.0200n -0.001148 166.0300n -0.001154 166.0400n -0.001140
+ 166.0500n -0.001109 166.0600n -0.001063 166.0700n -0.001005 166.0800n -0.000938 166.0900n -0.000864 166.1000n -0.000789 166.1100n -0.000714 166.1200n -0.000643 166.1300n -0.000579 166.1400n -0.000525 166.1500n -0.000482 166.1600n -0.000454 166.1700n -0.000442 166.1800n -0.000447 166.1900n -0.000469
+ 166.2000n -0.000508 166.2100n -0.000565 166.2200n -0.000638 166.2300n -0.000725 166.2400n -0.000826 166.2500n -0.000936 166.2600n -0.001054 166.2700n -0.001177 166.2800n -0.001301 166.2900n -0.001422 166.3000n -0.001538 166.3100n -0.001644 166.3200n -0.001738 166.3300n -0.001816 166.3400n -0.001875
+ 166.3500n -0.001912 166.3600n -0.001925 166.3700n -0.001913 166.3800n -0.001874 166.3900n -0.001808 166.4000n -0.001713 166.4100n -0.001592 166.4200n -0.001444 166.4300n -0.001271 166.4400n -0.001075 166.4500n -0.000860 166.4600n -0.000627 166.4700n -0.000382 166.4800n -0.000126 166.4900n 0.000135
+ 166.5000n 0.000398 166.5100n 0.000658 166.5200n 0.000910 166.5300n 0.001152 166.5400n 0.001378 166.5500n 0.001585 166.5600n 0.001770 166.5700n 0.001930 166.5800n 0.002062 166.5900n 0.002164 166.6000n 0.002235 166.6100n 0.002273 166.6200n 0.002280 166.6300n 0.002254 166.6400n 0.002198
+ 166.6500n 0.002112 166.6600n 0.001999 166.6700n 0.001861 166.6800n 0.001700 166.6900n 0.001521 166.7000n 0.001327 166.7100n 0.001121 166.7200n 0.000907 166.7300n 0.000690 166.7400n 0.000473 166.7500n 0.000260 166.7600n 0.000055 166.7700n -0.000140 166.7800n -0.000321 166.7900n -0.000485
+ 166.8000n -0.000631 166.8100n -0.000757 166.8200n -0.000862 166.8300n -0.000944 166.8400n -0.001005 166.8500n -0.001044 166.8600n -0.001061 166.8700n -0.001060 166.8800n -0.001040 166.8900n -0.001004 166.9000n -0.000955 166.9100n -0.000895 166.9200n -0.000826 166.9300n -0.000752 166.9400n -0.000676
+ 166.9500n -0.000600 166.9600n -0.000527 166.9700n -0.000461 166.9800n -0.000402 166.9900n -0.000354 167.0000n -0.000318 167.0100n -0.000295 167.0200n -0.000287 167.0300n -0.000295 167.0400n -0.000318 167.0500n -0.000357 167.0600n -0.000411 167.0700n -0.000479 167.0800n -0.000560 167.0900n -0.000652
+ 167.1000n -0.000755 167.1100n -0.000864 167.1200n -0.000980 167.1300n -0.001098 167.1400n -0.001218 167.1500n -0.001336 167.1600n -0.001451 167.1700n -0.001560 167.1800n -0.001661 167.1900n -0.001752 167.2000n -0.001832 167.2100n -0.001900 167.2200n -0.001954 167.2300n -0.001994 167.2400n -0.002019
+ 167.2500n -0.002028 167.2600n -0.002023 167.2700n -0.002004 167.2800n -0.001970 167.2900n -0.001924 167.3000n -0.001865 167.3100n -0.001796 167.3200n -0.001717 167.3300n -0.001629 167.3400n -0.001535 167.3500n -0.001436 167.3600n -0.001333 167.3700n -0.001226 167.3800n -0.001118 167.3900n -0.001009
+ 167.4000n -0.000900 167.4100n -0.000792 167.4200n -0.000685 167.4300n -0.000579 167.4400n -0.000475 167.4500n -0.000373 167.4600n -0.000271 167.4700n -0.000171 167.4800n -0.000071 167.4900n 0.000029 167.5000n 0.000130 167.5100n 0.000232 167.5200n 0.000335 167.5300n 0.000441 167.5400n 0.000549
+ 167.5500n 0.000659 167.5600n 0.000773 167.5700n 0.000889 167.5800n 0.001006 167.5900n 0.001126 167.6000n 0.001246 167.6100n 0.001365 167.6200n 0.001483 167.6300n 0.001597 167.6400n 0.001707 167.6500n 0.001810 167.6600n 0.001904 167.6700n 0.001987 167.6800n 0.002058 167.6900n 0.002114
+ 167.7000n 0.002153 167.7100n 0.002174 167.7200n 0.002175 167.7300n 0.002154 167.7400n 0.002110 167.7500n 0.002043 167.7600n 0.001952 167.7700n 0.001838 167.7800n 0.001699 167.7900n 0.001537 167.8000n 0.001354 167.8100n 0.001151 167.8200n 0.000930 167.8300n 0.000693 167.8400n 0.000443
+ 167.8500n 0.000184 167.8600n -0.000082 167.8700n -0.000349 167.8800n -0.000616 167.8900n -0.000877 167.9000n -0.001129 167.9100n -0.001368 167.9200n -0.001589 167.9300n -0.001790 167.9400n -0.001967 167.9500n -0.002116 167.9600n -0.002234 167.9700n -0.002321 167.9800n -0.002373 167.9900n -0.002389
+ 168.0000n -0.002369 168.0100n -0.002312 168.0200n -0.002218 168.0300n -0.002089 168.0400n -0.001926 168.0500n -0.001731 168.0600n -0.001506 168.0700n -0.001255 168.0800n -0.000980 168.0900n -0.000686 168.1000n -0.000376 168.1100n -0.000054 168.1200n 0.000274 168.1300n 0.000605 168.1400n 0.000934
+ 168.1500n 0.001257 168.1600n 0.001569 168.1700n 0.001867 168.1800n 0.002148 168.1900n 0.002407 168.2000n 0.002642 168.2100n 0.002850 168.2200n 0.003030 168.2300n 0.003181 168.2400n 0.003300 168.2500n 0.003389 168.2600n 0.003447 168.2700n 0.003474 168.2800n 0.003473 168.2900n 0.003444
+ 168.3000n 0.003390 168.3100n 0.003313 168.3200n 0.003215 168.3300n 0.003100 168.3400n 0.002971 168.3500n 0.002831 168.3600n 0.002684 168.3700n 0.002531 168.3800n 0.002378 168.3900n 0.002226 168.4000n 0.002079 168.4100n 0.001939 168.4200n 0.001809 168.4300n 0.001690 168.4400n 0.001584
+ 168.4500n 0.001493 168.4600n 0.001416 168.4700n 0.001355 168.4800n 0.001309 168.4900n 0.001279 168.5000n 0.001263 168.5100n 0.001260 168.5200n 0.001269 168.5300n 0.001288 168.5400n 0.001316 168.5500n 0.001349 168.5600n 0.001387 168.5700n 0.001427 168.5800n 0.001466 168.5900n 0.001502
+ 168.6000n 0.001534 168.6100n 0.001558 168.6200n 0.001574 168.6300n 0.001579 168.6400n 0.001572 168.6500n 0.001552 168.6600n 0.001518 168.6700n 0.001469 168.6800n 0.001406 168.6900n 0.001328 168.7000n 0.001236 168.7100n 0.001130 168.7200n 0.001012 168.7300n 0.000883 168.7400n 0.000744
+ 168.7500n 0.000597 168.7600n 0.000445 168.7700n 0.000288 168.7800n 0.000130 168.7900n -0.000027 168.8000n -0.000181 168.8100n -0.000330 168.8200n -0.000471 168.8300n -0.000603 168.8400n -0.000723 168.8500n -0.000830 168.8600n -0.000922 168.8700n -0.000998 168.8800n -0.001056 168.8900n -0.001095
+ 168.9000n -0.001116 168.9100n -0.001117 168.9200n -0.001099 168.9300n -0.001062 168.9400n -0.001007 168.9500n -0.000934 168.9600n -0.000845 168.9700n -0.000740 168.9800n -0.000623 168.9900n -0.000493 169.0000n -0.000353 169.0100n -0.000206 169.0200n -0.000054 169.0300n 0.000102 169.0400n 0.000258
+ 169.0500n 0.000413 169.0600n 0.000564 169.0700n 0.000709 169.0800n 0.000846 169.0900n 0.000972 169.1000n 0.001085 169.1100n 0.001184 169.1200n 0.001266 169.1300n 0.001332 169.1400n 0.001378 169.1500n 0.001405 169.1600n 0.001411 169.1700n 0.001396 169.1800n 0.001359 169.1900n 0.001301
+ 169.2000n 0.001223 169.2100n 0.001123 169.2200n 0.001004 169.2300n 0.000866 169.2400n 0.000711 169.2500n 0.000540 169.2600n 0.000355 169.2700n 0.000157 169.2800n -0.000051 169.2900n -0.000267 169.3000n -0.000490 169.3100n -0.000716 169.3200n -0.000942 169.3300n -0.001168 169.3400n -0.001390
+ 169.3500n -0.001606 169.3600n -0.001813 169.3700n -0.002009 169.3800n -0.002192 169.3900n -0.002361 169.4000n -0.002512 169.4100n -0.002645 169.4200n -0.002758 169.4300n -0.002850 169.4400n -0.002920 169.4500n -0.002967 169.4600n -0.002991 169.4700n -0.002991 169.4800n -0.002968 169.4900n -0.002922
+ 169.5000n -0.002853 169.5100n -0.002763 169.5200n -0.002652 169.5300n -0.002523 169.5400n -0.002376 169.5500n -0.002213 169.5600n -0.002037 169.5700n -0.001849 169.5800n -0.001651 169.5900n -0.001446 169.6000n -0.001236 169.6100n -0.001024 169.6200n -0.000811 169.6300n -0.000600 169.6400n -0.000394
+ 169.6500n -0.000194 169.6600n -0.000002 169.6700n 0.000179 169.6800n 0.000349 169.6900n 0.000505 169.7000n 0.000646 169.7100n 0.000771 169.7200n 0.000880 169.7300n 0.000971 169.7400n 0.001044 169.7500n 0.001099 169.7600n 0.001136 169.7700n 0.001155 169.7800n 0.001157 169.7900n 0.001141
+ 169.8000n 0.001110 169.8100n 0.001064 169.8200n 0.001003 169.8300n 0.000929 169.8400n 0.000844 169.8500n 0.000749 169.8600n 0.000644 169.8700n 0.000532 169.8800n 0.000414 169.8900n 0.000292 169.9000n 0.000167 169.9100n 0.000040 169.9200n -0.000087 169.9300n -0.000212 169.9400n -0.000335
+ 169.9500n -0.000454 169.9600n -0.000568 169.9700n -0.000676 169.9800n -0.000777 169.9900n -0.000869 170.0000n -0.000952 170.0100n -0.001025 170.0200n -0.001087 170.0300n -0.001138 170.0400n -0.001177 170.0500n -0.001203 170.0600n -0.001216 170.0700n -0.001215 170.0800n -0.001201 170.0900n -0.001172
+ 170.1000n -0.001130 170.1100n -0.001073 170.1200n -0.001002 170.1300n -0.000917 170.1400n -0.000818 170.1500n -0.000706 170.1600n -0.000581 170.1700n -0.000445 170.1800n -0.000296 170.1900n -0.000138 170.2000n 0.000030 170.2100n 0.000205 170.2200n 0.000388 170.2300n 0.000575 170.2400n 0.000766
+ 170.2500n 0.000959 170.2600n 0.001151 170.2700n 0.001341 170.2800n 0.001526 170.2900n 0.001706 170.3000n 0.001877 170.3100n 0.002037 170.3200n 0.002184 170.3300n 0.002317 170.3400n 0.002433 170.3500n 0.002531 170.3600n 0.002609 170.3700n 0.002666 170.3800n 0.002700 170.3900n 0.002710
+ 170.4000n 0.002697 170.4100n 0.002659 170.4200n 0.002597 170.4300n 0.002510 170.4400n 0.002401 170.4500n 0.002269 170.4600n 0.002116 170.4700n 0.001943 170.4800n 0.001753 170.4900n 0.001548 170.5000n 0.001330 170.5100n 0.001102 170.5200n 0.000866 170.5300n 0.000627 170.5400n 0.000386
+ 170.5500n 0.000146 170.5600n -0.000088 170.5700n -0.000315 170.5800n -0.000532 170.5900n -0.000736 170.6000n -0.000924 170.6100n -0.001095 170.6200n -0.001247 170.6300n -0.001378 170.6400n -0.001488 170.6500n -0.001576 170.6600n -0.001642 170.6700n -0.001686 170.6800n -0.001709 170.6900n -0.001712
+ 170.7000n -0.001697 170.7100n -0.001665 170.7200n -0.001619 170.7300n -0.001561 170.7400n -0.001494 170.7500n -0.001420 170.7600n -0.001344 170.7700n -0.001268 170.7800n -0.001194 170.7900n -0.001127 170.8000n -0.001068 170.8100n -0.001021 170.8200n -0.000988 170.8300n -0.000971 170.8400n -0.000971
+ 170.8500n -0.000990 170.8600n -0.001029 170.8700n -0.001088 170.8800n -0.001166 170.8900n -0.001265 170.9000n -0.001381 170.9100n -0.001514 170.9200n -0.001662 170.9300n -0.001822 170.9400n -0.001992 170.9500n -0.002169 170.9600n -0.002348 170.9700n -0.002528 170.9800n -0.002704 170.9900n -0.002872
+ 171.0000n -0.003030 171.0100n -0.003172 171.0200n -0.003297 171.0300n -0.003402 171.0400n -0.003482 171.0500n -0.003536 171.0600n -0.003563 171.0700n -0.003559 171.0800n -0.003526 171.0900n -0.003461 171.1000n -0.003365 171.1100n -0.003238 171.1200n -0.003083 171.1300n -0.002899 171.1400n -0.002690
+ 171.1500n -0.002458 171.1600n -0.002206 171.1700n -0.001937 171.1800n -0.001655 171.1900n -0.001363 171.2000n -0.001066 171.2100n -0.000768 171.2200n -0.000472 171.2300n -0.000182 171.2400n 0.000097 171.2500n 0.000363 171.2600n 0.000611 171.2700n 0.000840 171.2800n 0.001046 171.2900n 0.001228
+ 171.3000n 0.001383 171.3100n 0.001511 171.3200n 0.001610 171.3300n 0.001682 171.3400n 0.001726 171.3500n 0.001742 171.3600n 0.001733 171.3700n 0.001699 171.3800n 0.001643 171.3900n 0.001567 171.4000n 0.001474 171.4100n 0.001366 171.4200n 0.001246 171.4300n 0.001118 171.4400n 0.000983
+ 171.4500n 0.000846 171.4600n 0.000708 171.4700n 0.000572 171.4800n 0.000442 171.4900n 0.000318 171.5000n 0.000202 171.5100n 0.000097 171.5200n 0.000003 171.5300n -0.000079 171.5400n -0.000148 171.5500n -0.000205 171.5600n -0.000249 171.5700n -0.000282 171.5800n -0.000304 171.5900n -0.000316
+ 171.6000n -0.000320 171.6100n -0.000316 171.6200n -0.000307 171.6300n -0.000293 171.6400n -0.000277 171.6500n -0.000260 171.6600n -0.000244 171.6700n -0.000229 171.6800n -0.000218 171.6900n -0.000210 171.7000n -0.000207 171.7100n -0.000209 171.7200n -0.000216 171.7300n -0.000229 171.7400n -0.000246
+ 171.7500n -0.000268 171.7600n -0.000293 171.7700n -0.000321 171.7800n -0.000350 171.7900n -0.000380 171.8000n -0.000408 171.8100n -0.000433 171.8200n -0.000454 171.8300n -0.000469 171.8400n -0.000477 171.8500n -0.000477 171.8600n -0.000467 171.8700n -0.000447 171.8800n -0.000415 171.8900n -0.000372
+ 171.9000n -0.000318 171.9100n -0.000252 171.9200n -0.000175 171.9300n -0.000088 171.9400n 0.000009 171.9500n 0.000114 171.9600n 0.000225 171.9700n 0.000341 171.9800n 0.000461 171.9900n 0.000581 172.0000n 0.000701 172.0100n 0.000817 172.0200n 0.000929 172.0300n 0.001033 172.0400n 0.001127
+ 172.0500n 0.001211 172.0600n 0.001283 172.0700n 0.001340 172.0800n 0.001383 172.0900n 0.001410 172.1000n 0.001420 172.1100n 0.001415 172.1200n 0.001393 172.1300n 0.001355 172.1400n 0.001303 172.1500n 0.001237 172.1600n 0.001160 172.1700n 0.001071 172.1800n 0.000975 172.1900n 0.000871
+ 172.2000n 0.000764 172.2100n 0.000655 172.2200n 0.000547 172.2300n 0.000441 172.2400n 0.000341 172.2500n 0.000248 172.2600n 0.000164 172.2700n 0.000091 172.2800n 0.000030 172.2900n -0.000016 172.3000n -0.000048 172.3100n -0.000064 172.3200n -0.000064 172.3300n -0.000049 172.3400n -0.000018
+ 172.3500n 0.000028 172.3600n 0.000088 172.3700n 0.000160 172.3800n 0.000243 172.3900n 0.000336 172.4000n 0.000436 172.4100n 0.000542 172.4200n 0.000651 172.4300n 0.000762 172.4400n 0.000872 172.4500n 0.000979 172.4600n 0.001082 172.4700n 0.001178 172.4800n 0.001266 172.4900n 0.001344
+ 172.5000n 0.001412 172.5100n 0.001468 172.5200n 0.001511 172.5300n 0.001541 172.5400n 0.001558 172.5500n 0.001562 172.5600n 0.001552 172.5700n 0.001530 172.5800n 0.001497 172.5900n 0.001453 172.6000n 0.001398 172.6100n 0.001336 172.6200n 0.001265 172.6300n 0.001188 172.6400n 0.001107
+ 172.6500n 0.001021 172.6600n 0.000933 172.6700n 0.000843 172.6800n 0.000752 172.6900n 0.000662 172.7000n 0.000572 172.7100n 0.000483 172.7200n 0.000396 172.7300n 0.000311 172.7400n 0.000228 172.7500n 0.000146 172.7600n 0.000066 172.7700n -0.000014 172.7800n -0.000093 172.7900n -0.000172
+ 172.8000n -0.000251 172.8100n -0.000332 172.8200n -0.000414 172.8300n -0.000498 172.8400n -0.000585 172.8500n -0.000674 172.8600n -0.000766 172.8700n -0.000861 172.8800n -0.000958 172.8900n -0.001058 172.9000n -0.001158 172.9100n -0.001260 172.9200n -0.001362 172.9300n -0.001462 172.9400n -0.001560
+ 172.9500n -0.001654 172.9600n -0.001743 172.9700n -0.001825 172.9800n -0.001900 172.9900n -0.001964 173.0000n -0.002018 173.0100n -0.002059 173.0200n -0.002087 173.0300n -0.002100 173.0400n -0.002098 173.0500n -0.002080 173.0600n -0.002045 173.0700n -0.001995 173.0800n -0.001928 173.0900n -0.001846
+ 173.1000n -0.001749 173.1100n -0.001638 173.1200n -0.001515 173.1300n -0.001382 173.1400n -0.001239 173.1500n -0.001090 173.1600n -0.000936 173.1700n -0.000780 173.1800n -0.000625 173.1900n -0.000471 173.2000n -0.000322 173.2100n -0.000181 173.2200n -0.000048 173.2300n 0.000073 173.2400n 0.000182
+ 173.2500n 0.000276 173.2600n 0.000354 173.2700n 0.000416 173.2800n 0.000461 173.2900n 0.000488 173.3000n 0.000499 173.3100n 0.000492 173.3200n 0.000470 173.3300n 0.000433 173.3400n 0.000383 173.3500n 0.000321 173.3600n 0.000250 173.3700n 0.000171 173.3800n 0.000086 173.3900n -0.000001
+ 173.4000n -0.000089 173.4100n -0.000175 173.4200n -0.000257 173.4300n -0.000333 173.4400n -0.000400 173.4500n -0.000457 173.4600n -0.000503 173.4700n -0.000536 173.4800n -0.000555 173.4900n -0.000560 173.5000n -0.000550 173.5100n -0.000525 173.5200n -0.000487 173.5300n -0.000435 173.5400n -0.000371
+ 173.5500n -0.000296 173.5600n -0.000212 173.5700n -0.000121 173.5800n -0.000025 173.5900n 0.000074 173.6000n 0.000174 173.6100n 0.000272 173.6200n 0.000366 173.6300n 0.000453 173.6400n 0.000532 173.6500n 0.000600 173.6600n 0.000657 173.6700n 0.000699 173.6800n 0.000727 173.6900n 0.000738
+ 173.7000n 0.000733 173.7100n 0.000711 173.7200n 0.000672 173.7300n 0.000616 173.7400n 0.000545 173.7500n 0.000459 173.7600n 0.000359 173.7700n 0.000247 173.7800n 0.000126 173.7900n -0.000004 173.8000n -0.000141 173.8100n -0.000281 173.8200n -0.000422 173.8300n -0.000564 173.8400n -0.000702
+ 173.8500n -0.000836 173.8600n -0.000963 173.8700n -0.001081 173.8800n -0.001189 173.8900n -0.001285 173.9000n -0.001368 173.9100n -0.001436 173.9200n -0.001490 173.9300n -0.001529 173.9400n -0.001553 173.9500n -0.001562 173.9600n -0.001555 173.9700n -0.001534 173.9800n -0.001500 173.9900n -0.001453
+ 174.0000n -0.001394 174.0100n -0.001325 174.0200n -0.001247 174.0300n -0.001161 174.0400n -0.001068 174.0500n -0.000971 174.0600n -0.000869 174.0700n -0.000765 174.0800n -0.000659 174.0900n -0.000553 174.1000n -0.000447 174.1100n -0.000343 174.1200n -0.000241 174.1300n -0.000141 174.1400n -0.000045
+ 174.1500n 0.000049 174.1600n 0.000139 174.1700n 0.000225 174.1800n 0.000307 174.1900n 0.000386 174.2000n 0.000462 174.2100n 0.000533 174.2200n 0.000602 174.2300n 0.000667 174.2400n 0.000728 174.2500n 0.000786 174.2600n 0.000841 174.2700n 0.000893 174.2800n 0.000940 174.2900n 0.000983
+ 174.3000n 0.001022 174.3100n 0.001056 174.3200n 0.001084 174.3300n 0.001106 174.3400n 0.001122 174.3500n 0.001131 174.3600n 0.001132 174.3700n 0.001124 174.3800n 0.001108 174.3900n 0.001083 174.4000n 0.001048 174.4100n 0.001004 174.4200n 0.000950 174.4300n 0.000887 174.4400n 0.000814
+ 174.4500n 0.000733 174.4600n 0.000643 174.4700n 0.000546 174.4800n 0.000443 174.4900n 0.000334 174.5000n 0.000221 174.5100n 0.000106 174.5200n -0.000011 174.5300n -0.000127 174.5400n -0.000241 174.5500n -0.000351 174.5600n -0.000456 174.5700n -0.000554 174.5800n -0.000643 174.5900n -0.000723
+ 174.6000n -0.000792 174.6100n -0.000849 174.6200n -0.000893 174.6300n -0.000924 174.6400n -0.000942 174.6500n -0.000946 174.6600n -0.000936 174.6700n -0.000914 174.6800n -0.000880 174.6900n -0.000835 174.7000n -0.000780 174.7100n -0.000716 174.7200n -0.000646 174.7300n -0.000572 174.7400n -0.000494
+ 174.7500n -0.000416 174.7600n -0.000339 174.7700n -0.000265 174.7800n -0.000196 174.7900n -0.000135 174.8000n -0.000083 174.8100n -0.000041 174.8200n -0.000012 174.8300n 0.000004 174.8400n 0.000007 174.8500n -0.000006 174.8600n -0.000033 174.8700n -0.000076 174.8800n -0.000133 174.8900n -0.000205
+ 174.9000n -0.000289 174.9100n -0.000386 174.9200n -0.000493 174.9300n -0.000610 174.9400n -0.000733 174.9500n -0.000862 174.9600n -0.000993 174.9700n -0.001126 174.9800n -0.001256 174.9900n -0.001383 175.0000n -0.001504 175.0100n -0.001617 175.0200n -0.001720 175.0300n -0.001810 175.0400n -0.001887
+ 175.0500n -0.001949 175.0600n -0.001995 175.0700n -0.002023 175.0800n -0.002034 175.0900n -0.002026 175.1000n -0.001999 175.1100n -0.001955 175.1200n -0.001892 175.1300n -0.001811 175.1400n -0.001714 175.1500n -0.001601 175.1600n -0.001474 175.1700n -0.001334 175.1800n -0.001182 175.1900n -0.001019
+ 175.2000n -0.000848 175.2100n -0.000670 175.2200n -0.000487 175.2300n -0.000300 175.2400n -0.000110 175.2500n 0.000080 175.2600n 0.000269 175.2700n 0.000455 175.2800n 0.000639 175.2900n 0.000817 175.3000n 0.000989 175.3100n 0.001155 175.3200n 0.001312 175.3300n 0.001461 175.3400n 0.001599
+ 175.3500n 0.001728 175.3600n 0.001845 175.3700n 0.001950 175.3800n 0.002043 175.3900n 0.002122 175.4000n 0.002188 175.4100n 0.002239 175.4200n 0.002276 175.4300n 0.002298 175.4400n 0.002304 175.4500n 0.002294 175.4600n 0.002268 175.4700n 0.002225 175.4800n 0.002166 175.4900n 0.002090
+ 175.5000n 0.001998 175.5100n 0.001890 175.5200n 0.001766 175.5300n 0.001627 175.5400n 0.001475 175.5500n 0.001309 175.5600n 0.001132 175.5700n 0.000946 175.5800n 0.000751 175.5900n 0.000550 175.6000n 0.000345 175.6100n 0.000140 175.6200n -0.000065 175.6300n -0.000265 175.6400n -0.000458
+ 175.6500n -0.000641 175.6600n -0.000812 175.6700n -0.000966 175.6800n -0.001103 175.6900n -0.001218 175.7000n -0.001310 175.7100n -0.001376 175.7200n -0.001414 175.7300n -0.001424 175.7400n -0.001404 175.7500n -0.001354 175.7600n -0.001274 175.7700n -0.001164 175.7800n -0.001025 175.7900n -0.000859
+ 175.8000n -0.000667 175.8100n -0.000454 175.8200n -0.000221 175.8300n 0.000028 175.8400n 0.000288 175.8500n 0.000556 175.8600n 0.000827 175.8700n 0.001096 175.8800n 0.001359 175.8900n 0.001610 175.9000n 0.001844 175.9100n 0.002057 175.9200n 0.002245 175.9300n 0.002404 175.9400n 0.002530
+ 175.9500n 0.002620 175.9600n 0.002672 175.9700n 0.002684 175.9800n 0.002654 175.9900n 0.002584 176.0000n 0.002472 176.0100n 0.002321 176.0200n 0.002132 176.0300n 0.001908 176.0400n 0.001652 176.0500n 0.001369 176.0600n 0.001063 176.0700n 0.000740 176.0800n 0.000404 176.0900n 0.000061
+ 176.1000n -0.000281 176.1100n -0.000618 176.1200n -0.000944 176.1300n -0.001252 176.1400n -0.001538 176.1500n -0.001796 176.1600n -0.002022 176.1700n -0.002212 176.1800n -0.002363 176.1900n -0.002472 176.2000n -0.002538 176.2100n -0.002561 176.2200n -0.002540 176.2300n -0.002478 176.2400n -0.002375
+ 176.2500n -0.002235 176.2600n -0.002061 176.2700n -0.001859 176.2800n -0.001633 176.2900n -0.001389 176.3000n -0.001132 176.3100n -0.000869 176.3200n -0.000607 176.3300n -0.000352 176.3400n -0.000110 176.3500n 0.000112 176.3600n 0.000310 176.3700n 0.000477 176.3800n 0.000610 176.3900n 0.000704
+ 176.4000n 0.000757 176.4100n 0.000766 176.4200n 0.000731 176.4300n 0.000652 176.4400n 0.000529 176.4500n 0.000364 176.4600n 0.000160 176.4700n -0.000078 176.4800n -0.000347 176.4900n -0.000641 176.5000n -0.000955 176.5100n -0.001281 176.5200n -0.001612 176.5300n -0.001943 176.5400n -0.002265
+ 176.5500n -0.002573 176.5600n -0.002857 176.5700n -0.003114 176.5800n -0.003336 176.5900n -0.003518 176.6000n -0.003655 176.6100n -0.003745 176.6200n -0.003785 176.6300n -0.003772 176.6400n -0.003706 176.6500n -0.003587 176.6600n -0.003417 176.6700n -0.003199 176.6800n -0.002935 176.6900n -0.002631
+ 176.7000n -0.002291 176.7100n -0.001922 176.7200n -0.001529 176.7300n -0.001121 176.7400n -0.000703 176.7500n -0.000284 176.7600n 0.000130 176.7700n 0.000531 176.7800n 0.000912 176.7900n 0.001266 176.8000n 0.001589 176.8100n 0.001875 176.8200n 0.002119 176.8300n 0.002318 176.8400n 0.002471
+ 176.8500n 0.002575 176.8600n 0.002630 176.8700n 0.002638 176.8800n 0.002599 176.8900n 0.002517 176.9000n 0.002396 176.9100n 0.002239 176.9200n 0.002052 176.9300n 0.001841 176.9400n 0.001612 176.9500n 0.001371 176.9600n 0.001126 176.9700n 0.000882 176.9800n 0.000647 176.9900n 0.000427
+ 177.0000n 0.000227 177.0100n 0.000052 177.0200n -0.000092 177.0300n -0.000203 177.0400n -0.000277 177.0500n -0.000313 177.0600n -0.000310 177.0700n -0.000267 177.0800n -0.000186 177.0900n -0.000070 177.1000n 0.000080 177.1100n 0.000258 177.1200n 0.000461 177.1300n 0.000683 177.1400n 0.000917
+ 177.1500n 0.001159 177.1600n 0.001401 177.1700n 0.001638 177.1800n 0.001861 177.1900n 0.002065 177.2000n 0.002245 177.2100n 0.002394 177.2200n 0.002508 177.2300n 0.002583 177.2400n 0.002615 177.2500n 0.002602 177.2600n 0.002544 177.2700n 0.002438 177.2800n 0.002287 177.2900n 0.002092
+ 177.3000n 0.001856 177.3100n 0.001582 177.3200n 0.001275 177.3300n 0.000941 177.3400n 0.000585 177.3500n 0.000213 177.3600n -0.000166 177.3700n -0.000546 177.3800n -0.000920 177.3900n -0.001280 177.4000n -0.001620 177.4100n -0.001932 177.4200n -0.002210 177.4300n -0.002448 177.4400n -0.002642
+ 177.4500n -0.002788 177.4600n -0.002882 177.4700n -0.002923 177.4800n -0.002908 177.4900n -0.002838 177.5000n -0.002714 177.5100n -0.002538 177.5200n -0.002312 177.5300n -0.002041 177.5400n -0.001728 177.5500n -0.001380 177.5600n -0.001002 177.5700n -0.000600 177.5800n -0.000182 177.5900n 0.000245
+ 177.6000n 0.000676 177.6100n 0.001102 177.6200n 0.001517 177.6300n 0.001914 177.6400n 0.002287 177.6500n 0.002632 177.6600n 0.002943 177.6700n 0.003216 177.6800n 0.003448 177.6900n 0.003636 177.7000n 0.003780 177.7100n 0.003879 177.7200n 0.003932 177.7300n 0.003941 177.7400n 0.003908
+ 177.7500n 0.003835 177.7600n 0.003726 177.7700n 0.003584 177.7800n 0.003414 177.7900n 0.003219 177.8000n 0.003006 177.8100n 0.002779 177.8200n 0.002542 177.8300n 0.002301 177.8400n 0.002061 177.8500n 0.001825 177.8600n 0.001597 177.8700n 0.001382 177.8800n 0.001181 177.8900n 0.000998
+ 177.9000n 0.000834 177.9100n 0.000691 177.9200n 0.000569 177.9300n 0.000468 177.9400n 0.000388 177.9500n 0.000327 177.9600n 0.000284 177.9700n 0.000258 177.9800n 0.000245 177.9900n 0.000244 178.0000n 0.000252 178.0100n 0.000266 178.0200n 0.000283 178.0300n 0.000301 178.0400n 0.000317
+ 178.0500n 0.000328 178.0600n 0.000333 178.0700n 0.000330 178.0800n 0.000318 178.0900n 0.000295 178.1000n 0.000261 178.1100n 0.000215 178.1200n 0.000158 178.1300n 0.000091 178.1400n 0.000014 178.1500n -0.000071 178.1600n -0.000163 178.1700n -0.000260 178.1800n -0.000360 178.1900n -0.000462
+ 178.2000n -0.000563 178.2100n -0.000661 178.2200n -0.000754 178.2300n -0.000842 178.2400n -0.000921 178.2500n -0.000992 178.2600n -0.001052 178.2700n -0.001102 178.2800n -0.001141 178.2900n -0.001169 178.3000n -0.001187 178.3100n -0.001194 178.3200n -0.001193 178.3300n -0.001185 178.3400n -0.001170
+ 178.3500n -0.001151 178.3600n -0.001129 178.3700n -0.001107 178.3800n -0.001085 178.3900n -0.001067 178.4000n -0.001053 178.4100n -0.001046 178.4200n -0.001045 178.4300n -0.001054 178.4400n -0.001072 178.4500n -0.001099 178.4600n -0.001136 178.4700n -0.001183 178.4800n -0.001238 178.4900n -0.001300
+ 178.5000n -0.001369 178.5100n -0.001443 178.5200n -0.001518 178.5300n -0.001594 178.5400n -0.001668 178.5500n -0.001738 178.5600n -0.001800 178.5700n -0.001853 178.5800n -0.001894 178.5900n -0.001921 178.6000n -0.001932 178.6100n -0.001926 178.6200n -0.001901 178.6300n -0.001857 178.6400n -0.001792
+ 178.6500n -0.001708 178.6600n -0.001604 178.6700n -0.001483 178.6800n -0.001344 178.6900n -0.001191 178.7000n -0.001026 178.7100n -0.000851 178.7200n -0.000670 178.7300n -0.000485 178.7400n -0.000302 178.7500n -0.000122 178.7600n 0.000050 178.7700n 0.000210 178.7800n 0.000356 178.7900n 0.000484
+ 178.8000n 0.000591 178.8100n 0.000675 178.8200n 0.000733 178.8300n 0.000765 178.8400n 0.000769 178.8500n 0.000746 178.8600n 0.000694 178.8700n 0.000616 178.8800n 0.000513 178.8900n 0.000387 178.9000n 0.000241 178.9100n 0.000077 178.9200n -0.000099 178.9300n -0.000285 178.9400n -0.000477
+ 178.9500n -0.000668 178.9600n -0.000856 178.9700n -0.001035 178.9800n -0.001201 178.9900n -0.001349 179.0000n -0.001477 179.0100n -0.001578 179.0200n -0.001652 179.0300n -0.001695 179.0400n -0.001705 179.0500n -0.001681 179.0600n -0.001623 179.0700n -0.001529 179.0800n -0.001402 179.0900n -0.001242
+ 179.1000n -0.001052 179.1100n -0.000834 179.1200n -0.000592 179.1300n -0.000330 179.1400n -0.000052 179.1500n 0.000237 179.1600n 0.000533 179.1700n 0.000830 179.1800n 0.001124 179.1900n 0.001409 179.2000n 0.001680 179.2100n 0.001934 179.2200n 0.002165 179.2300n 0.002370 179.2400n 0.002547
+ 179.2500n 0.002691 179.2600n 0.002802 179.2700n 0.002877 179.2800n 0.002917 179.2900n 0.002921 179.3000n 0.002891 179.3100n 0.002827 179.3200n 0.002732 179.3300n 0.002608 179.3400n 0.002459 179.3500n 0.002287 179.3600n 0.002098 179.3700n 0.001894 179.3800n 0.001681 179.3900n 0.001463
+ 179.4000n 0.001244 179.4100n 0.001028 179.4200n 0.000819 179.4300n 0.000621 179.4400n 0.000437 179.4500n 0.000270 179.4600n 0.000123 179.4700n -0.000004 179.4800n -0.000109 179.4900n -0.000190 179.5000n -0.000249 179.5100n -0.000285 179.5200n -0.000300 179.5300n -0.000296 179.5400n -0.000274
+ 179.5500n -0.000237 179.5600n -0.000187 179.5700n -0.000128 179.5800n -0.000062 179.5900n 0.000006 179.6000n 0.000075 179.6100n 0.000141 179.6200n 0.000202 179.6300n 0.000253 179.6400n 0.000294 179.6500n 0.000323 179.6600n 0.000338 179.6700n 0.000337 179.6800n 0.000321 179.6900n 0.000290
+ 179.7000n 0.000244 179.7100n 0.000184 179.7200n 0.000112 179.7300n 0.000029 179.7400n -0.000062 179.7500n -0.000159 179.7600n -0.000259 179.7700n -0.000358 179.7800n -0.000454 179.7900n -0.000544 179.8000n -0.000625 179.8100n -0.000694 179.8200n -0.000748 179.8300n -0.000784 179.8400n -0.000802
+ 179.8500n -0.000799 179.8600n -0.000774 179.8700n -0.000726 179.8800n -0.000656 179.8900n -0.000563 179.9000n -0.000449 179.9100n -0.000315 179.9200n -0.000163 179.9300n 0.000005 179.9400n 0.000187 179.9500n 0.000378 179.9600n 0.000578 179.9700n 0.000781 179.9800n 0.000984 179.9900n 0.001184
+ 180.0000n 0.001378 180.0100n 0.001562 180.0200n 0.001733 180.0300n 0.001889 180.0400n 0.002026 180.0500n 0.002143 180.0600n 0.002238 180.0700n 0.002309 180.0800n 0.002357 180.0900n 0.002381 180.1000n 0.002382 180.1100n 0.002359 180.1200n 0.002314 180.1300n 0.002250 180.1400n 0.002167
+ 180.1500n 0.002068 180.1600n 0.001957 180.1700n 0.001835 180.1800n 0.001705 180.1900n 0.001571 180.2000n 0.001436 180.2100n 0.001302 180.2200n 0.001172 180.2300n 0.001048 180.2400n 0.000934 180.2500n 0.000830 180.2600n 0.000738 180.2700n 0.000659 180.2800n 0.000594 180.2900n 0.000544
+ 180.3000n 0.000507 180.3100n 0.000484 180.3200n 0.000474 180.3300n 0.000474 180.3400n 0.000485 180.3500n 0.000503 180.3600n 0.000527 180.3700n 0.000554 180.3800n 0.000583 180.3900n 0.000610 180.4000n 0.000634 180.4100n 0.000653 180.4200n 0.000664 180.4300n 0.000666 180.4400n 0.000657
+ 180.4500n 0.000637 180.4600n 0.000604 180.4700n 0.000558 180.4800n 0.000500 180.4900n 0.000429 180.5000n 0.000346 180.5100n 0.000253 180.5200n 0.000151 180.5300n 0.000041 180.5400n -0.000074 180.5500n -0.000192 180.5600n -0.000311 180.5700n -0.000428 180.5800n -0.000541 180.5900n -0.000648
+ 180.6000n -0.000745 180.6100n -0.000832 180.6200n -0.000905 180.6300n -0.000964 180.6400n -0.001008 180.6500n -0.001034 180.6600n -0.001044 180.6700n -0.001035 180.6800n -0.001010 180.6900n -0.000968 180.7000n -0.000911 180.7100n -0.000840 180.7200n -0.000757 180.7300n -0.000663 180.7400n -0.000562
+ 180.7500n -0.000456 180.7600n -0.000347 180.7700n -0.000239 180.7800n -0.000133 180.7900n -0.000033 180.8000n 0.000060 180.8100n 0.000142 180.8200n 0.000212 180.8300n 0.000268 180.8400n 0.000308 180.8500n 0.000332 180.8600n 0.000340 180.8700n 0.000330 180.8800n 0.000304 180.8900n 0.000262
+ 180.9000n 0.000205 180.9100n 0.000135 180.9200n 0.000054 180.9300n -0.000036 180.9400n -0.000132 180.9500n -0.000233 180.9600n -0.000334 180.9700n -0.000433 180.9800n -0.000528 180.9900n -0.000615 181.0000n -0.000692 181.0100n -0.000756 181.0200n -0.000806 181.0300n -0.000839 181.0400n -0.000854
+ 181.0500n -0.000850 181.0600n -0.000828 181.0700n -0.000785 181.0800n -0.000724 181.0900n -0.000645 181.1000n -0.000548 181.1100n -0.000437 181.1200n -0.000313 181.1300n -0.000179 181.1400n -0.000037 181.1500n 0.000109 181.1600n 0.000256 181.1700n 0.000402 181.1800n 0.000542 181.1900n 0.000673
+ 181.2000n 0.000794 181.2100n 0.000899 181.2200n 0.000988 181.2300n 0.001058 181.2400n 0.001107 181.2500n 0.001133 181.2600n 0.001136 181.2700n 0.001116 181.2800n 0.001072 181.2900n 0.001006 181.3000n 0.000917 181.3100n 0.000809 181.3200n 0.000683 181.3300n 0.000541 181.3400n 0.000387
+ 181.3500n 0.000224 181.3600n 0.000055 181.3700n -0.000117 181.3800n -0.000287 181.3900n -0.000452 181.4000n -0.000609 181.4100n -0.000754 181.4200n -0.000884 181.4300n -0.000996 181.4400n -0.001088 181.4500n -0.001157 181.4600n -0.001202 181.4700n -0.001221 181.4800n -0.001215 181.4900n -0.001183
+ 181.5000n -0.001125 181.5100n -0.001042 181.5200n -0.000937 181.5300n -0.000810 181.5400n -0.000664 181.5500n -0.000503 181.5600n -0.000328 181.5700n -0.000144 181.5800n 0.000047 181.5900n 0.000240 181.6000n 0.000432 181.6100n 0.000619 181.6200n 0.000798 181.6300n 0.000965 181.6400n 0.001117
+ 181.6500n 0.001252 181.6600n 0.001367 181.6700n 0.001461 181.6800n 0.001530 181.6900n 0.001575 181.7000n 0.001595 181.7100n 0.001590 181.7200n 0.001559 181.7300n 0.001504 181.7400n 0.001426 181.7500n 0.001326 181.7600n 0.001207 181.7700n 0.001071 181.7800n 0.000919 181.7900n 0.000756
+ 181.8000n 0.000584 181.8100n 0.000405 181.8200n 0.000223 181.8300n 0.000041 181.8400n -0.000139 181.8500n -0.000314 181.8600n -0.000481 181.8700n -0.000639 181.8800n -0.000785 181.8900n -0.000917 181.9000n -0.001035 181.9100n -0.001138 181.9200n -0.001224 181.9300n -0.001294 181.9400n -0.001348
+ 181.9500n -0.001386 181.9600n -0.001409 181.9700n -0.001417 181.9800n -0.001413 181.9900n -0.001397 182.0000n -0.001370 182.0100n -0.001335 182.0200n -0.001293 182.0300n -0.001246 182.0400n -0.001195 182.0500n -0.001142 182.0600n -0.001089 182.0700n -0.001036 182.0800n -0.000985 182.0900n -0.000937
+ 182.1000n -0.000893 182.1100n -0.000854 182.1200n -0.000819 182.1300n -0.000790 182.1400n -0.000766 182.1500n -0.000748 182.1600n -0.000734 182.1700n -0.000724 182.1800n -0.000719 182.1900n -0.000717 182.2000n -0.000718 182.2100n -0.000721 182.2200n -0.000725 182.2300n -0.000730 182.2400n -0.000735
+ 182.2500n -0.000739 182.2600n -0.000743 182.2700n -0.000744 182.2800n -0.000744 182.2900n -0.000742 182.3000n -0.000737 182.3100n -0.000731 182.3200n -0.000722 182.3300n -0.000711 182.3400n -0.000699 182.3500n -0.000685 182.3600n -0.000671 182.3700n -0.000655 182.3800n -0.000640 182.3900n -0.000625
+ 182.4000n -0.000610 182.4100n -0.000596 182.4200n -0.000583 182.4300n -0.000571 182.4400n -0.000560 182.4500n -0.000550 182.4600n -0.000541 182.4700n -0.000533 182.4800n -0.000524 182.4900n -0.000516 182.5000n -0.000507 182.5100n -0.000497 182.5200n -0.000485 182.5300n -0.000470 182.5400n -0.000452
+ 182.5500n -0.000430 182.5600n -0.000404 182.5700n -0.000374 182.5800n -0.000338 182.5900n -0.000296 182.6000n -0.000249 182.6100n -0.000197 182.6200n -0.000140 182.6300n -0.000078 182.6400n -0.000011 182.6500n 0.000059 182.6600n 0.000131 182.6700n 0.000204 182.6800n 0.000278 182.6900n 0.000351
+ 182.7000n 0.000421 182.7100n 0.000487 182.7200n 0.000547 182.7300n 0.000600 182.7400n 0.000645 182.7500n 0.000680 182.7600n 0.000703 182.7700n 0.000715 182.7800n 0.000713 182.7900n 0.000697 182.8000n 0.000668 182.8100n 0.000623 182.8200n 0.000565 182.8300n 0.000493 182.8400n 0.000407
+ 182.8500n 0.000310 182.8600n 0.000201 182.8700n 0.000084 182.8800n -0.000041 182.8900n -0.000172 182.9000n -0.000306 182.9100n -0.000441 182.9200n -0.000574 182.9300n -0.000704 182.9400n -0.000827 182.9500n -0.000942 182.9600n -0.001046 182.9700n -0.001137 182.9800n -0.001213 182.9900n -0.001272
+ 183.0000n -0.001314 183.0100n -0.001338 183.0200n -0.001341 183.0300n -0.001325 183.0400n -0.001290 183.0500n -0.001235 183.0600n -0.001162 183.0700n -0.001072 183.0800n -0.000966 183.0900n -0.000847 183.1000n -0.000716 183.1100n -0.000577 183.1200n -0.000431 183.1300n -0.000281 183.1400n -0.000131
+ 183.1500n 0.000018 183.1600n 0.000161 183.1700n 0.000297 183.1800n 0.000422 183.1900n 0.000534 183.2000n 0.000632 183.2100n 0.000713 183.2200n 0.000775 183.2300n 0.000818 183.2400n 0.000841 183.2500n 0.000843 183.2600n 0.000824 183.2700n 0.000785 183.2800n 0.000727 183.2900n 0.000650
+ 183.3000n 0.000557 183.3100n 0.000450 183.3200n 0.000330 183.3300n 0.000200 183.3400n 0.000062 183.3500n -0.000080 183.3600n -0.000223 183.3700n -0.000366 183.3800n -0.000505 183.3900n -0.000637 183.4000n -0.000760 183.4100n -0.000872 183.4200n -0.000970 183.4300n -0.001052 183.4400n -0.001118
+ 183.4500n -0.001166 183.4600n -0.001195 183.4700n -0.001205 183.4800n -0.001196 183.4900n -0.001168 183.5000n -0.001122 183.5100n -0.001060 183.5200n -0.000981 183.5300n -0.000889 183.5400n -0.000784 183.5500n -0.000669 183.5600n -0.000547 183.5700n -0.000418 183.5800n -0.000286 183.5900n -0.000152
+ 183.6000n -0.000020 183.6100n 0.000110 183.6200n 0.000235 183.6300n 0.000354 183.6400n 0.000465 183.6500n 0.000568 183.6600n 0.000660 183.6700n 0.000742 183.6800n 0.000814 183.6900n 0.000875 183.7000n 0.000926 183.7100n 0.000967 183.7200n 0.000999 183.7300n 0.001024 183.7400n 0.001042
+ 183.7500n 0.001054 183.7600n 0.001062 183.7700n 0.001069 183.7800n 0.001074 183.7900n 0.001079 183.8000n 0.001086 183.8100n 0.001097 183.8200n 0.001111 183.8300n 0.001129 183.8400n 0.001153 183.8500n 0.001183 183.8600n 0.001218 183.8700n 0.001258 183.8800n 0.001303 183.8900n 0.001352
+ 183.9000n 0.001404 183.9100n 0.001457 183.9200n 0.001510 183.9300n 0.001561 183.9400n 0.001608 183.9500n 0.001649 183.9600n 0.001682 183.9700n 0.001705 183.9800n 0.001716 183.9900n 0.001714 184.0000n 0.001695 184.0100n 0.001660 184.0200n 0.001606 184.0300n 0.001534 184.0400n 0.001441
+ 184.0500n 0.001327 184.0600n 0.001194 184.0700n 0.001041 184.0800n 0.000870 184.0900n 0.000681 184.1000n 0.000476 184.1100n 0.000258 184.1200n 0.000029 184.1300n -0.000208 184.1400n -0.000451 184.1500n -0.000695 184.1600n -0.000938 184.1700n -0.001176 184.1800n -0.001405 184.1900n -0.001622
+ 184.2000n -0.001824 184.2100n -0.002006 184.2200n -0.002165 184.2300n -0.002300 184.2400n -0.002407 184.2500n -0.002483 184.2600n -0.002528 184.2700n -0.002540 184.2800n -0.002517 184.2900n -0.002461 184.3000n -0.002370 184.3100n -0.002246 184.3200n -0.002090 184.3300n -0.001904 184.3400n -0.001690
+ 184.3500n -0.001450 184.3600n -0.001189 184.3700n -0.000909 184.3800n -0.000615 184.3900n -0.000310 184.4000n 0.000001 184.4100n 0.000314 184.4200n 0.000623 184.4300n 0.000925 184.4400n 0.001215 184.4500n 0.001489 184.4600n 0.001742 184.4700n 0.001971 184.4800n 0.002173 184.4900n 0.002343
+ 184.5000n 0.002481 184.5100n 0.002583 184.5200n 0.002648 184.5300n 0.002674 184.5400n 0.002662 184.5500n 0.002611 184.5600n 0.002523 184.5700n 0.002397 184.5800n 0.002236 184.5900n 0.002041 184.6000n 0.001817 184.6100n 0.001565 184.6200n 0.001289 184.6300n 0.000994 184.6400n 0.000682
+ 184.6500n 0.000359 184.6600n 0.000028 184.6700n -0.000306 184.6800n -0.000638 184.6900n -0.000964 184.7000n -0.001280 184.7100n -0.001581 184.7200n -0.001864 184.7300n -0.002126 184.7400n -0.002362 184.7500n -0.002571 184.7600n -0.002750 184.7700n -0.002897 184.7800n -0.003011 184.7900n -0.003091
+ 184.8000n -0.003136 184.8100n -0.003146 184.8200n -0.003123 184.8300n -0.003067 184.8400n -0.002981 184.8500n -0.002865 184.8600n -0.002722 184.8700n -0.002555 184.8800n -0.002368 184.8900n -0.002163 184.9000n -0.001944 184.9100n -0.001714 184.9200n -0.001477 184.9300n -0.001238 184.9400n -0.000998
+ 184.9500n -0.000763 184.9600n -0.000535 184.9700n -0.000318 184.9800n -0.000114 184.9900n 0.000073 185.0000n 0.000242 185.0100n 0.000391 185.0200n 0.000518 185.0300n 0.000622 185.0400n 0.000703 185.0500n 0.000760 185.0600n 0.000793 185.0700n 0.000803 185.0800n 0.000791 185.0900n 0.000759
+ 185.1000n 0.000708 185.1100n 0.000640 185.1200n 0.000557 185.1300n 0.000462 185.1400n 0.000358 185.1500n 0.000247 185.1600n 0.000132 185.1700n 0.000016 185.1800n -0.000098 185.1900n -0.000207 185.2000n -0.000310 185.2100n -0.000403 185.2200n -0.000485 185.2300n -0.000554 185.2400n -0.000608
+ 185.2500n -0.000647 185.2600n -0.000669 185.2700n -0.000674 185.2800n -0.000662 185.2900n -0.000634 185.3000n -0.000589 185.3100n -0.000530 185.3200n -0.000457 185.3300n -0.000372 185.3400n -0.000277 185.3500n -0.000174 185.3600n -0.000066 185.3700n 0.000046 185.3800n 0.000159 185.3900n 0.000271
+ 185.4000n 0.000379 185.4100n 0.000481 185.4200n 0.000575 185.4300n 0.000659 185.4400n 0.000732 185.4500n 0.000793 185.4600n 0.000839 185.4700n 0.000872 185.4800n 0.000890 185.4900n 0.000893 185.5000n 0.000882 185.5100n 0.000859 185.5200n 0.000823 185.5300n 0.000776 185.5400n 0.000721
+ 185.5500n 0.000659 185.5600n 0.000593 185.5700n 0.000525 185.5800n 0.000457 185.5900n 0.000392 185.6000n 0.000332 185.6100n 0.000281 185.6200n 0.000240 185.6300n 0.000211 185.6400n 0.000196 185.6500n 0.000197 185.6600n 0.000215 185.6700n 0.000251 185.6800n 0.000306 185.6900n 0.000378
+ 185.7000n 0.000469 185.7100n 0.000576 185.7200n 0.000699 185.7300n 0.000835 185.7400n 0.000983 185.7500n 0.001141 185.7600n 0.001304 185.7700n 0.001471 185.7800n 0.001638 185.7900n 0.001800 185.8000n 0.001956 185.8100n 0.002101 185.8200n 0.002232 185.8300n 0.002345 185.8400n 0.002438
+ 185.8500n 0.002507 185.8600n 0.002551 185.8700n 0.002567 185.8800n 0.002553 185.8900n 0.002510 185.9000n 0.002435 185.9100n 0.002330 185.9200n 0.002195 185.9300n 0.002031 185.9400n 0.001840 185.9500n 0.001624 185.9600n 0.001387 185.9700n 0.001131 185.9800n 0.000861 185.9900n 0.000580
+ 186.0000n 0.000293 186.0100n 0.000005 186.0200n -0.000281 186.0300n -0.000558 186.0400n -0.000823 186.0500n -0.001071 186.0600n -0.001298 186.0700n -0.001500 186.0800n -0.001673 186.0900n -0.001814 186.1000n -0.001921 186.1100n -0.001991 186.1200n -0.002024 186.1300n -0.002018 186.1400n -0.001974
+ 186.1500n -0.001892 186.1600n -0.001774 186.1700n -0.001621 186.1800n -0.001436 186.1900n -0.001222 186.2000n -0.000983 186.2100n -0.000722 186.2200n -0.000445 186.2300n -0.000155 186.2400n 0.000142 186.2500n 0.000442 186.2600n 0.000739 186.2700n 0.001029 186.2800n 0.001306 186.2900n 0.001567
+ 186.3000n 0.001807 186.3100n 0.002023 186.3200n 0.002211 186.3300n 0.002369 186.3400n 0.002493 186.3500n 0.002584 186.3600n 0.002640 186.3700n 0.002660 186.3800n 0.002646 186.3900n 0.002597 186.4000n 0.002516 186.4100n 0.002404 186.4200n 0.002265 186.4300n 0.002101 186.4400n 0.001916
+ 186.4500n 0.001712 186.4600n 0.001496 186.4700n 0.001269 186.4800n 0.001037 186.4900n 0.000803 186.5000n 0.000572 186.5100n 0.000347 186.5200n 0.000132 186.5300n -0.000070 186.5400n -0.000256 186.5500n -0.000424 186.5600n -0.000571 186.5700n -0.000696 186.5800n -0.000798 186.5900n -0.000877
+ 186.6000n -0.000932 186.6100n -0.000964 186.6200n -0.000973 186.6300n -0.000961 186.6400n -0.000930 186.6500n -0.000882 186.6600n -0.000819 186.6700n -0.000743 186.6800n -0.000658 186.6900n -0.000565 186.7000n -0.000468 186.7100n -0.000370 186.7200n -0.000273 186.7300n -0.000179 186.7400n -0.000092
+ 186.7500n -0.000013 186.7600n 0.000057 186.7700n 0.000114 186.7800n 0.000160 186.7900n 0.000191 186.8000n 0.000209 186.8100n 0.000213 186.8200n 0.000202 186.8300n 0.000179 186.8400n 0.000142 186.8500n 0.000095 186.8600n 0.000037 186.8700n -0.000030 186.8800n -0.000104 186.8900n -0.000183
+ 186.9000n -0.000265 186.9100n -0.000349 186.9200n -0.000434 186.9300n -0.000516 186.9400n -0.000595 186.9500n -0.000669 186.9600n -0.000737 186.9700n -0.000797 186.9800n -0.000849 186.9900n -0.000892 187.0000n -0.000926 187.0100n -0.000950 187.0200n -0.000964 187.0300n -0.000968 187.0400n -0.000963
+ 187.0500n -0.000949 187.0600n -0.000926 187.0700n -0.000896 187.0800n -0.000859 187.0900n -0.000815 187.1000n -0.000766 187.1100n -0.000713 187.1200n -0.000656 187.1300n -0.000597 187.1400n -0.000535 187.1500n -0.000471 187.1600n -0.000407 187.1700n -0.000342 187.1800n -0.000277 187.1900n -0.000211
+ 187.2000n -0.000146 187.2100n -0.000080 187.2200n -0.000014 187.2300n 0.000052 187.2400n 0.000119 187.2500n 0.000186 187.2600n 0.000255 187.2700n 0.000325 187.2800n 0.000396 187.2900n 0.000469 187.3000n 0.000544 187.3100n 0.000620 187.3200n 0.000698 187.3300n 0.000777 187.3400n 0.000857
+ 187.3500n 0.000937 187.3600n 0.001018 187.3700n 0.001097 187.3800n 0.001175 187.3900n 0.001251 187.4000n 0.001323 187.4100n 0.001391 187.4200n 0.001454 187.4300n 0.001510 187.4400n 0.001560 187.4500n 0.001601 187.4600n 0.001634 187.4700n 0.001657 187.4800n 0.001671 187.4900n 0.001675
+ 187.5000n 0.001669 187.5100n 0.001653 187.5200n 0.001627 187.5300n 0.001592 187.5400n 0.001548 187.5500n 0.001496 187.5600n 0.001438 187.5700n 0.001375 187.5800n 0.001308 187.5900n 0.001238 187.6000n 0.001167 187.6100n 0.001096 187.6200n 0.001028 187.6300n 0.000963 187.6400n 0.000904
+ 187.6500n 0.000850 187.6600n 0.000805 187.6700n 0.000768 187.6800n 0.000740 187.6900n 0.000723 187.7000n 0.000715 187.7100n 0.000718 187.7200n 0.000731 187.7300n 0.000753 187.7400n 0.000784 187.7500n 0.000822 187.7600n 0.000867 187.7700n 0.000916 187.7800n 0.000968 187.7900n 0.001022
+ 187.8000n 0.001074 187.8100n 0.001124 187.8200n 0.001168 187.8300n 0.001206 187.8400n 0.001235 187.8500n 0.001254 187.8600n 0.001261 187.8700n 0.001255 187.8800n 0.001234 187.8900n 0.001199 187.9000n 0.001148 187.9100n 0.001082 187.9200n 0.001001 187.9300n 0.000906 187.9400n 0.000798
+ 187.9500n 0.000678 187.9600n 0.000548 187.9700n 0.000411 187.9800n 0.000267 187.9900n 0.000121 188.0000n -0.000026 188.0100n -0.000171 188.0200n -0.000311 188.0300n -0.000442 188.0400n -0.000563 188.0500n -0.000671 188.0600n -0.000763 188.0700n -0.000838 188.0800n -0.000893 188.0900n -0.000927
+ 188.1000n -0.000939 188.1100n -0.000929 188.1200n -0.000895 188.1300n -0.000839 188.1400n -0.000761 188.1500n -0.000662 188.1600n -0.000544 188.1700n -0.000408 188.1800n -0.000257 188.1900n -0.000093 188.2000n 0.000081 188.2100n 0.000261 188.2200n 0.000445 188.2300n 0.000629 188.2400n 0.000811
+ 188.2500n 0.000986 188.2600n 0.001153 188.2700n 0.001307 188.2800n 0.001448 188.2900n 0.001571 188.3000n 0.001676 188.3100n 0.001761 188.3200n 0.001825 188.3300n 0.001867 188.3400n 0.001887 188.3500n 0.001886 188.3600n 0.001864 188.3700n 0.001822 188.3800n 0.001761 188.3900n 0.001684
+ 188.4000n 0.001594 188.4100n 0.001491 188.4200n 0.001379 188.4300n 0.001261 188.4400n 0.001139 188.4500n 0.001017 188.4600n 0.000896 188.4700n 0.000779 188.4800n 0.000669 188.4900n 0.000568 188.5000n 0.000478 188.5100n 0.000399 188.5200n 0.000333 188.5300n 0.000280 188.5400n 0.000241
+ 188.5500n 0.000215 188.5600n 0.000201 188.5700n 0.000199 188.5800n 0.000206 188.5900n 0.000222 188.6000n 0.000243 188.6100n 0.000269 188.6200n 0.000295 188.6300n 0.000320 188.6400n 0.000340 188.6500n 0.000354 188.6600n 0.000359 188.6700n 0.000352 188.6800n 0.000332 188.6900n 0.000296
+ 188.7000n 0.000244 188.7100n 0.000174 188.7200n 0.000085 188.7300n -0.000022 188.7400n -0.000147 188.7500n -0.000290 188.7600n -0.000448 188.7700n -0.000621 188.7800n -0.000806 188.7900n -0.001000 188.8000n -0.001202 188.8100n -0.001406 188.8200n -0.001611 188.8300n -0.001813 188.8400n -0.002008
+ 188.8500n -0.002193 188.8600n -0.002364 188.8700n -0.002518 188.8800n -0.002652 188.8900n -0.002764 188.9000n -0.002850 188.9100n -0.002910 188.9200n -0.002941 188.9300n -0.002944 188.9400n -0.002917 188.9500n -0.002860 188.9600n -0.002776 188.9700n -0.002664 188.9800n -0.002526 188.9900n -0.002366
+ 189.0000n -0.002185 189.0100n -0.001987 189.0200n -0.001776 189.0300n -0.001554 189.0400n -0.001326 189.0500n -0.001096 189.0600n -0.000868 189.0700n -0.000646 189.0800n -0.000433 189.0900n -0.000233 189.1000n -0.000050 189.1100n 0.000114 189.1200n 0.000256 189.1300n 0.000374 189.1400n 0.000467
+ 189.1500n 0.000533 189.1600n 0.000573 189.1700n 0.000585 189.1800n 0.000571 189.1900n 0.000532 189.2000n 0.000470 189.2100n 0.000387 189.2200n 0.000284 189.2300n 0.000166 189.2400n 0.000034 189.2500n -0.000106 189.2600n -0.000253 189.2700n -0.000402 189.2800n -0.000550 189.2900n -0.000694
+ 189.3000n -0.000829 189.3100n -0.000953 189.3200n -0.001064 189.3300n -0.001158 189.3400n -0.001233 189.3500n -0.001288 189.3600n -0.001322 189.3700n -0.001333 189.3800n -0.001321 189.3900n -0.001287 189.4000n -0.001231 189.4100n -0.001153 189.4200n -0.001056 189.4300n -0.000942 189.4400n -0.000811
+ 189.4500n -0.000667 189.4600n -0.000512 189.4700n -0.000349 189.4800n -0.000180 189.4900n -0.000009 189.5000n 0.000161 189.5100n 0.000329 189.5200n 0.000491 189.5300n 0.000644 189.5400n 0.000788 189.5500n 0.000918 189.5600n 0.001035 189.5700n 0.001136 189.5800n 0.001220 189.5900n 0.001287
+ 189.6000n 0.001335 189.6100n 0.001366 189.6200n 0.001378 189.6300n 0.001372 189.6400n 0.001349 189.6500n 0.001310 189.6600n 0.001255 189.6700n 0.001186 189.6800n 0.001104 189.6900n 0.001010 189.7000n 0.000906 189.7100n 0.000792 189.7200n 0.000671 189.7300n 0.000543 189.7400n 0.000410
+ 189.7500n 0.000273 189.7600n 0.000132 189.7700n -0.000010 189.7800n -0.000154 189.7900n -0.000299 189.8000n -0.000444 189.8100n -0.000588 189.8200n -0.000731 189.8300n -0.000873 189.8400n -0.001012 189.8500n -0.001149 189.8600n -0.001283 189.8700n -0.001413 189.8800n -0.001539 189.8900n -0.001661
+ 189.9000n -0.001777 189.9100n -0.001887 189.9200n -0.001989 189.9300n -0.002084 189.9400n -0.002168 189.9500n -0.002243 189.9600n -0.002306 189.9700n -0.002355 189.9800n -0.002391 189.9900n -0.002411 190.0000n -0.002414 190.0100n -0.002400 190.0200n -0.002367 190.0300n -0.002314 190.0400n -0.002242
+ 190.0500n -0.002149 190.0600n -0.002037 190.0700n -0.001904 190.0800n -0.001752 190.0900n -0.001581 190.1000n -0.001393 190.1100n -0.001189 190.1200n -0.000972 190.1300n -0.000744 190.1400n -0.000506 190.1500n -0.000263 190.1600n -0.000017 190.1700n 0.000229 190.1800n 0.000472 190.1900n 0.000707
+ 190.2000n 0.000932 190.2100n 0.001142 190.2200n 0.001336 190.2300n 0.001509 190.2400n 0.001659 190.2500n 0.001783 190.2600n 0.001880 190.2700n 0.001947 190.2800n 0.001984 190.2900n 0.001990 190.3000n 0.001964 190.3100n 0.001907 190.3200n 0.001819 190.3300n 0.001703 190.3400n 0.001561
+ 190.3500n 0.001394 190.3600n 0.001206 190.3700n 0.001000 190.3800n 0.000781 190.3900n 0.000551 190.4000n 0.000316 190.4100n 0.000080 190.4200n -0.000153 190.4300n -0.000379 190.4400n -0.000592 190.4500n -0.000790 190.4600n -0.000968 190.4700n -0.001122 190.4800n -0.001251 190.4900n -0.001350
+ 190.5000n -0.001420 190.5100n -0.001457 190.5200n -0.001462 190.5300n -0.001434 190.5400n -0.001374 190.5500n -0.001283 190.5600n -0.001163 190.5700n -0.001017 190.5800n -0.000847 190.5900n -0.000657 190.6000n -0.000451 190.6100n -0.000233 190.6200n -0.000007 190.6300n 0.000222 190.6400n 0.000449
+ 190.6500n 0.000670 190.6600n 0.000881 190.6700n 0.001077 190.6800n 0.001254 190.6900n 0.001408 190.7000n 0.001537 190.7100n 0.001638 190.7200n 0.001709 190.7300n 0.001748 190.7400n 0.001755 190.7500n 0.001729 190.7600n 0.001671 190.7700n 0.001583 190.7800n 0.001465 190.7900n 0.001321
+ 190.8000n 0.001153 190.8100n 0.000965 190.8200n 0.000759 190.8300n 0.000541 190.8400n 0.000314 190.8500n 0.000083 190.8600n -0.000149 190.8700n -0.000375 190.8800n -0.000593 190.8900n -0.000799 190.9000n -0.000988 190.9100n -0.001157 190.9200n -0.001304 190.9300n -0.001426 190.9400n -0.001521
+ 190.9500n -0.001588 190.9600n -0.001627 190.9700n -0.001637 190.9800n -0.001618 190.9900n -0.001572 191.0000n -0.001501 191.0100n -0.001406 191.0200n -0.001290 191.0300n -0.001156 191.0400n -0.001007 191.0500n -0.000848 191.0600n -0.000680 191.0700n -0.000509 191.0800n -0.000338 191.0900n -0.000170
+ 191.1000n -0.000010 191.1100n 0.000140 191.1200n 0.000275 191.1300n 0.000395 191.1400n 0.000495 191.1500n 0.000575 191.1600n 0.000633 191.1700n 0.000667 191.1800n 0.000678 191.1900n 0.000665 191.2000n 0.000629 191.2100n 0.000571 191.2200n 0.000493 191.2300n 0.000395 191.2400n 0.000280
+ 191.2500n 0.000151 191.2600n 0.000010 191.2700n -0.000140 191.2800n -0.000296 191.2900n -0.000455 191.3000n -0.000615 191.3100n -0.000771 191.3200n -0.000923 191.3300n -0.001066 191.3400n -0.001199 191.3500n -0.001319 191.3600n -0.001426 191.3700n -0.001517 191.3800n -0.001591 191.3900n -0.001648
+ 191.4000n -0.001687 191.4100n -0.001708 191.4200n -0.001712 191.4300n -0.001699 191.4400n -0.001670 191.4500n -0.001627 191.4600n -0.001569 191.4700n -0.001500 191.4800n -0.001420 191.4900n -0.001332 191.5000n -0.001237 191.5100n -0.001138 191.5200n -0.001035 191.5300n -0.000930 191.5400n -0.000826
+ 191.5500n -0.000723 191.5600n -0.000624 191.5700n -0.000528 191.5800n -0.000438 191.5900n -0.000353 191.6000n -0.000275 191.6100n -0.000204 191.6200n -0.000141 191.6300n -0.000085 191.6400n -0.000036 191.6500n 0.000005 191.6600n 0.000039 191.6700n 0.000067 191.6800n 0.000088 191.6900n 0.000102
+ 191.7000n 0.000112 191.7100n 0.000115 191.7200n 0.000114 191.7300n 0.000108 191.7400n 0.000098 191.7500n 0.000083 191.7600n 0.000063 191.7700n 0.000040 191.7800n 0.000012 191.7900n -0.000021 191.8000n -0.000058 191.8100n -0.000100 191.8200n -0.000148 191.8300n -0.000200 191.8400n -0.000259
+ 191.8500n -0.000323 191.8600n -0.000393 191.8700n -0.000469 191.8800n -0.000550 191.8900n -0.000638 191.9000n -0.000730 191.9100n -0.000827 191.9200n -0.000929 191.9300n -0.001034 191.9400n -0.001142 191.9500n -0.001251 191.9600n -0.001360 191.9700n -0.001469 191.9800n -0.001575 191.9900n -0.001678
+ 192.0000n -0.001776 192.0100n -0.001867 192.0200n -0.001950 192.0300n -0.002024 192.0400n -0.002088 192.0500n -0.002140 192.0600n -0.002179 192.0700n -0.002205 192.0800n -0.002218 192.0900n -0.002215 192.1000n -0.002199 192.1100n -0.002168 192.1200n -0.002123 192.1300n -0.002065 192.1400n -0.001995
+ 192.1500n -0.001914 192.1600n -0.001823 192.1700n -0.001724 192.1800n -0.001619 192.1900n -0.001509 192.2000n -0.001396 192.2100n -0.001284 192.2200n -0.001173 192.2300n -0.001066 192.2400n -0.000965 192.2500n -0.000871 192.2600n -0.000787 192.2700n -0.000715 192.2800n -0.000655 192.2900n -0.000609
+ 192.3000n -0.000577 192.3100n -0.000560 192.3200n -0.000559 192.3300n -0.000573 192.3400n -0.000601 192.3500n -0.000644 192.3600n -0.000700 192.3700n -0.000768 192.3800n -0.000846 192.3900n -0.000933 192.4000n -0.001026 192.4100n -0.001123 192.4200n -0.001221 192.4300n -0.001320 192.4400n -0.001415
+ 192.4500n -0.001505 192.4600n -0.001588 192.4700n -0.001660 192.4800n -0.001720 192.4900n -0.001767 192.5000n -0.001797 192.5100n -0.001811 192.5200n -0.001806 192.5300n -0.001782 192.5400n -0.001738 192.5500n -0.001674 192.5600n -0.001590 192.5700n -0.001487 192.5800n -0.001365 192.5900n -0.001225
+ 192.6000n -0.001069 192.6100n -0.000897 192.6200n -0.000713 192.6300n -0.000517 192.6400n -0.000312 192.6500n -0.000101 192.6600n 0.000116 192.6700n 0.000334 192.6800n 0.000551 192.6900n 0.000766 192.7000n 0.000976 192.7100n 0.001178 192.7200n 0.001371 192.7300n 0.001552 192.7400n 0.001720
+ 192.7500n 0.001872 192.7600n 0.002008 192.7700n 0.002127 192.7800n 0.002226 192.7900n 0.002306 192.8000n 0.002365 192.8100n 0.002404 192.8200n 0.002423 192.8300n 0.002421 192.8400n 0.002398 192.8500n 0.002356 192.8600n 0.002295 192.8700n 0.002215 192.8800n 0.002118 192.8900n 0.002005
+ 192.9000n 0.001878 192.9100n 0.001737 192.9200n 0.001584 192.9300n 0.001421 192.9400n 0.001250 192.9500n 0.001072 192.9600n 0.000889 192.9700n 0.000703 192.9800n 0.000516 192.9900n 0.000329 193.0000n 0.000146 193.0100n -0.000033 193.0200n -0.000206 193.0300n -0.000370 193.0400n -0.000524
+ 193.0500n -0.000667 193.0600n -0.000796 193.0700n -0.000909 193.0800n -0.001007 193.0900n -0.001087 193.1000n -0.001148 193.1100n -0.001190 193.1200n -0.001211 193.1300n -0.001212 193.1400n -0.001192 193.1500n -0.001151 193.1600n -0.001090 193.1700n -0.001008 193.1800n -0.000908 193.1900n -0.000790
+ 193.2000n -0.000656 193.2100n -0.000508 193.2200n -0.000346 193.2300n -0.000175 193.2400n 0.000004 193.2500n 0.000188 193.2600n 0.000374 193.2700n 0.000560 193.2800n 0.000741 193.2900n 0.000915 193.3000n 0.001080 193.3100n 0.001231 193.3200n 0.001367 193.3300n 0.001484 193.3400n 0.001580
+ 193.3500n 0.001654 193.3600n 0.001702 193.3700n 0.001724 193.3800n 0.001719 193.3900n 0.001686 193.4000n 0.001626 193.4100n 0.001538 193.4200n 0.001424 193.4300n 0.001285 193.4400n 0.001124 193.4500n 0.000942 193.4600n 0.000743 193.4700n 0.000530 193.4800n 0.000307 193.4900n 0.000077
+ 193.5000n -0.000154 193.5100n -0.000383 193.5200n -0.000605 193.5300n -0.000816 193.5400n -0.001011 193.5500n -0.001187 193.5600n -0.001338 193.5700n -0.001462 193.5800n -0.001556 193.5900n -0.001617 193.6000n -0.001642 193.6100n -0.001631 193.6200n -0.001582 193.6300n -0.001495 193.6400n -0.001372
+ 193.6500n -0.001212 193.6600n -0.001020 193.6700n -0.000796 193.6800n -0.000544 193.6900n -0.000269 193.7000n 0.000026 193.7100n 0.000334 193.7200n 0.000652 193.7300n 0.000973 193.7400n 0.001291 193.7500n 0.001601 193.7600n 0.001897 193.7700n 0.002173 193.7800n 0.002424 193.7900n 0.002645
+ 193.8000n 0.002832 193.8100n 0.002979 193.8200n 0.003085 193.8300n 0.003145 193.8400n 0.003160 193.8500n 0.003127 193.8600n 0.003047 193.8700n 0.002919 193.8800n 0.002747 193.8900n 0.002532 193.9000n 0.002277 193.9100n 0.001988 193.9200n 0.001667 193.9300n 0.001321 193.9400n 0.000956
+ 193.9500n 0.000577 193.9600n 0.000191 193.9700n -0.000194 193.9800n -0.000573 193.9900n -0.000939 194.0000n -0.001285 194.0100n -0.001605 194.0200n -0.001893 194.0300n -0.002145 194.0400n -0.002356 194.0500n -0.002521 194.0600n -0.002639 194.0700n -0.002707 194.0800n -0.002723 194.0900n -0.002689
+ 194.1000n -0.002603 194.1100n -0.002468 194.1200n -0.002286 194.1300n -0.002060 194.1400n -0.001795 194.1500n -0.001494 194.1600n -0.001164 194.1700n -0.000810 194.1800n -0.000438 194.1900n -0.000054 194.2000n 0.000334 194.2100n 0.000721 194.2200n 0.001100 194.2300n 0.001465 194.2400n 0.001809
+ 194.2500n 0.002127 194.2600n 0.002414 194.2700n 0.002666 194.2800n 0.002879 194.2900n 0.003050 194.3000n 0.003176 194.3100n 0.003257 194.3200n 0.003292 194.3300n 0.003280 194.3400n 0.003223 194.3500n 0.003122 194.3600n 0.002980 194.3700n 0.002799 194.3800n 0.002584 194.3900n 0.002338
+ 194.4000n 0.002065 194.4100n 0.001771 194.4200n 0.001460 194.4300n 0.001137 194.4400n 0.000807 194.4500n 0.000475 194.4600n 0.000145 194.4700n -0.000177 194.4800n -0.000487 194.4900n -0.000783 194.5000n -0.001059 194.5100n -0.001315 194.5200n -0.001546 194.5300n -0.001751 194.5400n -0.001929
+ 194.5500n -0.002079 194.5600n -0.002200 194.5700n -0.002293 194.5800n -0.002357 194.5900n -0.002395 194.6000n -0.002406 194.6100n -0.002394 194.6200n -0.002358 194.6300n -0.002302 194.6400n -0.002226 194.6500n -0.002134 194.6600n -0.002028 194.6700n -0.001908 194.6800n -0.001778 194.6900n -0.001639
+ 194.7000n -0.001492 194.7100n -0.001339 194.7200n -0.001182 194.7300n -0.001022 194.7400n -0.000859 194.7500n -0.000694 194.7600n -0.000528 194.7700n -0.000360 194.7800n -0.000193 194.7900n -0.000025 194.8000n 0.000143 194.8100n 0.000311 194.8200n 0.000480 194.8300n 0.000647 194.8400n 0.000815
+ 194.8500n 0.000981 194.8600n 0.001146 194.8700n 0.001309 194.8800n 0.001469 194.8900n 0.001626 194.9000n 0.001778 194.9100n 0.001924 194.9200n 0.002063 194.9300n 0.002193 194.9400n 0.002314 194.9500n 0.002423 194.9600n 0.002519 194.9700n 0.002600 194.9800n 0.002666 194.9900n 0.002715
+ 195.0000n 0.002747 195.0100n 0.002759 195.0200n 0.002753 195.0300n 0.002727 195.0400n 0.002682 195.0500n 0.002618 195.0600n 0.002536 195.0700n 0.002437 195.0800n 0.002323 195.0900n 0.002195 195.1000n 0.002056 195.1100n 0.001908 195.1200n 0.001753 195.1300n 0.001596 195.1400n 0.001438
+ 195.1500n 0.001283 195.1600n 0.001133 195.1700n 0.000993 195.1800n 0.000865 195.1900n 0.000751 195.2000n 0.000654 195.2100n 0.000577 195.2200n 0.000520 195.2300n 0.000487 195.2400n 0.000476 195.2500n 0.000490 195.2600n 0.000527 195.2700n 0.000587 195.2800n 0.000669 195.2900n 0.000771
+ 195.3000n 0.000891 195.3100n 0.001026 195.3200n 0.001173 195.3300n 0.001329 195.3400n 0.001490 195.3500n 0.001651 195.3600n 0.001809 195.3700n 0.001960 195.3800n 0.002099 195.3900n 0.002222 195.4000n 0.002326 195.4100n 0.002407 195.4200n 0.002461 195.4300n 0.002487 195.4400n 0.002482
+ 195.4500n 0.002444 195.4600n 0.002373 195.4700n 0.002268 195.4800n 0.002129 195.4900n 0.001957 195.5000n 0.001755 195.5100n 0.001524 195.5200n 0.001267 195.5300n 0.000988 195.5400n 0.000691 195.5500n 0.000379 195.5600n 0.000059 195.5700n -0.000266 195.5800n -0.000590 195.5900n -0.000908
+ 195.6000n -0.001215 195.6100n -0.001505 195.6200n -0.001775 195.6300n -0.002019 195.6400n -0.002234 195.6500n -0.002416 195.6600n -0.002562 195.6700n -0.002671 195.6800n -0.002739 195.6900n -0.002767 195.7000n -0.002753 195.7100n -0.002699 195.7200n -0.002605 195.7300n -0.002474 195.7400n -0.002307
+ 195.7500n -0.002109 195.7600n -0.001881 195.7700n -0.001629 195.7800n -0.001356 195.7900n -0.001067 195.8000n -0.000767 195.8100n -0.000461 195.8200n -0.000154 195.8300n 0.000150 195.8400n 0.000446 195.8500n 0.000730 195.8600n 0.000997 195.8700n 0.001244 195.8800n 0.001468 195.8900n 0.001666
+ 195.9000n 0.001836 195.9100n 0.001977 195.9200n 0.002088 195.9300n 0.002168 195.9400n 0.002217 195.9500n 0.002237 195.9600n 0.002228 195.9700n 0.002192 195.9800n 0.002132 195.9900n 0.002049 196.0000n 0.001947 196.0100n 0.001828 196.0200n 0.001695 196.0300n 0.001552 196.0400n 0.001401
+ 196.0500n 0.001246 196.0600n 0.001089 196.0700n 0.000933 196.0800n 0.000782 196.0900n 0.000636 196.1000n 0.000498 196.1100n 0.000369 196.1200n 0.000252 196.1300n 0.000146 196.1400n 0.000052 196.1500n -0.000030 196.1600n -0.000099 196.1700n -0.000156 196.1800n -0.000202 196.1900n -0.000237
+ 196.2000n -0.000262 196.2100n -0.000280 196.2200n -0.000289 196.2300n -0.000293 196.2400n -0.000291 196.2500n -0.000286 196.2600n -0.000278 196.2700n -0.000268 196.2800n -0.000257 196.2900n -0.000246 196.3000n -0.000234 196.3100n -0.000223 196.3200n -0.000213 196.3300n -0.000202 196.3400n -0.000192
+ 196.3500n -0.000181 196.3600n -0.000170 196.3700n -0.000157 196.3800n -0.000143 196.3900n -0.000125 196.4000n -0.000105 196.4100n -0.000081 196.4200n -0.000053 196.4300n -0.000021 196.4400n 0.000016 196.4500n 0.000057 196.4600n 0.000102 196.4700n 0.000152 196.4800n 0.000204 196.4900n 0.000259
+ 196.5000n 0.000315 196.5100n 0.000372 196.5200n 0.000427 196.5300n 0.000480 196.5400n 0.000528 196.5500n 0.000571 196.5600n 0.000606 196.5700n 0.000633 196.5800n 0.000649 196.5900n 0.000653 196.6000n 0.000644 196.6100n 0.000622 196.6200n 0.000585 196.6300n 0.000533 196.6400n 0.000466
+ 196.6500n 0.000384 196.6600n 0.000288 196.6700n 0.000179 196.6800n 0.000057 196.6900n -0.000074 196.7000n -0.000215 196.7100n -0.000361 196.7200n -0.000512 196.7300n -0.000664 196.7400n -0.000815 196.7500n -0.000962 196.7600n -0.001101 196.7700n -0.001232 196.7800n -0.001350 196.7900n -0.001453
+ 196.8000n -0.001540 196.8100n -0.001608 196.8200n -0.001655 196.8300n -0.001681 196.8400n -0.001685 196.8500n -0.001666 196.8600n -0.001624 196.8700n -0.001560 196.8800n -0.001476 196.8900n -0.001372 196.9000n -0.001250 196.9100n -0.001113 196.9200n -0.000964 196.9300n -0.000805 196.9400n -0.000640
+ 196.9500n -0.000472 196.9600n -0.000304 196.9700n -0.000140 196.9800n 0.000017 196.9900n 0.000164 197.0000n 0.000297 197.0100n 0.000413 197.0200n 0.000511 197.0300n 0.000588 197.0400n 0.000643 197.0500n 0.000673 197.0600n 0.000680 197.0700n 0.000661 197.0800n 0.000619 197.0900n 0.000553
+ 197.1000n 0.000465 197.1100n 0.000357 197.1200n 0.000232 197.1300n 0.000090 197.1400n -0.000063 197.1500n -0.000226 197.1600n -0.000396 197.1700n -0.000567 197.1800n -0.000738 197.1900n -0.000905 197.2000n -0.001064 197.2100n -0.001213 197.2200n -0.001348 197.2300n -0.001469 197.2400n -0.001571
+ 197.2500n -0.001655 197.2600n -0.001719 197.2700n -0.001762 197.2800n -0.001784 197.2900n -0.001786 197.3000n -0.001769 197.3100n -0.001734 197.3200n -0.001683 197.3300n -0.001618 197.3400n -0.001542 197.3500n -0.001457 197.3600n -0.001367 197.3700n -0.001274 197.3800n -0.001182 197.3900n -0.001094
+ 197.4000n -0.001012 197.4100n -0.000941 197.4200n -0.000881 197.4300n -0.000836 197.4400n -0.000807 197.4500n -0.000796 197.4600n -0.000803 197.4700n -0.000829 197.4800n -0.000874 197.4900n -0.000937 197.5000n -0.001017 197.5100n -0.001114 197.5200n -0.001223 197.5300n -0.001344 197.5400n -0.001474
+ 197.5500n -0.001609 197.5600n -0.001746 197.5700n -0.001883 197.5800n -0.002015 197.5900n -0.002139 197.6000n -0.002252 197.6100n -0.002350 197.6200n -0.002432 197.6300n -0.002493 197.6400n -0.002533 197.6500n -0.002549 197.6600n -0.002541 197.6700n -0.002506 197.6800n -0.002445 197.6900n -0.002359
+ 197.7000n -0.002247 197.7100n -0.002112 197.7200n -0.001954 197.7300n -0.001775 197.7400n -0.001579 197.7500n -0.001368 197.7600n -0.001145 197.7700n -0.000913 197.7800n -0.000675 197.7900n -0.000435 197.8000n -0.000196 197.8100n 0.000039 197.8200n 0.000267 197.8300n 0.000485 197.8400n 0.000692
+ 197.8500n 0.000885 197.8600n 0.001062 197.8700n 0.001223 197.8800n 0.001366 197.8900n 0.001492 197.9000n 0.001601 197.9100n 0.001693 197.9200n 0.001769 197.9300n 0.001832 197.9400n 0.001881 197.9500n 0.001921 197.9600n 0.001952 197.9700n 0.001977 197.9800n 0.001999 197.9900n 0.002019
+ 198.0000n 0.002040 198.0100n 0.002065 198.0200n 0.002095 198.0300n 0.002131 198.0400n 0.002175 198.0500n 0.002228 198.0600n 0.002291 198.0700n 0.002362 198.0800n 0.002443 198.0900n 0.002531 198.1000n 0.002627 198.1100n 0.002727 198.1200n 0.002830 198.1300n 0.002934 198.1400n 0.003036
+ 198.1500n 0.003133 198.1600n 0.003222 198.1700n 0.003299 198.1800n 0.003363 198.1900n 0.003409 198.2000n 0.003436 198.2100n 0.003439 198.2200n 0.003418 198.2300n 0.003370 198.2400n 0.003294 198.2500n 0.003189 198.2600n 0.003055 198.2700n 0.002891 198.2800n 0.002699 198.2900n 0.002479
+ 198.3000n 0.002234 198.3100n 0.001965 198.3200n 0.001676 198.3300n 0.001371 198.3400n 0.001052 198.3500n 0.000723 198.3600n 0.000390 198.3700n 0.000056 198.3800n -0.000274 198.3900n -0.000596 198.4000n -0.000906 198.4100n -0.001198 198.4200n -0.001469 198.4300n -0.001717 198.4400n -0.001937
+ 198.4500n -0.002126 198.4600n -0.002284 198.4700n -0.002407 198.4800n -0.002496 198.4900n -0.002550 198.5000n -0.002569 198.5100n -0.002554 198.5200n -0.002507 198.5300n -0.002429 198.5400n -0.002323 198.5500n -0.002192 198.5600n -0.002040 198.5700n -0.001869 198.5800n -0.001684 198.5900n -0.001489
+ 198.6000n -0.001288 198.6100n -0.001084 198.6200n -0.000882 198.6300n -0.000685 198.6400n -0.000496 198.6500n -0.000319 198.6600n -0.000157 198.6700n -0.000011 198.6800n 0.000117 198.6900n 0.000225 198.7000n 0.000312 198.7100n 0.000379 198.7200n 0.000426 198.7300n 0.000453 198.7400n 0.000462
+ 198.7500n 0.000454 198.7600n 0.000430 198.7700n 0.000394 198.7800n 0.000348 198.7900n 0.000294 198.8000n 0.000234 198.8100n 0.000172 198.8200n 0.000110 198.8300n 0.000050 198.8400n -0.000005 198.8500n -0.000053 198.8600n -0.000094 198.8700n -0.000124 198.8800n -0.000144 198.8900n -0.000153
+ 198.9000n -0.000151 198.9100n -0.000137 198.9200n -0.000113 198.9300n -0.000079 198.9400n -0.000038 198.9500n 0.000011 198.9600n 0.000064 198.9700n 0.000120 198.9800n 0.000176 198.9900n 0.000231 199.0000n 0.000282 199.0100n 0.000326 199.0200n 0.000363 199.0300n 0.000389 199.0400n 0.000404
+ 199.0500n 0.000406 199.0600n 0.000393 199.0700n 0.000366 199.0800n 0.000324 199.0900n 0.000267 199.1000n 0.000195 199.1100n 0.000109 199.1200n 0.000011 199.1300n -0.000098 199.1400n -0.000216 199.1500n -0.000342 199.1600n -0.000472 199.1700n -0.000604 199.1800n -0.000737 199.1900n -0.000866
+ 199.2000n -0.000991 199.2100n -0.001108 199.2200n -0.001216 199.2300n -0.001312 199.2400n -0.001395 199.2500n -0.001463 199.2600n -0.001516 199.2700n -0.001553 199.2800n -0.001574 199.2900n -0.001579 199.3000n -0.001568 199.3100n -0.001544 199.3200n -0.001507 199.3300n -0.001459 199.3400n -0.001402
+ 199.3500n -0.001340 199.3600n -0.001273 199.3700n -0.001206 199.3800n -0.001140 199.3900n -0.001078 199.4000n -0.001024 199.4100n -0.000979 199.4200n -0.000947 199.4300n -0.000928 199.4400n -0.000925 199.4500n -0.000938 199.4600n -0.000970 199.4700n -0.001019 199.4800n -0.001087 199.4900n -0.001172
+ 199.5000n -0.001273 199.5100n -0.001390 199.5200n -0.001519 199.5300n -0.001659 199.5400n -0.001807 199.5500n -0.001959 199.5600n -0.002113 199.5700n -0.002265 199.5800n -0.002412 199.5900n -0.002549 199.6000n -0.002674 199.6100n -0.002783 199.6200n -0.002874 199.6300n -0.002942 199.6400n -0.002986
+ 199.6500n -0.003004 199.6600n -0.002994 199.6700n -0.002955 199.6800n -0.002886 199.6900n -0.002789 199.7000n -0.002662 199.7100n -0.002509 199.7200n -0.002329 199.7300n -0.002127 199.7400n -0.001903 199.7500n -0.001663 199.7600n -0.001409 199.7700n -0.001145 199.7800n -0.000875 199.7900n -0.000604
+ 199.8000n -0.000336 199.8100n -0.000075 199.8200n 0.000175 199.8300n 0.000410 199.8400n 0.000625 199.8500n 0.000819 199.8600n 0.000987 199.8700n 0.001128 199.8800n 0.001240 199.8900n 0.001320 199.9000n 0.001370 199.9100n 0.001388 199.9200n 0.001376 199.9300n 0.001333 199.9400n 0.001263
+ 199.9500n 0.001167 199.9600n 0.001047 199.9700n 0.000909 199.9800n 0.000753 199.9900n 0.000585 200.0000n 0.000409 200.0100n 0.000229 200.0200n 0.000048 200.0300n -0.000128 200.0400n -0.000296 200.0500n -0.000452 200.0600n -0.000592 200.0700n -0.000714 200.0800n -0.000814 200.0900n -0.000889
+ 200.1000n -0.000939 200.1100n -0.000963 200.1200n -0.000958 200.1300n -0.000925 200.1400n -0.000866 200.1500n -0.000780 200.1600n -0.000669 200.1700n -0.000536 200.1800n -0.000382 200.1900n -0.000212 200.2000n -0.000027 200.2100n 0.000167 200.2200n 0.000369 200.2300n 0.000572 200.2400n 0.000775
+ 200.2500n 0.000972 200.2600n 0.001160 200.2700n 0.001335 200.2800n 0.001495 200.2900n 0.001635 200.3000n 0.001754 200.3100n 0.001848 200.3200n 0.001917 200.3300n 0.001959 200.3400n 0.001972 200.3500n 0.001958 200.3600n 0.001916 200.3700n 0.001846 200.3800n 0.001750 200.3900n 0.001631
+ 200.4000n 0.001489 200.4100n 0.001327 200.4200n 0.001149 200.4300n 0.000957 200.4400n 0.000755 200.4500n 0.000545 200.4600n 0.000333 200.4700n 0.000120 200.4800n -0.000088 200.4900n -0.000290 200.5000n -0.000481 200.5100n -0.000659 200.5200n -0.000821 200.5300n -0.000964 200.5400n -0.001087
+ 200.5500n -0.001187 200.5600n -0.001264 200.5700n -0.001316 200.5800n -0.001344 200.5900n -0.001347 200.6000n -0.001326 200.6100n -0.001281 200.6200n -0.001214 200.6300n -0.001126 200.6400n -0.001020 200.6500n -0.000896 200.6600n -0.000759 200.6700n -0.000610 200.6800n -0.000452 200.6900n -0.000287
+ 200.7000n -0.000120 200.7100n 0.000048 200.7200n 0.000213 200.7300n 0.000373 200.7400n 0.000526 200.7500n 0.000668 200.7600n 0.000797 200.7700n 0.000913 200.7800n 0.001012 200.7900n 0.001094 200.8000n 0.001158 200.8100n 0.001202 200.8200n 0.001227 200.8300n 0.001232 200.8400n 0.001217
+ 200.8500n 0.001183 200.8600n 0.001131 200.8700n 0.001062 200.8800n 0.000977 200.8900n 0.000877 200.9000n 0.000766 200.9100n 0.000643 200.9200n 0.000512 200.9300n 0.000375 200.9400n 0.000233 200.9500n 0.000089 200.9600n -0.000054 200.9700n -0.000195 200.9800n -0.000332 200.9900n -0.000462
+ 201.0000n -0.000584 201.0100n -0.000696 201.0200n -0.000797 201.0300n -0.000885 201.0400n -0.000959 201.0500n -0.001019 201.0600n -0.001064 201.0700n -0.001095 201.0800n -0.001110 201.0900n -0.001111 201.1000n -0.001098 201.1100n -0.001072 201.1200n -0.001034 201.1300n -0.000985 201.1400n -0.000927
+ 201.1500n -0.000861 201.1600n -0.000790 201.1700n -0.000715 201.1800n -0.000638 201.1900n -0.000561 201.2000n -0.000486 201.2100n -0.000416 201.2200n -0.000351 201.2300n -0.000295 201.2400n -0.000248 201.2500n -0.000211 201.2600n -0.000187 201.2700n -0.000176 201.2800n -0.000179 201.2900n -0.000196
+ 201.3000n -0.000227 201.3100n -0.000272 201.3200n -0.000331 201.3300n -0.000403 201.3400n -0.000487 201.3500n -0.000580 201.3600n -0.000683 201.3700n -0.000792 201.3800n -0.000905 201.3900n -0.001021 201.4000n -0.001136 201.4100n -0.001249 201.4200n -0.001357 201.4300n -0.001457 201.4400n -0.001547
+ 201.4500n -0.001624 201.4600n -0.001686 201.4700n -0.001732 201.4800n -0.001759 201.4900n -0.001766 201.5000n -0.001752 201.5100n -0.001716 201.5200n -0.001658 201.5300n -0.001578 201.5400n -0.001477 201.5500n -0.001355 201.5600n -0.001215 201.5700n -0.001057 201.5800n -0.000883 201.5900n -0.000697
+ 201.6000n -0.000502 201.6100n -0.000300 201.6200n -0.000094 201.6300n 0.000111 201.6400n 0.000312 201.6500n 0.000506 201.6600n 0.000689 201.6700n 0.000857 201.6800n 0.001008 201.6900n 0.001137 201.7000n 0.001243 201.7100n 0.001322 201.7200n 0.001374 201.7300n 0.001395 201.7400n 0.001386
+ 201.7500n 0.001346 201.7600n 0.001275 201.7700n 0.001173 201.7800n 0.001042 201.7900n 0.000883 201.8000n 0.000699 201.8100n 0.000492 201.8200n 0.000266 201.8300n 0.000025 201.8400n -0.000229 201.8500n -0.000490 201.8600n -0.000754 201.8700n -0.001017 201.8800n -0.001274 201.8900n -0.001520
+ 201.9000n -0.001752 201.9100n -0.001965 201.9200n -0.002155 201.9300n -0.002318 201.9400n -0.002452 201.9500n -0.002555 201.9600n -0.002623 201.9700n -0.002656 201.9800n -0.002652 201.9900n -0.002612 202.0000n -0.002536 202.0100n -0.002424 202.0200n -0.002279 202.0300n -0.002103 202.0400n -0.001898
+ 202.0500n -0.001667 202.0600n -0.001415 202.0700n -0.001144 202.0800n -0.000860 202.0900n -0.000566 202.1000n -0.000268 202.1100n 0.000031 202.1200n 0.000326 202.1300n 0.000613 202.1400n 0.000887 202.1500n 0.001145 202.1600n 0.001384 202.1700n 0.001600 202.1800n 0.001791 202.1900n 0.001955
+ 202.2000n 0.002091 202.2100n 0.002198 202.2200n 0.002275 202.2300n 0.002322 202.2400n 0.002341 202.2500n 0.002333 202.2600n 0.002300 202.2700n 0.002242 202.2800n 0.002164 202.2900n 0.002068 202.3000n 0.001957 202.3100n 0.001834 202.3200n 0.001702 202.3300n 0.001564 202.3400n 0.001425
+ 202.3500n 0.001286 202.3600n 0.001150 202.3700n 0.001021 202.3800n 0.000900 202.3900n 0.000790 202.4000n 0.000691 202.4100n 0.000605 202.4200n 0.000533 202.4300n 0.000475 202.4400n 0.000431 202.4500n 0.000400 202.4600n 0.000381 202.4700n 0.000373 202.4800n 0.000375 202.4900n 0.000385
+ 202.5000n 0.000401 202.5100n 0.000421 202.5200n 0.000443 202.5300n 0.000465 202.5400n 0.000485 202.5500n 0.000502 202.5600n 0.000513 202.5700n 0.000517 202.5800n 0.000514 202.5900n 0.000502 202.6000n 0.000481 202.6100n 0.000450 202.6200n 0.000412 202.6300n 0.000365 202.6400n 0.000311
+ 202.6500n 0.000251 202.6600n 0.000187 202.6700n 0.000121 202.6800n 0.000054 202.6900n -0.000010 202.7000n -0.000070 202.7100n -0.000124 202.7200n -0.000169 202.7300n -0.000202 202.7400n -0.000223 202.7500n -0.000229 202.7600n -0.000219 202.7700n -0.000191 202.7800n -0.000145 202.7900n -0.000081
+ 202.8000n 0.000002 202.8100n 0.000102 202.8200n 0.000220 202.8300n 0.000353 202.8400n 0.000499 202.8500n 0.000657 202.8600n 0.000824 202.8700n 0.000997 202.8800n 0.001173 202.8900n 0.001349 202.9000n 0.001522 202.9100n 0.001687 202.9200n 0.001842 202.9300n 0.001984 202.9400n 0.002109
+ 202.9500n 0.002214 202.9600n 0.002298 202.9700n 0.002359 202.9800n 0.002394 202.9900n 0.002402 203.0000n 0.002384 203.0100n 0.002339 203.0200n 0.002267 203.0300n 0.002170 203.0400n 0.002049 203.0500n 0.001907 203.0600n 0.001745 203.0700n 0.001568 203.0800n 0.001378 203.0900n 0.001179
+ 203.1000n 0.000975 203.1100n 0.000770 203.1200n 0.000569 203.1300n 0.000374 203.1400n 0.000191 203.1500n 0.000023 203.1600n -0.000126 203.1700n -0.000253 203.1800n -0.000356 203.1900n -0.000432 203.2000n -0.000479 203.2100n -0.000497 203.2200n -0.000483 203.2300n -0.000440 203.2400n -0.000366
+ 203.2500n -0.000263 203.2600n -0.000134 203.2700n 0.000021 203.2800n 0.000198 203.2900n 0.000393 203.3000n 0.000604 203.3100n 0.000826 203.3200n 0.001056 203.3300n 0.001289 203.3400n 0.001521 203.3500n 0.001747 203.3600n 0.001964 203.3700n 0.002168 203.3800n 0.002355 203.3900n 0.002521
+ 203.4000n 0.002664 203.4100n 0.002782 203.4200n 0.002872 203.4300n 0.002933 203.4400n 0.002965 203.4500n 0.002967 203.4600n 0.002939 203.4700n 0.002882 203.4800n 0.002797 203.4900n 0.002687 203.5000n 0.002554 203.5100n 0.002400 203.5200n 0.002228 203.5300n 0.002041 203.5400n 0.001843
+ 203.5500n 0.001638 203.5600n 0.001428 203.5700n 0.001217 203.5800n 0.001010 203.5900n 0.000807 203.6000n 0.000614 203.6100n 0.000432 203.6200n 0.000264 203.6300n 0.000111 203.6400n -0.000025 203.6500n -0.000143 203.6600n -0.000242 203.6700n -0.000322 203.6800n -0.000384 203.6900n -0.000427
+ 203.7000n -0.000454 203.7100n -0.000465 203.7200n -0.000461 203.7300n -0.000446 203.7400n -0.000420 203.7500n -0.000387 203.7600n -0.000347 203.7700n -0.000305 203.7800n -0.000260 203.7900n -0.000217 203.8000n -0.000177 203.8100n -0.000140 203.8200n -0.000110 203.8300n -0.000087 203.8400n -0.000073
+ 203.8500n -0.000067 203.8600n -0.000070 203.8700n -0.000082 203.8800n -0.000103 203.8900n -0.000132 203.9000n -0.000168 203.9100n -0.000210 203.9200n -0.000258 203.9300n -0.000308 203.9400n -0.000360 203.9500n -0.000412 203.9600n -0.000463 203.9700n -0.000510 203.9800n -0.000552 203.9900n -0.000587
+ 204.0000n -0.000615 204.0100n -0.000634 204.0200n -0.000642 204.0300n -0.000640 204.0400n -0.000627 204.0500n -0.000602 204.0600n -0.000567 204.0700n -0.000520 204.0800n -0.000463 204.0900n -0.000396 204.1000n -0.000321 204.1100n -0.000239 204.1200n -0.000152 204.1300n -0.000060 204.1400n 0.000035
+ 204.1500n 0.000130 204.1600n 0.000225 204.1700n 0.000318 204.1800n 0.000407 204.1900n 0.000491 204.2000n 0.000568 204.2100n 0.000639 204.2200n 0.000701 204.2300n 0.000755 204.2400n 0.000799 204.2500n 0.000835 204.2600n 0.000862 204.2700n 0.000880 204.2800n 0.000891 204.2900n 0.000895
+ 204.3000n 0.000892 204.3100n 0.000885 204.3200n 0.000874 204.3300n 0.000861 204.3400n 0.000848 204.3500n 0.000834 204.3600n 0.000823 204.3700n 0.000815 204.3800n 0.000810 204.3900n 0.000812 204.4000n 0.000819 204.4100n 0.000832 204.4200n 0.000853 204.4300n 0.000881 204.4400n 0.000915
+ 204.4500n 0.000956 204.4600n 0.001003 204.4700n 0.001054 204.4800n 0.001110 204.4900n 0.001168 204.5000n 0.001227 204.5100n 0.001285 204.5200n 0.001341 204.5300n 0.001392 204.5400n 0.001438 204.5500n 0.001476 204.5600n 0.001505 204.5700n 0.001523 204.5800n 0.001529 204.5900n 0.001522
+ 204.6000n 0.001499 204.6100n 0.001462 204.6200n 0.001409 204.6300n 0.001340 204.6400n 0.001256 204.6500n 0.001156 204.6600n 0.001042 204.6700n 0.000915 204.6800n 0.000775 204.6900n 0.000625 204.7000n 0.000467 204.7100n 0.000302 204.7200n 0.000133 204.7300n -0.000038 204.7400n -0.000209
+ 204.7500n -0.000376 204.7600n -0.000538 204.7700n -0.000693 204.7800n -0.000837 204.7900n -0.000969 204.8000n -0.001087 204.8100n -0.001189 204.8200n -0.001274 204.8300n -0.001339 204.8400n -0.001386 204.8500n -0.001412 204.8600n -0.001417 204.8700n -0.001402 204.8800n -0.001367 204.8900n -0.001313
+ 204.9000n -0.001240 204.9100n -0.001150 204.9200n -0.001044 204.9300n -0.000924 204.9400n -0.000792 204.9500n -0.000650 204.9600n -0.000500 204.9700n -0.000345 204.9800n -0.000186 204.9900n -0.000026 205.0000n 0.000132 205.0100n 0.000287 205.0200n 0.000436 205.0300n 0.000578 205.0400n 0.000711
+ 205.0500n 0.000832 205.0600n 0.000942 205.0700n 0.001038 205.0800n 0.001120 205.0900n 0.001187 205.1000n 0.001238 205.1100n 0.001274 205.1200n 0.001294 205.1300n 0.001299 205.1400n 0.001289 205.1500n 0.001264 205.1600n 0.001226 205.1700n 0.001175 205.1800n 0.001113 205.1900n 0.001040
+ 205.2000n 0.000958 205.2100n 0.000868 205.2200n 0.000771 205.2300n 0.000669 205.2400n 0.000563 205.2500n 0.000455 205.2600n 0.000345 205.2700n 0.000234 205.2800n 0.000125 205.2900n 0.000017 205.3000n -0.000088 205.3100n -0.000189 205.3200n -0.000285 205.3300n -0.000376 205.3400n -0.000462
+ 205.3500n -0.000541 205.3600n -0.000614 205.3700n -0.000680 205.3800n -0.000739 205.3900n -0.000790 205.4000n -0.000835 205.4100n -0.000872 205.4200n -0.000902 205.4300n -0.000926 205.4400n -0.000943 205.4500n -0.000953 205.4600n -0.000957 205.4700n -0.000956 205.4800n -0.000950 205.4900n -0.000938
+ 205.5000n -0.000923 205.5100n -0.000904 205.5200n -0.000881 205.5300n -0.000856 205.5400n -0.000829 205.5500n -0.000800 205.5600n -0.000771 205.5700n -0.000741 205.5800n -0.000711 205.5900n -0.000682 205.6000n -0.000654 205.6100n -0.000628 205.6200n -0.000604 205.6300n -0.000583 205.6400n -0.000565
+ 205.6500n -0.000550 205.6600n -0.000538 205.6700n -0.000529 205.6800n -0.000524 205.6900n -0.000522 205.7000n -0.000524 205.7100n -0.000528 205.7200n -0.000535 205.7300n -0.000545 205.7400n -0.000555 205.7500n -0.000567 205.7600n -0.000580 205.7700n -0.000592 205.7800n -0.000603 205.7900n -0.000612
+ 205.8000n -0.000619 205.8100n -0.000622 205.8200n -0.000622 205.8300n -0.000616 205.8400n -0.000606 205.8500n -0.000590 205.8600n -0.000567 205.8700n -0.000538 205.8800n -0.000502 205.8900n -0.000460 205.9000n -0.000411 205.9100n -0.000355 205.9200n -0.000294 205.9300n -0.000227 205.9400n -0.000155
+ 205.9500n -0.000079 205.9600n -0.000000 205.9700n 0.000080 205.9800n 0.000161 205.9900n 0.000242 206.0000n 0.000321 206.0100n 0.000397 206.0200n 0.000469 206.0300n 0.000535 206.0400n 0.000595 206.0500n 0.000646 206.0600n 0.000689 206.0700n 0.000723 206.0800n 0.000746 206.0900n 0.000758
+ 206.1000n 0.000760 206.1100n 0.000751 206.1200n 0.000731 206.1300n 0.000701 206.1400n 0.000661 206.1500n 0.000613 206.1600n 0.000556 206.1700n 0.000494 206.1800n 0.000426 206.1900n 0.000355 206.2000n 0.000282 206.2100n 0.000210 206.2200n 0.000139 206.2300n 0.000071 206.2400n 0.000009
+ 206.2500n -0.000046 206.2600n -0.000092 206.2700n -0.000128 206.2800n -0.000153 206.2900n -0.000166 206.3000n -0.000166 206.3100n -0.000152 206.3200n -0.000124 206.3300n -0.000083 206.3400n -0.000029 206.3500n 0.000039 206.3600n 0.000117 206.3700n 0.000206 206.3800n 0.000304 206.3900n 0.000408
+ 206.4000n 0.000518 206.4100n 0.000630 206.4200n 0.000742 206.4300n 0.000853 206.4400n 0.000959 206.4500n 0.001058 206.4600n 0.001147 206.4700n 0.001225 206.4800n 0.001289 206.4900n 0.001337 206.5000n 0.001367 206.5100n 0.001378 206.5200n 0.001368 206.5300n 0.001337 206.5400n 0.001284
+ 206.5500n 0.001209 206.5600n 0.001112 206.5700n 0.000994 206.5800n 0.000855 206.5900n 0.000696 206.6000n 0.000521 206.6100n 0.000329 206.6200n 0.000124 206.6300n -0.000092 206.6400n -0.000317 206.6500n -0.000548 206.6600n -0.000781 206.6700n -0.001014 206.6800n -0.001244 206.6900n -0.001468
+ 206.7000n -0.001684 206.7100n -0.001887 206.7200n -0.002077 206.7300n -0.002249 206.7400n -0.002403 206.7500n -0.002537 206.7600n -0.002649 206.7700n -0.002737 206.7800n -0.002801 206.7900n -0.002840 206.8000n -0.002854 206.8100n -0.002844 206.8200n -0.002808 206.8300n -0.002749 206.8400n -0.002667
+ 206.8500n -0.002563 206.8600n -0.002439 206.8700n -0.002297 206.8800n -0.002138 206.8900n -0.001964 206.9000n -0.001778 206.9100n -0.001582 206.9200n -0.001377 206.9300n -0.001167 206.9400n -0.000953 206.9500n -0.000738 206.9600n -0.000524 206.9700n -0.000312 206.9800n -0.000105 206.9900n 0.000095
+ 207.0000n 0.000286 207.0100n 0.000468 207.0200n 0.000638 207.0300n 0.000796 207.0400n 0.000940 207.0500n 0.001068 207.0600n 0.001181 207.0700n 0.001277 207.0800n 0.001356 207.0900n 0.001418 207.1000n 0.001461 207.1100n 0.001486 207.1200n 0.001492 207.1300n 0.001480 207.1400n 0.001450
+ 207.1500n 0.001401 207.1600n 0.001335 207.1700n 0.001251 207.1800n 0.001151 207.1900n 0.001035 207.2000n 0.000903 207.2100n 0.000758 207.2200n 0.000599 207.2300n 0.000429 207.2400n 0.000249 207.2500n 0.000060 207.2600n -0.000136 207.2700n -0.000337 207.2800n -0.000541 207.2900n -0.000747
+ 207.3000n -0.000951 207.3100n -0.001152 207.3200n -0.001347 207.3300n -0.001535 207.3400n -0.001712 207.3500n -0.001877 207.3600n -0.002027 207.3700n -0.002161 207.3800n -0.002275 207.3900n -0.002370 207.4000n -0.002442 207.4100n -0.002491 207.4200n -0.002516 207.4300n -0.002515 207.4400n -0.002489
+ 207.4500n -0.002438 207.4600n -0.002362 207.4700n -0.002262 207.4800n -0.002138 207.4900n -0.001993 207.5000n -0.001827 207.5100n -0.001645 207.5200n -0.001447 207.5300n -0.001237 207.5400n -0.001017 207.5500n -0.000792 207.5600n -0.000564 207.5700n -0.000336 207.5800n -0.000113 207.5900n 0.000102
+ 207.6000n 0.000307 207.6100n 0.000497 207.6200n 0.000670 207.6300n 0.000823 207.6400n 0.000954 207.6500n 0.001061 207.6600n 0.001143 207.6700n 0.001198 207.6800n 0.001226 207.6900n 0.001227 207.7000n 0.001202 207.7100n 0.001151 207.7200n 0.001076 207.7300n 0.000980 207.7400n 0.000864
+ 207.7500n 0.000732 207.7600n 0.000587 207.7700n 0.000432 207.7800n 0.000271 207.7900n 0.000108 207.8000n -0.000052 207.8100n -0.000207 207.8200n -0.000352 207.8300n -0.000483 207.8400n -0.000597 207.8500n -0.000691 207.8600n -0.000761 207.8700n -0.000806 207.8800n -0.000824 207.8900n -0.000812
+ 207.9000n -0.000771 207.9100n -0.000701 207.9200n -0.000601 207.9300n -0.000473 207.9400n -0.000318 207.9500n -0.000138 207.9600n 0.000064 207.9700n 0.000285 207.9800n 0.000522 207.9900n 0.000770 208.0000n 0.001026 208.0100n 0.001286 208.0200n 0.001546 208.0300n 0.001800 208.0400n 0.002046
+ 208.0500n 0.002278 208.0600n 0.002494 208.0700n 0.002689 208.0800n 0.002861 208.0900n 0.003007 208.1000n 0.003126 208.1100n 0.003215 208.1200n 0.003274 208.1300n 0.003303 208.1400n 0.003301 208.1500n 0.003270 208.1600n 0.003211 208.1700n 0.003125 208.1800n 0.003016 208.1900n 0.002886
+ 208.2000n 0.002739 208.2100n 0.002577 208.2200n 0.002405 208.2300n 0.002227 208.2400n 0.002045 208.2500n 0.001865 208.2600n 0.001689 208.2700n 0.001522 208.2800n 0.001366 208.2900n 0.001224 208.3000n 0.001099 208.3100n 0.000993 208.3200n 0.000907 208.3300n 0.000842 208.3400n 0.000800
+ 208.3500n 0.000778 208.3600n 0.000778 208.3700n 0.000797 208.3800n 0.000835 208.3900n 0.000890 208.4000n 0.000958 208.4100n 0.001037 208.4200n 0.001125 208.4300n 0.001217 208.4400n 0.001312 208.4500n 0.001405 208.4600n 0.001494 208.4700n 0.001575 208.4800n 0.001646 208.4900n 0.001704
+ 208.5000n 0.001747 208.5100n 0.001773 208.5200n 0.001781 208.5300n 0.001769 208.5400n 0.001738 208.5500n 0.001687 208.5600n 0.001618 208.5700n 0.001530 208.5800n 0.001426 208.5900n 0.001306 208.6000n 0.001175 208.6100n 0.001033 208.6200n 0.000884 208.6300n 0.000731 208.6400n 0.000576
+ 208.6500n 0.000424 208.6600n 0.000276 208.6700n 0.000136 208.6800n 0.000007 208.6900n -0.000109 208.7000n -0.000210 208.7100n -0.000294 208.7200n -0.000359 208.7300n -0.000404 208.7400n -0.000430 208.7500n -0.000435 208.7600n -0.000420 208.7700n -0.000386 208.7800n -0.000334 208.7900n -0.000266
+ 208.8000n -0.000183 208.8100n -0.000089 208.8200n 0.000015 208.8300n 0.000125 208.8400n 0.000240 208.8500n 0.000355 208.8600n 0.000469 208.8700n 0.000578 208.8800n 0.000679 208.8900n 0.000771 208.9000n 0.000852 208.9100n 0.000918 208.9200n 0.000970 208.9300n 0.001006 208.9400n 0.001025
+ 208.9500n 0.001027 208.9600n 0.001012 208.9700n 0.000982 208.9800n 0.000937 208.9900n 0.000878 209.0000n 0.000808 209.0100n 0.000728 209.0200n 0.000641 209.0300n 0.000549 209.0400n 0.000456 209.0500n 0.000363 209.0600n 0.000273 209.0700n 0.000190 209.0800n 0.000115 209.0900n 0.000050
+ 209.1000n -0.000001 209.1100n -0.000038 209.1200n -0.000059 209.1300n -0.000063 209.1400n -0.000049 209.1500n -0.000018 209.1600n 0.000032 209.1700n 0.000098 209.1800n 0.000182 209.1900n 0.000280 209.2000n 0.000392 209.2100n 0.000516 209.2200n 0.000649 209.2300n 0.000790 209.2400n 0.000937
+ 209.2500n 0.001086 209.2600n 0.001236 209.2700n 0.001384 209.2800n 0.001527 209.2900n 0.001665 209.3000n 0.001795 209.3100n 0.001915 209.3200n 0.002025 209.3300n 0.002122 209.3400n 0.002208 209.3500n 0.002281 209.3600n 0.002341 209.3700n 0.002390 209.3800n 0.002426 209.3900n 0.002453
+ 209.4000n 0.002470 209.4100n 0.002479 209.4200n 0.002482 209.4300n 0.002480 209.4400n 0.002475 209.4500n 0.002469 209.4600n 0.002464 209.4700n 0.002460 209.4800n 0.002460 209.4900n 0.002465 209.5000n 0.002475 209.5100n 0.002491 209.5200n 0.002514 209.5300n 0.002544 209.5400n 0.002579
+ 209.5500n 0.002620 209.5600n 0.002666 209.5700n 0.002716 209.5800n 0.002767 209.5900n 0.002819 209.6000n 0.002869 209.6100n 0.002915 209.6200n 0.002955 209.6300n 0.002987 209.6400n 0.003008 209.6500n 0.003017 209.6600n 0.003012 209.6700n 0.002991 209.6800n 0.002952 209.6900n 0.002895
+ 209.7000n 0.002818 209.7100n 0.002721 209.7200n 0.002604 209.7300n 0.002467 209.7400n 0.002311 209.7500n 0.002138 209.7600n 0.001948 209.7700n 0.001744 209.7800n 0.001528 209.7900n 0.001303 209.8000n 0.001071 209.8100n 0.000836 209.8200n 0.000600 209.8300n 0.000367 209.8400n 0.000140
+ 209.8500n -0.000078 209.8600n -0.000284 209.8700n -0.000474 209.8800n -0.000648 209.8900n -0.000802 209.9000n -0.000934 209.9100n -0.001043 209.9200n -0.001129 209.9300n -0.001190 209.9400n -0.001226 209.9500n -0.001238 209.9600n -0.001226 209.9700n -0.001192 209.9800n -0.001138 209.9900n -0.001066
+ 210.0000n -0.000977 210.0100n -0.000874 210.0200n -0.000761 210.0300n -0.000641 210.0400n -0.000515 210.0500n -0.000389 210.0600n -0.000263 210.0700n -0.000143 210.0800n -0.000029 210.0900n 0.000075 210.1000n 0.000168 210.1100n 0.000246 210.1200n 0.000310 210.1300n 0.000357 210.1400n 0.000386
+ 210.1500n 0.000399 210.1600n 0.000394 210.1700n 0.000373 210.1800n 0.000335 210.1900n 0.000283 210.2000n 0.000217 210.2100n 0.000140 210.2200n 0.000054 210.2300n -0.000040 210.2400n -0.000139 210.2500n -0.000241 210.2600n -0.000344 210.2700n -0.000445 210.2800n -0.000542 210.2900n -0.000635
+ 210.3000n -0.000720 210.3100n -0.000797 210.3200n -0.000864 210.3300n -0.000921 210.3400n -0.000968 210.3500n -0.001004 210.3600n -0.001029 210.3700n -0.001044 210.3800n -0.001050 210.3900n -0.001047 210.4000n -0.001037 210.4100n -0.001022 210.4200n -0.001002 210.4300n -0.000980 210.4400n -0.000956
+ 210.4500n -0.000934 210.4600n -0.000913 210.4700n -0.000895 210.4800n -0.000882 210.4900n -0.000875 210.5000n -0.000874 210.5100n -0.000880 210.5200n -0.000892 210.5300n -0.000911 210.5400n -0.000937 210.5500n -0.000969 210.5600n -0.001005 210.5700n -0.001045 210.5800n -0.001087 210.5900n -0.001129
+ 210.6000n -0.001171 210.6100n -0.001209 210.6200n -0.001243 210.6300n -0.001270 210.6400n -0.001289 210.6500n -0.001298 210.6600n -0.001296 210.6700n -0.001281 210.6800n -0.001253 210.6900n -0.001211 210.7000n -0.001155 210.7100n -0.001084 210.7200n -0.001000 210.7300n -0.000903 210.7400n -0.000795
+ 210.7500n -0.000676 210.7600n -0.000548 210.7700n -0.000414 210.7800n -0.000276 210.7900n -0.000136 210.8000n 0.000003 210.8100n 0.000139 210.8200n 0.000270 210.8300n 0.000391 210.8400n 0.000502 210.8500n 0.000600 210.8600n 0.000683 210.8700n 0.000749 210.8800n 0.000797 210.8900n 0.000827
+ 210.9000n 0.000837 210.9100n 0.000827 210.9200n 0.000798 210.9300n 0.000751 210.9400n 0.000687 210.9500n 0.000607 210.9600n 0.000512 210.9700n 0.000407 210.9800n 0.000292 210.9900n 0.000171 211.0000n 0.000046 211.0100n -0.000080 211.0200n -0.000203 211.0300n -0.000322 211.0400n -0.000433
+ 211.0500n -0.000534 211.0600n -0.000622 211.0700n -0.000697 211.0800n -0.000755 211.0900n -0.000798 211.1000n -0.000822 211.1100n -0.000830 211.1200n -0.000820 211.1300n -0.000794 211.1400n -0.000754 211.1500n -0.000699 211.1600n -0.000634 211.1700n -0.000560 211.1800n -0.000480 211.1900n -0.000396
+ 211.2000n -0.000313 211.2100n -0.000233 211.2200n -0.000159 211.2300n -0.000094 211.2400n -0.000041 211.2500n -0.000003 211.2600n 0.000018 211.2700n 0.000021 211.2800n 0.000003 211.2900n -0.000036 211.3000n -0.000097 211.3100n -0.000179 211.3200n -0.000283 211.3300n -0.000405 211.3400n -0.000546
+ 211.3500n -0.000703 211.3600n -0.000872 211.3700n -0.001051 211.3800n -0.001236 211.3900n -0.001425 211.4000n -0.001611 211.4100n -0.001793 211.4200n -0.001965 211.4300n -0.002125 211.4400n -0.002267 211.4500n -0.002390 211.4600n -0.002489 211.4700n -0.002563 211.4800n -0.002609 211.4900n -0.002625
+ 211.5000n -0.002612 211.5100n -0.002568 211.5200n -0.002495 211.5300n -0.002392 211.5400n -0.002263 211.5500n -0.002110 211.5600n -0.001935 211.5700n -0.001742 211.5800n -0.001535 211.5900n -0.001319 211.6000n -0.001098 211.6100n -0.000877 211.6200n -0.000661 211.6300n -0.000454 211.6400n -0.000262
+ 211.6500n -0.000089 211.6600n 0.000061 211.6700n 0.000185 211.6800n 0.000279 211.6900n 0.000340 211.7000n 0.000368 211.7100n 0.000361 211.7200n 0.000319 211.7300n 0.000242 211.7400n 0.000132 211.7500n -0.000009 211.7600n -0.000178 211.7700n -0.000372 211.7800n -0.000586 211.7900n -0.000816
+ 211.8000n -0.001056 211.8100n -0.001301 211.8200n -0.001544 211.8300n -0.001781 211.8400n -0.002004 211.8500n -0.002209 211.8600n -0.002389 211.8700n -0.002539 211.8800n -0.002656 211.8900n -0.002734 211.9000n -0.002770 211.9100n -0.002761 211.9200n -0.002707 211.9300n -0.002606 211.9400n -0.002457
+ 211.9500n -0.002262 211.9600n -0.002024 211.9700n -0.001743 211.9800n -0.001425 211.9900n -0.001073 212.0000n -0.000693 212.0100n -0.000291 212.0200n 0.000128 212.0300n 0.000556 212.0400n 0.000987 212.0500n 0.001413 212.0600n 0.001828 212.0700n 0.002224 212.0800n 0.002594 212.0900n 0.002933
+ 212.1000n 0.003234 212.1100n 0.003491 212.1200n 0.003701 212.1300n 0.003860 212.1400n 0.003963 212.1500n 0.004010 212.1600n 0.003999 212.1700n 0.003930 212.1800n 0.003803 212.1900n 0.003621 212.2000n 0.003385 212.2100n 0.003100 212.2200n 0.002769 212.2300n 0.002397 212.2400n 0.001989
+ 212.2500n 0.001553 212.2600n 0.001093 212.2700n 0.000617 212.2800n 0.000131 212.2900n -0.000358 212.3000n -0.000843 212.3100n -0.001318 212.3200n -0.001776 212.3300n -0.002213 212.3400n -0.002621 212.3500n -0.002997 212.3600n -0.003337 212.3700n -0.003637 212.3800n -0.003895 212.3900n -0.004108
+ 212.4000n -0.004276 212.4100n -0.004398 212.4200n -0.004473 212.4300n -0.004504 212.4400n -0.004492 212.4500n -0.004439 212.4600n -0.004347 212.4700n -0.004221 212.4800n -0.004063 212.4900n -0.003877 212.5000n -0.003667 212.5100n -0.003439 212.5200n -0.003195 212.5300n -0.002940 212.5400n -0.002678
+ 212.5500n -0.002414 212.5600n -0.002151 212.5700n -0.001892 212.5800n -0.001641 212.5900n -0.001400 212.6000n -0.001173 212.6100n -0.000960 212.6200n -0.000764 212.6300n -0.000586 212.6400n -0.000426 212.6500n -0.000286 212.6600n -0.000165 212.6700n -0.000064 212.6800n 0.000018 212.6900n 0.000082
+ 212.7000n 0.000128 212.7100n 0.000157 212.7200n 0.000171 212.7300n 0.000170 212.7400n 0.000156 212.7500n 0.000129 212.7600n 0.000092 212.7700n 0.000044 212.7800n -0.000013 212.7900n -0.000078 212.8000n -0.000150 212.8100n -0.000229 212.8200n -0.000314 212.8300n -0.000405 212.8400n -0.000501
+ 212.8500n -0.000601 212.8600n -0.000706 212.8700n -0.000815 212.8800n -0.000928 212.8900n -0.001044 212.9000n -0.001163 212.9100n -0.001285 212.9200n -0.001410 212.9300n -0.001536 212.9400n -0.001663 212.9500n -0.001791 212.9600n -0.001918 212.9700n -0.002044 212.9800n -0.002168 212.9900n -0.002288
+ 213.0000n -0.002404 213.0100n -0.002514 213.0200n -0.002617 213.0300n -0.002711 213.0400n -0.002796 213.0500n -0.002870 213.0600n -0.002932 213.0700n -0.002981 213.0800n -0.003016 213.0900n -0.003037 213.1000n -0.003041 213.1100n -0.003030 213.1200n -0.003003 213.1300n -0.002960 213.1400n -0.002901
+ 213.1500n -0.002826 213.1600n -0.002736 213.1700n -0.002632 213.1800n -0.002515 213.1900n -0.002386 213.2000n -0.002246 213.2100n -0.002097 213.2200n -0.001941 213.2300n -0.001779 213.2400n -0.001613 213.2500n -0.001445 213.2600n -0.001276 213.2700n -0.001108 213.2800n -0.000944 213.2900n -0.000784
+ 213.3000n -0.000630 213.3100n -0.000483 213.3200n -0.000345 213.3300n -0.000217 213.3400n -0.000098 213.3500n 0.000009 213.3600n 0.000105 213.3700n 0.000190 213.3800n 0.000263 213.3900n 0.000324 213.4000n 0.000375 213.4100n 0.000414 213.4200n 0.000443 213.4300n 0.000462 213.4400n 0.000473
+ 213.4500n 0.000475 213.4600n 0.000469 213.4700n 0.000457 213.4800n 0.000439 213.4900n 0.000415 213.5000n 0.000388 213.5100n 0.000356 213.5200n 0.000321 213.5300n 0.000283 213.5400n 0.000242 213.5500n 0.000199 213.5600n 0.000154 213.5700n 0.000108 213.5800n 0.000059 213.5900n 0.000009
+ 213.6000n -0.000043 213.6100n -0.000097 213.6200n -0.000153 213.6300n -0.000211 213.6400n -0.000270 213.6500n -0.000332 213.6600n -0.000396 213.6700n -0.000462 213.6800n -0.000529 213.6900n -0.000598 213.7000n -0.000668 213.7100n -0.000738 213.7200n -0.000808 213.7300n -0.000878 213.7400n -0.000947
+ 213.7500n -0.001014 213.7600n -0.001078 213.7700n -0.001138 213.7800n -0.001195 213.7900n -0.001246 213.8000n -0.001291 213.8100n -0.001330 213.8200n -0.001361 213.8300n -0.001384 213.8400n -0.001399 213.8500n -0.001405 213.8600n -0.001403 213.8700n -0.001391 213.8800n -0.001370 213.8900n -0.001341
+ 213.9000n -0.001303 213.9100n -0.001257 213.9200n -0.001203 213.9300n -0.001143 213.9400n -0.001078 213.9500n -0.001007 213.9600n -0.000932 213.9700n -0.000855 213.9800n -0.000775 213.9900n -0.000695 214.0000n -0.000615 214.0100n -0.000536 214.0200n -0.000459 214.0300n -0.000384 214.0400n -0.000313
+ 214.0500n -0.000246 214.0600n -0.000182 214.0700n -0.000123 214.0800n -0.000068 214.0900n -0.000017 214.1000n 0.000029 214.1100n 0.000072 214.1200n 0.000112 214.1300n 0.000149 214.1400n 0.000184 214.1500n 0.000218 214.1600n 0.000251 214.1700n 0.000283 214.1800n 0.000316 214.1900n 0.000350
+ 214.2000n 0.000386 214.2100n 0.000423 214.2200n 0.000463 214.2300n 0.000504 214.2400n 0.000547 214.2500n 0.000591 214.2600n 0.000636 214.2700n 0.000682 214.2800n 0.000727 214.2900n 0.000770 214.3000n 0.000811 214.3100n 0.000847 214.3200n 0.000879 214.3300n 0.000903 214.3400n 0.000920
+ 214.3500n 0.000927 214.3600n 0.000924 214.3700n 0.000909 214.3800n 0.000881 214.3900n 0.000839 214.4000n 0.000784 214.4100n 0.000714 214.4200n 0.000631 214.4300n 0.000533 214.4400n 0.000421 214.4500n 0.000298 214.4600n 0.000163 214.4700n 0.000019 214.4800n -0.000133 214.4900n -0.000290
+ 214.5000n -0.000450 214.5100n -0.000611 214.5200n -0.000769 214.5300n -0.000922 214.5400n -0.001067 214.5500n -0.001201 214.5600n -0.001322 214.5700n -0.001426 214.5800n -0.001512 214.5900n -0.001576 214.6000n -0.001618 214.6100n -0.001636 214.6200n -0.001630 214.6300n -0.001597 214.6400n -0.001539
+ 214.6500n -0.001455 214.6600n -0.001348 214.6700n -0.001217 214.6800n -0.001066 214.6900n -0.000896 214.7000n -0.000710 214.7100n -0.000512 214.7200n -0.000305 214.7300n -0.000092 214.7400n 0.000121 214.7500n 0.000332 214.7600n 0.000535 214.7700n 0.000727 214.7800n 0.000904 214.7900n 0.001063
+ 214.8000n 0.001199 214.8100n 0.001309 214.8200n 0.001392 214.8300n 0.001444 214.8400n 0.001465 214.8500n 0.001453 214.8600n 0.001408 214.8700n 0.001329 214.8800n 0.001219 214.8900n 0.001078 214.9000n 0.000909 214.9100n 0.000713 214.9200n 0.000495 214.9300n 0.000257 214.9400n 0.000004
+ 214.9500n -0.000260 214.9600n -0.000530 214.9700n -0.000802 214.9800n -0.001072 214.9900n -0.001334 215.0000n -0.001585 215.0100n -0.001819 215.0200n -0.002034 215.0300n -0.002225 215.0400n -0.002390 215.0500n -0.002526 215.0600n -0.002632 215.0700n -0.002705 215.0800n -0.002747 215.0900n -0.002755
+ 215.1000n -0.002732 215.1100n -0.002678 215.1200n -0.002596 215.1300n -0.002488 215.1400n -0.002357 215.1500n -0.002206 215.1600n -0.002039 215.1700n -0.001860 215.1800n -0.001673 215.1900n -0.001483 215.2000n -0.001294 215.2100n -0.001109 215.2200n -0.000934 215.2300n -0.000772 215.2400n -0.000626
+ 215.2500n -0.000499 215.2600n -0.000394 215.2700n -0.000312 215.2800n -0.000255 215.2900n -0.000224 215.3000n -0.000219 215.3100n -0.000239 215.3200n -0.000284 215.3300n -0.000352 215.3400n -0.000440 215.3500n -0.000547 215.3600n -0.000669 215.3700n -0.000803 215.3800n -0.000945 215.3900n -0.001093
+ 215.4000n -0.001241 215.4100n -0.001386 215.4200n -0.001525 215.4300n -0.001653 215.4400n -0.001768 215.4500n -0.001867 215.4600n -0.001946 215.4700n -0.002005 215.4800n -0.002041 215.4900n -0.002053 215.5000n -0.002040 215.5100n -0.002002 215.5200n -0.001941 215.5300n -0.001856 215.5400n -0.001749
+ 215.5500n -0.001623 215.5600n -0.001479 215.5700n -0.001320 215.5800n -0.001150 215.5900n -0.000970 215.6000n -0.000785 215.6100n -0.000598 215.6200n -0.000412 215.6300n -0.000231 215.6400n -0.000057 215.6500n 0.000107 215.6600n 0.000257 215.6700n 0.000393 215.6800n 0.000511 215.6900n 0.000612
+ 215.7000n 0.000692 215.7100n 0.000753 215.7200n 0.000793 215.7300n 0.000813 215.7400n 0.000814 215.7500n 0.000797 215.7600n 0.000762 215.7700n 0.000712 215.7800n 0.000649 215.7900n 0.000574 215.8000n 0.000489 215.8100n 0.000398 215.8200n 0.000301 215.8300n 0.000201 215.8400n 0.000100
+ 215.8500n -0.000000 215.8600n -0.000098 215.8700n -0.000193 215.8800n -0.000283 215.8900n -0.000367 215.9000n -0.000446 215.9100n -0.000520 215.9200n -0.000587 215.9300n -0.000650 215.9400n -0.000708 215.9500n -0.000763 215.9600n -0.000816 215.9700n -0.000867 215.9800n -0.000918 215.9900n -0.000971
+ 216.0000n -0.001027 216.0100n -0.001086 216.0200n -0.001149 216.0300n -0.001218 216.0400n -0.001293 216.0500n -0.001374 216.0600n -0.001461 216.0700n -0.001553 216.0800n -0.001650 216.0900n -0.001750 216.1000n -0.001852 216.1100n -0.001955 216.1200n -0.002055 216.1300n -0.002151 216.1400n -0.002240
+ 216.1500n -0.002320 216.1600n -0.002387 216.1700n -0.002440 216.1800n -0.002474 216.1900n -0.002489 216.2000n -0.002481 216.2100n -0.002449 216.2200n -0.002391 216.2300n -0.002305 216.2400n -0.002192 216.2500n -0.002050 216.2600n -0.001880 216.2700n -0.001683 216.2800n -0.001461 216.2900n -0.001215
+ 216.3000n -0.000947 216.3100n -0.000662 216.3200n -0.000362 216.3300n -0.000052 216.3400n 0.000265 216.3500n 0.000583 216.3600n 0.000898 216.3700n 0.001205 216.3800n 0.001499 216.3900n 0.001776 216.4000n 0.002030 216.4100n 0.002258 216.4200n 0.002455 216.4300n 0.002618 216.4400n 0.002745
+ 216.4500n 0.002832 216.4600n 0.002879 216.4700n 0.002884 216.4800n 0.002847 216.4900n 0.002769 216.5000n 0.002652 216.5100n 0.002497 216.5200n 0.002307 216.5300n 0.002085 216.5400n 0.001836 216.5500n 0.001564 216.5600n 0.001274 216.5700n 0.000971 216.5800n 0.000662 216.5900n 0.000351
+ 216.6000n 0.000044 216.6100n -0.000253 216.6200n -0.000534 216.6300n -0.000795 216.6400n -0.001031 216.6500n -0.001238 216.6600n -0.001412 216.6700n -0.001551 216.6800n -0.001651 216.6900n -0.001713 216.7000n -0.001734 216.7100n -0.001715 216.7200n -0.001657 216.7300n -0.001562 216.7400n -0.001431
+ 216.7500n -0.001268 216.7600n -0.001076 216.7700n -0.000860 216.7800n -0.000623 216.7900n -0.000370 216.8000n -0.000107 216.8100n 0.000162 216.8200n 0.000431 216.8300n 0.000696 216.8400n 0.000951 216.8500n 0.001193 216.8600n 0.001417 216.8700n 0.001620 216.8800n 0.001799 216.8900n 0.001950
+ 216.9000n 0.002073 216.9100n 0.002166 216.9200n 0.002229 216.9300n 0.002261 216.9400n 0.002265 216.9500n 0.002240 216.9600n 0.002189 216.9700n 0.002115 216.9800n 0.002020 216.9900n 0.001908 217.0000n 0.001782 217.0100n 0.001645 217.0200n 0.001503 217.0300n 0.001357 217.0400n 0.001213
+ 217.0500n 0.001073 217.0600n 0.000941 217.0700n 0.000820 217.0800n 0.000711 217.0900n 0.000617 217.1000n 0.000540 217.1100n 0.000480 217.1200n 0.000437 217.1300n 0.000412 217.1400n 0.000404 217.1500n 0.000412 217.1600n 0.000433 217.1700n 0.000467 217.1800n 0.000510 217.1900n 0.000560
+ 217.2000n 0.000613 217.2100n 0.000668 217.2200n 0.000721 217.2300n 0.000768 217.2400n 0.000807 217.2500n 0.000836 217.2600n 0.000851 217.2700n 0.000852 217.2800n 0.000835 217.2900n 0.000801 217.3000n 0.000748 217.3100n 0.000676 217.3200n 0.000586 217.3300n 0.000478 217.3400n 0.000354
+ 217.3500n 0.000216 217.3600n 0.000066 217.3700n -0.000094 217.3800n -0.000260 217.3900n -0.000428 217.4000n -0.000597 217.4100n -0.000761 217.4200n -0.000919 217.4300n -0.001065 217.4400n -0.001197 217.4500n -0.001312 217.4600n -0.001406 217.4700n -0.001479 217.4800n -0.001528 217.4900n -0.001551
+ 217.5000n -0.001548 217.5100n -0.001518 217.5200n -0.001462 217.5300n -0.001381 217.5400n -0.001276 217.5500n -0.001150 217.5600n -0.001004 217.5700n -0.000842 217.5800n -0.000668 217.5900n -0.000484 217.6000n -0.000295 217.6100n -0.000105 217.6200n 0.000082 217.6300n 0.000262 217.6400n 0.000432
+ 217.6500n 0.000587 217.6600n 0.000723 217.6700n 0.000839 217.6800n 0.000932 217.6900n 0.000999 217.7000n 0.001039 217.7100n 0.001051 217.7200n 0.001036 217.7300n 0.000993 217.7400n 0.000924 217.7500n 0.000830 217.7600n 0.000714 217.7700n 0.000579 217.7800n 0.000428 217.7900n 0.000265
+ 217.8000n 0.000094 217.8100n -0.000081 217.8200n -0.000255 217.8300n -0.000423 217.8400n -0.000581 217.8500n -0.000724 217.8600n -0.000849 217.8700n -0.000951 217.8800n -0.001026 217.8900n -0.001073 217.9000n -0.001087 217.9100n -0.001069 217.9200n -0.001016 217.9300n -0.000927 217.9400n -0.000804
+ 217.9500n -0.000647 217.9600n -0.000458 217.9700n -0.000239 217.9800n 0.000007 217.9900n 0.000276 218.0000n 0.000564 218.0100n 0.000868 218.0200n 0.001181 218.0300n 0.001499 218.0400n 0.001816 218.0500n 0.002128 218.0600n 0.002428 218.0700n 0.002713 218.0800n 0.002975 218.0900n 0.003212
+ 218.1000n 0.003419 218.1100n 0.003592 218.1200n 0.003728 218.1300n 0.003824 218.1400n 0.003879 218.1500n 0.003891 218.1600n 0.003860 218.1700n 0.003787 218.1800n 0.003671 218.1900n 0.003515 218.2000n 0.003322 218.2100n 0.003093 218.2200n 0.002833 218.2300n 0.002545 218.2400n 0.002234
+ 218.2500n 0.001905 218.2600n 0.001562 218.2700n 0.001210 218.2800n 0.000855 218.2900n 0.000502 218.3000n 0.000156 218.3100n -0.000179 218.3200n -0.000498 218.3300n -0.000798 218.3400n -0.001073 218.3500n -0.001322 218.3600n -0.001541 218.3700n -0.001728 218.3800n -0.001882 218.3900n -0.002003
+ 218.4000n -0.002088 218.4100n -0.002140 218.4200n -0.002159 218.4300n -0.002146 218.4400n -0.002103 218.4500n -0.002032 218.4600n -0.001937 218.4700n -0.001820 218.4800n -0.001684 218.4900n -0.001534 218.5000n -0.001372 218.5100n -0.001203 218.5200n -0.001029 218.5300n -0.000856 218.5400n -0.000685
+ 218.5500n -0.000520 218.5600n -0.000365 218.5700n -0.000221 218.5800n -0.000091 218.5900n 0.000023 218.6000n 0.000120 218.6100n 0.000198 218.6200n 0.000259 218.6300n 0.000300 218.6400n 0.000323 218.6500n 0.000328 218.6600n 0.000316 218.6700n 0.000290 218.6800n 0.000250 218.6900n 0.000198
+ 218.7000n 0.000138 218.7100n 0.000070 218.7200n -0.000002 218.7300n -0.000075 218.7400n -0.000147 218.7500n -0.000217 218.7600n -0.000280 218.7700n -0.000335 218.7800n -0.000380 218.7900n -0.000414 218.8000n -0.000434 218.8100n -0.000439 218.8200n -0.000429 218.8300n -0.000403 218.8400n -0.000360
+ 218.8500n -0.000301 218.8600n -0.000227 218.8700n -0.000138 218.8800n -0.000036 218.8900n 0.000078 218.9000n 0.000202 218.9100n 0.000335 218.9200n 0.000473 218.9300n 0.000614 218.9400n 0.000757 218.9500n 0.000897 218.9600n 0.001032 218.9700n 0.001160 218.9800n 0.001278 218.9900n 0.001383
+ 219.0000n 0.001474 219.0100n 0.001547 219.0200n 0.001601 219.0300n 0.001633 219.0400n 0.001644 219.0500n 0.001631 219.0600n 0.001594 219.0700n 0.001533 219.0800n 0.001447 219.0900n 0.001337 219.1000n 0.001203 219.1100n 0.001048 219.1200n 0.000872 219.1300n 0.000677 219.1400n 0.000466
+ 219.1500n 0.000241 219.1600n 0.000005 219.1700n -0.000239 219.1800n -0.000488 219.1900n -0.000739 219.2000n -0.000989 219.2100n -0.001233 219.2200n -0.001469 219.2300n -0.001693 219.2400n -0.001902 219.2500n -0.002094 219.2600n -0.002265 219.2700n -0.002412 219.2800n -0.002534 219.2900n -0.002629
+ 219.3000n -0.002695 219.3100n -0.002731 219.3200n -0.002737 219.3300n -0.002712 219.3400n -0.002656 219.3500n -0.002571 219.3600n -0.002457 219.3700n -0.002316 219.3800n -0.002149 219.3900n -0.001960 219.4000n -0.001750 219.4100n -0.001523 219.4200n -0.001281 219.4300n -0.001029 219.4400n -0.000769
+ 219.4500n -0.000506 219.4600n -0.000243 219.4700n 0.000017 219.4800n 0.000269 219.4900n 0.000510 219.5000n 0.000738 219.5100n 0.000948 219.5200n 0.001139 219.5300n 0.001308 219.5400n 0.001453 219.5500n 0.001572 219.5600n 0.001664 219.5700n 0.001729 219.5800n 0.001765 219.5900n 0.001774
+ 219.6000n 0.001756 219.6100n 0.001712 219.6200n 0.001642 219.6300n 0.001550 219.6400n 0.001437 219.6500n 0.001306 219.6600n 0.001159 219.6700n 0.000999 219.6800n 0.000829 219.6900n 0.000653 219.7000n 0.000473 219.7100n 0.000293 219.7200n 0.000115 219.7300n -0.000058 219.7400n -0.000222
+ 219.7500n -0.000376 219.7600n -0.000517 219.7700n -0.000644 219.7800n -0.000755 219.7900n -0.000848 219.8000n -0.000924 219.8100n -0.000981 219.8200n -0.001020 219.8300n -0.001041 219.8400n -0.001045 219.8500n -0.001033 219.8600n -0.001005 219.8700n -0.000964 219.8800n -0.000912 219.8900n -0.000850
+ 219.9000n -0.000780 219.9100n -0.000704 219.9200n -0.000626 219.9300n -0.000545 219.9400n -0.000466 219.9500n -0.000388 219.9600n -0.000315 219.9700n -0.000248 219.9800n -0.000187 219.9900n -0.000134 220.0000n -0.000089 220.0100n -0.000053 220.0200n -0.000026 220.0300n -0.000007 220.0400n 0.000004
+ 220.0500n 0.000008 220.0600n 0.000006 220.0700n -0.000001 220.0800n -0.000011 220.0900n -0.000023 220.1000n -0.000035 220.1100n -0.000046 220.1200n -0.000053 220.1300n -0.000056 220.1400n -0.000052 220.1500n -0.000041 220.1600n -0.000021 220.1700n 0.000009 220.1800n 0.000049 220.1900n 0.000100
+ 220.2000n 0.000162 220.2100n 0.000234 220.2200n 0.000315 220.2300n 0.000406 220.2400n 0.000504 220.2500n 0.000607 220.2600n 0.000715 220.2700n 0.000825 220.2800n 0.000935 220.2900n 0.001043 220.3000n 0.001145 220.3100n 0.001239 220.3200n 0.001324 220.3300n 0.001396 220.3400n 0.001453
+ 220.3500n 0.001493 220.3600n 0.001514 220.3700n 0.001515 220.3800n 0.001493 220.3900n 0.001449 220.4000n 0.001382 220.4100n 0.001291 220.4200n 0.001177 220.4300n 0.001040 220.4400n 0.000882 220.4500n 0.000705 220.4600n 0.000509 220.4700n 0.000297 220.4800n 0.000072 220.4900n -0.000163
+ 220.5000n -0.000405 220.5100n -0.000652 220.5200n -0.000899 220.5300n -0.001143 220.5400n -0.001382 220.5500n -0.001610 220.5600n -0.001826 220.5700n -0.002027 220.5800n -0.002209 220.5900n -0.002370 220.6000n -0.002508 220.6100n -0.002622 220.6200n -0.002709 220.6300n -0.002768 220.6400n -0.002800
+ 220.6500n -0.002804 220.6600n -0.002781 220.6700n -0.002730 220.6800n -0.002654 220.6900n -0.002553 220.7000n -0.002430 220.7100n -0.002286 220.7200n -0.002124 220.7300n -0.001946 220.7400n -0.001755 220.7500n -0.001555 220.7600n -0.001346 220.7700n -0.001133 220.7800n -0.000918 220.7900n -0.000704
+ 220.8000n -0.000493 220.8100n -0.000287 220.8200n -0.000089 220.8300n 0.000100 220.8400n 0.000278 220.8500n 0.000444 220.8600n 0.000596 220.8700n 0.000735 220.8800n 0.000859 220.8900n 0.000969 220.9000n 0.001065 220.9100n 0.001146 220.9200n 0.001214 220.9300n 0.001268 220.9400n 0.001311
+ 220.9500n 0.001342 220.9600n 0.001363 220.9700n 0.001374 220.9800n 0.001377 220.9900n 0.001372 221.0000n 0.001361 221.0100n 0.001344 221.0200n 0.001322 221.0300n 0.001295 221.0400n 0.001265 221.0500n 0.001231 221.0600n 0.001193 221.0700n 0.001152 221.0800n 0.001107 221.0900n 0.001059
+ 221.1000n 0.001008 221.1100n 0.000952 221.1200n 0.000892 221.1300n 0.000828 221.1400n 0.000760 221.1500n 0.000686 221.1600n 0.000607 221.1700n 0.000524 221.1800n 0.000435 221.1900n 0.000342 221.2000n 0.000245 221.2100n 0.000143 221.2200n 0.000038 221.2300n -0.000069 221.2400n -0.000177
+ 221.2500n -0.000285 221.2600n -0.000393 221.2700n -0.000498 221.2800n -0.000600 221.2900n -0.000696 221.3000n -0.000786 221.3100n -0.000868 221.3200n -0.000940 221.3300n -0.001000 221.3400n -0.001049 221.3500n -0.001085 221.3600n -0.001106 221.3700n -0.001113 221.3800n -0.001104 221.3900n -0.001079
+ 221.4000n -0.001040 221.4100n -0.000985 221.4200n -0.000915 221.4300n -0.000832 221.4400n -0.000736 221.4500n -0.000629 221.4600n -0.000513 221.4700n -0.000389 221.4800n -0.000259 221.4900n -0.000125 221.5000n 0.000011 221.5100n 0.000145 221.5200n 0.000277 221.5300n 0.000404 221.5400n 0.000524
+ 221.5500n 0.000635 221.5600n 0.000735 221.5700n 0.000823 221.5800n 0.000897 221.5900n 0.000957 221.6000n 0.001001 221.6100n 0.001029 221.6200n 0.001041 221.6300n 0.001037 221.6400n 0.001017 221.6500n 0.000983 221.6600n 0.000936 221.6700n 0.000876 221.6800n 0.000806 221.6900n 0.000727
+ 221.7000n 0.000640 221.7100n 0.000549 221.7200n 0.000455 221.7300n 0.000361 221.7400n 0.000268 221.7500n 0.000178 221.7600n 0.000094 221.7700n 0.000017 221.7800n -0.000051 221.7900n -0.000109 221.8000n -0.000156 221.8100n -0.000190 221.8200n -0.000212 221.8300n -0.000221 221.8400n -0.000217
+ 221.8500n -0.000201 221.8600n -0.000173 221.8700n -0.000133 221.8800n -0.000084 221.8900n -0.000026 221.9000n 0.000038 221.9100n 0.000108 221.9200n 0.000182 221.9300n 0.000257 221.9400n 0.000332 221.9500n 0.000405 221.9600n 0.000475 221.9700n 0.000538 221.9800n 0.000595 221.9900n 0.000643
+ 222.0000n 0.000682 222.0100n 0.000710 222.0200n 0.000728 222.0300n 0.000734 222.0400n 0.000728 222.0500n 0.000711 222.0600n 0.000682 222.0700n 0.000644 222.0800n 0.000595 222.0900n 0.000539 222.1000n 0.000475 222.1100n 0.000406 222.1200n 0.000332 222.1300n 0.000256 222.1400n 0.000180
+ 222.1500n 0.000104 222.1600n 0.000031 222.1700n -0.000037 222.1800n -0.000100 222.1900n -0.000156 222.2000n -0.000203 222.2100n -0.000241 222.2200n -0.000268 222.2300n -0.000285 222.2400n -0.000290 222.2500n -0.000284 222.2600n -0.000266 222.2700n -0.000238 222.2800n -0.000199 222.2900n -0.000151
+ 222.3000n -0.000093 222.3100n -0.000028 222.3200n 0.000043 222.3300n 0.000120 222.3400n 0.000200 222.3500n 0.000283 222.3600n 0.000367 222.3700n 0.000450 222.3800n 0.000531 222.3900n 0.000609 222.4000n 0.000683 222.4100n 0.000752 222.4200n 0.000814 222.4300n 0.000869 222.4400n 0.000916
+ 222.4500n 0.000956 222.4600n 0.000987 222.4700n 0.001011 222.4800n 0.001026 222.4900n 0.001034 222.5000n 0.001034 222.5100n 0.001028 222.5200n 0.001017 222.5300n 0.001000 222.5400n 0.000980 222.5500n 0.000957 222.5600n 0.000932 222.5700n 0.000907 222.5800n 0.000882 222.5900n 0.000859
+ 222.6000n 0.000839 222.6100n 0.000822 222.6200n 0.000810 222.6300n 0.000803 222.6400n 0.000803 222.6500n 0.000809 222.6600n 0.000822 222.6700n 0.000843 222.6800n 0.000872 222.6900n 0.000909 222.7000n 0.000953 222.7100n 0.001005 222.7200n 0.001065 222.7300n 0.001132 222.7400n 0.001205
+ 222.7500n 0.001284 222.7600n 0.001369 222.7700n 0.001458 222.7800n 0.001551 222.7900n 0.001646 222.8000n 0.001744 222.8100n 0.001842 222.8200n 0.001941 222.8300n 0.002038 222.8400n 0.002133 222.8500n 0.002224 222.8600n 0.002311 222.8700n 0.002392 222.8800n 0.002466 222.8900n 0.002533
+ 222.9000n 0.002590 222.9100n 0.002638 222.9200n 0.002675 222.9300n 0.002700 222.9400n 0.002712 222.9500n 0.002711 222.9600n 0.002696 222.9700n 0.002666 222.9800n 0.002622 222.9900n 0.002562 223.0000n 0.002486 223.0100n 0.002395 223.0200n 0.002289 223.0300n 0.002168 223.0400n 0.002033
+ 223.0500n 0.001885 223.0600n 0.001724 223.0700n 0.001552 223.0800n 0.001370 223.0900n 0.001180 223.1000n 0.000983 223.1100n 0.000782 223.1200n 0.000578 223.1300n 0.000374 223.1400n 0.000171 223.1500n -0.000027 223.1600n -0.000218 223.1700n -0.000401 223.1800n -0.000572 223.1900n -0.000730
+ 223.2000n -0.000873 223.2100n -0.000998 223.2200n -0.001104 223.2300n -0.001190 223.2400n -0.001255 223.2500n -0.001298 223.2600n -0.001318 223.2700n -0.001315 223.2800n -0.001290 223.2900n -0.001243 223.3000n -0.001175 223.3100n -0.001089 223.3200n -0.000985 223.3300n -0.000867 223.3400n -0.000736
+ 223.3500n -0.000595 223.3600n -0.000448 223.3700n -0.000297 223.3800n -0.000146 223.3900n 0.000001 223.4000n 0.000142 223.4100n 0.000272 223.4200n 0.000390 223.4300n 0.000491 223.4400n 0.000573 223.4500n 0.000634 223.4600n 0.000671 223.4700n 0.000684 223.4800n 0.000670 223.4900n 0.000630
+ 223.5000n 0.000563 223.5100n 0.000471 223.5200n 0.000353 223.5300n 0.000212 223.5400n 0.000049 223.5500n -0.000132 223.5600n -0.000329 223.5700n -0.000538 223.5800n -0.000756 223.5900n -0.000979 223.6000n -0.001202 223.6100n -0.001421 223.6200n -0.001631 223.6300n -0.001830 223.6400n -0.002013
+ 223.6500n -0.002175 223.6600n -0.002315 223.6700n -0.002428 223.6800n -0.002513 223.6900n -0.002567 223.7000n -0.002590 223.7100n -0.002581 223.7200n -0.002539 223.7300n -0.002466 223.7400n -0.002364 223.7500n -0.002233 223.7600n -0.002078 223.7700n -0.001901 223.7800n -0.001706 223.7900n -0.001497
+ 223.8000n -0.001280 223.8100n -0.001058 223.8200n -0.000837 223.8300n -0.000623 223.8400n -0.000419 223.8500n -0.000232 223.8600n -0.000065 223.8700n 0.000076 223.8800n 0.000190 223.8900n 0.000271 223.9000n 0.000318 223.9100n 0.000328 223.9200n 0.000301 223.9300n 0.000237 223.9400n 0.000136
+ 223.9500n -0.000002 223.9600n -0.000173 223.9700n -0.000374 223.9800n -0.000603 223.9900n -0.000855 224.0000n -0.001124 224.0100n -0.001407 224.0200n -0.001696 224.0300n -0.001986 224.0400n -0.002272 224.0500n -0.002546 224.0600n -0.002804 224.0700n -0.003039 224.0800n -0.003246 224.0900n -0.003421
+ 224.1000n -0.003559 224.1100n -0.003657 224.1200n -0.003712 224.1300n -0.003722 224.1400n -0.003687 224.1500n -0.003607 224.1600n -0.003482 224.1700n -0.003315 224.1800n -0.003108 224.1900n -0.002864 224.2000n -0.002590 224.2100n -0.002288 224.2200n -0.001967 224.2300n -0.001631 224.2400n -0.001287
+ 224.2500n -0.000942 224.2600n -0.000603 224.2700n -0.000277 224.2800n 0.000030 224.2900n 0.000310 224.3000n 0.000559 224.3100n 0.000771 224.3200n 0.000942 224.3300n 0.001067 224.3400n 0.001145 224.3500n 0.001172 224.3600n 0.001149 224.3700n 0.001076 224.3800n 0.000953 224.3900n 0.000784
+ 224.4000n 0.000570 224.4100n 0.000317 224.4200n 0.000029 224.4300n -0.000288 224.4400n -0.000627 224.4500n -0.000983 224.4600n -0.001348 224.4700n -0.001714 224.4800n -0.002074 224.4900n -0.002421 224.5000n -0.002748 224.5100n -0.003047 224.5200n -0.003314 224.5300n -0.003542 224.5400n -0.003726
+ 224.5500n -0.003864 224.5600n -0.003951 224.5700n -0.003985 224.5800n -0.003966 224.5900n -0.003894 224.6000n -0.003770 224.6100n -0.003595 224.6200n -0.003374 224.6300n -0.003109 224.6400n -0.002807 224.6500n -0.002471 224.6600n -0.002108 224.6700n -0.001725 224.6800n -0.001328 224.6900n -0.000925
+ 224.7000n -0.000523 224.7100n -0.000128 224.7200n 0.000253 224.7300n 0.000613 224.7400n 0.000947 224.7500n 0.001249 224.7600n 0.001514 224.7700n 0.001740 224.7800n 0.001923 224.7900n 0.002060 224.8000n 0.002152 224.8100n 0.002197 224.8200n 0.002196 224.8300n 0.002151 224.8400n 0.002065
+ 224.8500n 0.001940 224.8600n 0.001780 224.8700n 0.001590 224.8800n 0.001374 224.8900n 0.001138 224.9000n 0.000888 224.9100n 0.000627 224.9200n 0.000363 224.9300n 0.000101 224.9400n -0.000155 224.9500n -0.000399 224.9600n -0.000628 224.9700n -0.000837 224.9800n -0.001023 224.9900n -0.001183
+ 225.0000n -0.001316 225.0100n -0.001421 225.0200n -0.001497 225.0300n -0.001544 225.0400n -0.001563 225.0500n -0.001555 225.0600n -0.001524 225.0700n -0.001471 225.0800n -0.001399 225.0900n -0.001311 225.1000n -0.001212 225.1100n -0.001104 225.1200n -0.000992 225.1300n -0.000878 225.1400n -0.000767
+ 225.1500n -0.000662 225.1600n -0.000566 225.1700n -0.000481 225.1800n -0.000409 225.1900n -0.000351 225.2000n -0.000310 225.2100n -0.000284 225.2200n -0.000275 225.2300n -0.000282 225.2400n -0.000304 225.2500n -0.000338 225.2600n -0.000384 225.2700n -0.000439 225.2800n -0.000500 225.2900n -0.000565
+ 225.3000n -0.000631 225.3100n -0.000694 225.3200n -0.000753 225.3300n -0.000803 225.3400n -0.000844 225.3500n -0.000872 225.3600n -0.000885 225.3700n -0.000882 225.3800n -0.000862 225.3900n -0.000825 225.4000n -0.000769 225.4100n -0.000696 225.4200n -0.000606 225.4300n -0.000500 225.4400n -0.000381
+ 225.4500n -0.000249 225.4600n -0.000109 225.4700n 0.000038 225.4800n 0.000189 225.4900n 0.000340 225.5000n 0.000488 225.5100n 0.000632 225.5200n 0.000766 225.5300n 0.000889 225.5400n 0.000999 225.5500n 0.001092 225.5600n 0.001167 225.5700n 0.001223 225.5800n 0.001258 225.5900n 0.001273
+ 225.6000n 0.001267 225.6100n 0.001241 225.6200n 0.001195 225.6300n 0.001131 225.6400n 0.001052 225.6500n 0.000958 225.6600n 0.000853 225.6700n 0.000740 225.6800n 0.000621 225.6900n 0.000499 225.7000n 0.000378 225.7100n 0.000261 225.7200n 0.000149 225.7300n 0.000047 225.7400n -0.000043
+ 225.7500n -0.000121 225.7600n -0.000183 225.7700n -0.000229 225.7800n -0.000257 225.7900n -0.000269 225.8000n -0.000263 225.8100n -0.000241 225.8200n -0.000204 225.8300n -0.000153 225.8400n -0.000091 225.8500n -0.000019 225.8600n 0.000059 225.8700n 0.000140 225.8800n 0.000222 225.8900n 0.000301
+ 225.9000n 0.000375 225.9100n 0.000440 225.9200n 0.000493 225.9300n 0.000533 225.9400n 0.000556 225.9500n 0.000561 225.9600n 0.000546 225.9700n 0.000511 225.9800n 0.000454 225.9900n 0.000377 226.0000n 0.000279 226.0100n 0.000162 226.0200n 0.000026 226.0300n -0.000125 226.0400n -0.000289
+ 226.0500n -0.000464 226.0600n -0.000647 226.0700n -0.000834 226.0800n -0.001021 226.0900n -0.001207 226.1000n -0.001386 226.1100n -0.001556 226.1200n -0.001714 226.1300n -0.001856 226.1400n -0.001981 226.1500n -0.002086 226.1600n -0.002169 226.1700n -0.002230 226.1800n -0.002268 226.1900n -0.002283
+ 226.2000n -0.002276 226.2100n -0.002246 226.2200n -0.002197 226.2300n -0.002131 226.2400n -0.002049 226.2500n -0.001954 226.2600n -0.001851 226.2700n -0.001742 226.2800n -0.001631 226.2900n -0.001521 226.3000n -0.001416 226.3100n -0.001320 226.3200n -0.001236 226.3300n -0.001166 226.3400n -0.001114
+ 226.3500n -0.001081 226.3600n -0.001070 226.3700n -0.001081 226.3800n -0.001115 226.3900n -0.001171 226.4000n -0.001250 226.4100n -0.001350 226.4200n -0.001469 226.4300n -0.001604 226.4400n -0.001754 226.4500n -0.001914 226.4600n -0.002081 226.4700n -0.002251 226.4800n -0.002420 226.4900n -0.002584
+ 226.5000n -0.002739 226.5100n -0.002880 226.5200n -0.003004 226.5300n -0.003107 226.5400n -0.003186 226.5500n -0.003238 226.5600n -0.003261 226.5700n -0.003253 226.5800n -0.003213 226.5900n -0.003140 226.6000n -0.003035 226.6100n -0.002898 226.6200n -0.002731 226.6300n -0.002536 226.6400n -0.002316
+ 226.6500n -0.002073 226.6600n -0.001811 226.6700n -0.001535 226.6800n -0.001248 226.6900n -0.000955 226.7000n -0.000659 226.7100n -0.000367 226.7200n -0.000081 226.7300n 0.000193 226.7400n 0.000453 226.7500n 0.000694 226.7600n 0.000913 226.7700n 0.001109 226.7800n 0.001278 226.7900n 0.001419
+ 226.8000n 0.001532 226.8100n 0.001616 226.8200n 0.001672 226.8300n 0.001701 226.8400n 0.001704 226.8500n 0.001683 226.8600n 0.001641 226.8700n 0.001581 226.8800n 0.001506 226.8900n 0.001419 226.9000n 0.001324 226.9100n 0.001225 226.9200n 0.001125 226.9300n 0.001028 226.9400n 0.000936
+ 226.9500n 0.000854 226.9600n 0.000783 226.9700n 0.000725 226.9800n 0.000683 226.9900n 0.000657 227.0000n 0.000648 227.0100n 0.000656 227.0200n 0.000681 227.0300n 0.000722 227.0400n 0.000776 227.0500n 0.000843 227.0600n 0.000920 227.0700n 0.001004 227.0800n 0.001092 227.0900n 0.001180
+ 227.1000n 0.001267 227.1100n 0.001347 227.1200n 0.001419 227.1300n 0.001478 227.1400n 0.001523 227.1500n 0.001549 227.1600n 0.001556 227.1700n 0.001542 227.1800n 0.001505 227.1900n 0.001444 227.2000n 0.001359 227.2100n 0.001251 227.2200n 0.001120 227.2300n 0.000969 227.2400n 0.000799
+ 227.2500n 0.000612 227.2600n 0.000411 227.2700n 0.000201 227.2800n -0.000017 227.2900n -0.000237 227.3000n -0.000456 227.3100n -0.000670 227.3200n -0.000875 227.3300n -0.001067 227.3400n -0.001243 227.3500n -0.001399 227.3600n -0.001532 227.3700n -0.001640 227.3800n -0.001721 227.3900n -0.001773
+ 227.4000n -0.001796 227.4100n -0.001788 227.4200n -0.001751 227.4300n -0.001684 227.4400n -0.001590 227.4500n -0.001471 227.4600n -0.001328 227.4700n -0.001165 227.4800n -0.000984 227.4900n -0.000790 227.5000n -0.000586 227.5100n -0.000376 227.5200n -0.000164 227.5300n 0.000046 227.5400n 0.000251
+ 227.5500n 0.000446 227.5600n 0.000629 227.5700n 0.000796 227.5800n 0.000945 227.5900n 0.001074 227.6000n 0.001181 227.6100n 0.001265 227.6200n 0.001325 227.6300n 0.001361 227.6400n 0.001374 227.6500n 0.001364 227.6600n 0.001334 227.6700n 0.001284 227.6800n 0.001218 227.6900n 0.001137
+ 227.7000n 0.001044 227.7100n 0.000943 227.7200n 0.000837 227.7300n 0.000728 227.7400n 0.000619 227.7500n 0.000515 227.7600n 0.000416 227.7700n 0.000327 227.7800n 0.000248 227.7900n 0.000183 227.8000n 0.000131 227.8100n 0.000095 227.8200n 0.000075 227.8300n 0.000071 227.8400n 0.000082
+ 227.8500n 0.000108 227.8600n 0.000148 227.8700n 0.000200 227.8800n 0.000262 227.8900n 0.000332 227.9000n 0.000408 227.9100n 0.000487 227.9200n 0.000566 227.9300n 0.000643 227.9400n 0.000715 227.9500n 0.000780 227.9600n 0.000834 227.9700n 0.000877 227.9800n 0.000905 227.9900n 0.000918
+ 228.0000n 0.000915 228.0100n 0.000894 228.0200n 0.000855 228.0300n 0.000798 228.0400n 0.000725 228.0500n 0.000634 228.0600n 0.000529 228.0700n 0.000410 228.0800n 0.000280 228.0900n 0.000141 228.1000n -0.000005 228.1100n -0.000155 228.1200n -0.000307 228.1300n -0.000456 228.1400n -0.000601
+ 228.1500n -0.000739 228.1600n -0.000866 228.1700n -0.000981 228.1800n -0.001080 228.1900n -0.001163 228.2000n -0.001227 228.2100n -0.001271 228.2200n -0.001293 228.2300n -0.001294 228.2400n -0.001273 228.2500n -0.001229 228.2600n -0.001165 228.2700n -0.001080 228.2800n -0.000976 228.2900n -0.000854
+ 228.3000n -0.000716 228.3100n -0.000565 228.3200n -0.000402 228.3300n -0.000231 228.3400n -0.000053 228.3500n 0.000129 228.3600n 0.000312 228.3700n 0.000494 228.3800n 0.000672 228.3900n 0.000844 228.4000n 0.001008 228.4100n 0.001161 228.4200n 0.001303 228.4300n 0.001431 228.4400n 0.001545
+ 228.4500n 0.001642 228.4600n 0.001723 228.4700n 0.001788 228.4800n 0.001835 228.4900n 0.001865 228.5000n 0.001879 228.5100n 0.001876 228.5200n 0.001857 228.5300n 0.001824 228.5400n 0.001777 228.5500n 0.001716 228.5600n 0.001644 228.5700n 0.001562 228.5800n 0.001470 228.5900n 0.001369
+ 228.6000n 0.001262 228.6100n 0.001149 228.6200n 0.001031 228.6300n 0.000909 228.6400n 0.000785 228.6500n 0.000658 228.6600n 0.000531 228.6700n 0.000404 228.6800n 0.000277 228.6900n 0.000152 228.7000n 0.000029 228.7100n -0.000091 228.7200n -0.000209 228.7300n -0.000322 228.7400n -0.000430
+ 228.7500n -0.000534 228.7600n -0.000632 228.7700n -0.000723 228.7800n -0.000807 228.7900n -0.000884 228.8000n -0.000953 228.8100n -0.001013 228.8200n -0.001064 228.8300n -0.001104 228.8400n -0.001134 228.8500n -0.001154 228.8600n -0.001162 228.8700n -0.001159 228.8800n -0.001143 228.8900n -0.001117
+ 228.9000n -0.001078 228.9100n -0.001028 228.9200n -0.000967 228.9300n -0.000896 228.9400n -0.000814 228.9500n -0.000724 228.9600n -0.000626 228.9700n -0.000522 228.9800n -0.000412 228.9900n -0.000298 229.0000n -0.000182 229.0100n -0.000065 229.0200n 0.000052 229.0300n 0.000165 229.0400n 0.000275
+ 229.0500n 0.000379 229.0600n 0.000476 229.0700n 0.000564 229.0800n 0.000643 229.0900n 0.000710 229.1000n 0.000767 229.1100n 0.000811 229.1200n 0.000843 229.1300n 0.000863 229.1400n 0.000870 229.1500n 0.000865 229.1600n 0.000850 229.1700n 0.000824 229.1800n 0.000790 229.1900n 0.000749
+ 229.2000n 0.000701 229.2100n 0.000650 229.2200n 0.000597 229.2300n 0.000544 229.2400n 0.000493 229.2500n 0.000446 229.2600n 0.000404 229.2700n 0.000370 229.2800n 0.000345 229.2900n 0.000331 229.3000n 0.000328 229.3100n 0.000338 229.3200n 0.000360 229.3300n 0.000396 229.3400n 0.000445
+ 229.3500n 0.000507 229.3600n 0.000581 229.3700n 0.000666 229.3800n 0.000760 229.3900n 0.000861 229.4000n 0.000969 229.4100n 0.001079 229.4200n 0.001191 229.4300n 0.001302 229.4400n 0.001408 229.4500n 0.001508 229.4600n 0.001598 229.4700n 0.001678 229.4800n 0.001744 229.4900n 0.001794
+ 229.5000n 0.001826 229.5100n 0.001840 229.5200n 0.001834 229.5300n 0.001808 229.5400n 0.001761 229.5500n 0.001693 229.5600n 0.001606 229.5700n 0.001500 229.5800n 0.001377 229.5900n 0.001238 229.6000n 0.001086 229.6100n 0.000924 229.6200n 0.000753 229.6300n 0.000579 229.6400n 0.000402
+ 229.6500n 0.000228 229.6600n 0.000059 229.6700n -0.000102 229.6800n -0.000251 229.6900n -0.000386 229.7000n -0.000503 229.7100n -0.000601 229.7200n -0.000677 229.7300n -0.000731 229.7400n -0.000760 229.7500n -0.000764 229.7600n -0.000743 229.7700n -0.000698 229.7800n -0.000630 229.7900n -0.000539
+ 229.8000n -0.000428 229.8100n -0.000300 229.8200n -0.000157 229.8300n -0.000001 229.8400n 0.000162 229.8500n 0.000330 229.8600n 0.000499 229.8700n 0.000665 229.8800n 0.000824 229.8900n 0.000973 229.9000n 0.001107 229.9100n 0.001224 229.9200n 0.001320 229.9300n 0.001393 229.9400n 0.001440
+ 229.9500n 0.001459 229.9600n 0.001450 229.9700n 0.001412 229.9800n 0.001344 229.9900n 0.001247 230.0000n 0.001121 230.0100n 0.000970 230.0200n 0.000793 230.0300n 0.000595 230.0400n 0.000378 230.0500n 0.000145 230.0600n -0.000100 230.0700n -0.000353 230.0800n -0.000610 230.0900n -0.000867
+ 230.1000n -0.001120 230.1100n -0.001365 230.1200n -0.001599 230.1300n -0.001817 230.1400n -0.002016 230.1500n -0.002193 230.1600n -0.002346 230.1700n -0.002473 230.1800n -0.002572 230.1900n -0.002643 230.2000n -0.002685 230.2100n -0.002697 230.2200n -0.002682 230.2300n -0.002640 230.2400n -0.002572
+ 230.2500n -0.002482 230.2600n -0.002371 230.2700n -0.002243 230.2800n -0.002101 230.2900n -0.001948 230.3000n -0.001789 230.3100n -0.001626 230.3200n -0.001465 230.3300n -0.001308 230.3400n -0.001159 230.3500n -0.001022 230.3600n -0.000899 230.3700n -0.000794 230.3800n -0.000709 230.3900n -0.000646
+ 230.4000n -0.000606 230.4100n -0.000590 230.4200n -0.000600 230.4300n -0.000634 230.4400n -0.000693 230.4500n -0.000776 230.4600n -0.000881 230.4700n -0.001006 230.4800n -0.001150 230.4900n -0.001308 230.5000n -0.001480 230.5100n -0.001661 230.5200n -0.001848 230.5300n -0.002038 230.5400n -0.002227
+ 230.5500n -0.002411 230.5600n -0.002588 230.5700n -0.002754 230.5800n -0.002906 230.5900n -0.003041 230.6000n -0.003157 230.6100n -0.003250 230.6200n -0.003320 230.6300n -0.003365 230.6400n -0.003383 230.6500n -0.003375 230.6600n -0.003339 230.6700n -0.003276 230.6800n -0.003187 230.6900n -0.003072
+ 230.7000n -0.002933 230.7100n -0.002771 230.7200n -0.002589 230.7300n -0.002389 230.7400n -0.002172 230.7500n -0.001943 230.7600n -0.001704 230.7700n -0.001457 230.7800n -0.001206 230.7900n -0.000954 230.8000n -0.000704 230.8100n -0.000458 230.8200n -0.000220 230.8300n 0.000008 230.8400n 0.000223
+ 230.8500n 0.000424 230.8600n 0.000607 230.8700n 0.000772 230.8800n 0.000916 230.8900n 0.001039 230.9000n 0.001140 230.9100n 0.001218 230.9200n 0.001272 230.9300n 0.001304 230.9400n 0.001312 230.9500n 0.001298 230.9600n 0.001262 230.9700n 0.001206 230.9800n 0.001131 230.9900n 0.001039
+ 231.0000n 0.000931 231.0100n 0.000809 231.0200n 0.000675 231.0300n 0.000532 231.0400n 0.000383 231.0500n 0.000228 231.0600n 0.000071 231.0700n -0.000085 231.0800n -0.000239 231.0900n -0.000388 231.1000n -0.000529 231.1100n -0.000660 231.1200n -0.000780 231.1300n -0.000886 231.1400n -0.000976
+ 231.1500n -0.001049 231.1600n -0.001104 231.1700n -0.001139 231.1800n -0.001154 231.1900n -0.001147 231.2000n -0.001120 231.2100n -0.001071 231.2200n -0.001001 231.2300n -0.000910 231.2400n -0.000800 231.2500n -0.000672 231.2600n -0.000527 231.2700n -0.000368 231.2800n -0.000195 231.2900n -0.000011
+ 231.3000n 0.000181 231.3100n 0.000379 231.3200n 0.000579 231.3300n 0.000780 231.3400n 0.000978 231.3500n 0.001171 231.3600n 0.001355 231.3700n 0.001527 231.3800n 0.001686 231.3900n 0.001828 231.4000n 0.001952 231.4100n 0.002054 231.4200n 0.002133 231.4300n 0.002189 231.4400n 0.002219
+ 231.4500n 0.002223 231.4600n 0.002200 231.4700n 0.002151 231.4800n 0.002076 231.4900n 0.001976 231.5000n 0.001851 231.5100n 0.001705 231.5200n 0.001538 231.5300n 0.001352 231.5400n 0.001152 231.5500n 0.000938 231.5600n 0.000715 231.5700n 0.000486 231.5800n 0.000254 231.5900n 0.000023
+ 231.6000n -0.000204 231.6100n -0.000424 231.6200n -0.000634 231.6300n -0.000829 231.6400n -0.001008 231.6500n -0.001168 231.6600n -0.001306 231.6700n -0.001420 231.6800n -0.001510 231.6900n -0.001573 231.7000n -0.001610 231.7100n -0.001620 231.7200n -0.001603 231.7300n -0.001560 231.7400n -0.001492
+ 231.7500n -0.001400 231.7600n -0.001288 231.7700n -0.001156 231.7800n -0.001007 231.7900n -0.000845 231.8000n -0.000672 231.8100n -0.000492 231.8200n -0.000307 231.8300n -0.000122 231.8400n 0.000061 231.8500n 0.000239 231.8600n 0.000407 231.8700n 0.000564 231.8800n 0.000707 231.8900n 0.000834
+ 231.9000n 0.000942 231.9100n 0.001030 231.9200n 0.001097 231.9300n 0.001143 231.9400n 0.001166 231.9500n 0.001168 231.9600n 0.001148 231.9700n 0.001108 231.9800n 0.001048 231.9900n 0.000971 232.0000n 0.000879 232.0100n 0.000773 232.0200n 0.000656 232.0300n 0.000532 232.0400n 0.000402
+ 232.0500n 0.000270 232.0600n 0.000139 232.0700n 0.000010 232.0800n -0.000112 232.0900n -0.000226 232.1000n -0.000330 232.1100n -0.000420 232.1200n -0.000495 232.1300n -0.000555 232.1400n -0.000596 232.1500n -0.000620 232.1600n -0.000625 232.1700n -0.000611 232.1800n -0.000579 232.1900n -0.000528
+ 232.2000n -0.000461 232.2100n -0.000378 232.2200n -0.000280 232.2300n -0.000171 232.2400n -0.000051 232.2500n 0.000078 232.2600n 0.000212 232.2700n 0.000350 232.2800n 0.000490 232.2900n 0.000628 232.3000n 0.000763 232.3100n 0.000893 232.3200n 0.001014 232.3300n 0.001127 232.3400n 0.001227
+ 232.3500n 0.001316 232.3600n 0.001390 232.3700n 0.001449 232.3800n 0.001493 232.3900n 0.001520 232.4000n 0.001531 232.4100n 0.001526 232.4200n 0.001505 232.4300n 0.001469 232.4400n 0.001418 232.4500n 0.001354 232.4600n 0.001277 232.4700n 0.001189 232.4800n 0.001091 232.4900n 0.000985
+ 232.5000n 0.000872 232.5100n 0.000754 232.5200n 0.000632 232.5300n 0.000509 232.5400n 0.000385 232.5500n 0.000262 232.5600n 0.000141 232.5700n 0.000024 232.5800n -0.000089 232.5900n -0.000195 232.6000n -0.000295 232.6100n -0.000388 232.6200n -0.000472 232.6300n -0.000548 232.6400n -0.000614
+ 232.6500n -0.000671 232.6600n -0.000719 232.6700n -0.000756 232.6800n -0.000784 232.6900n -0.000803 232.7000n -0.000812 232.7100n -0.000811 232.7200n -0.000802 232.7300n -0.000783 232.7400n -0.000756 232.7500n -0.000721 232.7600n -0.000679 232.7700n -0.000629 232.7800n -0.000572 232.7900n -0.000508
+ 232.8000n -0.000439 232.8100n -0.000364 232.8200n -0.000283 232.8300n -0.000198 232.8400n -0.000109 232.8500n -0.000016 232.8600n 0.000080 232.8700n 0.000178 232.8800n 0.000279 232.8900n 0.000381 232.9000n 0.000484 232.9100n 0.000587 232.9200n 0.000690 232.9300n 0.000792 232.9400n 0.000892
+ 232.9500n 0.000990 232.9600n 0.001085 232.9700n 0.001177 232.9800n 0.001264 232.9900n 0.001348 233.0000n 0.001426 233.0100n 0.001500 233.0200n 0.001567 233.0300n 0.001629 233.0400n 0.001685 233.0500n 0.001735 233.0600n 0.001779 233.0700n 0.001817 233.0800n 0.001849 233.0900n 0.001876
+ 233.1000n 0.001897 233.1100n 0.001914 233.1200n 0.001927 233.1300n 0.001936 233.1400n 0.001941 233.1500n 0.001944 233.1600n 0.001945 233.1700n 0.001945 233.1800n 0.001944 233.1900n 0.001942 233.2000n 0.001941 233.2100n 0.001941 233.2200n 0.001941 233.2300n 0.001943 233.2400n 0.001946
+ 233.2500n 0.001952 233.2600n 0.001959 233.2700n 0.001967 233.2800n 0.001977 233.2900n 0.001988 233.3000n 0.002000 233.3100n 0.002013 233.3200n 0.002026 233.3300n 0.002038 233.3400n 0.002048 233.3500n 0.002057 233.3600n 0.002064 233.3700n 0.002068 233.3800n 0.002068 233.3900n 0.002064
+ 233.4000n 0.002056 233.4100n 0.002043 233.4200n 0.002024 233.4300n 0.002001 233.4400n 0.001972 233.4500n 0.001938 233.4600n 0.001898 233.4700n 0.001854 233.4800n 0.001806 233.4900n 0.001753 233.5000n 0.001697 233.5100n 0.001639 233.5200n 0.001579 233.5300n 0.001518 233.5400n 0.001457
+ 233.5500n 0.001397 233.5600n 0.001339 233.5700n 0.001283 233.5800n 0.001232 233.5900n 0.001184 233.6000n 0.001142 233.6100n 0.001105 233.6200n 0.001075 233.6300n 0.001051 233.6400n 0.001035 233.6500n 0.001025 233.6600n 0.001023 233.6700n 0.001027 233.6800n 0.001038 233.6900n 0.001055
+ 233.7000n 0.001078 233.7100n 0.001106 233.7200n 0.001138 233.7300n 0.001174 233.7400n 0.001212 233.7500n 0.001251 233.7600n 0.001291 233.7700n 0.001331 233.7800n 0.001369 233.7900n 0.001405 233.8000n 0.001438 233.8100n 0.001467 233.8200n 0.001492 233.8300n 0.001511 233.8400n 0.001525
+ 233.8500n 0.001533 233.8600n 0.001534 233.8700n 0.001529 233.8800n 0.001518 233.8900n 0.001500 233.9000n 0.001476 233.9100n 0.001445 233.9200n 0.001409 233.9300n 0.001368 233.9400n 0.001322 233.9500n 0.001271 233.9600n 0.001216 233.9700n 0.001157 233.9800n 0.001094 233.9900n 0.001028
+ 234.0000n 0.000960 234.0100n 0.000889 234.0200n 0.000815 234.0300n 0.000738 234.0400n 0.000659 234.0500n 0.000578 234.0600n 0.000493 234.0700n 0.000406 234.0800n 0.000315 234.0900n 0.000221 234.1000n 0.000123 234.1100n 0.000022 234.1200n -0.000084 234.1300n -0.000193 234.1400n -0.000307
+ 234.1500n -0.000425 234.1600n -0.000547 234.1700n -0.000672 234.1800n -0.000800 234.1900n -0.000931 234.2000n -0.001063 234.2100n -0.001195 234.2200n -0.001327 234.2300n -0.001457 234.2400n -0.001584 234.2500n -0.001705 234.2600n -0.001821 234.2700n -0.001928 234.2800n -0.002025 234.2900n -0.002110
+ 234.3000n -0.002183 234.3100n -0.002240 234.3200n -0.002281 234.3300n -0.002305 234.3400n -0.002310 234.3500n -0.002295 234.3600n -0.002261 234.3700n -0.002206 234.3800n -0.002130 234.3900n -0.002035 234.4000n -0.001920 234.4100n -0.001787 234.4200n -0.001637 234.4300n -0.001472 234.4400n -0.001295
+ 234.4500n -0.001106 234.4600n -0.000910 234.4700n -0.000708 234.4800n -0.000504 234.4900n -0.000301 234.5000n -0.000102 234.5100n 0.000090 234.5200n 0.000272 234.5300n 0.000441 234.5400n 0.000594 234.5500n 0.000729 234.5600n 0.000842 234.5700n 0.000934 234.5800n 0.001001 234.5900n 0.001044
+ 234.6000n 0.001061 234.6100n 0.001053 234.6200n 0.001019 234.6300n 0.000961 234.6400n 0.000881 234.6500n 0.000779 234.6600n 0.000659 234.6700n 0.000523 234.6800n 0.000374 234.6900n 0.000215 234.7000n 0.000051 234.7100n -0.000116 234.7200n -0.000281 234.7300n -0.000441 234.7400n -0.000592
+ 234.7500n -0.000731 234.7600n -0.000853 234.7700n -0.000956 234.7800n -0.001038 234.7900n -0.001095 234.8000n -0.001126 234.8100n -0.001131 234.8200n -0.001107 234.8300n -0.001055 234.8400n -0.000976 234.8500n -0.000869 234.8600n -0.000737 234.8700n -0.000582 234.8800n -0.000406 234.8900n -0.000212
+ 234.9000n -0.000004 234.9100n 0.000216 234.9200n 0.000442 234.9300n 0.000672 234.9400n 0.000901 234.9500n 0.001125 234.9600n 0.001340 234.9700n 0.001542 234.9800n 0.001728 234.9900n 0.001894 235.0000n 0.002038 235.0100n 0.002157 235.0200n 0.002250 235.0300n 0.002314 235.0400n 0.002350
+ 235.0500n 0.002356 235.0600n 0.002335 235.0700n 0.002285 235.0800n 0.002209 235.0900n 0.002109 235.1000n 0.001987 235.1100n 0.001846 235.1200n 0.001690 235.1300n 0.001521 235.1400n 0.001343 235.1500n 0.001160 235.1600n 0.000976 235.1700n 0.000795 235.1800n 0.000620 235.1900n 0.000455
+ 235.2000n 0.000302 235.2100n 0.000164 235.2200n 0.000045 235.2300n -0.000055 235.2400n -0.000133 235.2500n -0.000189 235.2600n -0.000223 235.2700n -0.000233 235.2800n -0.000222 235.2900n -0.000189 235.3000n -0.000137 235.3100n -0.000068 235.3200n 0.000017 235.3300n 0.000115 235.3400n 0.000222
+ 235.3500n 0.000337 235.3600n 0.000455 235.3700n 0.000575 235.3800n 0.000692 235.3900n 0.000804 235.4000n 0.000908 235.4100n 0.001002 235.4200n 0.001084 235.4300n 0.001151 235.4400n 0.001202 235.4500n 0.001237 235.4600n 0.001254 235.4700n 0.001253 235.4800n 0.001234 235.4900n 0.001198
+ 235.5000n 0.001146 235.5100n 0.001080 235.5200n 0.001000 235.5300n 0.000908 235.5400n 0.000808 235.5500n 0.000699 235.5600n 0.000586 235.5700n 0.000470 235.5800n 0.000352 235.5900n 0.000236 235.6000n 0.000124 235.6100n 0.000016 235.6200n -0.000086 235.6300n -0.000180 235.6400n -0.000266
+ 235.6500n -0.000343 235.6600n -0.000411 235.6700n -0.000471 235.6800n -0.000521 235.6900n -0.000564 235.7000n -0.000600 235.7100n -0.000630 235.7200n -0.000656 235.7300n -0.000678 235.7400n -0.000699 235.7500n -0.000720 235.7600n -0.000742 235.7700n -0.000767 235.7800n -0.000795 235.7900n -0.000828
+ 235.8000n -0.000866 235.8100n -0.000910 235.8200n -0.000960 235.8300n -0.001016 235.8400n -0.001077 235.8500n -0.001142 235.8600n -0.001210 235.8700n -0.001279 235.8800n -0.001348 235.8900n -0.001415 235.9000n -0.001477 235.9100n -0.001533 235.9200n -0.001580 235.9300n -0.001615 235.9400n -0.001637
+ 235.9500n -0.001644 235.9600n -0.001633 235.9700n -0.001603 235.9800n -0.001553 235.9900n -0.001482 236.0000n -0.001391 236.0100n -0.001278 236.0200n -0.001144 236.0300n -0.000992 236.0400n -0.000821 236.0500n -0.000635 236.0600n -0.000436 236.0700n -0.000227 236.0800n -0.000011 236.0900n 0.000208
+ 236.1000n 0.000426 236.1100n 0.000639 236.1200n 0.000843 236.1300n 0.001033 236.1400n 0.001207 236.1500n 0.001360 236.1600n 0.001488 236.1700n 0.001589 236.1800n 0.001661 236.1900n 0.001700 236.2000n 0.001706 236.2100n 0.001678 236.2200n 0.001615 236.2300n 0.001520 236.2400n 0.001392
+ 236.2500n 0.001234 236.2600n 0.001049 236.2700n 0.000840 236.2800n 0.000612 236.2900n 0.000368 236.3000n 0.000114 236.3100n -0.000145 236.3200n -0.000404 236.3300n -0.000657 236.3400n -0.000899 236.3500n -0.001123 236.3600n -0.001325 236.3700n -0.001500 236.3800n -0.001644 236.3900n -0.001753
+ 236.4000n -0.001823 236.4100n -0.001853 236.4200n -0.001841 236.4300n -0.001786 236.4400n -0.001689 236.4500n -0.001550 236.4600n -0.001371 236.4700n -0.001156 236.4800n -0.000908 236.4900n -0.000631 236.5000n -0.000330 236.5100n -0.000012 236.5200n 0.000319 236.5300n 0.000655 236.5400n 0.000990
+ 236.5500n 0.001317 236.5600n 0.001630 236.5700n 0.001922 236.5800n 0.002188 236.5900n 0.002421 236.6000n 0.002617 236.6100n 0.002772 236.6200n 0.002881 236.6300n 0.002942 236.6400n 0.002954 236.6500n 0.002916 236.6600n 0.002827 236.6700n 0.002690 236.6800n 0.002505 236.6900n 0.002277
+ 236.7000n 0.002009 236.7100n 0.001705 236.7200n 0.001372 236.7300n 0.001015 236.7400n 0.000640 236.7500n 0.000253 236.7600n -0.000137 236.7700n -0.000525 236.7800n -0.000903 236.7900n -0.001265 236.8000n -0.001605 236.8100n -0.001918 236.8200n -0.002197 236.8300n -0.002440 236.8400n -0.002641
+ 236.8500n -0.002800 236.8600n -0.002913 236.8700n -0.002980 236.8800n -0.003001 236.8900n -0.002977 236.9000n -0.002910 236.9100n -0.002803 236.9200n -0.002659 236.9300n -0.002482 236.9400n -0.002277 236.9500n -0.002050 236.9600n -0.001805 236.9700n -0.001549 236.9800n -0.001287 236.9900n -0.001025
+ 237.0000n -0.000769 237.0100n -0.000524 237.0200n -0.000295 237.0300n -0.000087 237.0400n 0.000098 237.0500n 0.000255 237.0600n 0.000382 237.0700n 0.000479 237.0800n 0.000543 237.0900n 0.000575 237.1000n 0.000576 237.1100n 0.000548 237.1200n 0.000492 237.1300n 0.000412 237.1400n 0.000311
+ 237.1500n 0.000192 237.1600n 0.000061 237.1700n -0.000078 237.1800n -0.000221 237.1900n -0.000362 237.2000n -0.000498 237.2100n -0.000623 237.2200n -0.000735 237.2300n -0.000828 237.2400n -0.000900 237.2500n -0.000948 237.2600n -0.000970 237.2700n -0.000966 237.2800n -0.000933 237.2900n -0.000873
+ 237.3000n -0.000786 237.3100n -0.000673 237.3200n -0.000537 237.3300n -0.000380 237.3400n -0.000205 237.3500n -0.000016 237.3600n 0.000183 237.3700n 0.000389 237.3800n 0.000596 237.3900n 0.000801 237.4000n 0.000999 237.4100n 0.001187 237.4200n 0.001361 237.4300n 0.001518 237.4400n 0.001654
+ 237.4500n 0.001767 237.4600n 0.001856 237.4700n 0.001918 237.4800n 0.001955 237.4900n 0.001965 237.5000n 0.001950 237.5100n 0.001911 237.5200n 0.001850 237.5300n 0.001769 237.5400n 0.001670 237.5500n 0.001559 237.5600n 0.001437 237.5700n 0.001309 237.5800n 0.001178 237.5900n 0.001049
+ 237.6000n 0.000924 237.6100n 0.000809 237.6200n 0.000706 237.6300n 0.000617 237.6400n 0.000546 237.6500n 0.000495 237.6600n 0.000464 237.6700n 0.000455 237.6800n 0.000468 237.6900n 0.000503 237.7000n 0.000558 237.7100n 0.000632 237.7200n 0.000723 237.7300n 0.000829 237.7400n 0.000945
+ 237.7500n 0.001070 237.7600n 0.001198 237.7700n 0.001327 237.7800n 0.001453 237.7900n 0.001571 237.8000n 0.001678 237.8100n 0.001770 237.8200n 0.001844 237.8300n 0.001897 237.8400n 0.001927 237.8500n 0.001931 237.8600n 0.001909 237.8700n 0.001859 237.8800n 0.001781 237.8900n 0.001676
+ 237.9000n 0.001545 237.9100n 0.001389 237.9200n 0.001211 237.9300n 0.001014 237.9400n 0.000800 237.9500n 0.000574 237.9600n 0.000339 237.9700n 0.000098 237.9800n -0.000142 237.9900n -0.000380 238.0000n -0.000609 238.0100n -0.000828 238.0200n -0.001031 238.0300n -0.001215 238.0400n -0.001379
+ 238.0500n -0.001519 238.0600n -0.001633 238.0700n -0.001721 238.0800n -0.001781 238.0900n -0.001813 238.1000n -0.001819 238.1100n -0.001798 238.1200n -0.001754 238.1300n -0.001687 238.1400n -0.001601 238.1500n -0.001498 238.1600n -0.001383 238.1700n -0.001257 238.1800n -0.001125 238.1900n -0.000992
+ 238.2000n -0.000859 238.2100n -0.000731 238.2200n -0.000611 238.2300n -0.000501 238.2400n -0.000405 238.2500n -0.000325 238.2600n -0.000262 238.2700n -0.000217 238.2800n -0.000191 238.2900n -0.000183 238.3000n -0.000195 238.3100n -0.000223 238.3200n -0.000267 238.3300n -0.000325 238.3400n -0.000395
+ 238.3500n -0.000473 238.3600n -0.000557 238.3700n -0.000643 238.3800n -0.000729 238.3900n -0.000811 238.4000n -0.000885 238.4100n -0.000950 238.4200n -0.001001 238.4300n -0.001037 238.4400n -0.001056 238.4500n -0.001055 238.4600n -0.001034 238.4700n -0.000992 238.4800n -0.000929 238.4900n -0.000845
+ 238.5000n -0.000741 238.5100n -0.000619 238.5200n -0.000480 238.5300n -0.000327 238.5400n -0.000162 238.5500n 0.000011 238.5600n 0.000190 238.5700n 0.000371 238.5800n 0.000550 238.5900n 0.000725 238.6000n 0.000891 238.6100n 0.001047 238.6200n 0.001188 238.6300n 0.001313 238.6400n 0.001419
+ 238.6500n 0.001505 238.6600n 0.001570 238.6700n 0.001613 238.6800n 0.001634 238.6900n 0.001633 238.7000n 0.001611 238.7100n 0.001570 238.7200n 0.001512 238.7300n 0.001439 238.7400n 0.001354 238.7500n 0.001260 238.7600n 0.001160 238.7700n 0.001057 238.7800n 0.000956 238.7900n 0.000859
+ 238.8000n 0.000769 238.8100n 0.000690 238.8200n 0.000625 238.8300n 0.000576 238.8400n 0.000544 238.8500n 0.000533 238.8600n 0.000541 238.8700n 0.000571 238.8800n 0.000622 238.8900n 0.000693 238.9000n 0.000783 238.9100n 0.000891 238.9200n 0.001014 238.9300n 0.001150 238.9400n 0.001296
+ 238.9500n 0.001448 238.9600n 0.001604 238.9700n 0.001759 238.9800n 0.001910 238.9900n 0.002053 239.0000n 0.002184 239.0100n 0.002301 239.0200n 0.002401 239.0300n 0.002480 239.0400n 0.002537 239.0500n 0.002570 239.0600n 0.002578 239.0700n 0.002560 239.0800n 0.002516 239.0900n 0.002447
+ 239.1000n 0.002354 239.1100n 0.002239 239.1200n 0.002103 239.1300n 0.001950 239.1400n 0.001783 239.1500n 0.001605 239.1600n 0.001420 239.1700n 0.001231 239.1800n 0.001043 239.1900n 0.000859 239.2000n 0.000683 239.2100n 0.000520 239.2200n 0.000371 239.2300n 0.000241 239.2400n 0.000131
+ 239.2500n 0.000044 239.2600n -0.000018 239.2700n -0.000056 239.2800n -0.000068 239.2900n -0.000054 239.3000n -0.000016 239.3100n 0.000045 239.3200n 0.000127 239.3300n 0.000227 239.3400n 0.000344 239.3500n 0.000473 239.3600n 0.000610 239.3700n 0.000753 239.3800n 0.000898 239.3900n 0.001039
+ 239.4000n 0.001174 239.4100n 0.001299 239.4200n 0.001410 239.4300n 0.001504 239.4400n 0.001579 239.4500n 0.001632 239.4600n 0.001661 239.4700n 0.001665 239.4800n 0.001644 239.4900n 0.001596 239.5000n 0.001524 239.5100n 0.001427 239.5200n 0.001308 239.5300n 0.001168 239.5400n 0.001011
+ 239.5500n 0.000838 239.5600n 0.000654 239.5700n 0.000462 239.5800n 0.000265 239.5900n 0.000067 239.6000n -0.000128 239.6100n -0.000316 239.6200n -0.000494 239.6300n -0.000659 239.6400n -0.000808 239.6500n -0.000939 239.6600n -0.001049 239.6700n -0.001138 239.6800n -0.001204 239.6900n -0.001248
+ 239.7000n -0.001268 239.7100n -0.001267 239.7200n -0.001245 239.7300n -0.001204 239.7400n -0.001145 239.7500n -0.001073 239.7600n -0.000989 239.7700n -0.000896 239.7800n -0.000798 239.7900n -0.000698 239.8000n -0.000599 239.8100n -0.000504 239.8200n -0.000416 239.8300n -0.000339 239.8400n -0.000274
+ 239.8500n -0.000223 239.8600n -0.000189 239.8700n -0.000171 239.8800n -0.000171 239.8900n -0.000189 239.9000n -0.000224 239.9100n -0.000275 239.9200n -0.000341 239.9300n -0.000420 239.9400n -0.000510 239.9500n -0.000608 239.9600n -0.000712 239.9700n -0.000817 239.9800n -0.000921 239.9900n -0.001022
+ 240.0000n -0.001114 240.0100n -0.001196 240.0200n -0.001265 240.0300n -0.001318 240.0400n -0.001353 240.0500n -0.001368 240.0600n -0.001362 240.0700n -0.001334 240.0800n -0.001284 240.0900n -0.001212 240.1000n -0.001120 240.1100n -0.001008 240.1200n -0.000879 240.1300n -0.000735 240.1400n -0.000578
+ 240.1500n -0.000413 240.1600n -0.000243 240.1700n -0.000071 240.1800n 0.000098 240.1900n 0.000261 240.2000n 0.000413 240.2100n 0.000552 240.2200n 0.000672 240.2300n 0.000772 240.2400n 0.000848 240.2500n 0.000898 240.2600n 0.000919 240.2700n 0.000911 240.2800n 0.000873 240.2900n 0.000804
+ 240.3000n 0.000706 240.3100n 0.000579 240.3200n 0.000426 240.3300n 0.000248 240.3400n 0.000049 240.3500n -0.000168 240.3600n -0.000400 240.3700n -0.000641 240.3800n -0.000887 240.3900n -0.001134 240.4000n -0.001377 240.4100n -0.001612 240.4200n -0.001833 240.4300n -0.002036 240.4400n -0.002218
+ 240.4500n -0.002375 240.4600n -0.002502 240.4700n -0.002599 240.4800n -0.002662 240.4900n -0.002690 240.5000n -0.002683 240.5100n -0.002639 240.5200n -0.002560 240.5300n -0.002447 240.5400n -0.002302 240.5500n -0.002126 240.5600n -0.001923 240.5700n -0.001697 240.5800n -0.001450 240.5900n -0.001188
+ 240.6000n -0.000914 240.6100n -0.000634 240.6200n -0.000351 240.6300n -0.000071 240.6400n 0.000202 240.6500n 0.000463 240.6600n 0.000710 240.6700n 0.000937 240.6800n 0.001143 240.6900n 0.001323 240.7000n 0.001475 240.7100n 0.001599 240.7200n 0.001693 240.7300n 0.001756 240.7400n 0.001788
+ 240.7500n 0.001790 240.7600n 0.001764 240.7700n 0.001710 240.7800n 0.001630 240.7900n 0.001529 240.8000n 0.001407 240.8100n 0.001268 240.8200n 0.001116 240.8300n 0.000954 240.8400n 0.000786 240.8500n 0.000614 240.8600n 0.000443 240.8700n 0.000275 240.8800n 0.000113 240.8900n -0.000039
+ 240.9000n -0.000179 240.9100n -0.000306 240.9200n -0.000418 240.9300n -0.000513 240.9400n -0.000590 240.9500n -0.000650 240.9600n -0.000692 240.9700n -0.000717 240.9800n -0.000725 240.9900n -0.000717 241.0000n -0.000695 241.0100n -0.000661 241.0200n -0.000615 241.0300n -0.000560 241.0400n -0.000498
+ 241.0500n -0.000431 241.0600n -0.000360 241.0700n -0.000289 241.0800n -0.000218 241.0900n -0.000148 241.1000n -0.000083 241.1100n -0.000021 241.1200n 0.000034 241.1300n 0.000084 241.1400n 0.000127 241.1500n 0.000163 241.1600n 0.000193 241.1700n 0.000217 241.1800n 0.000236 241.1900n 0.000249
+ 241.2000n 0.000260 241.2100n 0.000268 241.2200n 0.000274 241.2300n 0.000281 241.2400n 0.000288 241.2500n 0.000299 241.2600n 0.000313 241.2700n 0.000331 241.2800n 0.000356 241.2900n 0.000386 241.3000n 0.000423 241.3100n 0.000468 241.3200n 0.000520 241.3300n 0.000578 241.3400n 0.000643
+ 241.3500n 0.000715 241.3600n 0.000791 241.3700n 0.000871 241.3800n 0.000954 241.3900n 0.001039 241.4000n 0.001123 241.4100n 0.001206 241.4200n 0.001285 241.4300n 0.001359 241.4400n 0.001427 241.4500n 0.001487 241.4600n 0.001538 241.4700n 0.001578 241.4800n 0.001606 241.4900n 0.001623
+ 241.5000n 0.001627 241.5100n 0.001617 241.5200n 0.001595 241.5300n 0.001560 241.5400n 0.001513 241.5500n 0.001455 241.5600n 0.001387 241.5700n 0.001310 241.5800n 0.001227 241.5900n 0.001138 241.6000n 0.001046 241.6100n 0.000953 241.6200n 0.000860 241.6300n 0.000771 241.6400n 0.000688
+ 241.6500n 0.000611 241.6600n 0.000544 241.6700n 0.000488 241.6800n 0.000446 241.6900n 0.000417 241.7000n 0.000404 241.7100n 0.000407 241.7200n 0.000427 241.7300n 0.000465 241.7400n 0.000519 241.7500n 0.000591 241.7600n 0.000678 241.7700n 0.000780 241.7800n 0.000895 241.7900n 0.001023
+ 241.8000n 0.001160 241.8100n 0.001305 241.8200n 0.001456 241.8300n 0.001609 241.8400n 0.001762 241.8500n 0.001914 241.8600n 0.002060 241.8700n 0.002198 241.8800n 0.002326 241.8900n 0.002442 241.9000n 0.002543 241.9100n 0.002626 241.9200n 0.002691 241.9300n 0.002736 241.9400n 0.002759
+ 241.9500n 0.002759 241.9600n 0.002737 241.9700n 0.002691 241.9800n 0.002623 241.9900n 0.002532 242.0000n 0.002420 242.0100n 0.002287 242.0200n 0.002136 242.0300n 0.001968 242.0400n 0.001785 242.0500n 0.001589 242.0600n 0.001384 242.0700n 0.001172 242.0800n 0.000956 242.0900n 0.000738
+ 242.1000n 0.000521 242.1100n 0.000310 242.1200n 0.000105 242.1300n -0.000089 242.1400n -0.000271 242.1500n -0.000437 242.1600n -0.000587 242.1700n -0.000717 242.1800n -0.000827 242.1900n -0.000915 242.2000n -0.000979 242.2100n -0.001021 242.2200n -0.001038 242.2300n -0.001032 242.2400n -0.001003
+ 242.2500n -0.000951 242.2600n -0.000878 242.2700n -0.000786 242.2800n -0.000676 242.2900n -0.000549 242.3000n -0.000410 242.3100n -0.000259 242.3200n -0.000099 242.3300n 0.000066 242.3400n 0.000234 242.3500n 0.000402 242.3600n 0.000567 242.3700n 0.000727 242.3800n 0.000879 242.3900n 0.001020
+ 242.4000n 0.001149 242.4100n 0.001262 242.4200n 0.001359 242.4300n 0.001437 242.4400n 0.001496 242.4500n 0.001535 242.4600n 0.001553 242.4700n 0.001550 242.4800n 0.001526 242.4900n 0.001482 242.5000n 0.001419 242.5100n 0.001338 242.5200n 0.001240 242.5300n 0.001128 242.5400n 0.001003
+ 242.5500n 0.000867 242.5600n 0.000724 242.5700n 0.000575 242.5800n 0.000424 242.5900n 0.000273 242.6000n 0.000124 242.6100n -0.000020 242.6200n -0.000157 242.6300n -0.000284 242.6400n -0.000399 242.6500n -0.000501 242.6600n -0.000588 242.6700n -0.000658 242.6800n -0.000712 242.6900n -0.000748
+ 242.7000n -0.000767 242.7100n -0.000768 242.7200n -0.000753 242.7300n -0.000721 242.7400n -0.000676 242.7500n -0.000617 242.7600n -0.000548 242.7700n -0.000470 242.7800n -0.000385 242.7900n -0.000296 242.8000n -0.000206 242.8100n -0.000118 242.8200n -0.000032 242.8300n 0.000046 242.8400n 0.000116
+ 242.8500n 0.000176 242.8600n 0.000222 242.8700n 0.000253 242.8800n 0.000269 242.8900n 0.000267 242.9000n 0.000248 242.9100n 0.000210 242.9200n 0.000154 242.9300n 0.000082 242.9400n -0.000008 242.9500n -0.000112 242.9600n -0.000230 242.9700n -0.000360 242.9800n -0.000498 242.9900n -0.000643
+ 243.0000n -0.000791 243.0100n -0.000940 243.0200n -0.001087 243.0300n -0.001228 243.0400n -0.001361 243.0500n -0.001483 243.0600n -0.001590 243.0700n -0.001681 243.0800n -0.001754 243.0900n -0.001806 243.1000n -0.001836 243.1100n -0.001843 243.1200n -0.001828 243.1300n -0.001789 243.1400n -0.001727
+ 243.1500n -0.001643 243.1600n -0.001539 243.1700n -0.001416 243.1800n -0.001277 243.1900n -0.001125 243.2000n -0.000963 243.2100n -0.000794 243.2200n -0.000622 243.2300n -0.000450 243.2400n -0.000283 243.2500n -0.000124 243.2600n 0.000024 243.2700n 0.000156 243.2800n 0.000269 243.2900n 0.000361
+ 243.3000n 0.000428 243.3100n 0.000469 243.3200n 0.000481 243.3300n 0.000464 243.3400n 0.000418 243.3500n 0.000342 243.3600n 0.000236 243.3700n 0.000102 243.3800n -0.000058 243.3900n -0.000241 243.4000n -0.000446 243.4100n -0.000668 243.4200n -0.000905 243.4300n -0.001151 243.4400n -0.001402
+ 243.4500n -0.001655 243.4600n -0.001905 243.4700n -0.002146 243.4800n -0.002375 243.4900n -0.002586 243.5000n -0.002777 243.5100n -0.002944 243.5200n -0.003082 243.5300n -0.003189 243.5400n -0.003264 243.5500n -0.003304 243.5600n -0.003308 243.5700n -0.003276 243.5800n -0.003208 243.5900n -0.003105
+ 243.6000n -0.002968 243.6100n -0.002799 243.6200n -0.002601 243.6300n -0.002378 243.6400n -0.002132 243.6500n -0.001867 243.6600n -0.001588 243.6700n -0.001299 243.6800n -0.001004 243.6900n -0.000708 243.7000n -0.000416 243.7100n -0.000131 243.7200n 0.000142 243.7300n 0.000401 243.7400n 0.000640
+ 243.7500n 0.000858 243.7600n 0.001053 243.7700n 0.001221 243.7800n 0.001363 243.7900n 0.001477 243.8000n 0.001564 243.8100n 0.001623 243.8200n 0.001656 243.8300n 0.001665 243.8400n 0.001651 243.8500n 0.001616 243.8600n 0.001564 243.8700n 0.001498 243.8800n 0.001420 243.8900n 0.001335
+ 243.9000n 0.001245 243.9100n 0.001154 243.9200n 0.001065 243.9300n 0.000982 243.9400n 0.000907 243.9500n 0.000843 243.9600n 0.000792 243.9700n 0.000755 243.9800n 0.000735 243.9900n 0.000731 244.0000n 0.000745 244.0100n 0.000776 244.0200n 0.000823 244.0300n 0.000886 244.0400n 0.000963
+ 244.0500n 0.001052 244.0600n 0.001152 244.0700n 0.001259 244.0800n 0.001372 244.0900n 0.001487 244.1000n 0.001602 244.1100n 0.001714 244.1200n 0.001821 244.1300n 0.001920 244.1400n 0.002009 244.1500n 0.002086 244.1600n 0.002149 244.1700n 0.002197 244.1800n 0.002229 244.1900n 0.002244
+ 244.2000n 0.002244 244.2100n 0.002227 244.2200n 0.002195 244.2300n 0.002149 244.2400n 0.002090 244.2500n 0.002021 244.2600n 0.001943 244.2700n 0.001859 244.2800n 0.001772 244.2900n 0.001684 244.3000n 0.001598 244.3100n 0.001516 244.3200n 0.001441 244.3300n 0.001375 244.3400n 0.001320
+ 244.3500n 0.001278 244.3600n 0.001250 244.3700n 0.001238 244.3800n 0.001242 244.3900n 0.001262 244.4000n 0.001298 244.4100n 0.001349 244.4200n 0.001415 244.4300n 0.001493 244.4400n 0.001582 244.4500n 0.001679 244.4600n 0.001782 244.4700n 0.001888 244.4800n 0.001995 244.4900n 0.002099
+ 244.5000n 0.002197 244.5100n 0.002287 244.5200n 0.002365 244.5300n 0.002429 244.5400n 0.002476 244.5500n 0.002505 244.5600n 0.002514 244.5700n 0.002500 244.5800n 0.002464 244.5900n 0.002405 244.6000n 0.002323 244.6100n 0.002219 244.6200n 0.002093 244.6300n 0.001948 244.6400n 0.001784
+ 244.6500n 0.001605 244.6600n 0.001412 244.6700n 0.001209 244.6800n 0.001000 244.6900n 0.000786 244.7000n 0.000572 244.7100n 0.000361 244.7200n 0.000156 244.7300n -0.000040 244.7400n -0.000223 244.7500n -0.000392 244.7600n -0.000542 244.7700n -0.000673 244.7800n -0.000784 244.7900n -0.000872
+ 244.8000n -0.000936 244.8100n -0.000978 244.8200n -0.000997 244.8300n -0.000993 244.8400n -0.000969 244.8500n -0.000924 244.8600n -0.000862 244.8700n -0.000785 244.8800n -0.000694 244.8900n -0.000593 244.9000n -0.000485 244.9100n -0.000372 244.9200n -0.000257 244.9300n -0.000143 244.9400n -0.000033
+ 244.9500n 0.000070 244.9600n 0.000166 244.9700n 0.000250 244.9800n 0.000323 244.9900n 0.000381 245.0000n 0.000426 245.0100n 0.000456 245.0200n 0.000471 245.0300n 0.000471 245.0400n 0.000457 245.0500n 0.000430 245.0600n 0.000392 245.0700n 0.000344 245.0800n 0.000288 245.0900n 0.000226
+ 245.1000n 0.000160 245.1100n 0.000092 245.1200n 0.000025 245.1300n -0.000039 245.1400n -0.000099 245.1500n -0.000152 245.1600n -0.000197 245.1700n -0.000233 245.1800n -0.000258 245.1900n -0.000271 245.2000n -0.000273 245.2100n -0.000263 245.2200n -0.000242 245.2300n -0.000211 245.2400n -0.000169
+ 245.2500n -0.000120 245.2600n -0.000063 245.2700n -0.000002 245.2800n 0.000062 245.2900n 0.000128 245.3000n 0.000191 245.3100n 0.000252 245.3200n 0.000307 245.3300n 0.000354 245.3400n 0.000393 245.3500n 0.000420 245.3600n 0.000435 245.3700n 0.000437 245.3800n 0.000424 245.3900n 0.000398
+ 245.4000n 0.000357 245.4100n 0.000303 245.4200n 0.000236 245.4300n 0.000157 245.4400n 0.000068 245.4500n -0.000029 245.4600n -0.000133 245.4700n -0.000240 245.4800n -0.000349 245.4900n -0.000456 245.5000n -0.000560 245.5100n -0.000657 245.5200n -0.000745 245.5300n -0.000822 245.5400n -0.000885
+ 245.5500n -0.000933 245.5600n -0.000963 245.5700n -0.000975 245.5800n -0.000968 245.5900n -0.000941 245.6000n -0.000894 245.6100n -0.000829 245.6200n -0.000745 245.6300n -0.000645 245.6400n -0.000529 245.6500n -0.000401 245.6600n -0.000263 245.6700n -0.000117 245.6800n 0.000033 245.6900n 0.000185
+ 245.7000n 0.000334 245.7100n 0.000477 245.7200n 0.000612 245.7300n 0.000734 245.7400n 0.000841 245.7500n 0.000930 245.7600n 0.000997 245.7700n 0.001043 245.7800n 0.001063 245.7900n 0.001058 245.8000n 0.001025 245.8100n 0.000966 245.8200n 0.000879 245.8300n 0.000767 245.8400n 0.000629
+ 245.8500n 0.000468 245.8600n 0.000285 245.8700n 0.000083 245.8800n -0.000134 245.8900n -0.000364 245.9000n -0.000604 245.9100n -0.000849 245.9200n -0.001096 245.9300n -0.001342 245.9400n -0.001582 245.9500n -0.001813 245.9600n -0.002032 245.9700n -0.002235 245.9800n -0.002419 245.9900n -0.002582
+ 246.0000n -0.002722 246.0100n -0.002837 246.0200n -0.002926 246.0300n -0.002988 246.0400n -0.003022 246.0500n -0.003029 246.0600n -0.003009 246.0700n -0.002963 246.0800n -0.002894 246.0900n -0.002801 246.1000n -0.002689 246.1100n -0.002559 246.1200n -0.002414 246.1300n -0.002256 246.1400n -0.002089
+ 246.1500n -0.001916 246.1600n -0.001739 246.1700n -0.001562 246.1800n -0.001387 246.1900n -0.001217 246.2000n -0.001054 246.2100n -0.000900 246.2200n -0.000757 246.2300n -0.000627 246.2400n -0.000511 246.2500n -0.000409 246.2600n -0.000322 246.2700n -0.000250 246.2800n -0.000193 246.2900n -0.000149
+ 246.3000n -0.000119 246.3100n -0.000101 246.3200n -0.000094 246.3300n -0.000096 246.3400n -0.000105 246.3500n -0.000120 246.3600n -0.000138 246.3700n -0.000158 246.3800n -0.000177 246.3900n -0.000195 246.4000n -0.000208 246.4100n -0.000216 246.4200n -0.000217 246.4300n -0.000210 246.4400n -0.000194
+ 246.4500n -0.000167 246.4600n -0.000130 246.4700n -0.000082 246.4800n -0.000023 246.4900n 0.000048 246.5000n 0.000129 246.5100n 0.000220 246.5200n 0.000320 246.5300n 0.000429 246.5400n 0.000545 246.5500n 0.000667 246.5600n 0.000793 246.5700n 0.000923 246.5800n 0.001054 246.5900n 0.001185
+ 246.6000n 0.001315 246.6100n 0.001442 246.6200n 0.001565 246.6300n 0.001681 246.6400n 0.001790 246.6500n 0.001890 246.6600n 0.001981 246.6700n 0.002060 246.6800n 0.002127 246.6900n 0.002181 246.7000n 0.002222 246.7100n 0.002248 246.7200n 0.002258 246.7300n 0.002253 246.7400n 0.002233
+ 246.7500n 0.002196 246.7600n 0.002143 246.7700n 0.002074 246.7800n 0.001988 246.7900n 0.001887 246.8000n 0.001770 246.8100n 0.001638 246.8200n 0.001491 246.8300n 0.001330 246.8400n 0.001157 246.8500n 0.000971 246.8600n 0.000773 246.8700n 0.000566 246.8800n 0.000350 246.8900n 0.000126
+ 246.9000n -0.000103 246.9100n -0.000337 246.9200n -0.000574 246.9300n -0.000811 246.9400n -0.001048 246.9500n -0.001281 246.9600n -0.001509 246.9700n -0.001729 246.9800n -0.001941 246.9900n -0.002140 247.0000n -0.002327 247.0100n -0.002498 247.0200n -0.002651 247.0300n -0.002785 247.0400n -0.002898
+ 247.0500n -0.002989 247.0600n -0.003056 247.0700n -0.003098 247.0800n -0.003114 247.0900n -0.003105 247.1000n -0.003069 247.1100n -0.003007 247.1200n -0.002919 247.1300n -0.002806 247.1400n -0.002669 247.1500n -0.002509 247.1600n -0.002328 247.1700n -0.002128 247.1800n -0.001912 247.1900n -0.001681
+ 247.2000n -0.001439 247.2100n -0.001188 247.2200n -0.000931 247.2300n -0.000671 247.2400n -0.000412 247.2500n -0.000157 247.2600n 0.000092 247.2700n 0.000332 247.2800n 0.000559 247.2900n 0.000771 247.3000n 0.000965 247.3100n 0.001141 247.3200n 0.001295 247.3300n 0.001426 247.3400n 0.001534
+ 247.3500n 0.001617 247.3600n 0.001675 247.3700n 0.001708 247.3800n 0.001717 247.3900n 0.001702 247.4000n 0.001665 247.4100n 0.001606 247.4200n 0.001527 247.4300n 0.001430 247.4400n 0.001318 247.4500n 0.001193 247.4600n 0.001057 247.4700n 0.000912 247.4800n 0.000761 247.4900n 0.000606
+ 247.5000n 0.000450 247.5100n 0.000296 247.5200n 0.000144 247.5300n -0.000002 247.5400n -0.000142 247.5500n -0.000273 247.5600n -0.000395 247.5700n -0.000506 247.5800n -0.000607 247.5900n -0.000696 247.6000n -0.000773 247.6100n -0.000840 247.6200n -0.000895 247.6300n -0.000940 247.6400n -0.000975
+ 247.6500n -0.001003 247.6600n -0.001022 247.6700n -0.001036 247.6800n -0.001045 247.6900n -0.001050 247.7000n -0.001053 247.7100n -0.001054 247.7200n -0.001055 247.7300n -0.001058 247.7400n -0.001062 247.7500n -0.001068 247.7600n -0.001077 247.7700n -0.001089 247.7800n -0.001105 247.7900n -0.001124
+ 247.8000n -0.001145 247.8100n -0.001169 247.8200n -0.001195 247.8300n -0.001222 247.8400n -0.001249 247.8500n -0.001276 247.8600n -0.001300 247.8700n -0.001322 247.8800n -0.001341 247.8900n -0.001355 247.9000n -0.001363 247.9100n -0.001365 247.9200n -0.001360 247.9300n -0.001347 247.9400n -0.001327
+ 247.9500n -0.001299 247.9600n -0.001263 247.9700n -0.001219 247.9800n -0.001169 247.9900n -0.001111 248.0000n -0.001049 248.0100n -0.000981 248.0200n -0.000910 248.0300n -0.000837 248.0400n -0.000762 248.0500n -0.000689 248.0600n -0.000617 248.0700n -0.000548 248.0800n -0.000484 248.0900n -0.000425
+ 248.1000n -0.000374 248.1100n -0.000331 248.1200n -0.000297 248.1300n -0.000273 248.1400n -0.000258 248.1500n -0.000254 248.1600n -0.000261 248.1700n -0.000278 248.1800n -0.000305 248.1900n -0.000341 248.2000n -0.000385 248.2100n -0.000437 248.2200n -0.000494 248.2300n -0.000557 248.2400n -0.000623
+ 248.2500n -0.000691 248.2600n -0.000759 248.2700n -0.000826 248.2800n -0.000889 248.2900n -0.000949 248.3000n -0.001003 248.3100n -0.001049 248.3200n -0.001088 248.3300n -0.001117 248.3400n -0.001137 248.3500n -0.001147 248.3600n -0.001146 248.3700n -0.001134 248.3800n -0.001111 248.3900n -0.001079
+ 248.4000n -0.001037 248.4100n -0.000986 248.4200n -0.000928 248.4300n -0.000863 248.4400n -0.000792 248.4500n -0.000718 248.4600n -0.000640 248.4700n -0.000562 248.4800n -0.000484 248.4900n -0.000407 248.5000n -0.000333 248.5100n -0.000264 248.5200n -0.000200 248.5300n -0.000142 248.5400n -0.000091
+ 248.5500n -0.000047 248.5600n -0.000012 248.5700n 0.000015 248.5800n 0.000033 248.5900n 0.000043 248.6000n 0.000045 248.6100n 0.000040 248.6200n 0.000028 248.6300n 0.000010 248.6400n -0.000013 248.6500n -0.000040 248.6600n -0.000070 248.6700n -0.000102 248.6800n -0.000135 248.6900n -0.000167
+ 248.7000n -0.000199 248.7100n -0.000228 248.7200n -0.000254 248.7300n -0.000277 248.7400n -0.000295 248.7500n -0.000309 248.7600n -0.000317 248.7700n -0.000320 248.7800n -0.000318 248.7900n -0.000311 248.8000n -0.000300 248.8100n -0.000284 248.8200n -0.000264 248.8300n -0.000241 248.8400n -0.000216
+ 248.8500n -0.000189 248.8600n -0.000162 248.8700n -0.000134 248.8800n -0.000108 248.8900n -0.000083 248.9000n -0.000060 248.9100n -0.000040 248.9200n -0.000024 248.9300n -0.000012 248.9400n -0.000004 248.9500n -0.000001 248.9600n -0.000002 248.9700n -0.000008 248.9800n -0.000019 248.9900n -0.000034
+ 249.0000n -0.000053 249.0100n -0.000076 249.0200n -0.000101 249.0300n -0.000129 249.0400n -0.000160 249.0500n -0.000191 249.0600n -0.000223 249.0700n -0.000256 249.0800n -0.000288 249.0900n -0.000319 249.1000n -0.000349 249.1100n -0.000378 249.1200n -0.000405 249.1300n -0.000430 249.1400n -0.000453
+ 249.1500n -0.000474 249.1600n -0.000493 249.1700n -0.000511 249.1800n -0.000527 249.1900n -0.000543 249.2000n -0.000558 249.2100n -0.000574 249.2200n -0.000590 249.2300n -0.000607 249.2400n -0.000625 249.2500n -0.000646 249.2600n -0.000669 249.2700n -0.000694 249.2800n -0.000723 249.2900n -0.000754
+ 249.3000n -0.000789 249.3100n -0.000826 249.3200n -0.000867 249.3300n -0.000909 249.3400n -0.000954 249.3500n -0.001000 249.3600n -0.001047 249.3700n -0.001095 249.3800n -0.001141 249.3900n -0.001187 249.4000n -0.001230 249.4100n -0.001270 249.4200n -0.001306 249.4300n -0.001338 249.4400n -0.001365
+ 249.4500n -0.001385 249.4600n -0.001399 249.4700n -0.001406 249.4800n -0.001406 249.4900n -0.001398 249.5000n -0.001383 249.5100n -0.001360 249.5200n -0.001330 249.5300n -0.001293 249.5400n -0.001250 249.5500n -0.001202 249.5600n -0.001148 249.5700n -0.001090 249.5800n -0.001028 249.5900n -0.000964
+ 249.6000n -0.000898 249.6100n -0.000831 249.6200n -0.000764 249.6300n -0.000698 249.6400n -0.000633 249.6500n -0.000570 249.6600n -0.000509 249.6700n -0.000451 249.6800n -0.000396 249.6900n -0.000344 249.7000n -0.000295 249.7100n -0.000249 249.7200n -0.000205 249.7300n -0.000163 249.7400n -0.000122
+ 249.7500n -0.000082 249.7600n -0.000042 249.7700n -0.000001 249.7800n 0.000041 249.7900n 0.000086 249.8000n 0.000133 249.8100n 0.000184 249.8200n 0.000239 249.8300n 0.000298 249.8400n 0.000362 249.8500n 0.000431 249.8600n 0.000504 249.8700n 0.000581 249.8800n 0.000662 249.8900n 0.000746
+ 249.9000n 0.000832 249.9100n 0.000919 249.9200n 0.001007 249.9300n 0.001092 249.9400n 0.001175 249.9500n 0.001253 249.9600n 0.001325 249.9700n 0.001390 249.9800n 0.001445 249.9900n 0.001489 250.0000n 0.001522 250.0100n 0.001541 250.0200n 0.001545 250.0300n 0.001535 250.0400n 0.001508
+ 250.0500n 0.001466 250.0600n 0.001407 250.0700n 0.001332 250.0800n 0.001241 250.0900n 0.001136 250.1000n 0.001018 250.1100n 0.000887 250.1200n 0.000746 250.1300n 0.000597 250.1400n 0.000441 250.1500n 0.000281 250.1600n 0.000119 250.1700n -0.000043 250.1800n -0.000202 250.1900n -0.000355
+ 250.2000n -0.000500 250.2100n -0.000636 250.2200n -0.000761 250.2300n -0.000871 250.2400n -0.000967 250.2500n -0.001047 250.2600n -0.001110 250.2700n -0.001156 250.2800n -0.001184 250.2900n -0.001195 250.3000n -0.001189 250.3100n -0.001168 250.3200n -0.001131 250.3300n -0.001082 250.3400n -0.001021
+ 250.3500n -0.000951 250.3600n -0.000874 250.3700n -0.000792 250.3800n -0.000708 250.3900n -0.000623 250.4000n -0.000540 250.4100n -0.000462 250.4200n -0.000389 250.4300n -0.000325 250.4400n -0.000270 250.4500n -0.000225 250.4600n -0.000192 250.4700n -0.000172 250.4800n -0.000164 250.4900n -0.000168
+ 250.5000n -0.000184 250.5100n -0.000210 250.5200n -0.000246 250.5300n -0.000291 250.5400n -0.000341 250.5500n -0.000396 250.5600n -0.000454 250.5700n -0.000511 250.5800n -0.000566 250.5900n -0.000617 250.6000n -0.000661 250.6100n -0.000696 250.6200n -0.000720 250.6300n -0.000732 250.6400n -0.000731
+ 250.6500n -0.000715 250.6600n -0.000683 250.6700n -0.000637 250.6800n -0.000575 250.6900n -0.000498 250.7000n -0.000407 250.7100n -0.000304 250.7200n -0.000191 250.7300n -0.000069 250.7400n 0.000059 250.7500n 0.000191 250.7600n 0.000323 250.7700n 0.000454 250.7800n 0.000579 250.7900n 0.000697
+ 250.8000n 0.000803 250.8100n 0.000897 250.8200n 0.000974 250.8300n 0.001034 250.8400n 0.001074 250.8500n 0.001094 250.8600n 0.001091 250.8700n 0.001067 250.8800n 0.001020 250.8900n 0.000952 250.9000n 0.000864 250.9100n 0.000757 250.9200n 0.000633 250.9300n 0.000495 250.9400n 0.000345
+ 250.9500n 0.000187 250.9600n 0.000024 250.9700n -0.000140 250.9800n -0.000302 250.9900n -0.000458 251.0000n -0.000604 251.0100n -0.000738 251.0200n -0.000855 251.0300n -0.000953 251.0400n -0.001030 251.0500n -0.001082 251.0600n -0.001110 251.0700n -0.001111 251.0800n -0.001084 251.0900n -0.001031
+ 251.1000n -0.000952 251.1100n -0.000847 251.1200n -0.000719 251.1300n -0.000570 251.1400n -0.000402 251.1500n -0.000219 251.1600n -0.000024 251.1700n 0.000178 251.1800n 0.000386 251.1900n 0.000593 251.2000n 0.000796 251.2100n 0.000992 251.2200n 0.001175 251.2300n 0.001344 251.2400n 0.001494
+ 251.2500n 0.001623 251.2600n 0.001728 251.2700n 0.001808 251.2800n 0.001862 251.2900n 0.001888 251.3000n 0.001886 251.3100n 0.001858 251.3200n 0.001804 251.3300n 0.001726 251.3400n 0.001626 251.3500n 0.001506 251.3600n 0.001371 251.3700n 0.001223 251.3800n 0.001065 251.3900n 0.000903
+ 251.4000n 0.000739 251.4100n 0.000577 251.4200n 0.000422 251.4300n 0.000277 251.4400n 0.000145 251.4500n 0.000029 251.4600n -0.000067 251.4700n -0.000144 251.4800n -0.000197 251.4900n -0.000227 251.5000n -0.000234 251.5100n -0.000217 251.5200n -0.000177 251.5300n -0.000115 251.5400n -0.000034
+ 251.5500n 0.000065 251.5600n 0.000178 251.5700n 0.000303 251.5800n 0.000436 251.5900n 0.000573 251.6000n 0.000712 251.6100n 0.000848 251.6200n 0.000978 251.6300n 0.001098 251.6400n 0.001206 251.6500n 0.001298 251.6600n 0.001372 251.6700n 0.001427 251.6800n 0.001460 251.6900n 0.001471
+ 251.7000n 0.001460 251.7100n 0.001427 251.7200n 0.001373 251.7300n 0.001300 251.7400n 0.001208 251.7500n 0.001102 251.7600n 0.000983 251.7700n 0.000855 251.7800n 0.000722 251.7900n 0.000587 251.8000n 0.000454 251.8100n 0.000326 251.8200n 0.000208 251.8300n 0.000103 251.8400n 0.000014
+ 251.8500n -0.000057 251.8600n -0.000105 251.8700n -0.000131 251.8800n -0.000132 251.8900n -0.000107 251.9000n -0.000057 251.9100n 0.000018 251.9200n 0.000118 251.9300n 0.000240 251.9400n 0.000382 251.9500n 0.000541 251.9600n 0.000715 251.9700n 0.000899 251.9800n 0.001089 251.9900n 0.001282
+ 252.0000n 0.001474 252.0100n 0.001658 252.0200n 0.001833 252.0300n 0.001993 252.0400n 0.002135 252.0500n 0.002255 252.0600n 0.002350 252.0700n 0.002418 252.0800n 0.002457 252.0900n 0.002466 252.1000n 0.002445 252.1100n 0.002392 252.1200n 0.002309 252.1300n 0.002198 252.1400n 0.002060
+ 252.1500n 0.001898 252.1600n 0.001716 252.1700n 0.001516 252.1800n 0.001303 252.1900n 0.001082 252.2000n 0.000856 252.2100n 0.000630 252.2200n 0.000410 252.2300n 0.000199 252.2400n 0.000001 252.2500n -0.000179 252.2600n -0.000338 252.2700n -0.000473 252.2800n -0.000581 252.2900n -0.000660
+ 252.3000n -0.000710 252.3100n -0.000730 252.3200n -0.000719 252.3300n -0.000680 252.3400n -0.000612 252.3500n -0.000520 252.3600n -0.000404 252.3700n -0.000268 252.3800n -0.000117 252.3900n 0.000046 252.4000n 0.000216 252.4100n 0.000390 252.4200n 0.000562 252.4300n 0.000728 252.4400n 0.000884
+ 252.4500n 0.001026 252.4600n 0.001150 252.4700n 0.001252 252.4800n 0.001330 252.4900n 0.001381 252.5000n 0.001405 252.5100n 0.001400 252.5200n 0.001365 252.5300n 0.001302 252.5400n 0.001211 252.5500n 0.001095 252.5600n 0.000955 252.5700n 0.000794 252.5800n 0.000615 252.5900n 0.000424
+ 252.6000n 0.000222 252.6100n 0.000016 252.6200n -0.000191 252.6300n -0.000395 252.6400n -0.000591 252.6500n -0.000774 252.6600n -0.000942 252.6700n -0.001090 252.6800n -0.001215 252.6900n -0.001316 252.7000n -0.001389 252.7100n -0.001434 252.7200n -0.001449 252.7300n -0.001436 252.7400n -0.001393
+ 252.7500n -0.001323 252.7600n -0.001226 252.7700n -0.001106 252.7800n -0.000966 252.7900n -0.000807 252.8000n -0.000634 252.8100n -0.000451 252.8200n -0.000261 252.8300n -0.000068 252.8400n 0.000123 252.8500n 0.000309 252.8600n 0.000487 252.8700n 0.000653 252.8800n 0.000803 252.8900n 0.000937
+ 252.9000n 0.001051 252.9100n 0.001145 252.9200n 0.001217 252.9300n 0.001267 252.9400n 0.001295 252.9500n 0.001303 252.9600n 0.001290 252.9700n 0.001260 252.9800n 0.001214 252.9900n 0.001155 253.0000n 0.001086 253.0100n 0.001010 253.0200n 0.000929 253.0300n 0.000848 253.0400n 0.000769
+ 253.0500n 0.000695 253.0600n 0.000629 253.0700n 0.000573 253.0800n 0.000531 253.0900n 0.000502 253.1000n 0.000489 253.1100n 0.000493 253.1200n 0.000512 253.1300n 0.000548 253.1400n 0.000600 253.1500n 0.000665 253.1600n 0.000742 253.1700n 0.000829 253.1800n 0.000923 253.1900n 0.001022
+ 253.2000n 0.001121 253.2100n 0.001219 253.2200n 0.001311 253.2300n 0.001395 253.2400n 0.001467 253.2500n 0.001524 253.2600n 0.001564 253.2700n 0.001584 253.2800n 0.001583 253.2900n 0.001559 253.3000n 0.001511 253.3100n 0.001439 253.3200n 0.001344 253.3300n 0.001227 253.3400n 0.001088
+ 253.3500n 0.000930 253.3600n 0.000756 253.3700n 0.000569 253.3800n 0.000372 253.3900n 0.000169 253.4000n -0.000037 253.4100n -0.000240 253.4200n -0.000437 253.4300n -0.000623 253.4400n -0.000795 253.4500n -0.000948 253.4600n -0.001078 253.4700n -0.001184 253.4800n -0.001262 253.4900n -0.001309
+ 253.5000n -0.001325 253.5100n -0.001309 253.5200n -0.001260 253.5300n -0.001178 253.5400n -0.001065 253.5500n -0.000923 253.5600n -0.000753 253.5700n -0.000559 253.5800n -0.000344 253.5900n -0.000113 253.6000n 0.000132 253.6100n 0.000384 253.6200n 0.000640 253.6300n 0.000895 253.6400n 0.001144
+ 253.6500n 0.001383 253.6600n 0.001606 253.6700n 0.001810 253.6800n 0.001992 253.6900n 0.002148 253.7000n 0.002274 253.7100n 0.002370 253.7200n 0.002434 253.7300n 0.002465 253.7400n 0.002462 253.7500n 0.002426 253.7600n 0.002358 253.7700n 0.002261 253.7800n 0.002135 253.7900n 0.001984
+ 253.8000n 0.001812 253.8100n 0.001621 253.8200n 0.001415 253.8300n 0.001199 253.8400n 0.000977 253.8500n 0.000752 253.8600n 0.000529 253.8700n 0.000312 253.8800n 0.000104 253.8900n -0.000092 253.9000n -0.000272 253.9100n -0.000435 253.9200n -0.000578 253.9300n -0.000699 253.9400n -0.000799
+ 253.9500n -0.000876 253.9600n -0.000930 253.9700n -0.000964 253.9800n -0.000976 253.9900n -0.000970 254.0000n -0.000947 254.0100n -0.000910 254.0200n -0.000861 254.0300n -0.000802 254.0400n -0.000738 254.0500n -0.000670 254.0600n -0.000601 254.0700n -0.000535 254.0800n -0.000473 254.0900n -0.000418
+ 254.1000n -0.000372 254.1100n -0.000337 254.1200n -0.000313 254.1300n -0.000303 254.1400n -0.000305 254.1500n -0.000320 254.1600n -0.000347 254.1700n -0.000387 254.1800n -0.000436 254.1900n -0.000495 254.2000n -0.000560 254.2100n -0.000630 254.2200n -0.000703 254.2300n -0.000776 254.2400n -0.000847
+ 254.2500n -0.000913 254.2600n -0.000973 254.2700n -0.001023 254.2800n -0.001063 254.2900n -0.001091 254.3000n -0.001105 254.3100n -0.001104 254.3200n -0.001088 254.3300n -0.001057 254.3400n -0.001010 254.3500n -0.000950 254.3600n -0.000876 254.3700n -0.000789 254.3800n -0.000693 254.3900n -0.000589
+ 254.4000n -0.000478 254.4100n -0.000364 254.4200n -0.000249 254.4300n -0.000136 254.4400n -0.000026 254.4500n 0.000076 254.4600n 0.000170 254.4700n 0.000252 254.4800n 0.000321 254.4900n 0.000376 254.5000n 0.000414 254.5100n 0.000436 254.5200n 0.000440 254.5300n 0.000427 254.5400n 0.000397
+ 254.5500n 0.000351 254.5600n 0.000290 254.5700n 0.000216 254.5800n 0.000130 254.5900n 0.000035 254.6000n -0.000067 254.6100n -0.000173 254.6200n -0.000281 254.6300n -0.000387 254.6400n -0.000489 254.6500n -0.000584 254.6600n -0.000669 254.6700n -0.000743 254.6800n -0.000802 254.6900n -0.000845
+ 254.7000n -0.000871 254.7100n -0.000878 254.7200n -0.000865 254.7300n -0.000833 254.7400n -0.000781 254.7500n -0.000709 254.7600n -0.000619 254.7700n -0.000511 254.7800n -0.000388 254.7900n -0.000251 254.8000n -0.000102 254.8100n 0.000056 254.8200n 0.000221 254.8300n 0.000390 254.8400n 0.000561
+ 254.8500n 0.000731 254.8600n 0.000897 254.8700n 0.001058 254.8800n 0.001210 254.8900n 0.001353 254.9000n 0.001483 254.9100n 0.001601 254.9200n 0.001704 254.9300n 0.001793 254.9400n 0.001866 254.9500n 0.001923 254.9600n 0.001965 254.9700n 0.001993 254.9800n 0.002007 254.9900n 0.002007
+ 255.0000n 0.001997 255.0100n 0.001975 255.0200n 0.001946 255.0300n 0.001909 255.0400n 0.001866 255.0500n 0.001820 255.0600n 0.001771 255.0700n 0.001722 255.0800n 0.001672 255.0900n 0.001623 255.1000n 0.001577 255.1100n 0.001534 255.1200n 0.001493 255.1300n 0.001456 255.1400n 0.001422
+ 255.1500n 0.001391 255.1600n 0.001363 255.1700n 0.001336 255.1800n 0.001311 255.1900n 0.001286 255.2000n 0.001260 255.2100n 0.001232 255.2200n 0.001202 255.2300n 0.001169 255.2400n 0.001131 255.2500n 0.001089 255.2600n 0.001041 255.2700n 0.000988 255.2800n 0.000929 255.2900n 0.000865
+ 255.3000n 0.000797 255.3100n 0.000724 255.3200n 0.000649 255.3300n 0.000572 255.3400n 0.000495 255.3500n 0.000419 255.3600n 0.000346 255.3700n 0.000277 255.3800n 0.000216 255.3900n 0.000163 255.4000n 0.000121 255.4100n 0.000091 255.4200n 0.000074 255.4300n 0.000073 255.4400n 0.000087
+ 255.4500n 0.000119 255.4600n 0.000167 255.4700n 0.000233 255.4800n 0.000316 255.4900n 0.000416 255.5000n 0.000530 255.5100n 0.000658 255.5200n 0.000798 255.5300n 0.000947 255.5400n 0.001104 255.5500n 0.001264 255.5600n 0.001427 255.5700n 0.001587 255.5800n 0.001743 255.5900n 0.001891
+ 255.6000n 0.002027 255.6100n 0.002150 255.6200n 0.002256 255.6300n 0.002342 255.6400n 0.002407 255.6500n 0.002450 255.6600n 0.002468 255.6700n 0.002461 255.6800n 0.002428 255.6900n 0.002371 255.7000n 0.002289 255.7100n 0.002185 255.7200n 0.002059 255.7300n 0.001914 255.7400n 0.001754
+ 255.7500n 0.001580 255.7600n 0.001397 255.7700n 0.001208 255.7800n 0.001017 255.7900n 0.000828 255.8000n 0.000645 255.8100n 0.000472 255.8200n 0.000312 255.8300n 0.000169 255.8400n 0.000045 255.8500n -0.000056 255.8600n -0.000132 255.8700n -0.000182 255.8800n -0.000205 255.8900n -0.000200
+ 255.9000n -0.000167 255.9100n -0.000108 255.9200n -0.000023 255.9300n 0.000085 255.9400n 0.000213 255.9500n 0.000359 255.9600n 0.000519 255.9700n 0.000689 255.9800n 0.000865 255.9900n 0.001043 256.0000n 0.001218 256.0100n 0.001385 256.0200n 0.001540 256.0300n 0.001678 256.0400n 0.001797
+ 256.0500n 0.001892 256.0600n 0.001961 256.0700n 0.002000 256.0800n 0.002007 256.0900n 0.001982 256.1000n 0.001924 256.1100n 0.001832 256.1200n 0.001708 256.1300n 0.001552 256.1400n 0.001368 256.1500n 0.001157 256.1600n 0.000923 256.1700n 0.000669 256.1800n 0.000401 256.1900n 0.000122
+ 256.2000n -0.000163 256.2100n -0.000448 256.2200n -0.000730 256.2300n -0.001002 256.2400n -0.001260 256.2500n -0.001500 256.2600n -0.001717 256.2700n -0.001908 256.2800n -0.002070 256.2900n -0.002199 256.3000n -0.002295 256.3100n -0.002355 256.3200n -0.002380 256.3300n -0.002369 256.3400n -0.002324
+ 256.3500n -0.002245 256.3600n -0.002136 256.3700n -0.001998 256.3800n -0.001835 256.3900n -0.001651 256.4000n -0.001450 256.4100n -0.001237 256.4200n -0.001015 256.4300n -0.000790 256.4400n -0.000565 256.4500n -0.000347 256.4600n -0.000138 256.4700n 0.000057 256.4800n 0.000235 256.4900n 0.000393
+ 256.5000n 0.000529 256.5100n 0.000640 256.5200n 0.000725 256.5300n 0.000784 256.5400n 0.000817 256.5500n 0.000825 256.5600n 0.000809 256.5700n 0.000771 256.5800n 0.000713 256.5900n 0.000639 256.6000n 0.000552 256.6100n 0.000456 256.6200n 0.000354 256.6300n 0.000251 256.6400n 0.000151
+ 256.6500n 0.000057 256.6600n -0.000026 256.6700n -0.000095 256.6800n -0.000146 256.6900n -0.000177 256.7000n -0.000185 256.7100n -0.000169 256.7200n -0.000128 256.7300n -0.000061 256.7400n 0.000032 256.7500n 0.000150 256.7600n 0.000292 256.7700n 0.000455 256.7800n 0.000636 256.7900n 0.000833
+ 256.8000n 0.001042 256.8100n 0.001259 256.8200n 0.001480 256.8300n 0.001700 256.8400n 0.001914 256.8500n 0.002118 256.8600n 0.002308 256.8700n 0.002480 256.8800n 0.002628 256.8900n 0.002751 256.9000n 0.002844 256.9100n 0.002906 256.9200n 0.002934 256.9300n 0.002927 256.9400n 0.002885
+ 256.9500n 0.002807 256.9600n 0.002695 256.9700n 0.002549 256.9800n 0.002373 256.9900n 0.002170 257.0000n 0.001942 257.0100n 0.001693 257.0200n 0.001428 257.0300n 0.001152 257.0400n 0.000869 257.0500n 0.000586 257.0600n 0.000306 257.0700n 0.000035 257.0800n -0.000222 257.0900n -0.000460
+ 257.1000n -0.000674 257.1100n -0.000862 257.1200n -0.001019 257.1300n -0.001143 257.1400n -0.001230 257.1500n -0.001281 257.1600n -0.001294 257.1700n -0.001269 257.1800n -0.001206 257.1900n -0.001107 257.2000n -0.000975 257.2100n -0.000810 257.2200n -0.000618 257.2300n -0.000402 257.2400n -0.000165
+ 257.2500n 0.000087 257.2600n 0.000350 257.2700n 0.000618 257.2800n 0.000886 257.2900n 0.001150 257.3000n 0.001404 257.3100n 0.001644 257.3200n 0.001864 257.3300n 0.002062 257.3400n 0.002232 257.3500n 0.002373 257.3600n 0.002482 257.3700n 0.002556 257.3800n 0.002595 257.3900n 0.002598
+ 257.4000n 0.002565 257.4100n 0.002497 257.4200n 0.002396 257.4300n 0.002262 257.4400n 0.002100 257.4500n 0.001911 257.4600n 0.001700 257.4700n 0.001471 257.4800n 0.001227 257.4900n 0.000974 257.5000n 0.000715 257.5100n 0.000456 257.5200n 0.000201 257.5300n -0.000046 257.5400n -0.000281
+ 257.5500n -0.000499 257.5600n -0.000697 257.5700n -0.000872 257.5800n -0.001021 257.5900n -0.001142 257.6000n -0.001233 257.6100n -0.001294 257.6200n -0.001324 257.6300n -0.001323 257.6400n -0.001292 257.6500n -0.001231 257.6600n -0.001144 257.6700n -0.001031 257.6800n -0.000896 257.6900n -0.000742
+ 257.7000n -0.000572 257.7100n -0.000389 257.7200n -0.000197 257.7300n -0.000001 257.7400n 0.000197 257.7500n 0.000391 257.7600n 0.000579 257.7700n 0.000758 257.7800n 0.000922 257.7900n 0.001071 257.8000n 0.001201 257.8100n 0.001309 257.8200n 0.001394 257.8300n 0.001455 257.8400n 0.001491
+ 257.8500n 0.001501 257.8600n 0.001485 257.8700n 0.001444 257.8800n 0.001379 257.8900n 0.001292 257.9000n 0.001183 257.9100n 0.001055 257.9200n 0.000911 257.9300n 0.000753 257.9400n 0.000585 257.9500n 0.000409 257.9600n 0.000229 257.9700n 0.000047 257.9800n -0.000133 257.9900n -0.000307
+ 258.0000n -0.000473 258.0100n -0.000628 258.0200n -0.000769 258.0300n -0.000895 258.0400n -0.001002 258.0500n -0.001090 258.0600n -0.001157 258.0700n -0.001202 258.0800n -0.001225 258.0900n -0.001225 258.1000n -0.001203 258.1100n -0.001160 258.1200n -0.001096 258.1300n -0.001013 258.1400n -0.000912
+ 258.1500n -0.000796 258.1600n -0.000667 258.1700n -0.000528 258.1800n -0.000380 258.1900n -0.000226 258.2000n -0.000070 258.2100n 0.000086 258.2200n 0.000239 258.2300n 0.000387 258.2400n 0.000527 258.2500n 0.000657 258.2600n 0.000774 258.2700n 0.000877 258.2800n 0.000965 258.2900n 0.001035
+ 258.3000n 0.001088 258.3100n 0.001122 258.3200n 0.001138 258.3300n 0.001135 258.3400n 0.001114 258.3500n 0.001076 258.3600n 0.001022 258.3700n 0.000953 258.3800n 0.000872 258.3900n 0.000779 258.4000n 0.000677 258.4100n 0.000568 258.4200n 0.000454 258.4300n 0.000339 258.4400n 0.000223
+ 258.4500n 0.000110 258.4600n 0.000001 258.4700n -0.000101 258.4800n -0.000195 258.4900n -0.000279 258.5000n -0.000351 258.5100n -0.000410 258.5200n -0.000457 258.5300n -0.000489 258.5400n -0.000508 258.5500n -0.000513 258.5600n -0.000504 258.5700n -0.000484 258.5800n -0.000452 258.5900n -0.000411
+ 258.6000n -0.000361 258.6100n -0.000306 258.6200n -0.000247 258.6300n -0.000186 258.6400n -0.000126 258.6500n -0.000069 258.6600n -0.000017 258.6700n 0.000027 258.6800n 0.000060 258.6900n 0.000082 258.7000n 0.000090 258.7100n 0.000083 258.7200n 0.000059 258.7300n 0.000017 258.7400n -0.000043
+ 258.7500n -0.000122 258.7600n -0.000218 258.7700n -0.000333 258.7800n -0.000465 258.7900n -0.000612 258.8000n -0.000774 258.8100n -0.000948 258.8200n -0.001132 258.8300n -0.001323 258.8400n -0.001520 258.8500n -0.001719 258.8600n -0.001917 258.8700n -0.002112 258.8800n -0.002300 258.8900n -0.002479
+ 258.9000n -0.002647 258.9100n -0.002800 258.9200n -0.002936 258.9300n -0.003053 258.9400n -0.003151 258.9500n -0.003226 258.9600n -0.003279 258.9700n -0.003309 258.9800n -0.003316 258.9900n -0.003300 259.0000n -0.003262 259.0100n -0.003202 259.0200n -0.003123 259.0300n -0.003026 259.0400n -0.002913
+ 259.0500n -0.002787 259.0600n -0.002649 259.0700n -0.002504 259.0800n -0.002352 259.0900n -0.002198 259.1000n -0.002044 259.1100n -0.001892 259.1200n -0.001745 259.1300n -0.001606 259.1400n -0.001476 259.1500n -0.001357 259.1600n -0.001250 259.1700n -0.001157 259.1800n -0.001078 259.1900n -0.001014
+ 259.2000n -0.000964 259.2100n -0.000927 259.2200n -0.000903 259.2300n -0.000891 259.2400n -0.000889 259.2500n -0.000894 259.2600n -0.000905 259.2700n -0.000920 259.2800n -0.000936 259.2900n -0.000950 259.3000n -0.000960 259.3100n -0.000964 259.3200n -0.000959 259.3300n -0.000943 259.3400n -0.000915
+ 259.3500n -0.000872 259.3600n -0.000813 259.3700n -0.000738 259.3800n -0.000645 259.3900n -0.000536 259.4000n -0.000409 259.4100n -0.000266 259.4200n -0.000108 259.4300n 0.000063 259.4400n 0.000246 259.4500n 0.000438 259.4600n 0.000636 259.4700n 0.000839 259.4800n 0.001043 259.4900n 0.001244
+ 259.5000n 0.001440 259.5100n 0.001628 259.5200n 0.001805 259.5300n 0.001967 259.5400n 0.002113 259.5500n 0.002239 259.5600n 0.002345 259.5700n 0.002428 259.5800n 0.002487 259.5900n 0.002522 259.6000n 0.002531 259.6100n 0.002516 259.6200n 0.002477 259.6300n 0.002416 259.6400n 0.002332
+ 259.6500n 0.002230 259.6600n 0.002110 259.6700n 0.001976 259.6800n 0.001830 259.6900n 0.001676 259.7000n 0.001517 259.7100n 0.001355 259.7200n 0.001195 259.7300n 0.001038 259.7400n 0.000889 259.7500n 0.000749 259.7600n 0.000622 259.7700n 0.000509 259.7800n 0.000412 259.7900n 0.000331
+ 259.8000n 0.000269 259.8100n 0.000225 259.8200n 0.000198 259.8300n 0.000189 259.8400n 0.000196 259.8500n 0.000217 259.8600n 0.000251 259.8700n 0.000295 259.8800n 0.000347 259.8900n 0.000403 259.9000n 0.000461 259.9100n 0.000519 259.9200n 0.000571 259.9300n 0.000616 259.9400n 0.000651
+ 259.9500n 0.000673 259.9600n 0.000680 259.9700n 0.000669 259.9800n 0.000639 259.9900n 0.000589 260.0000n 0.000517 260.0100n 0.000424 260.0200n 0.000310 260.0300n 0.000175 260.0400n 0.000020 260.0500n -0.000152 260.0600n -0.000340 260.0700n -0.000541 260.0800n -0.000752 260.0900n -0.000970
+ 260.1000n -0.001193 260.1100n -0.001415 260.1200n -0.001635 260.1300n -0.001848 260.1400n -0.002050 260.1500n -0.002240 260.1600n -0.002412 260.1700n -0.002566 260.1800n -0.002698 260.1900n -0.002807 260.2000n -0.002891 260.2100n -0.002948 260.2200n -0.002979 260.2300n -0.002984 260.2400n -0.002963
+ 260.2500n -0.002916 260.2600n -0.002846 260.2700n -0.002755 260.2800n -0.002645 260.2900n -0.002517 260.3000n -0.002377 260.3100n -0.002225 260.3200n -0.002066 260.3300n -0.001904 260.3400n -0.001740 260.3500n -0.001579 260.3600n -0.001423 260.3700n -0.001274 260.3800n -0.001137 260.3900n -0.001011
+ 260.4000n -0.000900 260.4100n -0.000804 260.4200n -0.000724 260.4300n -0.000659 260.4400n -0.000611 260.4500n -0.000578 260.4600n -0.000558 260.4700n -0.000551 260.4800n -0.000554 260.4900n -0.000565 260.5000n -0.000581 260.5100n -0.000600 260.5200n -0.000619 260.5300n -0.000634 260.5400n -0.000644
+ 260.5500n -0.000645 260.5600n -0.000634 260.5700n -0.000611 260.5800n -0.000571 260.5900n -0.000515 260.6000n -0.000441 260.6100n -0.000348 260.6200n -0.000237 260.6300n -0.000107 260.6400n 0.000040 260.6500n 0.000203 260.6600n 0.000380 260.6700n 0.000569 260.6800n 0.000766 260.6900n 0.000968
+ 260.7000n 0.001173 260.7100n 0.001375 260.7200n 0.001572 260.7300n 0.001760 260.7400n 0.001934 260.7500n 0.002091 260.7600n 0.002227 260.7700n 0.002339 260.7800n 0.002424 260.7900n 0.002479 260.8000n 0.002504 260.8100n 0.002495 260.8200n 0.002453 260.8300n 0.002377 260.8400n 0.002268
+ 260.8500n 0.002126 260.8600n 0.001953 260.8700n 0.001752 260.8800n 0.001526 260.8900n 0.001277 260.9000n 0.001009 260.9100n 0.000727 260.9200n 0.000435 260.9300n 0.000138 260.9400n -0.000160 260.9500n -0.000454 260.9600n -0.000739 260.9700n -0.001010 260.9800n -0.001263 260.9900n -0.001495
+ 261.0000n -0.001701 261.0100n -0.001879 261.0200n -0.002026 261.0300n -0.002140 261.0400n -0.002220 261.0500n -0.002265 261.0600n -0.002274 261.0700n -0.002250 261.0800n -0.002192 261.0900n -0.002102 261.1000n -0.001984 261.1100n -0.001839 261.1200n -0.001672 261.1300n -0.001485 261.1400n -0.001283
+ 261.1500n -0.001070 261.1600n -0.000850 261.1700n -0.000628 261.1800n -0.000407 261.1900n -0.000192 261.2000n 0.000014 261.2100n 0.000206 261.2200n 0.000382 261.2300n 0.000538 261.2400n 0.000674 261.2500n 0.000786 261.2600n 0.000875 261.2700n 0.000938 261.2800n 0.000976 261.2900n 0.000990
+ 261.3000n 0.000980 261.3100n 0.000949 261.3200n 0.000897 261.3300n 0.000827 261.3400n 0.000742 261.3500n 0.000645 261.3600n 0.000539 261.3700n 0.000427 261.3800n 0.000313 261.3900n 0.000200 261.4000n 0.000091 261.4100n -0.000011 261.4200n -0.000103 261.4300n -0.000183 261.4400n -0.000248
+ 261.4500n -0.000297 261.4600n -0.000327 261.4700n -0.000339 261.4800n -0.000331 261.4900n -0.000304 261.5000n -0.000258 261.5100n -0.000193 261.5200n -0.000111 261.5300n -0.000013 261.5400n 0.000098 261.5500n 0.000222 261.5600n 0.000354 261.5700n 0.000494 261.5800n 0.000637 261.5900n 0.000783
+ 261.6000n 0.000927 261.6100n 0.001068 261.6200n 0.001203 261.6300n 0.001329 261.6400n 0.001445 261.6500n 0.001550 261.6600n 0.001640 261.6700n 0.001717 261.6800n 0.001777 261.6900n 0.001822 261.7000n 0.001851 261.7100n 0.001863 261.7200n 0.001861 261.7300n 0.001844 261.7400n 0.001813
+ 261.7500n 0.001771 261.7600n 0.001718 261.7700n 0.001656 261.7800n 0.001587 261.7900n 0.001513 261.8000n 0.001435 261.8100n 0.001356 261.8200n 0.001278 261.8300n 0.001201 261.8400n 0.001129 261.8500n 0.001061 261.8600n 0.000999 261.8700n 0.000945 261.8800n 0.000898 261.8900n 0.000860
+ 261.9000n 0.000830 261.9100n 0.000810 261.9200n 0.000797 261.9300n 0.000793 261.9400n 0.000796 261.9500n 0.000805 261.9600n 0.000820 261.9700n 0.000839 261.9800n 0.000861 261.9900n 0.000885 262.0000n 0.000910 262.0100n 0.000934 262.0200n 0.000955 262.0300n 0.000974 262.0400n 0.000988
+ 262.0500n 0.000997 262.0600n 0.000999 262.0700n 0.000994 262.0800n 0.000981 262.0900n 0.000960 262.1000n 0.000930 262.1100n 0.000891 262.1200n 0.000844 262.1300n 0.000787 262.1400n 0.000722 262.1500n 0.000649 262.1600n 0.000568 262.1700n 0.000480 262.1800n 0.000385 262.1900n 0.000284
+ 262.2000n 0.000178 262.2100n 0.000068 262.2200n -0.000047 262.2300n -0.000164 262.2400n -0.000284 262.2500n -0.000407 262.2600n -0.000530 262.2700n -0.000655 262.2800n -0.000779 262.2900n -0.000904 262.3000n -0.001029 262.3100n -0.001152 262.3200n -0.001275 262.3300n -0.001396 262.3400n -0.001516
+ 262.3500n -0.001633 262.3600n -0.001749 262.3700n -0.001862 262.3800n -0.001971 262.3900n -0.002078 262.4000n -0.002181 262.4100n -0.002280 262.4200n -0.002374 262.4300n -0.002463 262.4400n -0.002546 262.4500n -0.002622 262.4600n -0.002691 262.4700n -0.002752 262.4800n -0.002804 262.4900n -0.002847
+ 262.5000n -0.002879 262.5100n -0.002899 262.5200n -0.002909 262.5300n -0.002905 262.5400n -0.002889 262.5500n -0.002860 262.5600n -0.002817 262.5700n -0.002760 262.5800n -0.002689 262.5900n -0.002605 262.6000n -0.002507 262.6100n -0.002397 262.6200n -0.002274 262.6300n -0.002140 262.6400n -0.001995
+ 262.6500n -0.001841 262.6600n -0.001679 262.6700n -0.001509 262.6800n -0.001335 262.6900n -0.001156 262.7000n -0.000975 262.7100n -0.000794 262.7200n -0.000614 262.7300n -0.000436 262.7400n -0.000262 262.7500n -0.000094 262.7600n 0.000068 262.7700n 0.000221 262.7800n 0.000364 262.7900n 0.000497
+ 262.8000n 0.000619 262.8100n 0.000729 262.8200n 0.000827 262.8300n 0.000912 262.8400n 0.000984 262.8500n 0.001043 262.8600n 0.001090 262.8700n 0.001124 262.8800n 0.001147 262.8900n 0.001159 262.9000n 0.001161 262.9100n 0.001154 262.9200n 0.001139 262.9300n 0.001116 262.9400n 0.001087
+ 262.9500n 0.001053 262.9600n 0.001015 262.9700n 0.000974 262.9800n 0.000931 262.9900n 0.000887 263.0000n 0.000844 263.0100n 0.000801 263.0200n 0.000759 263.0300n 0.000720 263.0400n 0.000684 263.0500n 0.000652 263.0600n 0.000623 263.0700n 0.000598 263.0800n 0.000578 263.0900n 0.000562
+ 263.1000n 0.000552 263.1100n 0.000546 263.1200n 0.000545 263.1300n 0.000548 263.1400n 0.000557 263.1500n 0.000570 263.1600n 0.000588 263.1700n 0.000610 263.1800n 0.000636 263.1900n 0.000667 263.2000n 0.000701 263.2100n 0.000738 263.2200n 0.000779 263.2300n 0.000823 263.2400n 0.000869
+ 263.2500n 0.000917 263.2600n 0.000967 263.2700n 0.001018 263.2800n 0.001070 263.2900n 0.001122 263.3000n 0.001173 263.3100n 0.001222 263.3200n 0.001268 263.3300n 0.001312 263.3400n 0.001351 263.3500n 0.001385 263.3600n 0.001412 263.3700n 0.001432 263.3800n 0.001443 263.3900n 0.001445
+ 263.4000n 0.001436 263.4100n 0.001415 263.4200n 0.001382 263.4300n 0.001336 263.4400n 0.001277 263.4500n 0.001203 263.4600n 0.001114 263.4700n 0.001011 263.4800n 0.000894 263.4900n 0.000763 263.5000n 0.000618 263.5100n 0.000461 263.5200n 0.000292 263.5300n 0.000114 263.5400n -0.000073
+ 263.5500n -0.000266 263.5600n -0.000464 263.5700n -0.000664 263.5800n -0.000863 263.5900n -0.001061 263.6000n -0.001253 263.6100n -0.001438 263.6200n -0.001613 263.6300n -0.001776 263.6400n -0.001923 263.6500n -0.002054 263.6600n -0.002167 263.6700n -0.002259 263.6800n -0.002329 263.6900n -0.002376
+ 263.7000n -0.002401 263.7100n -0.002401 263.7200n -0.002378 263.7300n -0.002332 263.7400n -0.002264 263.7500n -0.002175 263.7600n -0.002067 263.7700n -0.001942 263.7800n -0.001803 263.7900n -0.001651 263.8000n -0.001491 263.8100n -0.001324 263.8200n -0.001154 263.8300n -0.000984 263.8400n -0.000817
+ 263.8500n -0.000657 263.8600n -0.000506 263.8700n -0.000367 263.8800n -0.000242 263.8900n -0.000134 263.9000n -0.000044 263.9100n 0.000026 263.9200n 0.000075 263.9300n 0.000104 263.9400n 0.000112 263.9500n 0.000099 263.9600n 0.000067 263.9700n 0.000016 263.9800n -0.000050 263.9900n -0.000130
+ 264.0000n -0.000221 264.0100n -0.000321 264.0200n -0.000425 264.0300n -0.000532 264.0400n -0.000637 264.0500n -0.000738 264.0600n -0.000831 264.0700n -0.000912 264.0800n -0.000980 264.0900n -0.001031 264.1000n -0.001064 264.1100n -0.001076 264.1200n -0.001067 264.1300n -0.001035 264.1400n -0.000980
+ 264.1500n -0.000903 264.1600n -0.000804 264.1700n -0.000685 264.1800n -0.000548 264.1900n -0.000396 264.2000n -0.000230 264.2100n -0.000055 264.2200n 0.000126 264.2300n 0.000310 264.2400n 0.000491 264.2500n 0.000667 264.2600n 0.000832 264.2700n 0.000984 264.2800n 0.001117 264.2900n 0.001230
+ 264.3000n 0.001318 264.3100n 0.001378 264.3200n 0.001409 264.3300n 0.001409 264.3400n 0.001377 264.3500n 0.001312 264.3600n 0.001214 264.3700n 0.001085 264.3800n 0.000926 264.3900n 0.000738 264.4000n 0.000525 264.4100n 0.000290 264.4200n 0.000037 264.4300n -0.000231 264.4400n -0.000509
+ 264.4500n -0.000791 264.4600n -0.001074 264.4700n -0.001353 264.4800n -0.001622 264.4900n -0.001877 264.5000n -0.002114 264.5100n -0.002328 264.5200n -0.002516 264.5300n -0.002676 264.5400n -0.002804 264.5500n -0.002898 264.5600n -0.002958 264.5700n -0.002982 264.5800n -0.002972 264.5900n -0.002927
+ 264.6000n -0.002850 264.6100n -0.002743 264.6200n -0.002607 264.6300n -0.002448 264.6400n -0.002267 264.6500n -0.002071 264.6600n -0.001862 264.6700n -0.001646 264.6800n -0.001427 264.6900n -0.001211 264.7000n -0.001000 264.7100n -0.000801 264.7200n -0.000617 264.7300n -0.000451 264.7400n -0.000307
+ 264.7500n -0.000187 264.7600n -0.000094 264.7700n -0.000029 264.7800n 0.000008 264.7900n 0.000016 264.8000n -0.000004 264.8100n -0.000050 264.8200n -0.000122 264.8300n -0.000216 264.8400n -0.000329 264.8500n -0.000458 264.8600n -0.000600 264.8700n -0.000749 264.8800n -0.000903 264.8900n -0.001056
+ 264.9000n -0.001204 264.9100n -0.001344 264.9200n -0.001470 264.9300n -0.001580 264.9400n -0.001670 264.9500n -0.001737 264.9600n -0.001779 264.9700n -0.001795 264.9800n -0.001782 264.9900n -0.001741 265.0000n -0.001672 265.0100n -0.001576 265.0200n -0.001453 265.0300n -0.001306 265.0400n -0.001137
+ 265.0500n -0.000950 265.0600n -0.000748 265.0700n -0.000535 265.0800n -0.000314 265.0900n -0.000090 265.1000n 0.000133 265.1100n 0.000351 265.1200n 0.000560 265.1300n 0.000756 265.1400n 0.000935 265.1500n 0.001095 265.1600n 0.001232 265.1700n 0.001344 265.1800n 0.001430 265.1900n 0.001489
+ 265.2000n 0.001520 265.2100n 0.001523 265.2200n 0.001499 265.2300n 0.001449 265.2400n 0.001376 265.2500n 0.001280 265.2600n 0.001166 265.2700n 0.001036 265.2800n 0.000894 265.2900n 0.000743 265.3000n 0.000587 265.3100n 0.000430 265.3200n 0.000275 265.3300n 0.000127 265.3400n -0.000013
+ 265.3500n -0.000139 265.3600n -0.000251 265.3700n -0.000345 265.3800n -0.000419 265.3900n -0.000473 265.4000n -0.000506 265.4100n -0.000517 265.4200n -0.000508 265.4300n -0.000477 265.4400n -0.000428 265.4500n -0.000362 265.4600n -0.000281 265.4700n -0.000188 265.4800n -0.000086 265.4900n 0.000022
+ 265.5000n 0.000132 265.5100n 0.000242 265.5200n 0.000347 265.5300n 0.000445 265.5400n 0.000532 265.5500n 0.000605 265.5600n 0.000662 265.5700n 0.000700 265.5800n 0.000717 265.5900n 0.000713 265.6000n 0.000685 265.6100n 0.000634 265.6200n 0.000559 265.6300n 0.000462 265.6400n 0.000343
+ 265.6500n 0.000204 265.6600n 0.000046 265.6700n -0.000127 265.6800n -0.000314 265.6900n -0.000512 265.7000n -0.000717 265.7100n -0.000926 265.7200n -0.001136 265.7300n -0.001344 265.7400n -0.001546 265.7500n -0.001740 265.7600n -0.001922 265.7700n -0.002090 265.7800n -0.002242 265.7900n -0.002376
+ 265.8000n -0.002489 265.8100n -0.002582 265.8200n -0.002652 265.8300n -0.002701 265.8400n -0.002728 265.8500n -0.002732 265.8600n -0.002716 265.8700n -0.002681 265.8800n -0.002626 265.8900n -0.002556 265.9000n -0.002470 265.9100n -0.002371 265.9200n -0.002262 265.9300n -0.002144 265.9400n -0.002020
+ 265.9500n -0.001891 265.9600n -0.001759 265.9700n -0.001627 265.9800n -0.001495 265.9900n -0.001365 266.0000n -0.001239 266.0100n -0.001116 266.0200n -0.000998 266.0300n -0.000885 266.0400n -0.000776 266.0500n -0.000673 266.0600n -0.000574 266.0700n -0.000478 266.0800n -0.000386 266.0900n -0.000297
+ 266.1000n -0.000209 266.1100n -0.000121 266.1200n -0.000033 266.1300n 0.000056 266.1400n 0.000146 266.1500n 0.000239 266.1600n 0.000335 266.1700n 0.000433 266.1800n 0.000535 266.1900n 0.000640 266.2000n 0.000747 266.2100n 0.000855 266.2200n 0.000965 266.2300n 0.001075 266.2400n 0.001183
+ 266.2500n 0.001288 266.2600n 0.001389 266.2700n 0.001485 266.2800n 0.001573 266.2900n 0.001651 266.3000n 0.001720 266.3100n 0.001776 266.3200n 0.001818 266.3300n 0.001846 266.3400n 0.001859 266.3500n 0.001855 266.3600n 0.001835 266.3700n 0.001798 266.3800n 0.001745 266.3900n 0.001675
+ 266.4000n 0.001590 266.4100n 0.001491 266.4200n 0.001379 266.4300n 0.001256 266.4400n 0.001124 266.4500n 0.000984 266.4600n 0.000839 266.4700n 0.000692 266.4800n 0.000544 266.4900n 0.000398 266.5000n 0.000256 266.5100n 0.000121 266.5200n -0.000006 266.5300n -0.000122 266.5400n -0.000226
+ 266.5500n -0.000318 266.5600n -0.000394 266.5700n -0.000456 266.5800n -0.000502 266.5900n -0.000532 266.6000n -0.000548 266.6100n -0.000548 266.6200n -0.000535 266.6300n -0.000509 266.6400n -0.000472 266.6500n -0.000425 266.6600n -0.000371 266.6700n -0.000311 266.6800n -0.000248 266.6900n -0.000183
+ 266.7000n -0.000118 266.7100n -0.000056 266.7200n 0.000002 266.7300n 0.000054 266.7400n 0.000099 266.7500n 0.000135 266.7600n 0.000163 266.7700n 0.000180 266.7800n 0.000188 266.7900n 0.000186 266.8000n 0.000174 266.8100n 0.000153 266.8200n 0.000125 266.8300n 0.000090 266.8400n 0.000051
+ 266.8500n 0.000008 266.8600n -0.000036 266.8700n -0.000079 266.8800n -0.000119 266.8900n -0.000154 266.9000n -0.000182 266.9100n -0.000202 266.9200n -0.000211 266.9300n -0.000208 266.9400n -0.000192 266.9500n -0.000161 266.9600n -0.000116 266.9700n -0.000055 266.9800n 0.000021 266.9900n 0.000112
+ 267.0000n 0.000216 267.0100n 0.000334 267.0200n 0.000464 267.0300n 0.000604 267.0400n 0.000751 267.0500n 0.000904 267.0600n 0.001061 267.0700n 0.001218 267.0800n 0.001374 267.0900n 0.001526 267.1000n 0.001671 267.1100n 0.001806 267.1200n 0.001930 267.1300n 0.002041 267.1400n 0.002135
+ 267.1500n 0.002213 267.1600n 0.002272 267.1700n 0.002312 267.1800n 0.002332 267.1900n 0.002331 267.2000n 0.002311 267.2100n 0.002271 267.2200n 0.002213 267.2300n 0.002137 267.2400n 0.002045 267.2500n 0.001940 267.2600n 0.001822 267.2700n 0.001694 267.2800n 0.001559 267.2900n 0.001419
+ 267.3000n 0.001276 267.3100n 0.001132 267.3200n 0.000990 267.3300n 0.000853 267.3400n 0.000721 267.3500n 0.000597 267.3600n 0.000483 267.3700n 0.000379 267.3800n 0.000287 267.3900n 0.000207 267.4000n 0.000140 267.4100n 0.000086 267.4200n 0.000044 267.4300n 0.000014 267.4400n -0.000005
+ 267.4500n -0.000014 267.4600n -0.000014 267.4700n -0.000007 267.4800n 0.000006 267.4900n 0.000024 267.5000n 0.000044 267.5100n 0.000066 267.5200n 0.000086 267.5300n 0.000105 267.5400n 0.000121 267.5500n 0.000131 267.5600n 0.000136 267.5700n 0.000135 267.5800n 0.000126 267.5900n 0.000110
+ 267.6000n 0.000086 267.6100n 0.000055 267.6200n 0.000016 267.6300n -0.000030 267.6400n -0.000082 267.6500n -0.000139 267.6600n -0.000200 267.6700n -0.000265 267.6800n -0.000333 267.6900n -0.000401 267.7000n -0.000470 267.7100n -0.000537 267.7200n -0.000602 267.7300n -0.000664 267.7400n -0.000723
+ 267.7500n -0.000777 267.7600n -0.000826 267.7700n -0.000871 267.7800n -0.000909 267.7900n -0.000943 267.8000n -0.000972 267.8100n -0.000996 267.8200n -0.001016 267.8300n -0.001033 267.8400n -0.001048 267.8500n -0.001060 267.8600n -0.001072 267.8700n -0.001084 267.8800n -0.001097 267.8900n -0.001112
+ 267.9000n -0.001130 267.9100n -0.001150 267.9200n -0.001175 267.9300n -0.001203 267.9400n -0.001235 267.9500n -0.001272 267.9600n -0.001312 267.9700n -0.001356 267.9800n -0.001402 267.9900n -0.001451 268.0000n -0.001500 268.0100n -0.001550 268.0200n -0.001598 268.0300n -0.001643 268.0400n -0.001684
+ 268.0500n -0.001720 268.0600n -0.001750 268.0700n -0.001771 268.0800n -0.001783 268.0900n -0.001784 268.1000n -0.001775 268.1100n -0.001753 268.1200n -0.001720 268.1300n -0.001674 268.1400n -0.001615 268.1500n -0.001544 268.1600n -0.001462 268.1700n -0.001368 268.1800n -0.001266 268.1900n -0.001154
+ 268.2000n -0.001036 268.2100n -0.000913 268.2200n -0.000787 268.2300n -0.000659 268.2400n -0.000533 268.2500n -0.000408 268.2600n -0.000289 268.2700n -0.000176 268.2800n -0.000072 268.2900n 0.000023 268.3000n 0.000105 268.3100n 0.000176 268.3200n 0.000232 268.3300n 0.000275 268.3400n 0.000302
+ 268.3500n 0.000316 268.3600n 0.000315 268.3700n 0.000300 268.3800n 0.000273 268.3900n 0.000235 268.4000n 0.000187 268.4100n 0.000130 268.4200n 0.000067 268.4300n 0.000000 268.4400n -0.000069 268.4500n -0.000138 268.4600n -0.000206 268.4700n -0.000269 268.4800n -0.000325 268.4900n -0.000374
+ 268.5000n -0.000413 268.5100n -0.000441 268.5200n -0.000457 268.5300n -0.000460 268.5400n -0.000449 268.5500n -0.000425 268.5600n -0.000388 268.5700n -0.000338 268.5800n -0.000275 268.5900n -0.000202 268.6000n -0.000120 268.6100n -0.000030 268.6200n 0.000066 268.6300n 0.000165 268.6400n 0.000266
+ 268.6500n 0.000365 268.6600n 0.000462 268.6700n 0.000554 268.6800n 0.000637 268.6900n 0.000712 268.7000n 0.000775 268.7100n 0.000825 268.7200n 0.000860 268.7300n 0.000881 268.7400n 0.000885 268.7500n 0.000872 268.7600n 0.000844 268.7700n 0.000798 268.7800n 0.000737 268.7900n 0.000662
+ 268.8000n 0.000573 268.8100n 0.000472 268.8200n 0.000360 268.8300n 0.000241 268.8400n 0.000115 268.8500n -0.000015 268.8600n -0.000147 268.8700n -0.000279 268.8800n -0.000408 268.8900n -0.000533 268.9000n -0.000651 268.9100n -0.000761 268.9200n -0.000861 268.9300n -0.000950 268.9400n -0.001027
+ 268.9500n -0.001092 268.9600n -0.001143 268.9700n -0.001181 268.9800n -0.001205 268.9900n -0.001217 269.0000n -0.001216 269.0100n -0.001204 269.0200n -0.001182 269.0300n -0.001150 269.0400n -0.001111 269.0500n -0.001065 269.0600n -0.001015 269.0700n -0.000960 269.0800n -0.000904 269.0900n -0.000846
+ 269.1000n -0.000789 269.1100n -0.000732 269.1200n -0.000677 269.1300n -0.000625 269.1400n -0.000576 269.1500n -0.000529 269.1600n -0.000485 269.1700n -0.000443 269.1800n -0.000403 269.1900n -0.000365 269.2000n -0.000327 269.2100n -0.000288 269.2200n -0.000247 269.2300n -0.000203 269.2400n -0.000155
+ 269.2500n -0.000102 269.2600n -0.000043 269.2700n 0.000023 269.2800n 0.000097 269.2900n 0.000180 269.3000n 0.000272 269.3100n 0.000372 269.3200n 0.000481 269.3300n 0.000599 269.3400n 0.000725 269.3500n 0.000857 269.3600n 0.000994 269.3700n 0.001136 269.3800n 0.001280 269.3900n 0.001424
+ 269.4000n 0.001567 269.4100n 0.001707 269.4200n 0.001841 269.4300n 0.001966 269.4400n 0.002082 269.4500n 0.002186 269.4600n 0.002276 269.4700n 0.002350 269.4800n 0.002408 269.4900n 0.002447 269.5000n 0.002467 269.5100n 0.002469 269.5200n 0.002450 269.5300n 0.002413 269.5400n 0.002357
+ 269.5500n 0.002283 269.5600n 0.002193 269.5700n 0.002088 269.5800n 0.001971 269.5900n 0.001843 269.6000n 0.001707 269.6100n 0.001566 269.6200n 0.001421 269.6300n 0.001277 269.6400n 0.001135 269.6500n 0.000998 269.6600n 0.000868 269.6700n 0.000747 269.6800n 0.000639 269.6900n 0.000543
+ 269.7000n 0.000462 269.7100n 0.000397 269.7200n 0.000347 269.7300n 0.000314 269.7400n 0.000297 269.7500n 0.000294 269.7600n 0.000307 269.7700n 0.000331 269.7800n 0.000367 269.7900n 0.000412 269.8000n 0.000464 269.8100n 0.000521 269.8200n 0.000579 269.8300n 0.000636 269.8400n 0.000690
+ 269.8500n 0.000738 269.8600n 0.000778 269.8700n 0.000807 269.8800n 0.000825 269.8900n 0.000828 269.9000n 0.000816 269.9100n 0.000788 269.9200n 0.000744 269.9300n 0.000684 269.9400n 0.000608 269.9500n 0.000516 269.9600n 0.000411 269.9700n 0.000294 269.9800n 0.000167 269.9900n 0.000032
+ 270.0000n -0.000108 270.0100n -0.000250 270.0200n -0.000392 270.0300n -0.000530 270.0400n -0.000661 270.0500n -0.000783 270.0600n -0.000893 270.0700n -0.000988 270.0800n -0.001067 270.0900n -0.001127 270.1000n -0.001167 270.1100n -0.001185 270.1200n -0.001182 270.1300n -0.001157 270.1400n -0.001110
+ 270.1500n -0.001043 270.1600n -0.000956 270.1700n -0.000851 270.1800n -0.000732 270.1900n -0.000599 270.2000n -0.000456 270.2100n -0.000306 270.2200n -0.000153 270.2300n 0.000001 270.2400n 0.000153 270.2500n 0.000298 270.2600n 0.000434 270.2700n 0.000558 270.2800n 0.000667 270.2900n 0.000760
+ 270.3000n 0.000833 270.3100n 0.000885 270.3200n 0.000917 270.3300n 0.000926 270.3400n 0.000913 270.3500n 0.000879 270.3600n 0.000824 270.3700n 0.000750 270.3800n 0.000659 270.3900n 0.000553 270.4000n 0.000435 270.4100n 0.000307 270.4200n 0.000173 270.4300n 0.000036 270.4400n -0.000102
+ 270.4500n -0.000237 270.4600n -0.000366 270.4700n -0.000486 270.4800n -0.000595 270.4900n -0.000690 270.5000n -0.000770 270.5100n -0.000834 270.5200n -0.000881 270.5300n -0.000910 270.5400n -0.000922 270.5500n -0.000917 270.5600n -0.000896 270.5700n -0.000862 270.5800n -0.000816 270.5900n -0.000762
+ 270.6000n -0.000701 270.6100n -0.000638 270.6200n -0.000574 270.6300n -0.000515 270.6400n -0.000462 270.6500n -0.000420 270.6600n -0.000392 270.6700n -0.000380 270.6800n -0.000388 270.6900n -0.000416 270.7000n -0.000468 270.7100n -0.000544 270.7200n -0.000644 270.7300n -0.000769 270.7400n -0.000917
+ 270.7500n -0.001088 270.7600n -0.001280 270.7700n -0.001490 270.7800n -0.001714 270.7900n -0.001950 270.8000n -0.002194 270.8100n -0.002441 270.8200n -0.002685 270.8300n -0.002924 270.8400n -0.003151 270.8500n -0.003363 270.8600n -0.003553 270.8700n -0.003719 270.8800n -0.003855 270.8900n -0.003959
+ 270.9000n -0.004027 270.9100n -0.004056 270.9200n -0.004045 270.9300n -0.003993 270.9400n -0.003899 270.9500n -0.003764 270.9600n -0.003589 270.9700n -0.003375 270.9800n -0.003127 270.9900n -0.002847 271.0000n -0.002539 271.0100n -0.002208 271.0200n -0.001859 271.0300n -0.001498 271.0400n -0.001131
+ 271.0500n -0.000763 271.0600n -0.000401 271.0700n -0.000050 271.0800n 0.000282 271.0900n 0.000592 271.1000n 0.000873 271.1100n 0.001121 271.1200n 0.001332 271.1300n 0.001502 271.1400n 0.001629 271.1500n 0.001710 271.1600n 0.001744 271.1700n 0.001732 271.1800n 0.001673 271.1900n 0.001568
+ 271.2000n 0.001421 271.2100n 0.001234 271.2200n 0.001010 271.2300n 0.000753 271.2400n 0.000469 271.2500n 0.000163 271.2600n -0.000161 271.2700n -0.000495 271.2800n -0.000835 271.2900n -0.001174 271.3000n -0.001507 271.3100n -0.001827 271.3200n -0.002130 271.3300n -0.002411 271.3400n -0.002665
+ 271.3500n -0.002888 271.3600n -0.003077 271.3700n -0.003230 271.3800n -0.003344 271.3900n -0.003418 271.4000n -0.003451 271.4100n -0.003444 271.4200n -0.003398 271.4300n -0.003314 271.4400n -0.003195 271.4500n -0.003042 271.4600n -0.002859 271.4700n -0.002651 271.4800n -0.002419 271.4900n -0.002170
+ 271.5000n -0.001906 271.5100n -0.001633 271.5200n -0.001354 271.5300n -0.001074 271.5400n -0.000798 271.5500n -0.000527 271.5600n -0.000267 271.5700n -0.000020 271.5800n 0.000210 271.5900n 0.000422 271.6000n 0.000615 271.6100n 0.000785 271.6200n 0.000933 271.6300n 0.001058 271.6400n 0.001160
+ 271.6500n 0.001239 271.6600n 0.001296 271.6700n 0.001333 271.6800n 0.001350 271.6900n 0.001349 271.7000n 0.001333 271.7100n 0.001302 271.7200n 0.001259 271.7300n 0.001207 271.7400n 0.001146 271.7500n 0.001080 271.7600n 0.001009 271.7700n 0.000935 271.7800n 0.000861 271.7900n 0.000787
+ 271.8000n 0.000715 271.8100n 0.000645 271.8200n 0.000577 271.8300n 0.000514 271.8400n 0.000454 271.8500n 0.000399 271.8600n 0.000347 271.8700n 0.000299 271.8800n 0.000255 271.8900n 0.000214 271.9000n 0.000176 271.9100n 0.000140 271.9200n 0.000107 271.9300n 0.000076 271.9400n 0.000046
+ 271.9500n 0.000018 271.9600n -0.000008 271.9700n -0.000032 271.9800n -0.000055 271.9900n -0.000075 272.0000n -0.000093 272.0100n -0.000106 272.0200n -0.000116 272.0300n -0.000122 272.0400n -0.000121 272.0500n -0.000115 272.0600n -0.000101 272.0700n -0.000080 272.0800n -0.000050 272.0900n -0.000011
+ 272.1000n 0.000037 272.1100n 0.000094 272.1200n 0.000161 272.1300n 0.000238 272.1400n 0.000323 272.1500n 0.000417 272.1600n 0.000519 272.1700n 0.000627 272.1800n 0.000741 272.1900n 0.000859 272.2000n 0.000979 272.2100n 0.001099 272.2200n 0.001219 272.2300n 0.001335 272.2400n 0.001447
+ 272.2500n 0.001551 272.2600n 0.001647 272.2700n 0.001732 272.2800n 0.001804 272.2900n 0.001863 272.3000n 0.001907 272.3100n 0.001935 272.3200n 0.001946 272.3300n 0.001940 272.3400n 0.001916 272.3500n 0.001875 272.3600n 0.001817 272.3700n 0.001743 272.3800n 0.001654 272.3900n 0.001552
+ 272.4000n 0.001438 272.4100n 0.001313 272.4200n 0.001181 272.4300n 0.001043 272.4400n 0.000901 272.4500n 0.000757 272.4600n 0.000615 272.4700n 0.000476 272.4800n 0.000342 272.4900n 0.000216 272.5000n 0.000099 272.5100n -0.000007 272.5200n -0.000101 272.5300n -0.000183 272.5400n -0.000250
+ 272.5500n -0.000303 272.5600n -0.000343 272.5700n -0.000369 272.5800n -0.000381 272.5900n -0.000382 272.6000n -0.000373 272.6100n -0.000354 272.6200n -0.000329 272.6300n -0.000298 272.6400n -0.000264 272.6500n -0.000230 272.6600n -0.000198 272.6700n -0.000170 272.6800n -0.000148 272.6900n -0.000134
+ 272.7000n -0.000131 272.7100n -0.000140 272.7200n -0.000162 272.7300n -0.000199 272.7400n -0.000252 272.7500n -0.000321 272.7600n -0.000407 272.7700n -0.000508 272.7800n -0.000624 272.7900n -0.000755 272.8000n -0.000899 272.8100n -0.001055 272.8200n -0.001219 272.8300n -0.001391 272.8400n -0.001567
+ 272.8500n -0.001745 272.8600n -0.001922 272.8700n -0.002095 272.8800n -0.002262 272.8900n -0.002419 272.9000n -0.002564 272.9100n -0.002694 272.9200n -0.002807 272.9300n -0.002900 272.9400n -0.002973 272.9500n -0.003022 272.9600n -0.003048 272.9700n -0.003048 272.9800n -0.003023 272.9900n -0.002974
+ 273.0000n -0.002899 273.0100n -0.002800 273.0200n -0.002678 273.0300n -0.002534 273.0400n -0.002371 273.0500n -0.002190 273.0600n -0.001994 273.0700n -0.001785 273.0800n -0.001567 273.0900n -0.001341 273.1000n -0.001112 273.1100n -0.000881 273.1200n -0.000653 273.1300n -0.000429 273.1400n -0.000213
+ 273.1500n -0.000007 273.1600n 0.000186 273.1700n 0.000364 273.1800n 0.000526 273.1900n 0.000669 273.2000n 0.000792 273.2100n 0.000895 273.2200n 0.000976 273.2300n 0.001035 273.2400n 0.001073 273.2500n 0.001089 273.2600n 0.001084 273.2700n 0.001059 273.2800n 0.001015 273.2900n 0.000953
+ 273.3000n 0.000875 273.3100n 0.000783 273.3200n 0.000678 273.3300n 0.000563 273.3400n 0.000439 273.3500n 0.000309 273.3600n 0.000175 273.3700n 0.000039 273.3800n -0.000097 273.3900n -0.000231 273.4000n -0.000360 273.4100n -0.000484 273.4200n -0.000600 273.4300n -0.000707 273.4400n -0.000804
+ 273.4500n -0.000888 273.4600n -0.000961 273.4700n -0.001019 273.4800n -0.001064 273.4900n -0.001094 273.5000n -0.001109 273.5100n -0.001110 273.5200n -0.001096 273.5300n -0.001068 273.5400n -0.001026 273.5500n -0.000972 273.5600n -0.000905 273.5700n -0.000828 273.5800n -0.000740 273.5900n -0.000645
+ 273.6000n -0.000542 273.6100n -0.000433 273.6200n -0.000320 273.6300n -0.000205 273.6400n -0.000089 273.6500n 0.000026 273.6600n 0.000138 273.6700n 0.000246 273.6800n 0.000348 273.6900n 0.000442 273.7000n 0.000526 273.7100n 0.000600 273.7200n 0.000662 273.7300n 0.000710 273.7400n 0.000744
+ 273.7500n 0.000762 273.7600n 0.000764 273.7700n 0.000749 273.7800n 0.000716 273.7900n 0.000667 273.8000n 0.000600 273.8100n 0.000516 273.8200n 0.000415 273.8300n 0.000298 273.8400n 0.000167 273.8500n 0.000022 273.8600n -0.000135 273.8700n -0.000303 273.8800n -0.000480 273.8900n -0.000664
+ 273.9000n -0.000853 273.9100n -0.001045 273.9200n -0.001238 273.9300n -0.001429 273.9400n -0.001616 273.9500n -0.001797 273.9600n -0.001970 273.9700n -0.002132 273.9800n -0.002282 273.9900n -0.002418 274.0000n -0.002538 274.0100n -0.002641 274.0200n -0.002725 274.0300n -0.002790 274.0400n -0.002835
+ 274.0500n -0.002860 274.0600n -0.002864 274.0700n -0.002847 274.0800n -0.002810 274.0900n -0.002754 274.1000n -0.002679 274.1100n -0.002587 274.1200n -0.002478 274.1300n -0.002356 274.1400n -0.002221 274.1500n -0.002074 274.1600n -0.001919 274.1700n -0.001757 274.1800n -0.001590 274.1900n -0.001419
+ 274.2000n -0.001248 274.2100n -0.001077 274.2200n -0.000909 274.2300n -0.000744 274.2400n -0.000585 274.2500n -0.000433 274.2600n -0.000288 274.2700n -0.000152 274.2800n -0.000025 274.2900n 0.000093 274.3000n 0.000201 274.3100n 0.000300 274.3200n 0.000389 274.3300n 0.000470 274.3400n 0.000541
+ 274.3500n 0.000606 274.3600n 0.000663 274.3700n 0.000714 274.3800n 0.000759 274.3900n 0.000800 274.4000n 0.000837 274.4100n 0.000871 274.4200n 0.000903 274.4300n 0.000933 274.4400n 0.000961 274.4500n 0.000989 274.4600n 0.001015 274.4700n 0.001041 274.4800n 0.001066 274.4900n 0.001089
+ 274.5000n 0.001110 274.5100n 0.001129 274.5200n 0.001144 274.5300n 0.001156 274.5400n 0.001162 274.5500n 0.001162 274.5600n 0.001156 274.5700n 0.001141 274.5800n 0.001117 274.5900n 0.001084 274.6000n 0.001040 274.6100n 0.000984 274.6200n 0.000917 274.6300n 0.000838 274.6400n 0.000747
+ 274.6500n 0.000644 274.6600n 0.000529 274.6700n 0.000403 274.6800n 0.000266 274.6900n 0.000120 274.7000n -0.000035 274.7100n -0.000197 274.7200n -0.000364 274.7300n -0.000535 274.7400n -0.000709 274.7500n -0.000883 274.7600n -0.001056 274.7700n -0.001226 274.7800n -0.001391 274.7900n -0.001550
+ 274.8000n -0.001701 274.8100n -0.001842 274.8200n -0.001972 274.8300n -0.002090 274.8400n -0.002196 274.8500n -0.002289 274.8600n -0.002367 274.8700n -0.002432 274.8800n -0.002484 274.8900n -0.002522 274.9000n -0.002547 274.9100n -0.002561 274.9200n -0.002563 274.9300n -0.002556 274.9400n -0.002540
+ 274.9500n -0.002517 274.9600n -0.002488 274.9700n -0.002455 274.9800n -0.002419 274.9900n -0.002381 275.0000n -0.002343 275.0100n -0.002306 275.0200n -0.002271 275.0300n -0.002238 275.0400n -0.002208 275.0500n -0.002181 275.0600n -0.002158 275.0700n -0.002138 275.0800n -0.002121 275.0900n -0.002107
+ 275.1000n -0.002094 275.1100n -0.002082 275.1200n -0.002069 275.1300n -0.002054 275.1400n -0.002037 275.1500n -0.002014 275.1600n -0.001986 275.1700n -0.001950 275.1800n -0.001906 275.1900n -0.001851 275.2000n -0.001786 275.2100n -0.001708 275.2200n -0.001617 275.2300n -0.001514 275.2400n -0.001397
+ 275.2500n -0.001266 275.2600n -0.001123 275.2700n -0.000967 275.2800n -0.000801 275.2900n -0.000624 275.3000n -0.000438 275.3100n -0.000246 275.3200n -0.000049 275.3300n 0.000151 275.3400n 0.000352 275.3500n 0.000551 275.3600n 0.000746 275.3700n 0.000934 275.3800n 0.001114 275.3900n 0.001283
+ 275.4000n 0.001439 275.4100n 0.001580 275.4200n 0.001705 275.4300n 0.001812 275.4400n 0.001900 275.4500n 0.001969 275.4600n 0.002018 275.4700n 0.002047 275.4800n 0.002056 275.4900n 0.002045 275.5000n 0.002017 275.5100n 0.001971 275.5200n 0.001910 275.5300n 0.001834 275.5400n 0.001747
+ 275.5500n 0.001649 275.5600n 0.001543 275.5700n 0.001432 275.5800n 0.001317 275.5900n 0.001200 275.6000n 0.001084 275.6100n 0.000971 275.6200n 0.000861 275.6300n 0.000758 275.6400n 0.000661 275.6500n 0.000573 275.6600n 0.000494 275.6700n 0.000424 275.6800n 0.000364 275.6900n 0.000313
+ 275.7000n 0.000272 275.7100n 0.000240 275.7200n 0.000215 275.7300n 0.000198 275.7400n 0.000186 275.7500n 0.000179 275.7600n 0.000175 275.7700n 0.000172 275.7800n 0.000170 275.7900n 0.000166 275.8000n 0.000160 275.8100n 0.000151 275.8200n 0.000138 275.8300n 0.000119 275.8400n 0.000094
+ 275.8500n 0.000063 275.8600n 0.000027 275.8700n -0.000016 275.8800n -0.000064 275.8900n -0.000117 275.9000n -0.000174 275.9100n -0.000234 275.9200n -0.000295 275.9300n -0.000356 275.9400n -0.000416 275.9500n -0.000472 275.9600n -0.000524 275.9700n -0.000570 275.9800n -0.000608 275.9900n -0.000636
+ 276.0000n -0.000655 276.0100n -0.000663 276.0200n -0.000658 276.0300n -0.000642 276.0400n -0.000612 276.0500n -0.000571 276.0600n -0.000518 276.0700n -0.000453 276.0800n -0.000379 276.0900n -0.000296 276.1000n -0.000207 276.1100n -0.000112 276.1200n -0.000015 276.1300n 0.000083 276.1400n 0.000179
+ 276.1500n 0.000271 276.1600n 0.000356 276.1700n 0.000431 276.1800n 0.000495 276.1900n 0.000546 276.2000n 0.000580 276.2100n 0.000597 276.2200n 0.000596 276.2300n 0.000574 276.2400n 0.000532 276.2500n 0.000469 276.2600n 0.000384 276.2700n 0.000279 276.2800n 0.000155 276.2900n 0.000012
+ 276.3000n -0.000148 276.3100n -0.000324 276.3200n -0.000511 276.3300n -0.000710 276.3400n -0.000916 276.3500n -0.001127 276.3600n -0.001340 276.3700n -0.001552 276.3800n -0.001760 276.3900n -0.001962 276.4000n -0.002154 276.4100n -0.002335 276.4200n -0.002501 276.4300n -0.002651 276.4400n -0.002784
+ 276.4500n -0.002897 276.4600n -0.002990 276.4700n -0.003063 276.4800n -0.003114 276.4900n -0.003145 276.5000n -0.003155 276.5100n -0.003146 276.5200n -0.003119 276.5300n -0.003074 276.5400n -0.003015 276.5500n -0.002941 276.5600n -0.002857 276.5700n -0.002762 276.5800n -0.002661 276.5900n -0.002554
+ 276.6000n -0.002443 276.6100n -0.002332 276.6200n -0.002220 276.6300n -0.002110 276.6400n -0.002004 276.6500n -0.001901 276.6600n -0.001803 276.6700n -0.001711 276.6800n -0.001624 276.6900n -0.001543 276.7000n -0.001468 276.7100n -0.001397 276.7200n -0.001330 276.7300n -0.001266 276.7400n -0.001205
+ 276.7500n -0.001144 276.7600n -0.001084 276.7700n -0.001021 276.7800n -0.000957 276.7900n -0.000888 276.8000n -0.000816 276.8100n -0.000738 276.8200n -0.000654 276.8300n -0.000565 276.8400n -0.000469 276.8500n -0.000367 276.8600n -0.000260 276.8700n -0.000148 276.8800n -0.000033 276.8900n 0.000084
+ 276.9000n 0.000203 276.9100n 0.000320 276.9200n 0.000435 276.9300n 0.000546 276.9400n 0.000650 276.9500n 0.000745 276.9600n 0.000830 276.9700n 0.000904 276.9800n 0.000963 276.9900n 0.001007 277.0000n 0.001035 277.0100n 0.001045 277.0200n 0.001038 277.0300n 0.001013 277.0400n 0.000970
+ 277.0500n 0.000909 277.0600n 0.000833 277.0700n 0.000741 277.0800n 0.000637 277.0900n 0.000521 277.1000n 0.000396 277.1100n 0.000265 277.1200n 0.000130 277.1300n -0.000005 277.1400n -0.000137 277.1500n -0.000264 277.1600n -0.000383 277.1700n -0.000491 277.1800n -0.000584 277.1900n -0.000661
+ 277.2000n -0.000719 277.2100n -0.000757 277.2200n -0.000773 277.2300n -0.000767 277.2400n -0.000737 277.2500n -0.000685 277.2600n -0.000609 277.2700n -0.000513 277.2800n -0.000396 277.2900n -0.000261 277.3000n -0.000111 277.3100n 0.000052 277.3200n 0.000225 277.3300n 0.000405 277.3400n 0.000587
+ 277.3500n 0.000769 277.3600n 0.000946 277.3700n 0.001116 277.3800n 0.001273 277.3900n 0.001416 277.4000n 0.001541 277.4100n 0.001646 277.4200n 0.001727 277.4300n 0.001784 277.4400n 0.001814 277.4500n 0.001816 277.4600n 0.001792 277.4700n 0.001740 277.4800n 0.001661 277.4900n 0.001557
+ 277.5000n 0.001429 277.5100n 0.001280 277.5200n 0.001113 277.5300n 0.000930 277.5400n 0.000735 277.5500n 0.000531 277.5600n 0.000322 277.5700n 0.000112 277.5800n -0.000094 277.5900n -0.000295 277.6000n -0.000485 277.6100n -0.000662 277.6200n -0.000822 277.6300n -0.000963 277.6400n -0.001083
+ 277.6500n -0.001180 277.6600n -0.001252 277.6700n -0.001299 277.6800n -0.001321 277.6900n -0.001318 277.7000n -0.001290 277.7100n -0.001240 277.7200n -0.001169 277.7300n -0.001079 277.7400n -0.000973 277.7500n -0.000853 277.7600n -0.000724 277.7700n -0.000587 277.7800n -0.000447 277.7900n -0.000308
+ 277.8000n -0.000171 277.8100n -0.000041 277.8200n 0.000080 277.8300n 0.000188 277.8400n 0.000281 277.8500n 0.000358 277.8600n 0.000417 277.8700n 0.000456 277.8800n 0.000476 277.8900n 0.000474 277.9000n 0.000453 277.9100n 0.000413 277.9200n 0.000355 277.9300n 0.000280 277.9400n 0.000190
+ 277.9500n 0.000089 277.9600n -0.000023 277.9700n -0.000141 277.9800n -0.000263 277.9900n -0.000386 278.0000n -0.000508 278.0100n -0.000625 278.0200n -0.000734 278.0300n -0.000833 278.0400n -0.000920 278.0500n -0.000993 278.0600n -0.001049 278.0700n -0.001088 278.0800n -0.001109 278.0900n -0.001111
+ 278.1000n -0.001095 278.1100n -0.001059 278.1200n -0.001006 278.1300n -0.000937 278.1400n -0.000851 278.1500n -0.000753 278.1600n -0.000642 278.1700n -0.000522 278.1800n -0.000394 278.1900n -0.000262 278.2000n -0.000127 278.2100n 0.000009 278.2200n 0.000142 278.2300n 0.000271 278.2400n 0.000394
+ 278.2500n 0.000510 278.2600n 0.000616 278.2700n 0.000711 278.2800n 0.000796 278.2900n 0.000868 278.3000n 0.000929 278.3100n 0.000978 278.3200n 0.001015 278.3300n 0.001042 278.3400n 0.001060 278.3500n 0.001069 278.3600n 0.001072 278.3700n 0.001069 278.3800n 0.001063 278.3900n 0.001055
+ 278.4000n 0.001048 278.4100n 0.001042 278.4200n 0.001039 278.4300n 0.001042 278.4400n 0.001050 278.4500n 0.001066 278.4600n 0.001090 278.4700n 0.001123 278.4800n 0.001165 278.4900n 0.001216 278.5000n 0.001276 278.5100n 0.001344 278.5200n 0.001419 278.5300n 0.001501 278.5400n 0.001588
+ 278.5500n 0.001679 278.5600n 0.001771 278.5700n 0.001864 278.5800n 0.001956 278.5900n 0.002044 278.6000n 0.002128 278.6100n 0.002204 278.6200n 0.002273 278.6300n 0.002331 278.6400n 0.002379 278.6500n 0.002415 278.6600n 0.002439 278.6700n 0.002449 278.6800n 0.002446 278.6900n 0.002431
+ 278.7000n 0.002402 278.7100n 0.002362 278.7200n 0.002311 278.7300n 0.002250 278.7400n 0.002180 278.7500n 0.002104 278.7600n 0.002023 278.7700n 0.001938 278.7800n 0.001852 278.7900n 0.001767 278.8000n 0.001683 278.8100n 0.001605 278.8200n 0.001531 278.8300n 0.001466 278.8400n 0.001408
+ 278.8500n 0.001361 278.8600n 0.001324 278.8700n 0.001298 278.8800n 0.001283 278.8900n 0.001280 278.9000n 0.001288 278.9100n 0.001306 278.9200n 0.001333 278.9300n 0.001369 278.9400n 0.001413 278.9500n 0.001461 278.9600n 0.001514 278.9700n 0.001569 278.9800n 0.001624 278.9900n 0.001678
+ 279.0000n 0.001728 279.0100n 0.001773 279.0200n 0.001811 279.0300n 0.001841 279.0400n 0.001860 279.0500n 0.001869 279.0600n 0.001864 279.0700n 0.001847 279.0800n 0.001817 279.0900n 0.001773 279.1000n 0.001715 279.1100n 0.001643 279.1200n 0.001559 279.1300n 0.001463 279.1400n 0.001356
+ 279.1500n 0.001240 279.1600n 0.001115 279.1700n 0.000984 279.1800n 0.000848 279.1900n 0.000708 279.2000n 0.000568 279.2100n 0.000427 279.2200n 0.000289 279.2300n 0.000155 279.2400n 0.000027 279.2500n -0.000095 279.2600n -0.000209 279.2700n -0.000313 279.2800n -0.000407 279.2900n -0.000490
+ 279.3000n -0.000561 279.3100n -0.000621 279.3200n -0.000669 279.3300n -0.000705 279.3400n -0.000731 279.3500n -0.000745 279.3600n -0.000750 279.3700n -0.000745 279.3800n -0.000733 279.3900n -0.000713 279.4000n -0.000688 279.4100n -0.000658 279.4200n -0.000624 279.4300n -0.000589 279.4400n -0.000553
+ 279.4500n -0.000517 279.4600n -0.000482 279.4700n -0.000450 279.4800n -0.000421 279.4900n -0.000396 279.5000n -0.000376 279.5100n -0.000361 279.5200n -0.000352 279.5300n -0.000349 279.5400n -0.000352 279.5500n -0.000361 279.5600n -0.000375 279.5700n -0.000395 279.5800n -0.000421 279.5900n -0.000451
+ 279.6000n -0.000486 279.6100n -0.000525 279.6200n -0.000566 279.6300n -0.000610 279.6400n -0.000655 279.6500n -0.000701 279.6600n -0.000747 279.6700n -0.000792 279.6800n -0.000835 279.6900n -0.000876 279.7000n -0.000914 279.7100n -0.000947 279.7200n -0.000976 279.7300n -0.000999 279.7400n -0.001015
+ 279.7500n -0.001025 279.7600n -0.001027 279.7700n -0.001022 279.7800n -0.001007 279.7900n -0.000984 279.8000n -0.000951 279.8100n -0.000909 279.8200n -0.000856 279.8300n -0.000794 279.8400n -0.000722 279.8500n -0.000640 279.8600n -0.000548 279.8700n -0.000447 279.8800n -0.000337 279.8900n -0.000219
+ 279.9000n -0.000093 279.9100n 0.000039 279.9200n 0.000177 279.9300n 0.000318 279.9400n 0.000463 279.9500n 0.000609 279.9600n 0.000755 279.9700n 0.000899 279.9800n 0.001040 279.9900n 0.001175 280.0000n 0.001304 280.0100n 0.001423 280.0200n 0.001531 280.0300n 0.001627 280.0400n 0.001708
+ 280.0500n 0.001774 280.0600n 0.001822 280.0700n 0.001852 280.0800n 0.001863 280.0900n 0.001854 280.1000n 0.001824 280.1100n 0.001774 280.1200n 0.001703 280.1300n 0.001613 280.1400n 0.001504 280.1500n 0.001377 280.1600n 0.001235 280.1700n 0.001078 280.1800n 0.000909 280.1900n 0.000731
+ 280.2000n 0.000546 280.2100n 0.000357 280.2200n 0.000168 280.2300n -0.000020 280.2400n -0.000202 280.2500n -0.000375 280.2600n -0.000536 280.2700n -0.000683 280.2800n -0.000813 280.2900n -0.000922 280.3000n -0.001010 280.3100n -0.001073 280.3200n -0.001111 280.3300n -0.001122 280.3400n -0.001107
+ 280.3500n -0.001064 280.3600n -0.000996 280.3700n -0.000901 280.3800n -0.000783 280.3900n -0.000642 280.4000n -0.000482 280.4100n -0.000304 280.4200n -0.000113 280.4300n 0.000088 280.4400n 0.000296 280.4500n 0.000507 280.4600n 0.000717 280.4700n 0.000921 280.4800n 0.001117 280.4900n 0.001300
+ 280.5000n 0.001466 280.5100n 0.001613 280.5200n 0.001738 280.5300n 0.001838 280.5400n 0.001911 280.5500n 0.001956 280.5600n 0.001972 280.5700n 0.001958 280.5800n 0.001916 280.5900n 0.001845 280.6000n 0.001748 280.6100n 0.001627 280.6200n 0.001483 280.6300n 0.001321 280.6400n 0.001143
+ 280.6500n 0.000954 280.6600n 0.000757 280.6700n 0.000557 280.6800n 0.000357 280.6900n 0.000162 280.7000n -0.000023 280.7100n -0.000195 280.7200n -0.000350 280.7300n -0.000486 280.7400n -0.000598 280.7500n -0.000684 280.7600n -0.000744 280.7700n -0.000775 280.7800n -0.000777 280.7900n -0.000750
+ 280.8000n -0.000695 280.8100n -0.000612 280.8200n -0.000505 280.8300n -0.000375 280.8400n -0.000225 280.8500n -0.000059 280.8600n 0.000120 280.8700n 0.000306 280.8800n 0.000497 280.8900n 0.000688 280.9000n 0.000874 280.9100n 0.001052 280.9200n 0.001216 280.9300n 0.001364 280.9400n 0.001492
+ 280.9500n 0.001596 280.9600n 0.001675 280.9700n 0.001726 280.9800n 0.001749 280.9900n 0.001743 281.0000n 0.001707 281.0100n 0.001642 281.0200n 0.001550 281.0300n 0.001433 281.0400n 0.001293 281.0500n 0.001132 281.0600n 0.000956 281.0700n 0.000766 281.0800n 0.000568 281.0900n 0.000365
+ 281.1000n 0.000162 281.1100n -0.000038 281.1200n -0.000229 281.1300n -0.000408 281.1400n -0.000571 281.1500n -0.000716 281.1600n -0.000839 281.1700n -0.000939 281.1800n -0.001013 281.1900n -0.001062 281.2000n -0.001083 281.2100n -0.001079 281.2200n -0.001049 281.2300n -0.000996 281.2400n -0.000921
+ 281.2500n -0.000828 281.2600n -0.000719 281.2700n -0.000598 281.2800n -0.000468 281.2900n -0.000334 281.3000n -0.000200 281.3100n -0.000070 281.3200n 0.000053 281.3300n 0.000165 281.3400n 0.000261 281.3500n 0.000341 281.3600n 0.000400 281.3700n 0.000437 281.3800n 0.000452 281.3900n 0.000442
+ 281.4000n 0.000409 281.4100n 0.000353 281.4200n 0.000276 281.4300n 0.000179 281.4400n 0.000065 281.4500n -0.000061 281.4600n -0.000197 281.4700n -0.000338 281.4800n -0.000480 281.4900n -0.000618 281.5000n -0.000747 281.5100n -0.000863 281.5200n -0.000961 281.5300n -0.001037 281.5400n -0.001086
+ 281.5500n -0.001105 281.5600n -0.001092 281.5700n -0.001043 281.5800n -0.000959 281.5900n -0.000837 281.6000n -0.000678 281.6100n -0.000484 281.6200n -0.000254 281.6300n 0.000006 281.6400n 0.000295 281.6500n 0.000608 281.6600n 0.000940 281.6700n 0.001286 281.6800n 0.001641 281.6900n 0.001997
+ 281.7000n 0.002349 281.7100n 0.002691 281.7200n 0.003015 281.7300n 0.003315 281.7400n 0.003587 281.7500n 0.003823 281.7600n 0.004019 281.7700n 0.004172 281.7800n 0.004277 281.7900n 0.004332 281.8000n 0.004335 281.8100n 0.004285 281.8200n 0.004182 281.8300n 0.004029 281.8400n 0.003826
+ 281.8500n 0.003577 281.8600n 0.003285 281.8700n 0.002956 281.8800n 0.002595 281.8900n 0.002207 281.9000n 0.001800 281.9100n 0.001379 281.9200n 0.000953 281.9300n 0.000527 281.9400n 0.000109 281.9500n -0.000295 281.9600n -0.000677 281.9700n -0.001033 281.9800n -0.001358 281.9900n -0.001646
+ 282.0000n -0.001894 282.0100n -0.002099 282.0200n -0.002259 282.0300n -0.002374 282.0400n -0.002443 282.0500n -0.002467 282.0600n -0.002448 282.0700n -0.002390 282.0800n -0.002295 282.0900n -0.002167 282.1000n -0.002012 282.1100n -0.001836 282.1200n -0.001642 282.1300n -0.001439 282.1400n -0.001230
+ 282.1500n -0.001024 282.1600n -0.000825 282.1700n -0.000638 282.1800n -0.000470 282.1900n -0.000324 282.2000n -0.000205 282.2100n -0.000115 282.2200n -0.000057 282.2300n -0.000032 282.2400n -0.000041 282.2500n -0.000084 282.2600n -0.000159 282.2700n -0.000266 282.2800n -0.000400 282.2900n -0.000558
+ 282.3000n -0.000738 282.3100n -0.000933 282.3200n -0.001138 282.3300n -0.001350 282.3400n -0.001561 282.3500n -0.001767 282.3600n -0.001961 282.3700n -0.002140 282.3800n -0.002297 282.3900n -0.002428 282.4000n -0.002530 282.4100n -0.002599 282.4200n -0.002633 282.4300n -0.002629 282.4400n -0.002588
+ 282.4500n -0.002508 282.4600n -0.002390 282.4700n -0.002237 282.4800n -0.002050 282.4900n -0.001832 282.5000n -0.001587 282.5100n -0.001320 282.5200n -0.001035 282.5300n -0.000737 282.5400n -0.000433 282.5500n -0.000127 282.5600n 0.000175 282.5700n 0.000467 282.5800n 0.000744 282.5900n 0.001002
+ 282.6000n 0.001235 282.6100n 0.001439 282.6200n 0.001612 282.6300n 0.001750 282.6400n 0.001852 282.6500n 0.001916 282.6600n 0.001942 282.6700n 0.001931 282.6800n 0.001883 282.6900n 0.001802 282.7000n 0.001688 282.7100n 0.001546 282.7200n 0.001380 282.7300n 0.001193 282.7400n 0.000991
+ 282.7500n 0.000777 282.7600n 0.000558 282.7700n 0.000338 282.7800n 0.000123 282.7900n -0.000084 282.8000n -0.000278 282.8100n -0.000454 282.8200n -0.000609 282.8300n -0.000741 282.8400n -0.000845 282.8500n -0.000922 282.8600n -0.000969 282.8700n -0.000987 282.8800n -0.000975 282.8900n -0.000935
+ 282.9000n -0.000868 282.9100n -0.000776 282.9200n -0.000662 282.9300n -0.000530 282.9400n -0.000382 282.9500n -0.000222 282.9600n -0.000055 282.9700n 0.000116 282.9800n 0.000286 282.9900n 0.000451 283.0000n 0.000608 283.0100n 0.000753 283.0200n 0.000884 283.0300n 0.000997 283.0400n 0.001090
+ 283.0500n 0.001161 283.0600n 0.001210 283.0700n 0.001235 283.0800n 0.001237 283.0900n 0.001217 283.1000n 0.001175 283.1100n 0.001114 283.1200n 0.001034 283.1300n 0.000940 283.1400n 0.000833 283.1500n 0.000717 283.1600n 0.000594 283.1700n 0.000469 283.1800n 0.000345 283.1900n 0.000224
+ 283.2000n 0.000111 283.2100n 0.000008 283.2200n -0.000082 283.2300n -0.000157 283.2400n -0.000216 283.2500n -0.000256 283.2600n -0.000276 283.2700n -0.000277 283.2800n -0.000257 283.2900n -0.000219 283.3000n -0.000162 283.3100n -0.000087 283.3200n 0.000002 283.3300n 0.000105 283.3400n 0.000218
+ 283.3500n 0.000339 283.3600n 0.000466 283.3700n 0.000594 283.3800n 0.000722 283.3900n 0.000847 283.4000n 0.000965 283.4100n 0.001075 283.4200n 0.001173 283.4300n 0.001258 283.4400n 0.001328 283.4500n 0.001382 283.4600n 0.001418 283.4700n 0.001437 283.4800n 0.001437 283.4900n 0.001420
+ 283.5000n 0.001386 283.5100n 0.001336 283.5200n 0.001271 283.5300n 0.001194 283.5400n 0.001105 283.5500n 0.001008 283.5600n 0.000903 283.5700n 0.000794 283.5800n 0.000684 283.5900n 0.000573 283.6000n 0.000464 283.6100n 0.000360 283.6200n 0.000261 283.6300n 0.000170 283.6400n 0.000088
+ 283.6500n 0.000015 283.6600n -0.000047 283.6700n -0.000098 283.6800n -0.000139 283.6900n -0.000170 283.7000n -0.000190 283.7100n -0.000203 283.7200n -0.000208 283.7300n -0.000206 283.7400n -0.000201 283.7500n -0.000192 283.7600n -0.000182 283.7700n -0.000173 283.7800n -0.000167 283.7900n -0.000164
+ 283.8000n -0.000167 283.8100n -0.000177 283.8200n -0.000194 283.8300n -0.000221 283.8400n -0.000257 283.8500n -0.000302 283.8600n -0.000358 283.8700n -0.000423 283.8800n -0.000497 283.8900n -0.000579 283.9000n -0.000668 283.9100n -0.000764 283.9200n -0.000863 283.9300n -0.000966 283.9400n -0.001070
+ 283.9500n -0.001173 283.9600n -0.001274 283.9700n -0.001371 283.9800n -0.001463 283.9900n -0.001547 284.0000n -0.001624 284.0100n -0.001690 284.0200n -0.001747 284.0300n -0.001793 284.0400n -0.001827 284.0500n -0.001850 284.0600n -0.001863 284.0700n -0.001864 284.0800n -0.001856 284.0900n -0.001839
+ 284.1000n -0.001814 284.1100n -0.001783 284.1200n -0.001747 284.1300n -0.001707 284.1400n -0.001666 284.1500n -0.001624 284.1600n -0.001583 284.1700n -0.001544 284.1800n -0.001509 284.1900n -0.001479 284.2000n -0.001454 284.2100n -0.001435 284.2200n -0.001422 284.2300n -0.001415 284.2400n -0.001413
+ 284.2500n -0.001416 284.2600n -0.001423 284.2700n -0.001433 284.2800n -0.001444 284.2900n -0.001455 284.3000n -0.001463 284.3100n -0.001468 284.3200n -0.001466 284.3300n -0.001456 284.3400n -0.001435 284.3500n -0.001403 284.3600n -0.001357 284.3700n -0.001295 284.3800n -0.001218 284.3900n -0.001123
+ 284.4000n -0.001010 284.4100n -0.000879 284.4200n -0.000731 284.4300n -0.000565 284.4400n -0.000384 284.4500n -0.000188 284.4600n 0.000020 284.4700n 0.000239 284.4800n 0.000465 284.4900n 0.000696 284.5000n 0.000929 284.5100n 0.001159 284.5200n 0.001385 284.5300n 0.001602 284.5400n 0.001806
+ 284.5500n 0.001996 284.5600n 0.002166 284.5700n 0.002315 284.5800n 0.002440 284.5900n 0.002539 284.6000n 0.002610 284.6100n 0.002651 284.6200n 0.002661 284.6300n 0.002641 284.6400n 0.002591 284.6500n 0.002512 284.6600n 0.002404 284.6700n 0.002270 284.6800n 0.002112 284.6900n 0.001933
+ 284.7000n 0.001736 284.7100n 0.001525 284.7200n 0.001304 284.7300n 0.001076 284.7400n 0.000846 284.7500n 0.000618 284.7600n 0.000396 284.7700n 0.000184 284.7800n -0.000014 284.7900n -0.000194 284.8000n -0.000355 284.8100n -0.000492 284.8200n -0.000604 284.8300n -0.000689 284.8400n -0.000746
+ 284.8500n -0.000774 284.8600n -0.000775 284.8700n -0.000747 284.8800n -0.000693 284.8900n -0.000615 284.9000n -0.000514 284.9100n -0.000394 284.9200n -0.000257 284.9300n -0.000108 284.9400n 0.000051 284.9500n 0.000214 284.9600n 0.000378 284.9700n 0.000539 284.9800n 0.000694 284.9900n 0.000837
+ 285.0000n 0.000966 285.0100n 0.001078 285.0200n 0.001169 285.0300n 0.001238 285.0400n 0.001282 285.0500n 0.001300 285.0600n 0.001292 285.0700n 0.001257 285.0800n 0.001196 285.0900n 0.001109 285.1000n 0.001000 285.1100n 0.000869 285.1200n 0.000720 285.1300n 0.000555 285.1400n 0.000378
+ 285.1500n 0.000194 285.1600n 0.000005 285.1700n -0.000184 285.1800n -0.000369 285.1900n -0.000545 285.2000n -0.000709 285.2100n -0.000856 285.2200n -0.000984 285.2300n -0.001089 285.2400n -0.001168 285.2500n -0.001218 285.2600n -0.001240 285.2700n -0.001230 285.2800n -0.001188 285.2900n -0.001115
+ 285.3000n -0.001012 285.3100n -0.000879 285.3200n -0.000718 285.3300n -0.000532 285.3400n -0.000324 285.3500n -0.000096 285.3600n 0.000146 285.3700n 0.000399 285.3800n 0.000660 285.3900n 0.000922 285.4000n 0.001182 285.4100n 0.001436 285.4200n 0.001678 285.4300n 0.001905 285.4400n 0.002112
+ 285.4500n 0.002296 285.4600n 0.002454 285.4700n 0.002582 285.4800n 0.002678 285.4900n 0.002742 285.5000n 0.002770 285.5100n 0.002764 285.5200n 0.002722 285.5300n 0.002646 285.5400n 0.002536 285.5500n 0.002395 285.5600n 0.002225 285.5700n 0.002028 285.5800n 0.001808 285.5900n 0.001569
+ 285.6000n 0.001314 285.6100n 0.001048 285.6200n 0.000775 285.6300n 0.000498 285.6400n 0.000224 285.6500n -0.000045 285.6600n -0.000303 285.6700n -0.000547 285.6800n -0.000773 285.6900n -0.000978 285.7000n -0.001158 285.7100n -0.001312 285.7200n -0.001436 285.7300n -0.001531 285.7400n -0.001593
+ 285.7500n -0.001624 285.7600n -0.001623 285.7700n -0.001590 285.7800n -0.001527 285.7900n -0.001435 285.8000n -0.001317 285.8100n -0.001173 285.8200n -0.001009 285.8300n -0.000825 285.8400n -0.000626 285.8500n -0.000414 285.8600n -0.000195 285.8700n 0.000030 285.8800n 0.000256 285.8900n 0.000479
+ 285.9000n 0.000697 285.9100n 0.000906 285.9200n 0.001104 285.9300n 0.001287 285.9400n 0.001453 285.9500n 0.001601 285.9600n 0.001728 285.9700n 0.001834 285.9800n 0.001918 285.9900n 0.001979 286.0000n 0.002019 286.0100n 0.002036 286.0200n 0.002033 286.0300n 0.002010 286.0400n 0.001970
+ 286.0500n 0.001914 286.0600n 0.001845 286.0700n 0.001764 286.0800n 0.001675 286.0900n 0.001581 286.1000n 0.001484 286.1100n 0.001386 286.1200n 0.001292 286.1300n 0.001203 286.1400n 0.001121 286.1500n 0.001050 286.1600n 0.000992 286.1700n 0.000947 286.1800n 0.000919 286.1900n 0.000907
+ 286.2000n 0.000912 286.2100n 0.000936 286.2200n 0.000978 286.2300n 0.001037 286.2400n 0.001113 286.2500n 0.001205 286.2600n 0.001311 286.2700n 0.001429 286.2800n 0.001558 286.2900n 0.001695 286.3000n 0.001837 286.3100n 0.001983 286.3200n 0.002128 286.3300n 0.002270 286.3400n 0.002406
+ 286.3500n 0.002534 286.3600n 0.002650 286.3700n 0.002752 286.3800n 0.002838 286.3900n 0.002904 286.4000n 0.002950 286.4100n 0.002974 286.4200n 0.002975 286.4300n 0.002951 286.4400n 0.002903 286.4500n 0.002830 286.4600n 0.002733 286.4700n 0.002612 286.4800n 0.002470 286.4900n 0.002307
+ 286.5000n 0.002125 286.5100n 0.001928 286.5200n 0.001717 286.5300n 0.001496 286.5400n 0.001268 286.5500n 0.001036 286.5600n 0.000803 286.5700n 0.000574 286.5800n 0.000351 286.5900n 0.000137 286.6000n -0.000063 286.6100n -0.000247 286.6200n -0.000412 286.6300n -0.000555 286.6400n -0.000675
+ 286.6500n -0.000769 286.6600n -0.000836 286.6700n -0.000875 286.6800n -0.000885 286.6900n -0.000866 286.7000n -0.000820 286.7100n -0.000746 286.7200n -0.000645 286.7300n -0.000521 286.7400n -0.000374 286.7500n -0.000207 286.7600n -0.000024 286.7700n 0.000174 286.7800n 0.000382 286.7900n 0.000597
+ 286.8000n 0.000815 286.8100n 0.001034 286.8200n 0.001249 286.8300n 0.001458 286.8400n 0.001656 286.8500n 0.001840 286.8600n 0.002008 286.8700n 0.002158 286.8800n 0.002286 286.8900n 0.002392 286.9000n 0.002474 286.9100n 0.002530 286.9200n 0.002561 286.9300n 0.002566 286.9400n 0.002546
+ 286.9500n 0.002501 286.9600n 0.002433 286.9700n 0.002344 286.9800n 0.002235 286.9900n 0.002109 287.0000n 0.001968 287.0100n 0.001816 287.0200n 0.001654 287.0300n 0.001486 287.0400n 0.001315 287.0500n 0.001145 287.0600n 0.000977 287.0700n 0.000816 287.0800n 0.000663 287.0900n 0.000521
+ 287.1000n 0.000392 287.1100n 0.000279 287.1200n 0.000181 287.1300n 0.000102 287.1400n 0.000040 287.1500n -0.000002 287.1600n -0.000026 287.1700n -0.000032 287.1800n -0.000020 287.1900n 0.000009 287.2000n 0.000052 287.2100n 0.000108 287.2200n 0.000175 287.2300n 0.000251 287.2400n 0.000334
+ 287.2500n 0.000421 287.2600n 0.000510 287.2700n 0.000598 287.2800n 0.000682 287.2900n 0.000761 287.3000n 0.000831 287.3100n 0.000892 287.3200n 0.000941 287.3300n 0.000976 287.3400n 0.000997 287.3500n 0.001002 287.3600n 0.000991 287.3700n 0.000963 287.3800n 0.000918 287.3900n 0.000857
+ 287.4000n 0.000780 287.4100n 0.000688 287.4200n 0.000584 287.4300n 0.000467 287.4400n 0.000340 287.4500n 0.000205 287.4600n 0.000063 287.4700n -0.000082 287.4800n -0.000228 287.4900n -0.000374 287.5000n -0.000516 287.5100n -0.000652 287.5200n -0.000781 287.5300n -0.000899 287.5400n -0.001005
+ 287.5500n -0.001097 287.5600n -0.001172 287.5700n -0.001231 287.5800n -0.001271 287.5900n -0.001291 287.6000n -0.001291 287.6100n -0.001270 287.6200n -0.001229 287.6300n -0.001166 287.6400n -0.001083 287.6500n -0.000979 287.6600n -0.000857 287.6700n -0.000716 287.6800n -0.000559 287.6900n -0.000387
+ 287.7000n -0.000200 287.7100n -0.000003 287.7200n 0.000205 287.7300n 0.000420 287.7400n 0.000641 287.7500n 0.000865 287.7600n 0.001090 287.7700n 0.001313 287.7800n 0.001533 287.7900n 0.001746 287.8000n 0.001951 287.8100n 0.002146 287.8200n 0.002328 287.8300n 0.002495 287.8400n 0.002645
+ 287.8500n 0.002777 287.8600n 0.002889 287.8700n 0.002980 287.8800n 0.003048 287.8900n 0.003092 287.9000n 0.003113 287.9100n 0.003108 287.9200n 0.003079 287.9300n 0.003024 287.9400n 0.002945 287.9500n 0.002842 287.9600n 0.002716 287.9700n 0.002568 287.9800n 0.002399 287.9900n 0.002212
+ 288.0000n 0.002008 288.0100n 0.001790 288.0200n 0.001561 288.0300n 0.001322 288.0400n 0.001078 288.0500n 0.000830 288.0600n 0.000583 288.0700n 0.000340 288.0800n 0.000103 288.0900n -0.000123 288.1000n -0.000336 288.1100n -0.000532 288.1200n -0.000709 288.1300n -0.000863 288.1400n -0.000992
+ 288.1500n -0.001095 288.1600n -0.001168 288.1700n -0.001211 288.1800n -0.001224 288.1900n -0.001204 288.2000n -0.001152 288.2100n -0.001070 288.2200n -0.000957 288.2300n -0.000815 288.2400n -0.000646 288.2500n -0.000453 288.2600n -0.000238 288.2700n -0.000006 288.2800n 0.000241 288.2900n 0.000499
+ 288.3000n 0.000762 288.3100n 0.001028 288.3200n 0.001291 288.3300n 0.001546 288.3400n 0.001790 288.3500n 0.002017 288.3600n 0.002225 288.3700n 0.002408 288.3800n 0.002564 288.3900n 0.002690 288.4000n 0.002783 288.4100n 0.002841 288.4200n 0.002863 288.4300n 0.002849 288.4400n 0.002799
+ 288.4500n 0.002713 288.4600n 0.002592 288.4700n 0.002440 288.4800n 0.002259 288.4900n 0.002052 288.5000n 0.001823 288.5100n 0.001577 288.5200n 0.001319 288.5300n 0.001053 288.5400n 0.000784 288.5500n 0.000519 288.5600n 0.000263 288.5700n 0.000021 288.5800n -0.000202 288.5900n -0.000402
+ 288.6000n -0.000573 288.6100n -0.000712 288.6200n -0.000815 288.6300n -0.000881 288.6400n -0.000908 288.6500n -0.000894 288.6600n -0.000839 288.6700n -0.000744 288.6800n -0.000611 288.6900n -0.000441 288.7000n -0.000239 288.7100n -0.000007 288.7200n 0.000249 288.7300n 0.000524 288.7400n 0.000813
+ 288.7500n 0.001110 288.7600n 0.001408 288.7700n 0.001702 288.7800n 0.001983 288.7900n 0.002247 288.8000n 0.002488 288.8100n 0.002698 288.8200n 0.002874 288.8300n 0.003011 288.8400n 0.003104 288.8500n 0.003150 288.8600n 0.003148 288.8700n 0.003096 288.8800n 0.002993 288.8900n 0.002841
+ 288.9000n 0.002640 288.9100n 0.002394 288.9200n 0.002105 288.9300n 0.001779 288.9400n 0.001420 288.9500n 0.001034 288.9600n 0.000627 288.9700n 0.000207 288.9800n -0.000219 288.9900n -0.000645 289.0000n -0.001063 289.0100n -0.001465 289.0200n -0.001844 289.0300n -0.002195 289.0400n -0.002510
+ 289.0500n -0.002784 289.0600n -0.003012 289.0700n -0.003191 289.0800n -0.003317 289.0900n -0.003389 289.1000n -0.003405 289.1100n -0.003366 289.1200n -0.003273 289.1300n -0.003128 289.1400n -0.002933 289.1500n -0.002694 289.1600n -0.002414 289.1700n -0.002100 289.1800n -0.001757 289.1900n -0.001393
+ 289.2000n -0.001014 289.2100n -0.000628 289.2200n -0.000242 289.2300n 0.000137 289.2400n 0.000501 289.2500n 0.000845 289.2600n 0.001161 289.2700n 0.001445 289.2800n 0.001691 289.2900n 0.001895 289.3000n 0.002055 289.3100n 0.002168 289.3200n 0.002232 289.3300n 0.002247 289.3400n 0.002215
+ 289.3500n 0.002136 289.3600n 0.002014 289.3700n 0.001851 289.3800n 0.001652 289.3900n 0.001422 289.4000n 0.001165 289.4100n 0.000888 289.4200n 0.000597 289.4300n 0.000298 289.4400n -0.000003 289.4500n -0.000300 289.4600n -0.000587 289.4700n -0.000857 289.4800n -0.001107 289.4900n -0.001332
+ 289.5000n -0.001527 289.5100n -0.001690 289.5200n -0.001818 289.5300n -0.001910 289.5400n -0.001965 289.5500n -0.001983 289.5600n -0.001965 289.5700n -0.001913 289.5800n -0.001830 289.5900n -0.001718 289.6000n -0.001580 289.6100n -0.001422 289.6200n -0.001248 289.6300n -0.001062 289.6400n -0.000870
+ 289.6500n -0.000676 289.6600n -0.000485 289.6700n -0.000302 289.6800n -0.000131 289.6900n 0.000024 289.7000n 0.000159 289.7100n 0.000272 289.7200n 0.000359 289.7300n 0.000420 289.7400n 0.000454 289.7500n 0.000460 289.7600n 0.000439 289.7700n 0.000391 289.7800n 0.000318 289.7900n 0.000223
+ 289.8000n 0.000108 289.8100n -0.000024 289.8200n -0.000168 289.8300n -0.000323 289.8400n -0.000483 289.8500n -0.000645 289.8600n -0.000805 289.8700n -0.000959 289.8800n -0.001104 289.8900n -0.001237 289.9000n -0.001355 289.9100n -0.001455 289.9200n -0.001537 289.9300n -0.001599 289.9400n -0.001639
+ 289.9500n -0.001659 289.9600n -0.001659 289.9700n -0.001639 289.9800n -0.001601 289.9900n -0.001548 290.0000n -0.001481 290.0100n -0.001404 290.0200n -0.001320 290.0300n -0.001231 290.0400n -0.001141 290.0500n -0.001053 290.0600n -0.000970 290.0700n -0.000896 290.0800n -0.000833 290.0900n -0.000783
+ 290.1000n -0.000748 290.1100n -0.000730 290.1200n -0.000730 290.1300n -0.000748 290.1400n -0.000784 290.1500n -0.000838 290.1600n -0.000908 290.1700n -0.000994 290.1800n -0.001092 290.1900n -0.001200 290.2000n -0.001316 290.2100n -0.001436 290.2200n -0.001556 290.2300n -0.001675 290.2400n -0.001787
+ 290.2500n -0.001890 290.2600n -0.001980 290.2700n -0.002055 290.2800n -0.002111 290.2900n -0.002147 290.3000n -0.002160 290.3100n -0.002149 290.3200n -0.002114 290.3300n -0.002053 290.3400n -0.001968 290.3500n -0.001858 290.3600n -0.001727 290.3700n -0.001574 290.3800n -0.001404 290.3900n -0.001218
+ 290.4000n -0.001020 290.4100n -0.000814 290.4200n -0.000603 290.4300n -0.000391 290.4400n -0.000182 290.4500n 0.000020 290.4600n 0.000212 290.4700n 0.000390 290.4800n 0.000551 290.4900n 0.000692 290.5000n 0.000811 290.5100n 0.000906 290.5200n 0.000976 290.5300n 0.001020 290.5400n 0.001038
+ 290.5500n 0.001030 290.5600n 0.000998 290.5700n 0.000943 290.5800n 0.000867 290.5900n 0.000773 290.6000n 0.000663 290.6100n 0.000540 290.6200n 0.000409 290.6300n 0.000272 290.6400n 0.000133 290.6500n -0.000004 290.6600n -0.000137 290.6700n -0.000261 290.6800n -0.000374 290.6900n -0.000474
+ 290.7000n -0.000558 290.7100n -0.000624 290.7200n -0.000673 290.7300n -0.000702 290.7400n -0.000712 290.7500n -0.000704 290.7600n -0.000679 290.7700n -0.000638 290.7800n -0.000583 290.7900n -0.000517 290.8000n -0.000443 290.8100n -0.000364 290.8200n -0.000282 290.8300n -0.000202 290.8400n -0.000126
+ 290.8500n -0.000059 290.8600n -0.000003 290.8700n 0.000040 290.8800n 0.000066 290.8900n 0.000073 290.9000n 0.000060 290.9100n 0.000025 290.9200n -0.000032 290.9300n -0.000110 290.9400n -0.000210 290.9500n -0.000331 290.9600n -0.000470 290.9700n -0.000625 290.9800n -0.000794 290.9900n -0.000973
+ 291.0000n -0.001158 291.0100n -0.001347 291.0200n -0.001534 291.0300n -0.001717 291.0400n -0.001890 291.0500n -0.002050 291.0600n -0.002193 291.0700n -0.002315 291.0800n -0.002414 291.0900n -0.002487 291.1000n -0.002531 291.1100n -0.002545 291.1200n -0.002529 291.1300n -0.002482 291.1400n -0.002404
+ 291.1500n -0.002296 291.1600n -0.002161 291.1700n -0.002000 291.1800n -0.001817 291.1900n -0.001615 291.2000n -0.001398 291.2100n -0.001171 291.2200n -0.000937 291.2300n -0.000701 291.2400n -0.000469 291.2500n -0.000244 291.2600n -0.000033 291.2700n 0.000163 291.2800n 0.000337 291.2900n 0.000487
+ 291.3000n 0.000610 291.3100n 0.000703 291.3200n 0.000765 291.3300n 0.000794 291.3400n 0.000790 291.3500n 0.000754 291.3600n 0.000686 291.3700n 0.000589 291.3800n 0.000465 291.3900n 0.000316 291.4000n 0.000147 291.4100n -0.000040 291.4200n -0.000238 291.4300n -0.000445 291.4400n -0.000654
+ 291.4500n -0.000862 291.4600n -0.001063 291.4700n -0.001253 291.4800n -0.001427 291.4900n -0.001583 291.5000n -0.001715 291.5100n -0.001823 291.5200n -0.001902 291.5300n -0.001951 291.5400n -0.001971 291.5500n -0.001959 291.5600n -0.001918 291.5700n -0.001847 291.5800n -0.001750 291.5900n -0.001629
+ 291.6000n -0.001487 291.6100n -0.001327 291.6200n -0.001155 291.6300n -0.000974 291.6400n -0.000789 291.6500n -0.000605 291.6600n -0.000428 291.6700n -0.000262 291.6800n -0.000111 291.6900n 0.000020 291.7000n 0.000127 291.7100n 0.000206 291.7200n 0.000255 291.7300n 0.000271 291.7400n 0.000252
+ 291.7500n 0.000199 291.7600n 0.000110 291.7700n -0.000014 291.7800n -0.000171 291.7900n -0.000360 291.8000n -0.000577 291.8100n -0.000820 291.8200n -0.001084 291.8300n -0.001364 291.8400n -0.001657 291.8500n -0.001957 291.8600n -0.002258 291.8700n -0.002556 291.8800n -0.002846 291.8900n -0.003121
+ 291.9000n -0.003377 291.9100n -0.003610 291.9200n -0.003816 291.9300n -0.003990 291.9400n -0.004130 291.9500n -0.004233 291.9600n -0.004298 291.9700n -0.004323 291.9800n -0.004309 291.9900n -0.004255 292.0000n -0.004163 292.0100n -0.004034 292.0200n -0.003871 292.0300n -0.003677 292.0400n -0.003455
+ 292.0500n -0.003210 292.0600n -0.002944 292.0700n -0.002664 292.0800n -0.002373 292.0900n -0.002077 292.1000n -0.001779 292.1100n -0.001485 292.1200n -0.001198 292.1300n -0.000924 292.1400n -0.000666 292.1500n -0.000427 292.1600n -0.000209 292.1700n -0.000017 292.1800n 0.000150 292.1900n 0.000288
+ 292.2000n 0.000399 292.2100n 0.000481 292.2200n 0.000534 292.2300n 0.000561 292.2400n 0.000561 292.2500n 0.000537 292.2600n 0.000491 292.2700n 0.000426 292.2800n 0.000343 292.2900n 0.000247 292.3000n 0.000139 292.3100n 0.000023 292.3200n -0.000097 292.3300n -0.000220 292.3400n -0.000342
+ 292.3500n -0.000461 292.3600n -0.000574 292.3700n -0.000679 292.3800n -0.000774 292.3900n -0.000859 292.4000n -0.000930 292.4100n -0.000989 292.4200n -0.001035 292.4300n -0.001066 292.4400n -0.001084 292.4500n -0.001089 292.4600n -0.001082 292.4700n -0.001064 292.4800n -0.001035 292.4900n -0.000998
+ 292.5000n -0.000953 292.5100n -0.000903 292.5200n -0.000848 292.5300n -0.000790 292.5400n -0.000731 292.5500n -0.000672 292.5600n -0.000615 292.5700n -0.000559 292.5800n -0.000508 292.5900n -0.000461 292.6000n -0.000419 292.6100n -0.000383 292.6200n -0.000353 292.6300n -0.000329 292.6400n -0.000312
+ 292.6500n -0.000301 292.6600n -0.000297 292.6700n -0.000298 292.6800n -0.000305 292.6900n -0.000317 292.7000n -0.000334 292.7100n -0.000355 292.7200n -0.000380 292.7300n -0.000408 292.7400n -0.000439 292.7500n -0.000472 292.7600n -0.000508 292.7700n -0.000545 292.7800n -0.000583 292.7900n -0.000623
+ 292.8000n -0.000663 292.8100n -0.000704 292.8200n -0.000745 292.8300n -0.000786 292.8400n -0.000828 292.8500n -0.000869 292.8600n -0.000910 292.8700n -0.000950 292.8800n -0.000990 292.8900n -0.001027 292.9000n -0.001063 292.9100n -0.001097 292.9200n -0.001128 292.9300n -0.001155 292.9400n -0.001177
+ 292.9500n -0.001195 292.9600n -0.001207 292.9700n -0.001213 292.9800n -0.001211 292.9900n -0.001202 293.0000n -0.001184 293.0100n -0.001156 293.0200n -0.001119 293.0300n -0.001072 293.0400n -0.001015 293.0500n -0.000947 293.0600n -0.000870 293.0700n -0.000782 293.0800n -0.000685 293.0900n -0.000580
+ 293.1000n -0.000467 293.1100n -0.000348 293.1200n -0.000223 293.1300n -0.000095 293.1400n 0.000035 293.1500n 0.000165 293.1600n 0.000293 293.1700n 0.000418 293.1800n 0.000537 293.1900n 0.000649 293.2000n 0.000751 293.2100n 0.000843 293.2200n 0.000921 293.2300n 0.000986 293.2400n 0.001035
+ 293.2500n 0.001068 293.2600n 0.001083 293.2700n 0.001082 293.2800n 0.001063 293.2900n 0.001027 293.3000n 0.000974 293.3100n 0.000906 293.3200n 0.000824 293.3300n 0.000728 293.3400n 0.000622 293.3500n 0.000507 293.3600n 0.000385 293.3700n 0.000260 293.3800n 0.000132 293.3900n 0.000005
+ 293.4000n -0.000118 293.4100n -0.000236 293.4200n -0.000345 293.4300n -0.000444 293.4400n -0.000530 293.4500n -0.000602 293.4600n -0.000659 293.4700n -0.000698 293.4800n -0.000721 293.4900n -0.000725 293.5000n -0.000712 293.5100n -0.000682 293.5200n -0.000635 293.5300n -0.000573 293.5400n -0.000498
+ 293.5500n -0.000411 293.5600n -0.000315 293.5700n -0.000213 293.5800n -0.000105 293.5900n 0.000003 293.6000n 0.000110 293.6100n 0.000213 293.6200n 0.000309 293.6300n 0.000396 293.6400n 0.000471 293.6500n 0.000531 293.6600n 0.000575 293.6700n 0.000602 293.6800n 0.000610 293.6900n 0.000598
+ 293.7000n 0.000567 293.7100n 0.000515 293.7200n 0.000445 293.7300n 0.000355 293.7400n 0.000250 293.7500n 0.000128 293.7600n -0.000006 293.7700n -0.000150 293.7800n -0.000303 293.7900n -0.000461 293.8000n -0.000620 293.8100n -0.000778 293.8200n -0.000933 293.8300n -0.001080 293.8400n -0.001216
+ 293.8500n -0.001340 293.8600n -0.001449 293.8700n -0.001540 293.8800n -0.001612 293.8900n -0.001663 293.9000n -0.001693 293.9100n -0.001700 293.9200n -0.001685 293.9300n -0.001648 293.9400n -0.001590 293.9500n -0.001512 293.9600n -0.001415 293.9700n -0.001302 293.9800n -0.001174 293.9900n -0.001035
+ 294.0000n -0.000886 294.0100n -0.000732 294.0200n -0.000573 294.0300n -0.000415 294.0400n -0.000258 294.0500n -0.000107 294.0600n 0.000037 294.0700n 0.000171 294.0800n 0.000293 294.0900n 0.000401 294.1000n 0.000495 294.1100n 0.000573 294.1200n 0.000634 294.1300n 0.000678 294.1400n 0.000706
+ 294.1500n 0.000718 294.1600n 0.000714 294.1700n 0.000697 294.1800n 0.000667 294.1900n 0.000626 294.2000n 0.000577 294.2100n 0.000520 294.2200n 0.000459 294.2300n 0.000394 294.2400n 0.000329 294.2500n 0.000264 294.2600n 0.000202 294.2700n 0.000145 294.2800n 0.000092 294.2900n 0.000045
+ 294.3000n 0.000006 294.3100n -0.000027 294.3200n -0.000053 294.3300n -0.000073 294.3400n -0.000087 294.3500n -0.000096 294.3600n -0.000103 294.3700n -0.000108 294.3800n -0.000114 294.3900n -0.000122 294.4000n -0.000134 294.4100n -0.000154 294.4200n -0.000182 294.4300n -0.000221 294.4400n -0.000274
+ 294.4500n -0.000340 294.4600n -0.000423 294.4700n -0.000523 294.4800n -0.000640 294.4900n -0.000776 294.5000n -0.000930 294.5100n -0.001101 294.5200n -0.001289 294.5300n -0.001492 294.5400n -0.001708 294.5500n -0.001935 294.5600n -0.002170 294.5700n -0.002411 294.5800n -0.002653 294.5900n -0.002894
+ 294.6000n -0.003129 294.6100n -0.003356 294.6200n -0.003569 294.6300n -0.003765 294.6400n -0.003941 294.6500n -0.004093 294.6600n -0.004218 294.6700n -0.004313 294.6800n -0.004375 294.6900n -0.004403 294.7000n -0.004395 294.7100n -0.004349 294.7200n -0.004266 294.7300n -0.004146 294.7400n -0.003989
+ 294.7500n -0.003796 294.7600n -0.003570 294.7700n -0.003312 294.7800n -0.003026 294.7900n -0.002714 294.8000n -0.002380 294.8100n -0.002029 294.8200n -0.001664 294.8300n -0.001289 294.8400n -0.000910 294.8500n -0.000530 294.8600n -0.000154 294.8700n 0.000214 294.8800n 0.000570 294.8900n 0.000909
+ 294.9000n 0.001229 294.9100n 0.001526 294.9200n 0.001797 294.9300n 0.002041 294.9400n 0.002254 294.9500n 0.002437 294.9600n 0.002588 294.9700n 0.002706 294.9800n 0.002792 294.9900n 0.002846 295.0000n 0.002869 295.0100n 0.002863 295.0200n 0.002828 295.0300n 0.002768 295.0400n 0.002684
+ 295.0500n 0.002579 295.0600n 0.002455 295.0700n 0.002315 295.0800n 0.002161 295.0900n 0.001996 295.1000n 0.001823 295.1100n 0.001644 295.1200n 0.001462 295.1300n 0.001278 295.1400n 0.001095 295.1500n 0.000913 295.1600n 0.000736 295.1700n 0.000563 295.1800n 0.000396 295.1900n 0.000236
+ 295.2000n 0.000083 295.2100n -0.000062 295.2200n -0.000199 295.2300n -0.000329 295.2400n -0.000451 295.2500n -0.000566 295.2600n -0.000673 295.2700n -0.000773 295.2800n -0.000867 295.2900n -0.000954 295.3000n -0.001035 295.3100n -0.001111 295.3200n -0.001180 295.3300n -0.001243 295.3400n -0.001300
+ 295.3500n -0.001352 295.3600n -0.001396 295.3700n -0.001434 295.3800n -0.001465 295.3900n -0.001487 295.4000n -0.001501 295.4100n -0.001506 295.4200n -0.001502 295.4300n -0.001487 295.4400n -0.001462 295.4500n -0.001426 295.4600n -0.001378 295.4700n -0.001318 295.4800n -0.001247 295.4900n -0.001164
+ 295.5000n -0.001070 295.5100n -0.000965 295.5200n -0.000850 295.5300n -0.000725 295.5400n -0.000592 295.5500n -0.000452 295.5600n -0.000306 295.5700n -0.000155 295.5800n -0.000002 295.5900n 0.000153 295.6000n 0.000306 295.6100n 0.000458 295.6200n 0.000605 295.6300n 0.000746 295.6400n 0.000880
+ 295.6500n 0.001004 295.6600n 0.001118 295.6700n 0.001220 295.6800n 0.001309 295.6900n 0.001384 295.7000n 0.001444 295.7100n 0.001489 295.7200n 0.001519 295.7300n 0.001534 295.7400n 0.001533 295.7500n 0.001518 295.7600n 0.001489 295.7700n 0.001446 295.7800n 0.001392 295.7900n 0.001327
+ 295.8000n 0.001252 295.8100n 0.001170 295.8200n 0.001081 295.8300n 0.000987 295.8400n 0.000889 295.8500n 0.000790 295.8600n 0.000691 295.8700n 0.000594 295.8800n 0.000498 295.8900n 0.000407 295.9000n 0.000321 295.9100n 0.000241 295.9200n 0.000168 295.9300n 0.000102 295.9400n 0.000044
+ 295.9500n -0.000005 295.9600n -0.000045 295.9700n -0.000077 295.9800n -0.000099 295.9900n -0.000114 296.0000n -0.000120 296.0100n -0.000118 296.0200n -0.000109 296.0300n -0.000093 296.0400n -0.000070 296.0500n -0.000041 296.0600n -0.000007 296.0700n 0.000032 296.0800n 0.000075 296.0900n 0.000123
+ 296.1000n 0.000173 296.1100n 0.000227 296.1200n 0.000284 296.1300n 0.000343 296.1400n 0.000404 296.1500n 0.000467 296.1600n 0.000532 296.1700n 0.000598 296.1800n 0.000665 296.1900n 0.000733 296.2000n 0.000802 296.2100n 0.000871 296.2200n 0.000941 296.2300n 0.001010 296.2400n 0.001078
+ 296.2500n 0.001145 296.2600n 0.001210 296.2700n 0.001272 296.2800n 0.001332 296.2900n 0.001387 296.3000n 0.001438 296.3100n 0.001484 296.3200n 0.001524 296.3300n 0.001557 296.3400n 0.001582 296.3500n 0.001599 296.3600n 0.001608 296.3700n 0.001607 296.3800n 0.001597 296.3900n 0.001577
+ 296.4000n 0.001548 296.4100n 0.001508 296.4200n 0.001460 296.4300n 0.001402 296.4400n 0.001336 296.4500n 0.001263 296.4600n 0.001184 296.4700n 0.001099 296.4800n 0.001010 296.4900n 0.000920 296.5000n 0.000828 296.5100n 0.000738 296.5200n 0.000649 296.5300n 0.000566 296.5400n 0.000488
+ 296.5500n 0.000418 296.5600n 0.000357 296.5700n 0.000307 296.5800n 0.000268 296.5900n 0.000242 296.6000n 0.000230 296.6100n 0.000232 296.6200n 0.000248 296.6300n 0.000278 296.6400n 0.000322 296.6500n 0.000379 296.6600n 0.000449 296.6700n 0.000529 296.6800n 0.000619 296.6900n 0.000717
+ 296.7000n 0.000820 296.7100n 0.000926 296.7200n 0.001034 296.7300n 0.001141 296.7400n 0.001243 296.7500n 0.001340 296.7600n 0.001428 296.7700n 0.001505 296.7800n 0.001568 296.7900n 0.001617 296.8000n 0.001649 296.8100n 0.001663 296.8200n 0.001658 296.8300n 0.001632 296.8400n 0.001587
+ 296.8500n 0.001520 296.8600n 0.001434 296.8700n 0.001329 296.8800n 0.001206 296.8900n 0.001066 296.9000n 0.000911 296.9100n 0.000743 296.9200n 0.000566 296.9300n 0.000380 296.9400n 0.000190 296.9500n -0.000002 296.9600n -0.000194 296.9700n -0.000382 296.9800n -0.000564 296.9900n -0.000736
+ 297.0000n -0.000897 297.0100n -0.001044 297.0200n -0.001174 297.0300n -0.001288 297.0400n -0.001382 297.0500n -0.001456 297.0600n -0.001510 297.0700n -0.001543 297.0800n -0.001555 297.0900n -0.001547 297.1000n -0.001520 297.1100n -0.001474 297.1200n -0.001413 297.1300n -0.001336 297.1400n -0.001246
+ 297.1500n -0.001146 297.1600n -0.001038 297.1700n -0.000923 297.1800n -0.000805 297.1900n -0.000685 297.2000n -0.000566 297.2100n -0.000449 297.2200n -0.000337 297.2300n -0.000231 297.2400n -0.000132 297.2500n -0.000043 297.2600n 0.000038 297.2700n 0.000109 297.2800n 0.000170 297.2900n 0.000222
+ 297.3000n 0.000264 297.3100n 0.000298 297.3200n 0.000325 297.3300n 0.000345 297.3400n 0.000359 297.3500n 0.000371 297.3600n 0.000380 297.3700n 0.000388 297.3800n 0.000396 297.3900n 0.000407 297.4000n 0.000420 297.4100n 0.000438 297.4200n 0.000461 297.4300n 0.000488 297.4400n 0.000522
+ 297.4500n 0.000560 297.4600n 0.000604 297.4700n 0.000652 297.4800n 0.000704 297.4900n 0.000757 297.5000n 0.000812 297.5100n 0.000865 297.5200n 0.000915 297.5300n 0.000960 297.5400n 0.000998 297.5500n 0.001026 297.5600n 0.001044 297.5700n 0.001047 297.5800n 0.001036 297.5900n 0.001007
+ 297.6000n 0.000961 297.6100n 0.000895 297.6200n 0.000809 297.6300n 0.000703 297.6400n 0.000578 297.6500n 0.000433 297.6600n 0.000269 297.6700n 0.000089 297.6800n -0.000106 297.6900n -0.000313 297.7000n -0.000529 297.7100n -0.000752 297.7200n -0.000979 297.7300n -0.001204 297.7400n -0.001426
+ 297.7500n -0.001639 297.7600n -0.001840 297.7700n -0.002025 297.7800n -0.002191 297.7900n -0.002334 297.8000n -0.002452 297.8100n -0.002540 297.8200n -0.002598 297.8300n -0.002623 297.8400n -0.002615 297.8500n -0.002572 297.8600n -0.002494 297.8700n -0.002383 297.8800n -0.002240 297.8900n -0.002066
+ 297.9000n -0.001863 297.9100n -0.001636 297.9200n -0.001387 297.9300n -0.001120 297.9400n -0.000840 297.9500n -0.000552 297.9600n -0.000260 297.9700n 0.000031 297.9800n 0.000315 297.9900n 0.000588 298.0000n 0.000845 298.0100n 0.001081 298.0200n 0.001291 298.0300n 0.001473 298.0400n 0.001623
+ 298.0500n 0.001737 298.0600n 0.001814 298.0700n 0.001852 298.0800n 0.001851 298.0900n 0.001809 298.1000n 0.001729 298.1100n 0.001610 298.1200n 0.001455 298.1300n 0.001266 298.1400n 0.001047 298.1500n 0.000801 298.1600n 0.000532 298.1700n 0.000245 298.1800n -0.000055 298.1900n -0.000364
+ 298.2000n -0.000677 298.2100n -0.000987 298.2200n -0.001291 298.2300n -0.001582 298.2400n -0.001857 298.2500n -0.002112 298.2600n -0.002341 298.2700n -0.002542 298.2800n -0.002712 298.2900n -0.002849 298.3000n -0.002950 298.3100n -0.003014 298.3200n -0.003041 298.3300n -0.003032 298.3400n -0.002986
+ 298.3500n -0.002905 298.3600n -0.002790 298.3700n -0.002645 298.3800n -0.002472 298.3900n -0.002274 298.4000n -0.002055 298.4100n -0.001818 298.4200n -0.001568 298.4300n -0.001307 298.4400n -0.001041 298.4500n -0.000773 298.4600n -0.000507 298.4700n -0.000246 298.4800n 0.000006 298.4900n 0.000246
+ 298.5000n 0.000472 298.5100n 0.000681 298.5200n 0.000872 298.5300n 0.001043 298.5400n 0.001193 298.5500n 0.001322 298.5600n 0.001429 298.5700n 0.001516 298.5800n 0.001582 298.5900n 0.001630 298.6000n 0.001660 298.6100n 0.001674 298.6200n 0.001674 298.6300n 0.001662 298.6400n 0.001640
+ 298.6500n 0.001612 298.6600n 0.001578 298.6700n 0.001541 298.6800n 0.001503 298.6900n 0.001467 298.7000n 0.001434 298.7100n 0.001405 298.7200n 0.001382 298.7300n 0.001367 298.7400n 0.001359 298.7500n 0.001360 298.7600n 0.001369 298.7700n 0.001387 298.7800n 0.001413 298.7900n 0.001447
+ 298.8000n 0.001488 298.8100n 0.001534 298.8200n 0.001586 298.8300n 0.001640 298.8400n 0.001697 298.8500n 0.001754 298.8600n 0.001810 298.8700n 0.001863 298.8800n 0.001912 298.8900n 0.001955 298.9000n 0.001991 298.9100n 0.002019 298.9200n 0.002038 298.9300n 0.002046 298.9400n 0.002044
+ 298.9500n 0.002029 298.9600n 0.002003 298.9700n 0.001964 298.9800n 0.001914 298.9900n 0.001852 299.0000n 0.001778 299.0100n 0.001693 299.0200n 0.001598 299.0300n 0.001494 299.0400n 0.001382 299.0500n 0.001263 299.0600n 0.001137 299.0700n 0.001007 299.0800n 0.000874 299.0900n 0.000738
+ 299.1000n 0.000602 299.1100n 0.000466 299.1200n 0.000332 299.1300n 0.000201 299.1400n 0.000074 299.1500n -0.000048 299.1600n -0.000164 299.1700n -0.000273 299.1800n -0.000374 299.1900n -0.000467 299.2000n -0.000551 299.2100n -0.000626 299.2200n -0.000692 299.2300n -0.000747 299.2400n -0.000793
+ 299.2500n -0.000828 299.2600n -0.000853 299.2700n -0.000869 299.2800n -0.000875 299.2900n -0.000872 299.3000n -0.000861 299.3100n -0.000840 299.3200n -0.000813 299.3300n -0.000778 299.3400n -0.000736 299.3500n -0.000689 299.3600n -0.000636 299.3700n -0.000579 299.3800n -0.000519 299.3900n -0.000456
+ 299.4000n -0.000391 299.4100n -0.000324 299.4200n -0.000258 299.4300n -0.000192 299.4400n -0.000128 299.4500n -0.000066 299.4600n -0.000006 299.4700n 0.000050 299.4800n 0.000101 299.4900n 0.000148 299.5000n 0.000190 299.5100n 0.000226 299.5200n 0.000256 299.5300n 0.000279 299.5400n 0.000296
+ 299.5500n 0.000307 299.5600n 0.000311 299.5700n 0.000309 299.5800n 0.000300 299.5900n 0.000285 299.6000n 0.000265 299.6100n 0.000240 299.6200n 0.000210 299.6300n 0.000177 299.6400n 0.000139 299.6500n 0.000099 299.6600n 0.000056 299.6700n 0.000012 299.6800n -0.000033 299.6900n -0.000079
+ 299.7000n -0.000125 299.7100n -0.000170 299.7200n -0.000215 299.7300n -0.000258 299.7400n -0.000300 299.7500n -0.000341 299.7600n -0.000380 299.7700n -0.000418 299.7800n -0.000455 299.7900n -0.000491 299.8000n -0.000526 299.8100n -0.000561 299.8200n -0.000596 299.8300n -0.000632 299.8400n -0.000669
+ 299.8500n -0.000707 299.8600n -0.000747 299.8700n -0.000790 299.8800n -0.000834 299.8900n -0.000882 299.9000n -0.000931 299.9100n -0.000984 299.9200n -0.001038 299.9300n -0.001095 299.9400n -0.001152 299.9500n -0.001210 299.9600n -0.001268 299.9700n -0.001324 299.9800n -0.001377 299.9900n -0.001426
+ 300.0000n -0.001470 300.0100n -0.001507 300.0200n -0.001535 300.0300n -0.001553 300.0400n -0.001560 300.0500n -0.001553 300.0600n -0.001532 300.0700n -0.001495 300.0800n -0.001442 300.0900n -0.001371 300.1000n -0.001282 300.1100n -0.001175 300.1200n -0.001050 300.1300n -0.000907 300.1400n -0.000747
+ 300.1500n -0.000572 300.1600n -0.000382 300.1700n -0.000181 300.1800n 0.000031 300.1900n 0.000251 300.2000n 0.000475 300.2100n 0.000700 300.2200n 0.000924 300.2300n 0.001142 300.2400n 0.001352 300.2500n 0.001549 300.2600n 0.001730 300.2700n 0.001892 300.2800n 0.002031 300.2900n 0.002144
+ 300.3000n 0.002229 300.3100n 0.002283 300.3200n 0.002304 300.3300n 0.002292 300.3400n 0.002244 300.3500n 0.002161 300.3600n 0.002042 300.3700n 0.001890 300.3800n 0.001704 300.3900n 0.001488 300.4000n 0.001243 300.4100n 0.000973 300.4200n 0.000682 300.4300n 0.000373 300.4400n 0.000052
+ 300.4500n -0.000278 300.4600n -0.000611 300.4700n -0.000942 300.4800n -0.001266 300.4900n -0.001577 300.5000n -0.001871 300.5100n -0.002143 300.5200n -0.002389 300.5300n -0.002604 300.5400n -0.002785 300.5500n -0.002929 300.5600n -0.003033 300.5700n -0.003096 300.5800n -0.003117 300.5900n -0.003095
+ 300.6000n -0.003031 300.6100n -0.002926 300.6200n -0.002782 300.6300n -0.002601 300.6400n -0.002386 300.6500n -0.002142 300.6600n -0.001872 300.6700n -0.001581 300.6800n -0.001274 300.6900n -0.000956 300.7000n -0.000632 300.7100n -0.000309 300.7200n 0.000009 300.7300n 0.000317 300.7400n 0.000610
+ 300.7500n 0.000883 300.7600n 0.001133 300.7700n 0.001355 300.7800n 0.001548 300.7900n 0.001708 300.8000n 0.001834 300.8100n 0.001925 300.8200n 0.001981 300.8300n 0.002003 300.8400n 0.001992 300.8500n 0.001950 300.8600n 0.001879 300.8700n 0.001782 300.8800n 0.001663 300.8900n 0.001527
+ 300.9000n 0.001377 300.9100n 0.001217 300.9200n 0.001053 300.9300n 0.000889 300.9400n 0.000729 300.9500n 0.000579 300.9600n 0.000441 300.9700n 0.000321 300.9800n 0.000220 300.9900n 0.000142 301.0000n 0.000089 301.0100n 0.000062 301.0200n 0.000063 301.0300n 0.000092 301.0400n 0.000147
+ 301.0500n 0.000229 301.0600n 0.000335 301.0700n 0.000463 301.0800n 0.000611 301.0900n 0.000774 301.1000n 0.000950 301.1100n 0.001133 301.1200n 0.001321 301.1300n 0.001507 301.1400n 0.001689 301.1500n 0.001861 301.1600n 0.002020 301.1700n 0.002161 301.1800n 0.002281 301.1900n 0.002376
+ 301.2000n 0.002444 301.2100n 0.002482 301.2200n 0.002489 301.2300n 0.002464 301.2400n 0.002406 301.2500n 0.002316 301.2600n 0.002194 301.2700n 0.002043 301.2800n 0.001864 301.2900n 0.001659 301.3000n 0.001432 301.3100n 0.001187 301.3200n 0.000927 301.3300n 0.000657 301.3400n 0.000380
+ 301.3500n 0.000102 301.3600n -0.000174 301.3700n -0.000443 301.3800n -0.000700 301.3900n -0.000943 301.4000n -0.001167 301.4100n -0.001370 301.4200n -0.001548 301.4300n -0.001699 301.4400n -0.001821 301.4500n -0.001914 301.4600n -0.001977 301.4700n -0.002009 301.4800n -0.002011 301.4900n -0.001984
+ 301.5000n -0.001930 301.5100n -0.001851 301.5200n -0.001748 301.5300n -0.001624 301.5400n -0.001483 301.5500n -0.001327 301.5600n -0.001160 301.5700n -0.000985 301.5800n -0.000805 301.5900n -0.000624 301.6000n -0.000444 301.6100n -0.000268 301.6200n -0.000099 301.6300n 0.000061 301.6400n 0.000210
+ 301.6500n 0.000347 301.6600n 0.000470 301.6700n 0.000578 301.6800n 0.000672 301.6900n 0.000751 301.7000n 0.000815 301.7100n 0.000866 301.7200n 0.000904 301.7300n 0.000931 301.7400n 0.000948 301.7500n 0.000957 301.7600n 0.000959 301.7700n 0.000957 301.7800n 0.000951 301.7900n 0.000945
+ 301.8000n 0.000939 301.8100n 0.000935 301.8200n 0.000934 301.8300n 0.000939 301.8400n 0.000948 301.8500n 0.000964 301.8600n 0.000986 301.8700n 0.001015 301.8800n 0.001050 301.8900n 0.001090 301.9000n 0.001136 301.9100n 0.001186 301.9200n 0.001239 301.9300n 0.001294 301.9400n 0.001348
+ 301.9500n 0.001402 301.9600n 0.001453 301.9700n 0.001499 301.9800n 0.001539 301.9900n 0.001572 302.0000n 0.001596 302.0100n 0.001610 302.0200n 0.001613 302.0300n 0.001604 302.0400n 0.001583 302.0500n 0.001549 302.0600n 0.001503 302.0700n 0.001444 302.0800n 0.001372 302.0900n 0.001290
+ 302.1000n 0.001196 302.1100n 0.001093 302.1200n 0.000982 302.1300n 0.000864 302.1400n 0.000740 302.1500n 0.000612 302.1600n 0.000482 302.1700n 0.000352 302.1800n 0.000223 302.1900n 0.000096 302.2000n -0.000027 302.2100n -0.000144 302.2200n -0.000255 302.2300n -0.000358 302.2400n -0.000452
+ 302.2500n -0.000538 302.2600n -0.000613 302.2700n -0.000679 302.2800n -0.000734 302.2900n -0.000779 302.3000n -0.000814 302.3100n -0.000840 302.3200n -0.000856 302.3300n -0.000865 302.3400n -0.000865 302.3500n -0.000859 302.3600n -0.000847 302.3700n -0.000829 302.3800n -0.000808 302.3900n -0.000783
+ 302.4000n -0.000755 302.4100n -0.000725 302.4200n -0.000695 302.4300n -0.000663 302.4400n -0.000632 302.4500n -0.000601 302.4600n -0.000571 302.4700n -0.000543 302.4800n -0.000516 302.4900n -0.000490 302.5000n -0.000466 302.5100n -0.000444 302.5200n -0.000423 302.5300n -0.000405 302.5400n -0.000388
+ 302.5500n -0.000373 302.5600n -0.000360 302.5700n -0.000349 302.5800n -0.000341 302.5900n -0.000335 302.6000n -0.000331 302.6100n -0.000330 302.6200n -0.000332 302.6300n -0.000337 302.6400n -0.000346 302.6500n -0.000359 302.6600n -0.000376 302.6700n -0.000398 302.6800n -0.000424 302.6900n -0.000455
+ 302.7000n -0.000490 302.7100n -0.000531 302.7200n -0.000576 302.7300n -0.000625 302.7400n -0.000678 302.7500n -0.000733 302.7600n -0.000792 302.7700n -0.000851 302.7800n -0.000911 302.7900n -0.000970 302.8000n -0.001027 302.8100n -0.001080 302.8200n -0.001128 302.8300n -0.001169 302.8400n -0.001202
+ 302.8500n -0.001225 302.8600n -0.001236 302.8700n -0.001234 302.8800n -0.001218 302.8900n -0.001186 302.9000n -0.001137 302.9100n -0.001071 302.9200n -0.000987 302.9300n -0.000885 302.9400n -0.000765 302.9500n -0.000627 302.9600n -0.000473 302.9700n -0.000302 302.9800n -0.000117 302.9900n 0.000082
+ 303.0000n 0.000291 303.0100n 0.000509 303.0200n 0.000734 303.0300n 0.000962 303.0400n 0.001191 303.0500n 0.001418 303.0600n 0.001641 303.0700n 0.001855 303.0800n 0.002059 303.0900n 0.002250 303.1000n 0.002425 303.1100n 0.002581 303.1200n 0.002717 303.1300n 0.002831 303.1400n 0.002921
+ 303.1500n 0.002986 303.1600n 0.003026 303.1700n 0.003041 303.1800n 0.003030 303.1900n 0.002994 303.2000n 0.002935 303.2100n 0.002852 303.2200n 0.002750 303.2300n 0.002628 303.2400n 0.002490 303.2500n 0.002337 303.2600n 0.002174 303.2700n 0.002002 303.2800n 0.001824 303.2900n 0.001643
+ 303.3000n 0.001461 303.3100n 0.001282 303.3200n 0.001108 303.3300n 0.000940 303.3400n 0.000781 303.3500n 0.000633 303.3600n 0.000495 303.3700n 0.000370 303.3800n 0.000257 303.3900n 0.000157 303.4000n 0.000069 303.4100n -0.000007 303.4200n -0.000073 303.4300n -0.000130 303.4400n -0.000179
+ 303.4500n -0.000222 303.4600n -0.000261 303.4700n -0.000298 303.4800n -0.000336 303.4900n -0.000375 303.5000n -0.000419 303.5100n -0.000468 303.5200n -0.000525 303.5300n -0.000590 303.5400n -0.000664 303.5500n -0.000749 303.5600n -0.000844 303.5700n -0.000950 303.5800n -0.001065 303.5900n -0.001189
+ 303.6000n -0.001320 303.6100n -0.001456 303.6200n -0.001596 303.6300n -0.001738 303.6400n -0.001878 303.6500n -0.002015 303.6600n -0.002144 303.6700n -0.002264 303.6800n -0.002372 303.6900n -0.002464 303.7000n -0.002539 303.7100n -0.002594 303.7200n -0.002626 303.7300n -0.002636 303.7400n -0.002620
+ 303.7500n -0.002580 303.7600n -0.002514 303.7700n -0.002423 303.7800n -0.002308 303.7900n -0.002170 303.8000n -0.002011 303.8100n -0.001834 303.8200n -0.001642 303.8300n -0.001438 303.8400n -0.001225 303.8500n -0.001007 303.8600n -0.000789 303.8700n -0.000575 303.8800n -0.000369 303.8900n -0.000174
+ 303.9000n 0.000004 303.9100n 0.000164 303.9200n 0.000300 303.9300n 0.000410 303.9400n 0.000493 303.9500n 0.000545 303.9600n 0.000567 303.9700n 0.000557 303.9800n 0.000515 303.9900n 0.000443 304.0000n 0.000342 304.0100n 0.000213 304.0200n 0.000061 304.0300n -0.000112 304.0400n -0.000302
+ 304.0500n -0.000504 304.0600n -0.000715 304.0700n -0.000928 304.0800n -0.001139 304.0900n -0.001343 304.1000n -0.001534 304.1100n -0.001709 304.1200n -0.001861 304.1300n -0.001987 304.1400n -0.002083 304.1500n -0.002146 304.1600n -0.002174 304.1700n -0.002163 304.1800n -0.002114 304.1900n -0.002026
+ 304.2000n -0.001900 304.2100n -0.001736 304.2200n -0.001536 304.2300n -0.001304 304.2400n -0.001043 304.2500n -0.000756 304.2600n -0.000450 304.2700n -0.000128 304.2800n 0.000204 304.2900n 0.000539 304.3000n 0.000873 304.3100n 0.001198 304.3200n 0.001510 304.3300n 0.001803 304.3400n 0.002070
+ 304.3500n 0.002309 304.3600n 0.002513 304.3700n 0.002679 304.3800n 0.002805 304.3900n 0.002888 304.4000n 0.002927 304.4100n 0.002920 304.4200n 0.002869 304.4300n 0.002774 304.4400n 0.002637 304.4500n 0.002461 304.4600n 0.002249 304.4700n 0.002005 304.4800n 0.001735 304.4900n 0.001442
+ 304.5000n 0.001133 304.5100n 0.000814 304.5200n 0.000490 304.5300n 0.000167 304.5400n -0.000148 304.5500n -0.000450 304.5600n -0.000733 304.5700n -0.000992 304.5800n -0.001224 304.5900n -0.001422 304.6000n -0.001586 304.6100n -0.001710 304.6200n -0.001795 304.6300n -0.001838 304.6400n -0.001840
+ 304.6500n -0.001800 304.6600n -0.001720 304.6700n -0.001602 304.6800n -0.001448 304.6900n -0.001262 304.7000n -0.001048 304.7100n -0.000808 304.7200n -0.000549 304.7300n -0.000275 304.7400n 0.000009 304.7500n 0.000299 304.7600n 0.000588 304.7700n 0.000873 304.7800n 0.001149 304.7900n 0.001412
+ 304.8000n 0.001657 304.8100n 0.001881 304.8200n 0.002082 304.8300n 0.002257 304.8400n 0.002404 304.8500n 0.002523 304.8600n 0.002613 304.8700n 0.002673 304.8800n 0.002706 304.8900n 0.002712 304.9000n 0.002692 304.9100n 0.002651 304.9200n 0.002589 304.9300n 0.002510 304.9400n 0.002417
+ 304.9500n 0.002315 304.9600n 0.002205 304.9700n 0.002093 304.9800n 0.001981 304.9900n 0.001873 305.0000n 0.001772 305.0100n 0.001680 305.0200n 0.001601 305.0300n 0.001536 305.0400n 0.001488 305.0500n 0.001458 305.0600n 0.001446 305.0700n 0.001453 305.0800n 0.001479 305.0900n 0.001523
+ 305.1000n 0.001585 305.1100n 0.001664 305.1200n 0.001756 305.1300n 0.001862 305.1400n 0.001978 305.1500n 0.002102 305.1600n 0.002232 305.1700n 0.002364 305.1800n 0.002497 305.1900n 0.002627 305.2000n 0.002751 305.2100n 0.002869 305.2200n 0.002976 305.2300n 0.003071 305.2400n 0.003152
+ 305.2500n 0.003218 305.2600n 0.003267 305.2700n 0.003298 305.2800n 0.003311 305.2900n 0.003305 305.3000n 0.003280 305.3100n 0.003237 305.3200n 0.003175 305.3300n 0.003096 305.3400n 0.003000 305.3500n 0.002889 305.3600n 0.002764 305.3700n 0.002626 305.3800n 0.002478 305.3900n 0.002320
+ 305.4000n 0.002154 305.4100n 0.001982 305.4200n 0.001805 305.4300n 0.001625 305.4400n 0.001443 305.4500n 0.001262 305.4600n 0.001081 305.4700n 0.000902 305.4800n 0.000727 305.4900n 0.000556 305.5000n 0.000390 305.5100n 0.000230 305.5200n 0.000076 305.5300n -0.000070 305.5400n -0.000210
+ 305.5500n -0.000342 305.5600n -0.000466 305.5700n -0.000582 305.5800n -0.000689 305.5900n -0.000787 305.6000n -0.000877 305.6100n -0.000958 305.6200n -0.001030 305.6300n -0.001093 305.6400n -0.001147 305.6500n -0.001191 305.6600n -0.001226 305.6700n -0.001252 305.6800n -0.001268 305.6900n -0.001274
+ 305.7000n -0.001271 305.7100n -0.001259 305.7200n -0.001237 305.7300n -0.001207 305.7400n -0.001168 305.7500n -0.001120 305.7600n -0.001064 305.7700n -0.001001 305.7800n -0.000932 305.7900n -0.000856 305.8000n -0.000775 305.8100n -0.000689 305.8200n -0.000599 305.8300n -0.000507 305.8400n -0.000413
+ 305.8500n -0.000318 305.8600n -0.000222 305.8700n -0.000128 305.8800n -0.000035 305.8900n 0.000056 305.9000n 0.000143 305.9100n 0.000227 305.9200n 0.000308 305.9300n 0.000383 305.9400n 0.000455 305.9500n 0.000521 305.9600n 0.000584 305.9700n 0.000642 305.9800n 0.000695 305.9900n 0.000746
+ 306.0000n 0.000793 306.0100n 0.000838 306.0200n 0.000881 306.0300n 0.000923 306.0400n 0.000964 306.0500n 0.001005 306.0600n 0.001047 306.0700n 0.001091 306.0800n 0.001135 306.0900n 0.001182 306.1000n 0.001230 306.1100n 0.001280 306.1200n 0.001332 306.1300n 0.001385 306.1400n 0.001438
+ 306.1500n 0.001490 306.1600n 0.001541 306.1700n 0.001590 306.1800n 0.001634 306.1900n 0.001673 306.2000n 0.001705 306.2100n 0.001727 306.2200n 0.001739 306.2300n 0.001739 306.2400n 0.001725 306.2500n 0.001696 306.2600n 0.001650 306.2700n 0.001586 306.2800n 0.001504 306.2900n 0.001402
+ 306.3000n 0.001280 306.3100n 0.001138 306.3200n 0.000977 306.3300n 0.000797 306.3400n 0.000599 306.3500n 0.000385 306.3600n 0.000158 306.3700n -0.000082 306.3800n -0.000331 306.3900n -0.000586 306.4000n -0.000845 306.4100n -0.001103 306.4200n -0.001358 306.4300n -0.001605 306.4400n -0.001842
+ 306.4500n -0.002063 306.4600n -0.002266 306.4700n -0.002448 306.4800n -0.002604 306.4900n -0.002733 306.5000n -0.002832 306.5100n -0.002898 306.5200n -0.002931 306.5300n -0.002928 306.5400n -0.002890 306.5500n -0.002816 306.5600n -0.002707 306.5700n -0.002564 306.5800n -0.002388 306.5900n -0.002183
+ 306.6000n -0.001950 306.6100n -0.001693 306.6200n -0.001415 306.6300n -0.001120 306.6400n -0.000813 306.6500n -0.000498 306.6600n -0.000179 306.6700n 0.000140 306.6800n 0.000452 306.6900n 0.000755 306.7000n 0.001043 306.7100n 0.001314 306.7200n 0.001563 306.7300n 0.001786 306.7400n 0.001982
+ 306.7500n 0.002148 306.7600n 0.002283 306.7700n 0.002384 306.7800n 0.002453 306.7900n 0.002488 306.8000n 0.002490 306.8100n 0.002461 306.8200n 0.002402 306.8300n 0.002315 306.8400n 0.002204 306.8500n 0.002071 306.8600n 0.001919 306.8700n 0.001752 306.8800n 0.001573 306.8900n 0.001388
+ 306.9000n 0.001199 306.9100n 0.001010 306.9200n 0.000825 306.9300n 0.000647 306.9400n 0.000480 306.9500n 0.000327 306.9600n 0.000189 306.9700n 0.000070 306.9800n -0.000030 306.9900n -0.000109 307.0000n -0.000166 307.0100n -0.000202 307.0200n -0.000216 307.0300n -0.000208 307.0400n -0.000181
+ 307.0500n -0.000136 307.0600n -0.000074 307.0700n 0.000003 307.0800n 0.000092 307.0900n 0.000191 307.1000n 0.000297 307.1100n 0.000408 307.1200n 0.000520 307.1300n 0.000632 307.1400n 0.000741 307.1500n 0.000845 307.1600n 0.000941 307.1700n 0.001028 307.1800n 0.001104 307.1900n 0.001168
+ 307.2000n 0.001219 307.2100n 0.001257 307.2200n 0.001280 307.2300n 0.001290 307.2400n 0.001287 307.2500n 0.001270 307.2600n 0.001241 307.2700n 0.001201 307.2800n 0.001151 307.2900n 0.001092 307.3000n 0.001026 307.3100n 0.000953 307.3200n 0.000876 307.3300n 0.000795 307.3400n 0.000712
+ 307.3500n 0.000628 307.3600n 0.000544 307.3700n 0.000460 307.3800n 0.000378 307.3900n 0.000298 307.4000n 0.000219 307.4100n 0.000143 307.4200n 0.000069 307.4300n -0.000003 307.4400n -0.000074 307.4500n -0.000144 307.4600n -0.000214 307.4700n -0.000284 307.4800n -0.000355 307.4900n -0.000427
+ 307.5000n -0.000502 307.5100n -0.000580 307.5200n -0.000660 307.5300n -0.000744 307.5400n -0.000831 307.5500n -0.000922 307.5600n -0.001015 307.5700n -0.001111 307.5800n -0.001209 307.5900n -0.001307 307.6000n -0.001405 307.6100n -0.001502 307.6200n -0.001596 307.6300n -0.001685 307.6400n -0.001769
+ 307.6500n -0.001845 307.6600n -0.001912 307.6700n -0.001968 307.6800n -0.002012 307.6900n -0.002044 307.7000n -0.002060 307.7100n -0.002062 307.7200n -0.002047 307.7300n -0.002016 307.7400n -0.001969 307.7500n -0.001906 307.7600n -0.001826 307.7700n -0.001732 307.7800n -0.001625 307.7900n -0.001505
+ 307.8000n -0.001374 307.8100n -0.001235 307.8200n -0.001089 307.8300n -0.000939 307.8400n -0.000788 307.8500n -0.000637 307.8600n -0.000489 307.8700n -0.000347 307.8800n -0.000214 307.8900n -0.000090 307.9000n 0.000021 307.9100n 0.000118 307.9200n 0.000200 307.9300n 0.000264 307.9400n 0.000312
+ 307.9500n 0.000341 307.9600n 0.000352 307.9700n 0.000346 307.9800n 0.000323 307.9900n 0.000284 308.0000n 0.000231 308.0100n 0.000165 308.0200n 0.000089 308.0300n 0.000005 308.0400n -0.000085 308.0500n -0.000178 308.0600n -0.000272 308.0700n -0.000363 308.0800n -0.000449 308.0900n -0.000527
+ 308.1000n -0.000596 308.1100n -0.000652 308.1200n -0.000694 308.1300n -0.000720 308.1400n -0.000729 308.1500n -0.000721 308.1600n -0.000694 308.1700n -0.000648 308.1800n -0.000584 308.1900n -0.000503 308.2000n -0.000406 308.2100n -0.000294 308.2200n -0.000168 308.2300n -0.000032 308.2400n 0.000113
+ 308.2500n 0.000264 308.2600n 0.000418 308.2700n 0.000573 308.2800n 0.000726 308.2900n 0.000874 308.3000n 0.001016 308.3100n 0.001147 308.3200n 0.001266 308.3300n 0.001372 308.3400n 0.001462 308.3500n 0.001536 308.3600n 0.001592 308.3700n 0.001629 308.3800n 0.001649 308.3900n 0.001650
+ 308.4000n 0.001634 308.4100n 0.001601 308.4200n 0.001553 308.4300n 0.001492 308.4400n 0.001419 308.4500n 0.001336 308.4600n 0.001246 308.4700n 0.001151 308.4800n 0.001053 308.4900n 0.000954 308.5000n 0.000858 308.5100n 0.000766 308.5200n 0.000680 308.5300n 0.000602 308.5400n 0.000534
+ 308.5500n 0.000476 308.5600n 0.000430 308.5700n 0.000396 308.5800n 0.000375 308.5900n 0.000366 308.6000n 0.000369 308.6100n 0.000384 308.6200n 0.000408 308.6300n 0.000442 308.6400n 0.000483 308.6500n 0.000530 308.6600n 0.000580 308.6700n 0.000632 308.6800n 0.000684 308.6900n 0.000734
+ 308.7000n 0.000779 308.7100n 0.000819 308.7200n 0.000851 308.7300n 0.000874 308.7400n 0.000886 308.7500n 0.000887 308.7600n 0.000875 308.7700n 0.000852 308.7800n 0.000815 308.7900n 0.000766 308.8000n 0.000705 308.8100n 0.000633 308.8200n 0.000550 308.8300n 0.000459 308.8400n 0.000360
+ 308.8500n 0.000255 308.8600n 0.000146 308.8700n 0.000035 308.8800n -0.000077 308.8900n -0.000188 308.9000n -0.000296 308.9100n -0.000400 308.9200n -0.000497 308.9300n -0.000588 308.9400n -0.000671 308.9500n -0.000744 308.9600n -0.000809 308.9700n -0.000864 308.9800n -0.000910 308.9900n -0.000946
+ 309.0000n -0.000974 309.0100n -0.000994 309.0200n -0.001008 309.0300n -0.001016 309.0400n -0.001020 309.0500n -0.001021 309.0600n -0.001021 309.0700n -0.001022 309.0800n -0.001024 309.0900n -0.001030 309.1000n -0.001041 309.1100n -0.001057 309.1200n -0.001081 309.1300n -0.001111 309.1400n -0.001149
+ 309.1500n -0.001196 309.1600n -0.001250 309.1700n -0.001312 309.1800n -0.001380 309.1900n -0.001455 309.2000n -0.001533 309.2100n -0.001615 309.2200n -0.001699 309.2300n -0.001782 309.2400n -0.001863 309.2500n -0.001939 309.2600n -0.002010 309.2700n -0.002072 309.2800n -0.002124 309.2900n -0.002164
+ 309.3000n -0.002191 309.3100n -0.002204 309.3200n -0.002201 309.3300n -0.002181 309.3400n -0.002145 309.3500n -0.002092 309.3600n -0.002022 309.3700n -0.001937 309.3800n -0.001838 309.3900n -0.001725 309.4000n -0.001601 309.4100n -0.001467 309.4200n -0.001326 309.4300n -0.001181 309.4400n -0.001034
+ 309.4500n -0.000888 309.4600n -0.000746 309.4700n -0.000611 309.4800n -0.000484 309.4900n -0.000370 309.5000n -0.000271 309.5100n -0.000188 309.5200n -0.000124 309.5300n -0.000079 309.5400n -0.000056 309.5500n -0.000055 309.5600n -0.000077 309.5700n -0.000120 309.5800n -0.000186 309.5900n -0.000271
+ 309.6000n -0.000377 309.6100n -0.000499 309.6200n -0.000636 309.6300n -0.000787 309.6400n -0.000946 309.6500n -0.001113 309.6600n -0.001283 309.6700n -0.001453 309.6800n -0.001620 309.6900n -0.001780 309.7000n -0.001930 309.7100n -0.002067 309.7200n -0.002188 309.7300n -0.002290 309.7400n -0.002371
+ 309.7500n -0.002429 309.7600n -0.002462 309.7700n -0.002468 309.7800n -0.002448 309.7900n -0.002400 309.8000n -0.002325 309.8100n -0.002223 309.8200n -0.002095 309.8300n -0.001942 309.8400n -0.001766 309.8500n -0.001568 309.8600n -0.001352 309.8700n -0.001120 309.8800n -0.000874 309.8900n -0.000616
+ 309.9000n -0.000351 309.9100n -0.000081 309.9200n 0.000192 309.9300n 0.000464 309.9400n 0.000733 309.9500n 0.000996 309.9600n 0.001251 309.9700n 0.001496 309.9800n 0.001728 309.9900n 0.001947 310.0000n 0.002151 310.0100n 0.002339 310.0200n 0.002510 310.0300n 0.002664 310.0400n 0.002800
+ 310.0500n 0.002919 310.0600n 0.003021 310.0700n 0.003106 310.0800n 0.003175 310.0900n 0.003229 310.1000n 0.003268 310.1100n 0.003294 310.1200n 0.003307 310.1300n 0.003309 310.1400n 0.003300 310.1500n 0.003281 310.1600n 0.003253 310.1700n 0.003217 310.1800n 0.003173 310.1900n 0.003122
+ 310.2000n 0.003065 310.2100n 0.003002 310.2200n 0.002932 310.2300n 0.002857 310.2400n 0.002776 310.2500n 0.002690 310.2600n 0.002598 310.2700n 0.002500 310.2800n 0.002396 310.2900n 0.002287 310.3000n 0.002172 310.3100n 0.002052 310.3200n 0.001926 310.3300n 0.001795 310.3400n 0.001659
+ 310.3500n 0.001519 310.3600n 0.001375 310.3700n 0.001229 310.3800n 0.001081 310.3900n 0.000932 310.4000n 0.000783 310.4100n 0.000636 310.4200n 0.000491 310.4300n 0.000350 310.4400n 0.000214 310.4500n 0.000085 310.4600n -0.000037 310.4700n -0.000149 310.4800n -0.000251 310.4900n -0.000342
+ 310.5000n -0.000420 310.5100n -0.000486 310.5200n -0.000539 310.5300n -0.000577 310.5400n -0.000602 310.5500n -0.000613 310.5600n -0.000611 310.5700n -0.000595 310.5800n -0.000567 310.5900n -0.000527 310.6000n -0.000477 310.6100n -0.000418 310.6200n -0.000351 310.6300n -0.000277 310.6400n -0.000198
+ 310.6500n -0.000116 310.6600n -0.000033 310.6700n 0.000051 310.6800n 0.000134 310.6900n 0.000214 310.7000n 0.000289 310.7100n 0.000360 310.7200n 0.000424 310.7300n 0.000480 310.7400n 0.000529 310.7500n 0.000569 310.7600n 0.000600 310.7700n 0.000622 310.7800n 0.000635 310.7900n 0.000640
+ 310.8000n 0.000636 310.8100n 0.000625 310.8200n 0.000607 310.8300n 0.000582 310.8400n 0.000553 310.8500n 0.000519 310.8600n 0.000482 310.8700n 0.000443 310.8800n 0.000402 310.8900n 0.000362 310.9000n 0.000322 310.9100n 0.000283 310.9200n 0.000246 310.9300n 0.000213 310.9400n 0.000182
+ 310.9500n 0.000154 310.9600n 0.000130 310.9700n 0.000110 310.9800n 0.000093 310.9900n 0.000079 311.0000n 0.000067 311.0100n 0.000058 311.0200n 0.000051 311.0300n 0.000045 311.0400n 0.000040 311.0500n 0.000034 311.0600n 0.000028 311.0700n 0.000021 311.0800n 0.000012 311.0900n 0.000001
+ 311.1000n -0.000013 311.1100n -0.000029 311.1200n -0.000049 311.1300n -0.000071 311.1400n -0.000096 311.1500n -0.000123 311.1600n -0.000153 311.1700n -0.000184 311.1800n -0.000216 311.1900n -0.000248 311.2000n -0.000280 311.2100n -0.000311 311.2200n -0.000339 311.2300n -0.000365 311.2400n -0.000387
+ 311.2500n -0.000405 311.2600n -0.000418 311.2700n -0.000425 311.2800n -0.000426 311.2900n -0.000420 311.3000n -0.000408 311.3100n -0.000388 311.3200n -0.000363 311.3300n -0.000331 311.3400n -0.000293 311.3500n -0.000249 311.3600n -0.000201 311.3700n -0.000149 311.3800n -0.000094 311.3900n -0.000037
+ 311.4000n 0.000022 311.4100n 0.000080 311.4200n 0.000137 311.4300n 0.000191 311.4400n 0.000243 311.4500n 0.000290 311.4600n 0.000333 311.4700n 0.000370 311.4800n 0.000400 311.4900n 0.000425 311.5000n 0.000442 311.5100n 0.000453 311.5200n 0.000457 311.5300n 0.000455 311.5400n 0.000447
+ 311.5500n 0.000434 311.5600n 0.000417 311.5700n 0.000396 311.5800n 0.000373 311.5900n 0.000349 311.6000n 0.000324 311.6100n 0.000301 311.6200n 0.000279 311.6300n 0.000261 311.6400n 0.000247 311.6500n 0.000237 311.6600n 0.000234 311.6700n 0.000236 311.6800n 0.000245 311.6900n 0.000261
+ 311.7000n 0.000283 311.7100n 0.000311 311.7200n 0.000345 311.7300n 0.000384 311.7400n 0.000427 311.7500n 0.000473 311.7600n 0.000521 311.7700n 0.000568 311.7800n 0.000615 311.7900n 0.000658 311.8000n 0.000696 311.8100n 0.000728 311.8200n 0.000753 311.8300n 0.000767 311.8400n 0.000771
+ 311.8500n 0.000763 311.8600n 0.000742 311.8700n 0.000707 311.8800n 0.000657 311.8900n 0.000592 311.9000n 0.000513 311.9100n 0.000419 311.9200n 0.000311 311.9300n 0.000190 311.9400n 0.000057 311.9500n -0.000087 311.9600n -0.000239 311.9700n -0.000398 311.9800n -0.000563 311.9900n -0.000729
+ 312.0000n -0.000896 312.0100n -0.001061 312.0200n -0.001222 312.0300n -0.001375 312.0400n -0.001519 312.0500n -0.001652 312.0600n -0.001772 312.0700n -0.001877 312.0800n -0.001964 312.0900n -0.002034 312.1000n -0.002085 312.1100n -0.002116 312.1200n -0.002127 312.1300n -0.002118 312.1400n -0.002090
+ 312.1500n -0.002042 312.1600n -0.001976 312.1700n -0.001893 312.1800n -0.001795 312.1900n -0.001683 312.2000n -0.001559 312.2100n -0.001425 312.2200n -0.001284 312.2300n -0.001137 312.2400n -0.000987 312.2500n -0.000836 312.2600n -0.000687 312.2700n -0.000540 312.2800n -0.000399 312.2900n -0.000266
+ 312.3000n -0.000140 312.3100n -0.000025 312.3200n 0.000079 312.3300n 0.000171 312.3400n 0.000251 312.3500n 0.000317 312.3600n 0.000371 312.3700n 0.000412 312.3800n 0.000441 312.3900n 0.000458 312.4000n 0.000465 312.4100n 0.000461 312.4200n 0.000448 312.4300n 0.000428 312.4400n 0.000402
+ 312.4500n 0.000370 312.4600n 0.000334 312.4700n 0.000296 312.4800n 0.000257 312.4900n 0.000217 312.5000n 0.000178 312.5100n 0.000140 312.5200n 0.000105 312.5300n 0.000072 312.5400n 0.000043 312.5500n 0.000017 312.5600n -0.000005 312.5700n -0.000024 312.5800n -0.000039 312.5900n -0.000051
+ 312.6000n -0.000060 312.6100n -0.000067 312.6200n -0.000073 312.6300n -0.000077 312.6400n -0.000080 312.6500n -0.000083 312.6600n -0.000086 312.6700n -0.000091 312.6800n -0.000096 312.6900n -0.000102 312.7000n -0.000110 312.7100n -0.000120 312.7200n -0.000131 312.7300n -0.000144 312.7400n -0.000158
+ 312.7500n -0.000172 312.7600n -0.000187 312.7700n -0.000202 312.7800n -0.000216 312.7900n -0.000229 312.8000n -0.000240 312.8100n -0.000249 312.8200n -0.000254 312.8300n -0.000256 312.8400n -0.000254 312.8500n -0.000247 312.8600n -0.000235 312.8700n -0.000219 312.8800n -0.000197 312.8900n -0.000171
+ 312.9000n -0.000140 312.9100n -0.000104 312.9200n -0.000065 312.9300n -0.000022 312.9400n 0.000024 312.9500n 0.000072 312.9600n 0.000120 312.9700n 0.000169 312.9800n 0.000217 312.9900n 0.000264 313.0000n 0.000308 313.0100n 0.000349 313.0200n 0.000386 313.0300n 0.000417 313.0400n 0.000444
+ 313.0500n 0.000464 313.0600n 0.000478 313.0700n 0.000486 313.0800n 0.000487 313.0900n 0.000481 313.1000n 0.000470 313.1100n 0.000452 313.1200n 0.000429 313.1300n 0.000401 313.1400n 0.000369 313.1500n 0.000334 313.1600n 0.000297 313.1700n 0.000257 313.1800n 0.000217 313.1900n 0.000177
+ 313.2000n 0.000138 313.2100n 0.000100 313.2200n 0.000064 313.2300n 0.000030 313.2400n -0.000000 313.2500n -0.000028 313.2600n -0.000053 313.2700n -0.000075 313.2800n -0.000094 313.2900n -0.000111 313.3000n -0.000127 313.3100n -0.000143 313.3200n -0.000158 313.3300n -0.000175 313.3400n -0.000193
+ 313.3500n -0.000215 313.3600n -0.000241 313.3700n -0.000272 313.3800n -0.000309 313.3900n -0.000353 313.4000n -0.000404 313.4100n -0.000463 313.4200n -0.000530 313.4300n -0.000605 313.4400n -0.000689 313.4500n -0.000780 313.4600n -0.000877 313.4700n -0.000981 313.4800n -0.001089 313.4900n -0.001201
+ 313.5000n -0.001314 313.5100n -0.001427 313.5200n -0.001538 313.5300n -0.001645 313.5400n -0.001745 313.5500n -0.001836 313.5600n -0.001917 313.5700n -0.001984 313.5800n -0.002037 313.5900n -0.002072 313.6000n -0.002088 313.6100n -0.002085 313.6200n -0.002060 313.6300n -0.002013 313.6400n -0.001943
+ 313.6500n -0.001851 313.6600n -0.001735 313.6700n -0.001598 313.6800n -0.001440 313.6900n -0.001263 313.7000n -0.001068 313.7100n -0.000857 313.7200n -0.000633 313.7300n -0.000398 313.7400n -0.000156 313.7500n 0.000091 313.7600n 0.000339 313.7700n 0.000586 313.7800n 0.000827 313.7900n 0.001061
+ 313.8000n 0.001282 313.8100n 0.001490 313.8200n 0.001681 313.8300n 0.001853 313.8400n 0.002003 313.8500n 0.002131 313.8600n 0.002234 313.8700n 0.002312 313.8800n 0.002364 313.8900n 0.002390 313.9000n 0.002391 313.9100n 0.002367 313.9200n 0.002319 313.9300n 0.002249 313.9400n 0.002158
+ 313.9500n 0.002049 313.9600n 0.001924 313.9700n 0.001785 313.9800n 0.001636 313.9900n 0.001478 314.0000n 0.001315 314.0100n 0.001149 314.0200n 0.000983 314.0300n 0.000819 314.0400n 0.000661 314.0500n 0.000509 314.0600n 0.000366 314.0700n 0.000233 314.0800n 0.000112 314.0900n 0.000004
+ 314.1000n -0.000090 314.1100n -0.000171 314.1200n -0.000237 314.1300n -0.000289 314.1400n -0.000328 314.1500n -0.000353 314.1600n -0.000367 314.1700n -0.000368 314.1800n -0.000360 314.1900n -0.000342 314.2000n -0.000317 314.2100n -0.000285 314.2200n -0.000247 314.2300n -0.000205 314.2400n -0.000159
+ 314.2500n -0.000110 314.2600n -0.000060 314.2700n -0.000009 314.2800n 0.000044 314.2900n 0.000096 314.3000n 0.000149 314.3100n 0.000203 314.3200n 0.000257 314.3300n 0.000311 314.3400n 0.000367 314.3500n 0.000424 314.3600n 0.000483 314.3700n 0.000543 314.3800n 0.000607 314.3900n 0.000672
+ 314.4000n 0.000741 314.4100n 0.000812 314.4200n 0.000886 314.4300n 0.000962 314.4400n 0.001039 314.4500n 0.001117 314.4600n 0.001196 314.4700n 0.001272 314.4800n 0.001347 314.4900n 0.001417 314.5000n 0.001482 314.5100n 0.001539 314.5200n 0.001587 314.5300n 0.001624 314.5400n 0.001649
+ 314.5500n 0.001659 314.5600n 0.001653 314.5700n 0.001630 314.5800n 0.001589 314.5900n 0.001528 314.6000n 0.001447 314.6100n 0.001347 314.6200n 0.001226 314.6300n 0.001086 314.6400n 0.000928 314.6500n 0.000752 314.6600n 0.000561 314.6700n 0.000356 314.6800n 0.000141 314.6900n -0.000082
+ 314.7000n -0.000311 314.7100n -0.000541 314.7200n -0.000770 314.7300n -0.000993 314.7400n -0.001208 314.7500n -0.001410 314.7600n -0.001596 314.7700n -0.001764 314.7800n -0.001909 314.7900n -0.002029 314.8000n -0.002122 314.8100n -0.002185 314.8200n -0.002219 314.8300n -0.002221 314.8400n -0.002191
+ 314.8500n -0.002130 314.8600n -0.002039 314.8700n -0.001918 314.8800n -0.001770 314.8900n -0.001597 314.9000n -0.001402 314.9100n -0.001189 314.9200n -0.000962 314.9300n -0.000723 314.9400n -0.000479 314.9500n -0.000232 314.9600n 0.000012 314.9700n 0.000250 314.9800n 0.000476 314.9900n 0.000687
+ 315.0000n 0.000879 315.0100n 0.001049 315.0200n 0.001194 315.0300n 0.001310 315.0400n 0.001398 315.0500n 0.001454 315.0600n 0.001479 315.0700n 0.001472 315.0800n 0.001435 315.0900n 0.001367 315.1000n 0.001271 315.1100n 0.001149 315.1200n 0.001004 315.1300n 0.000840 315.1400n 0.000658
+ 315.1500n 0.000465 315.1600n 0.000263 315.1700n 0.000056 315.1800n -0.000151 315.1900n -0.000354 315.2000n -0.000550 315.2100n -0.000734 315.2200n -0.000904 315.2300n -0.001057 315.2400n -0.001190 315.2500n -0.001301 315.2600n -0.001389 315.2700n -0.001454 315.2800n -0.001494 315.2900n -0.001511
+ 315.3000n -0.001505 315.3100n -0.001478 315.3200n -0.001432 315.3300n -0.001368 315.3400n -0.001290 315.3500n -0.001201 315.3600n -0.001105 315.3700n -0.001003 315.3800n -0.000901 315.3900n -0.000801 315.4000n -0.000706 315.4100n -0.000620 315.4200n -0.000546 315.4300n -0.000486 315.4400n -0.000441
+ 315.4500n -0.000414 315.4600n -0.000406 315.4700n -0.000416 315.4800n -0.000446 315.4900n -0.000494 315.5000n -0.000559 315.5100n -0.000639 315.5200n -0.000733 315.5300n -0.000838 315.5400n -0.000950 315.5500n -0.001068 315.5600n -0.001186 315.5700n -0.001302 315.5800n -0.001413 315.5900n -0.001513
+ 315.6000n -0.001601 315.6100n -0.001673 315.6200n -0.001725 315.6300n -0.001756 315.6400n -0.001763 315.6500n -0.001745 315.6600n -0.001700 315.6700n -0.001628 315.6800n -0.001530 315.6900n -0.001405 315.7000n -0.001255 315.7100n -0.001083 315.7200n -0.000890 315.7300n -0.000679 315.7400n -0.000453
+ 315.7500n -0.000217 315.7600n 0.000026 315.7700n 0.000271 315.7800n 0.000515 315.7900n 0.000754 315.8000n 0.000982 315.8100n 0.001196 315.8200n 0.001392 315.8300n 0.001568 315.8400n 0.001718 315.8500n 0.001842 315.8600n 0.001937 315.8700n 0.002002 315.8800n 0.002035 315.8900n 0.002037
+ 315.9000n 0.002007 315.9100n 0.001948 315.9200n 0.001860 315.9300n 0.001746 315.9400n 0.001608 315.9500n 0.001449 315.9600n 0.001273 315.9700n 0.001084 315.9800n 0.000884 315.9900n 0.000680 316.0000n 0.000474 316.0100n 0.000271 316.0200n 0.000074 316.0300n -0.000111 316.0400n -0.000284
+ 316.0500n -0.000439 316.0600n -0.000574 316.0700n -0.000688 316.0800n -0.000779 316.0900n -0.000845 316.1000n -0.000885 316.1100n -0.000901 316.1200n -0.000892 316.1300n -0.000859 316.1400n -0.000804 316.1500n -0.000730 316.1600n -0.000637 316.1700n -0.000529 316.1800n -0.000409 316.1900n -0.000280
+ 316.2000n -0.000145 316.2100n -0.000007 316.2200n 0.000131 316.2300n 0.000265 316.2400n 0.000392 316.2500n 0.000511 316.2600n 0.000619 316.2700n 0.000714 316.2800n 0.000794 316.2900n 0.000858 316.3000n 0.000906 316.3100n 0.000937 316.3200n 0.000952 316.3300n 0.000951 316.3400n 0.000936
+ 316.3500n 0.000907 316.3600n 0.000866 316.3700n 0.000815 316.3800n 0.000757 316.3900n 0.000694 316.4000n 0.000627 316.4100n 0.000560 316.4200n 0.000494 316.4300n 0.000432 316.4400n 0.000376 316.4500n 0.000327 316.4600n 0.000288 316.4700n 0.000259 316.4800n 0.000241 316.4900n 0.000235
+ 316.5000n 0.000241 316.5100n 0.000259 316.5200n 0.000289 316.5300n 0.000328 316.5400n 0.000377 316.5500n 0.000434 316.5600n 0.000498 316.5700n 0.000565 316.5800n 0.000635 316.5900n 0.000706 316.6000n 0.000775 316.6100n 0.000841 316.6200n 0.000901 316.6300n 0.000953 316.6400n 0.000997
+ 316.6500n 0.001031 316.6600n 0.001053 316.6700n 0.001063 316.6800n 0.001060 316.6900n 0.001045 316.7000n 0.001017 316.7100n 0.000976 316.7200n 0.000923 316.7300n 0.000860 316.7400n 0.000788 316.7500n 0.000707 316.7600n 0.000620 316.7700n 0.000527 316.7800n 0.000432 316.7900n 0.000335
+ 316.8000n 0.000238 316.8100n 0.000143 316.8200n 0.000051 316.8300n -0.000036 316.8400n -0.000118 316.8500n -0.000193 316.8600n -0.000262 316.8700n -0.000323 316.8800n -0.000378 316.8900n -0.000425 316.9000n -0.000466 316.9100n -0.000502 316.9200n -0.000533 316.9300n -0.000560 316.9400n -0.000586
+ 316.9500n -0.000612 316.9600n -0.000639 316.9700n -0.000668 316.9800n -0.000701 316.9900n -0.000740 317.0000n -0.000785 317.0100n -0.000838 317.0200n -0.000899 317.0300n -0.000969 317.0400n -0.001048 317.0500n -0.001136 317.0600n -0.001233 317.0700n -0.001336 317.0800n -0.001447 317.0900n -0.001562
+ 317.1000n -0.001680 317.1100n -0.001799 317.1200n -0.001918 317.1300n -0.002032 317.1400n -0.002141 317.1500n -0.002242 317.1600n -0.002332 317.1700n -0.002408 317.1800n -0.002470 317.1900n -0.002514 317.2000n -0.002539 317.2100n -0.002544 317.2200n -0.002528 317.2300n -0.002490 317.2400n -0.002430
+ 317.2500n -0.002349 317.2600n -0.002248 317.2700n -0.002128 317.2800n -0.001992 317.2900n -0.001840 317.3000n -0.001677 317.3100n -0.001505 317.3200n -0.001327 317.3300n -0.001148 317.3400n -0.000971 317.3500n -0.000799 317.3600n -0.000637 317.3700n -0.000489 317.3800n -0.000357 317.3900n -0.000245
+ 317.4000n -0.000156 317.4100n -0.000092 317.4200n -0.000056 317.4300n -0.000048 317.4400n -0.000069 317.4500n -0.000120 317.4600n -0.000200 317.4700n -0.000308 317.4800n -0.000441 317.4900n -0.000598 317.5000n -0.000776 317.5100n -0.000971 317.5200n -0.001180 317.5300n -0.001396 317.5400n -0.001617
+ 317.5500n -0.001838 317.5600n -0.002052 317.5700n -0.002257 317.5800n -0.002445 317.5900n -0.002614 317.6000n -0.002758 317.6100n -0.002874 317.6200n -0.002959 317.6300n -0.003009 317.6400n -0.003023 317.6500n -0.002999 317.6600n -0.002937 317.6700n -0.002836 317.6800n -0.002698 317.6900n -0.002524
+ 317.7000n -0.002317 317.7100n -0.002080 317.7200n -0.001816 317.7300n -0.001530 317.7400n -0.001227 317.7500n -0.000912 317.7600n -0.000591 317.7700n -0.000268 317.7800n 0.000049 317.7900n 0.000355 317.8000n 0.000645 317.8100n 0.000913 317.8200n 0.001155 317.8300n 0.001366 317.8400n 0.001542
+ 317.8500n 0.001680 317.8600n 0.001777 317.8700n 0.001833 317.8800n 0.001846 317.8900n 0.001816 317.9000n 0.001744 317.9100n 0.001632 317.9200n 0.001482 317.9300n 0.001297 317.9400n 0.001081 317.9500n 0.000839 317.9600n 0.000575 317.9700n 0.000294 317.9800n 0.000003 317.9900n -0.000293
+ 318.0000n -0.000589 318.0100n -0.000878 318.0200n -0.001155 318.0300n -0.001415 318.0400n -0.001654 318.0500n -0.001866 318.0600n -0.002048 318.0700n -0.002198 318.0800n -0.002312 318.0900n -0.002388 318.1000n -0.002427 318.1100n -0.002428 318.1200n -0.002392 318.1300n -0.002320 318.1400n -0.002214
+ 318.1500n -0.002076 318.1600n -0.001911 318.1700n -0.001723 318.1800n -0.001514 318.1900n -0.001290 318.2000n -0.001056 318.2100n -0.000816 318.2200n -0.000575 318.2300n -0.000338 318.2400n -0.000110 318.2500n 0.000107 318.2600n 0.000307 318.2700n 0.000487 318.2800n 0.000645 318.2900n 0.000779
+ 318.3000n 0.000888 318.3100n 0.000969 318.3200n 0.001024 318.3300n 0.001052 318.3400n 0.001055 318.3500n 0.001035 318.3600n 0.000993 318.3700n 0.000932 318.3800n 0.000857 318.3900n 0.000769 318.4000n 0.000673 318.4100n 0.000572 318.4200n 0.000472 318.4300n 0.000375 318.4400n 0.000285
+ 318.4500n 0.000206 318.4600n 0.000142 318.4700n 0.000094 318.4800n 0.000067 318.4900n 0.000061 318.5000n 0.000077 318.5100n 0.000118 318.5200n 0.000183 318.5300n 0.000273 318.5400n 0.000385 318.5500n 0.000518 318.5600n 0.000672 318.5700n 0.000842 318.5800n 0.001027 318.5900n 0.001223
+ 318.6000n 0.001427 318.6100n 0.001634 318.6200n 0.001842 318.6300n 0.002045 318.6400n 0.002241 318.6500n 0.002426 318.6600n 0.002595 318.6700n 0.002746 318.6800n 0.002876 318.6900n 0.002983 318.7000n 0.003064 318.7100n 0.003117 318.7200n 0.003143 318.7300n 0.003139 318.7400n 0.003107
+ 318.7500n 0.003047 318.7600n 0.002960 318.7700n 0.002847 318.7800n 0.002711 318.7900n 0.002554 318.8000n 0.002379 318.8100n 0.002188 318.8200n 0.001986 318.8300n 0.001776 318.8400n 0.001560 318.8500n 0.001344 318.8600n 0.001129 318.8700n 0.000920 318.8800n 0.000720 318.8900n 0.000532
+ 318.9000n 0.000358 318.9100n 0.000201 318.9200n 0.000063 318.9300n -0.000056 318.9400n -0.000153 318.9500n -0.000228 318.9600n -0.000280 318.9700n -0.000311 318.9800n -0.000320 318.9900n -0.000308 319.0000n -0.000277 319.0100n -0.000228 319.0200n -0.000162 319.0300n -0.000083 319.0400n 0.000007
+ 319.0500n 0.000108 319.0600n 0.000215 319.0700n 0.000326 319.0800n 0.000440 319.0900n 0.000553 319.1000n 0.000664 319.1100n 0.000770 319.1200n 0.000870 319.1300n 0.000961 319.1400n 0.001042 319.1500n 0.001113 319.1600n 0.001171 319.1700n 0.001216 319.1800n 0.001248 319.1900n 0.001267
+ 319.2000n 0.001271 319.2100n 0.001262 319.2200n 0.001239 319.2300n 0.001204 319.2400n 0.001156 319.2500n 0.001097 319.2600n 0.001028 319.2700n 0.000949 319.2800n 0.000861 319.2900n 0.000766 319.3000n 0.000664 319.3100n 0.000557 319.3200n 0.000445 319.3300n 0.000329 319.3400n 0.000210
+ 319.3500n 0.000090 319.3600n -0.000032 319.3700n -0.000154 319.3800n -0.000276 319.3900n -0.000398 319.4000n -0.000518 319.4100n -0.000636 319.4200n -0.000751 319.4300n -0.000864 319.4400n -0.000973 319.4500n -0.001079 319.4600n -0.001181 319.4700n -0.001277 319.4800n -0.001369 319.4900n -0.001455
+ 319.5000n -0.001535 319.5100n -0.001609 319.5200n -0.001675 319.5300n -0.001734 319.5400n -0.001786 319.5500n -0.001828 319.5600n -0.001862 319.5700n -0.001888 319.5800n -0.001903 319.5900n -0.001910 319.6000n -0.001906 319.6100n -0.001894 319.6200n -0.001871 319.6300n -0.001840 319.6400n -0.001799
+ 319.6500n -0.001750 319.6600n -0.001694 319.6700n -0.001630 319.6800n -0.001560 319.6900n -0.001484 319.7000n -0.001405 319.7100n -0.001322 319.7200n -0.001237 319.7300n -0.001151 319.7400n -0.001066 319.7500n -0.000983 319.7600n -0.000902 319.7700n -0.000826 319.7800n -0.000754 319.7900n -0.000690
+ 319.8000n -0.000632 319.8100n -0.000582 319.8200n -0.000540 319.8300n -0.000508 319.8400n -0.000484 319.8500n -0.000470 319.8600n -0.000465 319.8700n -0.000469 319.8800n -0.000481 319.8900n -0.000500 319.9000n -0.000527 319.9100n -0.000560 319.9200n -0.000597 319.9300n -0.000639 319.9400n -0.000682
+ 319.9500n -0.000727 319.9600n -0.000772 319.9700n -0.000815 319.9800n -0.000856 319.9900n -0.000893 320.0000n -0.000925 320.0100n -0.000951 320.0200n -0.000970 320.0300n -0.000981 320.0400n -0.000985 320.0500n -0.000980 320.0600n -0.000967 320.0700n -0.000945 320.0800n -0.000915 320.0900n -0.000876
+ 320.1000n -0.000831 320.1100n -0.000778 320.1200n -0.000720 320.1300n -0.000657 320.1400n -0.000591 320.1500n -0.000521 320.1600n -0.000451 320.1700n -0.000380 320.1800n -0.000310 320.1900n -0.000243 320.2000n -0.000179 320.2100n -0.000119 320.2200n -0.000066 320.2300n -0.000018 320.2400n 0.000021
+ 320.2500n 0.000053 320.2600n 0.000077 320.2700n 0.000091 320.2800n 0.000096 320.2900n 0.000092 320.3000n 0.000079 320.3100n 0.000056 320.3200n 0.000024 320.3300n -0.000016 320.3400n -0.000064 320.3500n -0.000120 320.3600n -0.000183 320.3700n -0.000253 320.3800n -0.000329 320.3900n -0.000410
+ 320.4000n -0.000496 320.4100n -0.000586 320.4200n -0.000680 320.4300n -0.000777 320.4400n -0.000876 320.4500n -0.000977 320.4600n -0.001081 320.4700n -0.001185 320.4800n -0.001291 320.4900n -0.001397 320.5000n -0.001503 320.5100n -0.001609 320.5200n -0.001715 320.5300n -0.001820 320.5400n -0.001924
+ 320.5500n -0.002026 320.5600n -0.002126 320.5700n -0.002224 320.5800n -0.002318 320.5900n -0.002409 320.6000n -0.002494 320.6100n -0.002575 320.6200n -0.002649 320.6300n -0.002716 320.6400n -0.002775 320.6500n -0.002826 320.6600n -0.002866 320.6700n -0.002897 320.6800n -0.002916 320.6900n -0.002923
+ 320.7000n -0.002918 320.7100n -0.002900 320.7200n -0.002870 320.7300n -0.002826 320.7400n -0.002769 320.7500n -0.002700 320.7600n -0.002619 320.7700n -0.002528 320.7800n -0.002426 320.7900n -0.002316 320.8000n -0.002198 320.8100n -0.002076 320.8200n -0.001950 320.8300n -0.001823 320.8400n -0.001697
+ 320.8500n -0.001574 320.8600n -0.001457 320.8700n -0.001348 320.8800n -0.001250 320.8900n -0.001165 320.9000n -0.001094 320.9100n -0.001040 320.9200n -0.001005 320.9300n -0.000989 320.9400n -0.000994 320.9500n -0.001021 320.9600n -0.001070 320.9700n -0.001141 320.9800n -0.001233 320.9900n -0.001346
+ 321.0000n -0.001477 321.0100n -0.001626 321.0200n -0.001790 321.0300n -0.001967 321.0400n -0.002152 321.0500n -0.002345 321.0600n -0.002540 321.0700n -0.002734 321.0800n -0.002925 321.0900n -0.003107 321.1000n -0.003277 321.1100n -0.003432 321.1200n -0.003568 321.1300n -0.003682 321.1400n -0.003771
+ 321.1500n -0.003833 321.1600n -0.003865 321.1700n -0.003867 321.1800n -0.003836 321.1900n -0.003773 321.2000n -0.003678 321.2100n -0.003551 321.2200n -0.003394 321.2300n -0.003208 321.2400n -0.002996 321.2500n -0.002760 321.2600n -0.002505 321.2700n -0.002234 321.2800n -0.001950 321.2900n -0.001658
+ 321.3000n -0.001363 321.3100n -0.001069 321.3200n -0.000781 321.3300n -0.000503 321.3400n -0.000240 321.3500n 0.000005 321.3600n 0.000228 321.3700n 0.000425 321.3800n 0.000594 321.3900n 0.000733 321.4000n 0.000839 321.4100n 0.000913 321.4200n 0.000952 321.4300n 0.000958 321.4400n 0.000932
+ 321.4500n 0.000875 321.4600n 0.000789 321.4700n 0.000676 321.4800n 0.000541 321.4900n 0.000387 321.5000n 0.000217 321.5100n 0.000037 321.5200n -0.000150 321.5300n -0.000339 321.5400n -0.000525 321.5500n -0.000704 321.5600n -0.000871 321.5700n -0.001023 321.5800n -0.001155 321.5900n -0.001264
+ 321.6000n -0.001347 321.6100n -0.001402 321.6200n -0.001427 321.6300n -0.001422 321.6400n -0.001384 321.6500n -0.001316 321.6600n -0.001217 321.6700n -0.001089 321.6800n -0.000933 321.6900n -0.000754 321.7000n -0.000553 321.7100n -0.000333 321.7200n -0.000100 321.7300n 0.000144 321.7400n 0.000393
+ 321.7500n 0.000643 321.7600n 0.000891 321.7700n 0.001131 321.7800n 0.001360 321.7900n 0.001573 321.8000n 0.001768 321.8100n 0.001940 321.8200n 0.002087 321.8300n 0.002207 321.8400n 0.002298 321.8500n 0.002359 321.8600n 0.002390 321.8700n 0.002390 321.8800n 0.002360 321.8900n 0.002301
+ 321.9000n 0.002216 321.9100n 0.002105 321.9200n 0.001973 321.9300n 0.001821 321.9400n 0.001654 321.9500n 0.001474 321.9600n 0.001285 321.9700n 0.001092 321.9800n 0.000897 321.9900n 0.000705 322.0000n 0.000519 322.0100n 0.000343 322.0200n 0.000178 322.0300n 0.000029 322.0400n -0.000102
+ 322.0500n -0.000214 322.0600n -0.000305 322.0700n -0.000375 322.0800n -0.000422 322.0900n -0.000446 322.1000n -0.000448 322.1100n -0.000429 322.1200n -0.000389 322.1300n -0.000331 322.1400n -0.000256 322.1500n -0.000167 322.1600n -0.000065 322.1700n 0.000047 322.1800n 0.000166 322.1900n 0.000290
+ 322.2000n 0.000416 322.2100n 0.000541 322.2200n 0.000664 322.2300n 0.000782 322.2400n 0.000894 322.2500n 0.000996 322.2600n 0.001089 322.2700n 0.001172 322.2800n 0.001242 322.2900n 0.001300 322.3000n 0.001346 322.3100n 0.001380 322.3200n 0.001402 322.3300n 0.001413 322.3400n 0.001414
+ 322.3500n 0.001406 322.3600n 0.001390 322.3700n 0.001368 322.3800n 0.001341 322.3900n 0.001311 322.4000n 0.001278 322.4100n 0.001244 322.4200n 0.001211 322.4300n 0.001179 322.4400n 0.001150 322.4500n 0.001125 322.4600n 0.001103 322.4700n 0.001085 322.4800n 0.001072 322.4900n 0.001064
+ 322.5000n 0.001059 322.5100n 0.001059 322.5200n 0.001061 322.5300n 0.001066 322.5400n 0.001072 322.5500n 0.001078 322.5600n 0.001084 322.5700n 0.001088 322.5800n 0.001090 322.5900n 0.001088 322.6000n 0.001081 322.6100n 0.001069 322.6200n 0.001050 322.6300n 0.001025 322.6400n 0.000992
+ 322.6500n 0.000952 322.6600n 0.000905 322.6700n 0.000851 322.6800n 0.000790 322.6900n 0.000722 322.7000n 0.000650 322.7100n 0.000572 322.7200n 0.000492 322.7300n 0.000409 322.7400n 0.000324 322.7500n 0.000240 322.7600n 0.000158 322.7700n 0.000078 322.7800n 0.000002 322.7900n -0.000069
+ 322.8000n -0.000134 322.8100n -0.000191 322.8200n -0.000241 322.8300n -0.000283 322.8400n -0.000315 322.8500n -0.000339 322.8600n -0.000353 322.8700n -0.000359 322.8800n -0.000357 322.8900n -0.000346 322.9000n -0.000329 322.9100n -0.000305 322.9200n -0.000276 322.9300n -0.000243 322.9400n -0.000208
+ 322.9500n -0.000170 322.9600n -0.000132 322.9700n -0.000095 322.9800n -0.000060 322.9900n -0.000028 323.0000n 0.000000 323.0100n 0.000024 323.0200n 0.000042 323.0300n 0.000054 323.0400n 0.000060 323.0500n 0.000060 323.0600n 0.000054 323.0700n 0.000041 323.0800n 0.000023 323.0900n 0.000001
+ 323.1000n -0.000026 323.1100n -0.000056 323.1200n -0.000088 323.1300n -0.000121 323.1400n -0.000153 323.1500n -0.000184 323.1600n -0.000212 323.1700n -0.000236 323.1800n -0.000255 323.1900n -0.000268 323.2000n -0.000274 323.2100n -0.000272 323.2200n -0.000262 323.2300n -0.000242 323.2400n -0.000213
+ 323.2500n -0.000175 323.2600n -0.000128 323.2700n -0.000071 323.2800n -0.000006 323.2900n 0.000066 323.3000n 0.000146 323.3100n 0.000232 323.3200n 0.000322 323.3300n 0.000416 323.3400n 0.000513 323.3500n 0.000610 323.3600n 0.000708 323.3700n 0.000803 323.3800n 0.000896 323.3900n 0.000984
+ 323.4000n 0.001067 323.4100n 0.001143 323.4200n 0.001211 323.4300n 0.001271 323.4400n 0.001321 323.4500n 0.001362 323.4600n 0.001393 323.4700n 0.001413 323.4800n 0.001423 323.4900n 0.001422 323.5000n 0.001411 323.5100n 0.001390 323.5200n 0.001360 323.5300n 0.001321 323.5400n 0.001274
+ 323.5500n 0.001219 323.5600n 0.001158 323.5700n 0.001091 323.5800n 0.001019 323.5900n 0.000942 323.6000n 0.000863 323.6100n 0.000781 323.6200n 0.000697 323.6300n 0.000612 323.6400n 0.000526 323.6500n 0.000441 323.6600n 0.000356 323.6700n 0.000272 323.6800n 0.000190 323.6900n 0.000109
+ 323.7000n 0.000030 323.7100n -0.000046 323.7200n -0.000120 323.7300n -0.000192 323.7400n -0.000261 323.7500n -0.000327 323.7600n -0.000390 323.7700n -0.000450 323.7800n -0.000507 323.7900n -0.000560 323.8000n -0.000610 323.8100n -0.000657 323.8200n -0.000699 323.8300n -0.000737 323.8400n -0.000771
+ 323.8500n -0.000800 323.8600n -0.000825 323.8700n -0.000844 323.8800n -0.000858 323.8900n -0.000866 323.9000n -0.000869 323.9100n -0.000866 323.9200n -0.000857 323.9300n -0.000843 323.9400n -0.000823 323.9500n -0.000798 323.9600n -0.000768 323.9700n -0.000734 323.9800n -0.000695 323.9900n -0.000654
+ 324.0000n -0.000610 324.0100n -0.000564 324.0200n -0.000517 324.0300n -0.000471 324.0400n -0.000425 324.0500n -0.000381 324.0600n -0.000341 324.0700n -0.000304 324.0800n -0.000272 324.0900n -0.000246 324.1000n -0.000226 324.1100n -0.000214 324.1200n -0.000209 324.1300n -0.000212 324.1400n -0.000224
+ 324.1500n -0.000245 324.1600n -0.000273 324.1700n -0.000310 324.1800n -0.000355 324.1900n -0.000407 324.2000n -0.000466 324.2100n -0.000530 324.2200n -0.000599 324.2300n -0.000671 324.2400n -0.000746 324.2500n -0.000822 324.2600n -0.000897 324.2700n -0.000971 324.2800n -0.001042 324.2900n -0.001108
+ 324.3000n -0.001170 324.3100n -0.001225 324.3200n -0.001272 324.3300n -0.001312 324.3400n -0.001343 324.3500n -0.001365 324.3600n -0.001378 324.3700n -0.001381 324.3800n -0.001375 324.3900n -0.001361 324.4000n -0.001339 324.4100n -0.001309 324.4200n -0.001273 324.4300n -0.001232 324.4400n -0.001188
+ 324.4500n -0.001140 324.4600n -0.001092 324.4700n -0.001044 324.4800n -0.000998 324.4900n -0.000954 324.5000n -0.000915 324.5100n -0.000882 324.5200n -0.000856 324.5300n -0.000837 324.5400n -0.000826 324.5500n -0.000824 324.5600n -0.000831 324.5700n -0.000847 324.5800n -0.000872 324.5900n -0.000905
+ 324.6000n -0.000945 324.6100n -0.000993 324.6200n -0.001045 324.6300n -0.001102 324.6400n -0.001161 324.6500n -0.001221 324.6600n -0.001280 324.6700n -0.001336 324.6800n -0.001388 324.6900n -0.001433 324.7000n -0.001470 324.7100n -0.001497 324.7200n -0.001512 324.7300n -0.001515 324.7400n -0.001503
+ 324.7500n -0.001476 324.7600n -0.001433 324.7700n -0.001374 324.7800n -0.001299 324.7900n -0.001207 324.8000n -0.001099 324.8100n -0.000976 324.8200n -0.000838 324.8300n -0.000688 324.8400n -0.000526 324.8500n -0.000354 324.8600n -0.000174 324.8700n 0.000012 324.8800n 0.000201 324.8900n 0.000393
+ 324.9000n 0.000583 324.9100n 0.000771 324.9200n 0.000953 324.9300n 0.001128 324.9400n 0.001294 324.9500n 0.001448 324.9600n 0.001589 324.9700n 0.001716 324.9800n 0.001826 324.9900n 0.001920 325.0000n 0.001996 325.0100n 0.002054 325.0200n 0.002093 325.0300n 0.002114 325.0400n 0.002116
+ 325.0500n 0.002100 325.0600n 0.002066 325.0700n 0.002016 325.0800n 0.001950 325.0900n 0.001870 325.1000n 0.001776 325.1100n 0.001671 325.1200n 0.001554 325.1300n 0.001429 325.1400n 0.001296 325.1500n 0.001157 325.1600n 0.001013 325.1700n 0.000866 325.1800n 0.000716 325.1900n 0.000565
+ 325.2000n 0.000414 325.2100n 0.000264 325.2200n 0.000116 325.2300n -0.000029 325.2400n -0.000171 325.2500n -0.000309 325.2600n -0.000442 325.2700n -0.000570 325.2800n -0.000693 325.2900n -0.000810 325.3000n -0.000920 325.3100n -0.001025 325.3200n -0.001122 325.3300n -0.001212 325.3400n -0.001295
+ 325.3500n -0.001371 325.3600n -0.001438 325.3700n -0.001496 325.3800n -0.001546 325.3900n -0.001586 325.4000n -0.001616 325.4100n -0.001637 325.4200n -0.001646 325.4300n -0.001645 325.4400n -0.001632 325.4500n -0.001608 325.4600n -0.001572 325.4700n -0.001524 325.4800n -0.001465 325.4900n -0.001393
+ 325.5000n -0.001310 325.5100n -0.001216 325.5200n -0.001111 325.5300n -0.000996 325.5400n -0.000872 325.5500n -0.000740 325.5600n -0.000601 325.5700n -0.000456 325.5800n -0.000307 325.5900n -0.000156 325.6000n -0.000003 325.6100n 0.000150 325.6200n 0.000300 325.6300n 0.000447 325.6400n 0.000589
+ 325.6500n 0.000723 325.6600n 0.000850 325.6700n 0.000966 325.6800n 0.001072 325.6900n 0.001165 325.7000n 0.001246 325.7100n 0.001313 325.7200n 0.001367 325.7300n 0.001406 325.7400n 0.001431 325.7500n 0.001443 325.7600n 0.001441 325.7700n 0.001426 325.7800n 0.001400 325.7900n 0.001363
+ 325.8000n 0.001317 325.8100n 0.001263 325.8200n 0.001203 325.8300n 0.001137 325.8400n 0.001068 325.8500n 0.000998 325.8600n 0.000926 325.8700n 0.000856 325.8800n 0.000789 325.8900n 0.000725 325.9000n 0.000665 325.9100n 0.000611 325.9200n 0.000562 325.9300n 0.000520 325.9400n 0.000485
+ 325.9500n 0.000456 325.9600n 0.000433 325.9700n 0.000416 325.9800n 0.000404 325.9900n 0.000396 326.0000n 0.000392 326.0100n 0.000389 326.0200n 0.000388 326.0300n 0.000387 326.0400n 0.000385 326.0500n 0.000381 326.0600n 0.000373 326.0700n 0.000362 326.0800n 0.000345 326.0900n 0.000323
+ 326.1000n 0.000295 326.1100n 0.000262 326.1200n 0.000223 326.1300n 0.000178 326.1400n 0.000130 326.1500n 0.000077 326.1600n 0.000022 326.1700n -0.000035 326.1800n -0.000091 326.1900n -0.000144 326.2000n -0.000194 326.2100n -0.000238 326.2200n -0.000274 326.2300n -0.000300 326.2400n -0.000315
+ 326.2500n -0.000316 326.2600n -0.000302 326.2700n -0.000272 326.2800n -0.000223 326.2900n -0.000157 326.3000n -0.000071 326.3100n 0.000034 326.3200n 0.000157 326.3300n 0.000299 326.3400n 0.000459 326.3500n 0.000634 326.3600n 0.000823 326.3700n 0.001024 326.3800n 0.001235 326.3900n 0.001452
+ 326.4000n 0.001673 326.4100n 0.001894 326.4200n 0.002112 326.4300n 0.002324 326.4400n 0.002525 326.4500n 0.002713 326.4600n 0.002885 326.4700n 0.003036 326.4800n 0.003165 326.4900n 0.003268 326.5000n 0.003343 326.5100n 0.003388 326.5200n 0.003402 326.5300n 0.003384 326.5400n 0.003334
+ 326.5500n 0.003251 326.5600n 0.003135 326.5700n 0.002989 326.5800n 0.002813 326.5900n 0.002609 326.6000n 0.002380 326.6100n 0.002129 326.6200n 0.001858 326.6300n 0.001571 326.6400n 0.001272 326.6500n 0.000965 326.6600n 0.000653 326.6700n 0.000340 326.6800n 0.000031 326.6900n -0.000272
+ 326.7000n -0.000564 326.7100n -0.000842 326.7200n -0.001103 326.7300n -0.001345 326.7400n -0.001564 326.7500n -0.001759 326.7600n -0.001929 326.7700n -0.002072 326.7800n -0.002187 326.7900n -0.002274 326.8000n -0.002334 326.8100n -0.002367 326.8200n -0.002373 326.8300n -0.002355 326.8400n -0.002314
+ 326.8500n -0.002251 326.8600n -0.002170 326.8700n -0.002071 326.8800n -0.001957 326.8900n -0.001832 326.9000n -0.001696 326.9100n -0.001553 326.9200n -0.001405 326.9300n -0.001254 326.9400n -0.001102 326.9500n -0.000950 326.9600n -0.000802 326.9700n -0.000657 326.9800n -0.000517 326.9900n -0.000384
+ 327.0000n -0.000257 327.0100n -0.000138 327.0200n -0.000026 327.0300n 0.000078 327.0400n 0.000175 327.0500n 0.000264 327.0600n 0.000347 327.0700n 0.000423 327.0800n 0.000492 327.0900n 0.000556 327.1000n 0.000616 327.1100n 0.000670 327.1200n 0.000721 327.1300n 0.000768 327.1400n 0.000811
+ 327.1500n 0.000852 327.1600n 0.000889 327.1700n 0.000924 327.1800n 0.000955 327.1900n 0.000984 327.2000n 0.001009 327.2100n 0.001030 327.2200n 0.001048 327.2300n 0.001062 327.2400n 0.001071 327.2500n 0.001075 327.2600n 0.001075 327.2700n 0.001070 327.2800n 0.001060 327.2900n 0.001045
+ 327.3000n 0.001025 327.3100n 0.001001 327.3200n 0.000972 327.3300n 0.000941 327.3400n 0.000907 327.3500n 0.000871 327.3600n 0.000835 327.3700n 0.000798 327.3800n 0.000763 327.3900n 0.000730 327.4000n 0.000700 327.4100n 0.000675 327.4200n 0.000655 327.4300n 0.000641 327.4400n 0.000634
+ 327.4500n 0.000635 327.4600n 0.000643 327.4700n 0.000659 327.4800n 0.000683 327.4900n 0.000714 327.5000n 0.000753 327.5100n 0.000797 327.5200n 0.000845 327.5300n 0.000897 327.5400n 0.000951 327.5500n 0.001005 327.5600n 0.001056 327.5700n 0.001104 327.5800n 0.001145 327.5900n 0.001178
+ 327.6000n 0.001201 327.6100n 0.001211 327.6200n 0.001206 327.6300n 0.001186 327.6400n 0.001148 327.6500n 0.001091 327.6600n 0.001016 327.6700n 0.000920 327.6800n 0.000804 327.6900n 0.000669 327.7000n 0.000515 327.7100n 0.000344 327.7200n 0.000157 327.7300n -0.000043 327.7400n -0.000255
+ 327.7500n -0.000474 327.7600n -0.000699 327.7700n -0.000926 327.7800n -0.001151 327.7900n -0.001371 327.8000n -0.001582 327.8100n -0.001781 327.8200n -0.001964 327.8300n -0.002127 327.8400n -0.002269 327.8500n -0.002386 327.8600n -0.002476 327.8700n -0.002538 327.8800n -0.002570 327.8900n -0.002572
+ 327.9000n -0.002544 327.9100n -0.002486 327.9200n -0.002399 327.9300n -0.002287 327.9400n -0.002149 327.9500n -0.001991 327.9600n -0.001815 327.9700n -0.001624 327.9800n -0.001423 327.9900n -0.001217 328.0000n -0.001010 328.0100n -0.000805 328.0200n -0.000609 328.0300n -0.000426 328.0400n -0.000259
+ 328.0500n -0.000113 328.0600n 0.000009 328.0700n 0.000105 328.0800n 0.000170 328.0900n 0.000205 328.1000n 0.000206 328.1100n 0.000175 328.1200n 0.000112 328.1300n 0.000017 328.1400n -0.000108 328.1500n -0.000260 328.1600n -0.000436 328.1700n -0.000633 328.1800n -0.000846 328.1900n -0.001071
+ 328.2000n -0.001303 328.2100n -0.001537 328.2200n -0.001767 328.2300n -0.001988 328.2400n -0.002194 328.2500n -0.002383 328.2600n -0.002547 328.2700n -0.002684 328.2800n -0.002790 328.2900n -0.002861 328.3000n -0.002896 328.3100n -0.002894 328.3200n -0.002853 328.3300n -0.002773 328.3400n -0.002656
+ 328.3500n -0.002504 328.3600n -0.002319 328.3700n -0.002104 328.3800n -0.001864 328.3900n -0.001603 328.4000n -0.001327 328.4100n -0.001041 328.4200n -0.000751 328.4300n -0.000463 328.4400n -0.000183 328.4500n 0.000083 328.4600n 0.000329 328.4700n 0.000549 328.4800n 0.000739 328.4900n 0.000894
+ 328.5000n 0.001010 328.5100n 0.001085 328.5200n 0.001116 328.5300n 0.001102 328.5400n 0.001042 328.5500n 0.000938 328.5600n 0.000790 328.5700n 0.000601 328.5800n 0.000375 328.5900n 0.000115 328.6000n -0.000174 328.6100n -0.000486 328.6200n -0.000816 328.6300n -0.001157 328.6400n -0.001502
+ 328.6500n -0.001845 328.6600n -0.002179 328.6700n -0.002497 328.6800n -0.002792 328.6900n -0.003060 328.7000n -0.003295 328.7100n -0.003490 328.7200n -0.003644 328.7300n -0.003751 328.7400n -0.003810 328.7500n -0.003819 328.7600n -0.003778 328.7700n -0.003686 328.7800n -0.003546 328.7900n -0.003359
+ 328.8000n -0.003129 328.8100n -0.002859 328.8200n -0.002554 328.8300n -0.002220 328.8400n -0.001861 328.8500n -0.001484 328.8600n -0.001096 328.8700n -0.000702 328.8800n -0.000310 328.8900n 0.000075 328.9000n 0.000446 328.9100n 0.000797 328.9200n 0.001123 328.9300n 0.001420 328.9400n 0.001683
+ 328.9500n 0.001910 328.9600n 0.002098 328.9700n 0.002244 328.9800n 0.002350 328.9900n 0.002413 329.0000n 0.002436 329.0100n 0.002420 329.0200n 0.002367 329.0300n 0.002280 329.0400n 0.002164 329.0500n 0.002022 329.0600n 0.001858 329.0700n 0.001678 329.0800n 0.001487 329.0900n 0.001289
+ 329.1000n 0.001090 329.1100n 0.000894 329.1200n 0.000706 329.1300n 0.000530 329.1400n 0.000370 329.1500n 0.000228 329.1600n 0.000109 329.1700n 0.000013 329.1800n -0.000059 329.1900n -0.000105 329.2000n -0.000126 329.2100n -0.000122 329.2200n -0.000095 329.2300n -0.000047 329.2400n 0.000020
+ 329.2500n 0.000102 329.2600n 0.000196 329.2700n 0.000299 329.2800n 0.000407 329.2900n 0.000515 329.3000n 0.000620 329.3100n 0.000717 329.3200n 0.000803 329.3300n 0.000875 329.3400n 0.000930 329.3500n 0.000964 329.3600n 0.000975 329.3700n 0.000963 329.3800n 0.000925 329.3900n 0.000861
+ 329.4000n 0.000772 329.4100n 0.000658 329.4200n 0.000520 329.4300n 0.000360 329.4400n 0.000181 329.4500n -0.000016 329.4600n -0.000225 329.4700n -0.000445 329.4800n -0.000671 329.4900n -0.000899 329.5000n -0.001126 329.5100n -0.001348 329.5200n -0.001559 329.5300n -0.001758 329.5400n -0.001940
+ 329.5500n -0.002103 329.5600n -0.002242 329.5700n -0.002357 329.5800n -0.002446 329.5900n -0.002506 329.6000n -0.002537 329.6100n -0.002539 329.6200n -0.002513 329.6300n -0.002458 329.6400n -0.002375 329.6500n -0.002268 329.6600n -0.002138 329.6700n -0.001986 329.6800n -0.001817 329.6900n -0.001633
+ 329.7000n -0.001437 329.7100n -0.001233 329.7200n -0.001023 329.7300n -0.000812 329.7400n -0.000602 329.7500n -0.000396 329.7600n -0.000198 329.7700n -0.000010 329.7800n 0.000166 329.7900n 0.000328 329.8000n 0.000474 329.8100n 0.000603 329.8200n 0.000713 329.8300n 0.000805 329.8400n 0.000878
+ 329.8500n 0.000932 329.8600n 0.000968 329.8700n 0.000987 329.8800n 0.000989 329.8900n 0.000976 329.9000n 0.000950 329.9100n 0.000911 329.9200n 0.000862 329.9300n 0.000804 329.9400n 0.000739 329.9500n 0.000668 329.9600n 0.000595 329.9700n 0.000519 329.9800n 0.000442 329.9900n 0.000366
+ 330.0000n 0.000291 330.0100n 0.000220 330.0200n 0.000151 330.0300n 0.000087 330.0400n 0.000027 330.0500n -0.000028 330.0600n -0.000079 330.0700n -0.000125 330.0800n -0.000166 330.0900n -0.000203 330.1000n -0.000236 330.1100n -0.000266 330.1200n -0.000292 330.1300n -0.000316 330.1400n -0.000337
+ 330.1500n -0.000356 330.1600n -0.000374 330.1700n -0.000390 330.1800n -0.000405 330.1900n -0.000419 330.2000n -0.000432 330.2100n -0.000444 330.2200n -0.000455 330.2300n -0.000465 330.2400n -0.000473 330.2500n -0.000480 330.2600n -0.000484 330.2700n -0.000487 330.2800n -0.000488 330.2900n -0.000485
+ 330.3000n -0.000481 330.3100n -0.000473 330.3200n -0.000463 330.3300n -0.000449 330.3400n -0.000433 330.3500n -0.000415 330.3600n -0.000394 330.3700n -0.000371 330.3800n -0.000347 330.3900n -0.000321 330.4000n -0.000294 330.4100n -0.000268 330.4200n -0.000241 330.4300n -0.000216 330.4400n -0.000192
+ 330.4500n -0.000169 330.4600n -0.000148 330.4700n -0.000130 330.4800n -0.000115 330.4900n -0.000102 330.5000n -0.000091 330.5100n -0.000084 330.5200n -0.000078 330.5300n -0.000075 330.5400n -0.000072 330.5500n -0.000071 330.5600n -0.000070 330.5700n -0.000068 330.5800n -0.000064 330.5900n -0.000059
+ 330.6000n -0.000050 330.6100n -0.000037 330.6200n -0.000019 330.6300n 0.000005 330.6400n 0.000035 330.6500n 0.000071 330.6600n 0.000115 330.6700n 0.000166 330.6800n 0.000224 330.6900n 0.000289 330.7000n 0.000362 330.7100n 0.000440 330.7200n 0.000524 330.7300n 0.000613 330.7400n 0.000705
+ 330.7500n 0.000799 330.7600n 0.000894 330.7700n 0.000988 330.7800n 0.001079 330.7900n 0.001166 330.8000n 0.001248 330.8100n 0.001322 330.8200n 0.001387 330.8300n 0.001442 330.8400n 0.001486 330.8500n 0.001516 330.8600n 0.001533 330.8700n 0.001536 330.8800n 0.001524 330.8900n 0.001497
+ 330.9000n 0.001455 330.9100n 0.001399 330.9200n 0.001329 330.9300n 0.001247 330.9400n 0.001153 330.9500n 0.001049 330.9600n 0.000937 330.9700n 0.000818 330.9800n 0.000694 330.9900n 0.000568 331.0000n 0.000441 331.0100n 0.000315 331.0200n 0.000192 331.0300n 0.000074 331.0400n -0.000037
+ 331.0500n -0.000140 331.0600n -0.000234 331.0700n -0.000317 331.0800n -0.000389 331.0900n -0.000450 331.1000n -0.000500 331.1100n -0.000538 331.1200n -0.000565 331.1300n -0.000583 331.1400n -0.000591 331.1500n -0.000592 331.1600n -0.000586 331.1700n -0.000576 331.1800n -0.000564 331.1900n -0.000550
+ 331.2000n -0.000537 331.2100n -0.000527 331.2200n -0.000521 331.2300n -0.000521 331.2400n -0.000528 331.2500n -0.000543 331.2600n -0.000567 331.2700n -0.000600 331.2800n -0.000644 331.2900n -0.000696 331.3000n -0.000757 331.3100n -0.000826 331.3200n -0.000901 331.3300n -0.000981 331.3400n -0.001064
+ 331.3500n -0.001147 331.3600n -0.001228 331.3700n -0.001306 331.3800n -0.001376 331.3900n -0.001436 331.4000n -0.001484 331.4100n -0.001518 331.4200n -0.001534 331.4300n -0.001531 331.4400n -0.001507 331.4500n -0.001461 331.4600n -0.001392 331.4700n -0.001299 331.4800n -0.001182 331.4900n -0.001043
+ 331.5000n -0.000881 331.5100n -0.000699 331.5200n -0.000499 331.5300n -0.000284 331.5400n -0.000056 331.5500n 0.000181 331.5600n 0.000423 331.5700n 0.000665 331.5800n 0.000905 331.5900n 0.001136 331.6000n 0.001354 331.6100n 0.001556 331.6200n 0.001736 331.6300n 0.001892 331.6400n 0.002018
+ 331.6500n 0.002112 331.6600n 0.002171 331.6700n 0.002193 331.6800n 0.002176 331.6900n 0.002120 331.7000n 0.002023 331.7100n 0.001888 331.7200n 0.001714 331.7300n 0.001504 331.7400n 0.001261 331.7500n 0.000987 331.7600n 0.000688 331.7700n 0.000366 331.7800n 0.000027 331.7900n -0.000323
+ 331.8000n -0.000680 331.8100n -0.001037 331.8200n -0.001389 331.8300n -0.001730 331.8400n -0.002055 331.8500n -0.002358 331.8600n -0.002635 331.8700n -0.002881 331.8800n -0.003092 331.8900n -0.003266 331.9000n -0.003399 331.9100n -0.003491 331.9200n -0.003539 331.9300n -0.003544 331.9400n -0.003506
+ 331.9500n -0.003428 331.9600n -0.003310 331.9700n -0.003155 331.9800n -0.002968 331.9900n -0.002753 332.0000n -0.002513 332.0100n -0.002254 332.0200n -0.001981 332.0300n -0.001700 332.0400n -0.001417 332.0500n -0.001136 332.0600n -0.000863 332.0700n -0.000604 332.0800n -0.000363 332.0900n -0.000145
+ 332.1000n 0.000046 332.1100n 0.000208 332.1200n 0.000337 332.1300n 0.000431 332.1400n 0.000489 332.1500n 0.000510 332.1600n 0.000495 332.1700n 0.000445 332.1800n 0.000360 332.1900n 0.000244 332.2000n 0.000099 332.2100n -0.000071 332.2200n -0.000264 332.2300n -0.000474 332.2400n -0.000697
+ 332.2500n -0.000929 332.2600n -0.001164 332.2700n -0.001399 332.2800n -0.001628 332.2900n -0.001848 332.3000n -0.002053 332.3100n -0.002241 332.3200n -0.002408 332.3300n -0.002551 332.3400n -0.002667 332.3500n -0.002756 332.3600n -0.002815 332.3700n -0.002844 332.3800n -0.002843 332.3900n -0.002813
+ 332.4000n -0.002754 332.4100n -0.002668 332.4200n -0.002556 332.4300n -0.002422 332.4400n -0.002268 332.4500n -0.002096 332.4600n -0.001911 332.4700n -0.001714 332.4800n -0.001510 332.4900n -0.001301 332.5000n -0.001092 332.5100n -0.000884 332.5200n -0.000681 332.5300n -0.000485 332.5400n -0.000298
+ 332.5500n -0.000123 332.5600n 0.000039 332.5700n 0.000187 332.5800n 0.000320 332.5900n 0.000437 332.6000n 0.000538 332.6100n 0.000623 332.6200n 0.000694 332.6300n 0.000749 332.6400n 0.000791 332.6500n 0.000821 332.6600n 0.000839 332.6700n 0.000847 332.6800n 0.000847 332.6900n 0.000840
+ 332.7000n 0.000827 332.7100n 0.000809 332.7200n 0.000788 332.7300n 0.000765 332.7400n 0.000740 332.7500n 0.000715 332.7600n 0.000690 332.7700n 0.000665 332.7800n 0.000641 332.7900n 0.000618 332.8000n 0.000595 332.8100n 0.000573 332.8200n 0.000552 332.8300n 0.000530 332.8400n 0.000509
+ 332.8500n 0.000487 332.8600n 0.000464 332.8700n 0.000440 332.8800n 0.000415 332.8900n 0.000389 332.9000n 0.000361 332.9100n 0.000333 332.9200n 0.000304 332.9300n 0.000275 332.9400n 0.000246 332.9500n 0.000219 332.9600n 0.000194 332.9700n 0.000172 332.9800n 0.000155 332.9900n 0.000142
+ 333.0000n 0.000136 333.0100n 0.000138 333.0200n 0.000148 333.0300n 0.000167 333.0400n 0.000195 333.0500n 0.000235 333.0600n 0.000284 333.0700n 0.000345 333.0800n 0.000416 333.0900n 0.000497 333.1000n 0.000588 333.1100n 0.000686 333.1200n 0.000792 333.1300n 0.000902 333.1400n 0.001017
+ 333.1500n 0.001132 333.1600n 0.001247 333.1700n 0.001359 333.1800n 0.001465 333.1900n 0.001563 333.2000n 0.001651 333.2100n 0.001726 333.2200n 0.001786 333.2300n 0.001829 333.2400n 0.001853 333.2500n 0.001857 333.2600n 0.001840 333.2700n 0.001802 333.2800n 0.001741 333.2900n 0.001658
+ 333.3000n 0.001554 333.3100n 0.001430 333.3200n 0.001288 333.3300n 0.001129 333.3400n 0.000956 333.3500n 0.000772 333.3600n 0.000580 333.3700n 0.000383 333.3800n 0.000185 333.3900n -0.000010 333.4000n -0.000199 333.4100n -0.000378 333.4200n -0.000543 333.4300n -0.000691 333.4400n -0.000819
+ 333.4500n -0.000923 333.4600n -0.001002 333.4700n -0.001053 333.4800n -0.001074 333.4900n -0.001066 333.5000n -0.001027 333.5100n -0.000957 333.5200n -0.000858 333.5300n -0.000731 333.5400n -0.000578 333.5500n -0.000401 333.5600n -0.000204 333.5700n 0.000010 333.5800n 0.000237 333.5900n 0.000473
+ 333.6000n 0.000713 333.6100n 0.000953 333.6200n 0.001189 333.6300n 0.001415 333.6400n 0.001627 333.6500n 0.001821 333.6600n 0.001994 333.6700n 0.002141 333.6800n 0.002260 333.6900n 0.002348 333.7000n 0.002404 333.7100n 0.002426 333.7200n 0.002413 333.7300n 0.002366 333.7400n 0.002285
+ 333.7500n 0.002172 333.7600n 0.002029 333.7700n 0.001859 333.7800n 0.001664 333.7900n 0.001448 333.8000n 0.001216 333.8100n 0.000971 333.8200n 0.000718 333.8300n 0.000462 333.8400n 0.000208 333.8500n -0.000039 333.8600n -0.000276 333.8700n -0.000498 333.8800n -0.000701 333.8900n -0.000881
+ 333.9000n -0.001035 333.9100n -0.001161 333.9200n -0.001257 333.9300n -0.001322 333.9400n -0.001354 333.9500n -0.001354 333.9600n -0.001323 333.9700n -0.001262 333.9800n -0.001172 333.9900n -0.001056 334.0000n -0.000918 334.0100n -0.000760 334.0200n -0.000585 334.0300n -0.000399 334.0400n -0.000205
+ 334.0500n -0.000008 334.0600n 0.000189 334.0700n 0.000380 334.0800n 0.000563 334.0900n 0.000733 334.1000n 0.000886 334.1100n 0.001020 334.1200n 0.001132 334.1300n 0.001219 334.1400n 0.001281 334.1500n 0.001316 334.1600n 0.001324 334.1700n 0.001305 334.1800n 0.001259 334.1900n 0.001188
+ 334.2000n 0.001093 334.2100n 0.000977 334.2200n 0.000842 334.2300n 0.000691 334.2400n 0.000528 334.2500n 0.000356 334.2600n 0.000178 334.2700n -0.000002 334.2800n -0.000180 334.2900n -0.000353 334.3000n -0.000518 334.3100n -0.000671 334.3200n -0.000810 334.3300n -0.000932 334.3400n -0.001036
+ 334.3500n -0.001120 334.3600n -0.001182 334.3700n -0.001222 334.3800n -0.001240 334.3900n -0.001237 334.4000n -0.001212 334.4100n -0.001167 334.4200n -0.001104 334.4300n -0.001025 334.4400n -0.000931 334.4500n -0.000826 334.4600n -0.000712 334.4700n -0.000592 334.4800n -0.000468 334.4900n -0.000344
+ 334.5000n -0.000222 334.5100n -0.000105 334.5200n 0.000004 334.5300n 0.000103 334.5400n 0.000191 334.5500n 0.000265 334.5600n 0.000325 334.5700n 0.000368 334.5800n 0.000395 334.5900n 0.000405 334.6000n 0.000398 334.6100n 0.000375 334.6200n 0.000336 334.6300n 0.000283 334.6400n 0.000217
+ 334.6500n 0.000139 334.6600n 0.000052 334.6700n -0.000043 334.6800n -0.000143 334.6900n -0.000246 334.7000n -0.000350 334.7100n -0.000453 334.7200n -0.000552 334.7300n -0.000646 334.7400n -0.000733 334.7500n -0.000810 334.7600n -0.000876 334.7700n -0.000930 334.7800n -0.000971 334.7900n -0.000998
+ 334.8000n -0.001010 334.8100n -0.001007 334.8200n -0.000990 334.8300n -0.000957 334.8400n -0.000910 334.8500n -0.000849 334.8600n -0.000776 334.8700n -0.000690 334.8800n -0.000594 334.8900n -0.000489 334.9000n -0.000376 334.9100n -0.000256 334.9200n -0.000132 334.9300n -0.000004 334.9400n 0.000125
+ 334.9500n 0.000254 334.9600n 0.000382 334.9700n 0.000507 334.9800n 0.000627 334.9900n 0.000743 335.0000n 0.000851 335.0100n 0.000952 335.0200n 0.001044 335.0300n 0.001126 335.0400n 0.001198 335.0500n 0.001259 335.0600n 0.001309 335.0700n 0.001346 335.0800n 0.001372 335.0900n 0.001386
+ 335.1000n 0.001387 335.1100n 0.001376 335.1200n 0.001354 335.1300n 0.001319 335.1400n 0.001273 335.1500n 0.001216 335.1600n 0.001149 335.1700n 0.001072 335.1800n 0.000986 335.1900n 0.000892 335.2000n 0.000790 335.2100n 0.000682 335.2200n 0.000569 335.2300n 0.000451 335.2400n 0.000330
+ 335.2500n 0.000207 335.2600n 0.000084 335.2700n -0.000039 335.2800n -0.000159 335.2900n -0.000276 335.3000n -0.000389 335.3100n -0.000495 335.3200n -0.000595 335.3300n -0.000685 335.3400n -0.000766 335.3500n -0.000836 335.3600n -0.000895 335.3700n -0.000941 335.3800n -0.000974 335.3900n -0.000993
+ 335.4000n -0.000999 335.4100n -0.000991 335.4200n -0.000969 335.4300n -0.000934 335.4400n -0.000887 335.4500n -0.000827 335.4600n -0.000756 335.4700n -0.000676 335.4800n -0.000588 335.4900n -0.000493 335.5000n -0.000392 335.5100n -0.000289 335.5200n -0.000184 335.5300n -0.000080 335.5400n 0.000022
+ 335.5500n 0.000119 335.5600n 0.000211 335.5700n 0.000294 335.5800n 0.000367 335.5900n 0.000430 335.6000n 0.000481 335.6100n 0.000518 335.6200n 0.000542 335.6300n 0.000552 335.6400n 0.000548 335.6500n 0.000529 335.6600n 0.000498 335.6700n 0.000454 335.6800n 0.000399 335.6900n 0.000334
+ 335.7000n 0.000262 335.7100n 0.000183 335.7200n 0.000100 335.7300n 0.000015 335.7400n -0.000068 335.7500n -0.000148 335.7600n -0.000223 335.7700n -0.000289 335.7800n -0.000345 335.7900n -0.000388 335.8000n -0.000417 335.8100n -0.000429 335.8200n -0.000423 335.8300n -0.000399 335.8400n -0.000355
+ 335.8500n -0.000290 335.8600n -0.000206 335.8700n -0.000102 335.8800n 0.000021 335.8900n 0.000161 335.9000n 0.000317 335.9100n 0.000487 335.9200n 0.000669 335.9300n 0.000860 335.9400n 0.001057 335.9500n 0.001258 335.9600n 0.001460 335.9700n 0.001658 335.9800n 0.001851 335.9900n 0.002035
+ 336.0000n 0.002207 336.0100n 0.002365 336.0200n 0.002505 336.0300n 0.002627 336.0400n 0.002728 336.0500n 0.002806 336.0600n 0.002861 336.0700n 0.002892 336.0800n 0.002899 336.0900n 0.002882 336.1000n 0.002842 336.1100n 0.002780 336.1200n 0.002699 336.1300n 0.002599 336.1400n 0.002484
+ 336.1500n 0.002356 336.1600n 0.002217 336.1700n 0.002072 336.1800n 0.001923 336.1900n 0.001773 336.2000n 0.001626 336.2100n 0.001485 336.2200n 0.001353 336.2300n 0.001233 336.2400n 0.001126 336.2500n 0.001036 336.2600n 0.000963 336.2700n 0.000911 336.2800n 0.000878 336.2900n 0.000867
+ 336.3000n 0.000876 336.3100n 0.000906 336.3200n 0.000955 336.3300n 0.001023 336.3400n 0.001107 336.3500n 0.001205 336.3600n 0.001315 336.3700n 0.001434 336.3800n 0.001559 336.3900n 0.001688 336.4000n 0.001816 336.4100n 0.001941 336.4200n 0.002059 336.4300n 0.002167 336.4400n 0.002264
+ 336.4500n 0.002345 336.4600n 0.002409 336.4700n 0.002453 336.4800n 0.002476 336.4900n 0.002477 336.5000n 0.002456 336.5100n 0.002411 336.5200n 0.002343 336.5300n 0.002253 336.5400n 0.002142 336.5500n 0.002012 336.5600n 0.001863 336.5700n 0.001700 336.5800n 0.001524 336.5900n 0.001338
+ 336.6000n 0.001145 336.6100n 0.000950 336.6200n 0.000754 336.6300n 0.000561 336.6400n 0.000375 336.6500n 0.000199 336.6600n 0.000036 336.6700n -0.000111 336.6800n -0.000241 336.6900n -0.000350 336.7000n -0.000437 336.7100n -0.000500 336.7200n -0.000538 336.7300n -0.000552 336.7400n -0.000540
+ 336.7500n -0.000503 336.7600n -0.000442 336.7700n -0.000359 336.7800n -0.000253 336.7900n -0.000129 336.8000n 0.000013 336.8100n 0.000170 336.8200n 0.000338 336.8300n 0.000515 336.8400n 0.000698 336.8500n 0.000883 336.8600n 0.001068 336.8700n 0.001248 336.8800n 0.001422 336.8900n 0.001585
+ 336.9000n 0.001736 336.9100n 0.001870 336.9200n 0.001987 336.9300n 0.002084 336.9400n 0.002159 336.9500n 0.002211 336.9600n 0.002239 336.9700n 0.002242 336.9800n 0.002219 336.9900n 0.002171 337.0000n 0.002098 337.0100n 0.002000 337.0200n 0.001879 337.0300n 0.001736 337.0400n 0.001572
+ 337.0500n 0.001390 337.0600n 0.001191 337.0700n 0.000977 337.0800n 0.000752 337.0900n 0.000517 337.1000n 0.000275 337.1100n 0.000029 337.1200n -0.000219 337.1300n -0.000465 337.1400n -0.000708 337.1500n -0.000945 337.1600n -0.001173 337.1700n -0.001389 337.1800n -0.001593 337.1900n -0.001781
+ 337.2000n -0.001951 337.2100n -0.002103 337.2200n -0.002234 337.2300n -0.002343 337.2400n -0.002430 337.2500n -0.002493 337.2600n -0.002532 337.2700n -0.002547 337.2800n -0.002537 337.2900n -0.002503 337.3000n -0.002446 337.3100n -0.002366 337.3200n -0.002264 337.3300n -0.002141 337.3400n -0.001999
+ 337.3500n -0.001840 337.3600n -0.001665 337.3700n -0.001476 337.3800n -0.001275 337.3900n -0.001066 337.4000n -0.000850 337.4100n -0.000630 337.4200n -0.000408 337.4300n -0.000188 337.4400n 0.000029 337.4500n 0.000239 337.4600n 0.000440 337.4700n 0.000630 337.4800n 0.000806 337.4900n 0.000965
+ 337.5000n 0.001107 337.5100n 0.001229 337.5200n 0.001331 337.5300n 0.001409 337.5400n 0.001465 337.5500n 0.001496 337.5600n 0.001504 337.5700n 0.001488 337.5800n 0.001448 337.5900n 0.001385 337.6000n 0.001301 337.6100n 0.001197 337.6200n 0.001074 337.6300n 0.000936 337.6400n 0.000783
+ 337.6500n 0.000618 337.6600n 0.000445 337.6700n 0.000266 337.6800n 0.000084 337.6900n -0.000099 337.7000n -0.000278 337.7100n -0.000453 337.7200n -0.000619 337.7300n -0.000774 337.7400n -0.000917 337.7500n -0.001044 337.7600n -0.001155 337.7700n -0.001247 337.7800n -0.001320 337.7900n -0.001373
+ 337.8000n -0.001406 337.8100n -0.001419 337.8200n -0.001412 337.8300n -0.001386 337.8400n -0.001343 337.8500n -0.001284 337.8600n -0.001211 337.8700n -0.001127 337.8800n -0.001033 337.8900n -0.000933 337.9000n -0.000829 337.9100n -0.000723 337.9200n -0.000619 337.9300n -0.000519 337.9400n -0.000427
+ 337.9500n -0.000344 337.9600n -0.000272 337.9700n -0.000214 337.9800n -0.000170 337.9900n -0.000144 338.0000n -0.000134 338.0100n -0.000142 338.0200n -0.000168 338.0300n -0.000212 338.0400n -0.000272 338.0500n -0.000348 338.0600n -0.000437 338.0700n -0.000539 338.0800n -0.000651 338.0900n -0.000770
+ 338.1000n -0.000895 338.1100n -0.001021 338.1200n -0.001147 338.1300n -0.001269 338.1400n -0.001385 338.1500n -0.001492 338.1600n -0.001588 338.1700n -0.001670 338.1800n -0.001737 338.1900n -0.001786 338.2000n -0.001816 338.2100n -0.001827 338.2200n -0.001818 338.2300n -0.001790 338.2400n -0.001742
+ 338.2500n -0.001675 338.2600n -0.001592 338.2700n -0.001493 338.2800n -0.001380 338.2900n -0.001257 338.3000n -0.001125 338.3100n -0.000988 338.3200n -0.000848 338.3300n -0.000709 338.3400n -0.000573 338.3500n -0.000445 338.3600n -0.000326 338.3700n -0.000220 338.3800n -0.000129 338.3900n -0.000055
+ 338.4000n -0.000001 338.4100n 0.000033 338.4200n 0.000045 338.4300n 0.000035 338.4400n 0.000001 338.4500n -0.000054 338.4600n -0.000131 338.4700n -0.000229 338.4800n -0.000345 338.4900n -0.000478 338.5000n -0.000626 338.5100n -0.000786 338.5200n -0.000955 338.5300n -0.001130 338.5400n -0.001308
+ 338.5500n -0.001486 338.5600n -0.001661 338.5700n -0.001831 338.5800n -0.001991 338.5900n -0.002139 338.6000n -0.002274 338.6100n -0.002393 338.6200n -0.002494 338.6300n -0.002576 338.6400n -0.002638 338.6500n -0.002680 338.6600n -0.002701 338.6700n -0.002702 338.6800n -0.002684 338.6900n -0.002646
+ 338.7000n -0.002592 338.7100n -0.002522 338.7200n -0.002438 338.7300n -0.002343 338.7400n -0.002238 338.7500n -0.002126 338.7600n -0.002008 338.7700n -0.001888 338.7800n -0.001768 338.7900n -0.001648 338.8000n -0.001531 338.8100n -0.001419 338.8200n -0.001312 338.8300n -0.001212 338.8400n -0.001119
+ 338.8500n -0.001033 338.8600n -0.000955 338.8700n -0.000884 338.8800n -0.000819 338.8900n -0.000760 338.9000n -0.000705 338.9100n -0.000653 338.9200n -0.000603 338.9300n -0.000553 338.9400n -0.000501 338.9500n -0.000447 338.9600n -0.000388 338.9700n -0.000324 338.9800n -0.000252 338.9900n -0.000174
+ 339.0000n -0.000086 339.0100n 0.000009 339.0200n 0.000113 339.0300n 0.000226 339.0400n 0.000346 339.0500n 0.000472 339.0600n 0.000603 339.0700n 0.000738 339.0800n 0.000873 339.0900n 0.001008 339.1000n 0.001139 339.1100n 0.001265 339.1200n 0.001381 339.1300n 0.001487 339.1400n 0.001578
+ 339.1500n 0.001653 339.1600n 0.001709 339.1700n 0.001744 339.1800n 0.001756 339.1900n 0.001744 339.2000n 0.001707 339.2100n 0.001644 339.2200n 0.001555 339.2300n 0.001441 339.2400n 0.001302 339.2500n 0.001140 339.2600n 0.000957 339.2700n 0.000755 339.2800n 0.000536 339.2900n 0.000305
+ 339.3000n 0.000064 339.3100n -0.000183 339.3200n -0.000432 339.3300n -0.000679 339.3400n -0.000920 339.3500n -0.001151 339.3600n -0.001368 339.3700n -0.001568 339.3800n -0.001747 339.3900n -0.001902 339.4000n -0.002031 339.4100n -0.002131 339.4200n -0.002202 339.4300n -0.002242 339.4400n -0.002250
+ 339.4500n -0.002228 339.4600n -0.002175 339.4700n -0.002094 339.4800n -0.001986 339.4900n -0.001854 339.5000n -0.001701 339.5100n -0.001530 339.5200n -0.001344 339.5300n -0.001149 339.5400n -0.000947 339.5500n -0.000744 339.5600n -0.000543 339.5700n -0.000348 339.5800n -0.000164 339.5900n 0.000006
+ 339.6000n 0.000158 339.6100n 0.000290 339.6200n 0.000398 339.6300n 0.000482 339.6400n 0.000540 339.6500n 0.000571 339.6600n 0.000574 339.6700n 0.000551 339.6800n 0.000502 339.6900n 0.000430 339.7000n 0.000335 339.7100n 0.000221 339.7200n 0.000092 339.7300n -0.000050 339.7400n -0.000200
+ 339.7500n -0.000356 339.7600n -0.000511 339.7700n -0.000663 339.7800n -0.000807 339.7900n -0.000939 339.8000n -0.001055 339.8100n -0.001153 339.8200n -0.001228 339.8300n -0.001278 339.8400n -0.001302 339.8500n -0.001297 339.8600n -0.001262 339.8700n -0.001197 339.8800n -0.001103 339.8900n -0.000980
+ 339.9000n -0.000829 339.9100n -0.000652 339.9200n -0.000452 339.9300n -0.000232 339.9400n 0.000006 339.9500n 0.000256 339.9600n 0.000517 339.9700n 0.000783 339.9800n 0.001050 339.9900n 0.001314 340.0000n 0.001571 340.0100n 0.001818 340.0200n 0.002050 340.0300n 0.002264 340.0400n 0.002456
+ 340.0500n 0.002625 340.0600n 0.002768 340.0700n 0.002883 340.0800n 0.002969 340.0900n 0.003025 340.1000n 0.003052 340.1100n 0.003048 340.1200n 0.003017 340.1300n 0.002958 340.1400n 0.002873 340.1500n 0.002765 340.1600n 0.002636 340.1700n 0.002489 340.1800n 0.002327 340.1900n 0.002152
+ 340.2000n 0.001969 340.2100n 0.001780 340.2200n 0.001588 340.2300n 0.001396 340.2400n 0.001208 340.2500n 0.001025 340.2600n 0.000851 340.2700n 0.000687 340.2800n 0.000535 340.2900n 0.000396 340.3000n 0.000272 340.3100n 0.000162 340.3200n 0.000068 340.3300n -0.000010 340.3400n -0.000074
+ 340.3500n -0.000124 340.3600n -0.000160 340.3700n -0.000184 340.3800n -0.000197 340.3900n -0.000201 340.4000n -0.000197 340.4100n -0.000186 340.4200n -0.000171 340.4300n -0.000153 340.4400n -0.000134 340.4500n -0.000114 340.4600n -0.000096 340.4700n -0.000079 340.4800n -0.000065 340.4900n -0.000055
+ 340.5000n -0.000049 340.5100n -0.000047 340.5200n -0.000049 340.5300n -0.000056 340.5400n -0.000066 340.5500n -0.000079 340.5600n -0.000094 340.5700n -0.000111 340.5800n -0.000129 340.5900n -0.000147 340.6000n -0.000163 340.6100n -0.000178 340.6200n -0.000190 340.6300n -0.000198 340.6400n -0.000202
+ 340.6500n -0.000201 340.6600n -0.000195 340.6700n -0.000183 340.6800n -0.000166 340.6900n -0.000143 340.7000n -0.000114 340.7100n -0.000081 340.7200n -0.000043 340.7300n -0.000001 340.7400n 0.000045 340.7500n 0.000092 340.7600n 0.000142 340.7700n 0.000191 340.7800n 0.000241 340.7900n 0.000289
+ 340.8000n 0.000335 340.8100n 0.000378 340.8200n 0.000418 340.8300n 0.000453 340.8400n 0.000483 340.8500n 0.000508 340.8600n 0.000528 340.8700n 0.000543 340.8800n 0.000553 340.8900n 0.000557 340.9000n 0.000557 340.9100n 0.000553 340.9200n 0.000545 340.9300n 0.000534 340.9400n 0.000522
+ 340.9500n 0.000508 340.9600n 0.000494 340.9700n 0.000480 340.9800n 0.000468 340.9900n 0.000457 341.0000n 0.000449 341.0100n 0.000444 341.0200n 0.000442 341.0300n 0.000444 341.0400n 0.000450 341.0500n 0.000459 341.0600n 0.000472 341.0700n 0.000489 341.0800n 0.000508 341.0900n 0.000529
+ 341.1000n 0.000551 341.1100n 0.000574 341.1200n 0.000597 341.1300n 0.000618 341.1400n 0.000637 341.1500n 0.000652 341.1600n 0.000663 341.1700n 0.000669 341.1800n 0.000669 341.1900n 0.000662 341.2000n 0.000648 341.2100n 0.000626 341.2200n 0.000597 341.2300n 0.000559 341.2400n 0.000513
+ 341.2500n 0.000461 341.2600n 0.000401 341.2700n 0.000335 341.2800n 0.000264 341.2900n 0.000189 341.3000n 0.000111 341.3100n 0.000031 341.3200n -0.000049 341.3300n -0.000127 341.3400n -0.000202 341.3500n -0.000272 341.3600n -0.000336 341.3700n -0.000393 341.3800n -0.000440 341.3900n -0.000478
+ 341.4000n -0.000503 341.4100n -0.000517 341.4200n -0.000517 341.4300n -0.000504 341.4400n -0.000477 341.4500n -0.000436 341.4600n -0.000382 341.4700n -0.000314 341.4800n -0.000233 341.4900n -0.000140 341.5000n -0.000037 341.5100n 0.000076 341.5200n 0.000197 341.5300n 0.000325 341.5400n 0.000457
+ 341.5500n 0.000593 341.5600n 0.000731 341.5700n 0.000868 341.5800n 0.001003 341.5900n 0.001134 341.6000n 0.001260 341.6100n 0.001379 341.6200n 0.001490 341.6300n 0.001590 341.6400n 0.001681 341.6500n 0.001759 341.6600n 0.001825 341.6700n 0.001877 341.6800n 0.001916 341.6900n 0.001941
+ 341.7000n 0.001953 341.7100n 0.001950 341.7200n 0.001934 341.7300n 0.001905 341.7400n 0.001864 341.7500n 0.001811 341.7600n 0.001746 341.7700n 0.001672 341.7800n 0.001588 341.7900n 0.001496 341.8000n 0.001396 341.8100n 0.001291 341.8200n 0.001180 341.8300n 0.001064 341.8400n 0.000946
+ 341.8500n 0.000825 341.8600n 0.000703 341.8700n 0.000580 341.8800n 0.000459 341.8900n 0.000338 341.9000n 0.000220 341.9100n 0.000105 341.9200n -0.000006 341.9300n -0.000112 341.9400n -0.000213 341.9500n -0.000307 341.9600n -0.000395 341.9700n -0.000474 341.9800n -0.000545 341.9900n -0.000607
+ 342.0000n -0.000660 342.0100n -0.000701 342.0200n -0.000732 342.0300n -0.000751 342.0400n -0.000759 342.0500n -0.000754 342.0600n -0.000736 342.0700n -0.000706 342.0800n -0.000663 342.0900n -0.000607 342.1000n -0.000539 342.1100n -0.000458 342.1200n -0.000366 342.1300n -0.000263 342.1400n -0.000150
+ 342.1500n -0.000028 342.1600n 0.000101 342.1700n 0.000237 342.1800n 0.000378 342.1900n 0.000521 342.2000n 0.000666 342.2100n 0.000811 342.2200n 0.000953 342.2300n 0.001091 342.2400n 0.001222 342.2500n 0.001345 342.2600n 0.001458 342.2700n 0.001558 342.2800n 0.001646 342.2900n 0.001719
+ 342.3000n 0.001775 342.3100n 0.001815 342.3200n 0.001837 342.3300n 0.001841 342.3400n 0.001827 342.3500n 0.001794 342.3600n 0.001745 342.3700n 0.001679 342.3800n 0.001597 342.3900n 0.001501 342.4000n 0.001394 342.4100n 0.001276 342.4200n 0.001150 342.4300n 0.001018 342.4400n 0.000884
+ 342.4500n 0.000748 342.4600n 0.000615 342.4700n 0.000486 342.4800n 0.000364 342.4900n 0.000252 342.5000n 0.000152 342.5100n 0.000065 342.5200n -0.000007 342.5300n -0.000061 342.5400n -0.000098 342.5500n -0.000117 342.5600n -0.000116 342.5700n -0.000097 342.5800n -0.000060 342.5900n -0.000005
+ 342.6000n 0.000065 342.6100n 0.000150 342.6200n 0.000248 342.6300n 0.000356 342.6400n 0.000471 342.6500n 0.000592 342.6600n 0.000715 342.6700n 0.000837 342.6800n 0.000955 342.6900n 0.001067 342.7000n 0.001170 342.7100n 0.001261 342.7200n 0.001337 342.7300n 0.001397 342.7400n 0.001439
+ 342.7500n 0.001461 342.7600n 0.001463 342.7700n 0.001443 342.7800n 0.001402 342.7900n 0.001340 342.8000n 0.001257 342.8100n 0.001155 342.8200n 0.001035 342.8300n 0.000900 342.8400n 0.000751 342.8500n 0.000590 342.8600n 0.000422 342.8700n 0.000248 342.8800n 0.000071 342.8900n -0.000104
+ 342.9000n -0.000276 342.9100n -0.000441 342.9200n -0.000597 342.9300n -0.000741 342.9400n -0.000870 342.9500n -0.000982 342.9600n -0.001077 342.9700n -0.001152 342.9800n -0.001208 342.9900n -0.001243 343.0000n -0.001257 343.0100n -0.001252 343.0200n -0.001229 343.0300n -0.001187 343.0400n -0.001131
+ 343.0500n -0.001061 343.0600n -0.000979 343.0700n -0.000890 343.0800n -0.000794 343.0900n -0.000696 343.1000n -0.000598 343.1100n -0.000503 343.1200n -0.000414 343.1300n -0.000334 343.1400n -0.000265 343.1500n -0.000208 343.1600n -0.000167 343.1700n -0.000142 343.1800n -0.000135 343.1900n -0.000146
+ 343.2000n -0.000175 343.2100n -0.000223 343.2200n -0.000287 343.2300n -0.000369 343.2400n -0.000465 343.2500n -0.000573 343.2600n -0.000693 343.2700n -0.000821 343.2800n -0.000955 343.2900n -0.001092 343.3000n -0.001228 343.3100n -0.001362 343.3200n -0.001490 343.3300n -0.001610 343.3400n -0.001718
+ 343.3500n -0.001813 343.3600n -0.001892 343.3700n -0.001953 343.3800n -0.001996 343.3900n -0.002019 343.4000n -0.002022 343.4100n -0.002004 343.4200n -0.001966 343.4300n -0.001907 343.4400n -0.001830 343.4500n -0.001736 343.4600n -0.001626 343.4700n -0.001502 343.4800n -0.001367 343.4900n -0.001223
+ 343.5000n -0.001072 343.5100n -0.000917 343.5200n -0.000761 343.5300n -0.000606 343.5400n -0.000455 343.5500n -0.000309 343.5600n -0.000171 343.5700n -0.000043 343.5800n 0.000075 343.5900n 0.000180 343.6000n 0.000273 343.6100n 0.000352 343.6200n 0.000418 343.6300n 0.000471 343.6400n 0.000512
+ 343.6500n 0.000542 343.6600n 0.000562 343.6700n 0.000573 343.6800n 0.000578 343.6900n 0.000578 343.7000n 0.000576 343.7100n 0.000572 343.7200n 0.000570 343.7300n 0.000572 343.7400n 0.000578 343.7500n 0.000592 343.7600n 0.000613 343.7700n 0.000644 343.7800n 0.000686 343.7900n 0.000738
+ 343.8000n 0.000801 343.8100n 0.000876 343.8200n 0.000961 343.8300n 0.001056 343.8400n 0.001160 343.8500n 0.001271 343.8600n 0.001387 343.8700n 0.001507 343.8800n 0.001629 343.8900n 0.001750 343.9000n 0.001868 343.9100n 0.001981 343.9200n 0.002086 343.9300n 0.002181 343.9400n 0.002264
+ 343.9500n 0.002333 343.9600n 0.002386 343.9700n 0.002422 343.9800n 0.002440 343.9900n 0.002439 344.0000n 0.002418 344.0100n 0.002378 344.0200n 0.002318 344.0300n 0.002240 344.0400n 0.002144 344.0500n 0.002031 344.0600n 0.001903 344.0700n 0.001762 344.0800n 0.001611 344.0900n 0.001450
+ 344.1000n 0.001283 344.1100n 0.001112 344.1200n 0.000939 344.1300n 0.000767 344.1400n 0.000598 344.1500n 0.000434 344.1600n 0.000278 344.1700n 0.000130 344.1800n -0.000007 344.1900n -0.000131 344.2000n -0.000243 344.2100n -0.000341 344.2200n -0.000425 344.2300n -0.000495 344.2400n -0.000551
+ 344.2500n -0.000593 344.2600n -0.000622 344.2700n -0.000639 344.2800n -0.000645 344.2900n -0.000642 344.3000n -0.000629 344.3100n -0.000610 344.3200n -0.000585 344.3300n -0.000555 344.3400n -0.000522 344.3500n -0.000487 344.3600n -0.000451 344.3700n -0.000415 344.3800n -0.000379 344.3900n -0.000344
+ 344.4000n -0.000310 344.4100n -0.000278 344.4200n -0.000246 344.4300n -0.000215 344.4400n -0.000183 344.4500n -0.000151 344.4600n -0.000116 344.4700n -0.000080 344.4800n -0.000039 344.4900n 0.000007 344.5000n 0.000059 344.5100n 0.000117 344.5200n 0.000184 344.5300n 0.000259 344.5400n 0.000344
+ 344.5500n 0.000437 344.5600n 0.000541 344.5700n 0.000654 344.5800n 0.000776 344.5900n 0.000906 344.6000n 0.001044 344.6100n 0.001188 344.6200n 0.001336 344.6300n 0.001488 344.6400n 0.001640 344.6500n 0.001791 344.6600n 0.001939 344.6700n 0.002080 344.6800n 0.002214 344.6900n 0.002336
+ 344.7000n 0.002446 344.7100n 0.002541 344.7200n 0.002619 344.7300n 0.002678 344.7400n 0.002717 344.7500n 0.002734 344.7600n 0.002729 344.7700n 0.002701 344.7800n 0.002649 344.7900n 0.002575 344.8000n 0.002479 344.8100n 0.002362 344.8200n 0.002225 344.8300n 0.002070 344.8400n 0.001899
+ 344.8500n 0.001715 344.8600n 0.001520 344.8700n 0.001317 344.8800n 0.001110 344.8900n 0.000900 344.9000n 0.000691 344.9100n 0.000487 344.9200n 0.000289 344.9300n 0.000102 344.9400n -0.000074 344.9500n -0.000234 344.9600n -0.000378 344.9700n -0.000503 344.9800n -0.000608 344.9900n -0.000693
+ 345.0000n -0.000756 345.0100n -0.000797 345.0200n -0.000818 345.0300n -0.000817 345.0400n -0.000797 345.0500n -0.000758 345.0600n -0.000702 345.0700n -0.000631 345.0800n -0.000547 345.0900n -0.000453 345.1000n -0.000350 345.1100n -0.000240 345.1200n -0.000128 345.1300n -0.000014 345.1400n 0.000099
+ 345.1500n 0.000209 345.1600n 0.000314 345.1700n 0.000412 345.1800n 0.000501 345.1900n 0.000581 345.2000n 0.000650 345.2100n 0.000708 345.2200n 0.000754 345.2300n 0.000789 345.2400n 0.000811 345.2500n 0.000823 345.2600n 0.000824 345.2700n 0.000815 345.2800n 0.000797 345.2900n 0.000772
+ 345.3000n 0.000740 345.3100n 0.000703 345.3200n 0.000662 345.3300n 0.000619 345.3400n 0.000574 345.3500n 0.000529 345.3600n 0.000484 345.3700n 0.000441 345.3800n 0.000400 345.3900n 0.000361 345.4000n 0.000325 345.4100n 0.000292 345.4200n 0.000262 345.4300n 0.000235 345.4400n 0.000210
+ 345.4500n 0.000187 345.4600n 0.000165 345.4700n 0.000144 345.4800n 0.000122 345.4900n 0.000100 345.5000n 0.000077 345.5100n 0.000051 345.5200n 0.000023 345.5300n -0.000008 345.5400n -0.000042 345.5500n -0.000079 345.5600n -0.000120 345.5700n -0.000163 345.5800n -0.000208 345.5900n -0.000256
+ 345.6000n -0.000304 345.6100n -0.000351 345.6200n -0.000397 345.6300n -0.000440 345.6400n -0.000479 345.6500n -0.000513 345.6600n -0.000539 345.6700n -0.000557 345.6800n -0.000565 345.6900n -0.000561 345.7000n -0.000546 345.7100n -0.000517 345.7200n -0.000474 345.7300n -0.000416 345.7400n -0.000345
+ 345.7500n -0.000258 345.7600n -0.000158 345.7700n -0.000044 345.7800n 0.000082 345.7900n 0.000220 345.8000n 0.000366 345.8100n 0.000520 345.8200n 0.000680 345.8300n 0.000843 345.8400n 0.001006 345.8500n 0.001168 345.8600n 0.001325 345.8700n 0.001475 345.8800n 0.001616 345.8900n 0.001745
+ 345.9000n 0.001860 345.9100n 0.001959 345.9200n 0.002041 345.9300n 0.002103 345.9400n 0.002145 345.9500n 0.002166 345.9600n 0.002165 345.9700n 0.002143 345.9800n 0.002100 345.9900n 0.002037 346.0000n 0.001955 346.0100n 0.001855 346.0200n 0.001740 346.0300n 0.001611 346.0400n 0.001470
+ 346.0500n 0.001321 346.0600n 0.001165 346.0700n 0.001006 346.0800n 0.000846 346.0900n 0.000688 346.1000n 0.000534 346.1100n 0.000386 346.1200n 0.000247 346.1300n 0.000118 346.1400n 0.000001 346.1500n -0.000102 346.1600n -0.000192 346.1700n -0.000267 346.1800n -0.000327 346.1900n -0.000373
+ 346.2000n -0.000406 346.2100n -0.000425 346.2200n -0.000433 346.2300n -0.000431 346.2400n -0.000421 346.2500n -0.000404 346.2600n -0.000383 346.2700n -0.000360 346.2800n -0.000337 346.2900n -0.000315 346.3000n -0.000298 346.3100n -0.000286 346.3200n -0.000280 346.3300n -0.000283 346.3400n -0.000295
+ 346.3500n -0.000316 346.3600n -0.000347 346.3700n -0.000387 346.3800n -0.000436 346.3900n -0.000492 346.4000n -0.000555 346.4100n -0.000623 346.4200n -0.000692 346.4300n -0.000762 346.4400n -0.000830 346.4500n -0.000892 346.4600n -0.000947 346.4700n -0.000991 346.4800n -0.001022 346.4900n -0.001036
+ 346.5000n -0.001032 346.5100n -0.001008 346.5200n -0.000961 346.5300n -0.000890 346.5400n -0.000794 346.5500n -0.000672 346.5600n -0.000524 346.5700n -0.000350 346.5800n -0.000152 346.5900n 0.000070 346.6000n 0.000313 346.6100n 0.000575 346.6200n 0.000853 346.6300n 0.001145 346.6400n 0.001446
+ 346.6500n 0.001753 346.6600n 0.002061 346.6700n 0.002368 346.6800n 0.002667 346.6900n 0.002956 346.7000n 0.003229 346.7100n 0.003484 346.7200n 0.003716 346.7300n 0.003921 346.7400n 0.004099 346.7500n 0.004244 346.7600n 0.004356 346.7700n 0.004434 346.7800n 0.004475 346.7900n 0.004481
+ 346.8000n 0.004451 346.8100n 0.004385 346.8200n 0.004287 346.8300n 0.004156 346.8400n 0.003997 346.8500n 0.003811 346.8600n 0.003603 346.8700n 0.003375 346.8800n 0.003131 346.8900n 0.002876 346.9000n 0.002614 346.9100n 0.002348 346.9200n 0.002084 346.9300n 0.001824 346.9400n 0.001572
+ 346.9500n 0.001333 346.9600n 0.001108 346.9700n 0.000902 346.9800n 0.000715 346.9900n 0.000550 347.0000n 0.000409 347.0100n 0.000291 347.0200n 0.000198 347.0300n 0.000129 347.0400n 0.000084 347.0500n 0.000061 347.0600n 0.000059 347.0700n 0.000076 347.0800n 0.000110 347.0900n 0.000159
+ 347.1000n 0.000219 347.1100n 0.000289 347.1200n 0.000364 347.1300n 0.000443 347.1400n 0.000523 347.1500n 0.000601 347.1600n 0.000674 347.1700n 0.000740 347.1800n 0.000797 347.1900n 0.000843 347.2000n 0.000877 347.2100n 0.000898 347.2200n 0.000905 347.2300n 0.000897 347.2400n 0.000875
+ 347.2500n 0.000839 347.2600n 0.000789 347.2700n 0.000727 347.2800n 0.000653 347.2900n 0.000569 347.3000n 0.000477 347.3100n 0.000378 347.3200n 0.000274 347.3300n 0.000167 347.3400n 0.000059 347.3500n -0.000049 347.3600n -0.000155 347.3700n -0.000257 347.3800n -0.000355 347.3900n -0.000445
+ 347.4000n -0.000529 347.4100n -0.000604 347.4200n -0.000671 347.4300n -0.000729 347.4400n -0.000777 347.4500n -0.000817 347.4600n -0.000847 347.4700n -0.000870 347.4800n -0.000885 347.4900n -0.000893 347.5000n -0.000896 347.5100n -0.000893 347.5200n -0.000887 347.5300n -0.000878 347.5400n -0.000867
+ 347.5500n -0.000855 347.5600n -0.000843 347.5700n -0.000832 347.5800n -0.000823 347.5900n -0.000816 347.6000n -0.000811 347.6100n -0.000809 347.6200n -0.000810 347.6300n -0.000813 347.6400n -0.000819 347.6500n -0.000827 347.6600n -0.000837 347.6700n -0.000849 347.6800n -0.000861 347.6900n -0.000873
+ 347.7000n -0.000884 347.7100n -0.000895 347.7200n -0.000903 347.7300n -0.000908 347.7400n -0.000910 347.7500n -0.000909 347.7600n -0.000903 347.7700n -0.000893 347.7800n -0.000878 347.7900n -0.000859 347.8000n -0.000835 347.8100n -0.000807 347.8200n -0.000775 347.8300n -0.000740 347.8400n -0.000701
+ 347.8500n -0.000660 347.8600n -0.000618 347.8700n -0.000574 347.8800n -0.000531 347.8900n -0.000488 347.9000n -0.000446 347.9100n -0.000407 347.9200n -0.000371 347.9300n -0.000337 347.9400n -0.000308 347.9500n -0.000283 347.9600n -0.000263 347.9700n -0.000248 347.9800n -0.000237 347.9900n -0.000231
+ 348.0000n -0.000230 348.0100n -0.000234 348.0200n -0.000241 348.0300n -0.000252 348.0400n -0.000266 348.0500n -0.000282 348.0600n -0.000300 348.0700n -0.000320 348.0800n -0.000340 348.0900n -0.000359 348.1000n -0.000379 348.1100n -0.000397 348.1200n -0.000413 348.1300n -0.000428 348.1400n -0.000440
+ 348.1500n -0.000449 348.1600n -0.000456 348.1700n -0.000461 348.1800n -0.000462 348.1900n -0.000462 348.2000n -0.000459 348.2100n -0.000455 348.2200n -0.000449 348.2300n -0.000441 348.2400n -0.000433 348.2500n -0.000425 348.2600n -0.000417 348.2700n -0.000408 348.2800n -0.000401 348.2900n -0.000394
+ 348.3000n -0.000388 348.3100n -0.000382 348.3200n -0.000378 348.3300n -0.000374 348.3400n -0.000370 348.3500n -0.000366 348.3600n -0.000362 348.3700n -0.000356 348.3800n -0.000348 348.3900n -0.000338 348.4000n -0.000325 348.4100n -0.000308 348.4200n -0.000286 348.4300n -0.000260 348.4400n -0.000227
+ 348.4500n -0.000188 348.4600n -0.000142 348.4700n -0.000090 348.4800n -0.000030 348.4900n 0.000037 348.5000n 0.000111 348.5100n 0.000192 348.5200n 0.000278 348.5300n 0.000370 348.5400n 0.000467 348.5500n 0.000567 348.5600n 0.000669 348.5700n 0.000773 348.5800n 0.000877 348.5900n 0.000979
+ 348.6000n 0.001078 348.6100n 0.001173 348.6200n 0.001262 348.6300n 0.001345 348.6400n 0.001420 348.6500n 0.001485 348.6600n 0.001540 348.6700n 0.001585 348.6800n 0.001619 348.6900n 0.001640 348.7000n 0.001651 348.7100n 0.001649 348.7200n 0.001637 348.7300n 0.001614 348.7400n 0.001581
+ 348.7500n 0.001540 348.7600n 0.001491 348.7700n 0.001435 348.7800n 0.001375 348.7900n 0.001311 348.8000n 0.001245 348.8100n 0.001178 348.8200n 0.001112 348.8300n 0.001049 348.8400n 0.000989 348.8500n 0.000933 348.8600n 0.000883 348.8700n 0.000839 348.8800n 0.000801 348.8900n 0.000770
+ 348.9000n 0.000745 348.9100n 0.000726 348.9200n 0.000713 348.9300n 0.000705 348.9400n 0.000700 348.9500n 0.000698 348.9600n 0.000696 348.9700n 0.000695 348.9800n 0.000691 348.9900n 0.000683 349.0000n 0.000670 349.0100n 0.000650 349.0200n 0.000621 349.0300n 0.000583 349.0400n 0.000534
+ 349.0500n 0.000474 349.0600n 0.000401 349.0700n 0.000317 349.0800n 0.000220 349.0900n 0.000112 349.1000n -0.000007 349.1100n -0.000135 349.1200n -0.000271 349.1300n -0.000413 349.1400n -0.000559 349.1500n -0.000705 349.1600n -0.000850 349.1700n -0.000991 349.1800n -0.001124 349.1900n -0.001247
+ 349.2000n -0.001357 349.2100n -0.001450 349.2200n -0.001525 349.2300n -0.001578 349.2400n -0.001608 349.2500n -0.001612 349.2600n -0.001590 349.2700n -0.001541 349.2800n -0.001463 349.2900n -0.001358 349.3000n -0.001225 349.3100n -0.001067 349.3200n -0.000884 349.3300n -0.000680 349.3400n -0.000457
+ 349.3500n -0.000218 349.3600n 0.000033 349.3700n 0.000293 349.3800n 0.000556 349.3900n 0.000819 349.4000n 0.001078 349.4100n 0.001327 349.4200n 0.001563 349.4300n 0.001781 349.4400n 0.001977 349.4500n 0.002149 349.4600n 0.002292 349.4700n 0.002404 349.4800n 0.002483 349.4900n 0.002528
+ 349.5000n 0.002539 349.5100n 0.002514 349.5200n 0.002455 349.5300n 0.002363 349.5400n 0.002240 349.5500n 0.002088 349.5600n 0.001911 349.5700n 0.001713 349.5800n 0.001498 349.5900n 0.001270 349.6000n 0.001035 349.6100n 0.000797 349.6200n 0.000561 349.6300n 0.000332 349.6400n 0.000116
+ 349.6500n -0.000083 349.6600n -0.000260 349.6700n -0.000412 349.6800n -0.000535 349.6900n -0.000627 349.7000n -0.000684 349.7100n -0.000707 349.7200n -0.000694 349.7300n -0.000645 349.7400n -0.000561 349.7500n -0.000443 349.7600n -0.000295 349.7700n -0.000118 349.7800n 0.000083 349.7900n 0.000303
+ 349.8000n 0.000540 349.8100n 0.000787 349.8200n 0.001039 349.8300n 0.001291 349.8400n 0.001537 349.8500n 0.001772 349.8600n 0.001991 349.8700n 0.002188 349.8800n 0.002359 349.8900n 0.002499 349.9000n 0.002607 349.9100n 0.002678 349.9200n 0.002710 349.9300n 0.002702 349.9400n 0.002653
+ 349.9500n 0.002564 349.9600n 0.002436 349.9700n 0.002270 349.9800n 0.002068 349.9900n 0.001835 350.0000n 0.001573 350.0100n 0.001287 350.0200n 0.000982 350.0300n 0.000663 350.0400n 0.000336 350.0500n 0.000006 350.0600n -0.000321 350.0700n -0.000640 350.0800n -0.000945 350.0900n -0.001232
+ 350.1000n -0.001495 350.1100n -0.001730 350.1200n -0.001934 350.1300n -0.002103 350.1400n -0.002235 350.1500n -0.002329 350.1600n -0.002383 350.1700n -0.002397 350.1800n -0.002372 350.1900n -0.002308 350.2000n -0.002209 350.2100n -0.002075 350.2200n -0.001912 350.2300n -0.001721 350.2400n -0.001507
+ 350.2500n -0.001275 350.2600n -0.001028 350.2700n -0.000772 350.2800n -0.000512 350.2900n -0.000251 350.3000n 0.000004 350.3100n 0.000251 350.3200n 0.000484 350.3300n 0.000701 350.3400n 0.000897 350.3500n 0.001071 350.3600n 0.001219 350.3700n 0.001341 350.3800n 0.001435 350.3900n 0.001500
+ 350.4000n 0.001536 350.4100n 0.001545 350.4200n 0.001526 350.4300n 0.001481 350.4400n 0.001413 350.4500n 0.001323 350.4600n 0.001214 350.4700n 0.001089 350.4800n 0.000950 350.4900n 0.000800 350.5000n 0.000643 350.5100n 0.000481 350.5200n 0.000317 350.5300n 0.000153 350.5400n -0.000008
+ 350.5500n -0.000164 350.5600n -0.000313 350.5700n -0.000453 350.5800n -0.000584 350.5900n -0.000704 350.6000n -0.000813 350.6100n -0.000910 350.6200n -0.000997 350.6300n -0.001072 350.6400n -0.001137 350.6500n -0.001192 350.6600n -0.001238 350.6700n -0.001276 350.6800n -0.001308 350.6900n -0.001334
+ 350.7000n -0.001355 350.7100n -0.001373 350.7200n -0.001388 350.7300n -0.001402 350.7400n -0.001414 350.7500n -0.001425 350.7600n -0.001436 350.7700n -0.001447 350.7800n -0.001458 350.7900n -0.001468 350.8000n -0.001476 350.8100n -0.001484 350.8200n -0.001489 350.8300n -0.001491 350.8400n -0.001490
+ 350.8500n -0.001483 350.8600n -0.001471 350.8700n -0.001453 350.8800n -0.001427 350.8900n -0.001394 350.9000n -0.001353 350.9100n -0.001303 350.9200n -0.001244 350.9300n -0.001176 350.9400n -0.001100 350.9500n -0.001015 350.9600n -0.000923 350.9700n -0.000825 350.9800n -0.000721 350.9900n -0.000612
+ 351.0000n -0.000500 351.0100n -0.000386 351.0200n -0.000271 351.0300n -0.000158 351.0400n -0.000047 351.0500n 0.000060 351.0600n 0.000162 351.0700n 0.000258 351.0800n 0.000346 351.0900n 0.000426 351.1000n 0.000497 351.1100n 0.000559 351.1200n 0.000611 351.1300n 0.000654 351.1400n 0.000687
+ 351.1500n 0.000712 351.1600n 0.000729 351.1700n 0.000738 351.1800n 0.000741 351.1900n 0.000739 351.2000n 0.000733 351.2100n 0.000725 351.2200n 0.000716 351.2300n 0.000707 351.2400n 0.000699 351.2500n 0.000694 351.2600n 0.000692 351.2700n 0.000695 351.2800n 0.000702 351.2900n 0.000715
+ 351.3000n 0.000732 351.3100n 0.000755 351.3200n 0.000783 351.3300n 0.000814 351.3400n 0.000849 351.3500n 0.000885 351.3600n 0.000921 351.3700n 0.000957 351.3800n 0.000990 351.3900n 0.001018 351.4000n 0.001040 351.4100n 0.001053 351.4200n 0.001058 351.4300n 0.001050 351.4400n 0.001031
+ 351.4500n 0.000997 351.4600n 0.000950 351.4700n 0.000887 351.4800n 0.000809 351.4900n 0.000715 351.5000n 0.000608 351.5100n 0.000487 351.5200n 0.000353 351.5300n 0.000209 351.5400n 0.000057 351.5500n -0.000101 351.5600n -0.000263 351.5700n -0.000425 351.5800n -0.000584 351.5900n -0.000738
+ 351.6000n -0.000883 351.6100n -0.001015 351.6200n -0.001133 351.6300n -0.001232 351.6400n -0.001311 351.6500n -0.001367 351.6600n -0.001399 351.6700n -0.001404 351.6800n -0.001381 351.6900n -0.001331 351.7000n -0.001253 351.7100n -0.001148 351.7200n -0.001016 351.7300n -0.000860 351.7400n -0.000682
+ 351.7500n -0.000485 351.7600n -0.000271 351.7700n -0.000044 351.7800n 0.000192 351.7900n 0.000433 351.8000n 0.000675 351.8100n 0.000912 351.8200n 0.001143 351.8300n 0.001360 351.8400n 0.001562 351.8500n 0.001744 351.8600n 0.001902 351.8700n 0.002033 351.8800n 0.002136 351.8900n 0.002207
+ 351.9000n 0.002246 351.9100n 0.002251 351.9200n 0.002223 351.9300n 0.002162 351.9400n 0.002069 351.9500n 0.001946 351.9600n 0.001795 351.9700n 0.001619 351.9800n 0.001421 351.9900n 0.001205 352.0000n 0.000974 352.0100n 0.000734 352.0200n 0.000488 352.0300n 0.000241 352.0400n -0.000002
+ 352.0500n -0.000238 352.0600n -0.000462 352.0700n -0.000671 352.0800n -0.000861 352.0900n -0.001029 352.1000n -0.001173 352.1100n -0.001290 352.1200n -0.001380 352.1300n -0.001441 352.1400n -0.001474 352.1500n -0.001479 352.1600n -0.001456 352.1700n -0.001409 352.1800n -0.001338 352.1900n -0.001246
+ 352.2000n -0.001136 352.2100n -0.001011 352.2200n -0.000875 352.2300n -0.000731 352.2400n -0.000582 352.2500n -0.000433 352.2600n -0.000286 352.2700n -0.000145 352.2800n -0.000013 352.2900n 0.000108 352.3000n 0.000215 352.3100n 0.000307 352.3200n 0.000383 352.3300n 0.000441 352.3400n 0.000481
+ 352.3500n 0.000505 352.3600n 0.000512 352.3700n 0.000504 352.3800n 0.000482 352.3900n 0.000448 352.4000n 0.000405 352.4100n 0.000355 352.4200n 0.000302 352.4300n 0.000247 352.4400n 0.000193 352.4500n 0.000144 352.4600n 0.000101 352.4700n 0.000068 352.4800n 0.000046 352.4900n 0.000036
+ 352.5000n 0.000040 352.5100n 0.000059 352.5200n 0.000093 352.5300n 0.000142 352.5400n 0.000204 352.5500n 0.000279 352.5600n 0.000365 352.5700n 0.000460 352.5800n 0.000561 352.5900n 0.000665 352.6000n 0.000769 352.6100n 0.000870 352.6200n 0.000964 352.6300n 0.001048 352.6400n 0.001118
+ 352.6500n 0.001171 352.6600n 0.001204 352.6700n 0.001215 352.6800n 0.001200 352.6900n 0.001159 352.7000n 0.001090 352.7100n 0.000992 352.7200n 0.000865 352.7300n 0.000710 352.7400n 0.000528 352.7500n 0.000321 352.7600n 0.000092 352.7700n -0.000158 352.7800n -0.000424 352.7900n -0.000702
+ 352.8000n -0.000988 352.8100n -0.001277 352.8200n -0.001566 352.8300n -0.001848 352.8400n -0.002118 352.8500n -0.002373 352.8600n -0.002608 352.8700n -0.002818 352.8800n -0.002999 352.8900n -0.003149 352.9000n -0.003264 352.9100n -0.003343 352.9200n -0.003384 352.9300n -0.003386 352.9400n -0.003349
+ 352.9500n -0.003275 352.9600n -0.003165 352.9700n -0.003020 352.9800n -0.002844 352.9900n -0.002641 353.0000n -0.002414 353.0100n -0.002169 353.0200n -0.001908 353.0300n -0.001639 353.0400n -0.001366 353.0500n -0.001094 353.0600n -0.000829 353.0700n -0.000576 353.0800n -0.000339 353.0900n -0.000123
+ 353.1000n 0.000068 353.1100n 0.000232 353.1200n 0.000364 353.1300n 0.000465 353.1400n 0.000531 353.1500n 0.000563 353.1600n 0.000560 353.1700n 0.000525 353.1800n 0.000459 353.1900n 0.000363 353.2000n 0.000242 353.2100n 0.000099 353.2200n -0.000062 353.2300n -0.000236 353.2400n -0.000419
+ 353.2500n -0.000605 353.2600n -0.000789 353.2700n -0.000967 353.2800n -0.001133 353.2900n -0.001282 353.3000n -0.001411 353.3100n -0.001515 353.3200n -0.001590 353.3300n -0.001636 353.3400n -0.001648 353.3500n -0.001626 353.3600n -0.001569 353.3700n -0.001477 353.3800n -0.001352 353.3900n -0.001194
+ 353.4000n -0.001007 353.4100n -0.000792 353.4200n -0.000555 353.4300n -0.000298 353.4400n -0.000027 353.4500n 0.000254 353.4600n 0.000539 353.4700n 0.000824 353.4800n 0.001102 353.4900n 0.001369 353.5000n 0.001620 353.5100n 0.001850 353.5200n 0.002054 353.5300n 0.002229 353.5400n 0.002371
+ 353.5500n 0.002478 353.5600n 0.002547 353.5700n 0.002577 353.5800n 0.002567 353.5900n 0.002518 353.6000n 0.002430 353.6100n 0.002305 353.6200n 0.002144 353.6300n 0.001951 353.6400n 0.001728 353.6500n 0.001480 353.6600n 0.001211 353.6700n 0.000925 353.6800n 0.000626 353.6900n 0.000321
+ 353.7000n 0.000013 353.7100n -0.000293 353.7200n -0.000591 353.7300n -0.000878 353.7400n -0.001149 353.7500n -0.001401 353.7600n -0.001630 353.7700n -0.001834 353.7800n -0.002010 353.7900n -0.002157 353.8000n -0.002274 353.8100n -0.002360 353.8200n -0.002416 353.8300n -0.002442 353.8400n -0.002440
+ 353.8500n -0.002411 353.8600n -0.002357 353.8700n -0.002282 353.8800n -0.002188 353.8900n -0.002078 353.9000n -0.001955 353.9100n -0.001824 353.9200n -0.001688 353.9300n -0.001550 353.9400n -0.001413 353.9500n -0.001280 353.9600n -0.001156 353.9700n -0.001041 353.9800n -0.000939 353.9900n -0.000851
+ 354.0000n -0.000778 354.0100n -0.000723 354.0200n -0.000684 354.0300n -0.000663 354.0400n -0.000660 354.0500n -0.000672 354.0600n -0.000700 354.0700n -0.000741 354.0800n -0.000794 354.0900n -0.000857 354.1000n -0.000928 354.1100n -0.001004 354.1200n -0.001082 354.1300n -0.001161 354.1400n -0.001236
+ 354.1500n -0.001306 354.1600n -0.001369 354.1700n -0.001421 354.1800n -0.001461 354.1900n -0.001487 354.2000n -0.001497 354.2100n -0.001490 354.2200n -0.001465 354.2300n -0.001421 354.2400n -0.001359 354.2500n -0.001277 354.2600n -0.001176 354.2700n -0.001057 354.2800n -0.000921 354.2900n -0.000768
+ 354.3000n -0.000602 354.3100n -0.000422 354.3200n -0.000231 354.3300n -0.000032 354.3400n 0.000175 354.3500n 0.000386 354.3600n 0.000599 354.3700n 0.000813 354.3800n 0.001025 354.3900n 0.001232 354.4000n 0.001433 354.4100n 0.001626 354.4200n 0.001809 354.4300n 0.001981 354.4400n 0.002139
+ 354.4500n 0.002283 354.4600n 0.002412 354.4700n 0.002525 354.4800n 0.002620 354.4900n 0.002699 354.5000n 0.002760 354.5100n 0.002804 354.5200n 0.002831 354.5300n 0.002841 354.5400n 0.002835 354.5500n 0.002813 354.5600n 0.002777 354.5700n 0.002727 354.5800n 0.002664 354.5900n 0.002589
+ 354.6000n 0.002505 354.6100n 0.002411 354.6200n 0.002309 354.6300n 0.002202 354.6400n 0.002089 354.6500n 0.001972 354.6600n 0.001852 354.6700n 0.001732 354.6800n 0.001611 354.6900n 0.001492 354.7000n 0.001374 354.7100n 0.001260 354.7200n 0.001149 354.7300n 0.001044 354.7400n 0.000943
+ 354.7500n 0.000849 354.7600n 0.000761 354.7700n 0.000680 354.7800n 0.000606 354.7900n 0.000539 354.8000n 0.000478 354.8100n 0.000425 354.8200n 0.000377 354.8300n 0.000336 354.8400n 0.000300 354.8500n 0.000270 354.8600n 0.000243 354.8700n 0.000219 354.8800n 0.000199 354.8900n 0.000179
+ 354.9000n 0.000161 354.9100n 0.000142 354.9200n 0.000122 354.9300n 0.000099 354.9400n 0.000074 354.9500n 0.000045 354.9600n 0.000011 354.9700n -0.000029 354.9800n -0.000074 354.9900n -0.000126 355.0000n -0.000185 355.0100n -0.000251 355.0200n -0.000324 355.0300n -0.000404 355.0400n -0.000491
+ 355.0500n -0.000584 355.0600n -0.000682 355.0700n -0.000786 355.0800n -0.000894 355.0900n -0.001005 355.1000n -0.001119 355.1100n -0.001233 355.1200n -0.001348 355.1300n -0.001461 355.1400n -0.001571 355.1500n -0.001678 355.1600n -0.001779 355.1700n -0.001875 355.1800n -0.001962 355.1900n -0.002042
+ 355.2000n -0.002112 355.2100n -0.002172 355.2200n -0.002222 355.2300n -0.002260 355.2400n -0.002288 355.2500n -0.002305 355.2600n -0.002311 355.2700n -0.002306 355.2800n -0.002292 355.2900n -0.002268 355.3000n -0.002236 355.3100n -0.002197 355.3200n -0.002152 355.3300n -0.002101 355.3400n -0.002048
+ 355.3500n -0.001991 355.3600n -0.001934 355.3700n -0.001877 355.3800n -0.001822 355.3900n -0.001769 355.4000n -0.001720 355.4100n -0.001675 355.4200n -0.001636 355.4300n -0.001602 355.4400n -0.001574 355.4500n -0.001553 355.4600n -0.001537 355.4700n -0.001527 355.4800n -0.001523 355.4900n -0.001523
+ 355.5000n -0.001526 355.5100n -0.001532 355.5200n -0.001539 355.5300n -0.001546 355.5400n -0.001552 355.5500n -0.001556 355.5600n -0.001555 355.5700n -0.001548 355.5800n -0.001535 355.5900n -0.001514 355.6000n -0.001484 355.6100n -0.001443 355.6200n -0.001393 355.6300n -0.001331 355.6400n -0.001258
+ 355.6500n -0.001174 355.6600n -0.001079 355.6700n -0.000974 355.6800n -0.000859 355.6900n -0.000737 355.7000n -0.000608 355.7100n -0.000473 355.7200n -0.000336 355.7300n -0.000197 355.7400n -0.000059 355.7500n 0.000076 355.7600n 0.000205 355.7700n 0.000326 355.7800n 0.000438 355.7900n 0.000538
+ 355.8000n 0.000623 355.8100n 0.000693 355.8200n 0.000745 355.8300n 0.000778 355.8400n 0.000791 355.8500n 0.000784 355.8600n 0.000755 355.8700n 0.000705 355.8800n 0.000634 355.8900n 0.000542 355.9000n 0.000432 355.9100n 0.000303 355.9200n 0.000158 355.9300n -0.000001 355.9400n -0.000173
+ 355.9500n -0.000354 355.9600n -0.000543 355.9700n -0.000736 355.9800n -0.000930 355.9900n -0.001123 356.0000n -0.001312 356.0100n -0.001494 356.0200n -0.001666 356.0300n -0.001826 356.0400n -0.001971 356.0500n -0.002099 356.0600n -0.002208 356.0700n -0.002296 356.0800n -0.002363 356.0900n -0.002407
+ 356.1000n -0.002428 356.1100n -0.002425 356.1200n -0.002398 356.1300n -0.002349 356.1400n -0.002277 356.1500n -0.002183 356.1600n -0.002069 356.1700n -0.001937 356.1800n -0.001788 356.1900n -0.001623 356.2000n -0.001447 356.2100n -0.001259 356.2200n -0.001063 356.2300n -0.000861 356.2400n -0.000655
+ 356.2500n -0.000448 356.2600n -0.000241 356.2700n -0.000038 356.2800n 0.000161 356.2900n 0.000354 356.3000n 0.000538 356.3100n 0.000712 356.3200n 0.000875 356.3300n 0.001026 356.3400n 0.001163 356.3500n 0.001286 356.3600n 0.001395 356.3700n 0.001488 356.3800n 0.001566 356.3900n 0.001629
+ 356.4000n 0.001675 356.4100n 0.001706 356.4200n 0.001722 356.4300n 0.001722 356.4400n 0.001708 356.4500n 0.001679 356.4600n 0.001636 356.4700n 0.001579 356.4800n 0.001510 356.4900n 0.001428 356.5000n 0.001334 356.5100n 0.001229 356.5200n 0.001114 356.5300n 0.000990 356.5400n 0.000856
+ 356.5500n 0.000715 356.5600n 0.000567 356.5700n 0.000412 356.5800n 0.000253 356.5900n 0.000091 356.6000n -0.000074 356.6100n -0.000240 356.6200n -0.000405 356.6300n -0.000568 356.6400n -0.000728 356.6500n -0.000882 356.6600n -0.001029 356.6700n -0.001167 356.6800n -0.001294 356.6900n -0.001409
+ 356.7000n -0.001511 356.7100n -0.001597 356.7200n -0.001666 356.7300n -0.001717 356.7400n -0.001749 356.7500n -0.001761 356.7600n -0.001752 356.7700n -0.001722 356.7800n -0.001671 356.7900n -0.001599 356.8000n -0.001507 356.8100n -0.001395 356.8200n -0.001266 356.8300n -0.001121 356.8400n -0.000960
+ 356.8500n -0.000788 356.8600n -0.000607 356.8700n -0.000418 356.8800n -0.000226 356.8900n -0.000033 356.9000n 0.000158 356.9100n 0.000342 356.9200n 0.000516 356.9300n 0.000678 356.9400n 0.000824 356.9500n 0.000951 356.9600n 0.001056 356.9700n 0.001136 356.9800n 0.001190 356.9900n 0.001215
+ 357.0000n 0.001210 357.0100n 0.001175 357.0200n 0.001109 357.0300n 0.001011 357.0400n 0.000884 357.0500n 0.000727 357.0600n 0.000543 357.0700n 0.000334 357.0800n 0.000102 357.0900n -0.000149 357.1000n -0.000415 357.1100n -0.000693 357.1200n -0.000979 357.1300n -0.001269 357.1400n -0.001557
+ 357.1500n -0.001840 357.1600n -0.002112 357.1700n -0.002370 357.1800n -0.002609 357.1900n -0.002825 357.2000n -0.003015 357.2100n -0.003175 357.2200n -0.003302 357.2300n -0.003395 357.2400n -0.003452 357.2500n -0.003470 357.2600n -0.003451 357.2700n -0.003394 357.2800n -0.003299 357.2900n -0.003168
+ 357.3000n -0.003003 357.3100n -0.002806 357.3200n -0.002580 357.3300n -0.002328 357.3400n -0.002055 357.3500n -0.001764 357.3600n -0.001459 357.3700n -0.001145 357.3800n -0.000827 357.3900n -0.000510 357.4000n -0.000196 357.4100n 0.000108 357.4200n 0.000398 357.4300n 0.000672 357.4400n 0.000925
+ 357.4500n 0.001154 357.4600n 0.001357 357.4700n 0.001532 357.4800n 0.001676 357.4900n 0.001788 357.5000n 0.001869 357.5100n 0.001918 357.5200n 0.001936 357.5300n 0.001922 357.5400n 0.001880 357.5500n 0.001811 357.5600n 0.001716 357.5700n 0.001599 357.5800n 0.001463 357.5900n 0.001311
+ 357.6000n 0.001145 357.6100n 0.000969 357.6200n 0.000786 357.6300n 0.000600 357.6400n 0.000414 357.6500n 0.000230 357.6600n 0.000053 357.6700n -0.000117 357.6800n -0.000277 357.6900n -0.000424 357.7000n -0.000557 357.7100n -0.000675 357.7200n -0.000778 357.7300n -0.000863 357.7400n -0.000932
+ 357.7500n -0.000984 357.7600n -0.001020 357.7700n -0.001041 357.7800n -0.001046 357.7900n -0.001039 357.8000n -0.001019 357.8100n -0.000989 357.8200n -0.000949 357.8300n -0.000902 357.8400n -0.000849 357.8500n -0.000791 357.8600n -0.000730 357.8700n -0.000668 357.8800n -0.000605 357.8900n -0.000543
+ 357.9000n -0.000483 357.9100n -0.000425 357.9200n -0.000370 357.9300n -0.000318 357.9400n -0.000270 357.9500n -0.000226 357.9600n -0.000186 357.9700n -0.000149 357.9800n -0.000115 357.9900n -0.000085 358.0000n -0.000057 358.0100n -0.000030 358.0200n -0.000005 358.0300n 0.000018 358.0400n 0.000041
+ 358.0500n 0.000064 358.0600n 0.000087 358.0700n 0.000111 358.0800n 0.000134 358.0900n 0.000158 358.1000n 0.000183 358.1100n 0.000207 358.1200n 0.000231 358.1300n 0.000255 358.1400n 0.000277 358.1500n 0.000298 358.1600n 0.000316 358.1700n 0.000332 358.1800n 0.000343 358.1900n 0.000351
+ 358.2000n 0.000353 358.2100n 0.000350 358.2200n 0.000341 358.2300n 0.000325 358.2400n 0.000303 358.2500n 0.000274 358.2600n 0.000238 358.2700n 0.000195 358.2800n 0.000146 358.2900n 0.000091 358.3000n 0.000030 358.3100n -0.000037 358.3200n -0.000107 358.3300n -0.000181 358.3400n -0.000257
+ 358.3500n -0.000334 358.3600n -0.000412 358.3700n -0.000489 358.3800n -0.000564 358.3900n -0.000636 358.4000n -0.000704 358.4100n -0.000767 358.4200n -0.000824 358.4300n -0.000875 358.4400n -0.000918 358.4500n -0.000954 358.4600n -0.000981 358.4700n -0.001001 358.4800n -0.001012 358.4900n -0.001014
+ 358.5000n -0.001009 358.5100n -0.000997 358.5200n -0.000977 358.5300n -0.000951 358.5400n -0.000920 358.5500n -0.000883 358.5600n -0.000843 358.5700n -0.000800 358.5800n -0.000755 358.5900n -0.000708 358.6000n -0.000662 358.6100n -0.000616 358.6200n -0.000572 358.6300n -0.000531 358.6400n -0.000492
+ 358.6500n -0.000457 358.6600n -0.000425 358.6700n -0.000398 358.6800n -0.000376 358.6900n -0.000358 358.7000n -0.000344 358.7100n -0.000335 358.7200n -0.000331 358.7300n -0.000330 358.7400n -0.000333 358.7500n -0.000340 358.7600n -0.000349 358.7700n -0.000361 358.7800n -0.000375 358.7900n -0.000390
+ 358.8000n -0.000407 358.8100n -0.000424 358.8200n -0.000441 358.8300n -0.000459 358.8400n -0.000476 358.8500n -0.000493 358.8600n -0.000509 358.8700n -0.000525 358.8800n -0.000540 358.8900n -0.000555 358.9000n -0.000569 358.9100n -0.000583 358.9200n -0.000596 358.9300n -0.000609 358.9400n -0.000623
+ 358.9500n -0.000636 358.9600n -0.000650 358.9700n -0.000664 358.9800n -0.000678 358.9900n -0.000692 359.0000n -0.000706 359.0100n -0.000720 359.0200n -0.000734 359.0300n -0.000746 359.0400n -0.000758 359.0500n -0.000768 359.0600n -0.000776 359.0700n -0.000781 359.0800n -0.000782 359.0900n -0.000781
+ 359.1000n -0.000774 359.1100n -0.000763 359.1200n -0.000747 359.1300n -0.000725 359.1400n -0.000697 359.1500n -0.000663 359.1600n -0.000623 359.1700n -0.000576 359.1800n -0.000524 359.1900n -0.000465 359.2000n -0.000401 359.2100n -0.000332 359.2200n -0.000260 359.2300n -0.000184 359.2400n -0.000105
+ 359.2500n -0.000025 359.2600n 0.000055 359.2700n 0.000134 359.2800n 0.000210 359.2900n 0.000284 359.3000n 0.000353 359.3100n 0.000416 359.3200n 0.000473 359.3300n 0.000521 359.3400n 0.000562 359.3500n 0.000592 359.3600n 0.000614 359.3700n 0.000624 359.3800n 0.000625 359.3900n 0.000615
+ 359.4000n 0.000595 359.4100n 0.000565 359.4200n 0.000526 359.4300n 0.000479 359.4400n 0.000424 359.4500n 0.000363 359.4600n 0.000297 359.4700n 0.000227 359.4800n 0.000154 359.4900n 0.000080 359.5000n 0.000006 359.5100n -0.000067 359.5200n -0.000137 359.5300n -0.000203 359.5400n -0.000265
+ 359.5500n -0.000321 359.5600n -0.000371 359.5700n -0.000414 359.5800n -0.000450 359.5900n -0.000479 359.6000n -0.000502 359.6100n -0.000518 359.6200n -0.000529 359.6300n -0.000535 359.6400n -0.000538 359.6500n -0.000538 359.6600n -0.000537 359.6700n -0.000536 359.6800n -0.000538 359.6900n -0.000542
+ 359.7000n -0.000551 359.7100n -0.000567 359.7200n -0.000590 359.7300n -0.000621 359.7400n -0.000662 359.7500n -0.000713 359.7600n -0.000776 359.7700n -0.000849 359.7800n -0.000932 359.7900n -0.001027 359.8000n -0.001131 359.8100n -0.001244 359.8200n -0.001365 359.8300n -0.001492 359.8400n -0.001623
+ 359.8500n -0.001756 359.8600n -0.001890 359.8700n -0.002020 359.8800n -0.002147 359.8900n -0.002265 359.9000n -0.002374 359.9100n -0.002471 359.9200n -0.002553 359.9300n -0.002618 359.9400n -0.002664 359.9500n -0.002690 359.9600n -0.002694 359.9700n -0.002675 359.9800n -0.002631 359.9900n -0.002564
+ 360.0000n -0.002472 360.0100n -0.002356 360.0200n -0.002217 360.0300n -0.002057 360.0400n -0.001876 360.0500n -0.001677 360.0600n -0.001462 360.0700n -0.001234 360.0800n -0.000995 360.0900n -0.000748 360.1000n -0.000497 360.1100n -0.000245 360.1200n 0.000006 360.1300n 0.000251 360.1400n 0.000488
+ 360.1500n 0.000714 360.1600n 0.000926 360.1700n 0.001121 360.1800n 0.001298 360.1900n 0.001454 360.2000n 0.001588 360.2100n 0.001698 360.2200n 0.001785 360.2300n 0.001847 360.2400n 0.001884 360.2500n 0.001898 360.2600n 0.001888 360.2700n 0.001856 360.2800n 0.001804 360.2900n 0.001732
+ 360.3000n 0.001644 360.3100n 0.001541 360.3200n 0.001426 360.3300n 0.001300 360.3400n 0.001168 360.3500n 0.001030 360.3600n 0.000890 360.3700n 0.000751 360.3800n 0.000613 360.3900n 0.000480 360.4000n 0.000354 360.4100n 0.000235 360.4200n 0.000126 360.4300n 0.000028 360.4400n -0.000058
+ 360.4500n -0.000132 360.4600n -0.000193 360.4700n -0.000240 360.4800n -0.000275 360.4900n -0.000297 360.5000n -0.000307 360.5100n -0.000304 360.5200n -0.000291 360.5300n -0.000268 360.5400n -0.000236 360.5500n -0.000196 360.5600n -0.000150 360.5700n -0.000097 360.5800n -0.000040 360.5900n 0.000021
+ 360.6000n 0.000084 360.6100n 0.000149 360.6200n 0.000216 360.6300n 0.000282 360.6400n 0.000348 360.6500n 0.000413 360.6600n 0.000477 360.6700n 0.000539 360.6800n 0.000599 360.6900n 0.000657 360.7000n 0.000712 360.7100n 0.000765 360.7200n 0.000814 360.7300n 0.000861 360.7400n 0.000905
+ 360.7500n 0.000946 360.7600n 0.000983 360.7700n 0.001016 360.7800n 0.001046 360.7900n 0.001071 360.8000n 0.001093 360.8100n 0.001109 360.8200n 0.001120 360.8300n 0.001126 360.8400n 0.001126 360.8500n 0.001119 360.8600n 0.001107 360.8700n 0.001088 360.8800n 0.001063 360.8900n 0.001031
+ 360.9000n 0.000994 360.9100n 0.000950 360.9200n 0.000901 360.9300n 0.000847 360.9400n 0.000789 360.9500n 0.000728 360.9600n 0.000666 360.9700n 0.000603 360.9800n 0.000540 360.9900n 0.000480 361.0000n 0.000424 361.0100n 0.000374 361.0200n 0.000330 361.0300n 0.000295 361.0400n 0.000271
+ 361.0500n 0.000258 361.0600n 0.000258 361.0700n 0.000272 361.0800n 0.000301 361.0900n 0.000345 361.1000n 0.000405 361.1100n 0.000480 361.1200n 0.000571 361.1300n 0.000676 361.1400n 0.000795 361.1500n 0.000925 361.1600n 0.001065 361.1700n 0.001213 361.1800n 0.001367 361.1900n 0.001524
+ 361.2000n 0.001680 361.2100n 0.001833 361.2200n 0.001979 361.2300n 0.002116 361.2400n 0.002240 361.2500n 0.002349 361.2600n 0.002438 361.2700n 0.002506 361.2800n 0.002550 361.2900n 0.002569 361.3000n 0.002560 361.3100n 0.002523 361.3200n 0.002458 361.3300n 0.002363 361.3400n 0.002240
+ 361.3500n 0.002090 361.3600n 0.001914 361.3700n 0.001715 361.3800n 0.001496 361.3900n 0.001259 361.4000n 0.001009 361.4100n 0.000750 361.4200n 0.000485 361.4300n 0.000220 361.4400n -0.000041 361.4500n -0.000293 361.4600n -0.000532 361.4700n -0.000753 361.4800n -0.000953 361.4900n -0.001127
+ 361.5000n -0.001273 361.5100n -0.001387 361.5200n -0.001467 361.5300n -0.001512 361.5400n -0.001522 361.5500n -0.001495 361.5600n -0.001434 361.5700n -0.001339 361.5800n -0.001213 361.5900n -0.001058 361.6000n -0.000879 361.6100n -0.000678 361.6200n -0.000462 361.6300n -0.000235 361.6400n -0.000002
+ 361.6500n 0.000230 361.6600n 0.000458 361.6700n 0.000674 361.6800n 0.000873 361.6900n 0.001051 361.7000n 0.001203 361.7100n 0.001324 361.7200n 0.001411 361.7300n 0.001461 361.7400n 0.001472 361.7500n 0.001443 361.7600n 0.001373 361.7700n 0.001263 361.7800n 0.001115 361.7900n 0.000931
+ 361.8000n 0.000714 361.8100n 0.000468 361.8200n 0.000198 361.8300n -0.000090 361.8400n -0.000392 361.8500n -0.000700 361.8600n -0.001007 361.8700n -0.001308 361.8800n -0.001596 361.8900n -0.001863 361.9000n -0.002104 361.9100n -0.002313 361.9200n -0.002484 361.9300n -0.002614 361.9400n -0.002697
+ 361.9500n -0.002732 361.9600n -0.002715 361.9700n -0.002648 361.9800n -0.002529 361.9900n -0.002359 362.0000n -0.002141 362.0100n -0.001879 362.0200n -0.001576 362.0300n -0.001237 362.0400n -0.000869 362.0500n -0.000477 362.0600n -0.000070 362.0700n 0.000346 362.0800n 0.000763 362.0900n 0.001173
+ 362.1000n 0.001568 362.1100n 0.001941 362.1200n 0.002284 362.1300n 0.002592 362.1400n 0.002857 362.1500n 0.003075 362.1600n 0.003242 362.1700n 0.003355 362.1800n 0.003411 362.1900n 0.003409 362.2000n 0.003350 362.2100n 0.003235 362.2200n 0.003066 362.2300n 0.002847 362.2400n 0.002582
+ 362.2500n 0.002277 362.2600n 0.001937 362.2700n 0.001571 362.2800n 0.001184 362.2900n 0.000785 362.3000n 0.000383 362.3100n -0.000016 362.3200n -0.000404 362.3300n -0.000771 362.3400n -0.001113 362.3500n -0.001421 362.3600n -0.001690 362.3700n -0.001915 362.3800n -0.002093 362.3900n -0.002219
+ 362.4000n -0.002293 362.4100n -0.002313 362.4200n -0.002280 362.4300n -0.002195 362.4400n -0.002061 362.4500n -0.001881 362.4600n -0.001661 362.4700n -0.001405 362.4800n -0.001119 362.4900n -0.000810 362.5000n -0.000486 362.5100n -0.000153 362.5200n 0.000181 362.5300n 0.000508 362.5400n 0.000821
+ 362.5500n 0.001114 362.5600n 0.001380 362.5700n 0.001613 362.5800n 0.001808 362.5900n 0.001961 362.6000n 0.002070 362.6100n 0.002131 362.6200n 0.002144 362.6300n 0.002110 362.6400n 0.002028 362.6500n 0.001901 362.6600n 0.001732 362.6700n 0.001526 362.6800n 0.001286 362.6900n 0.001018
+ 362.7000n 0.000729 362.7100n 0.000424 362.7200n 0.000111 362.7300n -0.000204 362.7400n -0.000514 362.7500n -0.000812 362.7600n -0.001092 362.7700n -0.001348 362.7800n -0.001575 362.7900n -0.001768 362.8000n -0.001922 362.8100n -0.002036 362.8200n -0.002107 362.8300n -0.002134 362.8400n -0.002117
+ 362.8500n -0.002057 362.8600n -0.001954 362.8700n -0.001813 362.8800n -0.001637 362.8900n -0.001429 362.9000n -0.001194 362.9100n -0.000938 362.9200n -0.000667 362.9300n -0.000385 362.9400n -0.000101 362.9500n 0.000181 362.9600n 0.000455 362.9700n 0.000715 362.9800n 0.000955 362.9900n 0.001172
+ 363.0000n 0.001360 363.0100n 0.001517 363.0200n 0.001641 363.0300n 0.001728 363.0400n 0.001779 363.0500n 0.001792 363.0600n 0.001770 363.0700n 0.001713 363.0800n 0.001623 363.0900n 0.001504 363.1000n 0.001359 363.1100n 0.001193 363.1200n 0.001009 363.1300n 0.000812 363.1400n 0.000608
+ 363.1500n 0.000402 363.1600n 0.000198 363.1700n 0.000001 363.1800n -0.000184 363.1900n -0.000353 363.2000n -0.000503 363.2100n -0.000630 363.2200n -0.000732 363.2300n -0.000808 363.2400n -0.000857 363.2500n -0.000877 363.2600n -0.000870 363.2700n -0.000837 363.2800n -0.000780 363.2900n -0.000701
+ 363.3000n -0.000603 363.3100n -0.000489 363.3200n -0.000364 363.3300n -0.000232 363.3400n -0.000096 363.3500n 0.000038 363.3600n 0.000167 363.3700n 0.000286 363.3800n 0.000391 363.3900n 0.000478 363.4000n 0.000546 363.4100n 0.000590 363.4200n 0.000608 363.4300n 0.000600 363.4400n 0.000565
+ 363.4500n 0.000501 363.4600n 0.000411 363.4700n 0.000295 363.4800n 0.000154 363.4900n -0.000008 363.5000n -0.000188 363.5100n -0.000385 363.5200n -0.000592 363.5300n -0.000807 363.5400n -0.001025 363.5500n -0.001242 363.5600n -0.001453 363.5700n -0.001654 363.5800n -0.001841 363.5900n -0.002010
+ 363.6000n -0.002157 363.6100n -0.002281 363.6200n -0.002377 363.6300n -0.002445 363.6400n -0.002482 363.6500n -0.002489 363.6600n -0.002464 363.6700n -0.002409 363.6800n -0.002325 363.6900n -0.002214 363.7000n -0.002077 363.7100n -0.001917 363.7200n -0.001738 363.7300n -0.001542 363.7400n -0.001335
+ 363.7500n -0.001118 363.7600n -0.000898 363.7700n -0.000676 363.7800n -0.000458 363.7900n -0.000247 363.8000n -0.000047 363.8100n 0.000140 363.8200n 0.000311 363.8300n 0.000463 363.8400n 0.000594 363.8500n 0.000704 363.8600n 0.000790 363.8700n 0.000853 363.8800n 0.000893 363.8900n 0.000910
+ 363.9000n 0.000905 363.9100n 0.000879 363.9200n 0.000835 363.9300n 0.000774 363.9400n 0.000699 363.9500n 0.000611 363.9600n 0.000513 363.9700n 0.000409 363.9800n 0.000299 363.9900n 0.000187 364.0000n 0.000074 364.0100n -0.000036 364.0200n -0.000144 364.0300n -0.000246 364.0400n -0.000342
+ 364.0500n -0.000432 364.0600n -0.000514 364.0700n -0.000589 364.0800n -0.000657 364.0900n -0.000718 364.1000n -0.000772 364.1100n -0.000822 364.1200n -0.000867 364.1300n -0.000909 364.1400n -0.000950 364.1500n -0.000990 364.1600n -0.001032 364.1700n -0.001075 364.1800n -0.001122 364.1900n -0.001172
+ 364.2000n -0.001227 364.2100n -0.001287 364.2200n -0.001352 364.2300n -0.001422 364.2400n -0.001495 364.2500n -0.001572 364.2600n -0.001652 364.2700n -0.001732 364.2800n -0.001811 364.2900n -0.001888 364.3000n -0.001959 364.3100n -0.002024 364.3200n -0.002080 364.3300n -0.002124 364.3400n -0.002155
+ 364.3500n -0.002171 364.3600n -0.002169 364.3700n -0.002149 364.3800n -0.002108 364.3900n -0.002046 364.4000n -0.001963 364.4100n -0.001858 364.4200n -0.001731 364.4300n -0.001584 364.4400n -0.001417 364.4500n -0.001231 364.4600n -0.001029 364.4700n -0.000814 364.4800n -0.000587 364.4900n -0.000352
+ 364.5000n -0.000112 364.5100n 0.000129 364.5200n 0.000369 364.5300n 0.000603 364.5400n 0.000828 364.5500n 0.001040 364.5600n 0.001237 364.5700n 0.001415 364.5800n 0.001572 364.5900n 0.001704 364.6000n 0.001811 364.6100n 0.001890 364.6200n 0.001940 364.6300n 0.001962 364.6400n 0.001954
+ 364.6500n 0.001917 364.6600n 0.001853 364.6700n 0.001762 364.6800n 0.001647 364.6900n 0.001509 364.7000n 0.001352 364.7100n 0.001178 364.7200n 0.000990 364.7300n 0.000792 364.7400n 0.000587 364.7500n 0.000378 364.7600n 0.000170 364.7700n -0.000035 364.7800n -0.000234 364.7900n -0.000423
+ 364.8000n -0.000600 364.8100n -0.000763 364.8200n -0.000909 364.8300n -0.001038 364.8400n -0.001147 364.8500n -0.001235 364.8600n -0.001304 364.8700n -0.001352 364.8800n -0.001381 364.8900n -0.001390 364.9000n -0.001382 364.9100n -0.001357 364.9200n -0.001317 364.9300n -0.001264 364.9400n -0.001200
+ 364.9500n -0.001127 364.9600n -0.001048 364.9700n -0.000964 364.9800n -0.000877 364.9900n -0.000789 365.0000n -0.000702 365.0100n -0.000617 365.0200n -0.000535 365.0300n -0.000458 365.0400n -0.000386 365.0500n -0.000320 365.0600n -0.000260 365.0700n -0.000205 365.0800n -0.000155 365.0900n -0.000110
+ 365.1000n -0.000069 365.1100n -0.000031 365.1200n 0.000005 365.1300n 0.000041 365.1400n 0.000077 365.1500n 0.000116 365.1600n 0.000157 365.1700n 0.000201 365.1800n 0.000251 365.1900n 0.000307 365.2000n 0.000368 365.2100n 0.000436 365.2200n 0.000510 365.2300n 0.000591 365.2400n 0.000677
+ 365.2500n 0.000769 365.2600n 0.000865 365.2700n 0.000964 365.2800n 0.001065 365.2900n 0.001166 365.3000n 0.001265 365.3100n 0.001361 365.3200n 0.001453 365.3300n 0.001538 365.3400n 0.001614 365.3500n 0.001680 365.3600n 0.001735 365.3700n 0.001777 365.3800n 0.001806 365.3900n 0.001819
+ 365.4000n 0.001817 365.4100n 0.001800 365.4200n 0.001766 365.4300n 0.001718 365.4400n 0.001655 365.4500n 0.001578 365.4600n 0.001488 365.4700n 0.001387 365.4800n 0.001277 365.4900n 0.001158 365.5000n 0.001034 365.5100n 0.000906 365.5200n 0.000777 365.5300n 0.000648 365.5400n 0.000521
+ 365.5500n 0.000399 365.5600n 0.000283 365.5700n 0.000175 365.5800n 0.000077 365.5900n -0.000012 365.6000n -0.000089 365.6100n -0.000155 365.6200n -0.000208 365.6300n -0.000250 365.6400n -0.000280 365.6500n -0.000299 365.6600n -0.000309 365.6700n -0.000310 365.6800n -0.000303 365.6900n -0.000291
+ 365.7000n -0.000275 365.7100n -0.000257 365.7200n -0.000239 365.7300n -0.000223 365.7400n -0.000211 365.7500n -0.000203 365.7600n -0.000202 365.7700n -0.000210 365.7800n -0.000226 365.7900n -0.000253 365.8000n -0.000291 365.8100n -0.000339 365.8200n -0.000398 365.8300n -0.000467 365.8400n -0.000546
+ 365.8500n -0.000634 365.8600n -0.000729 365.8700n -0.000830 365.8800n -0.000935 365.8900n -0.001042 365.9000n -0.001149 365.9100n -0.001254 365.9200n -0.001354 365.9300n -0.001449 365.9400n -0.001534 365.9500n -0.001610 365.9600n -0.001673 365.9700n -0.001723 365.9800n -0.001758 365.9900n -0.001777
+ 366.0000n -0.001779 366.0100n -0.001765 366.0200n -0.001734 366.0300n -0.001686 366.0400n -0.001623 366.0500n -0.001545 366.0600n -0.001454 366.0700n -0.001352 366.0800n -0.001240 366.0900n -0.001120 366.1000n -0.000995 366.1100n -0.000868 366.1200n -0.000739 366.1300n -0.000613 366.1400n -0.000491
+ 366.1500n -0.000375 366.1600n -0.000268 366.1700n -0.000170 366.1800n -0.000085 366.1900n -0.000012 366.2000n 0.000047 366.2100n 0.000093 366.2200n 0.000123 366.2300n 0.000140 366.2400n 0.000144 366.2500n 0.000135 366.2600n 0.000115 366.2700n 0.000086 366.2800n 0.000050 366.2900n 0.000008
+ 366.3000n -0.000036 366.3100n -0.000080 366.3200n -0.000121 366.3300n -0.000158 366.3400n -0.000186 366.3500n -0.000204 366.3600n -0.000210 366.3700n -0.000200 366.3800n -0.000174 366.3900n -0.000130 366.4000n -0.000066 366.4100n 0.000018 366.4200n 0.000124 366.4300n 0.000250 366.4400n 0.000396
+ 366.4500n 0.000562 366.4600n 0.000746 366.4700n 0.000947 366.4800n 0.001162 366.4900n 0.001389 366.5000n 0.001626 366.5100n 0.001869 366.5200n 0.002116 366.5300n 0.002363 366.5400n 0.002606 366.5500n 0.002844 366.5600n 0.003071 366.5700n 0.003285 366.5800n 0.003483 366.5900n 0.003663
+ 366.6000n 0.003820 366.6100n 0.003955 366.6200n 0.004063 366.6300n 0.004145 366.6400n 0.004199 366.6500n 0.004224 366.6600n 0.004220 366.6700n 0.004187 366.6800n 0.004127 366.6900n 0.004039 366.7000n 0.003926 366.7100n 0.003789 366.7200n 0.003630 366.7300n 0.003453 366.7400n 0.003258
+ 366.7500n 0.003050 366.7600n 0.002831 366.7700n 0.002604 366.7800n 0.002373 366.7900n 0.002139 366.8000n 0.001907 366.8100n 0.001679 366.8200n 0.001458 366.8300n 0.001245 366.8400n 0.001044 366.8500n 0.000857 366.8600n 0.000684 366.8700n 0.000528 366.8800n 0.000388 366.8900n 0.000267
+ 366.9000n 0.000165 366.9100n 0.000080 366.9200n 0.000014 366.9300n -0.000034 366.9400n -0.000066 366.9500n -0.000082 366.9600n -0.000084 366.9700n -0.000072 366.9800n -0.000050 366.9900n -0.000018 367.0000n 0.000022 367.0100n 0.000068 367.0200n 0.000118 367.0300n 0.000169 367.0400n 0.000221
+ 367.0500n 0.000272 367.0600n 0.000319 367.0700n 0.000361 367.0800n 0.000397 367.0900n 0.000426 367.1000n 0.000447 367.1100n 0.000458 367.1200n 0.000460 367.1300n 0.000451 367.1400n 0.000432 367.1500n 0.000402 367.1600n 0.000362 367.1700n 0.000312 367.1800n 0.000253 367.1900n 0.000184
+ 367.2000n 0.000108 367.2100n 0.000026 367.2200n -0.000063 367.2300n -0.000155 367.2400n -0.000251 367.2500n -0.000348 367.2600n -0.000445 367.2700n -0.000541 367.2800n -0.000633 367.2900n -0.000721 367.3000n -0.000802 367.3100n -0.000876 367.3200n -0.000941 367.3300n -0.000995 367.3400n -0.001037
+ 367.3500n -0.001066 367.3600n -0.001082 367.3700n -0.001083 367.3800n -0.001068 367.3900n -0.001038 367.4000n -0.000992 367.4100n -0.000930 367.4200n -0.000852 367.4300n -0.000759 367.4400n -0.000650 367.4500n -0.000528 367.4600n -0.000393 367.4700n -0.000246 367.4800n -0.000089 367.4900n 0.000077
+ 367.5000n 0.000249 367.5100n 0.000425 367.5200n 0.000604 367.5300n 0.000784 367.5400n 0.000960 367.5500n 0.001132 367.5600n 0.001297 367.5700n 0.001453 367.5800n 0.001597 367.5900n 0.001726 367.6000n 0.001840 367.6100n 0.001935 367.6200n 0.002011 367.6300n 0.002065 367.6400n 0.002096
+ 367.6500n 0.002105 367.6600n 0.002089 367.6700n 0.002048 367.6800n 0.001984 367.6900n 0.001895 367.7000n 0.001784 367.7100n 0.001651 367.7200n 0.001497 367.7300n 0.001325 367.7400n 0.001136 367.7500n 0.000933 367.7600n 0.000720 367.7700n 0.000497 367.7800n 0.000269 367.7900n 0.000039
+ 367.8000n -0.000190 367.8100n -0.000416 367.8200n -0.000634 367.8300n -0.000843 367.8400n -0.001038 367.8500n -0.001218 367.8600n -0.001380 367.8700n -0.001522 367.8800n -0.001642 367.8900n -0.001739 367.9000n -0.001811 367.9100n -0.001859 367.9200n -0.001882 367.9300n -0.001880 367.9400n -0.001854
+ 367.9500n -0.001805 367.9600n -0.001735 367.9700n -0.001644 367.9800n -0.001536 367.9900n -0.001413 368.0000n -0.001276 368.0100n -0.001130 368.0200n -0.000976 368.0300n -0.000817 368.0400n -0.000656 368.0500n -0.000497 368.0600n -0.000341 368.0700n -0.000191 368.0800n -0.000048 368.0900n 0.000084
+ 368.1000n 0.000205 368.1100n 0.000313 368.1200n 0.000408 368.1300n 0.000489 368.1400n 0.000557 368.1500n 0.000611 368.1600n 0.000653 368.1700n 0.000684 368.1800n 0.000705 368.1900n 0.000718 368.2000n 0.000725 368.2100n 0.000728 368.2200n 0.000730 368.2300n 0.000733 368.2400n 0.000740
+ 368.2500n 0.000752 368.2600n 0.000773 368.2700n 0.000804 368.2800n 0.000846 368.2900n 0.000903 368.3000n 0.000974 368.3100n 0.001060 368.3200n 0.001162 368.3300n 0.001280 368.3400n 0.001413 368.3500n 0.001559 368.3600n 0.001719 368.3700n 0.001889 368.3800n 0.002067 368.3900n 0.002251
+ 368.4000n 0.002438 368.4100n 0.002624 368.4200n 0.002805 368.4300n 0.002978 368.4400n 0.003140 368.4500n 0.003287 368.4600n 0.003415 368.4700n 0.003520 368.4800n 0.003600 368.4900n 0.003652 368.5000n 0.003673 368.5100n 0.003661 368.5200n 0.003614 368.5300n 0.003533 368.5400n 0.003415
+ 368.5500n 0.003262 368.5600n 0.003075 368.5700n 0.002854 368.5800n 0.002602 368.5900n 0.002321 368.6000n 0.002015 368.6100n 0.001687 368.6200n 0.001341 368.6300n 0.000981 368.6400n 0.000612 368.6500n 0.000238 368.6600n -0.000134 368.6700n -0.000500 368.6800n -0.000856 368.6900n -0.001197
+ 368.7000n -0.001517 368.7100n -0.001813 368.7200n -0.002080 368.7300n -0.002317 368.7400n -0.002518 368.7500n -0.002683 368.7600n -0.002810 368.7700n -0.002897 368.7800n -0.002943 368.7900n -0.002950 368.8000n -0.002918 368.8100n -0.002848 368.8200n -0.002742 368.8300n -0.002604 368.8400n -0.002435
+ 368.8500n -0.002240 368.8600n -0.002022 368.8700n -0.001785 368.8800n -0.001534 368.8900n -0.001273 368.9000n -0.001007 368.9100n -0.000739 368.9200n -0.000475 368.9300n -0.000219 368.9400n 0.000027 368.9500n 0.000258 368.9600n 0.000470 368.9700n 0.000663 368.9800n 0.000832 368.9900n 0.000977
+ 369.0000n 0.001097 369.0100n 0.001189 369.0200n 0.001256 369.0300n 0.001296 369.0400n 0.001310 369.0500n 0.001301 369.0600n 0.001268 369.0700n 0.001216 369.0800n 0.001145 369.0900n 0.001058 369.1000n 0.000959 369.1100n 0.000850 369.1200n 0.000734 369.1300n 0.000614 369.1400n 0.000493
+ 369.1500n 0.000373 369.1600n 0.000258 369.1700n 0.000150 369.1800n 0.000050 369.1900n -0.000039 369.2000n -0.000116 369.2100n -0.000179 369.2200n -0.000228 369.2300n -0.000262 369.2400n -0.000281 369.2500n -0.000286 369.2600n -0.000276 369.2700n -0.000253 369.2800n -0.000217 369.2900n -0.000171
+ 369.3000n -0.000114 369.3100n -0.000050 369.3200n 0.000021 369.3300n 0.000096 369.3400n 0.000175 369.3500n 0.000254 369.3600n 0.000332 369.3700n 0.000409 369.3800n 0.000481 369.3900n 0.000549 369.4000n 0.000610 369.4100n 0.000664 369.4200n 0.000710 369.4300n 0.000747 369.4400n 0.000776
+ 369.4500n 0.000796 369.4600n 0.000807 369.4700n 0.000809 369.4800n 0.000804 369.4900n 0.000791 369.5000n 0.000771 369.5100n 0.000746 369.5200n 0.000716 369.5300n 0.000682 369.5400n 0.000646 369.5500n 0.000608 369.5600n 0.000569 369.5700n 0.000530 369.5800n 0.000493 369.5900n 0.000459
+ 369.6000n 0.000427 369.6100n 0.000399 369.6200n 0.000375 369.6300n 0.000356 369.6400n 0.000341 369.6500n 0.000332 369.6600n 0.000328 369.6700n 0.000330 369.6800n 0.000336 369.6900n 0.000348 369.7000n 0.000363 369.7100n 0.000383 369.7200n 0.000407 369.7300n 0.000434 369.7400n 0.000464
+ 369.7500n 0.000496 369.7600n 0.000529 369.7700n 0.000564 369.7800n 0.000600 369.7900n 0.000635 369.8000n 0.000670 369.8100n 0.000705 369.8200n 0.000738 369.8300n 0.000770 369.8400n 0.000800 369.8500n 0.000827 369.8600n 0.000852 369.8700n 0.000874 369.8800n 0.000893 369.8900n 0.000908
+ 369.9000n 0.000920 369.9100n 0.000929 369.9200n 0.000933 369.9300n 0.000933 369.9400n 0.000928 369.9500n 0.000919 369.9600n 0.000906 369.9700n 0.000887 369.9800n 0.000863 369.9900n 0.000833 370.0000n 0.000799 370.0100n 0.000759 370.0200n 0.000713 370.0300n 0.000661 370.0400n 0.000605
+ 370.0500n 0.000543 370.0600n 0.000475 370.0700n 0.000403 370.0800n 0.000327 370.0900n 0.000246 370.1000n 0.000162 370.1100n 0.000076 370.1200n -0.000013 370.1300n -0.000103 370.1400n -0.000194 370.1500n -0.000284 370.1600n -0.000372 370.1700n -0.000458 370.1800n -0.000540 370.1900n -0.000618
+ 370.2000n -0.000689 370.2100n -0.000754 370.2200n -0.000811 370.2300n -0.000859 370.2400n -0.000897 370.2500n -0.000926 370.2600n -0.000943 370.2700n -0.000949 370.2800n -0.000943 370.2900n -0.000925 370.3000n -0.000896 370.3100n -0.000855 370.3200n -0.000802 370.3300n -0.000739 370.3400n -0.000666
+ 370.3500n -0.000583 370.3600n -0.000492 370.3700n -0.000395 370.3800n -0.000291 370.3900n -0.000183 370.4000n -0.000071 370.4100n 0.000042 370.4200n 0.000156 370.4300n 0.000268 370.4400n 0.000378 370.4500n 0.000484 370.4600n 0.000585 370.4700n 0.000680 370.4800n 0.000767 370.4900n 0.000846
+ 370.5000n 0.000915 370.5100n 0.000975 370.5200n 0.001024 370.5300n 0.001063 370.5400n 0.001092 370.5500n 0.001109 370.5600n 0.001116 370.5700n 0.001114 370.5800n 0.001101 370.5900n 0.001080 370.6000n 0.001051 370.6100n 0.001014 370.6200n 0.000971 370.6300n 0.000922 370.6400n 0.000868
+ 370.6500n 0.000811 370.6600n 0.000751 370.6700n 0.000690 370.6800n 0.000628 370.6900n 0.000565 370.7000n 0.000504 370.7100n 0.000444 370.7200n 0.000385 370.7300n 0.000330 370.7400n 0.000277 370.7500n 0.000226 370.7600n 0.000180 370.7700n 0.000136 370.7800n 0.000096 370.7900n 0.000059
+ 370.8000n 0.000025 370.8100n -0.000007 370.8200n -0.000035 370.8300n -0.000062 370.8400n -0.000086 370.8500n -0.000109 370.8600n -0.000130 370.8700n -0.000151 370.8800n -0.000170 370.8900n -0.000189 370.9000n -0.000208 370.9100n -0.000226 370.9200n -0.000245 370.9300n -0.000264 370.9400n -0.000283
+ 370.9500n -0.000302 370.9600n -0.000323 370.9700n -0.000343 370.9800n -0.000365 370.9900n -0.000387 371.0000n -0.000409 371.0100n -0.000433 371.0200n -0.000458 371.0300n -0.000484 371.0400n -0.000511 371.0500n -0.000540 371.0600n -0.000571 371.0700n -0.000603 371.0800n -0.000638 371.0900n -0.000676
+ 371.1000n -0.000716 371.1100n -0.000760 371.1200n -0.000807 371.1300n -0.000858 371.1400n -0.000913 371.1500n -0.000971 371.1600n -0.001033 371.1700n -0.001099 371.1800n -0.001169 371.1900n -0.001242 371.2000n -0.001317 371.2100n -0.001394 371.2200n -0.001473 371.2300n -0.001552 371.2400n -0.001631
+ 371.2500n -0.001708 371.2600n -0.001781 371.2700n -0.001850 371.2800n -0.001913 371.2900n -0.001969 371.3000n -0.002016 371.3100n -0.002052 371.3200n -0.002077 371.3300n -0.002088 371.3400n -0.002085 371.3500n -0.002066 371.3600n -0.002031 371.3700n -0.001978 371.3800n -0.001908 371.3900n -0.001820
+ 371.4000n -0.001714 371.4100n -0.001591 371.4200n -0.001452 371.4300n -0.001298 371.4400n -0.001129 371.4500n -0.000949 371.4600n -0.000758 371.4700n -0.000560 371.4800n -0.000357 371.4900n -0.000152 371.5000n 0.000052 371.5100n 0.000253 371.5200n 0.000447 371.5300n 0.000631 371.5400n 0.000802
+ 371.5500n 0.000957 371.5600n 0.001094 371.5700n 0.001209 371.5800n 0.001301 371.5900n 0.001368 371.6000n 0.001409 371.6100n 0.001422 371.6200n 0.001408 371.6300n 0.001366 371.6400n 0.001296 371.6500n 0.001201 371.6600n 0.001081 371.6700n 0.000939 371.6800n 0.000776 371.6900n 0.000598
+ 371.7000n 0.000405 371.7100n 0.000203 371.7200n -0.000005 371.7300n -0.000214 371.7400n -0.000421 371.7500n -0.000621 371.7600n -0.000809 371.7700n -0.000983 371.7800n -0.001138 371.7900n -0.001270 371.8000n -0.001376 371.8100n -0.001454 371.8200n -0.001502 371.8300n -0.001518 371.8400n -0.001500
+ 371.8500n -0.001449 371.8600n -0.001365 371.8700n -0.001249 371.8800n -0.001103 371.8900n -0.000928 371.9000n -0.000728 371.9100n -0.000506 371.9200n -0.000265 371.9300n -0.000011 371.9400n 0.000253 371.9500n 0.000522 371.9600n 0.000791 371.9700n 0.001055 371.9800n 0.001309 371.9900n 0.001548
+ 372.0000n 0.001768 372.0100n 0.001965 372.0200n 0.002136 372.0300n 0.002276 372.0400n 0.002384 372.0500n 0.002458 372.0600n 0.002496 372.0700n 0.002499 372.0800n 0.002465 372.0900n 0.002397 372.1000n 0.002295 372.1100n 0.002163 372.1200n 0.002002 372.1300n 0.001818 372.1400n 0.001613
+ 372.1500n 0.001392 372.1600n 0.001160 372.1700n 0.000922 372.1800n 0.000682 372.1900n 0.000447 372.2000n 0.000221 372.2100n 0.000009 372.2200n -0.000185 372.2300n -0.000356 372.2400n -0.000500 372.2500n -0.000616 372.2600n -0.000699 372.2700n -0.000749 372.2800n -0.000764 372.2900n -0.000745
+ 372.3000n -0.000690 372.3100n -0.000602 372.3200n -0.000482 372.3300n -0.000332 372.3400n -0.000157 372.3500n 0.000041 372.3600n 0.000258 372.3700n 0.000488 372.3800n 0.000728 372.3900n 0.000971 372.4000n 0.001214 372.4100n 0.001451 372.4200n 0.001677 372.4300n 0.001888 372.4400n 0.002079
+ 372.4500n 0.002246 372.4600n 0.002386 372.4700n 0.002496 372.4800n 0.002574 372.4900n 0.002619 372.5000n 0.002629 372.5100n 0.002605 372.5200n 0.002546 372.5300n 0.002455 372.5400n 0.002332 372.5500n 0.002182 372.5600n 0.002006 372.5700n 0.001808 372.5800n 0.001592 372.5900n 0.001362
+ 372.6000n 0.001122 372.6100n 0.000878 372.6200n 0.000633 372.6300n 0.000392 372.6400n 0.000160 372.6500n -0.000060 372.6600n -0.000264 372.6700n -0.000450 372.6800n -0.000613 372.6900n -0.000752 372.7000n -0.000865 372.7100n -0.000952 372.7200n -0.001011 372.7300n -0.001044 372.7400n -0.001050
+ 372.7500n -0.001032 372.7600n -0.000990 372.7700n -0.000927 372.7800n -0.000847 372.7900n -0.000751 372.8000n -0.000644 372.8100n -0.000529 372.8200n -0.000408 372.8300n -0.000287 372.8400n -0.000168 372.8500n -0.000054 372.8600n 0.000051 372.8700n 0.000145 372.8800n 0.000225 372.8900n 0.000289
+ 372.9000n 0.000336 372.9100n 0.000365 372.9200n 0.000376 372.9300n 0.000368 372.9400n 0.000341 372.9500n 0.000297 372.9600n 0.000238 372.9700n 0.000164 372.9800n 0.000079 372.9900n -0.000016 373.0000n -0.000118 373.0100n -0.000224 373.0200n -0.000332 373.0300n -0.000437 373.0400n -0.000539
+ 373.0500n -0.000633 373.0600n -0.000718 373.0700n -0.000790 373.0800n -0.000850 373.0900n -0.000894 373.1000n -0.000922 373.1100n -0.000932 373.1200n -0.000925 373.1300n -0.000901 373.1400n -0.000861 373.1500n -0.000804 373.1600n -0.000733 373.1700n -0.000649 373.1800n -0.000554 373.1900n -0.000450
+ 373.2000n -0.000340 373.2100n -0.000225 373.2200n -0.000109 373.2300n 0.000006 373.2400n 0.000118 373.2500n 0.000224 373.2600n 0.000323 373.2700n 0.000413 373.2800n 0.000491 373.2900n 0.000558 373.3000n 0.000611 373.3100n 0.000651 373.3200n 0.000677 373.3300n 0.000689 373.3400n 0.000689
+ 373.3500n 0.000677 373.3600n 0.000654 373.3700n 0.000621 373.3800n 0.000581 373.3900n 0.000536 373.4000n 0.000487 373.4100n 0.000436 373.4200n 0.000385 373.4300n 0.000337 373.4400n 0.000293 373.4500n 0.000256 373.4600n 0.000226 373.4700n 0.000205 373.4800n 0.000194 373.4900n 0.000194
+ 373.5000n 0.000204 373.5100n 0.000226 373.5200n 0.000258 373.5300n 0.000301 373.5400n 0.000353 373.5500n 0.000413 373.5600n 0.000480 373.5700n 0.000551 373.5800n 0.000626 373.5900n 0.000702 373.6000n 0.000777 373.6100n 0.000849 373.6200n 0.000916 373.6300n 0.000977 373.6400n 0.001030
+ 373.6500n 0.001074 373.6600n 0.001107 373.6700n 0.001128 373.6800n 0.001137 373.6900n 0.001133 373.7000n 0.001117 373.7100n 0.001089 373.7200n 0.001049 373.7300n 0.001000 373.7400n 0.000941 373.7500n 0.000876 373.7600n 0.000804 373.7700n 0.000729 373.7800n 0.000653 373.7900n 0.000577
+ 373.8000n 0.000504 373.8100n 0.000435 373.8200n 0.000373 373.8300n 0.000319 373.8400n 0.000274 373.8500n 0.000241 373.8600n 0.000219 373.8700n 0.000209 373.8800n 0.000212 373.8900n 0.000227 373.9000n 0.000254 373.9100n 0.000292 373.9200n 0.000338 373.9300n 0.000393 373.9400n 0.000453
+ 373.9500n 0.000517 373.9600n 0.000582 373.9700n 0.000646 373.9800n 0.000706 373.9900n 0.000760 374.0000n 0.000806 374.0100n 0.000840 374.0200n 0.000861 374.0300n 0.000866 374.0400n 0.000856 374.0500n 0.000827 374.0600n 0.000780 374.0700n 0.000713 374.0800n 0.000628 374.0900n 0.000525
+ 374.1000n 0.000404 374.1100n 0.000268 374.1200n 0.000119 374.1300n -0.000042 374.1400n -0.000212 374.1500n -0.000387 374.1600n -0.000565 374.1700n -0.000741 374.1800n -0.000913 374.1900n -0.001076 374.2000n -0.001228 374.2100n -0.001364 374.2200n -0.001483 374.2300n -0.001580 374.2400n -0.001654
+ 374.2500n -0.001702 374.2600n -0.001724 374.2700n -0.001717 374.2800n -0.001682 374.2900n -0.001619 374.3000n -0.001528 374.3100n -0.001410 374.3200n -0.001267 374.3300n -0.001102 374.3400n -0.000917 374.3500n -0.000716 374.3600n -0.000502 374.3700n -0.000278 374.3800n -0.000050 374.3900n 0.000180
+ 374.4000n 0.000407 374.4100n 0.000626 374.4200n 0.000834 374.4300n 0.001028 374.4400n 0.001203 374.4500n 0.001357 374.4600n 0.001488 374.4700n 0.001592 374.4800n 0.001670 374.4900n 0.001719 374.5000n 0.001740 374.5100n 0.001733 374.5200n 0.001698 374.5300n 0.001638 374.5400n 0.001554
+ 374.5500n 0.001448 374.5600n 0.001325 374.5700n 0.001186 374.5800n 0.001035 374.5900n 0.000876 374.6000n 0.000714 374.6100n 0.000552 374.6200n 0.000393 374.6300n 0.000241 374.6400n 0.000101 374.6500n -0.000026 374.6600n -0.000136 374.6700n -0.000227 374.6800n -0.000297 374.6900n -0.000345
+ 374.7000n -0.000370 374.7100n -0.000372 374.7200n -0.000352 374.7300n -0.000311 374.7400n -0.000249 374.7500n -0.000170 374.7600n -0.000075 374.7700n 0.000032 374.7800n 0.000149 374.7900n 0.000271 374.8000n 0.000396 374.8100n 0.000519 374.8200n 0.000638 374.8300n 0.000748 374.8400n 0.000846
+ 374.8500n 0.000929 374.8600n 0.000994 374.8700n 0.001038 374.8800n 0.001061 374.8900n 0.001060 374.9000n 0.001034 374.9100n 0.000984 374.9200n 0.000909 374.9300n 0.000809 374.9400n 0.000687 374.9500n 0.000544 374.9600n 0.000382 374.9700n 0.000203 374.9800n 0.000011 374.9900n -0.000191
+ 375.0000n -0.000399 375.0100n -0.000611 375.0200n -0.000823 375.0300n -0.001031 375.0400n -0.001232 375.0500n -0.001422 375.0600n -0.001599 375.0700n -0.001759 375.0800n -0.001902 375.0900n -0.002024 375.1000n -0.002124 375.1100n -0.002202 375.1200n -0.002257 375.1300n -0.002289 375.1400n -0.002298
+ 375.1500n -0.002286 375.1600n -0.002254 375.1700n -0.002204 375.1800n -0.002137 375.1900n -0.002056 375.2000n -0.001964 375.2100n -0.001863 375.2200n -0.001755 375.2300n -0.001644 375.2400n -0.001532 375.2500n -0.001421 375.2600n -0.001314 375.2700n -0.001212 375.2800n -0.001117 375.2900n -0.001031
+ 375.3000n -0.000954 375.3100n -0.000886 375.3200n -0.000829 375.3300n -0.000780 375.3400n -0.000741 375.3500n -0.000709 375.3600n -0.000683 375.3700n -0.000663 375.3800n -0.000644 375.3900n -0.000627 375.4000n -0.000608 375.4100n -0.000586 375.4200n -0.000557 375.4300n -0.000521 375.4400n -0.000476
+ 375.4500n -0.000418 375.4600n -0.000348 375.4700n -0.000265 375.4800n -0.000166 375.4900n -0.000053 375.5000n 0.000075 375.5100n 0.000217 375.5200n 0.000373 375.5300n 0.000541 375.5400n 0.000719 375.5500n 0.000905 375.5600n 0.001097 375.5700n 0.001292 375.5800n 0.001488 375.5900n 0.001681
+ 375.6000n 0.001868 375.6100n 0.002046 375.6200n 0.002213 375.6300n 0.002364 375.6400n 0.002499 375.6500n 0.002614 375.6600n 0.002708 375.6700n 0.002779 375.6800n 0.002825 375.6900n 0.002846 375.7000n 0.002843 375.7100n 0.002814 375.7200n 0.002761 375.7300n 0.002686 375.7400n 0.002590
+ 375.7500n 0.002474 375.7600n 0.002342 375.7700n 0.002197 375.7800n 0.002041 375.7900n 0.001879 375.8000n 0.001712 375.8100n 0.001546 375.8200n 0.001383 375.8300n 0.001226 375.8400n 0.001080 375.8500n 0.000946 375.8600n 0.000827 375.8700n 0.000725 375.8800n 0.000643 375.8900n 0.000581
+ 375.9000n 0.000540 375.9100n 0.000520 375.9200n 0.000522 375.9300n 0.000543 375.9400n 0.000584 375.9500n 0.000641 375.9600n 0.000714 375.9700n 0.000799 375.9800n 0.000893 375.9900n 0.000994 376.0000n 0.001098 376.0100n 0.001201 376.0200n 0.001300 376.0300n 0.001392 376.0400n 0.001474
+ 376.0500n 0.001542 376.0600n 0.001594 376.0700n 0.001628 376.0800n 0.001641 376.0900n 0.001633 376.1000n 0.001602 376.1100n 0.001548 376.1200n 0.001470 376.1300n 0.001371 376.1400n 0.001251 376.1500n 0.001111 376.1600n 0.000954 376.1700n 0.000783 376.1800n 0.000601 376.1900n 0.000410
+ 376.2000n 0.000215 376.2100n 0.000020 376.2200n -0.000172 376.2300n -0.000358 376.2400n -0.000532 376.2500n -0.000692 376.2600n -0.000834 376.2700n -0.000955 376.2800n -0.001053 376.2900n -0.001125 376.3000n -0.001169 376.3100n -0.001184 376.3200n -0.001171 376.3300n -0.001127 376.3400n -0.001055
+ 376.3500n -0.000955 376.3600n -0.000828 376.3700n -0.000677 376.3800n -0.000504 376.3900n -0.000313 376.4000n -0.000106 376.4100n 0.000113 376.4200n 0.000340 376.4300n 0.000571 376.4400n 0.000802 376.4500n 0.001028 376.4600n 0.001247 376.4700n 0.001455 376.4800n 0.001647 376.4900n 0.001821
+ 376.5000n 0.001975 376.5100n 0.002105 376.5200n 0.002210 376.5300n 0.002288 376.5400n 0.002340 376.5500n 0.002364 376.5600n 0.002360 376.5700n 0.002331 376.5800n 0.002276 376.5900n 0.002198 376.6000n 0.002099 376.6100n 0.001982 376.6200n 0.001849 376.6300n 0.001703 376.6400n 0.001549
+ 376.6500n 0.001389 376.6600n 0.001227 376.6700n 0.001066 376.6800n 0.000911 376.6900n 0.000764 376.7000n 0.000629 376.7100n 0.000507 376.7200n 0.000403 376.7300n 0.000318 376.7400n 0.000253 376.7500n 0.000211 376.7600n 0.000192 376.7700n 0.000196 376.7800n 0.000224 376.7900n 0.000275
+ 376.8000n 0.000348 376.8100n 0.000442 376.8200n 0.000556 376.8300n 0.000686 376.8400n 0.000832 376.8500n 0.000991 376.8600n 0.001159 376.8700n 0.001334 376.8800n 0.001512 376.8900n 0.001692 376.9000n 0.001870 376.9100n 0.002043 376.9200n 0.002207 376.9300n 0.002362 376.9400n 0.002502
+ 376.9500n 0.002628 376.9600n 0.002736 376.9700n 0.002825 376.9800n 0.002893 376.9900n 0.002940 377.0000n 0.002964 377.0100n 0.002964 377.0200n 0.002942 377.0300n 0.002896 377.0400n 0.002827 377.0500n 0.002737 377.0600n 0.002625 377.0700n 0.002494 377.0800n 0.002345 377.0900n 0.002179
+ 377.1000n 0.001998 377.1100n 0.001805 377.1200n 0.001601 377.1300n 0.001388 377.1400n 0.001170 377.1500n 0.000948 377.1600n 0.000724 377.1700n 0.000502 377.1800n 0.000283 377.1900n 0.000069 377.2000n -0.000137 377.2100n -0.000334 377.2200n -0.000519 377.2300n -0.000690 377.2400n -0.000847
+ 377.2500n -0.000986 377.2600n -0.001108 377.2700n -0.001211 377.2800n -0.001293 377.2900n -0.001355 377.3000n -0.001396 377.3100n -0.001415 377.3200n -0.001412 377.3300n -0.001388 377.3400n -0.001343 377.3500n -0.001277 377.3600n -0.001192 377.3700n -0.001088 377.3800n -0.000967 377.3900n -0.000831
+ 377.4000n -0.000680 377.4100n -0.000518 377.4200n -0.000346 377.4300n -0.000166 377.4400n 0.000019 377.4500n 0.000207 377.4600n 0.000395 377.4700n 0.000581 377.4800n 0.000762 377.4900n 0.000934 377.5000n 0.001097 377.5100n 0.001247 377.5200n 0.001382 377.5300n 0.001500 377.5400n 0.001599
+ 377.5500n 0.001677 377.5600n 0.001733 377.5700n 0.001765 377.5800n 0.001773 377.5900n 0.001755 377.6000n 0.001713 377.6100n 0.001645 377.6200n 0.001553 377.6300n 0.001437 377.6400n 0.001299 377.6500n 0.001139 377.6600n 0.000961 377.6700n 0.000766 377.6800n 0.000556 377.6900n 0.000334
+ 377.7000n 0.000104 377.7100n -0.000133 377.7200n -0.000372 377.7300n -0.000611 377.7400n -0.000847 377.7500n -0.001076 377.7600n -0.001296 377.7700n -0.001503 377.7800n -0.001696 377.7900n -0.001871 377.8000n -0.002026 377.8100n -0.002160 377.8200n -0.002271 377.8300n -0.002359 377.8400n -0.002421
+ 377.8500n -0.002458 377.8600n -0.002469 377.8700n -0.002456 377.8800n -0.002418 377.8900n -0.002356 377.9000n -0.002273 377.9100n -0.002169 377.9200n -0.002047 377.9300n -0.001908 377.9400n -0.001755 377.9500n -0.001589 377.9600n -0.001415 377.9700n -0.001232 377.9800n -0.001046 377.9900n -0.000856
+ 378.0000n -0.000666 378.0100n -0.000479 378.0200n -0.000294 378.0300n -0.000115 378.0400n 0.000057 378.0500n 0.000220 378.0600n 0.000375 378.0700n 0.000521 378.0800n 0.000656 378.0900n 0.000781 378.1000n 0.000895 378.1100n 0.000999 378.1200n 0.001094 378.1300n 0.001180 378.1400n 0.001257
+ 378.1500n 0.001327 378.1600n 0.001390 378.1700n 0.001447 378.1800n 0.001499 378.1900n 0.001546 378.2000n 0.001591 378.2100n 0.001632 378.2200n 0.001671 378.2300n 0.001708 378.2400n 0.001743 378.2500n 0.001775 378.2600n 0.001806 378.2700n 0.001833 378.2800n 0.001858 378.2900n 0.001878
+ 378.3000n 0.001894 378.3100n 0.001904 378.3200n 0.001907 378.3300n 0.001902 378.3400n 0.001888 378.3500n 0.001864 378.3600n 0.001829 378.3700n 0.001782 378.3800n 0.001722 378.3900n 0.001648 378.4000n 0.001561 378.4100n 0.001459 378.4200n 0.001343 378.4300n 0.001213 378.4400n 0.001070
+ 378.4500n 0.000914 378.4600n 0.000747 378.4700n 0.000569 378.4800n 0.000383 378.4900n 0.000189 378.5000n -0.000010 378.5100n -0.000212 378.5200n -0.000414 378.5300n -0.000615 378.5400n -0.000813 378.5500n -0.001005 378.5600n -0.001188 378.5700n -0.001361 378.5800n -0.001522 378.5900n -0.001669
+ 378.6000n -0.001800 378.6100n -0.001914 378.6200n -0.002010 378.6300n -0.002088 378.6400n -0.002145 378.6500n -0.002184 378.6600n -0.002203 378.6700n -0.002203 378.6800n -0.002186 378.6900n -0.002151 378.7000n -0.002100 378.7100n -0.002036 378.7200n -0.001959 378.7300n -0.001871 378.7400n -0.001774
+ 378.7500n -0.001671 378.7600n -0.001563 378.7700n -0.001453 378.7800n -0.001342 378.7900n -0.001232 378.8000n -0.001124 378.8100n -0.001021 378.8200n -0.000923 378.8300n -0.000832 378.8400n -0.000748 378.8500n -0.000672 378.8600n -0.000604 378.8700n -0.000544 378.8800n -0.000492 378.8900n -0.000448
+ 378.9000n -0.000410 378.9100n -0.000378 378.9200n -0.000351 378.9300n -0.000328 378.9400n -0.000307 378.9500n -0.000288 378.9600n -0.000269 378.9700n -0.000250 378.9800n -0.000228 378.9900n -0.000204 379.0000n -0.000175 379.0100n -0.000143 379.0200n -0.000106 379.0300n -0.000063 379.0400n -0.000016
+ 379.0500n 0.000036 379.0600n 0.000092 379.0700n 0.000152 379.0800n 0.000215 379.0900n 0.000279 379.1000n 0.000344 379.1100n 0.000408 379.1200n 0.000470 379.1300n 0.000528 379.1400n 0.000581 379.1500n 0.000628 379.1600n 0.000667 379.1700n 0.000696 379.1800n 0.000716 379.1900n 0.000725
+ 379.2000n 0.000722 379.2100n 0.000707 379.2200n 0.000680 379.2300n 0.000642 379.2400n 0.000591 379.2500n 0.000530 379.2600n 0.000458 379.2700n 0.000378 379.2800n 0.000291 379.2900n 0.000197 379.3000n 0.000100 379.3100n 0.000001 379.3200n -0.000098 379.3300n -0.000195 379.3400n -0.000288
+ 379.3500n -0.000375 379.3600n -0.000454 379.3700n -0.000523 379.3800n -0.000581 379.3900n -0.000626 379.4000n -0.000657 379.4100n -0.000674 379.4200n -0.000676 379.4300n -0.000662 379.4400n -0.000633 379.4500n -0.000590 379.4600n -0.000533 379.4700n -0.000462 379.4800n -0.000381 379.4900n -0.000289
+ 379.5000n -0.000189 379.5100n -0.000083 379.5200n 0.000027 379.5300n 0.000139 379.5400n 0.000251 379.5500n 0.000360 379.5600n 0.000465 379.5700n 0.000563 379.5800n 0.000653 379.5900n 0.000733 379.6000n 0.000802 379.6100n 0.000859 379.6200n 0.000903 379.6300n 0.000933 379.6400n 0.000950
+ 379.6500n 0.000953 379.6600n 0.000944 379.6700n 0.000922 379.6800n 0.000890 379.6900n 0.000848 379.7000n 0.000797 379.7100n 0.000741 379.7200n 0.000680 379.7300n 0.000617 379.7400n 0.000553 379.7500n 0.000491 379.7600n 0.000432 379.7700n 0.000379 379.7800n 0.000332 379.7900n 0.000295
+ 379.8000n 0.000267 379.8100n 0.000249 379.8200n 0.000243 379.8300n 0.000249 379.8400n 0.000267 379.8500n 0.000297 379.8600n 0.000338 379.8700n 0.000389 379.8800n 0.000449 379.8900n 0.000518 379.9000n 0.000593 379.9100n 0.000672 379.9200n 0.000755 379.9300n 0.000839 379.9400n 0.000922
+ 379.9500n 0.001002 379.9600n 0.001077 379.9700n 0.001146 379.9800n 0.001207 379.9900n 0.001258 380.0000n 0.001299 380.0100n 0.001329 380.0200n 0.001346 380.0300n 0.001351 380.0400n 0.001343 380.0500n 0.001322 380.0600n 0.001290 380.0700n 0.001247 380.0800n 0.001193 380.0900n 0.001130
+ 380.1000n 0.001060 380.1100n 0.000984 380.1200n 0.000903 380.1300n 0.000820 380.1400n 0.000736 380.1500n 0.000652 380.1600n 0.000570 380.1700n 0.000492 380.1800n 0.000420 380.1900n 0.000353 380.2000n 0.000293 380.2100n 0.000240 380.2200n 0.000195 380.2300n 0.000159 380.2400n 0.000130
+ 380.2500n 0.000108 380.2600n 0.000093 380.2700n 0.000083 380.2800n 0.000078 380.2900n 0.000076 380.3000n 0.000076 380.3100n 0.000076 380.3200n 0.000075 380.3300n 0.000071 380.3400n 0.000063 380.3500n 0.000050 380.3600n 0.000029 380.3700n 0.000000 380.3800n -0.000037 380.3900n -0.000083
+ 380.4000n -0.000139 380.4100n -0.000204 380.4200n -0.000278 380.4300n -0.000361 380.4400n -0.000450 380.4500n -0.000546 380.4600n -0.000647 380.4700n -0.000751 380.4800n -0.000855 380.4900n -0.000958 380.5000n -0.001058 380.5100n -0.001153 380.5200n -0.001240 380.5300n -0.001317 380.5400n -0.001382
+ 380.5500n -0.001433 380.5600n -0.001469 380.5700n -0.001489 380.5800n -0.001491 380.5900n -0.001475 380.6000n -0.001440 380.6100n -0.001388 380.6200n -0.001317 380.6300n -0.001230 380.6400n -0.001127 380.6500n -0.001011 380.6600n -0.000883 380.6700n -0.000746 380.6800n -0.000602 380.6900n -0.000455
+ 380.7000n -0.000306 380.7100n -0.000160 380.7200n -0.000019 380.7300n 0.000115 380.7400n 0.000237 380.7500n 0.000346 380.7600n 0.000438 380.7700n 0.000513 380.7800n 0.000569 380.7900n 0.000603 380.8000n 0.000616 380.8100n 0.000607 380.8200n 0.000577 380.8300n 0.000525 380.8400n 0.000453
+ 380.8500n 0.000363 380.8600n 0.000257 380.8700n 0.000137 380.8800n 0.000005 380.8900n -0.000134 380.9000n -0.000278 380.9100n -0.000424 380.9200n -0.000568 380.9300n -0.000706 380.9400n -0.000836 380.9500n -0.000953 380.9600n -0.001056 380.9700n -0.001141 380.9800n -0.001206 380.9900n -0.001249
+ 381.0000n -0.001270 381.0100n -0.001267 381.0200n -0.001239 381.0300n -0.001188 381.0400n -0.001114 381.0500n -0.001018 381.0600n -0.000902 381.0700n -0.000769 381.0800n -0.000620 381.0900n -0.000460 381.1000n -0.000291 381.1100n -0.000118 381.1200n 0.000057 381.1300n 0.000230 381.1400n 0.000396
+ 381.1500n 0.000553 381.1600n 0.000696 381.1700n 0.000823 381.1800n 0.000931 381.1900n 0.001017 381.2000n 0.001081 381.2100n 0.001119 381.2200n 0.001133 381.2300n 0.001121 381.2400n 0.001083 381.2500n 0.001022 381.2600n 0.000938 381.2700n 0.000833 381.2800n 0.000710 381.2900n 0.000573
+ 381.3000n 0.000423 381.3100n 0.000266 381.3200n 0.000104 381.3300n -0.000058 381.3400n -0.000216 381.3500n -0.000366 381.3600n -0.000504 381.3700n -0.000627 381.3800n -0.000731 381.3900n -0.000813 381.4000n -0.000872 381.4100n -0.000904 381.4200n -0.000909 381.4300n -0.000885 381.4400n -0.000833
+ 381.4500n -0.000753 381.4600n -0.000645 381.4700n -0.000512 381.4800n -0.000355 381.4900n -0.000177 381.5000n 0.000018 381.5100n 0.000228 381.5200n 0.000448 381.5300n 0.000674 381.5400n 0.000903 381.5500n 0.001129 381.5600n 0.001350 381.5700n 0.001560 381.5800n 0.001756 381.5900n 0.001934
+ 381.6000n 0.002091 381.6100n 0.002224 381.6200n 0.002332 381.6300n 0.002412 381.6400n 0.002463 381.6500n 0.002484 381.6600n 0.002477 381.6700n 0.002440 381.6800n 0.002376 381.6900n 0.002287 381.7000n 0.002174 381.7100n 0.002040 381.7200n 0.001888 381.7300n 0.001722 381.7400n 0.001546
+ 381.7500n 0.001362 381.7600n 0.001175 381.7700n 0.000989 381.7800n 0.000807 381.7900n 0.000633 381.8000n 0.000470 381.8100n 0.000321 381.8200n 0.000188 381.8300n 0.000073 381.8400n -0.000021 381.8500n -0.000095 381.8600n -0.000147 381.8700n -0.000178 381.8800n -0.000188 381.8900n -0.000178
+ 381.9000n -0.000150 381.9100n -0.000105 381.9200n -0.000047 381.9300n 0.000023 381.9400n 0.000101 381.9500n 0.000185 381.9600n 0.000270 381.9700n 0.000355 381.9800n 0.000436 381.9900n 0.000510 382.0000n 0.000574 382.0100n 0.000627 382.0200n 0.000664 382.0300n 0.000686 382.0400n 0.000691
+ 382.0500n 0.000678 382.0600n 0.000646 382.0700n 0.000596 382.0800n 0.000528 382.0900n 0.000444 382.1000n 0.000345 382.1100n 0.000233 382.1200n 0.000111 382.1300n -0.000020 382.1400n -0.000155 382.1500n -0.000292 382.1600n -0.000428 382.1700n -0.000560 382.1800n -0.000684 382.1900n -0.000798
+ 382.2000n -0.000898 382.2100n -0.000983 382.2200n -0.001049 382.2300n -0.001095 382.2400n -0.001119 382.2500n -0.001121 382.2600n -0.001101 382.2700n -0.001057 382.2800n -0.000991 382.2900n -0.000903 382.3000n -0.000795 382.3100n -0.000670 382.3200n -0.000529 382.3300n -0.000374 382.3400n -0.000210
+ 382.3500n -0.000039 382.3600n 0.000135 382.3700n 0.000309 382.3800n 0.000480 382.3900n 0.000643 382.4000n 0.000796 382.4100n 0.000934 382.4200n 0.001056 382.4300n 0.001159 382.4400n 0.001240 382.4500n 0.001298 382.4600n 0.001330 382.4700n 0.001337 382.4800n 0.001318 382.4900n 0.001272
+ 382.5000n 0.001201 382.5100n 0.001105 382.5200n 0.000985 382.5300n 0.000845 382.5400n 0.000686 382.5500n 0.000510 382.5600n 0.000321 382.5700n 0.000122 382.5800n -0.000085 382.5900n -0.000294 382.6000n -0.000504 382.6100n -0.000711 382.6200n -0.000910 382.6300n -0.001100 382.6400n -0.001277
+ 382.6500n -0.001438 382.6600n -0.001581 382.6700n -0.001704 382.6800n -0.001805 382.6900n -0.001882 382.7000n -0.001935 382.7100n -0.001963 382.7200n -0.001965 382.7300n -0.001943 382.7400n -0.001896 382.7500n -0.001825 382.7600n -0.001732 382.7700n -0.001618 382.7800n -0.001485 382.7900n -0.001334
+ 382.8000n -0.001168 382.8100n -0.000989 382.8200n -0.000799 382.8300n -0.000601 382.8400n -0.000396 382.8500n -0.000188 382.8600n 0.000021 382.8700n 0.000231 382.8800n 0.000437 382.8900n 0.000639 382.9000n 0.000836 382.9100n 0.001024 382.9200n 0.001204 382.9300n 0.001373 382.9400n 0.001531
+ 382.9500n 0.001678 382.9600n 0.001811 382.9700n 0.001932 382.9800n 0.002038 382.9900n 0.002131 383.0000n 0.002210 383.0100n 0.002275 383.0200n 0.002325 383.0300n 0.002362 383.0400n 0.002384 383.0500n 0.002392 383.0600n 0.002387 383.0700n 0.002368 383.0800n 0.002335 383.0900n 0.002289
+ 383.1000n 0.002230 383.1100n 0.002158 383.1200n 0.002073 383.1300n 0.001976 383.1400n 0.001867 383.1500n 0.001746 383.1600n 0.001614 383.1700n 0.001472 383.1800n 0.001320 383.1900n 0.001159 383.2000n 0.000990 383.2100n 0.000814 383.2200n 0.000632 383.2300n 0.000446 383.2400n 0.000256
+ 383.2500n 0.000065 383.2600n -0.000127 383.2700n -0.000316 383.2800n -0.000502 383.2900n -0.000683 383.3000n -0.000856 383.3100n -0.001020 383.3200n -0.001172 383.3300n -0.001312 383.3400n -0.001438 383.3500n -0.001546 383.3600n -0.001638 383.3700n -0.001710 383.3800n -0.001761 383.3900n -0.001792
+ 383.4000n -0.001801 383.4100n -0.001789 383.4200n -0.001754 383.4300n -0.001697 383.4400n -0.001619 383.4500n -0.001521 383.4600n -0.001403 383.4700n -0.001267 383.4800n -0.001115 383.4900n -0.000949 383.5000n -0.000771 383.5100n -0.000583 383.5200n -0.000387 383.5300n -0.000188 383.5400n 0.000014
+ 383.5500n 0.000215 383.5600n 0.000411 383.5700n 0.000602 383.5800n 0.000783 383.5900n 0.000952 383.6000n 0.001107 383.6100n 0.001245 383.6200n 0.001365 383.6300n 0.001465 383.6400n 0.001543 383.6500n 0.001598 383.6600n 0.001629 383.6700n 0.001635 383.6800n 0.001617 383.6900n 0.001574
+ 383.7000n 0.001507 383.7100n 0.001416 383.7200n 0.001303 383.7300n 0.001168 383.7400n 0.001014 383.7500n 0.000842 383.7600n 0.000654 383.7700n 0.000453 383.7800n 0.000240 383.7900n 0.000019 383.8000n -0.000209 383.8100n -0.000441 383.8200n -0.000673 383.8300n -0.000904 383.8400n -0.001130
+ 383.8500n -0.001350 383.8600n -0.001560 383.8700n -0.001759 383.8800n -0.001944 383.8900n -0.002113 383.9000n -0.002265 383.9100n -0.002397 383.9200n -0.002509 383.9300n -0.002599 383.9400n -0.002666 383.9500n -0.002709 383.9600n -0.002728 383.9700n -0.002723 383.9800n -0.002693 383.9900n -0.002638
+ 384.0000n -0.002560 384.0100n -0.002458 384.0200n -0.002334 384.0300n -0.002189 384.0400n -0.002023 384.0500n -0.001838 384.0600n -0.001637 384.0700n -0.001420 384.0800n -0.001189 384.0900n -0.000948 384.1000n -0.000697 384.1100n -0.000439 384.1200n -0.000178 384.1300n 0.000086 384.1400n 0.000350
+ 384.1500n 0.000610 384.1600n 0.000865 384.1700n 0.001112 384.1800n 0.001349 384.1900n 0.001573 384.2000n 0.001782 384.2100n 0.001974 384.2200n 0.002147 384.2300n 0.002300 384.2400n 0.002431 384.2500n 0.002538 384.2600n 0.002620 384.2700n 0.002678 384.2800n 0.002709 384.2900n 0.002715
+ 384.3000n 0.002694 384.3100n 0.002648 384.3200n 0.002577 384.3300n 0.002482 384.3400n 0.002364 384.3500n 0.002225 384.3600n 0.002067 384.3700n 0.001891 384.3800n 0.001701 384.3900n 0.001497 384.4000n 0.001283 384.4100n 0.001062 384.4200n 0.000836 384.4300n 0.000608 384.4400n 0.000380
+ 384.4500n 0.000156 384.4600n -0.000063 384.4700n -0.000273 384.4800n -0.000472 384.4900n -0.000659 384.5000n -0.000832 384.5100n -0.000988 384.5200n -0.001128 384.5300n -0.001249 384.5400n -0.001352 384.5500n -0.001436 384.5600n -0.001501 384.5700n -0.001547 384.5800n -0.001576 384.5900n -0.001589
+ 384.6000n -0.001586 384.6100n -0.001570 384.6200n -0.001542 384.6300n -0.001504 384.6400n -0.001458 384.6500n -0.001407 384.6600n -0.001352 384.6700n -0.001297 384.6800n -0.001243 384.6900n -0.001193 384.7000n -0.001148 384.7100n -0.001111 384.7200n -0.001083 384.7300n -0.001065 384.7400n -0.001059
+ 384.7500n -0.001066 384.7600n -0.001085 384.7700n -0.001119 384.7800n -0.001165 384.7900n -0.001225 384.8000n -0.001296 384.8100n -0.001379 384.8200n -0.001472 384.8300n -0.001574 384.8400n -0.001682 384.8500n -0.001795 384.8600n -0.001911 384.8700n -0.002028 384.8800n -0.002143 384.8900n -0.002255
+ 384.9000n -0.002360 384.9100n -0.002458 384.9200n -0.002546 384.9300n -0.002622 384.9400n -0.002684 384.9500n -0.002732 384.9600n -0.002763 384.9700n -0.002778 384.9800n -0.002775 384.9900n -0.002754 385.0000n -0.002715 385.0100n -0.002658 385.0200n -0.002584 385.0300n -0.002494 385.0400n -0.002387
+ 385.0500n -0.002267 385.0600n -0.002133 385.0700n -0.001988 385.0800n -0.001834 385.0900n -0.001672 385.1000n -0.001504 385.1100n -0.001332 385.1200n -0.001158 385.1300n -0.000984 385.1400n -0.000812 385.1500n -0.000644 385.1600n -0.000481 385.1700n -0.000325 385.1800n -0.000178 385.1900n -0.000040
+ 385.2000n 0.000088 385.2100n 0.000204 385.2200n 0.000309 385.2300n 0.000400 385.2400n 0.000479 385.2500n 0.000544 385.2600n 0.000597 385.2700n 0.000636 385.2800n 0.000663 385.2900n 0.000677 385.3000n 0.000680 385.3100n 0.000671 385.3200n 0.000651 385.3300n 0.000621 385.3400n 0.000582
+ 385.3500n 0.000534 385.3600n 0.000478 385.3700n 0.000415 385.3800n 0.000346 385.3900n 0.000271 385.4000n 0.000190 385.4100n 0.000106 385.4200n 0.000018 385.4300n -0.000074 385.4400n -0.000167 385.4500n -0.000262 385.4600n -0.000358 385.4700n -0.000453 385.4800n -0.000548 385.4900n -0.000642
+ 385.5000n -0.000734 385.5100n -0.000823 385.5200n -0.000908 385.5300n -0.000988 385.5400n -0.001064 385.5500n -0.001133 385.5600n -0.001195 385.5700n -0.001250 385.5800n -0.001296 385.5900n -0.001334 385.6000n -0.001361 385.6100n -0.001379 385.6200n -0.001387 385.6300n -0.001384 385.6400n -0.001370
+ 385.6500n -0.001345 385.6600n -0.001310 385.6700n -0.001265 385.6800n -0.001211 385.6900n -0.001148 385.7000n -0.001077 385.7100n -0.000999 385.7200n -0.000915 385.7300n -0.000828 385.7400n -0.000738 385.7500n -0.000647 385.7600n -0.000556 385.7700n -0.000468 385.7800n -0.000383 385.7900n -0.000304
+ 385.8000n -0.000232 385.8100n -0.000169 385.8200n -0.000116 385.8300n -0.000073 385.8400n -0.000042 385.8500n -0.000024 385.8600n -0.000018 385.8700n -0.000025 385.8800n -0.000045 385.8900n -0.000077 385.9000n -0.000120 385.9100n -0.000173 385.9200n -0.000235 385.9300n -0.000303 385.9400n -0.000377
+ 385.9500n -0.000453 385.9600n -0.000529 385.9700n -0.000603 385.9800n -0.000673 385.9900n -0.000735 386.0000n -0.000788 386.0100n -0.000829 386.0200n -0.000855 386.0300n -0.000865 386.0400n -0.000857 386.0500n -0.000830 386.0600n -0.000782 386.0700n -0.000713 386.0800n -0.000623 386.0900n -0.000512
+ 386.1000n -0.000381 386.1100n -0.000231 386.1200n -0.000063 386.1300n 0.000119 386.1400n 0.000315 386.1500n 0.000519 386.1600n 0.000731 386.1700n 0.000945 386.1800n 0.001158 386.1900n 0.001367 386.2000n 0.001566 386.2100n 0.001753 386.2200n 0.001924 386.2300n 0.002075 386.2400n 0.002202
+ 386.2500n 0.002302 386.2600n 0.002374 386.2700n 0.002414 386.2800n 0.002421 386.2900n 0.002394 386.3000n 0.002332 386.3100n 0.002236 386.3200n 0.002106 386.3300n 0.001943 386.3400n 0.001751 386.3500n 0.001530 386.3600n 0.001285 386.3700n 0.001019 386.3800n 0.000736 386.3900n 0.000440
+ 386.4000n 0.000136 386.4100n -0.000170 386.4200n -0.000475 386.4300n -0.000773 386.4400n -0.001060 386.4500n -0.001331 386.4600n -0.001581 386.4700n -0.001807 386.4800n -0.002005 386.4900n -0.002172 386.5000n -0.002307 386.5100n -0.002407 386.5200n -0.002471 386.5300n -0.002500 386.5400n -0.002493
+ 386.5500n -0.002451 386.5600n -0.002376 386.5700n -0.002271 386.5800n -0.002139 386.5900n -0.001982 386.6000n -0.001804 386.6100n -0.001611 386.6200n -0.001406 386.6300n -0.001193 386.6400n -0.000978 386.6500n -0.000765 386.6600n -0.000558 386.6700n -0.000361 386.6800n -0.000179 386.6900n -0.000015
+ 386.7000n 0.000128 386.7100n 0.000249 386.7200n 0.000344 386.7300n 0.000414 386.7400n 0.000457 386.7500n 0.000474 386.7600n 0.000465 386.7700n 0.000433 386.7800n 0.000378 386.7900n 0.000304 386.8000n 0.000214 386.8100n 0.000111 386.8200n -0.000001 386.8300n -0.000119 386.8400n -0.000238
+ 386.8500n -0.000354 386.8600n -0.000464 386.8700n -0.000563 386.8800n -0.000648 386.8900n -0.000717 386.9000n -0.000766 386.9100n -0.000793 386.9200n -0.000798 386.9300n -0.000779 386.9400n -0.000736 386.9500n -0.000669 386.9600n -0.000580 386.9700n -0.000471 386.9800n -0.000344 386.9900n -0.000201
+ 387.0000n -0.000047 387.0100n 0.000115 387.0200n 0.000281 387.0300n 0.000447 387.0400n 0.000606 387.0500n 0.000757 387.0600n 0.000893 387.0700n 0.001011 387.0800n 0.001106 387.0900n 0.001176 387.1000n 0.001217 387.1100n 0.001228 387.1200n 0.001205 387.1300n 0.001148 387.1400n 0.001058
+ 387.1500n 0.000933 387.1600n 0.000777 387.1700n 0.000590 387.1800n 0.000375 387.1900n 0.000136 387.2000n -0.000123 387.2100n -0.000398 387.2200n -0.000684 387.2300n -0.000975 387.2400n -0.001266 387.2500n -0.001550 387.2600n -0.001823 387.2700n -0.002079 387.2800n -0.002312 387.2900n -0.002518
+ 387.3000n -0.002692 387.3100n -0.002829 387.3200n -0.002928 387.3300n -0.002985 387.3400n -0.002999 387.3500n -0.002969 387.3600n -0.002894 387.3700n -0.002776 387.3800n -0.002617 387.3900n -0.002418 387.4000n -0.002184 387.4100n -0.001919 387.4200n -0.001626 387.4300n -0.001313 387.4400n -0.000983
+ 387.4500n -0.000643 387.4600n -0.000300 387.4700n 0.000040 387.4800n 0.000372 387.4900n 0.000689 387.5000n 0.000985 387.5100n 0.001255 387.5200n 0.001495 387.5300n 0.001700 387.5400n 0.001867 387.5500n 0.001993 387.5600n 0.002078 387.5700n 0.002119 387.5800n 0.002117 387.5900n 0.002073
+ 387.6000n 0.001988 387.6100n 0.001866 387.6200n 0.001709 387.6300n 0.001523 387.6400n 0.001310 387.6500n 0.001078 387.6600n 0.000830 387.6700n 0.000574 387.6800n 0.000314 387.6900n 0.000058 387.7000n -0.000189 387.7100n -0.000422 387.7200n -0.000635 387.7300n -0.000823 387.7400n -0.000982
+ 387.7500n -0.001108 387.7600n -0.001198 387.7700n -0.001250 387.7800n -0.001263 387.7900n -0.001236 387.8000n -0.001170 387.8100n -0.001065 387.8200n -0.000923 387.8300n -0.000748 387.8400n -0.000542 387.8500n -0.000310 387.8600n -0.000055 387.8700n 0.000217 387.8800n 0.000500 387.8900n 0.000790
+ 387.9000n 0.001082 387.9100n 0.001369 387.9200n 0.001646 387.9300n 0.001908 387.9400n 0.002151 387.9500n 0.002369 387.9600n 0.002560 387.9700n 0.002720 387.9800n 0.002846 387.9900n 0.002937 388.0000n 0.002991 388.0100n 0.003009 388.0200n 0.002989 388.0300n 0.002934 388.0400n 0.002844
+ 388.0500n 0.002722 388.0600n 0.002572 388.0700n 0.002395 388.0800n 0.002197 388.0900n 0.001980 388.1000n 0.001749 388.1100n 0.001509 388.1200n 0.001264 388.1300n 0.001018 388.1400n 0.000776 388.1500n 0.000541 388.1600n 0.000318 388.1700n 0.000109 388.1800n -0.000083 388.1900n -0.000254
+ 388.2000n -0.000404 388.2100n -0.000530 388.2200n -0.000633 388.2300n -0.000711 388.2400n -0.000765 388.2500n -0.000796 388.2600n -0.000804 388.2700n -0.000792 388.2800n -0.000762 388.2900n -0.000716 388.3000n -0.000656 388.3100n -0.000585 388.3200n -0.000506 388.3300n -0.000423 388.3400n -0.000337
+ 388.3500n -0.000252 388.3600n -0.000171 388.3700n -0.000095 388.3800n -0.000027 388.3900n 0.000031 388.4000n 0.000077 388.4100n 0.000111 388.4200n 0.000131 388.4300n 0.000138 388.4400n 0.000130 388.4500n 0.000109 388.4600n 0.000074 388.4700n 0.000027 388.4800n -0.000032 388.4900n -0.000100
+ 388.5000n -0.000177 388.5100n -0.000261 388.5200n -0.000350 388.5300n -0.000442 388.5400n -0.000535 388.5500n -0.000628 388.5600n -0.000719 388.5700n -0.000807 388.5800n -0.000889 388.5900n -0.000966 388.6000n -0.001035 388.6100n -0.001096 388.6200n -0.001149 388.6300n -0.001193 388.6400n -0.001227
+ 388.6500n -0.001253 388.6600n -0.001270 388.6700n -0.001278 388.6800n -0.001279 388.6900n -0.001272 388.7000n -0.001259 388.7100n -0.001240 388.7200n -0.001215 388.7300n -0.001187 388.7400n -0.001155 388.7500n -0.001120 388.7600n -0.001083 388.7700n -0.001044 388.7800n -0.001003 388.7900n -0.000962
+ 388.8000n -0.000920 388.8100n -0.000876 388.8200n -0.000832 388.8300n -0.000787 388.8400n -0.000741 388.8500n -0.000693 388.8600n -0.000643 388.8700n -0.000592 388.8800n -0.000537 388.8900n -0.000480 388.9000n -0.000421 388.9100n -0.000358 388.9200n -0.000292 388.9300n -0.000223 388.9400n -0.000151
+ 388.9500n -0.000077 388.9600n -0.000001 388.9700n 0.000076 388.9800n 0.000153 388.9900n 0.000231 389.0000n 0.000306 389.0100n 0.000379 389.0200n 0.000448 389.0300n 0.000512 389.0400n 0.000570 389.0500n 0.000620 389.0600n 0.000661 389.0700n 0.000693 389.0800n 0.000714 389.0900n 0.000723
+ 389.1000n 0.000720 389.1100n 0.000705 389.1200n 0.000677 389.1300n 0.000637 389.1400n 0.000584 389.1500n 0.000519 389.1600n 0.000444 389.1700n 0.000358 389.1800n 0.000264 389.1900n 0.000163 389.2000n 0.000057 389.2100n -0.000053 389.2200n -0.000164 389.2300n -0.000275 389.2400n -0.000383
+ 389.2500n -0.000486 389.2600n -0.000583 389.2700n -0.000672 389.2800n -0.000750 389.2900n -0.000817 389.3000n -0.000870 389.3100n -0.000910 389.3200n -0.000934 389.3300n -0.000944 389.3400n -0.000938 389.3500n -0.000917 389.3600n -0.000881 389.3700n -0.000831 389.3800n -0.000768 389.3900n -0.000695
+ 389.4000n -0.000612 389.4100n -0.000521 389.4200n -0.000424 389.4300n -0.000324 389.4400n -0.000222 389.4500n -0.000122 389.4600n -0.000024 389.4700n 0.000068 389.4800n 0.000153 389.4900n 0.000229 389.5000n 0.000294 389.5100n 0.000348 389.5200n 0.000389 389.5300n 0.000416 389.5400n 0.000430
+ 389.5500n 0.000430 389.5600n 0.000417 389.5700n 0.000391 389.5800n 0.000354 389.5900n 0.000308 389.6000n 0.000253 389.6100n 0.000192 389.6200n 0.000127 389.6300n 0.000060 389.6400n -0.000006 389.6500n -0.000069 389.6600n -0.000127 389.6700n -0.000177 389.6800n -0.000217 389.6900n -0.000245
+ 389.7000n -0.000259 389.7100n -0.000259 389.7200n -0.000242 389.7300n -0.000209 389.7400n -0.000158 389.7500n -0.000090 389.7600n -0.000005 389.7700n 0.000095 389.7800n 0.000210 389.7900n 0.000338 389.8000n 0.000476 389.8100n 0.000624 389.8200n 0.000777 389.8300n 0.000935 389.8400n 0.001092
+ 389.8500n 0.001247 389.8600n 0.001397 389.8700n 0.001539 389.8800n 0.001669 389.8900n 0.001786 389.9000n 0.001886 389.9100n 0.001968 389.9200n 0.002030 389.9300n 0.002071 389.9400n 0.002088 389.9500n 0.002083 389.9600n 0.002054 389.9700n 0.002002 389.9800n 0.001927 389.9900n 0.001832
+ 390.0000n 0.001716 390.0100n 0.001583 390.0200n 0.001434 390.0300n 0.001272 390.0400n 0.001100 390.0500n 0.000921 390.0600n 0.000738 390.0700n 0.000554 390.0800n 0.000372 390.0900n 0.000196 390.1000n 0.000027 390.1100n -0.000130 390.1200n -0.000274 390.1300n -0.000402 390.1400n -0.000513
+ 390.1500n -0.000605 390.1600n -0.000678 390.1700n -0.000729 390.1800n -0.000760 390.1900n -0.000770 390.2000n -0.000759 390.2100n -0.000730 390.2200n -0.000684 390.2300n -0.000621 390.2400n -0.000544 390.2500n -0.000456 390.2600n -0.000359 390.2700n -0.000255 390.2800n -0.000147 390.2900n -0.000038
+ 390.3000n 0.000070 390.3100n 0.000173 390.3200n 0.000269 390.3300n 0.000357 390.3400n 0.000433 390.3500n 0.000496 390.3600n 0.000545 390.3700n 0.000579 390.3800n 0.000595 390.3900n 0.000595 390.4000n 0.000577 390.4100n 0.000543 390.4200n 0.000491 390.4300n 0.000424 390.4400n 0.000343
+ 390.4500n 0.000248 390.4600n 0.000141 390.4700n 0.000024 390.4800n -0.000101 390.4900n -0.000231 390.5000n -0.000366 390.5100n -0.000502 390.5200n -0.000638 390.5300n -0.000772 390.5400n -0.000901 390.5500n -0.001025 390.5600n -0.001141 390.5700n -0.001248 390.5800n -0.001344 390.5900n -0.001429
+ 390.6000n -0.001503 390.6100n -0.001563 390.6200n -0.001611 390.6300n -0.001646 390.6400n -0.001668 390.6500n -0.001678 390.6600n -0.001676 390.6700n -0.001662 390.6800n -0.001638 390.6900n -0.001605 390.7000n -0.001564 390.7100n -0.001515 390.7200n -0.001461 390.7300n -0.001402 390.7400n -0.001339
+ 390.7500n -0.001274 390.7600n -0.001208 390.7700n -0.001142 390.7800n -0.001076 390.7900n -0.001013 390.8000n -0.000953 390.8100n -0.000896 390.8200n -0.000844 390.8300n -0.000797 390.8400n -0.000755 390.8500n -0.000720 390.8600n -0.000690 390.8700n -0.000668 390.8800n -0.000652 390.8900n -0.000643
+ 390.9000n -0.000641 390.9100n -0.000646 390.9200n -0.000658 390.9300n -0.000677 390.9400n -0.000702 390.9500n -0.000733 390.9600n -0.000771 390.9700n -0.000814 390.9800n -0.000862 390.9900n -0.000915 391.0000n -0.000972 391.0100n -0.001032 391.0200n -0.001095 391.0300n -0.001159 391.0400n -0.001225
+ 391.0500n -0.001290 391.0600n -0.001355 391.0700n -0.001417 391.0800n -0.001476 391.0900n -0.001530 391.1000n -0.001578 391.1100n -0.001619 391.1200n -0.001652 391.1300n -0.001676 391.1400n -0.001689 391.1500n -0.001690 391.1600n -0.001678 391.1700n -0.001653 391.1800n -0.001614 391.1900n -0.001560
+ 391.2000n -0.001491 391.2100n -0.001407 391.2200n -0.001308 391.2300n -0.001195 391.2400n -0.001069 391.2500n -0.000930 391.2600n -0.000780 391.2700n -0.000620 391.2800n -0.000453 391.2900n -0.000280 391.3000n -0.000103 391.3100n 0.000074 391.3200n 0.000249 391.3300n 0.000420 391.3400n 0.000583
+ 391.3500n 0.000735 391.3600n 0.000875 391.3700n 0.000999 391.3800n 0.001104 391.3900n 0.001189 391.4000n 0.001250 391.4100n 0.001287 391.4200n 0.001298 391.4300n 0.001282 391.4400n 0.001238 391.4500n 0.001166 391.4600n 0.001066 391.4700n 0.000940 391.4800n 0.000789 391.4900n 0.000614
+ 391.5000n 0.000418 391.5100n 0.000204 391.5200n -0.000025 391.5300n -0.000267 391.5400n -0.000516 391.5500n -0.000768 391.5600n -0.001021 391.5700n -0.001269 391.5800n -0.001508 391.5900n -0.001733 391.6000n -0.001941 391.6100n -0.002128 391.6200n -0.002290 391.6300n -0.002423 391.6400n -0.002526
+ 391.6500n -0.002596 391.6600n -0.002630 391.6700n -0.002629 391.6800n -0.002591 391.6900n -0.002517 391.7000n -0.002407 391.7100n -0.002263 391.7200n -0.002088 391.7300n -0.001882 391.7400n -0.001651 391.7500n -0.001397 391.7600n -0.001125 391.7700n -0.000839 391.7800n -0.000544 391.7900n -0.000244
+ 391.8000n 0.000054 391.8100n 0.000347 391.8200n 0.000628 391.8300n 0.000895 391.8400n 0.001141 391.8500n 0.001363 391.8600n 0.001557 391.8700n 0.001721 391.8800n 0.001851 391.8900n 0.001945 391.9000n 0.002003 391.9100n 0.002023 391.9200n 0.002006 391.9300n 0.001953 391.9400n 0.001864
+ 391.9500n 0.001741 391.9600n 0.001589 391.9700n 0.001408 391.9800n 0.001204 391.9900n 0.000979 392.0000n 0.000739 392.0100n 0.000487 392.0200n 0.000229 392.0300n -0.000031 392.0400n -0.000288 392.0500n -0.000539 392.0600n -0.000778 392.0700n -0.001001 392.0800n -0.001206 392.0900n -0.001389
+ 392.1000n -0.001547 392.1100n -0.001678 392.1200n -0.001782 392.1300n -0.001855 392.1400n -0.001900 392.1500n -0.001915 392.1600n -0.001901 392.1700n -0.001860 392.1800n -0.001793 392.1900n -0.001703 392.2000n -0.001592 392.2100n -0.001464 392.2200n -0.001320 392.2300n -0.001166 392.2400n -0.001003
+ 392.2500n -0.000835 392.2600n -0.000666 392.2700n -0.000499 392.2800n -0.000337 392.2900n -0.000182 392.3000n -0.000037 392.3100n 0.000096 392.3200n 0.000215 392.3300n 0.000320 392.3400n 0.000408 392.3500n 0.000481 392.3600n 0.000537 392.3700n 0.000578 392.3800n 0.000604 392.3900n 0.000616
+ 392.4000n 0.000615 392.4100n 0.000604 392.4200n 0.000583 392.4300n 0.000555 392.4400n 0.000523 392.4500n 0.000487 392.4600n 0.000450 392.4700n 0.000414 392.4800n 0.000380 392.4900n 0.000350 392.5000n 0.000325 392.5100n 0.000306 392.5200n 0.000294 392.5300n 0.000290 392.5400n 0.000292
+ 392.5500n 0.000302 392.5600n 0.000318 392.5700n 0.000340 392.5800n 0.000367 392.5900n 0.000397 392.6000n 0.000429 392.6100n 0.000461 392.6200n 0.000493 392.6300n 0.000521 392.6400n 0.000546 392.6500n 0.000565 392.6600n 0.000576 392.6700n 0.000579 392.6800n 0.000573 392.6900n 0.000557
+ 392.7000n 0.000530 392.7100n 0.000492 392.7200n 0.000444 392.7300n 0.000386 392.7400n 0.000318 392.7500n 0.000242 392.7600n 0.000159 392.7700n 0.000070 392.7800n -0.000023 392.7900n -0.000118 392.8000n -0.000213 392.8100n -0.000306 392.8200n -0.000395 392.8300n -0.000479 392.8400n -0.000556
+ 392.8500n -0.000623 392.8600n -0.000680 392.8700n -0.000726 392.8800n -0.000760 392.8900n -0.000781 392.9000n -0.000789 392.9100n -0.000784 392.9200n -0.000768 392.9300n -0.000741 392.9400n -0.000704 392.9500n -0.000659 392.9600n -0.000608 392.9700n -0.000554 392.9800n -0.000497 392.9900n -0.000442
+ 393.0000n -0.000390 393.0100n -0.000345 393.0200n -0.000308 393.0300n -0.000282 393.0400n -0.000270 393.0500n -0.000272 393.0600n -0.000292 393.0700n -0.000330 393.0800n -0.000387 393.0900n -0.000463 393.1000n -0.000560 393.1100n -0.000675 393.1200n -0.000809 393.1300n -0.000959 393.1400n -0.001124
+ 393.1500n -0.001302 393.1600n -0.001490 393.1700n -0.001685 393.1800n -0.001884 393.1900n -0.002082 393.2000n -0.002277 393.2100n -0.002464 393.2200n -0.002640 393.2300n -0.002801 393.2400n -0.002943 393.2500n -0.003064 393.2600n -0.003160 393.2700n -0.003229 393.2800n -0.003267 393.2900n -0.003275
+ 393.3000n -0.003250 393.3100n -0.003192 393.3200n -0.003101 393.3300n -0.002977 393.3400n -0.002822 393.3500n -0.002636 393.3600n -0.002423 393.3700n -0.002186 393.3800n -0.001926 393.3900n -0.001648 393.4000n -0.001356 393.4100n -0.001053 393.4200n -0.000745 393.4300n -0.000435 393.4400n -0.000127
+ 393.4500n 0.000173 393.4600n 0.000463 393.4700n 0.000737 393.4800n 0.000992 393.4900n 0.001226 393.5000n 0.001435 393.5100n 0.001617 393.5200n 0.001771 393.5300n 0.001894 393.5400n 0.001987 393.5500n 0.002049 393.5600n 0.002081 393.5700n 0.002083 393.5800n 0.002058 393.5900n 0.002006
+ 393.6000n 0.001931 393.6100n 0.001835 393.6200n 0.001722 393.6300n 0.001593 393.6400n 0.001454 393.6500n 0.001307 393.6600n 0.001156 393.6700n 0.001005 393.6800n 0.000857 393.6900n 0.000715 393.7000n 0.000582 393.7100n 0.000460 393.7200n 0.000353 393.7300n 0.000262 393.7400n 0.000189
+ 393.7500n 0.000135 393.7600n 0.000100 393.7700n 0.000085 393.7800n 0.000090 393.7900n 0.000114 393.8000n 0.000156 393.8100n 0.000216 393.8200n 0.000292 393.8300n 0.000381 393.8400n 0.000482 393.8500n 0.000593 393.8600n 0.000712 393.8700n 0.000835 393.8800n 0.000962 393.8900n 0.001089
+ 393.9000n 0.001214 393.9100n 0.001336 393.9200n 0.001452 393.9300n 0.001561 393.9400n 0.001660 393.9500n 0.001750 393.9600n 0.001827 393.9700n 0.001893 393.9800n 0.001946 393.9900n 0.001985 394.0000n 0.002011 394.0100n 0.002023 394.0200n 0.002022 394.0300n 0.002008 394.0400n 0.001981
+ 394.0500n 0.001943 394.0600n 0.001892 394.0700n 0.001831 394.0800n 0.001760 394.0900n 0.001680 394.1000n 0.001590 394.1100n 0.001492 394.1200n 0.001387 394.1300n 0.001274 394.1400n 0.001155 394.1500n 0.001029 394.1600n 0.000898 394.1700n 0.000761 394.1800n 0.000618 394.1900n 0.000471
+ 394.2000n 0.000319 394.2100n 0.000162 394.2200n 0.000002 394.2300n -0.000162 394.2400n -0.000329 394.2500n -0.000499 394.2600n -0.000670 394.2700n -0.000842 394.2800n -0.001013 394.2900n -0.001183 394.3000n -0.001350 394.3100n -0.001513 394.3200n -0.001671 394.3300n -0.001821 394.3400n -0.001962
+ 394.3500n -0.002093 394.3600n -0.002211 394.3700n -0.002315 394.3800n -0.002403 394.3900n -0.002474 394.4000n -0.002527 394.4100n -0.002560 394.4200n -0.002573 394.4300n -0.002564 394.4400n -0.002533 394.4500n -0.002481 394.4600n -0.002407 394.4700n -0.002312 394.4800n -0.002197 394.4900n -0.002064
+ 394.5000n -0.001913 394.5100n -0.001748 394.5200n -0.001569 394.5300n -0.001380 394.5400n -0.001184 394.5500n -0.000984 394.5600n -0.000782 394.5700n -0.000582 394.5800n -0.000388 394.5900n -0.000201 394.6000n -0.000027 394.6100n 0.000133 394.6200n 0.000276 394.6300n 0.000400 394.6400n 0.000501
+ 394.6500n 0.000579 394.6600n 0.000632 394.6700n 0.000658 394.6800n 0.000659 394.6900n 0.000633 394.7000n 0.000582 394.7100n 0.000505 394.7200n 0.000406 394.7300n 0.000285 394.7400n 0.000145 394.7500n -0.000012 394.7600n -0.000181 394.7700n -0.000361 394.7800n -0.000548 394.7900n -0.000737
+ 394.8000n -0.000926 394.8100n -0.001111 394.8200n -0.001289 394.8300n -0.001455 394.8400n -0.001607 394.8500n -0.001742 394.8600n -0.001858 394.8700n -0.001952 394.8800n -0.002023 394.8900n -0.002070 394.9000n -0.002092 394.9100n -0.002088 394.9200n -0.002060 394.9300n -0.002007 394.9400n -0.001932
+ 394.9500n -0.001836 394.9600n -0.001720 394.9700n -0.001588 394.9800n -0.001442 394.9900n -0.001286 395.0000n -0.001121 395.0100n -0.000953 395.0200n -0.000783 395.0300n -0.000615 395.0400n -0.000452 395.0500n -0.000298 395.0600n -0.000154 395.0700n -0.000024 395.0800n 0.000091 395.0900n 0.000189
+ 395.1000n 0.000269 395.1100n 0.000331 395.1200n 0.000372 395.1300n 0.000395 395.1400n 0.000398 395.1500n 0.000384 395.1600n 0.000353 395.1700n 0.000308 395.1800n 0.000250 395.1900n 0.000181 395.2000n 0.000103 395.2100n 0.000021 395.2200n -0.000065 395.2300n -0.000151 395.2400n -0.000235
+ 395.2500n -0.000314 395.2600n -0.000385 395.2700n -0.000448 395.2800n -0.000500 395.2900n -0.000539 395.3000n -0.000565 395.3100n -0.000576 395.3200n -0.000573 395.3300n -0.000555 395.3400n -0.000522 395.3500n -0.000476 395.3600n -0.000418 395.3700n -0.000348 395.3800n -0.000269 395.3900n -0.000182
+ 395.4000n -0.000091 395.4100n 0.000004 395.4200n 0.000100 395.4300n 0.000195 395.4400n 0.000285 395.4500n 0.000370 395.4600n 0.000447 395.4700n 0.000514 395.4800n 0.000570 395.4900n 0.000613 395.5000n 0.000642 395.5100n 0.000658 395.5200n 0.000659 395.5300n 0.000647 395.5400n 0.000620
+ 395.5500n 0.000580 395.5600n 0.000529 395.5700n 0.000467 395.5800n 0.000397 395.5900n 0.000320 395.6000n 0.000238 395.6100n 0.000154 395.6200n 0.000070 395.6300n -0.000012 395.6400n -0.000090 395.6500n -0.000161 395.6600n -0.000224 395.6700n -0.000277 395.6800n -0.000318 395.6900n -0.000345
+ 395.7000n -0.000359 395.7100n -0.000358 395.7200n -0.000343 395.7300n -0.000312 395.7400n -0.000268 395.7500n -0.000210 395.7600n -0.000139 395.7700n -0.000058 395.7800n 0.000033 395.7900n 0.000130 395.8000n 0.000233 395.8100n 0.000338 395.8200n 0.000444 395.8300n 0.000548 395.8400n 0.000648
+ 395.8500n 0.000741 395.8600n 0.000825 395.8700n 0.000899 395.8800n 0.000959 395.8900n 0.001006 395.9000n 0.001037 395.9100n 0.001052 395.9200n 0.001051 395.9300n 0.001032 395.9400n 0.000996 395.9500n 0.000944 395.9600n 0.000877 395.9700n 0.000795 395.9800n 0.000701 395.9900n 0.000596
+ 396.0000n 0.000481 396.0100n 0.000360 396.0200n 0.000235 396.0300n 0.000108 396.0400n -0.000019 396.0500n -0.000143 396.0600n -0.000261 396.0700n -0.000371 396.0800n -0.000470 396.0900n -0.000558 396.1000n -0.000631 396.1100n -0.000688 396.1200n -0.000728 396.1300n -0.000750 396.1400n -0.000753
+ 396.1500n -0.000737 396.1600n -0.000701 396.1700n -0.000646 396.1800n -0.000572 396.1900n -0.000480 396.2000n -0.000371 396.2100n -0.000247 396.2200n -0.000108 396.2300n 0.000043 396.2400n 0.000205 396.2500n 0.000375 396.2600n 0.000552 396.2700n 0.000734 396.2800n 0.000918 396.2900n 0.001102
+ 396.3000n 0.001286 396.3100n 0.001466 396.3200n 0.001641 396.3300n 0.001809 396.3400n 0.001969 396.3500n 0.002119 396.3600n 0.002259 396.3700n 0.002387 396.3800n 0.002503 396.3900n 0.002606 396.4000n 0.002694 396.4100n 0.002769 396.4200n 0.002830 396.4300n 0.002876 396.4400n 0.002908
+ 396.4500n 0.002926 396.4600n 0.002930 396.4700n 0.002921 396.4800n 0.002899 396.4900n 0.002863 396.5000n 0.002816 396.5100n 0.002757 396.5200n 0.002687 396.5300n 0.002607 396.5400n 0.002516 396.5500n 0.002417 396.5600n 0.002309 396.5700n 0.002192 396.5800n 0.002069 396.5900n 0.001939
+ 396.6000n 0.001804 396.6100n 0.001664 396.6200n 0.001520 396.6300n 0.001372 396.6400n 0.001223 396.6500n 0.001073 396.6600n 0.000923 396.6700n 0.000774 396.6800n 0.000627 396.6900n 0.000483 396.7000n 0.000344 396.7100n 0.000211 396.7200n 0.000085 396.7300n -0.000033 396.7400n -0.000142
+ 396.7500n -0.000241 396.7600n -0.000329 396.7700n -0.000405 396.7800n -0.000468 396.7900n -0.000518 396.8000n -0.000555 396.8100n -0.000578 396.8200n -0.000587 396.8300n -0.000583 396.8400n -0.000566 396.8500n -0.000536 396.8600n -0.000494 396.8700n -0.000441 396.8800n -0.000379 396.8900n -0.000308
+ 396.9000n -0.000230 396.9100n -0.000147 396.9200n -0.000060 396.9300n 0.000030 396.9400n 0.000119 396.9500n 0.000207 396.9600n 0.000291 396.9700n 0.000371 396.9800n 0.000444 396.9900n 0.000509 397.0000n 0.000565 397.0100n 0.000611 397.0200n 0.000645 397.0300n 0.000667 397.0400n 0.000677
+ 397.0500n 0.000673 397.0600n 0.000658 397.0700n 0.000629 397.0800n 0.000589 397.0900n 0.000537 397.1000n 0.000475 397.1100n 0.000403 397.1200n 0.000323 397.1300n 0.000237 397.1400n 0.000145 397.1500n 0.000050 397.1600n -0.000048 397.1700n -0.000146 397.1800n -0.000244 397.1900n -0.000339
+ 397.2000n -0.000432 397.2100n -0.000519 397.2200n -0.000601 397.2300n -0.000678 397.2400n -0.000747 397.2500n -0.000810 397.2600n -0.000865 397.2700n -0.000914 397.2800n -0.000956 397.2900n -0.000993 397.3000n -0.001024 397.3100n -0.001051 397.3200n -0.001075 397.3300n -0.001097 397.3400n -0.001119
+ 397.3500n -0.001141 397.3600n -0.001166 397.3700n -0.001194 397.3800n -0.001226 397.3900n -0.001263 397.4000n -0.001308 397.4100n -0.001359 397.4200n -0.001418 397.4300n -0.001484 397.4400n -0.001559 397.4500n -0.001642 397.4600n -0.001732 397.4700n -0.001829 397.4800n -0.001931 397.4900n -0.002038
+ 397.5000n -0.002147 397.5100n -0.002259 397.5200n -0.002370 397.5300n -0.002479 397.5400n -0.002584 397.5500n -0.002683 397.5600n -0.002775 397.5700n -0.002857 397.5800n -0.002928 397.5900n -0.002987 397.6000n -0.003031 397.6100n -0.003060 397.6200n -0.003074 397.6300n -0.003070 397.6400n -0.003051
+ 397.6500n -0.003014 397.6600n -0.002961 397.6700n -0.002893 397.6800n -0.002811 397.6900n -0.002715 397.7000n -0.002608 397.7100n -0.002491 397.7200n -0.002367 397.7300n -0.002238 397.7400n -0.002105 397.7500n -0.001972 397.7600n -0.001841 397.7700n -0.001715 397.7800n -0.001594 397.7900n -0.001483
+ 397.8000n -0.001382 397.8100n -0.001294 397.8200n -0.001219 397.8300n -0.001159 397.8400n -0.001115 397.8500n -0.001087 397.8600n -0.001075 397.8700n -0.001079 397.8800n -0.001098 397.8900n -0.001131 397.9000n -0.001177 397.9100n -0.001235 397.9200n -0.001301 397.9300n -0.001375 397.9400n -0.001453
+ 397.9500n -0.001534 397.9600n -0.001614 397.9700n -0.001692 397.9800n -0.001764 397.9900n -0.001829 398.0000n -0.001883 398.0100n -0.001926 398.0200n -0.001955 398.0300n -0.001969 398.0400n -0.001967 398.0500n -0.001947 398.0600n -0.001910 398.0700n -0.001855 398.0800n -0.001783 398.0900n -0.001694
+ 398.1000n -0.001589 398.1100n -0.001471 398.1200n -0.001340 398.1300n -0.001199 398.1400n -0.001050 398.1500n -0.000895 398.1600n -0.000737 398.1700n -0.000579 398.1800n -0.000423 398.1900n -0.000272 398.2000n -0.000128 398.2100n 0.000005 398.2200n 0.000127 398.2300n 0.000234 398.2400n 0.000326
+ 398.2500n 0.000400 398.2600n 0.000457 398.2700n 0.000494 398.2800n 0.000513 398.2900n 0.000512 398.3000n 0.000493 398.3100n 0.000457 398.3200n 0.000404 398.3300n 0.000336 398.3400n 0.000255 398.3500n 0.000163 398.3600n 0.000062 398.3700n -0.000045 398.3800n -0.000157 398.3900n -0.000270
+ 398.4000n -0.000383 398.4100n -0.000492 398.4200n -0.000596 398.4300n -0.000693 398.4400n -0.000780 398.4500n -0.000857 398.4600n -0.000921 398.4700n -0.000972 398.4800n -0.001008 398.4900n -0.001031 398.5000n -0.001039 398.5100n -0.001033 398.5200n -0.001013 398.5300n -0.000981 398.5400n -0.000938
+ 398.5500n -0.000884 398.5600n -0.000822 398.5700n -0.000753 398.5800n -0.000680 398.5900n -0.000604 398.6000n -0.000527 398.6100n -0.000452 398.6200n -0.000379 398.6300n -0.000312 398.6400n -0.000251 398.6500n -0.000198 398.6600n -0.000155 398.6700n -0.000122 398.6800n -0.000101 398.6900n -0.000091
+ 398.7000n -0.000093 398.7100n -0.000107 398.7200n -0.000133 398.7300n -0.000170 398.7400n -0.000217 398.7500n -0.000274 398.7600n -0.000338 398.7700n -0.000410 398.7800n -0.000486 398.7900n -0.000567 398.8000n -0.000649 398.8100n -0.000731 398.8200n -0.000813 398.8300n -0.000891 398.8400n -0.000965
+ 398.8500n -0.001034 398.8600n -0.001095 398.8700n -0.001148 398.8800n -0.001192 398.8900n -0.001227 398.9000n -0.001251 398.9100n -0.001265 398.9200n -0.001268 398.9300n -0.001260 398.9400n -0.001242 398.9500n -0.001215 398.9600n -0.001178 398.9700n -0.001132 398.9800n -0.001078 398.9900n -0.001018
+ 399.0000n -0.000952 399.0100n -0.000880 399.0200n -0.000805 399.0300n -0.000727 399.0400n -0.000647 399.0500n -0.000565 399.0600n -0.000484 399.0700n -0.000402 399.0800n -0.000322 399.0900n -0.000244 399.1000n -0.000167 399.1100n -0.000093 399.1200n -0.000022 399.1300n 0.000047 399.1400n 0.000113
+ 399.1500n 0.000175 399.1600n 0.000235 399.1700n 0.000292 399.1800n 0.000346 399.1900n 0.000397 399.2000n 0.000446 399.2100n 0.000493 399.2200n 0.000537 399.2300n 0.000579 399.2400n 0.000619 399.2500n 0.000656 399.2600n 0.000691 399.2700n 0.000722 399.2800n 0.000751 399.2900n 0.000777
+ 399.3000n 0.000799 399.3100n 0.000816 399.3200n 0.000830 399.3300n 0.000839 399.3400n 0.000842 399.3500n 0.000840 399.3600n 0.000832 399.3700n 0.000818 399.3800n 0.000798 399.3900n 0.000772 399.4000n 0.000739 399.4100n 0.000700 399.4200n 0.000656 399.4300n 0.000605 399.4400n 0.000550
+ 399.4500n 0.000491 399.4600n 0.000428 399.4700n 0.000362 399.4800n 0.000294 399.4900n 0.000225 399.5000n 0.000156 399.5100n 0.000089 399.5200n 0.000024 399.5300n -0.000038 399.5400n -0.000095 399.5500n -0.000147 399.5600n -0.000192 399.5700n -0.000231 399.5800n -0.000261 399.5900n -0.000284
+ 399.6000n -0.000298 399.6100n -0.000302 399.6200n -0.000299 399.6300n -0.000286 399.6400n -0.000265 399.6500n -0.000237 399.6600n -0.000201 399.6700n -0.000159 399.6800n -0.000112 399.6900n -0.000061 399.7000n -0.000006 399.7100n 0.000050 399.7200n 0.000106 399.7300n 0.000162 399.7400n 0.000216
+ 399.7500n 0.000267 399.7600n 0.000313 399.7700n 0.000355 399.7800n 0.000390 399.7900n 0.000419 399.8000n 0.000441 399.8100n 0.000455 399.8200n 0.000462 399.8300n 0.000461 399.8400n 0.000454 399.8500n 0.000441 399.8600n 0.000422 399.8700n 0.000398 399.8800n 0.000372 399.8900n 0.000342
+ 399.9000n 0.000313 399.9100n 0.000283 399.9200n 0.000256 399.9300n 0.000233 399.9400n 0.000214 399.9500n 0.000203 399.9600n 0.000199 399.9700n 0.000204 399.9800n 0.000219 399.9900n 0.000245 400.0000n 0.000282 400.0100n 0.000332 400.0200n 0.000394 400.0300n 0.000468 400.0400n 0.000553
+ 400.0500n 0.000650 400.0600n 0.000757 400.0700n 0.000873 400.0800n 0.000998 400.0900n 0.001129 400.1000n 0.001265 400.1100n 0.001404 400.1200n 0.001544 400.1300n 0.001684 400.1400n 0.001822 400.1500n 0.001955 400.1600n 0.002081 400.1700n 0.002200 400.1800n 0.002309 400.1900n 0.002407
+ 400.2000n 0.002492 400.2100n 0.002563 400.2200n 0.002620 400.2300n 0.002662 400.2400n 0.002687 400.2500n 0.002697 400.2600n 0.002691 400.2700n 0.002670 400.2800n 0.002634 400.2900n 0.002583 400.3000n 0.002520 400.3100n 0.002444 400.3200n 0.002358 400.3300n 0.002263 400.3400n 0.002161
+ 400.3500n 0.002052 400.3600n 0.001939 400.3700n 0.001824 400.3800n 0.001707 400.3900n 0.001591 400.4000n 0.001477 400.4100n 0.001366 400.4200n 0.001260 400.4300n 0.001159 400.4400n 0.001065 400.4500n 0.000979 400.4600n 0.000900 400.4700n 0.000829 400.4800n 0.000767 400.4900n 0.000713
+ 400.5000n 0.000668 400.5100n 0.000632 400.5200n 0.000603 400.5300n 0.000582 400.5400n 0.000567 400.5500n 0.000559 400.5600n 0.000557 400.5700n 0.000560 400.5800n 0.000566 400.5900n 0.000577 400.6000n 0.000590 400.6100n 0.000606 400.6200n 0.000623 400.6300n 0.000641 400.6400n 0.000659
+ 400.6500n 0.000677 400.6600n 0.000695 400.6700n 0.000712 400.6800n 0.000728 400.6900n 0.000742 400.7000n 0.000754 400.7100n 0.000765 400.7200n 0.000773 400.7300n 0.000779 400.7400n 0.000783 400.7500n 0.000784 400.7600n 0.000781 400.7700n 0.000776 400.7800n 0.000767 400.7900n 0.000755
+ 400.8000n 0.000739 400.8100n 0.000718 400.8200n 0.000693 400.8300n 0.000662 400.8400n 0.000627 400.8500n 0.000586 400.8600n 0.000539 400.8700n 0.000487 400.8800n 0.000428 400.8900n 0.000363 400.9000n 0.000291 400.9100n 0.000214 400.9200n 0.000130 400.9300n 0.000041 400.9400n -0.000054
+ 400.9500n -0.000153 400.9600n -0.000257 400.9700n -0.000363 400.9800n -0.000472 400.9900n -0.000583 401.0000n -0.000693 401.0100n -0.000802 401.0200n -0.000910 401.0300n -0.001013 401.0400n -0.001112 401.0500n -0.001205 401.0600n -0.001291 401.0700n -0.001368 401.0800n -0.001436 401.0900n -0.001494
+ 401.1000n -0.001541 401.1100n -0.001577 401.1200n -0.001601 401.1300n -0.001614 401.1400n -0.001614 401.1500n -0.001604 401.1600n -0.001583 401.1700n -0.001552 401.1800n -0.001512 401.1900n -0.001465 401.2000n -0.001412 401.2100n -0.001355 401.2200n -0.001296 401.2300n -0.001235 401.2400n -0.001176
+ 401.2500n -0.001119 401.2600n -0.001068 401.2700n -0.001023 401.2800n -0.000986 401.2900n -0.000960 401.3000n -0.000944 401.3100n -0.000940 401.3200n -0.000950 401.3300n -0.000972 401.3400n -0.001008 401.3500n -0.001058 401.3600n -0.001120 401.3700n -0.001195 401.3800n -0.001280 401.3900n -0.001375
+ 401.4000n -0.001477 401.4100n -0.001585 401.4200n -0.001697 401.4300n -0.001810 401.4400n -0.001922 401.4500n -0.002030 401.4600n -0.002132 401.4700n -0.002226 401.4800n -0.002308 401.4900n -0.002377 401.5000n -0.002432 401.5100n -0.002470 401.5200n -0.002489 401.5300n -0.002490 401.5400n -0.002471
+ 401.5500n -0.002433 401.5600n -0.002375 401.5700n -0.002298 401.5800n -0.002204 401.5900n -0.002093 401.6000n -0.001967 401.6100n -0.001830 401.6200n -0.001682 401.6300n -0.001527 401.6400n -0.001369 401.6500n -0.001208 401.6600n -0.001050 401.6700n -0.000897 401.6800n -0.000751 401.6900n -0.000616
+ 401.7000n -0.000494 401.7100n -0.000388 401.7200n -0.000299 401.7300n -0.000229 401.7400n -0.000180 401.7500n -0.000151 401.7600n -0.000143 401.7700n -0.000155 401.7800n -0.000187 401.7900n -0.000238 401.8000n -0.000305 401.8100n -0.000386 401.8200n -0.000479 401.8300n -0.000581 401.8400n -0.000688
+ 401.8500n -0.000797 401.8600n -0.000905 401.8700n -0.001008 401.8800n -0.001102 401.8900n -0.001185 401.9000n -0.001252 401.9100n -0.001302 401.9200n -0.001331 401.9300n -0.001338 401.9400n -0.001321 401.9500n -0.001279 401.9600n -0.001212 401.9700n -0.001119 401.9800n -0.001003 401.9900n -0.000863
+ 402.0000n -0.000703 402.0100n -0.000524 402.0200n -0.000330 402.0300n -0.000125 402.0400n 0.000089 402.0500n 0.000306 402.0600n 0.000522 402.0700n 0.000732 402.0800n 0.000933 402.0900n 0.001118 402.1000n 0.001285 402.1100n 0.001428 402.1200n 0.001545 402.1300n 0.001631 402.1400n 0.001684
+ 402.1500n 0.001702 402.1600n 0.001683 402.1700n 0.001627 402.1800n 0.001533 402.1900n 0.001402 402.2000n 0.001235 402.2100n 0.001034 402.2200n 0.000802 402.2300n 0.000543 402.2400n 0.000260 402.2500n -0.000042 402.2600n -0.000358 402.2700n -0.000683 402.2800n -0.001012 402.2900n -0.001339
+ 402.3000n -0.001658 402.3100n -0.001964 402.3200n -0.002252 402.3300n -0.002517 402.3400n -0.002755 402.3500n -0.002961 402.3600n -0.003132 402.3700n -0.003266 402.3800n -0.003361 402.3900n -0.003415 402.4000n -0.003428 402.4100n -0.003401 402.4200n -0.003335 402.4300n -0.003231 402.4400n -0.003092
+ 402.4500n -0.002922 402.4600n -0.002725 402.4700n -0.002504 402.4800n -0.002265 402.4900n -0.002013 402.5000n -0.001753 402.5100n -0.001491 402.5200n -0.001231 402.5300n -0.000980 402.5400n -0.000742 402.5500n -0.000521 402.5600n -0.000323 402.5700n -0.000150 402.5800n -0.000006 402.5900n 0.000106
+ 402.6000n 0.000186 402.6100n 0.000231 402.6200n 0.000242 402.6300n 0.000219 402.6400n 0.000164 402.6500n 0.000078 402.6600n -0.000037 402.6700n -0.000177 402.6800n -0.000339 402.6900n -0.000518 402.7000n -0.000711 402.7100n -0.000912 402.7200n -0.001118 402.7300n -0.001323 402.7400n -0.001523
+ 402.7500n -0.001714 402.7600n -0.001890 402.7700n -0.002049 402.7800n -0.002187 402.7900n -0.002301 402.8000n -0.002389 402.8100n -0.002449 402.8200n -0.002479 402.8300n -0.002481 402.8400n -0.002452 402.8500n -0.002396 402.8600n -0.002312 402.8700n -0.002203 402.8800n -0.002071 402.8900n -0.001919
+ 402.9000n -0.001750 402.9100n -0.001568 402.9200n -0.001377 402.9300n -0.001180 402.9400n -0.000982 402.9500n -0.000785 402.9600n -0.000594 402.9700n -0.000413 402.9800n -0.000243 402.9900n -0.000089 403.0000n 0.000048 403.0100n 0.000165 403.0200n 0.000262 403.0300n 0.000336 403.0400n 0.000389
+ 403.0500n 0.000419 403.0600n 0.000428 403.0700n 0.000416 403.0800n 0.000384 403.0900n 0.000336 403.1000n 0.000272 403.1100n 0.000195 403.1200n 0.000107 403.1300n 0.000012 403.1400n -0.000089 403.1500n -0.000192 403.1600n -0.000295 403.1700n -0.000396 403.1800n -0.000492 403.1900n -0.000581
+ 403.2000n -0.000662 403.2100n -0.000734 403.2200n -0.000796 403.2300n -0.000847 403.2400n -0.000886 403.2500n -0.000915 403.2600n -0.000934 403.2700n -0.000943 403.2800n -0.000944 403.2900n -0.000938 403.3000n -0.000928 403.3100n -0.000914 403.3200n -0.000898 403.3300n -0.000883 403.3400n -0.000870
+ 403.3500n -0.000862 403.3600n -0.000858 403.3700n -0.000862 403.3800n -0.000874 403.3900n -0.000895 403.4000n -0.000926 403.4100n -0.000966 403.4200n -0.001016 403.4300n -0.001075 403.4400n -0.001143 403.4500n -0.001218 403.4600n -0.001299 403.4700n -0.001384 403.4800n -0.001472 403.4900n -0.001560
+ 403.5000n -0.001645 403.5100n -0.001727 403.5200n -0.001802 403.5300n -0.001869 403.5400n -0.001925 403.5500n -0.001968 403.5600n -0.001997 403.5700n -0.002011 403.5800n -0.002007 403.5900n -0.001986 403.6000n -0.001947 403.6100n -0.001890 403.6200n -0.001815 403.6300n -0.001724 403.6400n -0.001616
+ 403.6500n -0.001495 403.6600n -0.001360 403.6700n -0.001216 403.6800n -0.001063 403.6900n -0.000904 403.7000n -0.000743 403.7100n -0.000580 403.7200n -0.000420 403.7300n -0.000265 403.7400n -0.000117 403.7500n 0.000022 403.7600n 0.000150 403.7700n 0.000264 403.7800n 0.000364 403.7900n 0.000449
+ 403.8000n 0.000517 403.8100n 0.000569 403.8200n 0.000605 403.8300n 0.000625 403.8400n 0.000630 403.8500n 0.000623 403.8600n 0.000603 403.8700n 0.000574 403.8800n 0.000538 403.8900n 0.000496 403.9000n 0.000452 403.9100n 0.000408 403.9200n 0.000366 403.9300n 0.000330 403.9400n 0.000301
+ 403.9500n 0.000281 403.9600n 0.000274 403.9700n 0.000280 403.9800n 0.000300 403.9900n 0.000336 404.0000n 0.000388 404.0100n 0.000457 404.0200n 0.000542 404.0300n 0.000643 404.0400n 0.000758 404.0500n 0.000886 404.0600n 0.001026 404.0700n 0.001175 404.0800n 0.001331 404.0900n 0.001491
+ 404.1000n 0.001653 404.1100n 0.001814 404.1200n 0.001972 404.1300n 0.002122 404.1400n 0.002264 404.1500n 0.002394 404.1600n 0.002510 404.1700n 0.002610 404.1800n 0.002693 404.1900n 0.002756 404.2000n 0.002799 404.2100n 0.002822 404.2200n 0.002823 404.2300n 0.002804 404.2400n 0.002765
+ 404.2500n 0.002707 404.2600n 0.002630 404.2700n 0.002537 404.2800n 0.002430 404.2900n 0.002309 404.3000n 0.002178 404.3100n 0.002040 404.3200n 0.001895 404.3300n 0.001747 404.3400n 0.001597 404.3500n 0.001448 404.3600n 0.001303 404.3700n 0.001162 404.3800n 0.001027 404.3900n 0.000899
+ 404.4000n 0.000780 404.4100n 0.000670 404.4200n 0.000569 404.4300n 0.000478 404.4400n 0.000396 404.4500n 0.000322 404.4600n 0.000255 404.4700n 0.000196 404.4800n 0.000141 404.4900n 0.000091 404.5000n 0.000043 404.5100n -0.000004 404.5200n -0.000052 404.5300n -0.000102 404.5400n -0.000154
+ 404.5500n -0.000212 404.5600n -0.000274 404.5700n -0.000343 404.5800n -0.000418 404.5900n -0.000500 404.6000n -0.000588 404.6100n -0.000683 404.6200n -0.000782 404.6300n -0.000887 404.6400n -0.000994 404.6500n -0.001103 404.6600n -0.001211 404.6700n -0.001317 404.6800n -0.001419 404.6900n -0.001515
+ 404.7000n -0.001603 404.7100n -0.001680 404.7200n -0.001744 404.7300n -0.001794 404.7400n -0.001829 404.7500n -0.001846 404.7600n -0.001844 404.7700n -0.001823 404.7800n -0.001783 404.7900n -0.001723 404.8000n -0.001644 404.8100n -0.001545 404.8200n -0.001429 404.8300n -0.001297 404.8400n -0.001150
+ 404.8500n -0.000990 404.8600n -0.000820 404.8700n -0.000642 404.8800n -0.000459 404.8900n -0.000273 404.9000n -0.000087 404.9100n 0.000096 404.9200n 0.000273 404.9300n 0.000441 404.9400n 0.000600 404.9500n 0.000745 404.9600n 0.000877 404.9700n 0.000992 404.9800n 0.001090 404.9900n 0.001171
+ 405.0000n 0.001233 405.0100n 0.001277 405.0200n 0.001303 405.0300n 0.001312 405.0400n 0.001305 405.0500n 0.001284 405.0600n 0.001250 405.0700n 0.001205 405.0800n 0.001151 405.0900n 0.001091 405.1000n 0.001027 405.1100n 0.000961 405.1200n 0.000896 405.1300n 0.000833 405.1400n 0.000775
+ 405.1500n 0.000724 405.1600n 0.000681 405.1700n 0.000647 405.1800n 0.000624 405.1900n 0.000612 405.2000n 0.000611 405.2100n 0.000622 405.2200n 0.000643 405.2300n 0.000674 405.2400n 0.000715 405.2500n 0.000762 405.2600n 0.000816 405.2700n 0.000874 405.2800n 0.000935 405.2900n 0.000995
+ 405.3000n 0.001054 405.3100n 0.001108 405.3200n 0.001156 405.3300n 0.001197 405.3400n 0.001228 405.3500n 0.001247 405.3600n 0.001255 405.3700n 0.001248 405.3800n 0.001228 405.3900n 0.001194 405.4000n 0.001146 405.4100n 0.001084 405.4200n 0.001009 405.4300n 0.000922 405.4400n 0.000825
+ 405.4500n 0.000719 405.4600n 0.000607 405.4700n 0.000489 405.4800n 0.000370 405.4900n 0.000250 405.5000n 0.000132 405.5100n 0.000019 405.5200n -0.000087 405.5300n -0.000185 405.5400n -0.000272 405.5500n -0.000346 405.5600n -0.000407 405.5700n -0.000454 405.5800n -0.000485 405.5900n -0.000500
+ 405.6000n -0.000499 405.6100n -0.000483 405.6200n -0.000453 405.6300n -0.000408 405.6400n -0.000352 405.6500n -0.000285 405.6600n -0.000209 405.6700n -0.000126 405.6800n -0.000039 405.6900n 0.000051 405.7000n 0.000141 405.7100n 0.000228 405.7200n 0.000312 405.7300n 0.000389 405.7400n 0.000458
+ 405.7500n 0.000518 405.7600n 0.000567 405.7700n 0.000604 405.7800n 0.000629 405.7900n 0.000641 405.8000n 0.000641 405.8100n 0.000628 405.8200n 0.000603 405.8300n 0.000568 405.8400n 0.000524 405.8500n 0.000472 405.8600n 0.000414 405.8700n 0.000351 405.8800n 0.000286 405.8900n 0.000221
+ 405.9000n 0.000158 405.9100n 0.000098 405.9200n 0.000043 405.9300n -0.000005 405.9400n -0.000044 405.9500n -0.000075 405.9600n -0.000095 405.9700n -0.000105 405.9800n -0.000105 405.9900n -0.000095 406.0000n -0.000074 406.0100n -0.000046 406.0200n -0.000010 406.0300n 0.000032 406.0400n 0.000078
+ 406.0500n 0.000125 406.0600n 0.000172 406.0700n 0.000216 406.0800n 0.000256 406.0900n 0.000287 406.1000n 0.000310 406.1100n 0.000320 406.1200n 0.000317 406.1300n 0.000298 406.1400n 0.000262 406.1500n 0.000209 406.1600n 0.000137 406.1700n 0.000047 406.1800n -0.000062 406.1900n -0.000188
+ 406.2000n -0.000331 406.2100n -0.000489 406.2200n -0.000661 406.2300n -0.000843 406.2400n -0.001034 406.2500n -0.001231 406.2600n -0.001430 406.2700n -0.001629 406.2800n -0.001824 406.2900n -0.002012 406.3000n -0.002190 406.3100n -0.002355 406.3200n -0.002504 406.3300n -0.002635 406.3400n -0.002746
+ 406.3500n -0.002834 406.3600n -0.002898 406.3700n -0.002939 406.3800n -0.002954 406.3900n -0.002945 406.4000n -0.002911 406.4100n -0.002855 406.4200n -0.002778 406.4300n -0.002681 406.4400n -0.002568 406.4500n -0.002441 406.4600n -0.002303 406.4700n -0.002158 406.4800n -0.002009 406.4900n -0.001859
+ 406.5000n -0.001713 406.5100n -0.001574 406.5200n -0.001445 406.5300n -0.001328 406.5400n -0.001228 406.5500n -0.001146 406.5600n -0.001085 406.5700n -0.001045 406.5800n -0.001028 406.5900n -0.001035 406.6000n -0.001065 406.6100n -0.001118 406.6200n -0.001194 406.6300n -0.001289 406.6400n -0.001403
+ 406.6500n -0.001533 406.6600n -0.001677 406.6700n -0.001830 406.6800n -0.001991 406.6900n -0.002154 406.7000n -0.002318 406.7100n -0.002479 406.7200n -0.002632 406.7300n -0.002775 406.7400n -0.002905 406.7500n -0.003019 406.7600n -0.003114 406.7700n -0.003189 406.7800n -0.003242 406.7900n -0.003272
+ 406.8000n -0.003278 406.8100n -0.003260 406.8200n -0.003219 406.8300n -0.003155 406.8400n -0.003070 406.8500n -0.002966 406.8600n -0.002845 406.8700n -0.002708 406.8800n -0.002560 406.8900n -0.002403 406.9000n -0.002239 406.9100n -0.002072 406.9200n -0.001906 406.9300n -0.001742 406.9400n -0.001584
+ 406.9500n -0.001434 406.9600n -0.001295 406.9700n -0.001169 406.9800n -0.001057 406.9900n -0.000960 407.0000n -0.000879 407.0100n -0.000814 407.0200n -0.000766 407.0300n -0.000733 407.0400n -0.000714 407.0500n -0.000708 407.0600n -0.000714 407.0700n -0.000729 407.0800n -0.000751 407.0900n -0.000777
+ 407.1000n -0.000805 407.1100n -0.000832 407.1200n -0.000856 407.1300n -0.000874 407.1400n -0.000883 407.1500n -0.000882 407.1600n -0.000869 407.1700n -0.000842 407.1800n -0.000800 407.1900n -0.000742 407.2000n -0.000669 407.2100n -0.000579 407.2200n -0.000474 407.2300n -0.000354 407.2400n -0.000222
+ 407.2500n -0.000078 407.2600n 0.000075 407.2700n 0.000234 407.2800n 0.000398 407.2900n 0.000562 407.3000n 0.000724 407.3100n 0.000881 407.3200n 0.001029 407.3300n 0.001167 407.3400n 0.001290 407.3500n 0.001396 407.3600n 0.001483 407.3700n 0.001548 407.3800n 0.001591 407.3900n 0.001609
+ 407.4000n 0.001601 407.4100n 0.001568 407.4200n 0.001509 407.4300n 0.001426 407.4400n 0.001317 407.4500n 0.001186 407.4600n 0.001034 407.4700n 0.000864 407.4800n 0.000676 407.4900n 0.000476 407.5000n 0.000264 407.5100n 0.000046 407.5200n -0.000177 407.5300n -0.000400 407.5400n -0.000622
+ 407.5500n -0.000837 407.5600n -0.001044 407.5700n -0.001240 407.5800n -0.001422 407.5900n -0.001588 407.6000n -0.001736 407.6100n -0.001864 407.6200n -0.001972 407.6300n -0.002058 407.6400n -0.002123 407.6500n -0.002166 407.6600n -0.002188 407.6700n -0.002189 407.6800n -0.002171 407.6900n -0.002135
+ 407.7000n -0.002083 407.7100n -0.002016 407.7200n -0.001936 407.7300n -0.001846 407.7400n -0.001747 407.7500n -0.001643 407.7600n -0.001533 407.7700n -0.001422 407.7800n -0.001310 407.7900n -0.001200 407.8000n -0.001092 407.8100n -0.000988 407.8200n -0.000889 407.8300n -0.000796 407.8400n -0.000709
+ 407.8500n -0.000628 407.8600n -0.000554 407.8700n -0.000486 407.8800n -0.000425 407.8900n -0.000368 407.9000n -0.000317 407.9100n -0.000269 407.9200n -0.000225 407.9300n -0.000182 407.9400n -0.000141 407.9500n -0.000101 407.9600n -0.000060 407.9700n -0.000018 407.9800n 0.000025 407.9900n 0.000070
+ 408.0000n 0.000116 408.0100n 0.000165 408.0200n 0.000216 408.0300n 0.000267 408.0400n 0.000320 408.0500n 0.000372 408.0600n 0.000424 408.0700n 0.000473 408.0800n 0.000519 408.0900n 0.000560 408.1000n 0.000596 408.1100n 0.000624 408.1200n 0.000644 408.1300n 0.000654 408.1400n 0.000653
+ 408.1500n 0.000640 408.1600n 0.000614 408.1700n 0.000575 408.1800n 0.000521 408.1900n 0.000453 408.2000n 0.000370 408.2100n 0.000274 408.2200n 0.000164 408.2300n 0.000041 408.2400n -0.000094 408.2500n -0.000240 408.2600n -0.000394 408.2700n -0.000557 408.2800n -0.000724 408.2900n -0.000896
+ 408.3000n -0.001069 408.3100n -0.001242 408.3200n -0.001413 408.3300n -0.001579 408.3400n -0.001738 408.3500n -0.001888 408.3600n -0.002028 408.3700n -0.002156 408.3800n -0.002270 408.3900n -0.002370 408.4000n -0.002453 408.4100n -0.002519 408.4200n -0.002568 408.4300n -0.002600 408.4400n -0.002613
+ 408.4500n -0.002609 408.4600n -0.002588 408.4700n -0.002551 408.4800n -0.002498 408.4900n -0.002431 408.5000n -0.002350 408.5100n -0.002257 408.5200n -0.002154 408.5300n -0.002043 408.5400n -0.001923 408.5500n -0.001798 408.5600n -0.001669 408.5700n -0.001537 408.5800n -0.001404 408.5900n -0.001272
+ 408.6000n -0.001140 408.6100n -0.001011 408.6200n -0.000886 408.6300n -0.000765 408.6400n -0.000649 408.6500n -0.000539 408.6600n -0.000436 408.6700n -0.000338 408.6800n -0.000248 408.6900n -0.000164 408.7000n -0.000086 408.7100n -0.000016 408.7200n 0.000049 408.7300n 0.000108 408.7400n 0.000160
+ 408.7500n 0.000208 408.7600n 0.000251 408.7700n 0.000288 408.7800n 0.000322 408.7900n 0.000352 408.8000n 0.000378 408.8100n 0.000400 408.8200n 0.000419 408.8300n 0.000436 408.8400n 0.000449 408.8500n 0.000460 408.8600n 0.000468 408.8700n 0.000473 408.8800n 0.000476 408.8900n 0.000476
+ 408.9000n 0.000474 408.9100n 0.000470 408.9200n 0.000463 408.9300n 0.000453 408.9400n 0.000442 408.9500n 0.000429 408.9600n 0.000414 408.9700n 0.000397 408.9800n 0.000379 408.9900n 0.000361 409.0000n 0.000341 409.0100n 0.000322 409.0200n 0.000303 409.0300n 0.000284 409.0400n 0.000267
+ 409.0500n 0.000251 409.0600n 0.000237 409.0700n 0.000225 409.0800n 0.000215 409.0900n 0.000209 409.1000n 0.000205 409.1100n 0.000205 409.1200n 0.000208 409.1300n 0.000213 409.1400n 0.000222 409.1500n 0.000234 409.1600n 0.000248 409.1700n 0.000263 409.1800n 0.000281 409.1900n 0.000299
+ 409.2000n 0.000318 409.2100n 0.000336 409.2200n 0.000353 409.2300n 0.000369 409.2400n 0.000382 409.2500n 0.000392 409.2600n 0.000398 409.2700n 0.000399 409.2800n 0.000396 409.2900n 0.000388 409.3000n 0.000374 409.3100n 0.000354 409.3200n 0.000328 409.3300n 0.000297 409.3400n 0.000259
+ 409.3500n 0.000216 409.3600n 0.000169 409.3700n 0.000116 409.3800n 0.000060 409.3900n 0.000001 409.4000n -0.000060 409.4100n -0.000123 409.4200n -0.000186 409.4300n -0.000248 409.4400n -0.000309 409.4500n -0.000366 409.4600n -0.000420 409.4700n -0.000470 409.4800n -0.000513 409.4900n -0.000551
+ 409.5000n -0.000581 409.5100n -0.000604 409.5200n -0.000619 409.5300n -0.000625 409.5400n -0.000623 409.5500n -0.000612 409.5600n -0.000593 409.5700n -0.000566 409.5800n -0.000531 409.5900n -0.000488 409.6000n -0.000439 409.6100n -0.000383 409.6200n -0.000322 409.6300n -0.000256 409.6400n -0.000187
+ 409.6500n -0.000114 409.6600n -0.000039 409.6700n 0.000037 409.6800n 0.000114 409.6900n 0.000190 409.7000n 0.000266 409.7100n 0.000341 409.7200n 0.000414 409.7300n 0.000485 409.7400n 0.000553 409.7500n 0.000618 409.7600n 0.000681 409.7700n 0.000741 409.7800n 0.000797 409.7900n 0.000851
+ 409.8000n 0.000903 409.8100n 0.000952 409.8200n 0.000998 409.8300n 0.001043 409.8400n 0.001085 409.8500n 0.001126 409.8600n 0.001165 409.8700n 0.001202 409.8800n 0.001238 409.8900n 0.001272 409.9000n 0.001305 409.9100n 0.001336 409.9200n 0.001364 409.9300n 0.001391 409.9400n 0.001414
+ 409.9500n 0.001434 409.9600n 0.001451 409.9700n 0.001463 409.9800n 0.001472 409.9900n 0.001475 410.0000n 0.001473 410.0100n 0.001465 410.0200n 0.001452 410.0300n 0.001432 410.0400n 0.001407 410.0500n 0.001375 410.0600n 0.001338 410.0700n 0.001295 410.0800n 0.001248 410.0900n 0.001196
+ 410.1000n 0.001141 410.1100n 0.001084 410.1200n 0.001025 410.1300n 0.000966 410.1400n 0.000908 410.1500n 0.000852 410.1600n 0.000801 410.1700n 0.000754 410.1800n 0.000714 410.1900n 0.000681 410.2000n 0.000658 410.2100n 0.000645 410.2200n 0.000643 410.2300n 0.000653 410.2400n 0.000675
+ 410.2500n 0.000710 410.2600n 0.000758 410.2700n 0.000819 410.2800n 0.000892 410.2900n 0.000976 410.3000n 0.001071 410.3100n 0.001175 410.3200n 0.001286 410.3300n 0.001404 410.3400n 0.001526 410.3500n 0.001649 410.3600n 0.001773 410.3700n 0.001893 410.3800n 0.002009 410.3900n 0.002117
+ 410.4000n 0.002215 410.4100n 0.002302 410.4200n 0.002374 410.4300n 0.002430 410.4400n 0.002468 410.4500n 0.002486 410.4600n 0.002485 410.4700n 0.002462 410.4800n 0.002417 410.4900n 0.002350 410.5000n 0.002261 410.5100n 0.002151 410.5200n 0.002021 410.5300n 0.001871 410.5400n 0.001705
+ 410.5500n 0.001523 410.5600n 0.001327 410.5700n 0.001121 410.5800n 0.000906 410.5900n 0.000685 410.6000n 0.000462 410.6100n 0.000238 410.6200n 0.000017 410.6300n -0.000198 410.6400n -0.000406 410.6500n -0.000604 410.6600n -0.000789 410.6700n -0.000959 410.6800n -0.001114 410.6900n -0.001251
+ 410.7000n -0.001370 410.7100n -0.001470 410.7200n -0.001550 410.7300n -0.001611 410.7400n -0.001653 410.7500n -0.001677 410.7600n -0.001684 410.7700n -0.001674 410.7800n -0.001649 410.7900n -0.001612 410.8000n -0.001563 410.8100n -0.001504 410.8200n -0.001437 410.8300n -0.001364 410.8400n -0.001287
+ 410.8500n -0.001207 410.8600n -0.001126 410.8700n -0.001045 410.8800n -0.000966 410.8900n -0.000889 410.9000n -0.000815 410.9100n -0.000744 410.9200n -0.000676 410.9300n -0.000612 410.9400n -0.000551 410.9500n -0.000492 410.9600n -0.000435 410.9700n -0.000379 410.9800n -0.000323 410.9900n -0.000265
+ 411.0000n -0.000205 411.0100n -0.000140 411.0200n -0.000071 411.0300n 0.000004 411.0400n 0.000087 411.0500n 0.000177 411.0600n 0.000275 411.0700n 0.000383 411.0800n 0.000499 411.0900n 0.000624 411.1000n 0.000757 411.1100n 0.000898 411.1200n 0.001045 411.1300n 0.001197 411.1400n 0.001353
+ 411.1500n 0.001512 411.1600n 0.001670 411.1700n 0.001826 411.1800n 0.001977 411.1900n 0.002122 411.2000n 0.002259 411.2100n 0.002384 411.2200n 0.002496 411.2300n 0.002593 411.2400n 0.002672 411.2500n 0.002733 411.2600n 0.002775 411.2700n 0.002795 411.2800n 0.002793 411.2900n 0.002770
+ 411.3000n 0.002725 411.3100n 0.002658 411.3200n 0.002571 411.3300n 0.002464 411.3400n 0.002340 411.3500n 0.002199 411.3600n 0.002043 411.3700n 0.001876 411.3800n 0.001699 411.3900n 0.001516 411.4000n 0.001328 411.4100n 0.001138 411.4200n 0.000949 411.4300n 0.000764 411.4400n 0.000584
+ 411.4500n 0.000412 411.4600n 0.000250 411.4700n 0.000098 411.4800n -0.000040 411.4900n -0.000166 411.5000n -0.000277 411.5100n -0.000375 411.5200n -0.000458 411.5300n -0.000529 411.5400n -0.000587 411.5500n -0.000635 411.5600n -0.000673 411.5700n -0.000703 411.5800n -0.000727 411.5900n -0.000748
+ 411.6000n -0.000768 411.6100n -0.000788 411.6200n -0.000810 411.6300n -0.000838 411.6400n -0.000872 411.6500n -0.000915 411.6600n -0.000967 411.6700n -0.001030 411.6800n -0.001104 411.6900n -0.001190 411.7000n -0.001288 411.7100n -0.001396 411.7200n -0.001516 411.7300n -0.001644 411.7400n -0.001780
+ 411.7500n -0.001922 411.7600n -0.002067 411.7700n -0.002213 411.7800n -0.002358 411.7900n -0.002498 411.8000n -0.002630 411.8100n -0.002752 411.8200n -0.002861 411.8300n -0.002954 411.8400n -0.003029 411.8500n -0.003082 411.8600n -0.003113 411.8700n -0.003120 411.8800n -0.003101 411.8900n -0.003056
+ 411.9000n -0.002984 411.9100n -0.002886 411.9200n -0.002761 411.9300n -0.002612 411.9400n -0.002439 411.9500n -0.002245 411.9600n -0.002033 411.9700n -0.001804 411.9800n -0.001562 411.9900n -0.001310 412.0000n -0.001052 412.0100n -0.000792 412.0200n -0.000532 412.0300n -0.000277 412.0400n -0.000030
+ 412.0500n 0.000205 412.0600n 0.000426 412.0700n 0.000629 412.0800n 0.000813 412.0900n 0.000974 412.1000n 0.001111 412.1100n 0.001223 412.1200n 0.001310 412.1300n 0.001370 412.1400n 0.001405 412.1500n 0.001414 412.1600n 0.001399 412.1700n 0.001362 412.1800n 0.001303 412.1900n 0.001227
+ 412.2000n 0.001134 412.2100n 0.001028 412.2200n 0.000911 412.2300n 0.000787 412.2400n 0.000659 412.2500n 0.000529 412.2600n 0.000400 412.2700n 0.000275 412.2800n 0.000157 412.2900n 0.000047 412.3000n -0.000052 412.3100n -0.000139 412.3200n -0.000212 412.3300n -0.000271 412.3400n -0.000315
+ 412.3500n -0.000343 412.3600n -0.000357 412.3700n -0.000356 412.3800n -0.000341 412.3900n -0.000314 412.4000n -0.000275 412.4100n -0.000226 412.4200n -0.000169 412.4300n -0.000105 412.4400n -0.000036 412.4500n 0.000035 412.4600n 0.000108 412.4700n 0.000181 412.4800n 0.000252 412.4900n 0.000319
+ 412.5000n 0.000383 412.5100n 0.000442 412.5200n 0.000494 412.5300n 0.000541 412.5400n 0.000582 412.5500n 0.000616 412.5600n 0.000644 412.5700n 0.000667 412.5800n 0.000686 412.5900n 0.000700 412.6000n 0.000712 412.6100n 0.000722 412.6200n 0.000731 412.6300n 0.000740 412.6400n 0.000750
+ 412.6500n 0.000763 412.6600n 0.000779 412.6700n 0.000798 412.6800n 0.000822 412.6900n 0.000851 412.7000n 0.000884 412.7100n 0.000921 412.7200n 0.000963 412.7300n 0.001009 412.7400n 0.001057 412.7500n 0.001108 412.7600n 0.001159 412.7700n 0.001210 412.7800n 0.001259 412.7900n 0.001305
+ 412.8000n 0.001347 412.8100n 0.001382 412.8200n 0.001411 412.8300n 0.001430 412.8400n 0.001440 412.8500n 0.001439 412.8600n 0.001427 412.8700n 0.001403 412.8800n 0.001367 412.8900n 0.001318 412.9000n 0.001258 412.9100n 0.001186 412.9200n 0.001104 412.9300n 0.001013 412.9400n 0.000913
+ 412.9500n 0.000807 412.9600n 0.000697 412.9700n 0.000583 412.9800n 0.000468 412.9900n 0.000354 413.0000n 0.000243 413.0100n 0.000137 413.0200n 0.000037 413.0300n -0.000055 413.0400n -0.000137 413.0500n -0.000208 413.0600n -0.000268 413.0700n -0.000315 413.0800n -0.000350 413.0900n -0.000372
+ 413.1000n -0.000382 413.1100n -0.000380 413.1200n -0.000367 413.1300n -0.000346 413.1400n -0.000316 413.1500n -0.000281 413.1600n -0.000243 413.1700n -0.000202 413.1800n -0.000162 413.1900n -0.000125 413.2000n -0.000094 413.2100n -0.000069 413.2200n -0.000055 413.2300n -0.000052 413.2400n -0.000061
+ 413.2500n -0.000086 413.2600n -0.000126 413.2700n -0.000181 413.2800n -0.000254 413.2900n -0.000343 413.3000n -0.000447 413.3100n -0.000567 413.3200n -0.000700 413.3300n -0.000845 413.3400n -0.001000 413.3500n -0.001162 413.3600n -0.001330 413.3700n -0.001500 413.3800n -0.001669 413.3900n -0.001835
+ 413.4000n -0.001994 413.4100n -0.002143 413.4200n -0.002280 413.4300n -0.002401 413.4400n -0.002505 413.4500n -0.002590 413.4600n -0.002653 413.4700n -0.002693 413.4800n -0.002709 413.4900n -0.002701 413.5000n -0.002668 413.5100n -0.002612 413.5200n -0.002532 413.5300n -0.002430 413.5400n -0.002308
+ 413.5500n -0.002167 413.5600n -0.002011 413.5700n -0.001841 413.5800n -0.001661 413.5900n -0.001474 413.6000n -0.001282 413.6100n -0.001090 413.6200n -0.000900 413.6300n -0.000714 413.6400n -0.000537 413.6500n -0.000370 413.6600n -0.000216 413.6700n -0.000077 413.6800n 0.000046 413.6900n 0.000152
+ 413.7000n 0.000239 413.7100n 0.000307 413.7200n 0.000356 413.7300n 0.000387 413.7400n 0.000401 413.7500n 0.000399 413.7600n 0.000382 413.7700n 0.000353 413.7800n 0.000313 413.7900n 0.000265 413.8000n 0.000211 413.8100n 0.000153 413.8200n 0.000095 413.8300n 0.000037 413.8400n -0.000017
+ 413.8500n -0.000065 413.8600n -0.000107 413.8700n -0.000139 413.8800n -0.000162 413.8900n -0.000175 413.9000n -0.000176 413.9100n -0.000166 413.9200n -0.000146 413.9300n -0.000115 413.9400n -0.000076 413.9500n -0.000029 413.9600n 0.000025 413.9700n 0.000082 413.9800n 0.000141 413.9900n 0.000201
+ 414.0000n 0.000258 414.0100n 0.000311 414.0200n 0.000357 414.0300n 0.000395 414.0400n 0.000422 414.0500n 0.000437 414.0600n 0.000439 414.0700n 0.000426 414.0800n 0.000399 414.0900n 0.000356 414.1000n 0.000298 414.1100n 0.000225 414.1200n 0.000138 414.1300n 0.000039 414.1400n -0.000070
+ 414.1500n -0.000189 414.1600n -0.000315 414.1700n -0.000444 414.1800n -0.000576 414.1900n -0.000706 414.2000n -0.000833 414.2100n -0.000953 414.2200n -0.001064 414.2300n -0.001164 414.2400n -0.001250 414.2500n -0.001320 414.2600n -0.001373 414.2700n -0.001408 414.2800n -0.001423 414.2900n -0.001419
+ 414.3000n -0.001395 414.3100n -0.001353 414.3200n -0.001291 414.3300n -0.001214 414.3400n -0.001121 414.3500n -0.001015 414.3600n -0.000899 414.3700n -0.000775 414.3800n -0.000646 414.3900n -0.000515 414.4000n -0.000385 414.4100n -0.000259 414.4200n -0.000141 414.4300n -0.000032 414.4400n 0.000063
+ 414.4500n 0.000145 414.4600n 0.000209 414.4700n 0.000255 414.4800n 0.000282 414.4900n 0.000289 414.5000n 0.000276 414.5100n 0.000243 414.5200n 0.000192 414.5300n 0.000123 414.5400n 0.000038 414.5500n -0.000060 414.5600n -0.000168 414.5700n -0.000285 414.5800n -0.000406 414.5900n -0.000529
+ 414.6000n -0.000650 414.6100n -0.000765 414.6200n -0.000871 414.6300n -0.000965 414.6400n -0.001044 414.6500n -0.001104 414.6600n -0.001144 414.6700n -0.001160 414.6800n -0.001153 414.6900n -0.001119 414.7000n -0.001060 414.7100n -0.000974 414.7200n -0.000862 414.7300n -0.000725 414.7400n -0.000565
+ 414.7500n -0.000384 414.7600n -0.000184 414.7700n 0.000032 414.7800n 0.000261 414.7900n 0.000500 414.8000n 0.000743 414.8100n 0.000989 414.8200n 0.001232 414.8300n 0.001469 414.8400n 0.001696 414.8500n 0.001909 414.8600n 0.002106 414.8700n 0.002282 414.8800n 0.002435 414.8900n 0.002564
+ 414.9000n 0.002665 414.9100n 0.002739 414.9200n 0.002783 414.9300n 0.002798 414.9400n 0.002785 414.9500n 0.002742 414.9600n 0.002673 414.9700n 0.002579 414.9800n 0.002461 414.9900n 0.002322 415.0000n 0.002165 415.0100n 0.001994 415.0200n 0.001810 415.0300n 0.001617 415.0400n 0.001419
+ 415.0500n 0.001218 415.0600n 0.001019 415.0700n 0.000823 415.0800n 0.000633 415.0900n 0.000452 415.1000n 0.000283 415.1100n 0.000126 415.1200n -0.000017 415.1300n -0.000145 415.1400n -0.000257 415.1500n -0.000353 415.1600n -0.000433 415.1700n -0.000498 415.1800n -0.000549 415.1900n -0.000586
+ 415.2000n -0.000612 415.2100n -0.000627 415.2200n -0.000633 415.2300n -0.000633 415.2400n -0.000628 415.2500n -0.000619 415.2600n -0.000609 415.2700n -0.000600 415.2800n -0.000592 415.2900n -0.000587 415.3000n -0.000586 415.3100n -0.000590 415.3200n -0.000599 415.3300n -0.000613 415.3400n -0.000633
+ 415.3500n -0.000658 415.3600n -0.000688 415.3700n -0.000721 415.3800n -0.000757 415.3900n -0.000794 415.4000n -0.000831 415.4100n -0.000867 415.4200n -0.000900 415.4300n -0.000930 415.4400n -0.000953 415.4500n -0.000970 415.4600n -0.000980 415.4700n -0.000980 415.4800n -0.000971 415.4900n -0.000952
+ 415.5000n -0.000924 415.5100n -0.000885 415.5200n -0.000837 415.5300n -0.000780 415.5400n -0.000715 415.5500n -0.000644 415.5600n -0.000568 415.5700n -0.000489 415.5800n -0.000408 415.5900n -0.000328 415.6000n -0.000251 415.6100n -0.000179 415.6200n -0.000113 415.6300n -0.000056 415.6400n -0.000010
+ 415.6500n 0.000023 415.6600n 0.000043 415.6700n 0.000047 415.6800n 0.000036 415.6900n 0.000007 415.7000n -0.000038 415.7100n -0.000099 415.7200n -0.000177 415.7300n -0.000270 415.7400n -0.000376 415.7500n -0.000495 415.7600n -0.000624 415.7700n -0.000761 415.7800n -0.000904 415.7900n -0.001049
+ 415.8000n -0.001195 415.8100n -0.001337 415.8200n -0.001474 415.8300n -0.001602 415.8400n -0.001718 415.8500n -0.001820 415.8600n -0.001905 415.8700n -0.001972 415.8800n -0.002018 415.8900n -0.002041 415.9000n -0.002041 415.9100n -0.002017 415.9200n -0.001968 415.9300n -0.001894 415.9400n -0.001797
+ 415.9500n -0.001677 415.9600n -0.001535 415.9700n -0.001373 415.9800n -0.001194 415.9900n -0.000999 416.0000n -0.000791 416.0100n -0.000574 416.0200n -0.000350 416.0300n -0.000122 416.0400n 0.000106 416.0500n 0.000332 416.0600n 0.000551 416.0700n 0.000762 416.0800n 0.000961 416.0900n 0.001146
+ 416.1000n 0.001315 416.1100n 0.001465 416.1200n 0.001594 416.1300n 0.001703 416.1400n 0.001789 416.1500n 0.001852 416.1600n 0.001893 416.1700n 0.001910 416.1800n 0.001905 416.1900n 0.001880 416.2000n 0.001834 416.2100n 0.001770 416.2200n 0.001690 416.2300n 0.001595 416.2400n 0.001487
+ 416.2500n 0.001370 416.2600n 0.001246 416.2700n 0.001116 416.2800n 0.000983 416.2900n 0.000851 416.3000n 0.000720 416.3100n 0.000594 416.3200n 0.000473 416.3300n 0.000361 416.3400n 0.000259 416.3500n 0.000167 416.3600n 0.000087 416.3700n 0.000021 416.3800n -0.000032 416.3900n -0.000070
+ 416.4000n -0.000095 416.4100n -0.000105 416.4200n -0.000102 416.4300n -0.000085 416.4400n -0.000056 416.4500n -0.000015 416.4600n 0.000037 416.4700n 0.000099 416.4800n 0.000169 416.4900n 0.000246 416.5000n 0.000329 416.5100n 0.000417 416.5200n 0.000508 416.5300n 0.000601 416.5400n 0.000695
+ 416.5500n 0.000788 416.5600n 0.000879 416.5700n 0.000968 416.5800n 0.001052 416.5900n 0.001132 416.6000n 0.001206 416.6100n 0.001273 416.6200n 0.001334 416.6300n 0.001386 416.6400n 0.001430 416.6500n 0.001466 416.6600n 0.001492 416.6700n 0.001508 416.6800n 0.001516 416.6900n 0.001513
+ 416.7000n 0.001500 416.7100n 0.001478 416.7200n 0.001446 416.7300n 0.001405 416.7400n 0.001354 416.7500n 0.001295 416.7600n 0.001227 416.7700n 0.001152 416.7800n 0.001069 416.7900n 0.000980 416.8000n 0.000885 416.8100n 0.000785 416.8200n 0.000681 416.8300n 0.000574 416.8400n 0.000465
+ 416.8500n 0.000355 416.8600n 0.000246 416.8700n 0.000139 416.8800n 0.000034 416.8900n -0.000067 416.9000n -0.000163 416.9100n -0.000252 416.9200n -0.000334 416.9300n -0.000407 416.9400n -0.000471 416.9500n -0.000525 416.9600n -0.000567 416.9700n -0.000598 416.9800n -0.000617 416.9900n -0.000623
+ 417.0000n -0.000618 417.0100n -0.000600 417.0200n -0.000570 417.0300n -0.000529 417.0400n -0.000477 417.0500n -0.000415 417.0600n -0.000344 417.0700n -0.000265 417.0800n -0.000180 417.0900n -0.000090 417.1000n 0.000003 417.1100n 0.000099 417.1200n 0.000195 417.1300n 0.000290 417.1400n 0.000383
+ 417.1500n 0.000472 417.1600n 0.000555 417.1700n 0.000632 417.1800n 0.000702 417.1900n 0.000763 417.2000n 0.000815 417.2100n 0.000858 417.2200n 0.000890 417.2300n 0.000913 417.2400n 0.000926 417.2500n 0.000930 417.2600n 0.000925 417.2700n 0.000912 417.2800n 0.000892 417.2900n 0.000866
+ 417.3000n 0.000836 417.3100n 0.000803 417.3200n 0.000767 417.3300n 0.000732 417.3400n 0.000697 417.3500n 0.000665 417.3600n 0.000636 417.3700n 0.000613 417.3800n 0.000595 417.3900n 0.000585 417.4000n 0.000582 417.4100n 0.000588 417.4200n 0.000602 417.4300n 0.000625 417.4400n 0.000656
+ 417.4500n 0.000695 417.4600n 0.000742 417.4700n 0.000796 417.4800n 0.000856 417.4900n 0.000920 417.5000n 0.000988 417.5100n 0.001059 417.5200n 0.001130 417.5300n 0.001200 417.5400n 0.001269 417.5500n 0.001334 417.5600n 0.001394 417.5700n 0.001449 417.5800n 0.001497 417.5900n 0.001538
+ 417.6000n 0.001570 417.6100n 0.001594 417.6200n 0.001610 417.6300n 0.001616 417.6400n 0.001615 417.6500n 0.001606 417.6600n 0.001590 417.6700n 0.001568 417.6800n 0.001542 417.6900n 0.001512 417.7000n 0.001480 417.7100n 0.001447 417.7200n 0.001415 417.7300n 0.001386 417.7400n 0.001360
+ 417.7500n 0.001339 417.7600n 0.001325 417.7700n 0.001318 417.7800n 0.001319 417.7900n 0.001328 417.8000n 0.001346 417.8100n 0.001372 417.8200n 0.001407 417.8300n 0.001450 417.8400n 0.001499 417.8500n 0.001553 417.8600n 0.001611 417.8700n 0.001670 417.8800n 0.001730 417.8900n 0.001787
+ 417.9000n 0.001840 417.9100n 0.001886 417.9200n 0.001922 417.9300n 0.001946 417.9400n 0.001956 417.9500n 0.001950 417.9600n 0.001926 417.9700n 0.001882 417.9800n 0.001817 417.9900n 0.001729 418.0000n 0.001619 418.0100n 0.001485 418.0200n 0.001329 418.0300n 0.001151 418.0400n 0.000951
+ 418.0500n 0.000733 418.0600n 0.000496 418.0700n 0.000245 418.0800n -0.000018 418.0900n -0.000290 418.1000n -0.000568 418.1100n -0.000849 418.1200n -0.001128 418.1300n -0.001401 418.1400n -0.001666 418.1500n -0.001917 418.1600n -0.002153 418.1700n -0.002368 418.1800n -0.002561 418.1900n -0.002728
+ 418.2000n -0.002868 418.2100n -0.002977 418.2200n -0.003055 418.2300n -0.003101 418.2400n -0.003114 418.2500n -0.003095 418.2600n -0.003045 418.2700n -0.002963 418.2800n -0.002853 418.2900n -0.002716 418.3000n -0.002556 418.3100n -0.002374 418.3200n -0.002175 418.3300n -0.001961 418.3400n -0.001738
+ 418.3500n -0.001507 418.3600n -0.001275 418.3700n -0.001043 418.3800n -0.000817 418.3900n -0.000600 418.4000n -0.000394 418.4100n -0.000203 418.4200n -0.000030 418.4300n 0.000123 418.4400n 0.000254 418.4500n 0.000362 418.4600n 0.000447 418.4700n 0.000507 418.4800n 0.000543 418.4900n 0.000556
+ 418.5000n 0.000547 418.5100n 0.000517 418.5200n 0.000468 418.5300n 0.000402 418.5400n 0.000322 418.5500n 0.000231 418.5600n 0.000131 418.5700n 0.000025 418.5800n -0.000083 418.5900n -0.000191 418.6000n -0.000297 418.6100n -0.000396 418.6200n -0.000487 418.6300n -0.000568 418.6400n -0.000637
+ 418.6500n -0.000692 418.6600n -0.000733 418.6700n -0.000757 418.6800n -0.000766 418.6900n -0.000758 418.7000n -0.000735 418.7100n -0.000696 418.7200n -0.000643 418.7300n -0.000577 418.7400n -0.000499 418.7500n -0.000411 418.7600n -0.000316 418.7700n -0.000214 418.7800n -0.000109 418.7900n -0.000001
+ 418.8000n 0.000107 418.8100n 0.000213 418.8200n 0.000316 418.8300n 0.000414 418.8400n 0.000506 418.8500n 0.000591 418.8600n 0.000667 418.8700n 0.000735 418.8800n 0.000793 418.8900n 0.000842 418.9000n 0.000882 418.9100n 0.000914 418.9200n 0.000938 418.9300n 0.000954 418.9400n 0.000964
+ 418.9500n 0.000969 418.9600n 0.000969 418.9700n 0.000967 418.9800n 0.000963 418.9900n 0.000958 419.0000n 0.000953 419.0100n 0.000949 419.0200n 0.000947 419.0300n 0.000947 419.0400n 0.000951 419.0500n 0.000957 419.0600n 0.000967 419.0700n 0.000979 419.0800n 0.000994 419.0900n 0.001011
+ 419.1000n 0.001029 419.1100n 0.001047 419.1200n 0.001064 419.1300n 0.001080 419.1400n 0.001093 419.1500n 0.001101 419.1600n 0.001105 419.1700n 0.001102 419.1800n 0.001092 419.1900n 0.001073 419.2000n 0.001046 419.2100n 0.001010 419.2200n 0.000964 419.2300n 0.000909 419.2400n 0.000844
+ 419.2500n 0.000770 419.2600n 0.000688 419.2700n 0.000599 419.2800n 0.000503 419.2900n 0.000402 419.3000n 0.000298 419.3100n 0.000192 419.3200n 0.000085 419.3300n -0.000020 419.3400n -0.000122 419.3500n -0.000219 419.3600n -0.000309 419.3700n -0.000391 419.3800n -0.000464 419.3900n -0.000525
+ 419.4000n -0.000575 419.4100n -0.000612 419.4200n -0.000636 419.4300n -0.000647 419.4400n -0.000644 419.4500n -0.000628 419.4600n -0.000600 419.4700n -0.000560 419.4800n -0.000510 419.4900n -0.000450 419.5000n -0.000382 419.5100n -0.000309 419.5200n -0.000231 419.5300n -0.000151 419.5400n -0.000071
+ 419.5500n 0.000009 419.5600n 0.000085 419.5700n 0.000157 419.5800n 0.000222 419.5900n 0.000280 419.6000n 0.000330 419.6100n 0.000369 419.6200n 0.000399 419.6300n 0.000418 419.6400n 0.000427 419.6500n 0.000426 419.6600n 0.000415 419.6700n 0.000396 419.6800n 0.000368 419.6900n 0.000334
+ 419.7000n 0.000295 419.7100n 0.000252 419.7200n 0.000207 419.7300n 0.000161 419.7400n 0.000117 419.7500n 0.000077 419.7600n 0.000040 419.7700n 0.000009 419.7800n -0.000014 419.7900n -0.000029 419.8000n -0.000036 419.8100n -0.000033 419.8200n -0.000021 419.8300n -0.000000 419.8400n 0.000030
+ 419.8500n 0.000068 419.8600n 0.000113 419.8700n 0.000163 419.8800n 0.000218 419.8900n 0.000275 419.9000n 0.000332 419.9100n 0.000387 419.9200n 0.000438 419.9300n 0.000483 419.9400n 0.000520 419.9500n 0.000546 419.9600n 0.000560 419.9700n 0.000560 419.9800n 0.000544 419.9900n 0.000512
+ 420.0000n 0.000462 420.0100n 0.000394 420.0200n 0.000307 420.0300n 0.000202 420.0400n 0.000080 420.0500n -0.000059 420.0600n -0.000212 420.0700n -0.000380 420.0800n -0.000558 420.0900n -0.000746 420.1000n -0.000940 420.1100n -0.001138 420.1200n -0.001336 420.1300n -0.001532 420.1400n -0.001723
+ 420.1500n -0.001905 420.1600n -0.002076 420.1700n -0.002232 420.1800n -0.002372 420.1900n -0.002492 420.2000n -0.002592 420.2100n -0.002668 420.2200n -0.002720 420.2300n -0.002747 420.2400n -0.002749 420.2500n -0.002725 420.2600n -0.002675 420.2700n -0.002601 420.2800n -0.002504 420.2900n -0.002384
+ 420.3000n -0.002245 420.3100n -0.002087 420.3200n -0.001914 420.3300n -0.001728 420.3400n -0.001532 420.3500n -0.001329 420.3600n -0.001121 420.3700n -0.000911 420.3800n -0.000703 420.3900n -0.000498 420.4000n -0.000300 420.4100n -0.000110 420.4200n 0.000070 420.4300n 0.000237 420.4400n 0.000390
+ 420.4500n 0.000528 420.4600n 0.000651 420.4700n 0.000757 420.4800n 0.000846 420.4900n 0.000919 420.5000n 0.000975 420.5100n 0.001016 420.5200n 0.001041 420.5300n 0.001053 420.5400n 0.001051 420.5500n 0.001037 420.5600n 0.001012 420.5700n 0.000978 420.5800n 0.000936 420.5900n 0.000886
+ 420.6000n 0.000830 420.6100n 0.000769 420.6200n 0.000703 420.6300n 0.000634 420.6400n 0.000561 420.6500n 0.000486 420.6600n 0.000408 420.6700n 0.000328 420.6800n 0.000245 420.6900n 0.000160 420.7000n 0.000072 420.7100n -0.000020 420.7200n -0.000114 420.7300n -0.000212 420.7400n -0.000314
+ 420.7500n -0.000419 420.7600n -0.000529 420.7700n -0.000643 420.7800n -0.000760 420.7900n -0.000881 420.8000n -0.001005 420.8100n -0.001131 420.8200n -0.001258 420.8300n -0.001385 420.8400n -0.001511 420.8500n -0.001634 420.8600n -0.001752 420.8700n -0.001865 420.8800n -0.001970 420.8900n -0.002065
+ 420.9000n -0.002149 420.9100n -0.002220 420.9200n -0.002276 420.9300n -0.002315 420.9400n -0.002337 420.9500n -0.002340 420.9600n -0.002322 420.9700n -0.002285 420.9800n -0.002226 420.9900n -0.002147 421.0000n -0.002047 421.0100n -0.001928 421.0200n -0.001790 421.0300n -0.001635 421.0400n -0.001465
+ 421.0500n -0.001281 421.0600n -0.001086 421.0700n -0.000883 421.0800n -0.000674 421.0900n -0.000461 421.1000n -0.000249 421.1100n -0.000039 421.1200n 0.000166 421.1300n 0.000361 421.1400n 0.000546 421.1500n 0.000718 421.1600n 0.000874 421.1700n 0.001012 421.1800n 0.001132 421.1900n 0.001232
+ 421.2000n 0.001311 421.2100n 0.001369 421.2200n 0.001406 421.2300n 0.001423 421.2400n 0.001420 421.2500n 0.001399 421.2600n 0.001362 421.2700n 0.001310 421.2800n 0.001245 421.2900n 0.001170 421.3000n 0.001088 421.3100n 0.001000 421.3200n 0.000910 421.3300n 0.000821 421.3400n 0.000733
+ 421.3500n 0.000651 421.3600n 0.000576 421.3700n 0.000510 421.3800n 0.000455 421.3900n 0.000411 421.4000n 0.000379 421.4100n 0.000361 421.4200n 0.000355 421.4300n 0.000362 421.4400n 0.000381 421.4500n 0.000411 421.4600n 0.000450 421.4700n 0.000497 421.4800n 0.000550 421.4900n 0.000607
+ 421.5000n 0.000666 421.5100n 0.000723 421.5200n 0.000778 421.5300n 0.000827 421.5400n 0.000868 421.5500n 0.000901 421.5600n 0.000922 421.5700n 0.000931 421.5800n 0.000926 421.5900n 0.000906 421.6000n 0.000872 421.6100n 0.000824 421.6200n 0.000761 421.6300n 0.000685 421.6400n 0.000597
+ 421.6500n 0.000499 421.6600n 0.000393 421.6700n 0.000280 421.6800n 0.000164 421.6900n 0.000047 421.7000n -0.000069 421.7100n -0.000179 421.7200n -0.000282 421.7300n -0.000375 421.7400n -0.000456 421.7500n -0.000521 421.7600n -0.000569 421.7700n -0.000598 421.7800n -0.000607 421.7900n -0.000596
+ 421.8000n -0.000563 421.8100n -0.000509 421.8200n -0.000434 421.8300n -0.000340 421.8400n -0.000228 421.8500n -0.000100 421.8600n 0.000042 421.8700n 0.000195 421.8800n 0.000356 421.8900n 0.000521 421.9000n 0.000688 421.9100n 0.000853 421.9200n 0.001012 421.9300n 0.001162 421.9400n 0.001300
+ 421.9500n 0.001423 421.9600n 0.001527 421.9700n 0.001611 421.9800n 0.001673 421.9900n 0.001711 422.0000n 0.001725 422.0100n 0.001713 422.0200n 0.001677 422.0300n 0.001616 422.0400n 0.001531 422.0500n 0.001426 422.0600n 0.001301 422.0700n 0.001159 422.0800n 0.001004 422.0900n 0.000838
+ 422.1000n 0.000666 422.1100n 0.000490 422.1200n 0.000315 422.1300n 0.000144 422.1400n -0.000018 422.1500n -0.000170 422.1600n -0.000307 422.1700n -0.000426 422.1800n -0.000526 422.1900n -0.000603 422.2000n -0.000658 422.2100n -0.000688 422.2200n -0.000694 422.2300n -0.000675 422.2400n -0.000633
+ 422.2500n -0.000568 422.2600n -0.000483 422.2700n -0.000380 422.2800n -0.000262 422.2900n -0.000132 422.3000n 0.000008 422.3100n 0.000152 422.3200n 0.000297 422.3300n 0.000440 422.3400n 0.000576 422.3500n 0.000702 422.3600n 0.000815 422.3700n 0.000911 422.3800n 0.000988 422.3900n 0.001043
+ 422.4000n 0.001074 422.4100n 0.001081 422.4200n 0.001062 422.4300n 0.001017 422.4400n 0.000947 422.4500n 0.000853 422.4600n 0.000737 422.4700n 0.000600 422.4800n 0.000445 422.4900n 0.000276 422.5000n 0.000096 422.5100n -0.000092 422.5200n -0.000284 422.5300n -0.000475 422.5400n -0.000662
+ 422.5500n -0.000840 422.5600n -0.001006 422.5700n -0.001156 422.5800n -0.001288 422.5900n -0.001397 422.6000n -0.001482 422.6100n -0.001541 422.6200n -0.001573 422.6300n -0.001576 422.6400n -0.001552 422.6500n -0.001499 422.6600n -0.001421 422.6700n -0.001317 422.6800n -0.001191 422.6900n -0.001045
+ 422.7000n -0.000882 422.7100n -0.000706 422.7200n -0.000521 422.7300n -0.000330 422.7400n -0.000138 422.7500n 0.000051 422.7600n 0.000233 422.7700n 0.000405 422.7800n 0.000562 422.7900n 0.000702 422.8000n 0.000822 422.8100n 0.000918 422.8200n 0.000990 422.8300n 0.001036 422.8400n 0.001055
+ 422.8500n 0.001047 422.8600n 0.001013 422.8700n 0.000953 422.8800n 0.000870 422.8900n 0.000765 422.9000n 0.000642 422.9100n 0.000503 422.9200n 0.000352 422.9300n 0.000192 422.9400n 0.000028 422.9500n -0.000136 422.9600n -0.000297 422.9700n -0.000450 422.9800n -0.000590 422.9900n -0.000716
+ 423.0000n -0.000823 423.0100n -0.000908 423.0200n -0.000968 423.0300n -0.001003 423.0400n -0.001009 423.0500n -0.000987 423.0600n -0.000936 423.0700n -0.000856 423.0800n -0.000747 423.0900n -0.000612 423.1000n -0.000453 423.1100n -0.000271 423.1200n -0.000070 423.1300n 0.000148 423.1400n 0.000378
+ 423.1500n 0.000617 423.1600n 0.000861 423.1700n 0.001105 423.1800n 0.001346 423.1900n 0.001580 423.2000n 0.001803 423.2100n 0.002011 423.2200n 0.002201 423.2300n 0.002370 423.2400n 0.002516 423.2500n 0.002636 423.2600n 0.002728 423.2700n 0.002792 423.2800n 0.002827 423.2900n 0.002833
+ 423.3000n 0.002810 423.3100n 0.002758 423.3200n 0.002680 423.3300n 0.002577 423.3400n 0.002451 423.3500n 0.002304 423.3600n 0.002139 423.3700n 0.001960 423.3800n 0.001768 423.3900n 0.001567 423.4000n 0.001360 423.4100n 0.001151 423.4200n 0.000942 423.4300n 0.000736 423.4400n 0.000536
+ 423.4500n 0.000344 423.4600n 0.000162 423.4700n -0.000007 423.4800n -0.000162 423.4900n -0.000303 423.5000n -0.000427 423.5100n -0.000534 423.5200n -0.000624 423.5300n -0.000698 423.5400n -0.000754 423.5500n -0.000795 423.5600n -0.000820 423.5700n -0.000830 423.5800n -0.000827 423.5900n -0.000813
+ 423.6000n -0.000787 423.6100n -0.000752 423.6200n -0.000709 423.6300n -0.000659 423.6400n -0.000604 423.6500n -0.000545 423.6600n -0.000483 423.6700n -0.000419 423.6800n -0.000354 423.6900n -0.000290 423.7000n -0.000226 423.7100n -0.000164 423.7200n -0.000104 423.7300n -0.000046 423.7400n 0.000009
+ 423.7500n 0.000062 423.7600n 0.000111 423.7700n 0.000157 423.7800n 0.000199 423.7900n 0.000239 423.8000n 0.000275 423.8100n 0.000307 423.8200n 0.000336 423.8300n 0.000361 423.8400n 0.000383 423.8500n 0.000400 423.8600n 0.000413 423.8700n 0.000422 423.8800n 0.000426 423.8900n 0.000425
+ 423.9000n 0.000418 423.9100n 0.000406 423.9200n 0.000389 423.9300n 0.000365 423.9400n 0.000335 423.9500n 0.000298 423.9600n 0.000256 423.9700n 0.000207 423.9800n 0.000152 423.9900n 0.000092 424.0000n 0.000026 424.0100n -0.000044 424.0200n -0.000118 424.0300n -0.000196 424.0400n -0.000275
+ 424.0500n -0.000356 424.0600n -0.000436 424.0700n -0.000516 424.0800n -0.000593 424.0900n -0.000666 424.1000n -0.000735 424.1100n -0.000798 424.1200n -0.000853 424.1300n -0.000900 424.1400n -0.000939 424.1500n -0.000967 424.1600n -0.000985 424.1700n -0.000992 424.1800n -0.000988 424.1900n -0.000973
+ 424.2000n -0.000947 424.2100n -0.000910 424.2200n -0.000864 424.2300n -0.000809 424.2400n -0.000745 424.2500n -0.000676 424.2600n -0.000600 424.2700n -0.000521 424.2800n -0.000440 424.2900n -0.000358 424.3000n -0.000278 424.3100n -0.000200 424.3200n -0.000127 424.3300n -0.000061 424.3400n -0.000002
+ 424.3500n 0.000048 424.3600n 0.000088 424.3700n 0.000116 424.3800n 0.000133 424.3900n 0.000137 424.4000n 0.000128 424.4100n 0.000106 424.4200n 0.000072 424.4300n 0.000026 424.4400n -0.000032 424.4500n -0.000100 424.4600n -0.000177 424.4700n -0.000262 424.4800n -0.000354 424.4900n -0.000450
+ 424.5000n -0.000550 424.5100n -0.000651 424.5200n -0.000751 424.5300n -0.000850 424.5400n -0.000945 424.5500n -0.001035 424.5600n -0.001118 424.5700n -0.001193 424.5800n -0.001260 424.5900n -0.001317 424.6000n -0.001364 424.6100n -0.001401 424.6200n -0.001427 424.6300n -0.001443 424.6400n -0.001449
+ 424.6500n -0.001446 424.6600n -0.001434 424.6700n -0.001414 424.6800n -0.001388 424.6900n -0.001357 424.7000n -0.001322 424.7100n -0.001285 424.7200n -0.001247 424.7300n -0.001209 424.7400n -0.001172 424.7500n -0.001139 424.7600n -0.001109 424.7700n -0.001084 424.7800n -0.001065 424.7900n -0.001052
+ 424.8000n -0.001045 424.8100n -0.001044 424.8200n -0.001051 424.8300n -0.001063 424.8400n -0.001080 424.8500n -0.001102 424.8600n -0.001128 424.8700n -0.001157 424.8800n -0.001187 424.8900n -0.001216 424.9000n -0.001245 424.9100n -0.001270 424.9200n -0.001291 424.9300n -0.001306 424.9400n -0.001314
+ 424.9500n -0.001314 424.9600n -0.001305 424.9700n -0.001285 424.9800n -0.001254 424.9900n -0.001211 425.0000n -0.001157 425.0100n -0.001091 425.0200n -0.001013 425.0300n -0.000925 425.0400n -0.000826 425.0500n -0.000717 425.0600n -0.000600 425.0700n -0.000476 425.0800n -0.000347 425.0900n -0.000213
+ 425.1000n -0.000078 425.1100n 0.000059 425.1200n 0.000194 425.1300n 0.000326 425.1400n 0.000453 425.1500n 0.000574 425.1600n 0.000688 425.1700n 0.000792 425.1800n 0.000886 425.1900n 0.000969 425.2000n 0.001040 425.2100n 0.001099 425.2200n 0.001144 425.2300n 0.001177 425.2400n 0.001197
+ 425.2500n 0.001205 425.2600n 0.001201 425.2700n 0.001186 425.2800n 0.001162 425.2900n 0.001128 425.3000n 0.001087 425.3100n 0.001040 425.3200n 0.000988 425.3300n 0.000933 425.3400n 0.000875 425.3500n 0.000817 425.3600n 0.000760 425.3700n 0.000704 425.3800n 0.000652 425.3900n 0.000604
+ 425.4000n 0.000562 425.4100n 0.000524 425.4200n 0.000494 425.4300n 0.000470 425.4400n 0.000453 425.4500n 0.000443 425.4600n 0.000440 425.4700n 0.000444 425.4800n 0.000454 425.4900n 0.000471 425.5000n 0.000493 425.5100n 0.000519 425.5200n 0.000550 425.5300n 0.000584 425.5400n 0.000621
+ 425.5500n 0.000660 425.5600n 0.000700 425.5700n 0.000741 425.5800n 0.000781 425.5900n 0.000822 425.6000n 0.000861 425.6100n 0.000898 425.6200n 0.000934 425.6300n 0.000967 425.6400n 0.000998 425.6500n 0.001026 425.6600n 0.001052 425.6700n 0.001075 425.6800n 0.001095 425.6900n 0.001113
+ 425.7000n 0.001127 425.7100n 0.001139 425.7200n 0.001148 425.7300n 0.001153 425.7400n 0.001156 425.7500n 0.001155 425.7600n 0.001150 425.7700n 0.001141 425.7800n 0.001129 425.7900n 0.001111 425.8000n 0.001089 425.8100n 0.001061 425.8200n 0.001027 425.8300n 0.000987 425.8400n 0.000940
+ 425.8500n 0.000886 425.8600n 0.000825 425.8700n 0.000756 425.8800n 0.000678 425.8900n 0.000593 425.9000n 0.000500 425.9100n 0.000400 425.9200n 0.000292 425.9300n 0.000177 425.9400n 0.000057 425.9500n -0.000069 425.9600n -0.000198 425.9700n -0.000330 425.9800n -0.000464 425.9900n -0.000597
+ 426.0000n -0.000728 426.0100n -0.000856 426.0200n -0.000978 426.0300n -0.001093 426.0400n -0.001199 426.0500n -0.001294 426.0600n -0.001376 426.0700n -0.001444 426.0800n -0.001497 426.0900n -0.001533 426.1000n -0.001551 426.1100n -0.001550 426.1200n -0.001530 426.1300n -0.001491 426.1400n -0.001431
+ 426.1500n -0.001353 426.1600n -0.001257 426.1700n -0.001142 426.1800n -0.001012 426.1900n -0.000867 426.2000n -0.000709 426.2100n -0.000541 426.2200n -0.000364 426.2300n -0.000181 426.2400n 0.000006 426.2500n 0.000193 426.2600n 0.000378 426.2700n 0.000559 426.2800n 0.000733 426.2900n 0.000896
+ 426.3000n 0.001048 426.3100n 0.001185 426.3200n 0.001306 426.3300n 0.001409 426.3400n 0.001493 426.3500n 0.001557 426.3600n 0.001599 426.3700n 0.001620 426.3800n 0.001619 426.3900n 0.001597 426.4000n 0.001555 426.4100n 0.001494 426.4200n 0.001415 426.4300n 0.001319 426.4400n 0.001209
+ 426.4500n 0.001086 426.4600n 0.000954 426.4700n 0.000814 426.4800n 0.000668 426.4900n 0.000520 426.5000n 0.000373 426.5100n 0.000227 426.5200n 0.000087 426.5300n -0.000047 426.5400n -0.000171 426.5500n -0.000284 426.5600n -0.000384 426.5700n -0.000471 426.5800n -0.000542 426.5900n -0.000597
+ 426.6000n -0.000635 426.6100n -0.000657 426.6200n -0.000662 426.6300n -0.000650 426.6400n -0.000622 426.6500n -0.000579 426.6600n -0.000522 426.6700n -0.000452 426.6800n -0.000371 426.6900n -0.000279 426.7000n -0.000179 426.7100n -0.000072 426.7200n 0.000041 426.7300n 0.000158 426.7400n 0.000276
+ 426.7500n 0.000396 426.7600n 0.000515 426.7700n 0.000631 426.7800n 0.000745 426.7900n 0.000854 426.8000n 0.000959 426.8100n 0.001057 426.8200n 0.001149 426.8300n 0.001233 426.8400n 0.001311 426.8500n 0.001381 426.8600n 0.001443 426.8700n 0.001498 426.8800n 0.001545 426.8900n 0.001584
+ 426.9000n 0.001617 426.9100n 0.001643 426.9200n 0.001662 426.9300n 0.001675 426.9400n 0.001682 426.9500n 0.001684 426.9600n 0.001681 426.9700n 0.001672 426.9800n 0.001659 426.9900n 0.001642 427.0000n 0.001620 427.0100n 0.001595 427.0200n 0.001565 427.0300n 0.001533 427.0400n 0.001497
+ 427.0500n 0.001458 427.0600n 0.001416 427.0700n 0.001372 427.0800n 0.001326 427.0900n 0.001278 427.1000n 0.001228 427.1100n 0.001177 427.1200n 0.001126 427.1300n 0.001075 427.1400n 0.001025 427.1500n 0.000975 427.1600n 0.000928 427.1700n 0.000882 427.1800n 0.000840 427.1900n 0.000801
+ 427.2000n 0.000766 427.2100n 0.000735 427.2200n 0.000709 427.2300n 0.000688 427.2400n 0.000672 427.2500n 0.000662 427.2600n 0.000656 427.2700n 0.000655 427.2800n 0.000658 427.2900n 0.000665 427.3000n 0.000675 427.3100n 0.000687 427.3200n 0.000701 427.3300n 0.000714 427.3400n 0.000727
+ 427.3500n 0.000736 427.3600n 0.000743 427.3700n 0.000744 427.3800n 0.000739 427.3900n 0.000726 427.4000n 0.000705 427.4100n 0.000674 427.4200n 0.000633 427.4300n 0.000581 427.4400n 0.000518 427.4500n 0.000444 427.4600n 0.000358 427.4700n 0.000262 427.4800n 0.000157 427.4900n 0.000042
+ 427.5000n -0.000079 427.5100n -0.000206 427.5200n -0.000337 427.5300n -0.000468 427.5400n -0.000598 427.5500n -0.000724 427.5600n -0.000844 427.5700n -0.000953 427.5800n -0.001051 427.5900n -0.001132 427.6000n -0.001196 427.6100n -0.001239 427.6200n -0.001260 427.6300n -0.001255 427.6400n -0.001224
+ 427.6500n -0.001165 427.6600n -0.001078 427.6700n -0.000962 427.6800n -0.000817 427.6900n -0.000644 427.7000n -0.000445 427.7100n -0.000220 427.7200n 0.000027 427.7300n 0.000293 427.7400n 0.000576 427.7500n 0.000872 427.7600n 0.001176 427.7700n 0.001484 427.7800n 0.001792 427.7900n 0.002096
+ 427.8000n 0.002389 427.8100n 0.002668 427.8200n 0.002927 427.8300n 0.003164 427.8400n 0.003372 427.8500n 0.003550 427.8600n 0.003693 427.8700n 0.003799 427.8800n 0.003866 427.8900n 0.003891 427.9000n 0.003876 427.9100n 0.003819 427.9200n 0.003721 427.9300n 0.003583 427.9400n 0.003408
+ 427.9500n 0.003198 427.9600n 0.002957 427.9700n 0.002688 427.9800n 0.002396 427.9900n 0.002085 428.0000n 0.001761 428.0100n 0.001429 428.0200n 0.001094 428.0300n 0.000762 428.0400n 0.000438 428.0500n 0.000127 428.0600n -0.000166 428.0700n -0.000436 428.0800n -0.000680 428.0900n -0.000894
+ 428.1000n -0.001075 428.1100n -0.001222 428.1200n -0.001333 428.1300n -0.001407 428.1400n -0.001444 428.1500n -0.001446 428.1600n -0.001414 428.1700n -0.001350 428.1800n -0.001257 428.1900n -0.001138 428.2000n -0.000999 428.2100n -0.000842 428.2200n -0.000673 428.2300n -0.000497 428.2400n -0.000318
+ 428.2500n -0.000142 428.2600n 0.000026 428.2700n 0.000183 428.2800n 0.000323 428.2900n 0.000443 428.3000n 0.000539 428.3100n 0.000608 428.3200n 0.000649 428.3300n 0.000659 428.3400n 0.000639 428.3500n 0.000587 428.3600n 0.000505 428.3700n 0.000395 428.3800n 0.000257 428.3900n 0.000095
+ 428.4000n -0.000087 428.4100n -0.000287 428.4200n -0.000499 428.4300n -0.000720 428.4400n -0.000944 428.4500n -0.001167 428.4600n -0.001383 428.4700n -0.001589 428.4800n -0.001779 428.4900n -0.001948 428.5000n -0.002094 428.5100n -0.002213 428.5200n -0.002301 428.5300n -0.002357 428.5400n -0.002378
+ 428.5500n -0.002365 428.5600n -0.002316 428.5700n -0.002233 428.5800n -0.002116 428.5900n -0.001968 428.6000n -0.001791 428.6100n -0.001587 428.6200n -0.001362 428.6300n -0.001118 428.6400n -0.000860 428.6500n -0.000592 428.6600n -0.000320 428.6700n -0.000049 428.6800n 0.000218 428.6900n 0.000475
+ 428.7000n 0.000717 428.7100n 0.000942 428.7200n 0.001145 428.7300n 0.001324 428.7400n 0.001475 428.7500n 0.001597 428.7600n 0.001688 428.7700n 0.001747 428.7800n 0.001775 428.7900n 0.001773 428.8000n 0.001740 428.8100n 0.001680 428.8200n 0.001594 428.8300n 0.001485 428.8400n 0.001357
+ 428.8500n 0.001213 428.8600n 0.001056 428.8700n 0.000890 428.8800n 0.000720 428.8900n 0.000549 428.9000n 0.000382 428.9100n 0.000221 428.9200n 0.000070 428.9300n -0.000067 428.9400n -0.000189 428.9500n -0.000293 428.9600n -0.000378 428.9700n -0.000441 428.9800n -0.000484 428.9900n -0.000505
+ 429.0000n -0.000505 429.0100n -0.000484 429.0200n -0.000445 429.0300n -0.000389 429.0400n -0.000318 429.0500n -0.000235 429.0600n -0.000141 429.0700n -0.000041 429.0800n 0.000064 429.0900n 0.000170 429.1000n 0.000274 429.1100n 0.000375 429.1200n 0.000469 429.1300n 0.000553 429.1400n 0.000627
+ 429.1500n 0.000689 429.1600n 0.000737 429.1700n 0.000771 429.1800n 0.000790 429.1900n 0.000794 429.2000n 0.000784 429.2100n 0.000760 429.2200n 0.000725 429.2300n 0.000679 429.2400n 0.000624 429.2500n 0.000561 429.2600n 0.000495 429.2700n 0.000426 429.2800n 0.000356 429.2900n 0.000289
+ 429.3000n 0.000226 429.3100n 0.000170 429.3200n 0.000122 429.3300n 0.000084 429.3400n 0.000057 429.3500n 0.000042 429.3600n 0.000040 429.3700n 0.000051 429.3800n 0.000075 429.3900n 0.000112 429.4000n 0.000161 429.4100n 0.000220 429.4200n 0.000288 429.4300n 0.000364 429.4400n 0.000446
+ 429.4500n 0.000531 429.4600n 0.000618 429.4700n 0.000704 429.4800n 0.000787 429.4900n 0.000865 429.5000n 0.000935 429.5100n 0.000997 429.5200n 0.001049 429.5300n 0.001088 429.5400n 0.001115 429.5500n 0.001128 429.5600n 0.001127 429.5700n 0.001112 429.5800n 0.001084 429.5900n 0.001042
+ 429.6000n 0.000989 429.6100n 0.000924 429.6200n 0.000851 429.6300n 0.000771 429.6400n 0.000685 429.6500n 0.000597 429.6600n 0.000507 429.6700n 0.000419 429.6800n 0.000334 429.6900n 0.000255 429.7000n 0.000183 429.7100n 0.000120 429.7200n 0.000068 429.7300n 0.000028 429.7400n 0.000000
+ 429.7500n -0.000014 429.7600n -0.000015 429.7700n -0.000003 429.7800n 0.000022 429.7900n 0.000059 429.8000n 0.000106 429.8100n 0.000163 429.8200n 0.000227 429.8300n 0.000296 429.8400n 0.000368 429.8500n 0.000442 429.8600n 0.000515 429.8700n 0.000584 429.8800n 0.000648 429.8900n 0.000704
+ 429.9000n 0.000750 429.9100n 0.000786 429.9200n 0.000809 429.9300n 0.000819 429.9400n 0.000814 429.9500n 0.000795 429.9600n 0.000761 429.9700n 0.000713 429.9800n 0.000651 429.9900n 0.000578 430.0000n 0.000493 430.0100n 0.000400 430.0200n 0.000299 430.0300n 0.000194 430.0400n 0.000086
+ 430.0500n -0.000022 430.0600n -0.000127 430.0700n -0.000227 430.0800n -0.000319 430.0900n -0.000402 430.1000n -0.000473 430.1100n -0.000530 430.1200n -0.000572 430.1300n -0.000597 430.1400n -0.000605 430.1500n -0.000596 430.1600n -0.000568 430.1700n -0.000523 430.1800n -0.000461 430.1900n -0.000384
+ 430.2000n -0.000293 430.2100n -0.000190 430.2200n -0.000077 430.2300n 0.000044 430.2400n 0.000169 430.2500n 0.000297 430.2600n 0.000425 430.2700n 0.000549 430.2800n 0.000667 430.2900n 0.000777 430.3000n 0.000876 430.3100n 0.000961 430.3200n 0.001032 430.3300n 0.001085 430.3400n 0.001121
+ 430.3500n 0.001138 430.3600n 0.001137 430.3700n 0.001116 430.3800n 0.001077 430.3900n 0.001020 430.4000n 0.000948 430.4100n 0.000860 430.4200n 0.000760 430.4300n 0.000649 430.4400n 0.000531 430.4500n 0.000408 430.4600n 0.000282 430.4700n 0.000157 430.4800n 0.000035 430.4900n -0.000081
+ 430.5000n -0.000189 430.5100n -0.000285 430.5200n -0.000367 430.5300n -0.000435 430.5400n -0.000486 430.5500n -0.000518 430.5600n -0.000532 430.5700n -0.000527 430.5800n -0.000503 430.5900n -0.000460 430.6000n -0.000400 430.6100n -0.000323 430.6200n -0.000231 430.6300n -0.000126 430.6400n -0.000010
+ 430.6500n 0.000114 430.6600n 0.000244 430.6700n 0.000378 430.6800n 0.000511 430.6900n 0.000643 430.7000n 0.000769 430.7100n 0.000888 430.7200n 0.000998 430.7300n 0.001095 430.7400n 0.001178 430.7500n 0.001246 430.7600n 0.001297 430.7700n 0.001330 430.7800n 0.001346 430.7900n 0.001343
+ 430.8000n 0.001322 430.8100n 0.001283 430.8200n 0.001227 430.8300n 0.001155 430.8400n 0.001070 430.8500n 0.000971 430.8600n 0.000862 430.8700n 0.000743 430.8800n 0.000618 430.8900n 0.000487 430.9000n 0.000354 430.9100n 0.000219 430.9200n 0.000085 430.9300n -0.000046 430.9400n -0.000174
+ 430.9500n -0.000296 430.9600n -0.000412 430.9700n -0.000522 430.9800n -0.000624 430.9900n -0.000718 431.0000n -0.000805 431.0100n -0.000885 431.0200n -0.000958 431.0300n -0.001025 431.0400n -0.001087 431.0500n -0.001145 431.0600n -0.001201 431.0700n -0.001255 431.0800n -0.001309 431.0900n -0.001364
+ 431.1000n -0.001421 431.1100n -0.001481 431.1200n -0.001546 431.1300n -0.001616 431.1400n -0.001691 431.1500n -0.001771 431.1600n -0.001857 431.1700n -0.001949 431.1800n -0.002045 431.1900n -0.002145 431.2000n -0.002247 431.2100n -0.002351 431.2200n -0.002454 431.2300n -0.002555 431.2400n -0.002651
+ 431.2500n -0.002741 431.2600n -0.002822 431.2700n -0.002891 431.2800n -0.002947 431.2900n -0.002987 431.3000n -0.003009 431.3100n -0.003010 431.3200n -0.002990 431.3300n -0.002945 431.3400n -0.002876 431.3500n -0.002780 431.3600n -0.002658 431.3700n -0.002508 431.3800n -0.002332 431.3900n -0.002128
+ 431.4000n -0.001899 431.4100n -0.001645 431.4200n -0.001369 431.4300n -0.001071 431.4400n -0.000754 431.4500n -0.000421 431.4600n -0.000075 431.4700n 0.000281 431.4800n 0.000644 431.4900n 0.001010 431.5000n 0.001376 431.5100n 0.001739 431.5200n 0.002094 431.5300n 0.002438 431.5400n 0.002768
+ 431.5500n 0.003080 431.5600n 0.003371 431.5700n 0.003639 431.5800n 0.003880 431.5900n 0.004093 431.6000n 0.004276 431.6100n 0.004427 431.6200n 0.004544 431.6300n 0.004627 431.6400n 0.004676 431.6500n 0.004690 431.6600n 0.004670 431.6700n 0.004616 431.6800n 0.004530 431.6900n 0.004412
+ 431.7000n 0.004265 431.7100n 0.004091 431.7200n 0.003891 431.7300n 0.003669 431.7400n 0.003427 431.7500n 0.003168 431.7600n 0.002894 431.7700n 0.002611 431.7800n 0.002319 431.7900n 0.002024 431.8000n 0.001728 431.8100n 0.001433 431.8200n 0.001145 431.8300n 0.000865 431.8400n 0.000597
+ 431.8500n 0.000343 431.8600n 0.000106 431.8700n -0.000111 431.8800n -0.000306 431.8900n -0.000478 431.9000n -0.000625 431.9100n -0.000745 431.9200n -0.000837 431.9300n -0.000901 431.9400n -0.000936 431.9500n -0.000942 431.9600n -0.000918 431.9700n -0.000867 431.9800n -0.000789 431.9900n -0.000684
+ 432.0000n -0.000554 432.0100n -0.000402 432.0200n -0.000229 432.0300n -0.000038 432.0400n 0.000170 432.0500n 0.000390 432.0600n 0.000620 432.0700n 0.000858 432.0800n 0.001099 432.0900n 0.001342 432.1000n 0.001582 432.1100n 0.001816 432.1200n 0.002041 432.1300n 0.002255 432.1400n 0.002454
+ 432.1500n 0.002636 432.1600n 0.002798 432.1700n 0.002939 432.1800n 0.003056 432.1900n 0.003148 432.2000n 0.003214 432.2100n 0.003254 432.2200n 0.003266 432.2300n 0.003252 432.2400n 0.003211 432.2500n 0.003145 432.2600n 0.003055 432.2700n 0.002943 432.2800n 0.002810 432.2900n 0.002660
+ 432.3000n 0.002494 432.3100n 0.002315 432.3200n 0.002127 432.3300n 0.001933 432.3400n 0.001736 432.3500n 0.001539 432.3600n 0.001346 432.3700n 0.001160 432.3800n 0.000983 432.3900n 0.000818 432.4000n 0.000669 432.4100n 0.000537 432.4200n 0.000424 432.4300n 0.000331 432.4400n 0.000260
+ 432.4500n 0.000212 432.4600n 0.000185 432.4700n 0.000182 432.4800n 0.000200 432.4900n 0.000238 432.5000n 0.000296 432.5100n 0.000371 432.5200n 0.000461 432.5300n 0.000564 432.5400n 0.000676 432.5500n 0.000796 432.5600n 0.000920 432.5700n 0.001044 432.5800n 0.001166 432.5900n 0.001284
+ 432.6000n 0.001393 432.6100n 0.001491 432.6200n 0.001577 432.6300n 0.001647 432.6400n 0.001699 432.6500n 0.001733 432.6600n 0.001747 432.6700n 0.001741 432.6800n 0.001714 432.6900n 0.001666 432.7000n 0.001598 432.7100n 0.001512 432.7200n 0.001408 432.7300n 0.001288 432.7400n 0.001154
+ 432.7500n 0.001009 432.7600n 0.000855 432.7700n 0.000695 432.7800n 0.000531 432.7900n 0.000367 432.8000n 0.000205 432.8100n 0.000047 432.8200n -0.000103 432.8300n -0.000243 432.8400n -0.000371 432.8500n -0.000486 432.8600n -0.000585 432.8700n -0.000667 432.8800n -0.000733 432.8900n -0.000780
+ 432.9000n -0.000810 432.9100n -0.000823 432.9200n -0.000818 432.9300n -0.000798 432.9400n -0.000764 432.9500n -0.000716 432.9600n -0.000658 432.9700n -0.000590 432.9800n -0.000515 432.9900n -0.000435 433.0000n -0.000353 433.0100n -0.000270 433.0200n -0.000189 433.0300n -0.000111 433.0400n -0.000037
+ 433.0500n 0.000029 433.0600n 0.000088 433.0700n 0.000138 433.0800n 0.000179 433.0900n 0.000210 433.1000n 0.000232 433.1100n 0.000244 433.1200n 0.000247 433.1300n 0.000243 433.1400n 0.000232 433.1500n 0.000216 433.1600n 0.000196 433.1700n 0.000173 433.1800n 0.000150 433.1900n 0.000128
+ 433.2000n 0.000108 433.2100n 0.000093 433.2200n 0.000084 433.2300n 0.000081 433.2400n 0.000086 433.2500n 0.000100 433.2600n 0.000123 433.2700n 0.000156 433.2800n 0.000198 433.2900n 0.000248 433.3000n 0.000307 433.3100n 0.000373 433.3200n 0.000444 433.3300n 0.000519 433.3400n 0.000597
+ 433.3500n 0.000675 433.3600n 0.000751 433.3700n 0.000823 433.3800n 0.000889 433.3900n 0.000948 433.4000n 0.000996 433.4100n 0.001032 433.4200n 0.001055 433.4300n 0.001062 433.4400n 0.001054 433.4500n 0.001030 433.4600n 0.000989 433.4700n 0.000930 433.4800n 0.000856 433.4900n 0.000766
+ 433.5000n 0.000663 433.5100n 0.000547 433.5200n 0.000420 433.5300n 0.000286 433.5400n 0.000146 433.5500n 0.000003 433.5600n -0.000139 433.5700n -0.000277 433.5800n -0.000409 433.5900n -0.000532 433.6000n -0.000641 433.6100n -0.000736 433.6200n -0.000812 433.6300n -0.000868 433.6400n -0.000903
+ 433.6500n -0.000914 433.6600n -0.000900 433.6700n -0.000862 433.6800n -0.000798 433.6900n -0.000710 433.7000n -0.000598 433.7100n -0.000465 433.7200n -0.000311 433.7300n -0.000139 433.7400n 0.000048 433.7500n 0.000247 433.7600n 0.000455 433.7700n 0.000668 433.7800n 0.000882 433.7900n 0.001094
+ 433.8000n 0.001300 433.8100n 0.001496 433.8200n 0.001678 433.8300n 0.001845 433.8400n 0.001991 433.8500n 0.002116 433.8600n 0.002216 433.8700n 0.002291 433.8800n 0.002338 433.8900n 0.002357 433.9000n 0.002348 433.9100n 0.002311 433.9200n 0.002247 433.9300n 0.002157 433.9400n 0.002042
+ 433.9500n 0.001906 433.9600n 0.001751 433.9700n 0.001579 433.9800n 0.001394 433.9900n 0.001198 434.0000n 0.000995 434.0100n 0.000789 434.0200n 0.000583 434.0300n 0.000380 434.0400n 0.000183 434.0500n -0.000005 434.0600n -0.000182 434.0700n -0.000345 434.0800n -0.000492 434.0900n -0.000622
+ 434.1000n -0.000735 434.1100n -0.000829 434.1200n -0.000905 434.1300n -0.000962 434.1400n -0.001001 434.1500n -0.001024 434.1600n -0.001032 434.1700n -0.001025 434.1800n -0.001007 434.1900n -0.000980 434.2000n -0.000944 434.2100n -0.000904 434.2200n -0.000859 434.2300n -0.000814 434.2400n -0.000769
+ 434.2500n -0.000727 434.2600n -0.000689 434.2700n -0.000656 434.2800n -0.000629 434.2900n -0.000610 434.3000n -0.000597 434.3100n -0.000592 434.3200n -0.000595 434.3300n -0.000603 434.3400n -0.000617 434.3500n -0.000636 434.3600n -0.000658 434.3700n -0.000681 434.3800n -0.000704 434.3900n -0.000726
+ 434.4000n -0.000744 434.4100n -0.000756 434.4200n -0.000763 434.4300n -0.000761 434.4400n -0.000750 434.4500n -0.000729 434.4600n -0.000697 434.4700n -0.000654 434.4800n -0.000600 434.4900n -0.000536 434.5000n -0.000462 434.5100n -0.000379 434.5200n -0.000289 434.5300n -0.000193 434.5400n -0.000094
+ 434.5500n 0.000007 434.5600n 0.000107 434.5700n 0.000202 434.5800n 0.000292 434.5900n 0.000373 434.6000n 0.000442 434.6100n 0.000497 434.6200n 0.000537 434.6300n 0.000558 434.6400n 0.000561 434.6500n 0.000542 434.6600n 0.000502 434.6700n 0.000439 434.6800n 0.000355 434.6900n 0.000249
+ 434.7000n 0.000123 434.7100n -0.000022 434.7200n -0.000184 434.7300n -0.000361 434.7400n -0.000550 434.7500n -0.000747 434.7600n -0.000950 434.7700n -0.001154 434.7800n -0.001357 434.7900n -0.001553 434.8000n -0.001740 434.8100n -0.001914 434.8200n -0.002071 434.8300n -0.002207 434.8400n -0.002320
+ 434.8500n -0.002407 434.8600n -0.002466 434.8700n -0.002494 434.8800n -0.002491 434.8900n -0.002456 434.9000n -0.002388 434.9100n -0.002288 434.9200n -0.002157 434.9300n -0.001997 434.9400n -0.001809 434.9500n -0.001595 434.9600n -0.001360 434.9700n -0.001105 434.9800n -0.000835 434.9900n -0.000553
+ 435.0000n -0.000264 435.0100n 0.000029 435.0200n 0.000321 435.0300n 0.000609 435.0400n 0.000888 435.0500n 0.001155 435.0600n 0.001406 435.0700n 0.001638 435.0800n 0.001849 435.0900n 0.002035 435.1000n 0.002196 435.1100n 0.002329 435.1200n 0.002434 435.1300n 0.002511 435.1400n 0.002559
+ 435.1500n 0.002579 435.1600n 0.002571 435.1700n 0.002538 435.1800n 0.002481 435.1900n 0.002402 435.2000n 0.002304 435.2100n 0.002188 435.2200n 0.002058 435.2300n 0.001916 435.2400n 0.001765 435.2500n 0.001608 435.2600n 0.001448 435.2700n 0.001286 435.2800n 0.001127 435.2900n 0.000971
+ 435.3000n 0.000821 435.3100n 0.000678 435.3200n 0.000544 435.3300n 0.000419 435.3400n 0.000306 435.3500n 0.000204 435.3600n 0.000113 435.3700n 0.000034 435.3800n -0.000033 435.3900n -0.000090 435.4000n -0.000135 435.4100n -0.000171 435.4200n -0.000198 435.4300n -0.000216 435.4400n -0.000226
+ 435.4500n -0.000230 435.4600n -0.000228 435.4700n -0.000220 435.4800n -0.000207 435.4900n -0.000190 435.5000n -0.000169 435.5100n -0.000145 435.5200n -0.000116 435.5300n -0.000084 435.5400n -0.000048 435.5500n -0.000009 435.5600n 0.000035 435.5700n 0.000083 435.5800n 0.000136 435.5900n 0.000193
+ 435.6000n 0.000256 435.6100n 0.000324 435.6200n 0.000397 435.6300n 0.000476 435.6400n 0.000559 435.6500n 0.000647 435.6600n 0.000739 435.6700n 0.000833 435.6800n 0.000930 435.6900n 0.001027 435.7000n 0.001124 435.7100n 0.001219 435.7200n 0.001310 435.7300n 0.001396 435.7400n 0.001474
+ 435.7500n 0.001544 435.7600n 0.001602 435.7700n 0.001648 435.7800n 0.001679 435.7900n 0.001695 435.8000n 0.001694 435.8100n 0.001674 435.8200n 0.001635 435.8300n 0.001577 435.8400n 0.001500 435.8500n 0.001403 435.8600n 0.001287 435.8700n 0.001154 435.8800n 0.001004 435.8900n 0.000839
+ 435.9000n 0.000662 435.9100n 0.000474 435.9200n 0.000279 435.9300n 0.000079 435.9400n -0.000123 435.9500n -0.000324 435.9600n -0.000520 435.9700n -0.000709 435.9800n -0.000886 435.9900n -0.001050 436.0000n -0.001197 436.0100n -0.001325 436.0200n -0.001431 436.0300n -0.001514 436.0400n -0.001573
+ 436.0500n -0.001605 436.0600n -0.001611 436.0700n -0.001591 436.0800n -0.001545 436.0900n -0.001474 436.1000n -0.001379 436.1100n -0.001263 436.1200n -0.001127 436.1300n -0.000975 436.1400n -0.000810 436.1500n -0.000634 436.1600n -0.000451 436.1700n -0.000265 436.1800n -0.000080 436.1900n 0.000100
+ 436.2000n 0.000273 436.2100n 0.000434 436.2200n 0.000581 436.2300n 0.000710 436.2400n 0.000818 436.2500n 0.000905 436.2600n 0.000967 436.2700n 0.001004 436.2800n 0.001015 436.2900n 0.001000 436.3000n 0.000959 436.3100n 0.000892 436.3200n 0.000802 436.3300n 0.000690 436.3400n 0.000559
+ 436.3500n 0.000410 436.3600n 0.000247 436.3700n 0.000073 436.3800n -0.000109 436.3900n -0.000295 436.4000n -0.000482 436.4100n -0.000666 436.4200n -0.000844 436.4300n -0.001012 436.4400n -0.001168 436.4500n -0.001309 436.4600n -0.001433 436.4700n -0.001538 436.4800n -0.001621 436.4900n -0.001683
+ 436.5000n -0.001722 436.5100n -0.001739 436.5200n -0.001733 436.5300n -0.001706 436.5400n -0.001658 436.5500n -0.001591 436.5600n -0.001507 436.5700n -0.001409 436.5800n -0.001298 436.5900n -0.001177 436.6000n -0.001048 436.6100n -0.000915 436.6200n -0.000780 436.6300n -0.000646 436.6400n -0.000515
+ 436.6500n -0.000390 436.6600n -0.000272 436.6700n -0.000163 436.6800n -0.000066 436.6900n 0.000020 436.7000n 0.000094 436.7100n 0.000154 436.7200n 0.000202 436.7300n 0.000236 436.7400n 0.000259 436.7500n 0.000271 436.7600n 0.000273 436.7700n 0.000267 436.7800n 0.000254 436.7900n 0.000236
+ 436.8000n 0.000216 436.8100n 0.000194 436.8200n 0.000174 436.8300n 0.000156 436.8400n 0.000143 436.8500n 0.000136 436.8600n 0.000137 436.8700n 0.000147 436.8800n 0.000165 436.8900n 0.000194 436.9000n 0.000234 436.9100n 0.000283 436.9200n 0.000343 436.9300n 0.000411 436.9400n 0.000488
+ 436.9500n 0.000572 436.9600n 0.000661 436.9700n 0.000755 436.9800n 0.000851 436.9900n 0.000946 437.0000n 0.001041 437.0100n 0.001131 437.0200n 0.001216 437.0300n 0.001293 437.0400n 0.001360 437.0500n 0.001417 437.0600n 0.001461 437.0700n 0.001491 437.0800n 0.001507 437.0900n 0.001507
+ 437.1000n 0.001492 437.1100n 0.001460 437.1200n 0.001413 437.1300n 0.001350 437.1400n 0.001272 437.1500n 0.001181 437.1600n 0.001077 437.1700n 0.000961 437.1800n 0.000836 437.1900n 0.000703 437.2000n 0.000564 437.2100n 0.000420 437.2200n 0.000273 437.2300n 0.000125 437.2400n -0.000021
+ 437.2500n -0.000166 437.2600n -0.000306 437.2700n -0.000440 437.2800n -0.000568 437.2900n -0.000687 437.3000n -0.000798 437.3100n -0.000899 437.3200n -0.000989 437.3300n -0.001069 437.3400n -0.001138 437.3500n -0.001195 437.3600n -0.001242 437.3700n -0.001277 437.3800n -0.001302 437.3900n -0.001317
+ 437.4000n -0.001321 437.4100n -0.001316 437.4200n -0.001303 437.4300n -0.001280 437.4400n -0.001249 437.4500n -0.001211 437.4600n -0.001165 437.4700n -0.001112 437.4800n -0.001053 437.4900n -0.000987 437.5000n -0.000915 437.5100n -0.000836 437.5200n -0.000752 437.5300n -0.000662 437.5400n -0.000566
+ 437.5500n -0.000465 437.5600n -0.000359 437.5700n -0.000248 437.5800n -0.000133 437.5900n -0.000014 437.6000n 0.000108 437.6100n 0.000232 437.6200n 0.000358 437.6300n 0.000484 437.6400n 0.000610 437.6500n 0.000733 437.6600n 0.000853 437.6700n 0.000969 437.6800n 0.001077 437.6900n 0.001178
+ 437.7000n 0.001269 437.7100n 0.001348 437.7200n 0.001415 437.7300n 0.001468 437.7400n 0.001504 437.7500n 0.001525 437.7600n 0.001527 437.7700n 0.001511 437.7800n 0.001477 437.7900n 0.001423 437.8000n 0.001351 437.8100n 0.001260 437.8200n 0.001153 437.8300n 0.001029 437.8400n 0.000890
+ 437.8500n 0.000739 437.8600n 0.000577 437.8700n 0.000407 437.8800n 0.000232 437.8900n 0.000054 437.9000n -0.000124 437.9100n -0.000299 437.9200n -0.000467 437.9300n -0.000626 437.9400n -0.000773 437.9500n -0.000905 437.9600n -0.001020 437.9700n -0.001115 437.9800n -0.001189 437.9900n -0.001240
+ 438.0000n -0.001266 438.0100n -0.001269 438.0200n -0.001247 438.0300n -0.001201 438.0400n -0.001131 438.0500n -0.001040 438.0600n -0.000929 438.0700n -0.000800 438.0800n -0.000656 438.0900n -0.000501 438.1000n -0.000337 438.1100n -0.000168 438.1200n 0.000002 438.1300n 0.000169 438.1400n 0.000330
+ 438.1500n 0.000481 438.1600n 0.000617 438.1700n 0.000737 438.1800n 0.000836 438.1900n 0.000913 438.2000n 0.000964 438.2100n 0.000989 438.2200n 0.000986 438.2300n 0.000955 438.2400n 0.000895 438.2500n 0.000808 438.2600n 0.000694 438.2700n 0.000556 438.2800n 0.000395 438.2900n 0.000215
+ 438.3000n 0.000019 438.3100n -0.000190 438.3200n -0.000407 438.3300n -0.000628 438.3400n -0.000850 438.3500n -0.001067 438.3600n -0.001275 438.3700n -0.001470 438.3800n -0.001649 438.3900n -0.001807 438.4000n -0.001941 438.4100n -0.002049 438.4200n -0.002128 438.4300n -0.002177 438.4400n -0.002195
+ 438.4500n -0.002181 438.4600n -0.002136 438.4700n -0.002060 438.4800n -0.001955 438.4900n -0.001824 438.5000n -0.001670 438.5100n -0.001495 438.5200n -0.001303 438.5300n -0.001098 438.5400n -0.000885 438.5500n -0.000668 438.5600n -0.000452 438.5700n -0.000241 438.5800n -0.000040 438.5900n 0.000147
+ 438.6000n 0.000315 438.6100n 0.000463 438.6200n 0.000586 438.6300n 0.000682 438.6400n 0.000749 438.6500n 0.000786 438.6600n 0.000792 438.6700n 0.000767 438.6800n 0.000713 438.6900n 0.000630 438.7000n 0.000522 438.7100n 0.000389 438.7200n 0.000237 438.7300n 0.000068 438.7400n -0.000112
+ 438.7500n -0.000301 438.7600n -0.000492 438.7700n -0.000682 438.7800n -0.000866 438.7900n -0.001038 438.8000n -0.001194 438.8100n -0.001330 438.8200n -0.001442 438.8300n -0.001527 438.8400n -0.001581 438.8500n -0.001603 438.8600n -0.001592 438.8700n -0.001545 438.8800n -0.001463 438.8900n -0.001346
+ 438.9000n -0.001195 438.9100n -0.001013 438.9200n -0.000802 438.9300n -0.000564 438.9400n -0.000304 438.9500n -0.000026 438.9600n 0.000267 438.9700n 0.000568 438.9800n 0.000875 438.9900n 0.001180 439.0000n 0.001481 439.0100n 0.001771 439.0200n 0.002045 439.0300n 0.002301 439.0400n 0.002533
+ 439.0500n 0.002739 439.0600n 0.002914 439.0700n 0.003058 439.0800n 0.003167 439.0900n 0.003241 439.1000n 0.003279 439.1100n 0.003282 439.1200n 0.003249 439.1300n 0.003184 439.1400n 0.003086 439.1500n 0.002959 439.1600n 0.002806 439.1700n 0.002631 439.1800n 0.002435 439.1900n 0.002225
+ 439.2000n 0.002003 439.2100n 0.001774 439.2200n 0.001541 439.2300n 0.001310 439.2400n 0.001083 439.2500n 0.000865 439.2600n 0.000658 439.2700n 0.000465 439.2800n 0.000290 439.2900n 0.000134 439.3000n -0.000001 439.3100n -0.000114 439.3200n -0.000205 439.3300n -0.000273 439.3400n -0.000318
+ 439.3500n -0.000342 439.3600n -0.000345 439.3700n -0.000329 439.3800n -0.000295 439.3900n -0.000246 439.4000n -0.000185 439.4100n -0.000112 439.4200n -0.000032 439.4300n 0.000055 439.4400n 0.000144 439.4500n 0.000235 439.4600n 0.000324 439.4700n 0.000410 439.4800n 0.000491 439.4900n 0.000566
+ 439.5000n 0.000633 439.5100n 0.000692 439.5200n 0.000741 439.5300n 0.000780 439.5400n 0.000811 439.5500n 0.000831 439.5600n 0.000843 439.5700n 0.000847 439.5800n 0.000843 439.5900n 0.000833 439.6000n 0.000818 439.6100n 0.000799 439.6200n 0.000777 439.6300n 0.000753 439.6400n 0.000729
+ 439.6500n 0.000705 439.6600n 0.000682 439.6700n 0.000661 439.6800n 0.000642 439.6900n 0.000626 439.7000n 0.000613 439.7100n 0.000603 439.7200n 0.000595 439.7300n 0.000589 439.7400n 0.000585 439.7500n 0.000582 439.7600n 0.000578 439.7700n 0.000574 439.7800n 0.000567 439.7900n 0.000558
+ 439.8000n 0.000545 439.8100n 0.000526 439.8200n 0.000503 439.8300n 0.000473 439.8400n 0.000436 439.8500n 0.000392 439.8600n 0.000341 439.8700n 0.000284 439.8800n 0.000219 439.8900n 0.000148 439.9000n 0.000072 439.9100n -0.000008 439.9200n -0.000091 439.9300n -0.000176 439.9400n -0.000261
+ 439.9500n -0.000344 439.9600n -0.000424 439.9700n -0.000499 439.9800n -0.000568 439.9900n -0.000628 440.0000n -0.000678 440.0100n -0.000716 440.0200n -0.000742 440.0300n -0.000753 440.0400n -0.000750 440.0500n -0.000732 440.0600n -0.000699 440.0700n -0.000650 440.0800n -0.000586 440.0900n -0.000507
+ 440.1000n -0.000416 440.1100n -0.000312 440.1200n -0.000198 440.1300n -0.000075 440.1400n 0.000054 440.1500n 0.000187 440.1600n 0.000323 440.1700n 0.000457 440.1800n 0.000589 440.1900n 0.000715 440.2000n 0.000833 440.2100n 0.000940 440.2200n 0.001035 440.2300n 0.001115 440.2400n 0.001179
+ 440.2500n 0.001224 440.2600n 0.001251 440.2700n 0.001257 440.2800n 0.001242 440.2900n 0.001207 440.3000n 0.001152 440.3100n 0.001076 440.3200n 0.000981 440.3300n 0.000868 440.3400n 0.000738 440.3500n 0.000594 440.3600n 0.000437 440.3700n 0.000269 440.3800n 0.000094 440.3900n -0.000087
+ 440.4000n -0.000272 440.4100n -0.000456 440.4200n -0.000639 440.4300n -0.000816 440.4400n -0.000987 440.4500n -0.001148 440.4600n -0.001298 440.4700n -0.001435 440.4800n -0.001557 440.4900n -0.001663 440.5000n -0.001751 440.5100n -0.001821 440.5200n -0.001873 440.5300n -0.001905 440.5400n -0.001919
+ 440.5500n -0.001914 440.5600n -0.001891 440.5700n -0.001851 440.5800n -0.001795 440.5900n -0.001723 440.6000n -0.001638 440.6100n -0.001540 440.6200n -0.001431 440.6300n -0.001313 440.6400n -0.001187 440.6500n -0.001054 440.6600n -0.000916 440.6700n -0.000776 440.6800n -0.000633 440.6900n -0.000489
+ 440.7000n -0.000346 440.7100n -0.000205 440.7200n -0.000067 440.7300n 0.000068 440.7400n 0.000198 440.7500n 0.000323 440.7600n 0.000443 440.7700n 0.000556 440.7800n 0.000663 440.7900n 0.000763 440.8000n 0.000857 440.8100n 0.000943 440.8200n 0.001021 440.8300n 0.001092 440.8400n 0.001156
+ 440.8500n 0.001213 440.8600n 0.001261 440.8700n 0.001302 440.8800n 0.001336 440.8900n 0.001362 440.9000n 0.001380 440.9100n 0.001391 440.9200n 0.001394 440.9300n 0.001389 440.9400n 0.001377 440.9500n 0.001358 440.9600n 0.001332 440.9700n 0.001298 440.9800n 0.001258 440.9900n 0.001212
+ 441.0000n 0.001160 441.0100n 0.001102 441.0200n 0.001040 441.0300n 0.000973 441.0400n 0.000904 441.0500n 0.000832 441.0600n 0.000758 441.0700n 0.000684 441.0800n 0.000610 441.0900n 0.000538 441.1000n 0.000468 441.1100n 0.000402 441.1200n 0.000340 441.1300n 0.000284 441.1400n 0.000234
+ 441.1500n 0.000192 441.1600n 0.000158 441.1700n 0.000132 441.1800n 0.000115 441.1900n 0.000108 441.2000n 0.000111 441.2100n 0.000123 441.2200n 0.000144 441.2300n 0.000175 441.2400n 0.000214 441.2500n 0.000261 441.2600n 0.000316 441.2700n 0.000376 441.2800n 0.000442 441.2900n 0.000511
+ 441.3000n 0.000584 441.3100n 0.000657 441.3200n 0.000731 441.3300n 0.000804 441.3400n 0.000874 441.3500n 0.000941 441.3600n 0.001003 441.3700n 0.001058 441.3800n 0.001107 441.3900n 0.001148 441.4000n 0.001180 441.4100n 0.001203 441.4200n 0.001218 441.4300n 0.001222 441.4400n 0.001217
+ 441.4500n 0.001203 441.4600n 0.001180 441.4700n 0.001148 441.4800n 0.001109 441.4900n 0.001062 441.5000n 0.001009 441.5100n 0.000950 441.5200n 0.000887 441.5300n 0.000820 441.5400n 0.000751 441.5500n 0.000680 441.5600n 0.000608 441.5700n 0.000536 441.5800n 0.000465 441.5900n 0.000396
+ 441.6000n 0.000328 441.6100n 0.000263 441.6200n 0.000200 441.6300n 0.000140 441.6400n 0.000083 441.6500n 0.000029 441.6600n -0.000023 441.6700n -0.000073 441.6800n -0.000121 441.6900n -0.000168 441.7000n -0.000214 441.7100n -0.000259 441.7200n -0.000305 441.7300n -0.000352 441.7400n -0.000399
+ 441.7500n -0.000448 441.7600n -0.000499 441.7700n -0.000552 441.7800n -0.000607 441.7900n -0.000664 441.8000n -0.000722 441.8100n -0.000782 441.8200n -0.000843 441.8300n -0.000904 441.8400n -0.000965 441.8500n -0.001025 441.8600n -0.001082 441.8700n -0.001137 441.8800n -0.001188 441.8900n -0.001234
+ 441.9000n -0.001274 441.9100n -0.001308 441.9200n -0.001334 441.9300n -0.001352 441.9400n -0.001360 441.9500n -0.001360 441.9600n -0.001350 441.9700n -0.001330 441.9800n -0.001300 441.9900n -0.001261 442.0000n -0.001213 442.0100n -0.001156 442.0200n -0.001092 442.0300n -0.001022 442.0400n -0.000946
+ 442.0500n -0.000866 442.0600n -0.000784 442.0700n -0.000700 442.0800n -0.000617 442.0900n -0.000537 442.1000n -0.000459 442.1100n -0.000387 442.1200n -0.000320 442.1300n -0.000262 442.1400n -0.000211 442.1500n -0.000170 442.1600n -0.000139 442.1700n -0.000119 442.1800n -0.000108 442.1900n -0.000108
+ 442.2000n -0.000118 442.2100n -0.000137 442.2200n -0.000165 442.2300n -0.000199 442.2400n -0.000240 442.2500n -0.000284 442.2600n -0.000331 442.2700n -0.000379 442.2800n -0.000425 442.2900n -0.000469 442.3000n -0.000507 442.3100n -0.000539 442.3200n -0.000563 442.3300n -0.000576 442.3400n -0.000578
+ 442.3500n -0.000568 442.3600n -0.000544 442.3700n -0.000506 442.3800n -0.000455 442.3900n -0.000390 442.4000n -0.000311 442.4100n -0.000219 442.4200n -0.000116 442.4300n -0.000003 442.4400n 0.000118 442.4500n 0.000246 442.4600n 0.000378 442.4700n 0.000512 442.4800n 0.000644 442.4900n 0.000774
+ 442.5000n 0.000897 442.5100n 0.001011 442.5200n 0.001113 442.5300n 0.001202 442.5400n 0.001274 442.5500n 0.001328 442.5600n 0.001362 442.5700n 0.001374 442.5800n 0.001363 442.5900n 0.001329 442.6000n 0.001271 442.6100n 0.001188 442.6200n 0.001082 442.6300n 0.000953 442.6400n 0.000802
+ 442.6500n 0.000632 442.6600n 0.000442 442.6700n 0.000237 442.6800n 0.000018 442.6900n -0.000212 442.7000n -0.000451 442.7100n -0.000696 442.7200n -0.000943 442.7300n -0.001190 442.7400n -0.001434 442.7500n -0.001672 442.7600n -0.001902 442.7700n -0.002121 442.7800n -0.002328 442.7900n -0.002520
+ 442.8000n -0.002695 442.8100n -0.002854 442.8200n -0.002995 442.8300n -0.003117 442.8400n -0.003220 442.8500n -0.003305 442.8600n -0.003371 442.8700n -0.003421 442.8800n -0.003453 442.8900n -0.003471 442.9000n -0.003475 442.9100n -0.003466 442.9200n -0.003447 442.9300n -0.003419 442.9400n -0.003384
+ 442.9500n -0.003343 442.9600n -0.003297 442.9700n -0.003249 442.9800n -0.003199 442.9900n -0.003148 443.0000n -0.003098 443.0100n -0.003048 443.0200n -0.003000 443.0300n -0.002952 443.0400n -0.002906 443.0500n -0.002860 443.0600n -0.002815 443.0700n -0.002769 443.0800n -0.002721 443.0900n -0.002671
+ 443.1000n -0.002617 443.1100n -0.002558 443.1200n -0.002494 443.1300n -0.002422 443.1400n -0.002343 443.1500n -0.002254 443.1600n -0.002156 443.1700n -0.002048 443.1800n -0.001929 443.1900n -0.001799 443.2000n -0.001659 443.2100n -0.001509 443.2200n -0.001350 443.2300n -0.001181 443.2400n -0.001006
+ 443.2500n -0.000825 443.2600n -0.000639 443.2700n -0.000451 443.2800n -0.000262 443.2900n -0.000075 443.3000n 0.000109 443.3100n 0.000287 443.3200n 0.000458 443.3300n 0.000619 443.3400n 0.000769 443.3500n 0.000906 443.3600n 0.001029 443.3700n 0.001136 443.3800n 0.001226 443.3900n 0.001300
+ 443.4000n 0.001356 443.4100n 0.001394 443.4200n 0.001416 443.4300n 0.001421 443.4400n 0.001411 443.4500n 0.001387 443.4600n 0.001351 443.4700n 0.001303 443.4800n 0.001247 443.4900n 0.001185 443.5000n 0.001118 443.5100n 0.001050 443.5200n 0.000981 443.5300n 0.000916 443.5400n 0.000855
+ 443.5500n 0.000801 443.5600n 0.000756 443.5700n 0.000721 443.5800n 0.000699 443.5900n 0.000689 443.6000n 0.000692 443.6100n 0.000710 443.6200n 0.000742 443.6300n 0.000788 443.6400n 0.000848 443.6500n 0.000920 443.6600n 0.001003 443.6700n 0.001096 443.6800n 0.001197 443.6900n 0.001305
+ 443.7000n 0.001417 443.7100n 0.001531 443.7200n 0.001645 443.7300n 0.001756 443.7400n 0.001862 443.7500n 0.001962 443.7600n 0.002053 443.7700n 0.002134 443.7800n 0.002202 443.7900n 0.002256 443.8000n 0.002295 443.8100n 0.002319 443.8200n 0.002327 443.8300n 0.002318 443.8400n 0.002293
+ 443.8500n 0.002252 443.8600n 0.002196 443.8700n 0.002125 443.8800n 0.002041 443.8900n 0.001945 443.9000n 0.001839 443.9100n 0.001724 443.9200n 0.001603 443.9300n 0.001476 443.9400n 0.001346 443.9500n 0.001215 443.9600n 0.001085 443.9700n 0.000956 443.9800n 0.000831 443.9900n 0.000711
+ 444.0000n 0.000597 444.0100n 0.000490 444.0200n 0.000390 444.0300n 0.000299 444.0400n 0.000215 444.0500n 0.000141 444.0600n 0.000074 444.0700n 0.000015 444.0800n -0.000037 444.0900n -0.000083 444.1000n -0.000124 444.1100n -0.000159 444.1200n -0.000192 444.1300n -0.000222 444.1400n -0.000251
+ 444.1500n -0.000279 444.1600n -0.000307 444.1700n -0.000337 444.1800n -0.000369 444.1900n -0.000404 444.2000n -0.000441 444.2100n -0.000481 444.2200n -0.000523 444.2300n -0.000568 444.2400n -0.000616 444.2500n -0.000664 444.2600n -0.000713 444.2700n -0.000762 444.2800n -0.000809 444.2900n -0.000853
+ 444.3000n -0.000894 444.3100n -0.000929 444.3200n -0.000958 444.3300n -0.000980 444.3400n -0.000992 444.3500n -0.000995 444.3600n -0.000986 444.3700n -0.000967 444.3800n -0.000935 444.3900n -0.000891 444.4000n -0.000835 444.4100n -0.000767 444.4200n -0.000687 444.4300n -0.000595 444.4400n -0.000494
+ 444.4500n -0.000384 444.4600n -0.000266 444.4700n -0.000142 444.4800n -0.000014 444.4900n 0.000116 444.5000n 0.000247 444.5100n 0.000376 444.5200n 0.000502 444.5300n 0.000622 444.5400n 0.000734 444.5500n 0.000836 444.5600n 0.000927 444.5700n 0.001005 444.5800n 0.001069 444.5900n 0.001117
+ 444.6000n 0.001148 444.6100n 0.001161 444.6200n 0.001157 444.6300n 0.001135 444.6400n 0.001095 444.6500n 0.001037 444.6600n 0.000963 444.6700n 0.000872 444.6800n 0.000767 444.6900n 0.000649 444.7000n 0.000518 444.7100n 0.000378 444.7200n 0.000229 444.7300n 0.000074 444.7400n -0.000085
+ 444.7500n -0.000246 444.7600n -0.000408 444.7700n -0.000568 444.7800n -0.000724 444.7900n -0.000874 444.8000n -0.001017 444.8100n -0.001151 444.8200n -0.001275 444.8300n -0.001387 444.8400n -0.001486 444.8500n -0.001572 444.8600n -0.001644 444.8700n -0.001701 444.8800n -0.001743 444.8900n -0.001771
+ 444.9000n -0.001783 444.9100n -0.001782 444.9200n -0.001766 444.9300n -0.001737 444.9400n -0.001695 444.9500n -0.001641 444.9600n -0.001577 444.9700n -0.001503 444.9800n -0.001420 444.9900n -0.001330 445.0000n -0.001233 445.0100n -0.001131 445.0200n -0.001024 445.0300n -0.000915 445.0400n -0.000805
+ 445.0500n -0.000694 445.0600n -0.000583 445.0700n -0.000474 445.0800n -0.000368 445.0900n -0.000265 445.1000n -0.000168 445.1100n -0.000076 445.1200n 0.000010 445.1300n 0.000088 445.1400n 0.000159 445.1500n 0.000220 445.1600n 0.000272 445.1700n 0.000315 445.1800n 0.000347 445.1900n 0.000368
+ 445.2000n 0.000379 445.2100n 0.000378 445.2200n 0.000366 445.2300n 0.000343 445.2400n 0.000309 445.2500n 0.000265 445.2600n 0.000210 445.2700n 0.000145 445.2800n 0.000072 445.2900n -0.000010 445.3000n -0.000098 445.3100n -0.000193 445.3200n -0.000292 445.3300n -0.000394 445.3400n -0.000498
+ 445.3500n -0.000603 445.3600n -0.000706 445.3700n -0.000806 445.3800n -0.000901 445.3900n -0.000990 445.4000n -0.001070 445.4100n -0.001141 445.4200n -0.001200 445.4300n -0.001247 445.4400n -0.001279 445.4500n -0.001296 445.4600n -0.001298 445.4700n -0.001282 445.4800n -0.001250 445.4900n -0.001200
+ 445.5000n -0.001133 445.5100n -0.001049 445.5200n -0.000949 445.5300n -0.000834 445.5400n -0.000705 445.5500n -0.000563 445.5600n -0.000410 445.5700n -0.000248 445.5800n -0.000079 445.5900n 0.000094 445.6000n 0.000269 445.6100n 0.000445 445.6200n 0.000617 445.6300n 0.000785 445.6400n 0.000945
+ 445.6500n 0.001094 445.6600n 0.001232 445.6700n 0.001356 445.6800n 0.001463 445.6900n 0.001553 445.7000n 0.001624 445.7100n 0.001675 445.7200n 0.001705 445.7300n 0.001714 445.7400n 0.001702 445.7500n 0.001670 445.7600n 0.001617 445.7700n 0.001544 445.7800n 0.001454 445.7900n 0.001346
+ 445.8000n 0.001224 445.8100n 0.001088 445.8200n 0.000941 445.8300n 0.000785 445.8400n 0.000622 445.8500n 0.000454 445.8600n 0.000283 445.8700n 0.000112 445.8800n -0.000058 445.8900n -0.000225 445.9000n -0.000386 445.9100n -0.000542 445.9200n -0.000689 445.9300n -0.000829 445.9400n -0.000958
+ 445.9500n -0.001079 445.9600n -0.001189 445.9700n -0.001290 445.9800n -0.001381 445.9900n -0.001463 446.0000n -0.001537 446.0100n -0.001603 446.0200n -0.001663 446.0300n -0.001718 446.0400n -0.001768 446.0500n -0.001816 446.0600n -0.001862 446.0700n -0.001906 446.0800n -0.001951 446.0900n -0.001997
+ 446.1000n -0.002044 446.1100n -0.002094 446.1200n -0.002145 446.1300n -0.002199 446.1400n -0.002255 446.1500n -0.002312 446.1600n -0.002371 446.1700n -0.002429 446.1800n -0.002486 446.1900n -0.002541 446.2000n -0.002593 446.2100n -0.002639 446.2200n -0.002679 446.2300n -0.002711 446.2400n -0.002734
+ 446.2500n -0.002746 446.2600n -0.002745 446.2700n -0.002732 446.2800n -0.002705 446.2900n -0.002663 446.3000n -0.002605 446.3100n -0.002533 446.3200n -0.002445 446.3300n -0.002343 446.3400n -0.002226 446.3500n -0.002097 446.3600n -0.001956 446.3700n -0.001805 446.3800n -0.001646 446.3900n -0.001481
+ 446.4000n -0.001311 446.4100n -0.001140 446.4200n -0.000969 446.4300n -0.000801 446.4400n -0.000638 446.4500n -0.000482 446.4600n -0.000336 446.4700n -0.000200 446.4800n -0.000077 446.4900n 0.000033 446.5000n 0.000127 446.5100n 0.000207 446.5200n 0.000271 446.5300n 0.000320 446.5400n 0.000354
+ 446.5500n 0.000374 446.5600n 0.000381 446.5700n 0.000378 446.5800n 0.000365 446.5900n 0.000345 446.6000n 0.000321 446.6100n 0.000294 446.6200n 0.000268 446.6300n 0.000245 446.6400n 0.000227 446.6500n 0.000217 446.6600n 0.000217 446.6700n 0.000229 446.6800n 0.000255 446.6900n 0.000296
+ 446.7000n 0.000354 446.7100n 0.000429 446.7200n 0.000521 446.7300n 0.000629 446.7400n 0.000754 446.7500n 0.000894 446.7600n 0.001047 446.7700n 0.001211 446.7800n 0.001384 446.7900n 0.001563 446.8000n 0.001746 446.8100n 0.001927 446.8200n 0.002105 446.8300n 0.002276 446.8400n 0.002436
+ 446.8500n 0.002582 446.8600n 0.002710 446.8700n 0.002818 446.8800n 0.002902 446.8900n 0.002960 446.9000n 0.002991 446.9100n 0.002992 446.9200n 0.002963 446.9300n 0.002903 446.9400n 0.002812 446.9500n 0.002691 446.9600n 0.002540 446.9700n 0.002363 446.9800n 0.002160 446.9900n 0.001935
+ 447.0000n 0.001691 447.0100n 0.001432 447.0200n 0.001161 447.0300n 0.000882 447.0400n 0.000599 447.0500n 0.000318 447.0600n 0.000042 447.0700n -0.000225 447.0800n -0.000478 447.0900n -0.000714 447.1000n -0.000930 447.1100n -0.001121 447.1200n -0.001287 447.1300n -0.001424 447.1400n -0.001531
+ 447.1500n -0.001608 447.1600n -0.001653 447.1700n -0.001667 447.1800n -0.001650 447.1900n -0.001605 447.2000n -0.001532 447.2100n -0.001434 447.2200n -0.001314 447.2300n -0.001175 447.2400n -0.001021 447.2500n -0.000853 447.2600n -0.000678 447.2700n -0.000498 447.2800n -0.000316 447.2900n -0.000137
+ 447.3000n 0.000035 447.3100n 0.000199 447.3200n 0.000350 447.3300n 0.000487 447.3400n 0.000606 447.3500n 0.000708 447.3600n 0.000789 447.3700n 0.000851 447.3800n 0.000891 447.3900n 0.000912 447.4000n 0.000913 447.4100n 0.000896 447.4200n 0.000863 447.4300n 0.000815 447.4400n 0.000755
+ 447.4500n 0.000685 447.4600n 0.000609 447.4700n 0.000528 447.4800n 0.000447 447.4900n 0.000368 447.5000n 0.000294 447.5100n 0.000227 447.5200n 0.000170 447.5300n 0.000126 447.5400n 0.000096 447.5500n 0.000082 447.5600n 0.000084 447.5700n 0.000105 447.5800n 0.000144 447.5900n 0.000201
+ 447.6000n 0.000276 447.6100n 0.000368 447.6200n 0.000475 447.6300n 0.000597 447.6400n 0.000732 447.6500n 0.000877 447.6600n 0.001030 447.6700n 0.001189 447.6800n 0.001352 447.6900n 0.001515 447.7000n 0.001677 447.7100n 0.001834 447.7200n 0.001985 447.7300n 0.002127 447.7400n 0.002259
+ 447.7500n 0.002379 447.7600n 0.002485 447.7700n 0.002576 447.7800n 0.002652 447.7900n 0.002711 447.8000n 0.002754 447.8100n 0.002781 447.8200n 0.002791 447.8300n 0.002786 447.8400n 0.002765 447.8500n 0.002731 447.8600n 0.002684 447.8700n 0.002626 447.8800n 0.002557 447.8900n 0.002479
+ 447.9000n 0.002394 447.9100n 0.002303 447.9200n 0.002206 447.9300n 0.002106 447.9400n 0.002002 447.9500n 0.001897 447.9600n 0.001790 447.9700n 0.001683 447.9800n 0.001575 447.9900n 0.001468 448.0000n 0.001360 448.0100n 0.001253 448.0200n 0.001145 448.0300n 0.001037 448.0400n 0.000928
+ 448.0500n 0.000818 448.0600n 0.000707 448.0700n 0.000594 448.0800n 0.000479 448.0900n 0.000361 448.1000n 0.000241 448.1100n 0.000119 448.1200n -0.000006 448.1300n -0.000133 448.1400n -0.000262 448.1500n -0.000391 448.1600n -0.000522 448.1700n -0.000651 448.1800n -0.000779 448.1900n -0.000905
+ 448.2000n -0.001026 448.2100n -0.001143 448.2200n -0.001252 448.2300n -0.001354 448.2400n -0.001447 448.2500n -0.001530 448.2600n -0.001601 448.2700n -0.001660 448.2800n -0.001705 448.2900n -0.001737 448.3000n -0.001754 448.3100n -0.001757 448.3200n -0.001745 448.3300n -0.001720 448.3400n -0.001681
+ 448.3500n -0.001629 448.3600n -0.001566 448.3700n -0.001492 448.3800n -0.001410 448.3900n -0.001321 448.4000n -0.001227 448.4100n -0.001129 448.4200n -0.001030 448.4300n -0.000931 448.4400n -0.000835 448.4500n -0.000743 448.4600n -0.000657 448.4700n -0.000579 448.4800n -0.000510 448.4900n -0.000451
+ 448.5000n -0.000403 448.5100n -0.000368 448.5200n -0.000345 448.5300n -0.000334 448.5400n -0.000335 448.5500n -0.000349 448.5600n -0.000373 448.5700n -0.000408 448.5800n -0.000452 448.5900n -0.000504 448.6000n -0.000561 448.6100n -0.000623 448.6200n -0.000688 448.6300n -0.000754 448.6400n -0.000819
+ 448.6500n -0.000882 448.6600n -0.000940 448.6700n -0.000993 448.6800n -0.001040 448.6900n -0.001078 448.7000n -0.001107 448.7100n -0.001127 448.7200n -0.001137 448.7300n -0.001137 448.7400n -0.001127 448.7500n -0.001108 448.7600n -0.001079 448.7700n -0.001042 448.7800n -0.000998 448.7900n -0.000948
+ 448.8000n -0.000893 448.8100n -0.000833 448.8200n -0.000772 448.8300n -0.000709 448.8400n -0.000646 448.8500n -0.000585 448.8600n -0.000525 448.8700n -0.000469 448.8800n -0.000416 448.8900n -0.000368 448.9000n -0.000324 448.9100n -0.000284 448.9200n -0.000249 448.9300n -0.000217 448.9400n -0.000189
+ 448.9500n -0.000163 448.9600n -0.000139 448.9700n -0.000115 448.9800n -0.000090 448.9900n -0.000064 449.0000n -0.000034 449.0100n -0.000000 449.0200n 0.000039 449.0300n 0.000084 449.0400n 0.000137 449.0500n 0.000196 449.0600n 0.000263 449.0700n 0.000338 449.0800n 0.000420 449.0900n 0.000508
+ 449.1000n 0.000602 449.1100n 0.000701 449.1200n 0.000802 449.1300n 0.000905 449.1400n 0.001006 449.1500n 0.001104 449.1600n 0.001197 449.1700n 0.001281 449.1800n 0.001356 449.1900n 0.001417 449.2000n 0.001464 449.2100n 0.001493 449.2200n 0.001504 449.2300n 0.001493 449.2400n 0.001461
+ 449.2500n 0.001407 449.2600n 0.001329 449.2700n 0.001229 449.2800n 0.001106 449.2900n 0.000962 449.3000n 0.000799 449.3100n 0.000619 449.3200n 0.000424 449.3300n 0.000217 449.3400n 0.000002 449.3500n -0.000218 449.3600n -0.000438 449.3700n -0.000654 449.3800n -0.000863 449.3900n -0.001059
+ 449.4000n -0.001240 449.4100n -0.001400 449.4200n -0.001537 449.4300n -0.001647 449.4400n -0.001727 449.4500n -0.001776 449.4600n -0.001790 449.4700n -0.001771 449.4800n -0.001717 449.4900n -0.001628 449.5000n -0.001506 449.5100n -0.001354 449.5200n -0.001173 449.5300n -0.000967 449.5400n -0.000739
+ 449.5500n -0.000495 449.5600n -0.000239 449.5700n 0.000023 449.5800n 0.000286 449.5900n 0.000544 449.6000n 0.000791 449.6100n 0.001022 449.6200n 0.001231 449.6300n 0.001413 449.6400n 0.001564 449.6500n 0.001679 449.6600n 0.001754 449.6700n 0.001788 449.6800n 0.001778 449.6900n 0.001723
+ 449.7000n 0.001623 449.7100n 0.001480 449.7200n 0.001294 449.7300n 0.001068 449.7400n 0.000806 449.7500n 0.000513 449.7600n 0.000193 449.7700n -0.000147 449.7800n -0.000502 449.7900n -0.000865 449.8000n -0.001229 449.8100n -0.001586 449.8200n -0.001930 449.8300n -0.002253 449.8400n -0.002550
+ 449.8500n -0.002813 449.8600n -0.003037 449.8700n -0.003217 449.8800n -0.003350 449.8900n -0.003430 449.9000n -0.003458 449.9100n -0.003430 449.9200n -0.003346 449.9300n -0.003208 449.9400n -0.003018 449.9500n -0.002778 449.9600n -0.002491 449.9700n -0.002163 449.9800n -0.001800 449.9900n -0.001407
+ 450.0000n -0.000991 450.0100n -0.000560 450.0200n -0.000120 450.0300n 0.000320 450.0400n 0.000753 450.0500n 0.001171 450.0600n 0.001568 450.0700n 0.001937 450.0800n 0.002272 450.0900n 0.002567 450.1000n 0.002819 450.1100n 0.003023 450.1200n 0.003177 450.1300n 0.003280 450.1400n 0.003331
+ 450.1500n 0.003331 450.1600n 0.003281 450.1700n 0.003184 450.1800n 0.003044 450.1900n 0.002865 450.2000n 0.002651 450.2100n 0.002409 450.2200n 0.002146 450.2300n 0.001867 450.2400n 0.001579 450.2500n 0.001289 450.2600n 0.001004 450.2700n 0.000731 450.2800n 0.000475 450.2900n 0.000242
+ 450.3000n 0.000037 450.3100n -0.000135 450.3200n -0.000271 450.3300n -0.000370 450.3400n -0.000428 450.3500n -0.000446 450.3600n -0.000423 450.3700n -0.000361 450.3800n -0.000263 450.3900n -0.000130 450.4000n 0.000032 450.4100n 0.000220 450.4200n 0.000429 450.4300n 0.000652 450.4400n 0.000885
+ 450.4500n 0.001122 450.4600n 0.001356 450.4700n 0.001581 450.4800n 0.001792 450.4900n 0.001983 450.5000n 0.002150 450.5100n 0.002289 450.5200n 0.002395 450.5300n 0.002466 450.5400n 0.002501 450.5500n 0.002497 450.5600n 0.002455 450.5700n 0.002375 450.5800n 0.002258 450.5900n 0.002108
+ 450.6000n 0.001927 450.6100n 0.001719 450.6200n 0.001488 450.6300n 0.001238 450.6400n 0.000976 450.6500n 0.000707 450.6600n 0.000436 450.6700n 0.000169 450.6800n -0.000089 450.6900n -0.000332 450.7000n -0.000556 450.7100n -0.000755 450.7200n -0.000927 450.7300n -0.001068 450.7400n -0.001176
+ 450.7500n -0.001248 450.7600n -0.001284 450.7700n -0.001283 450.7800n -0.001246 450.7900n -0.001175 450.8000n -0.001072 450.8100n -0.000938 450.8200n -0.000779 450.8300n -0.000596 450.8400n -0.000395 450.8500n -0.000181 450.8600n 0.000044 450.8700n 0.000272 450.8800n 0.000500 450.8900n 0.000724
+ 450.9000n 0.000938 450.9100n 0.001139 450.9200n 0.001323 450.9300n 0.001488 450.9400n 0.001630 450.9500n 0.001749 450.9600n 0.001842 450.9700n 0.001909 450.9800n 0.001950 450.9900n 0.001967 451.0000n 0.001960 451.0100n 0.001932 451.0200n 0.001884 451.0300n 0.001821 451.0400n 0.001744
+ 451.0500n 0.001657 451.0600n 0.001565 451.0700n 0.001470 451.0800n 0.001377 451.0900n 0.001288 451.1000n 0.001207 451.1100n 0.001137 451.1200n 0.001080 451.1300n 0.001038 451.1400n 0.001013 451.1500n 0.001006 451.1600n 0.001017 451.1700n 0.001045 451.1800n 0.001090 451.1900n 0.001150
+ 451.2000n 0.001224 451.2100n 0.001309 451.2200n 0.001403 451.2300n 0.001502 451.2400n 0.001602 451.2500n 0.001701 451.2600n 0.001794 451.2700n 0.001879 451.2800n 0.001952 451.2900n 0.002009 451.3000n 0.002047 451.3100n 0.002065 451.3200n 0.002060 451.3300n 0.002032 451.3400n 0.001978
+ 451.3500n 0.001899 451.3600n 0.001795 451.3700n 0.001667 451.3800n 0.001517 451.3900n 0.001348 451.4000n 0.001161 451.4100n 0.000961 451.4200n 0.000752 451.4300n 0.000537 451.4400n 0.000320 451.4500n 0.000107 451.4600n -0.000098 451.4700n -0.000290 451.4800n -0.000466 451.4900n -0.000620
+ 451.5000n -0.000749 451.5100n -0.000849 451.5200n -0.000919 451.5300n -0.000955 451.5400n -0.000956 451.5500n -0.000920 451.5600n -0.000849 451.5700n -0.000743 451.5800n -0.000602 451.5900n -0.000429 451.6000n -0.000227 451.6100n 0.000001 451.6200n 0.000251 451.6300n 0.000519 451.6400n 0.000799
+ 451.6500n 0.001086 451.6600n 0.001376 451.6700n 0.001663 451.6800n 0.001940 451.6900n 0.002204 451.7000n 0.002449 451.7100n 0.002670 451.7200n 0.002862 451.7300n 0.003023 451.7400n 0.003149 451.7500n 0.003238 451.7600n 0.003287 451.7700n 0.003295 451.7800n 0.003263 451.7900n 0.003190
+ 451.8000n 0.003079 451.8100n 0.002929 451.8200n 0.002745 451.8300n 0.002530 451.8400n 0.002285 451.8500n 0.002017 451.8600n 0.001729 451.8700n 0.001426 451.8800n 0.001112 451.8900n 0.000793 451.9000n 0.000473 451.9100n 0.000157 451.9200n -0.000150 451.9300n -0.000445 451.9400n -0.000724
+ 451.9500n -0.000983 451.9600n -0.001220 451.9700n -0.001432 451.9800n -0.001619 451.9900n -0.001778 452.0000n -0.001910 452.0100n -0.002014 452.0200n -0.002092 452.0300n -0.002144 452.0400n -0.002173 452.0500n -0.002180 452.0600n -0.002167 452.0700n -0.002138 452.0800n -0.002095 452.0900n -0.002042
+ 452.1000n -0.001980 452.1100n -0.001914 452.1200n -0.001845 452.1300n -0.001777 452.1400n -0.001712 452.1500n -0.001651 452.1600n -0.001596 452.1700n -0.001549 452.1800n -0.001510 452.1900n -0.001479 452.2000n -0.001457 452.2100n -0.001443 452.2200n -0.001435 452.2300n -0.001433 452.2400n -0.001435
+ 452.2500n -0.001438 452.2600n -0.001442 452.2700n -0.001443 452.2800n -0.001440 452.2900n -0.001430 452.3000n -0.001410 452.3100n -0.001379 452.3200n -0.001335 452.3300n -0.001276 452.3400n -0.001201 452.3500n -0.001108 452.3600n -0.000998 452.3700n -0.000870 452.3800n -0.000725 452.3900n -0.000562
+ 452.4000n -0.000384 452.4100n -0.000192 452.4200n 0.000012 452.4300n 0.000225 452.4400n 0.000446 452.4500n 0.000671 452.4600n 0.000896 452.4700n 0.001120 452.4800n 0.001337 452.4900n 0.001546 452.5000n 0.001743 452.5100n 0.001925 452.5200n 0.002088 452.5300n 0.002232 452.5400n 0.002352
+ 452.5500n 0.002449 452.5600n 0.002519 452.5700n 0.002563 452.5800n 0.002580 452.5900n 0.002569 452.6000n 0.002532 452.6100n 0.002470 452.6200n 0.002383 452.6300n 0.002274 452.6400n 0.002146 452.6500n 0.001999 452.6600n 0.001839 452.6700n 0.001666 452.6800n 0.001486 452.6900n 0.001300
+ 452.7000n 0.001113 452.7100n 0.000927 452.7200n 0.000746 452.7300n 0.000572 452.7400n 0.000408 452.7500n 0.000256 452.7600n 0.000118 452.7700n -0.000003 452.7800n -0.000107 452.7900n -0.000194 452.8000n -0.000262 452.8100n -0.000312 452.8200n -0.000345 452.8300n -0.000361 452.8400n -0.000361
+ 452.8500n -0.000348 452.8600n -0.000322 452.8700n -0.000287 452.8800n -0.000245 452.8900n -0.000197 452.9000n -0.000147 452.9100n -0.000096 452.9200n -0.000049 452.9300n -0.000006 452.9400n 0.000031 452.9500n 0.000058 452.9600n 0.000074 452.9700n 0.000079 452.9800n 0.000070 452.9900n 0.000047
+ 453.0000n 0.000010 453.0100n -0.000042 453.0200n -0.000109 453.0300n -0.000188 453.0400n -0.000281 453.0500n -0.000385 453.0600n -0.000499 453.0700n -0.000621 453.0800n -0.000749 453.0900n -0.000881 453.1000n -0.001016 453.1100n -0.001150 453.1200n -0.001282 453.1300n -0.001409 453.1400n -0.001530
+ 453.1500n -0.001642 453.1600n -0.001743 453.1700n -0.001832 453.1800n -0.001907 453.1900n -0.001968 453.2000n -0.002014 453.2100n -0.002043 453.2200n -0.002056 453.2300n -0.002052 453.2400n -0.002032 453.2500n -0.001997 453.2600n -0.001946 453.2700n -0.001882 453.2800n -0.001805 453.2900n -0.001716
+ 453.3000n -0.001616 453.3100n -0.001509 453.3200n -0.001394 453.3300n -0.001273 453.3400n -0.001149 453.3500n -0.001023 453.3600n -0.000896 453.3700n -0.000770 453.3800n -0.000646 453.3900n -0.000525 453.4000n -0.000408 453.4100n -0.000297 453.4200n -0.000192 453.4300n -0.000094 453.4400n -0.000003
+ 453.4500n 0.000081 453.4600n 0.000156 453.4700n 0.000224 453.4800n 0.000284 453.4900n 0.000337 453.5000n 0.000382 453.5100n 0.000420 453.5200n 0.000452 453.5300n 0.000477 453.5400n 0.000497 453.5500n 0.000511 453.5600n 0.000521 453.5700n 0.000526 453.5800n 0.000528 453.5900n 0.000526
+ 453.6000n 0.000521 453.6100n 0.000514 453.6200n 0.000505 453.6300n 0.000493 453.6400n 0.000480 453.6500n 0.000466 453.6600n 0.000451 453.6700n 0.000435 453.6800n 0.000419 453.6900n 0.000403 453.7000n 0.000387 453.7100n 0.000371 453.7200n 0.000356 453.7300n 0.000342 453.7400n 0.000330
+ 453.7500n 0.000319 453.7600n 0.000310 453.7700n 0.000303 453.7800n 0.000299 453.7900n 0.000297 453.8000n 0.000299 453.8100n 0.000304 453.8200n 0.000312 453.8300n 0.000324 453.8400n 0.000340 453.8500n 0.000359 453.8600n 0.000382 453.8700n 0.000407 453.8800n 0.000436 453.8900n 0.000467
+ 453.9000n 0.000501 453.9100n 0.000535 453.9200n 0.000571 453.9300n 0.000606 453.9400n 0.000641 453.9500n 0.000674 453.9600n 0.000705 453.9700n 0.000732 453.9800n 0.000755 453.9900n 0.000772 454.0000n 0.000784 454.0100n 0.000789 454.0200n 0.000786 454.0300n 0.000775 454.0400n 0.000756
+ 454.0500n 0.000728 454.0600n 0.000691 454.0700n 0.000645 454.0800n 0.000591 454.0900n 0.000529 454.1000n 0.000459 454.1100n 0.000383 454.1200n 0.000301 454.1300n 0.000214 454.1400n 0.000124 454.1500n 0.000031 454.1600n -0.000062 454.1700n -0.000154 454.1800n -0.000243 454.1900n -0.000329
+ 454.2000n -0.000409 454.2100n -0.000483 454.2200n -0.000549 454.2300n -0.000605 454.2400n -0.000651 454.2500n -0.000686 454.2600n -0.000710 454.2700n -0.000721 454.2800n -0.000721 454.2900n -0.000709 454.3000n -0.000686 454.3100n -0.000653 454.3200n -0.000610 454.3300n -0.000559 454.3400n -0.000501
+ 454.3500n -0.000438 454.3600n -0.000372 454.3700n -0.000304 454.3800n -0.000237 454.3900n -0.000173 454.4000n -0.000114 454.4100n -0.000062 454.4200n -0.000019 454.4300n 0.000013 454.4400n 0.000033 454.4500n 0.000038 454.4600n 0.000029 454.4700n 0.000004 454.4800n -0.000037 454.4900n -0.000096
+ 454.5000n -0.000171 454.5100n -0.000262 454.5200n -0.000369 454.5300n -0.000490 454.5400n -0.000624 454.5500n -0.000768 454.5600n -0.000922 454.5700n -0.001083 454.5800n -0.001247 454.5900n -0.001413 454.6000n -0.001579 454.6100n -0.001740 454.6200n -0.001894 454.6300n -0.002039 454.6400n -0.002172
+ 454.6500n -0.002290 454.6600n -0.002392 454.6700n -0.002475 454.6800n -0.002537 454.6900n -0.002578 454.7000n -0.002596 454.7100n -0.002591 454.7200n -0.002563 454.7300n -0.002511 454.7400n -0.002437 454.7500n -0.002341 454.7600n -0.002225 454.7700n -0.002090 454.7800n -0.001939 454.7900n -0.001773
+ 454.8000n -0.001596 454.8100n -0.001410 454.8200n -0.001218 454.8300n -0.001022 454.8400n -0.000827 454.8500n -0.000633 454.8600n -0.000445 454.8700n -0.000265 454.8800n -0.000096 454.8900n 0.000061 454.9000n 0.000204 454.9100n 0.000330 454.9200n 0.000439 454.9300n 0.000529 454.9400n 0.000601
+ 454.9500n 0.000653 454.9600n 0.000687 454.9700n 0.000702 454.9800n 0.000699 454.9900n 0.000681 455.0000n 0.000648 455.0100n 0.000601 455.0200n 0.000544 455.0300n 0.000478 455.0400n 0.000405 455.0500n 0.000328 455.0600n 0.000249 455.0700n 0.000171 455.0800n 0.000095 455.0900n 0.000024
+ 455.1000n -0.000041 455.1100n -0.000096 455.1200n -0.000142 455.1300n -0.000176 455.1400n -0.000197 455.1500n -0.000205 455.1600n -0.000199 455.1700n -0.000180 455.1800n -0.000146 455.1900n -0.000099 455.2000n -0.000040 455.2100n 0.000032 455.2200n 0.000113 455.2300n 0.000205 455.2400n 0.000304
+ 455.2500n 0.000409 455.2600n 0.000518 455.2700n 0.000630 455.2800n 0.000743 455.2900n 0.000854 455.3000n 0.000963 455.3100n 0.001068 455.3200n 0.001167 455.3300n 0.001258 455.3400n 0.001341 455.3500n 0.001414 455.3600n 0.001476 455.3700n 0.001528 455.3800n 0.001568 455.3900n 0.001597
+ 455.4000n 0.001613 455.4100n 0.001618 455.4200n 0.001612 455.4300n 0.001595 455.4400n 0.001568 455.4500n 0.001531 455.4600n 0.001487 455.4700n 0.001435 455.4800n 0.001376 455.4900n 0.001313 455.5000n 0.001245 455.5100n 0.001175 455.5200n 0.001102 455.5300n 0.001029 455.5400n 0.000956
+ 455.5500n 0.000884 455.5600n 0.000813 455.5700n 0.000745 455.5800n 0.000680 455.5900n 0.000619 455.6000n 0.000561 455.6100n 0.000508 455.6200n 0.000460 455.6300n 0.000415 455.6400n 0.000376 455.6500n 0.000340 455.6600n 0.000309 455.6700n 0.000282 455.6800n 0.000258 455.6900n 0.000238
+ 455.7000n 0.000221 455.7100n 0.000207 455.7200n 0.000194 455.7300n 0.000184 455.7400n 0.000174 455.7500n 0.000166 455.7600n 0.000158 455.7700n 0.000151 455.7800n 0.000143 455.7900n 0.000134 455.8000n 0.000125 455.8100n 0.000114 455.8200n 0.000101 455.8300n 0.000087 455.8400n 0.000070
+ 455.8500n 0.000050 455.8600n 0.000028 455.8700n 0.000003 455.8800n -0.000026 455.8900n -0.000057 455.9000n -0.000093 455.9100n -0.000133 455.9200n -0.000176 455.9300n -0.000223 455.9400n -0.000275 455.9500n -0.000331 455.9600n -0.000390 455.9700n -0.000454 455.9800n -0.000522 455.9900n -0.000593
+ 456.0000n -0.000667 456.0100n -0.000745 456.0200n -0.000824 456.0300n -0.000906 456.0400n -0.000989 456.0500n -0.001073 456.0600n -0.001156 456.0700n -0.001239 456.0800n -0.001320 456.0900n -0.001398 456.1000n -0.001472 456.1100n -0.001542 456.1200n -0.001606 456.1300n -0.001664 456.1400n -0.001715
+ 456.1500n -0.001757 456.1600n -0.001790 456.1700n -0.001813 456.1800n -0.001826 456.1900n -0.001828 456.2000n -0.001819 456.2100n -0.001799 456.2200n -0.001767 456.2300n -0.001723 456.2400n -0.001669 456.2500n -0.001604 456.2600n -0.001528 456.2700n -0.001444 456.2800n -0.001351 456.2900n -0.001251
+ 456.3000n -0.001144 456.3100n -0.001033 456.3200n -0.000919 456.3300n -0.000802 456.3400n -0.000685 456.3500n -0.000570 456.3600n -0.000457 456.3700n -0.000348 456.3800n -0.000244 456.3900n -0.000148 456.4000n -0.000060 456.4100n 0.000019 456.4200n 0.000087 456.4300n 0.000144 456.4400n 0.000189
+ 456.4500n 0.000222 456.4600n 0.000242 456.4700n 0.000250 456.4800n 0.000245 456.4900n 0.000227 456.5000n 0.000198 456.5100n 0.000158 456.5200n 0.000108 456.5300n 0.000049 456.5400n -0.000019 456.5500n -0.000093 456.5600n -0.000173 456.5700n -0.000256 456.5800n -0.000343 456.5900n -0.000430
+ 456.6000n -0.000518 456.6100n -0.000603 456.6200n -0.000686 456.6300n -0.000765 456.6400n -0.000839 456.6500n -0.000906 456.6600n -0.000966 456.6700n -0.001019 456.6800n -0.001062 456.6900n -0.001096 456.7000n -0.001121 456.7100n -0.001137 456.7200n -0.001143 456.7300n -0.001139 456.7400n -0.001125
+ 456.7500n -0.001103 456.7600n -0.001071 456.7700n -0.001032 456.7800n -0.000984 456.7900n -0.000930 456.8000n -0.000869 456.8100n -0.000803 456.8200n -0.000731 456.8300n -0.000655 456.8400n -0.000575 456.8500n -0.000492 456.8600n -0.000407 456.8700n -0.000320 456.8800n -0.000232 456.8900n -0.000144
+ 456.9000n -0.000055 456.9100n 0.000033 456.9200n 0.000119 456.9300n 0.000204 456.9400n 0.000287 456.9500n 0.000367 456.9600n 0.000444 456.9700n 0.000517 456.9800n 0.000586 456.9900n 0.000651 457.0000n 0.000710 457.0100n 0.000764 457.0200n 0.000811 457.0300n 0.000852 457.0400n 0.000885
+ 457.0500n 0.000911 457.0600n 0.000928 457.0700n 0.000937 457.0800n 0.000937 457.0900n 0.000927 457.1000n 0.000908 457.1100n 0.000879 457.1200n 0.000840 457.1300n 0.000792 457.1400n 0.000734 457.1500n 0.000667 457.1600n 0.000592 457.1700n 0.000508 457.1800n 0.000418 457.1900n 0.000322
+ 457.2000n 0.000221 457.2100n 0.000116 457.2200n 0.000009 457.2300n -0.000098 457.2400n -0.000205 457.2500n -0.000308 457.2600n -0.000407 457.2700n -0.000500 457.2800n -0.000584 457.2900n -0.000659 457.3000n -0.000721 457.3100n -0.000771 457.3200n -0.000806 457.3300n -0.000826 457.3400n -0.000828
+ 457.3500n -0.000813 457.3600n -0.000780 457.3700n -0.000728 457.3800n -0.000657 457.3900n -0.000569 457.4000n -0.000463 457.4100n -0.000340 457.4200n -0.000202 457.4300n -0.000049 457.4400n 0.000116 457.4500n 0.000291 457.4600n 0.000475 457.4700n 0.000665 457.4800n 0.000858 457.4900n 0.001053
+ 457.5000n 0.001246 457.5100n 0.001436 457.5200n 0.001619 457.5300n 0.001794 457.5400n 0.001959 457.5500n 0.002111 457.5600n 0.002248 457.5700n 0.002370 457.5800n 0.002476 457.5900n 0.002563 457.6000n 0.002633 457.6100n 0.002684 457.6200n 0.002717 457.6300n 0.002733 457.6400n 0.002732
+ 457.6500n 0.002716 457.6600n 0.002685 457.6700n 0.002643 457.6800n 0.002590 457.6900n 0.002529 457.7000n 0.002462 457.7100n 0.002392 457.7200n 0.002319 457.7300n 0.002248 457.7400n 0.002179 457.7500n 0.002115 457.7600n 0.002057 457.7700n 0.002007 457.7800n 0.001967 457.7900n 0.001936
+ 457.8000n 0.001917 457.8100n 0.001908 457.8200n 0.001910 457.8300n 0.001922 457.8400n 0.001944 457.8500n 0.001975 457.8600n 0.002012 457.8700n 0.002055 457.8800n 0.002100 457.8900n 0.002147 457.9000n 0.002192 457.9100n 0.002234 457.9200n 0.002270 457.9300n 0.002297 457.9400n 0.002314
+ 457.9500n 0.002318 457.9600n 0.002307 457.9700n 0.002281 457.9800n 0.002236 457.9900n 0.002173 458.0000n 0.002091 458.0100n 0.001989 458.0200n 0.001868 458.0300n 0.001729 458.0400n 0.001572 458.0500n 0.001400 458.0600n 0.001214 458.0700n 0.001015 458.0800n 0.000808 458.0900n 0.000594
+ 458.1000n 0.000377 458.1100n 0.000160 458.1200n -0.000054 458.1300n -0.000261 458.1400n -0.000459 458.1500n -0.000644 458.1600n -0.000813 458.1700n -0.000964 458.1800n -0.001095 458.1900n -0.001202 458.2000n -0.001286 458.2100n -0.001343 458.2200n -0.001375 458.2300n -0.001381 458.2400n -0.001361
+ 458.2500n -0.001316 458.2600n -0.001247 458.2700n -0.001157 458.2800n -0.001047 458.2900n -0.000921 458.3000n -0.000781 458.3100n -0.000631 458.3200n -0.000474 458.3300n -0.000314 458.3400n -0.000155 458.3500n -0.000001 458.3600n 0.000146 458.3700n 0.000280 458.3800n 0.000399 458.3900n 0.000501
+ 458.4000n 0.000581 458.4100n 0.000638 458.4200n 0.000670 458.4300n 0.000677 458.4400n 0.000656 458.4500n 0.000608 458.4600n 0.000533 458.4700n 0.000433 458.4800n 0.000308 458.4900n 0.000160 458.5000n -0.000008 458.5100n -0.000193 458.5200n -0.000392 458.5300n -0.000602 458.5400n -0.000819
+ 458.5500n -0.001039 458.5600n -0.001258 458.5700n -0.001472 458.5800n -0.001677 458.5900n -0.001870 458.6000n -0.002046 458.6100n -0.002203 458.6200n -0.002337 458.6300n -0.002446 458.6400n -0.002528 458.6500n -0.002582 458.6600n -0.002605 458.6700n -0.002598 458.6800n -0.002560 458.6900n -0.002492
+ 458.7000n -0.002395 458.7100n -0.002270 458.7200n -0.002119 458.7300n -0.001946 458.7400n -0.001751 458.7500n -0.001540 458.7600n -0.001314 458.7700n -0.001078 458.7800n -0.000835 458.7900n -0.000589 458.8000n -0.000343 458.8100n -0.000103 458.8200n 0.000130 458.8300n 0.000351 458.8400n 0.000558
+ 458.8500n 0.000747 458.8600n 0.000916 458.8700n 0.001062 458.8800n 0.001184 458.8900n 0.001281 458.9000n 0.001351 458.9100n 0.001395 458.9200n 0.001411 458.9300n 0.001400 458.9400n 0.001362 458.9500n 0.001300 458.9600n 0.001214 458.9700n 0.001105 458.9800n 0.000977 458.9900n 0.000830
+ 459.0000n 0.000668 459.0100n 0.000493 459.0200n 0.000307 459.0300n 0.000113 459.0400n -0.000086 459.0500n -0.000288 459.0600n -0.000491 459.0700n -0.000691 459.0800n -0.000886 459.0900n -0.001075 459.1000n -0.001256 459.1100n -0.001426 459.1200n -0.001584 459.1300n -0.001730 459.1400n -0.001861
+ 459.1500n -0.001977 459.1600n -0.002078 459.1700n -0.002162 459.1800n -0.002231 459.1900n -0.002283 459.2000n -0.002319 459.2100n -0.002339 459.2200n -0.002343 459.2300n -0.002333 459.2400n -0.002309 459.2500n -0.002272 459.2600n -0.002223 459.2700n -0.002162 459.2800n -0.002091 459.2900n -0.002011
+ 459.3000n -0.001923 459.3100n -0.001827 459.3200n -0.001726 459.3300n -0.001620 459.3400n -0.001511 459.3500n -0.001399 459.3600n -0.001285 459.3700n -0.001171 459.3800n -0.001058 459.3900n -0.000946 459.4000n -0.000836 459.4100n -0.000730 459.4200n -0.000628 459.4300n -0.000531 459.4400n -0.000439
+ 459.4500n -0.000353 459.4600n -0.000273 459.4700n -0.000200 459.4800n -0.000135 459.4900n -0.000076 459.5000n -0.000024 459.5100n 0.000020 459.5200n 0.000057 459.5300n 0.000088 459.5400n 0.000113 459.5500n 0.000132 459.5600n 0.000146 459.5700n 0.000156 459.5800n 0.000162 459.5900n 0.000165
+ 459.6000n 0.000167 459.6100n 0.000168 459.6200n 0.000169 459.6300n 0.000171 459.6400n 0.000174 459.6500n 0.000181 459.6600n 0.000190 459.6700n 0.000203 459.6800n 0.000221 459.6900n 0.000243 459.7000n 0.000270 459.7100n 0.000302 459.7200n 0.000338 459.7300n 0.000378 459.7400n 0.000422
+ 459.7500n 0.000468 459.7600n 0.000515 459.7700n 0.000563 459.7800n 0.000610 459.7900n 0.000654 459.8000n 0.000695 459.8100n 0.000729 459.8200n 0.000756 459.8300n 0.000775 459.8400n 0.000782 459.8500n 0.000777 459.8600n 0.000759 459.8700n 0.000725 459.8800n 0.000676 459.8900n 0.000610
+ 459.9000n 0.000527 459.9100n 0.000426 459.9200n 0.000308 459.9300n 0.000173 459.9400n 0.000022 459.9500n -0.000144 459.9600n -0.000323 459.9700n -0.000513 459.9800n -0.000712 459.9900n -0.000918 460.0000n -0.001128 460.0100n -0.001338 460.0200n -0.001546 460.0300n -0.001748 460.0400n -0.001942
+ 460.0500n -0.002124 460.0600n -0.002290 460.0700n -0.002437 460.0800n -0.002564 460.0900n -0.002667 460.1000n -0.002744 460.1100n -0.002793 460.1200n -0.002813 460.1300n -0.002803 460.1400n -0.002763 460.1500n -0.002693 460.1600n -0.002593 460.1700n -0.002464 460.1800n -0.002310 460.1900n -0.002131
+ 460.2000n -0.001930 460.2100n -0.001711 460.2200n -0.001478 460.2300n -0.001233 460.2400n -0.000981 460.2500n -0.000727 460.2600n -0.000474 460.2700n -0.000227 460.2800n 0.000010 460.2900n 0.000233 460.3000n 0.000438 460.3100n 0.000621 460.3200n 0.000780 460.3300n 0.000913 460.3400n 0.001016
+ 460.3500n 0.001089 460.3600n 0.001131 460.3700n 0.001141 460.3800n 0.001121 460.3900n 0.001070 460.4000n 0.000992 460.4100n 0.000887 460.4200n 0.000760 460.4300n 0.000612 460.4400n 0.000449 460.4500n 0.000273 460.4600n 0.000088 460.4700n -0.000099 460.4800n -0.000286 460.4900n -0.000468
+ 460.5000n -0.000640 460.5100n -0.000799 460.5200n -0.000941 460.5300n -0.001062 460.5400n -0.001160 460.5500n -0.001233 460.5600n -0.001278 460.5700n -0.001295 460.5800n -0.001284 460.5900n -0.001244 460.6000n -0.001177 460.6100n -0.001085 460.6200n -0.000969 460.6300n -0.000832 460.6400n -0.000679
+ 460.6500n -0.000511 460.6600n -0.000334 460.6700n -0.000153 460.6800n 0.000030 460.6900n 0.000209 460.7000n 0.000379 460.7100n 0.000536 460.7200n 0.000676 460.7300n 0.000796 460.7400n 0.000892 460.7500n 0.000961 460.7600n 0.001001 460.7700n 0.001011 460.7800n 0.000990 460.7900n 0.000937
+ 460.8000n 0.000853 460.8100n 0.000740 460.8200n 0.000599 460.8300n 0.000434 460.8400n 0.000247 460.8500n 0.000042 460.8600n -0.000176 460.8700n -0.000404 460.8800n -0.000635 460.8900n -0.000865 460.9000n -0.001089 460.9100n -0.001302 460.9200n -0.001498 460.9300n -0.001675 460.9400n -0.001826
+ 460.9500n -0.001949 460.9600n -0.002040 460.9700n -0.002097 460.9800n -0.002118 460.9900n -0.002102 461.0000n -0.002048 461.0100n -0.001958 461.0200n -0.001832 461.0300n -0.001673 461.0400n -0.001483 461.0500n -0.001265 461.0600n -0.001024 461.0700n -0.000764 461.0800n -0.000490 461.0900n -0.000207
+ 461.1000n 0.000079 461.1100n 0.000363 461.1200n 0.000640 461.1300n 0.000905 461.1400n 0.001152 461.1500n 0.001376 461.1600n 0.001574 461.1700n 0.001742 461.1800n 0.001877 461.1900n 0.001977 461.2000n 0.002040 461.2100n 0.002065 461.2200n 0.002053 461.2300n 0.002004 461.2400n 0.001920
+ 461.2500n 0.001803 461.2600n 0.001656 461.2700n 0.001483 461.2800n 0.001288 461.2900n 0.001075 461.3000n 0.000849 461.3100n 0.000615 461.3200n 0.000379 461.3300n 0.000145 461.3400n -0.000082 461.3500n -0.000295 461.3600n -0.000492 461.3700n -0.000669 461.3800n -0.000820 461.3900n -0.000944
+ 461.4000n -0.001038 461.4100n -0.001101 461.4200n -0.001131 461.4300n -0.001129 461.4400n -0.001094 461.4500n -0.001028 461.4600n -0.000933 461.4700n -0.000811 461.4800n -0.000666 461.4900n -0.000500 461.5000n -0.000318 461.5100n -0.000124 461.5200n 0.000078 461.5300n 0.000284 461.5400n 0.000489
+ 461.5500n 0.000688 461.5600n 0.000878 461.5700n 0.001055 461.5800n 0.001215 461.5900n 0.001355 461.6000n 0.001472 461.6100n 0.001566 461.6200n 0.001634 461.6300n 0.001675 461.6400n 0.001690 461.6500n 0.001679 461.6600n 0.001643 461.6700n 0.001583 461.6800n 0.001502 461.6900n 0.001402
+ 461.7000n 0.001286 461.7100n 0.001156 461.7200n 0.001017 461.7300n 0.000870 461.7400n 0.000721 461.7500n 0.000572 461.7600n 0.000426 461.7700n 0.000286 461.7800n 0.000155 461.7900n 0.000035 461.8000n -0.000073 461.8100n -0.000166 461.8200n -0.000245 461.8300n -0.000309 461.8400n -0.000358
+ 461.8500n -0.000393 461.8600n -0.000415 461.8700n -0.000426 461.8800n -0.000428 461.8900n -0.000422 461.9000n -0.000412 461.9100n -0.000400 461.9200n -0.000390 461.9300n -0.000383 461.9400n -0.000383 461.9500n -0.000392 461.9600n -0.000412 461.9700n -0.000446 461.9800n -0.000496 461.9900n -0.000562
+ 462.0000n -0.000645 462.0100n -0.000746 462.0200n -0.000864 462.0300n -0.000998 462.0400n -0.001148 462.0500n -0.001311 462.0600n -0.001485 462.0700n -0.001667 462.0800n -0.001854 462.0900n -0.002043 462.1000n -0.002230 462.1100n -0.002412 462.1200n -0.002584 462.1300n -0.002742 462.1400n -0.002884
+ 462.1500n -0.003005 462.1600n -0.003103 462.1700n -0.003174 462.1800n -0.003217 462.1900n -0.003229 462.2000n -0.003210 462.2100n -0.003158 462.2200n -0.003074 462.2300n -0.002959 462.2400n -0.002813 462.2500n -0.002638 462.2600n -0.002437 462.2700n -0.002213 462.2800n -0.001969 462.2900n -0.001709
+ 462.3000n -0.001438 462.3100n -0.001159 462.3200n -0.000878 462.3300n -0.000599 462.3400n -0.000326 462.3500n -0.000064 462.3600n 0.000182 462.3700n 0.000409 462.3800n 0.000614 462.3900n 0.000792 462.4000n 0.000943 462.4100n 0.001063 462.4200n 0.001151 462.4300n 0.001208 462.4400n 0.001232
+ 462.4500n 0.001225 462.4600n 0.001187 462.4700n 0.001121 462.4800n 0.001029 462.4900n 0.000913 462.5000n 0.000778 462.5100n 0.000627 462.5200n 0.000463 462.5300n 0.000291 462.5400n 0.000116 462.5500n -0.000060 462.5600n -0.000231 462.5700n -0.000395 462.5800n -0.000546 462.5900n -0.000683
+ 462.6000n -0.000802 462.6100n -0.000900 462.6200n -0.000977 462.6300n -0.001030 462.6400n -0.001059 462.6500n -0.001064 462.6600n -0.001044 462.6700n -0.001002 462.6800n -0.000939 462.6900n -0.000855 462.7000n -0.000755 462.7100n -0.000640 462.7200n -0.000513 462.7300n -0.000379 462.7400n -0.000239
+ 462.7500n -0.000097 462.7600n 0.000043 462.7700n 0.000178 462.7800n 0.000305 462.7900n 0.000421 462.8000n 0.000524 462.8100n 0.000611 462.8200n 0.000682 462.8300n 0.000733 462.8400n 0.000766 462.8500n 0.000779 462.8600n 0.000772 462.8700n 0.000746 462.8800n 0.000702 462.8900n 0.000642
+ 462.9000n 0.000566 462.9100n 0.000478 462.9200n 0.000379 462.9300n 0.000272 462.9400n 0.000160 462.9500n 0.000044 462.9600n -0.000071 462.9700n -0.000184 462.9800n -0.000292 462.9900n -0.000394 463.0000n -0.000486 463.0100n -0.000567 463.0200n -0.000636 463.0300n -0.000693 463.0400n -0.000735
+ 463.0500n -0.000763 463.0600n -0.000778 463.0700n -0.000779 463.0800n -0.000767 463.0900n -0.000744 463.1000n -0.000711 463.1100n -0.000669 463.1200n -0.000621 463.1300n -0.000568 463.1400n -0.000513 463.1500n -0.000456 463.1600n -0.000401 463.1700n -0.000350 463.1800n -0.000303 463.1900n -0.000263
+ 463.2000n -0.000232 463.2100n -0.000209 463.2200n -0.000196 463.2300n -0.000194 463.2400n -0.000203 463.2500n -0.000222 463.2600n -0.000252 463.2700n -0.000291 463.2800n -0.000339 463.2900n -0.000395 463.3000n -0.000457 463.3100n -0.000524 463.3200n -0.000594 463.3300n -0.000666 463.3400n -0.000737
+ 463.3500n -0.000806 463.3600n -0.000873 463.3700n -0.000934 463.3800n -0.000990 463.3900n -0.001038 463.4000n -0.001078 463.4100n -0.001110 463.4200n -0.001132 463.4300n -0.001146 463.4400n -0.001151 463.4500n -0.001147 463.4600n -0.001135 463.4700n -0.001116 463.4800n -0.001092 463.4900n -0.001062
+ 463.5000n -0.001029 463.5100n -0.000994 463.5200n -0.000958 463.5300n -0.000923 463.5400n -0.000889 463.5500n -0.000858 463.5600n -0.000831 463.5700n -0.000809 463.5800n -0.000792 463.5900n -0.000781 463.6000n -0.000775 463.6100n -0.000775 463.6200n -0.000779 463.6300n -0.000788 463.6400n -0.000801
+ 463.6500n -0.000815 463.6600n -0.000830 463.6700n -0.000845 463.6800n -0.000857 463.6900n -0.000866 463.7000n -0.000868 463.7100n -0.000863 463.7200n -0.000849 463.7300n -0.000825 463.7400n -0.000789 463.7500n -0.000741 463.7600n -0.000679 463.7700n -0.000604 463.7800n -0.000514 463.7900n -0.000411
+ 463.8000n -0.000295 463.8100n -0.000167 463.8200n -0.000029 463.8300n 0.000118 463.8400n 0.000272 463.8500n 0.000431 463.8600n 0.000592 463.8700n 0.000753 463.8800n 0.000910 463.8900n 0.001061 463.9000n 0.001203 463.9100n 0.001333 463.9200n 0.001449 463.9300n 0.001548 463.9400n 0.001628
+ 463.9500n 0.001687 463.9600n 0.001724 463.9700n 0.001738 463.9800n 0.001727 463.9900n 0.001693 464.0000n 0.001635 464.0100n 0.001554 464.0200n 0.001451 464.0300n 0.001329 464.0400n 0.001188 464.0500n 0.001033 464.0600n 0.000866 464.0700n 0.000690 464.0800n 0.000508 464.0900n 0.000325
+ 464.1000n 0.000143 464.1100n -0.000033 464.1200n -0.000201 464.1300n -0.000356 464.1400n -0.000496 464.1500n -0.000617 464.1600n -0.000717 464.1700n -0.000795 464.1800n -0.000848 464.1900n -0.000875 464.2000n -0.000876 464.2100n -0.000851 464.2200n -0.000800 464.2300n -0.000724 464.2400n -0.000625
+ 464.2500n -0.000505 464.2600n -0.000366 464.2700n -0.000211 464.2800n -0.000042 464.2900n 0.000136 464.3000n 0.000320 464.3100n 0.000507 464.3200n 0.000692 464.3300n 0.000874 464.3400n 0.001047 464.3500n 0.001210 464.3600n 0.001359 464.3700n 0.001491 464.3800n 0.001606 464.3900n 0.001700
+ 464.4000n 0.001773 464.4100n 0.001825 464.4200n 0.001854 464.4300n 0.001862 464.4400n 0.001849 464.4500n 0.001816 464.4600n 0.001765 464.4700n 0.001699 464.4800n 0.001619 464.4900n 0.001529 464.5000n 0.001430 464.5100n 0.001326 464.5200n 0.001220 464.5300n 0.001115 464.5400n 0.001013
+ 464.5500n 0.000917 464.5600n 0.000829 464.5700n 0.000752 464.5800n 0.000686 464.5900n 0.000634 464.6000n 0.000596 464.6100n 0.000572 464.6200n 0.000563 464.6300n 0.000567 464.6400n 0.000584 464.6500n 0.000612 464.6600n 0.000650 464.6700n 0.000696 464.6800n 0.000747 464.6900n 0.000800
+ 464.7000n 0.000854 464.7100n 0.000905 464.7200n 0.000951 464.7300n 0.000990 464.7400n 0.001018 464.7500n 0.001034 464.7600n 0.001035 464.7700n 0.001022 464.7800n 0.000991 464.7900n 0.000943 464.8000n 0.000878 464.8100n 0.000797 464.8200n 0.000698 464.8300n 0.000586 464.8400n 0.000460
+ 464.8500n 0.000323 464.8600n 0.000179 464.8700n 0.000029 464.8800n -0.000123 464.8900n -0.000273 464.9000n -0.000418 464.9100n -0.000555 464.9200n -0.000680 464.9300n -0.000790 464.9400n -0.000882 464.9500n -0.000952 464.9600n -0.000999 464.9700n -0.001021 464.9800n -0.001016 464.9900n -0.000983
+ 465.0000n -0.000922 465.0100n -0.000834 465.0200n -0.000718 465.0300n -0.000578 465.0400n -0.000414 465.0500n -0.000229 465.0600n -0.000027 465.0700n 0.000190 465.0800n 0.000416 465.0900n 0.000648 465.1000n 0.000881 465.1100n 0.001112 465.1200n 0.001334 465.1300n 0.001544 465.1400n 0.001738
+ 465.1500n 0.001911 465.1600n 0.002060 465.1700n 0.002181 465.1800n 0.002272 465.1900n 0.002330 465.2000n 0.002354 465.2100n 0.002343 465.2200n 0.002297 465.2300n 0.002216 465.2400n 0.002102 465.2500n 0.001955 465.2600n 0.001780 465.2700n 0.001577 465.2800n 0.001352 465.2900n 0.001108
+ 465.3000n 0.000850 465.3100n 0.000582 465.3200n 0.000308 465.3300n 0.000035 465.3400n -0.000234 465.3500n -0.000493 465.3600n -0.000738 465.3700n -0.000965 465.3800n -0.001170 465.3900n -0.001349 465.4000n -0.001499 465.4100n -0.001619 465.4200n -0.001706 465.4300n -0.001760 465.4400n -0.001781
+ 465.4500n -0.001767 465.4600n -0.001722 465.4700n -0.001645 465.4800n -0.001540 465.4900n -0.001409 465.5000n -0.001256 465.5100n -0.001083 465.5200n -0.000895 465.5300n -0.000696 465.5400n -0.000491 465.5500n -0.000282 465.5600n -0.000076 465.5700n 0.000125 465.5800n 0.000315 465.5900n 0.000493
+ 465.6000n 0.000654 465.6100n 0.000796 465.6200n 0.000917 465.6300n 0.001014 465.6400n 0.001088 465.6500n 0.001136 465.6600n 0.001160 465.6700n 0.001159 465.6800n 0.001135 465.6900n 0.001090 465.7000n 0.001025 465.7100n 0.000943 465.7200n 0.000847 465.7300n 0.000739 465.7400n 0.000624
+ 465.7500n 0.000504 465.7600n 0.000383 465.7700n 0.000263 465.7800n 0.000149 465.7900n 0.000042 465.8000n -0.000054 465.8100n -0.000136 465.8200n -0.000204 465.8300n -0.000256 465.8400n -0.000291 465.8500n -0.000307 465.8600n -0.000306 465.8700n -0.000288 465.8800n -0.000253 465.8900n -0.000203
+ 465.9000n -0.000140 465.9100n -0.000066 465.9200n 0.000016 465.9300n 0.000104 465.9400n 0.000195 465.9500n 0.000286 465.9600n 0.000374 465.9700n 0.000456 465.9800n 0.000528 465.9900n 0.000589 466.0000n 0.000636 466.0100n 0.000666 466.0200n 0.000678 466.0300n 0.000671 466.0400n 0.000644
+ 466.0500n 0.000596 466.0600n 0.000527 466.0700n 0.000439 466.0800n 0.000331 466.0900n 0.000206 466.1000n 0.000065 466.1100n -0.000089 466.1200n -0.000254 466.1300n -0.000426 466.1400n -0.000603 466.1500n -0.000780 466.1600n -0.000956 466.1700n -0.001125 466.1800n -0.001285 466.1900n -0.001433
+ 466.2000n -0.001565 466.2100n -0.001678 466.2200n -0.001770 466.2300n -0.001839 466.2400n -0.001882 466.2500n -0.001899 466.2600n -0.001889 466.2700n -0.001851 466.2800n -0.001786 466.2900n -0.001693 466.3000n -0.001575 466.3100n -0.001432 466.3200n -0.001268 466.3300n -0.001083 466.3400n -0.000881
+ 466.3500n -0.000665 466.3600n -0.000439 466.3700n -0.000205 466.3800n 0.000034 466.3900n 0.000272 466.4000n 0.000507 466.4100n 0.000736 466.4200n 0.000954 466.4300n 0.001159 466.4400n 0.001349 466.4500n 0.001520 466.4600n 0.001670 466.4700n 0.001798 466.4800n 0.001903 466.4900n 0.001982
+ 466.5000n 0.002037 466.5100n 0.002066 466.5200n 0.002070 466.5300n 0.002050 466.5400n 0.002007 466.5500n 0.001942 466.5600n 0.001858 466.5700n 0.001757 466.5800n 0.001640 466.5900n 0.001511 466.6000n 0.001372 466.6100n 0.001226 466.6200n 0.001076 466.6300n 0.000925 466.6400n 0.000775
+ 466.6500n 0.000629 466.6600n 0.000490 466.6700n 0.000361 466.6800n 0.000242 466.6900n 0.000136 466.7000n 0.000045 466.7100n -0.000030 466.7200n -0.000089 466.7300n -0.000130 466.7400n -0.000154 466.7500n -0.000159 466.7600n -0.000148 466.7700n -0.000120 466.7800n -0.000076 466.7900n -0.000017
+ 466.8000n 0.000055 466.8100n 0.000140 466.8200n 0.000234 466.8300n 0.000336 466.8400n 0.000445 466.8500n 0.000558 466.8600n 0.000674 466.8700n 0.000790 466.8800n 0.000904 466.8900n 0.001015 466.9000n 0.001121 466.9100n 0.001221 466.9200n 0.001312 466.9300n 0.001394 466.9400n 0.001466
+ 466.9500n 0.001526 466.9600n 0.001574 466.9700n 0.001610 466.9800n 0.001633 466.9900n 0.001643 467.0000n 0.001641 467.0100n 0.001627 467.0200n 0.001602 467.0300n 0.001566 467.0400n 0.001520 467.0500n 0.001466 467.0600n 0.001404 467.0700n 0.001336 467.0800n 0.001263 467.0900n 0.001187
+ 467.1000n 0.001108 467.1100n 0.001029 467.1200n 0.000951 467.1300n 0.000875 467.1400n 0.000802 467.1500n 0.000733 467.1600n 0.000670 467.1700n 0.000614 467.1800n 0.000564 467.1900n 0.000522 467.2000n 0.000488 467.2100n 0.000462 467.2200n 0.000445 467.2300n 0.000436 467.2400n 0.000435
+ 467.2500n 0.000441 467.2600n 0.000454 467.2700n 0.000473 467.2800n 0.000497 467.2900n 0.000525 467.3000n 0.000556 467.3100n 0.000589 467.3200n 0.000621 467.3300n 0.000653 467.3400n 0.000682 467.3500n 0.000708 467.3600n 0.000729 467.3700n 0.000744 467.3800n 0.000751 467.3900n 0.000751
+ 467.4000n 0.000741 467.4100n 0.000723 467.4200n 0.000694 467.4300n 0.000655 467.4400n 0.000605 467.4500n 0.000546 467.4600n 0.000477 467.4700n 0.000399 467.4800n 0.000312 467.4900n 0.000219 467.5000n 0.000119 467.5100n 0.000015 467.5200n -0.000093 467.5300n -0.000202 467.5400n -0.000311
+ 467.5500n -0.000417 467.5600n -0.000520 467.5700n -0.000618 467.5800n -0.000708 467.5900n -0.000788 467.6000n -0.000859 467.6100n -0.000917 467.6200n -0.000962 467.6300n -0.000992 467.6400n -0.001007 467.6500n -0.001007 467.6600n -0.000990 467.6700n -0.000957 467.6800n -0.000909 467.6900n -0.000845
+ 467.7000n -0.000767 467.7100n -0.000675 467.7200n -0.000571 467.7300n -0.000457 467.7400n -0.000334 467.7500n -0.000205 467.7600n -0.000070 467.7700n 0.000067 467.7800n 0.000204 467.7900n 0.000339 467.8000n 0.000470 467.8100n 0.000594 467.8200n 0.000710 467.8300n 0.000816 467.8400n 0.000910
+ 467.8500n 0.000990 467.8600n 0.001056 467.8700n 0.001106 467.8800n 0.001139 467.8900n 0.001156 467.9000n 0.001157 467.9100n 0.001141 467.9200n 0.001109 467.9300n 0.001063 467.9400n 0.001003 467.9500n 0.000931 467.9600n 0.000848 467.9700n 0.000756 467.9800n 0.000657 467.9900n 0.000554
+ 468.0000n 0.000448 468.0100n 0.000342 468.0200n 0.000237 468.0300n 0.000136 468.0400n 0.000040 468.0500n -0.000049 468.0600n -0.000129 468.0700n -0.000199 468.0800n -0.000258 468.0900n -0.000305 468.1000n -0.000340 468.1100n -0.000363 468.1200n -0.000373 468.1300n -0.000372 468.1400n -0.000359
+ 468.1500n -0.000336 468.1600n -0.000305 468.1700n -0.000266 468.1800n -0.000220 468.1900n -0.000171 468.2000n -0.000118 468.2100n -0.000065 468.2200n -0.000012 468.2300n 0.000038 468.2400n 0.000084 468.2500n 0.000124 468.2600n 0.000158 468.2700n 0.000184 468.2800n 0.000202 468.2900n 0.000211
+ 468.3000n 0.000211 468.3100n 0.000201 468.3200n 0.000183 468.3300n 0.000157 468.3400n 0.000124 468.3500n 0.000085 468.3600n 0.000041 468.3700n -0.000007 468.3800n -0.000055 468.3900n -0.000104 468.4000n -0.000150 468.4100n -0.000193 468.4200n -0.000231 468.4300n -0.000261 468.4400n -0.000283
+ 468.4500n -0.000295 468.4600n -0.000297 468.4700n -0.000287 468.4800n -0.000266 468.4900n -0.000233 468.5000n -0.000188 468.5100n -0.000132 468.5200n -0.000066 468.5300n 0.000009 468.5400n 0.000090 468.5500n 0.000178 468.5600n 0.000268 468.5700n 0.000359 468.5800n 0.000449 468.5900n 0.000536
+ 468.6000n 0.000615 468.6100n 0.000686 468.6200n 0.000745 468.6300n 0.000791 468.6400n 0.000821 468.6500n 0.000833 468.6600n 0.000827 468.6700n 0.000800 468.6800n 0.000753 468.6900n 0.000685 468.7000n 0.000596 468.7100n 0.000487 468.7200n 0.000359 468.7300n 0.000214 468.7400n 0.000053
+ 468.7500n -0.000121 468.7600n -0.000306 468.7700n -0.000497 468.7800n -0.000693 468.7900n -0.000890 468.8000n -0.001084 468.8100n -0.001271 468.8200n -0.001448 468.8300n -0.001612 468.8400n -0.001759 468.8500n -0.001886 468.8600n -0.001991 468.8700n -0.002071 468.8800n -0.002124 468.8900n -0.002150
+ 468.9000n -0.002148 468.9100n -0.002116 468.9200n -0.002056 468.9300n -0.001968 468.9400n -0.001854 468.9500n -0.001716 468.9600n -0.001556 468.9700n -0.001377 468.9800n -0.001182 468.9900n -0.000975 469.0000n -0.000760 469.0100n -0.000541 469.0200n -0.000322 469.0300n -0.000107 469.0400n 0.000100
+ 469.0500n 0.000294 469.0600n 0.000473 469.0700n 0.000633 469.0800n 0.000770 469.0900n 0.000883 469.1000n 0.000968 469.1100n 0.001026 469.1200n 0.001055 469.1300n 0.001054 469.1400n 0.001024 469.1500n 0.000966 469.1600n 0.000881 469.1700n 0.000771 469.1800n 0.000639 469.1900n 0.000488
+ 469.2000n 0.000320 469.2100n 0.000140 469.2200n -0.000048 469.2300n -0.000242 469.2400n -0.000435 469.2500n -0.000626 469.2600n -0.000809 469.2700n -0.000981 469.2800n -0.001138 469.2900n -0.001278 469.3000n -0.001398 469.3100n -0.001495 469.3200n -0.001568 469.3300n -0.001615 469.3400n -0.001637
+ 469.3500n -0.001632 469.3600n -0.001601 469.3700n -0.001546 469.3800n -0.001468 469.3900n -0.001369 469.4000n -0.001251 469.4100n -0.001117 469.4200n -0.000971 469.4300n -0.000815 469.4400n -0.000653 469.4500n -0.000489 469.4600n -0.000326 469.4700n -0.000167 469.4800n -0.000016 469.4900n 0.000124
+ 469.5000n 0.000251 469.5100n 0.000363 469.5200n 0.000456 469.5300n 0.000531 469.5400n 0.000586 469.5500n 0.000620 469.5600n 0.000633 469.5700n 0.000627 469.5800n 0.000602 469.5900n 0.000558 469.6000n 0.000500 469.6100n 0.000427 469.6200n 0.000343 469.6300n 0.000251 469.6400n 0.000153
+ 469.6500n 0.000052 469.6600n -0.000049 469.6700n -0.000147 469.6800n -0.000239 469.6900n -0.000323 469.7000n -0.000396 469.7100n -0.000457 469.7200n -0.000504 469.7300n -0.000536 469.7400n -0.000551 469.7500n -0.000551 469.7600n -0.000534 469.7700n -0.000501 469.7800n -0.000455 469.7900n -0.000395
+ 469.8000n -0.000323 469.8100n -0.000243 469.8200n -0.000155 469.8300n -0.000064 469.8400n 0.000029 469.8500n 0.000120 469.8600n 0.000207 469.8700n 0.000287 469.8800n 0.000357 469.8900n 0.000415 469.9000n 0.000458 469.9100n 0.000485 469.9200n 0.000493 469.9300n 0.000483 469.9400n 0.000453
+ 469.9500n 0.000402 469.9600n 0.000331 469.9700n 0.000241 469.9800n 0.000133 469.9900n 0.000007 470.0000n -0.000133 470.0100n -0.000286 470.0200n -0.000450 470.0300n -0.000621 470.0400n -0.000797 470.0500n -0.000974 470.0600n -0.001149 470.0700n -0.001320 470.0800n -0.001482 470.0900n -0.001634
+ 470.1000n -0.001772 470.1100n -0.001895 470.1200n -0.001999 470.1300n -0.002083 470.1400n -0.002146 470.1500n -0.002186 470.1600n -0.002203 470.1700n -0.002198 470.1800n -0.002169 470.1900n -0.002118 470.2000n -0.002047 470.2100n -0.001955 470.2200n -0.001846 470.2300n -0.001721 470.2400n -0.001583
+ 470.2500n -0.001433 470.2600n -0.001275 470.2700n -0.001112 470.2800n -0.000945 470.2900n -0.000778 470.3000n -0.000614 470.3100n -0.000453 470.3200n -0.000299 470.3300n -0.000154 470.3400n -0.000019 470.3500n 0.000105 470.3600n 0.000216 470.3700n 0.000314 470.3800n 0.000398 470.3900n 0.000469
+ 470.4000n 0.000527 470.4100n 0.000571 470.4200n 0.000603 470.4300n 0.000625 470.4400n 0.000636 470.4500n 0.000639 470.4600n 0.000634 470.4700n 0.000624 470.4800n 0.000610 470.4900n 0.000592 470.5000n 0.000573 470.5100n 0.000554 470.5200n 0.000536 470.5300n 0.000519 470.5400n 0.000505
+ 470.5500n 0.000494 470.5600n 0.000485 470.5700n 0.000480 470.5800n 0.000478 470.5900n 0.000478 470.6000n 0.000480 470.6100n 0.000483 470.6200n 0.000486 470.6300n 0.000488 470.6400n 0.000489 470.6500n 0.000486 470.6600n 0.000479 470.6700n 0.000468 470.6800n 0.000449 470.6900n 0.000425
+ 470.7000n 0.000392 470.7100n 0.000351 470.7200n 0.000302 470.7300n 0.000245 470.7400n 0.000179 470.7500n 0.000106 470.7600n 0.000025 470.7700n -0.000061 470.7800n -0.000152 470.7900n -0.000247 470.8000n -0.000344 470.8100n -0.000441 470.8200n -0.000536 470.8300n -0.000627 470.8400n -0.000714
+ 470.8500n -0.000792 470.8600n -0.000862 470.8700n -0.000920 470.8800n -0.000965 470.8900n -0.000997 470.9000n -0.001012 470.9100n -0.001012 470.9200n -0.000994 470.9300n -0.000959 470.9400n -0.000906 470.9500n -0.000835 470.9600n -0.000747 470.9700n -0.000643 470.9800n -0.000523 470.9900n -0.000390
+ 471.0000n -0.000243 471.0100n -0.000086 471.0200n 0.000079 471.0300n 0.000252 471.0400n 0.000430 471.0500n 0.000610 471.0600n 0.000791 471.0700n 0.000971 471.0800n 0.001146 471.0900n 0.001317 471.1000n 0.001481 471.1100n 0.001636 471.1200n 0.001782 471.1300n 0.001916 471.1400n 0.002040
+ 471.1500n 0.002151 471.1600n 0.002251 471.1700n 0.002338 471.1800n 0.002413 471.1900n 0.002477 471.2000n 0.002530 471.2100n 0.002574 471.2200n 0.002609 471.2300n 0.002636 471.2400n 0.002657 471.2500n 0.002673 471.2600n 0.002685 471.2700n 0.002694 471.2800n 0.002702 471.2900n 0.002710
+ 471.3000n 0.002718 471.3100n 0.002727 471.3200n 0.002738 471.3300n 0.002751 471.3400n 0.002766 471.3500n 0.002783 471.3600n 0.002802 471.3700n 0.002823 471.3800n 0.002844 471.3900n 0.002866 471.4000n 0.002886 471.4100n 0.002905 471.4200n 0.002921 471.4300n 0.002932 471.4400n 0.002938
+ 471.4500n 0.002938 471.4600n 0.002930 471.4700n 0.002914 471.4800n 0.002888 471.4900n 0.002852 471.5000n 0.002806 471.5100n 0.002749 471.5200n 0.002681 471.5300n 0.002602 471.5400n 0.002513 471.5500n 0.002414 471.5600n 0.002306 471.5700n 0.002190 471.5800n 0.002067 471.5900n 0.001938
+ 471.6000n 0.001805 471.6100n 0.001669 471.6200n 0.001532 471.6300n 0.001396 471.6400n 0.001261 471.6500n 0.001130 471.6600n 0.001004 471.6700n 0.000884 471.6800n 0.000771 471.6900n 0.000667 471.7000n 0.000572 471.7100n 0.000487 471.7200n 0.000412 471.7300n 0.000347 471.7400n 0.000293
+ 471.7500n 0.000248 471.7600n 0.000213 471.7700n 0.000187 471.7800n 0.000168 471.7900n 0.000156 471.8000n 0.000149 471.8100n 0.000147 471.8200n 0.000147 471.8300n 0.000149 471.8400n 0.000152 471.8500n 0.000153 471.8600n 0.000151 471.8700n 0.000147 471.8800n 0.000138 471.8900n 0.000124
+ 471.9000n 0.000103 471.9100n 0.000077 471.9200n 0.000044 471.9300n 0.000005 471.9400n -0.000041 471.9500n -0.000093 471.9600n -0.000151 471.9700n -0.000213 471.9800n -0.000279 471.9900n -0.000349 472.0000n -0.000420 472.0100n -0.000492 472.0200n -0.000564 472.0300n -0.000635 472.0400n -0.000703
+ 472.0500n -0.000767 472.0600n -0.000827 472.0700n -0.000882 472.0800n -0.000932 472.0900n -0.000974 472.1000n -0.001010 472.1100n -0.001039 472.1200n -0.001061 472.1300n -0.001076 472.1400n -0.001085 472.1500n -0.001088 472.1600n -0.001085 472.1700n -0.001077 472.1800n -0.001066 472.1900n -0.001052
+ 472.2000n -0.001035 472.2100n -0.001017 472.2200n -0.000999 472.2300n -0.000980 472.2400n -0.000963 472.2500n -0.000947 472.2600n -0.000933 472.2700n -0.000921 472.2800n -0.000912 472.2900n -0.000904 472.3000n -0.000899 472.3100n -0.000894 472.3200n -0.000891 472.3300n -0.000888 472.3400n -0.000883
+ 472.3500n -0.000878 472.3600n -0.000869 472.3700n -0.000856 472.3800n -0.000839 472.3900n -0.000816 472.4000n -0.000785 472.4100n -0.000747 472.4200n -0.000701 472.4300n -0.000645 472.4400n -0.000581 472.4500n -0.000507 472.4600n -0.000424 472.4700n -0.000332 472.4800n -0.000233 472.4900n -0.000127
+ 472.5000n -0.000016 472.5100n 0.000100 472.5200n 0.000217 472.5300n 0.000334 472.5400n 0.000450 472.5500n 0.000560 472.5600n 0.000664 472.5700n 0.000759 472.5800n 0.000842 472.5900n 0.000911 472.6000n 0.000963 472.6100n 0.000998 472.6200n 0.001012 472.6300n 0.001006 472.6400n 0.000976
+ 472.6500n 0.000924 472.6600n 0.000848 472.6700n 0.000748 472.6800n 0.000626 472.6900n 0.000482 472.7000n 0.000317 472.7100n 0.000134 472.7200n -0.000066 472.7300n -0.000279 472.7400n -0.000502 472.7500n -0.000733 472.7600n -0.000968 472.7700n -0.001203 472.7800n -0.001434 472.7900n -0.001657
+ 472.8000n -0.001869 472.8100n -0.002066 472.8200n -0.002245 472.8300n -0.002401 472.8400n -0.002534 472.8500n -0.002639 472.8600n -0.002715 472.8700n -0.002761 472.8800n -0.002774 472.8900n -0.002756 472.9000n -0.002705 472.9100n -0.002622 472.9200n -0.002509 472.9300n -0.002366 472.9400n -0.002197
+ 472.9500n -0.002003 472.9600n -0.001788 472.9700n -0.001554 472.9800n -0.001307 472.9900n -0.001048 473.0000n -0.000782 473.0100n -0.000513 473.0200n -0.000246 473.0300n 0.000017 473.0400n 0.000272 473.0500n 0.000515 473.0600n 0.000743 473.0700n 0.000953 473.0800n 0.001144 473.0900n 0.001313
+ 473.1000n 0.001458 473.1100n 0.001580 473.1200n 0.001677 473.1300n 0.001750 473.1400n 0.001799 473.1500n 0.001826 473.1600n 0.001832 473.1700n 0.001818 473.1800n 0.001788 473.1900n 0.001742 473.2000n 0.001685 473.2100n 0.001619 473.2200n 0.001547 473.2300n 0.001471 473.2400n 0.001394
+ 473.2500n 0.001320 473.2600n 0.001250 473.2700n 0.001187 473.2800n 0.001132 473.2900n 0.001088 473.3000n 0.001054 473.3100n 0.001033 473.3200n 0.001024 473.3300n 0.001028 473.3400n 0.001043 473.3500n 0.001070 473.3600n 0.001106 473.3700n 0.001151 473.3800n 0.001202 473.3900n 0.001257
+ 473.4000n 0.001315 473.4100n 0.001372 473.4200n 0.001427 473.4300n 0.001476 473.4400n 0.001519 473.4500n 0.001551 473.4600n 0.001572 473.4700n 0.001580 473.4800n 0.001573 473.4900n 0.001549 473.5000n 0.001509 473.5100n 0.001450 473.5200n 0.001374 473.5300n 0.001281 473.5400n 0.001171
+ 473.5500n 0.001045 473.5600n 0.000904 473.5700n 0.000750 473.5800n 0.000585 473.5900n 0.000411 473.6000n 0.000230 473.6100n 0.000044 473.6200n -0.000144 473.6300n -0.000331 473.6400n -0.000515 473.6500n -0.000695 473.6600n -0.000868 473.6700n -0.001031 473.6800n -0.001184 473.6900n -0.001325
+ 473.7000n -0.001453 473.7100n -0.001567 473.7200n -0.001666 473.7300n -0.001751 473.7400n -0.001822 473.7500n -0.001879 473.7600n -0.001922 473.7700n -0.001954 473.7800n -0.001974 473.7900n -0.001985 473.8000n -0.001988 473.8100n -0.001985 473.8200n -0.001977 473.8300n -0.001966 473.8400n -0.001953
+ 473.8500n -0.001940 473.8600n -0.001928 473.8700n -0.001918 473.8800n -0.001911 473.8900n -0.001907 473.9000n -0.001908 473.9100n -0.001912 473.9200n -0.001920 473.9300n -0.001931 473.9400n -0.001944 473.9500n -0.001958 473.9600n -0.001973 473.9700n -0.001986 473.9800n -0.001997 473.9900n -0.002003
+ 474.0000n -0.002002 474.0100n -0.001994 474.0200n -0.001977 474.0300n -0.001949 474.0400n -0.001909 474.0500n -0.001855 474.0600n -0.001787 474.0700n -0.001705 474.0800n -0.001608 474.0900n -0.001495 474.1000n -0.001368 474.1100n -0.001227 474.1200n -0.001073 474.1300n -0.000908 474.1400n -0.000733
+ 474.1500n -0.000551 474.1600n -0.000363 474.1700n -0.000172 474.1800n 0.000019 474.1900n 0.000208 474.2000n 0.000392 474.2100n 0.000569 474.2200n 0.000734 474.2300n 0.000887 474.2400n 0.001024 474.2500n 0.001144 474.2600n 0.001244 474.2700n 0.001323 474.2800n 0.001380 474.2900n 0.001414
+ 474.3000n 0.001424 474.3100n 0.001411 474.3200n 0.001374 474.3300n 0.001315 474.3400n 0.001235 474.3500n 0.001136 474.3600n 0.001018 474.3700n 0.000885 474.3800n 0.000739 474.3900n 0.000582 474.4000n 0.000416 474.4100n 0.000246 474.4200n 0.000073 474.4300n -0.000099 474.4400n -0.000268
+ 474.4500n -0.000431 474.4600n -0.000587 474.4700n -0.000732 474.4800n -0.000865 474.4900n -0.000984 474.5000n -0.001088 474.5100n -0.001176 474.5200n -0.001248 474.5300n -0.001304 474.5400n -0.001343 474.5500n -0.001366 474.5600n -0.001373 474.5700n -0.001367 474.5800n -0.001347 474.5900n -0.001317
+ 474.6000n -0.001276 474.6100n -0.001228 474.6200n -0.001173 474.6300n -0.001114 474.6400n -0.001052 474.6500n -0.000989 474.6600n -0.000928 474.6700n -0.000868 474.6800n -0.000812 474.6900n -0.000761 474.7000n -0.000714 474.7100n -0.000674 474.7200n -0.000640 474.7300n -0.000613 474.7400n -0.000592
+ 474.7500n -0.000577 474.7600n -0.000567 474.7700n -0.000562 474.7800n -0.000561 474.7900n -0.000563 474.8000n -0.000566 474.8100n -0.000571 474.8200n -0.000575 474.8300n -0.000578 474.8400n -0.000578 474.8500n -0.000575 474.8600n -0.000569 474.8700n -0.000557 474.8800n -0.000541 474.8900n -0.000520
+ 474.9000n -0.000494 474.9100n -0.000462 474.9200n -0.000426 474.9300n -0.000386 474.9400n -0.000342 474.9500n -0.000296 474.9600n -0.000247 474.9700n -0.000199 474.9800n -0.000150 474.9900n -0.000103 475.0000n -0.000058 475.0100n -0.000016 475.0200n 0.000021 475.0300n 0.000053 475.0400n 0.000080
+ 475.0500n 0.000100 475.0600n 0.000114 475.0700n 0.000122 475.0800n 0.000124 475.0900n 0.000120 475.1000n 0.000110 475.1100n 0.000097 475.1200n 0.000079 475.1300n 0.000060 475.1400n 0.000039 475.1500n 0.000018 475.1600n -0.000002 475.1700n -0.000018 475.1800n -0.000031 475.1900n -0.000039
+ 475.2000n -0.000041 475.2100n -0.000036 475.2200n -0.000023 475.2300n -0.000003 475.2400n 0.000026 475.2500n 0.000063 475.2600n 0.000108 475.2700n 0.000160 475.2800n 0.000217 475.2900n 0.000279 475.3000n 0.000343 475.3100n 0.000409 475.3200n 0.000474 475.3300n 0.000536 475.3400n 0.000592
+ 475.3500n 0.000640 475.3600n 0.000678 475.3700n 0.000703 475.3800n 0.000714 475.3900n 0.000708 475.4000n 0.000683 475.4100n 0.000638 475.4200n 0.000572 475.4300n 0.000484 475.4400n 0.000373 475.4500n 0.000240 475.4600n 0.000085 475.4700n -0.000090 475.4800n -0.000285 475.4900n -0.000497
+ 475.5000n -0.000724 475.5100n -0.000963 475.5200n -0.001210 475.5300n -0.001463 475.5400n -0.001718 475.5500n -0.001970 475.5600n -0.002216 475.5700n -0.002452 475.5800n -0.002673 475.5900n -0.002876 475.6000n -0.003057 475.6100n -0.003213 475.6200n -0.003341 475.6300n -0.003439 475.6400n -0.003504
+ 475.6500n -0.003535 475.6600n -0.003531 475.6700n -0.003492 475.6800n -0.003418 475.6900n -0.003310 475.7000n -0.003170 475.7100n -0.003000 475.7200n -0.002803 475.7300n -0.002581 475.7400n -0.002339 475.7500n -0.002081 475.7600n -0.001810 475.7700n -0.001532 475.7800n -0.001252 475.7900n -0.000973
+ 475.8000n -0.000701 475.8100n -0.000440 475.8200n -0.000195 475.8300n 0.000032 475.8400n 0.000235 475.8500n 0.000412 475.8600n 0.000562 475.8700n 0.000680 475.8800n 0.000767 475.8900n 0.000822 475.9000n 0.000845 475.9100n 0.000836 475.9200n 0.000797 475.9300n 0.000729 475.9400n 0.000635
+ 475.9500n 0.000518 475.9600n 0.000381 475.9700n 0.000229 475.9800n 0.000064 475.9900n -0.000109 476.0000n -0.000285 476.0100n -0.000460 476.0200n -0.000631 476.0300n -0.000792 476.0400n -0.000941 476.0500n -0.001074 476.0600n -0.001189 476.0700n -0.001281 476.0800n -0.001351 476.0900n -0.001396
+ 476.1000n -0.001415 476.1100n -0.001409 476.1200n -0.001377 476.1300n -0.001322 476.1400n -0.001244 476.1500n -0.001146 476.1600n -0.001030 476.1700n -0.000899 476.1800n -0.000757 476.1900n -0.000607 476.2000n -0.000454 476.2100n -0.000300 476.2200n -0.000150 476.2300n -0.000008 476.2400n 0.000123
+ 476.2500n 0.000239 476.2600n 0.000338 476.2700n 0.000416 476.2800n 0.000471 476.2900n 0.000503 476.3000n 0.000508 476.3100n 0.000488 476.3200n 0.000442 476.3300n 0.000370 476.3400n 0.000273 476.3500n 0.000154 476.3600n 0.000014 476.3700n -0.000144 476.3800n -0.000318 476.3900n -0.000503
+ 476.4000n -0.000697 476.4100n -0.000896 476.4200n -0.001096 476.4300n -0.001294 476.4400n -0.001485 476.4500n -0.001666 476.4600n -0.001834 476.4700n -0.001986 476.4800n -0.002119 476.4900n -0.002232 476.5000n -0.002321 476.5100n -0.002386 476.5200n -0.002427 476.5300n -0.002443 476.5400n -0.002434
+ 476.5500n -0.002401 476.5600n -0.002345 476.5700n -0.002269 476.5800n -0.002173 476.5900n -0.002061 476.6000n -0.001936 476.6100n -0.001800 476.6200n -0.001657 476.6300n -0.001509 476.6400n -0.001361 476.6500n -0.001215 476.6600n -0.001075 476.6700n -0.000943 476.6800n -0.000822 476.6900n -0.000714
+ 476.7000n -0.000622 476.7100n -0.000548 476.7200n -0.000491 476.7300n -0.000454 476.7400n -0.000436 476.7500n -0.000438 476.7600n -0.000459 476.7700n -0.000498 476.7800n -0.000554 476.7900n -0.000625 476.8000n -0.000709 476.8100n -0.000804 476.8200n -0.000909 476.8300n -0.001019 476.8400n -0.001134
+ 476.8500n -0.001249 476.8600n -0.001364 476.8700n -0.001474 476.8800n -0.001578 476.8900n -0.001674 476.9000n -0.001760 476.9100n -0.001833 476.9200n -0.001894 476.9300n -0.001940 476.9400n -0.001971 476.9500n -0.001987 476.9600n -0.001987 476.9700n -0.001973 476.9800n -0.001943 476.9900n -0.001900
+ 477.0000n -0.001844 477.0100n -0.001777 477.0200n -0.001699 477.0300n -0.001614 477.0400n -0.001521 477.0500n -0.001424 477.0600n -0.001323 477.0700n -0.001221 477.0800n -0.001119 477.0900n -0.001019 477.1000n -0.000921 477.1100n -0.000828 477.1200n -0.000740 477.1300n -0.000659 477.1400n -0.000584
+ 477.1500n -0.000516 477.1600n -0.000456 477.1700n -0.000403 477.1800n -0.000357 477.1900n -0.000318 477.2000n -0.000285 477.2100n -0.000258 477.2200n -0.000235 477.2300n -0.000217 477.2400n -0.000202 477.2500n -0.000190 477.2600n -0.000179 477.2700n -0.000169 477.2800n -0.000159 477.2900n -0.000149
+ 477.3000n -0.000137 477.3100n -0.000125 477.3200n -0.000111 477.3300n -0.000095 477.3400n -0.000078 477.3500n -0.000060 477.3600n -0.000040 477.3700n -0.000021 477.3800n -0.000001 477.3900n 0.000017 477.4000n 0.000034 477.4100n 0.000049 477.4200n 0.000060 477.4300n 0.000067 477.4400n 0.000069
+ 477.4500n 0.000066 477.4600n 0.000057 477.4700n 0.000041 477.4800n 0.000017 477.4900n -0.000014 477.5000n -0.000052 477.5100n -0.000098 477.5200n -0.000152 477.5300n -0.000212 477.5400n -0.000280 477.5500n -0.000353 477.5600n -0.000432 477.5700n -0.000516 477.5800n -0.000603 477.5900n -0.000693
+ 477.6000n -0.000784 477.6100n -0.000876 477.6200n -0.000968 477.6300n -0.001057 477.6400n -0.001144 477.6500n -0.001227 477.6600n -0.001306 477.6700n -0.001379 477.6800n -0.001446 477.6900n -0.001507 477.7000n -0.001560 477.7100n -0.001607 477.7200n -0.001645 477.7300n -0.001676 477.7400n -0.001700
+ 477.7500n -0.001716 477.7600n -0.001725 477.7700n -0.001728 477.7800n -0.001724 477.7900n -0.001715 477.8000n -0.001701 477.8100n -0.001682 477.8200n -0.001659 477.8300n -0.001632 477.8400n -0.001603 477.8500n -0.001570 477.8600n -0.001536 477.8700n -0.001499 477.8800n -0.001461 477.8900n -0.001420
+ 477.9000n -0.001378 477.9100n -0.001334 477.9200n -0.001288 477.9300n -0.001240 477.9400n -0.001190 477.9500n -0.001136 477.9600n -0.001079 477.9700n -0.001019 477.9800n -0.000955 477.9900n -0.000887 478.0000n -0.000814 478.0100n -0.000737 478.0200n -0.000655 478.0300n -0.000569 478.0400n -0.000477
+ 478.0500n -0.000382 478.0600n -0.000282 478.0700n -0.000179 478.0800n -0.000074 478.0900n 0.000034 478.1000n 0.000143 478.1100n 0.000253 478.1200n 0.000361 478.1300n 0.000468 478.1400n 0.000572 478.1500n 0.000671 478.1600n 0.000765 478.1700n 0.000853 478.1800n 0.000932 478.1900n 0.001003
+ 478.2000n 0.001064 478.2100n 0.001114 478.2200n 0.001154 478.2300n 0.001181 478.2400n 0.001197 478.2500n 0.001200 478.2600n 0.001191 478.2700n 0.001170 478.2800n 0.001138 478.2900n 0.001095 478.3000n 0.001042 478.3100n 0.000980 478.3200n 0.000911 478.3300n 0.000834 478.3400n 0.000753
+ 478.3500n 0.000668 478.3600n 0.000580 478.3700n 0.000492 478.3800n 0.000405 478.3900n 0.000319 478.4000n 0.000238 478.4100n 0.000161 478.4200n 0.000090 478.4300n 0.000025 478.4400n -0.000031 478.4500n -0.000079 478.4600n -0.000119 478.4700n -0.000149 478.4800n -0.000171 478.4900n -0.000183
+ 478.5000n -0.000188 478.5100n -0.000184 478.5200n -0.000173 478.5300n -0.000156 478.5400n -0.000134 478.5500n -0.000107 478.5600n -0.000077 478.5700n -0.000045 478.5800n -0.000012 478.5900n 0.000021 478.6000n 0.000052 478.6100n 0.000081 478.6200n 0.000106 478.6300n 0.000128 478.6400n 0.000145
+ 478.6500n 0.000156 478.6600n 0.000163 478.6700n 0.000163 478.6800n 0.000158 478.6900n 0.000148 478.7000n 0.000133 478.7100n 0.000113 478.7200n 0.000090 478.7300n 0.000064 478.7400n 0.000036 478.7500n 0.000007 478.7600n -0.000022 478.7700n -0.000050 478.7800n -0.000076 478.7900n -0.000098
+ 478.8000n -0.000117 478.8100n -0.000130 478.8200n -0.000138 478.8300n -0.000139 478.8400n -0.000133 478.8500n -0.000121 478.8600n -0.000100 478.8700n -0.000073 478.8800n -0.000039 478.8900n 0.000003 478.9000n 0.000050 478.9100n 0.000103 478.9200n 0.000160 478.9300n 0.000221 478.9400n 0.000285
+ 478.9500n 0.000350 478.9600n 0.000415 478.9700n 0.000480 478.9800n 0.000542 478.9900n 0.000601 479.0000n 0.000656 479.0100n 0.000706 479.0200n 0.000749 479.0300n 0.000786 479.0400n 0.000815 479.0500n 0.000837 479.0600n 0.000850 479.0700n 0.000855 479.0800n 0.000851 479.0900n 0.000841
+ 479.1000n 0.000822 479.1100n 0.000797 479.1200n 0.000767 479.1300n 0.000731 479.1400n 0.000692 479.1500n 0.000649 479.1600n 0.000606 479.1700n 0.000562 479.1800n 0.000519 479.1900n 0.000479 479.2000n 0.000442 479.2100n 0.000410 479.2200n 0.000384 479.2300n 0.000365 479.2400n 0.000354
+ 479.2500n 0.000352 479.2600n 0.000358 479.2700n 0.000375 479.2800n 0.000401 479.2900n 0.000438 479.3000n 0.000485 479.3100n 0.000541 479.3200n 0.000607 479.3300n 0.000682 479.3400n 0.000766 479.3500n 0.000856 479.3600n 0.000954 479.3700n 0.001057 479.3800n 0.001165 479.3900n 0.001276
+ 479.4000n 0.001390 479.4100n 0.001504 479.4200n 0.001619 479.4300n 0.001732 479.4400n 0.001842 479.4500n 0.001949 479.4600n 0.002051 479.4700n 0.002147 479.4800n 0.002236 479.4900n 0.002317 479.5000n 0.002389 479.5100n 0.002452 479.5200n 0.002504 479.5300n 0.002545 479.5400n 0.002575
+ 479.5500n 0.002592 479.5600n 0.002597 479.5700n 0.002589 479.5800n 0.002568 479.5900n 0.002533 479.6000n 0.002485 479.6100n 0.002422 479.6200n 0.002346 479.6300n 0.002257 479.6400n 0.002154 479.6500n 0.002037 479.6600n 0.001907 479.6700n 0.001765 479.6800n 0.001611 479.6900n 0.001446
+ 479.7000n 0.001269 479.7100n 0.001083 479.7200n 0.000888 479.7300n 0.000685 479.7400n 0.000476 479.7500n 0.000261 479.7600n 0.000043 479.7700n -0.000178 479.7800n -0.000399 479.7900n -0.000620 479.8000n -0.000837 479.8100n -0.001051 479.8200n -0.001257 479.8300n -0.001456 479.8400n -0.001644
+ 479.8500n -0.001820 479.8600n -0.001983 479.8700n -0.002131 479.8800n -0.002262 479.8900n -0.002375 479.9000n -0.002469 479.9100n -0.002543 479.9200n -0.002596 479.9300n -0.002628 479.9400n -0.002638 479.9500n -0.002627 479.9600n -0.002595 479.9700n -0.002543 479.9800n -0.002471 479.9900n -0.002380
+ 480.0000n -0.002273 480.0100n -0.002150 480.0200n -0.002014 480.0300n -0.001866 480.0400n -0.001708 480.0500n -0.001544 480.0600n -0.001375 480.0700n -0.001204 480.0800n -0.001033 480.0900n -0.000864 480.1000n -0.000700 480.1100n -0.000543 480.1200n -0.000395 480.1300n -0.000257 480.1400n -0.000132
+ 480.1500n -0.000020 480.1600n 0.000077 480.1700n 0.000159 480.1800n 0.000225 480.1900n 0.000275 480.2000n 0.000310 480.2100n 0.000330 480.2200n 0.000335 480.2300n 0.000327 480.2400n 0.000307 480.2500n 0.000276 480.2600n 0.000236 480.2700n 0.000188 480.2800n 0.000136 480.2900n 0.000079
+ 480.3000n 0.000021 480.3100n -0.000037 480.3200n -0.000093 480.3300n -0.000146 480.3400n -0.000194 480.3500n -0.000236 480.3600n -0.000271 480.3700n -0.000298 480.3800n -0.000317 480.3900n -0.000327 480.4000n -0.000328 480.4100n -0.000320 480.4200n -0.000305 480.4300n -0.000283 480.4400n -0.000254
+ 480.4500n -0.000221 480.4600n -0.000183 480.4700n -0.000144 480.4800n -0.000103 480.4900n -0.000063 480.5000n -0.000026 480.5100n 0.000008 480.5200n 0.000037 480.5300n 0.000060 480.5400n 0.000075 480.5500n 0.000082 480.5600n 0.000081 480.5700n 0.000070 480.5800n 0.000050 480.5900n 0.000021
+ 480.6000n -0.000017 480.6100n -0.000063 480.6200n -0.000117 480.6300n -0.000176 480.6400n -0.000241 480.6500n -0.000308 480.6600n -0.000377 480.6700n -0.000446 480.6800n -0.000514 480.6900n -0.000577 480.7000n -0.000636 480.7100n -0.000687 480.7200n -0.000730 480.7300n -0.000763 480.7400n -0.000785
+ 480.7500n -0.000795 480.7600n -0.000792 480.7700n -0.000776 480.7800n -0.000747 480.7900n -0.000705 480.8000n -0.000651 480.8100n -0.000585 480.8200n -0.000509 480.8300n -0.000423 480.8400n -0.000330 480.8500n -0.000230 480.8600n -0.000126 480.8700n -0.000020 480.8800n 0.000087 480.8900n 0.000192
+ 480.9000n 0.000294 480.9100n 0.000391 480.9200n 0.000480 480.9300n 0.000562 480.9400n 0.000633 480.9500n 0.000694 480.9600n 0.000744 480.9700n 0.000783 480.9800n 0.000809 480.9900n 0.000824 481.0000n 0.000828 481.0100n 0.000821 481.0200n 0.000806 481.0300n 0.000783 481.0400n 0.000754
+ 481.0500n 0.000721 481.0600n 0.000685 481.0700n 0.000649 481.0800n 0.000615 481.0900n 0.000584 481.1000n 0.000558 481.1100n 0.000539 481.1200n 0.000529 481.1300n 0.000529 481.1400n 0.000540 481.1500n 0.000563 481.1600n 0.000597 481.1700n 0.000644 481.1800n 0.000702 481.1900n 0.000772
+ 481.2000n 0.000851 481.2100n 0.000939 481.2200n 0.001034 481.2300n 0.001134 481.2400n 0.001236 481.2500n 0.001339 481.2600n 0.001440 481.2700n 0.001536 481.2800n 0.001624 481.2900n 0.001703 481.3000n 0.001770 481.3100n 0.001822 481.3200n 0.001857 481.3300n 0.001875 481.3400n 0.001874
+ 481.3500n 0.001852 481.3600n 0.001810 481.3700n 0.001748 481.3800n 0.001665 481.3900n 0.001563 481.4000n 0.001443 481.4100n 0.001307 481.4200n 0.001158 481.4300n 0.000997 481.4400n 0.000827 481.4500n 0.000653 481.4600n 0.000476 481.4700n 0.000301 481.4800n 0.000130 481.4900n -0.000032
+ 481.5000n -0.000183 481.5100n -0.000319 481.5200n -0.000438 481.5300n -0.000537 481.5400n -0.000615 481.5500n -0.000669 481.5600n -0.000698 481.5700n -0.000702 481.5800n -0.000682 481.5900n -0.000636 481.6000n -0.000567 481.6100n -0.000476 481.6200n -0.000365 481.6300n -0.000237 481.6400n -0.000095
+ 481.6500n 0.000059 481.6600n 0.000219 481.6700n 0.000383 481.6800n 0.000546 481.6900n 0.000705 481.7000n 0.000856 481.7100n 0.000994 481.7200n 0.001116 481.7300n 0.001220 481.7400n 0.001302 481.7500n 0.001360 481.7600n 0.001391 481.7700n 0.001396 481.7800n 0.001373 481.7900n 0.001322
+ 481.8000n 0.001243 481.8100n 0.001138 481.8200n 0.001010 481.8300n 0.000859 481.8400n 0.000689 481.8500n 0.000503 481.8600n 0.000306 481.8700n 0.000101 481.8800n -0.000108 481.8900n -0.000316 481.9000n -0.000519 481.9100n -0.000712 481.9200n -0.000891 481.9300n -0.001053 481.9400n -0.001193
+ 481.9500n -0.001308 481.9600n -0.001395 481.9700n -0.001453 481.9800n -0.001481 481.9900n -0.001476 482.0000n -0.001439 482.0100n -0.001370 482.0200n -0.001270 482.0300n -0.001142 482.0400n -0.000988 482.0500n -0.000810 482.0600n -0.000612 482.0700n -0.000398 482.0800n -0.000173 482.0900n 0.000060
+ 482.1000n 0.000295 482.1100n 0.000528 482.1200n 0.000754 482.1300n 0.000969 482.1400n 0.001167 482.1500n 0.001345 482.1600n 0.001500 482.1700n 0.001628 482.1800n 0.001726 482.1900n 0.001793 482.2000n 0.001827 482.2100n 0.001828 482.2200n 0.001794 482.2300n 0.001728 482.2400n 0.001630
+ 482.2500n 0.001501 482.2600n 0.001345 482.2700n 0.001165 482.2800n 0.000963 482.2900n 0.000744 482.3000n 0.000511 482.3100n 0.000270 482.3200n 0.000023 482.3300n -0.000224 482.3400n -0.000467 482.3500n -0.000702 482.3600n -0.000925 482.3700n -0.001133 482.3800n -0.001323 482.3900n -0.001491
+ 482.4000n -0.001635 482.4100n -0.001754 482.4200n -0.001847 482.4300n -0.001913 482.4400n -0.001953 482.4500n -0.001966 482.4600n -0.001953 482.4700n -0.001918 482.4800n -0.001860 482.4900n -0.001783 482.5000n -0.001689 482.5100n -0.001581 482.5200n -0.001463 482.5300n -0.001336 482.5400n -0.001205
+ 482.5500n -0.001072 482.5600n -0.000939 482.5700n -0.000811 482.5800n -0.000689 482.5900n -0.000575 482.6000n -0.000470 482.6100n -0.000377 482.6200n -0.000296 482.6300n -0.000227 482.6400n -0.000171 482.6500n -0.000127 482.6600n -0.000095 482.6700n -0.000073 482.6800n -0.000061 482.6900n -0.000057
+ 482.7000n -0.000058 482.7100n -0.000064 482.7200n -0.000072 482.7300n -0.000080 482.7400n -0.000088 482.7500n -0.000091 482.7600n -0.000091 482.7700n -0.000084 482.7800n -0.000070 482.7900n -0.000048 482.8000n -0.000018 482.8100n 0.000020 482.8200n 0.000066 482.8300n 0.000119 482.8400n 0.000179
+ 482.8500n 0.000244 482.8600n 0.000313 482.8700n 0.000384 482.8800n 0.000454 482.8900n 0.000522 482.9000n 0.000587 482.9100n 0.000645 482.9200n 0.000695 482.9300n 0.000735 482.9400n 0.000763 482.9500n 0.000777 482.9600n 0.000778 482.9700n 0.000763 482.9800n 0.000732 482.9900n 0.000686
+ 483.0000n 0.000625 483.0100n 0.000549 483.0200n 0.000459 483.0300n 0.000358 483.0400n 0.000247 483.0500n 0.000128 483.0600n 0.000005 483.0700n -0.000122 483.0800n -0.000248 483.0900n -0.000370 483.1000n -0.000487 483.1100n -0.000594 483.1200n -0.000689 483.1300n -0.000770 483.1400n -0.000834
+ 483.1500n -0.000880 483.1600n -0.000905 483.1700n -0.000909 483.1800n -0.000892 483.1900n -0.000853 483.2000n -0.000792 483.2100n -0.000712 483.2200n -0.000612 483.2300n -0.000495 483.2400n -0.000363 483.2500n -0.000220 483.2600n -0.000068 483.2700n 0.000090 483.2800n 0.000249 483.2900n 0.000406
+ 483.3000n 0.000558 483.3100n 0.000700 483.3200n 0.000829 483.3300n 0.000942 483.3400n 0.001036 483.3500n 0.001108 483.3600n 0.001156 483.3700n 0.001178 483.3800n 0.001174 483.3900n 0.001142 483.4000n 0.001082 483.4100n 0.000996 483.4200n 0.000885 483.4300n 0.000750 483.4400n 0.000594
+ 483.4500n 0.000420 483.4600n 0.000231 483.4700n 0.000031 483.4800n -0.000176 483.4900n -0.000386 483.5000n -0.000595 483.5100n -0.000797 483.5200n -0.000989 483.5300n -0.001167 483.5400n -0.001327 483.5500n -0.001464 483.5600n -0.001577 483.5700n -0.001663 483.5800n -0.001718 483.5900n -0.001743
+ 483.6000n -0.001736 483.6100n -0.001697 483.6200n -0.001627 483.6300n -0.001527 483.6400n -0.001398 483.6500n -0.001243 483.6600n -0.001065 483.6700n -0.000867 483.6800n -0.000654 483.6900n -0.000429 483.7000n -0.000197 483.7100n 0.000037 483.7200n 0.000270 483.7300n 0.000497 483.7400n 0.000712
+ 483.7500n 0.000913 483.7600n 0.001095 483.7700n 0.001255 483.7800n 0.001391 483.7900n 0.001499 483.8000n 0.001578 483.8100n 0.001628 483.8200n 0.001647 483.8300n 0.001635 483.8400n 0.001594 483.8500n 0.001525 483.8600n 0.001430 483.8700n 0.001311 483.8800n 0.001171 483.8900n 0.001014
+ 483.9000n 0.000843 483.9100n 0.000662 483.9200n 0.000475 483.9300n 0.000286 483.9400n 0.000099 483.9500n -0.000082 483.9600n -0.000254 483.9700n -0.000414 483.9800n -0.000559 483.9900n -0.000686 484.0000n -0.000794 484.0100n -0.000880 484.0200n -0.000945 484.0300n -0.000988 484.0400n -0.001010
+ 484.0500n -0.001010 484.0600n -0.000991 484.0700n -0.000954 484.0800n -0.000902 484.0900n -0.000837 484.1000n -0.000762 484.1100n -0.000679 484.1200n -0.000593 484.1300n -0.000505 484.1400n -0.000420 484.1500n -0.000340 484.1600n -0.000268 484.1700n -0.000206 484.1800n -0.000157 484.1900n -0.000122
+ 484.2000n -0.000102 484.2100n -0.000098 484.2200n -0.000110 484.2300n -0.000139 484.2400n -0.000183 484.2500n -0.000241 484.2600n -0.000311 484.2700n -0.000392 484.2800n -0.000480 484.2900n -0.000573 484.3000n -0.000668 484.3100n -0.000763 484.3200n -0.000852 484.3300n -0.000935 484.3400n -0.001007
+ 484.3500n -0.001065 484.3600n -0.001108 484.3700n -0.001133 484.3800n -0.001137 484.3900n -0.001121 484.4000n -0.001082 484.4100n -0.001020 484.4200n -0.000936 484.4300n -0.000831 484.4400n -0.000705 484.4500n -0.000561 484.4600n -0.000401 484.4700n -0.000228 484.4800n -0.000044 484.4900n 0.000146
+ 484.5000n 0.000338 484.5100n 0.000530 484.5200n 0.000716 484.5300n 0.000893 484.5400n 0.001057 484.5500n 0.001204 484.5600n 0.001330 484.5700n 0.001433 484.5800n 0.001510 484.5900n 0.001559 484.6000n 0.001577 484.6100n 0.001565 484.6200n 0.001521 484.6300n 0.001445 484.6400n 0.001339
+ 484.6500n 0.001204 484.6600n 0.001041 484.6700n 0.000854 484.6800n 0.000645 484.6900n 0.000418 484.7000n 0.000176 484.7100n -0.000076 484.7200n -0.000333 484.7300n -0.000593 484.7400n -0.000849 484.7500n -0.001097 484.7600n -0.001334 484.7700n -0.001556 484.7800n -0.001757 484.7900n -0.001936
+ 484.8000n -0.002089 484.8100n -0.002214 484.8200n -0.002309 484.8300n -0.002373 484.8400n -0.002405 484.8500n -0.002405 484.8600n -0.002374 484.8700n -0.002312 484.8800n -0.002221 484.8900n -0.002103 484.9000n -0.001960 484.9100n -0.001796 484.9200n -0.001614 484.9300n -0.001417 484.9400n -0.001207
+ 484.9500n -0.000990 484.9600n -0.000769 484.9700n -0.000546 484.9800n -0.000325 484.9900n -0.000110 485.0000n 0.000097 485.0100n 0.000294 485.0200n 0.000478 485.0300n 0.000647 485.0400n 0.000801 485.0500n 0.000939 485.0600n 0.001060 485.0700n 0.001164 485.0800n 0.001252 485.0900n 0.001324
+ 485.1000n 0.001382 485.1100n 0.001427 485.1200n 0.001461 485.1300n 0.001484 485.1400n 0.001500 485.1500n 0.001510 485.1600n 0.001516 485.1700n 0.001520 485.1800n 0.001522 485.1900n 0.001526 485.2000n 0.001531 485.2100n 0.001540 485.2200n 0.001551 485.2300n 0.001566 485.2400n 0.001585
+ 485.2500n 0.001607 485.2600n 0.001632 485.2700n 0.001657 485.2800n 0.001683 485.2900n 0.001708 485.3000n 0.001729 485.3100n 0.001744 485.3200n 0.001753 485.3300n 0.001752 485.3400n 0.001740 485.3500n 0.001715 485.3600n 0.001675 485.3700n 0.001618 485.3800n 0.001543 485.3900n 0.001449
+ 485.4000n 0.001335 485.4100n 0.001201 485.4200n 0.001048 485.4300n 0.000875 485.4400n 0.000684 485.4500n 0.000475 485.4600n 0.000252 485.4700n 0.000015 485.4800n -0.000233 485.4900n -0.000488 485.5000n -0.000748 485.5100n -0.001010 485.5200n -0.001270 485.5300n -0.001524 485.5400n -0.001770
+ 485.5500n -0.002004 485.5600n -0.002223 485.5700n -0.002423 485.5800n -0.002602 485.5900n -0.002758 485.6000n -0.002887 485.6100n -0.002990 485.6200n -0.003063 485.6300n -0.003107 485.6400n -0.003121 485.6500n -0.003105 485.6600n -0.003060 485.6700n -0.002987 485.6800n -0.002887 485.6900n -0.002762
+ 485.7000n -0.002615 485.7100n -0.002448 485.7200n -0.002265 485.7300n -0.002067 485.7400n -0.001858 485.7500n -0.001642 485.7600n -0.001421 485.7700n -0.001200 485.7800n -0.000980 485.7900n -0.000765 485.8000n -0.000557 485.8100n -0.000360 485.8200n -0.000174 485.8300n -0.000002 485.8400n 0.000155
+ 485.8500n 0.000296 485.8600n 0.000420 485.8700n 0.000527 485.8800n 0.000617 485.8900n 0.000690 485.9000n 0.000748 485.9100n 0.000791 485.9200n 0.000820 485.9300n 0.000838 485.9400n 0.000845 485.9500n 0.000843 485.9600n 0.000834 485.9700n 0.000820 485.9800n 0.000802 485.9900n 0.000782
+ 486.0000n 0.000761 486.0100n 0.000741 486.0200n 0.000722 486.0300n 0.000705 486.0400n 0.000691 486.0500n 0.000680 486.0600n 0.000671 486.0700n 0.000666 486.0800n 0.000662 486.0900n 0.000660 486.1000n 0.000658 486.1100n 0.000655 486.1200n 0.000651 486.1300n 0.000643 486.1400n 0.000630
+ 486.1500n 0.000612 486.1600n 0.000586 486.1700n 0.000552 486.1800n 0.000508 486.1900n 0.000453 486.2000n 0.000387 486.2100n 0.000310 486.2200n 0.000221 486.2300n 0.000120 486.2400n 0.000008 486.2500n -0.000115 486.2600n -0.000248 486.2700n -0.000388 486.2800n -0.000535 486.2900n -0.000687
+ 486.3000n -0.000841 486.3100n -0.000996 486.3200n -0.001149 486.3300n -0.001298 486.3400n -0.001440 486.3500n -0.001572 486.3600n -0.001693 486.3700n -0.001799 486.3800n -0.001889 486.3900n -0.001961 486.4000n -0.002013 486.4100n -0.002044 486.4200n -0.002052 486.4300n -0.002037 486.4400n -0.001999
+ 486.4500n -0.001937 486.4600n -0.001852 486.4700n -0.001745 486.4800n -0.001617 486.4900n -0.001470 486.5000n -0.001305 486.5100n -0.001125 486.5200n -0.000933 486.5300n -0.000731 486.5400n -0.000522 486.5500n -0.000309 486.5600n -0.000095 486.5700n 0.000116 486.5800n 0.000321 486.5900n 0.000518
+ 486.6000n 0.000702 486.6100n 0.000872 486.6200n 0.001024 486.6300n 0.001157 486.6400n 0.001268 486.6500n 0.001355 486.6600n 0.001418 486.6700n 0.001456 486.6800n 0.001467 486.6900n 0.001451 486.7000n 0.001410 486.7100n 0.001342 486.7200n 0.001251 486.7300n 0.001136 486.7400n 0.000999
+ 486.7500n 0.000843 486.7600n 0.000669 486.7700n 0.000481 486.7800n 0.000280 486.7900n 0.000070 486.8000n -0.000147 486.8100n -0.000367 486.8200n -0.000587 486.8300n -0.000805 486.8400n -0.001018 486.8500n -0.001223 486.8600n -0.001416 486.8700n -0.001596 486.8800n -0.001761 486.8900n -0.001908
+ 486.9000n -0.002035 486.9100n -0.002142 486.9200n -0.002226 486.9300n -0.002287 486.9400n -0.002324 486.9500n -0.002337 486.9600n -0.002326 486.9700n -0.002291 486.9800n -0.002233 486.9900n -0.002151 487.0000n -0.002049 487.0100n -0.001926 487.0200n -0.001784 487.0300n -0.001625 487.0400n -0.001451
+ 487.0500n -0.001264 487.0600n -0.001065 487.0700n -0.000858 487.0800n -0.000643 487.0900n -0.000425 487.1000n -0.000204 487.1100n 0.000017 487.1200n 0.000235 487.1300n 0.000448 487.1400n 0.000655 487.1500n 0.000853 487.1600n 0.001041 487.1700n 0.001216 487.1800n 0.001378 487.1900n 0.001524
+ 487.2000n 0.001654 487.2100n 0.001766 487.2200n 0.001860 487.2300n 0.001935 487.2400n 0.001992 487.2500n 0.002028 487.2600n 0.002045 487.2700n 0.002044 487.2800n 0.002023 487.2900n 0.001984 487.3000n 0.001929 487.3100n 0.001857 487.3200n 0.001770 487.3300n 0.001669 487.3400n 0.001555
+ 487.3500n 0.001431 487.3600n 0.001298 487.3700n 0.001156 487.3800n 0.001009 487.3900n 0.000857 487.4000n 0.000703 487.4100n 0.000547 487.4200n 0.000392 487.4300n 0.000239 487.4400n 0.000090 487.4500n -0.000055 487.4600n -0.000195 487.4700n -0.000327 487.4800n -0.000452 487.4900n -0.000568
+ 487.5000n -0.000676 487.5100n -0.000774 487.5200n -0.000862 487.5300n -0.000941 487.5400n -0.001010 487.5500n -0.001070 487.5600n -0.001121 487.5700n -0.001163 487.5800n -0.001197 487.5900n -0.001224 487.6000n -0.001244 487.6100n -0.001258 487.6200n -0.001266 487.6300n -0.001270 487.6400n -0.001269
+ 487.6500n -0.001265 487.6600n -0.001257 487.6700n -0.001247 487.6800n -0.001235 487.6900n -0.001221 487.7000n -0.001204 487.7100n -0.001186 487.7200n -0.001166 487.7300n -0.001143 487.7400n -0.001118 487.7500n -0.001090 487.7600n -0.001058 487.7700n -0.001022 487.7800n -0.000982 487.7900n -0.000937
+ 487.8000n -0.000886 487.8100n -0.000828 487.8200n -0.000764 487.8300n -0.000693 487.8400n -0.000614 487.8500n -0.000528 487.8600n -0.000433 487.8700n -0.000331 487.8800n -0.000222 487.8900n -0.000105 487.9000n 0.000019 487.9100n 0.000148 487.9200n 0.000282 487.9300n 0.000420 487.9400n 0.000560
+ 487.9500n 0.000702 487.9600n 0.000843 487.9700n 0.000982 487.9800n 0.001118 487.9900n 0.001248 488.0000n 0.001372 488.0100n 0.001486 488.0200n 0.001591 488.0300n 0.001684 488.0400n 0.001763 488.0500n 0.001828 488.0600n 0.001878 488.0700n 0.001911 488.0800n 0.001927 488.0900n 0.001925
+ 488.1000n 0.001906 488.1100n 0.001870 488.1200n 0.001816 488.1300n 0.001746 488.1400n 0.001660 488.1500n 0.001560 488.1600n 0.001446 488.1700n 0.001322 488.1800n 0.001187 488.1900n 0.001044 488.2000n 0.000896 488.2100n 0.000743 488.2200n 0.000589 488.2300n 0.000435 488.2400n 0.000283
+ 488.2500n 0.000135 488.2600n -0.000006 488.2700n -0.000139 488.2800n -0.000263 488.2900n -0.000376 488.3000n -0.000477 488.3100n -0.000565 488.3200n -0.000639 488.3300n -0.000698 488.3400n -0.000743 488.3500n -0.000774 488.3600n -0.000790 488.3700n -0.000792 488.3800n -0.000781 488.3900n -0.000758
+ 488.4000n -0.000723 488.4100n -0.000677 488.4200n -0.000622 488.4300n -0.000559 488.4400n -0.000489 488.4500n -0.000413 488.4600n -0.000333 488.4700n -0.000249 488.4800n -0.000163 488.4900n -0.000076 488.5000n 0.000011 488.5100n 0.000099 488.5200n 0.000185 488.5300n 0.000269 488.5400n 0.000352
+ 488.5500n 0.000432 488.5600n 0.000510 488.5700n 0.000585 488.5800n 0.000659 488.5900n 0.000729 488.6000n 0.000798 488.6100n 0.000865 488.6200n 0.000930 488.6300n 0.000993 488.6400n 0.001055 488.6500n 0.001114 488.6600n 0.001172 488.6700n 0.001229 488.6800n 0.001283 488.6900n 0.001334
+ 488.7000n 0.001383 488.7100n 0.001427 488.7200n 0.001468 488.7300n 0.001503 488.7400n 0.001532 488.7500n 0.001554 488.7600n 0.001568 488.7700n 0.001573 488.7800n 0.001569 488.7900n 0.001554 488.8000n 0.001527 488.8100n 0.001489 488.8200n 0.001438 488.8300n 0.001374 488.8400n 0.001297
+ 488.8500n 0.001208 488.8600n 0.001107 488.8700n 0.000993 488.8800n 0.000870 488.8900n 0.000736 488.9000n 0.000595 488.9100n 0.000447 488.9200n 0.000294 488.9300n 0.000139 488.9400n -0.000016 488.9500n -0.000169 488.9600n -0.000318 488.9700n -0.000460 488.9800n -0.000593 488.9900n -0.000714
+ 489.0000n -0.000822 489.0100n -0.000914 489.0200n -0.000989 489.0300n -0.001045 489.0400n -0.001081 489.0500n -0.001096 489.0600n -0.001091 489.0700n -0.001064 489.0800n -0.001017 489.0900n -0.000951 489.1000n -0.000866 489.1100n -0.000765 489.1200n -0.000650 489.1300n -0.000523 489.1400n -0.000387
+ 489.1500n -0.000245 489.1600n -0.000100 489.1700n 0.000044 489.1800n 0.000183 489.1900n 0.000315 489.2000n 0.000436 489.2100n 0.000542 489.2200n 0.000631 489.2300n 0.000700 489.2400n 0.000745 489.2500n 0.000767 489.2600n 0.000762 489.2700n 0.000729 489.2800n 0.000669 489.2900n 0.000582
+ 489.3000n 0.000467 489.3100n 0.000326 489.3200n 0.000161 489.3300n -0.000025 489.3400n -0.000231 489.3500n -0.000453 489.3600n -0.000687 489.3700n -0.000929 489.3800n -0.001175 489.3900n -0.001421 489.4000n -0.001663 489.4100n -0.001895 489.4200n -0.002114 489.4300n -0.002316 489.4400n -0.002496
+ 489.4500n -0.002652 489.4600n -0.002779 489.4700n -0.002876 489.4800n -0.002941 489.4900n -0.002971 489.5000n -0.002967 489.5100n -0.002928 489.5200n -0.002855 489.5300n -0.002748 489.5400n -0.002609 489.5500n -0.002442 489.5600n -0.002248 489.5700n -0.002032 489.5800n -0.001797 489.5900n -0.001547
+ 489.6000n -0.001286 489.6100n -0.001020 489.6200n -0.000753 489.6300n -0.000490 489.6400n -0.000235 489.6500n 0.000008 489.6600n 0.000234 489.6700n 0.000439 489.6800n 0.000621 489.6900n 0.000776 489.7000n 0.000903 489.7100n 0.000999 489.7200n 0.001065 489.7300n 0.001100 489.7400n 0.001103
+ 489.7500n 0.001077 489.7600n 0.001023 489.7700n 0.000943 489.7800n 0.000840 489.7900n 0.000716 489.8000n 0.000577 489.8100n 0.000425 489.8200n 0.000264 489.8300n 0.000100 489.8400n -0.000065 489.8500n -0.000225 489.8600n -0.000377 489.8700n -0.000517 489.8800n -0.000642 489.8900n -0.000748
+ 489.9000n -0.000833 489.9100n -0.000895 489.9200n -0.000932 489.9300n -0.000944 489.9400n -0.000930 489.9500n -0.000890 489.9600n -0.000827 489.9700n -0.000740 489.9800n -0.000632 489.9900n -0.000506 490.0000n -0.000365 490.0100n -0.000212 490.0200n -0.000050 490.0300n 0.000116 490.0400n 0.000283
+ 490.0500n 0.000446 490.0600n 0.000602 490.0700n 0.000747 490.0800n 0.000878 490.0900n 0.000990 490.1000n 0.001083 490.1100n 0.001152 490.1200n 0.001197 490.1300n 0.001216 490.1400n 0.001208 490.1500n 0.001173 490.1600n 0.001112 490.1700n 0.001026 490.1800n 0.000916 490.1900n 0.000784
+ 490.2000n 0.000632 490.2100n 0.000465 490.2200n 0.000285 490.2300n 0.000096 490.2400n -0.000099 490.2500n -0.000295 490.2600n -0.000489 490.2700n -0.000676 490.2800n -0.000852 490.2900n -0.001015 490.3000n -0.001161 490.3100n -0.001287 490.3200n -0.001390 490.3300n -0.001468 490.3400n -0.001520
+ 490.3500n -0.001544 490.3600n -0.001541 490.3700n -0.001510 490.3800n -0.001451 490.3900n -0.001367 490.4000n -0.001257 490.4100n -0.001126 490.4200n -0.000974 490.4300n -0.000805 490.4400n -0.000621 490.4500n -0.000427 490.4600n -0.000226 490.4700n -0.000021 490.4800n 0.000184 490.4900n 0.000386
+ 490.5000n 0.000581 490.5100n 0.000766 490.5200n 0.000938 490.5300n 0.001095 490.5400n 0.001233 490.5500n 0.001352 490.5600n 0.001449 490.5700n 0.001524 490.5800n 0.001576 490.5900n 0.001604 490.6000n 0.001609 490.6100n 0.001591 490.6200n 0.001552 490.6300n 0.001492 490.6400n 0.001413
+ 490.6500n 0.001317 490.6600n 0.001207 490.6700n 0.001084 490.6800n 0.000950 490.6900n 0.000809 490.7000n 0.000663 490.7100n 0.000513 490.7200n 0.000363 490.7300n 0.000214 490.7400n 0.000069 490.7500n -0.000070 490.7600n -0.000203 490.7700n -0.000326 490.7800n -0.000440 490.7900n -0.000543
+ 490.8000n -0.000634 490.8100n -0.000712 490.8200n -0.000778 490.8300n -0.000831 490.8400n -0.000871 490.8500n -0.000898 490.8600n -0.000913 490.8700n -0.000916 490.8800n -0.000906 490.8900n -0.000886 490.9000n -0.000854 490.9100n -0.000812 490.9200n -0.000761 490.9300n -0.000700 490.9400n -0.000630
+ 490.9500n -0.000551 490.9600n -0.000465 490.9700n -0.000370 490.9800n -0.000268 490.9900n -0.000158 491.0000n -0.000041 491.0100n 0.000083 491.0200n 0.000214 491.0300n 0.000352 491.0400n 0.000495 491.0500n 0.000644 491.0600n 0.000798 491.0700n 0.000956 491.0800n 0.001118 491.0900n 0.001283
+ 491.1000n 0.001449 491.1100n 0.001616 491.1200n 0.001781 491.1300n 0.001945 491.1400n 0.002104 491.1500n 0.002257 491.1600n 0.002403 491.1700n 0.002539 491.1800n 0.002664 491.1900n 0.002776 491.2000n 0.002873 491.2100n 0.002953 491.2200n 0.003015 491.2300n 0.003058 491.2400n 0.003079
+ 491.2500n 0.003079 491.2600n 0.003056 491.2700n 0.003010 491.2800n 0.002940 491.2900n 0.002848 491.3000n 0.002734 491.3100n 0.002598 491.3200n 0.002442 491.3300n 0.002268 491.3400n 0.002077 491.3500n 0.001871 491.3600n 0.001654 491.3700n 0.001426 491.3800n 0.001193 491.3900n 0.000955
+ 491.4000n 0.000717 491.4100n 0.000481 491.4200n 0.000250 491.4300n 0.000028 491.4400n -0.000184 491.4500n -0.000383 491.4600n -0.000566 491.4700n -0.000731 491.4800n -0.000877 491.4900n -0.001003 491.5000n -0.001107 491.5100n -0.001189 491.5200n -0.001249 491.5300n -0.001287 491.5400n -0.001305
+ 491.5500n -0.001302 491.5600n -0.001280 491.5700n -0.001242 491.5800n -0.001189 491.5900n -0.001123 491.6000n -0.001048 491.6100n -0.000964 491.6200n -0.000876 491.6300n -0.000786 491.6400n -0.000696 491.6500n -0.000609 491.6600n -0.000528 491.6700n -0.000454 491.6800n -0.000390 491.6900n -0.000337
+ 491.7000n -0.000298 491.7100n -0.000272 491.7200n -0.000261 491.7300n -0.000265 491.7400n -0.000283 491.7500n -0.000317 491.7600n -0.000365 491.7700n -0.000426 491.7800n -0.000498 491.7900n -0.000581 491.8000n -0.000673 491.8100n -0.000771 491.8200n -0.000874 491.8300n -0.000980 491.8400n -0.001086
+ 491.8500n -0.001190 491.8600n -0.001291 491.8700n -0.001386 491.8800n -0.001474 491.8900n -0.001553 491.9000n -0.001621 491.9100n -0.001679 491.9200n -0.001724 491.9300n -0.001757 491.9400n -0.001776 491.9500n -0.001783 491.9600n -0.001776 491.9700n -0.001758 491.9800n -0.001727 491.9900n -0.001686
+ 492.0000n -0.001635 492.0100n -0.001576 492.0200n -0.001510 492.0300n -0.001438 492.0400n -0.001361 492.0500n -0.001281 492.0600n -0.001200 492.0700n -0.001118 492.0800n -0.001037 492.0900n -0.000957 492.1000n -0.000880 492.1100n -0.000806 492.1200n -0.000735 492.1300n -0.000669 492.1400n -0.000607
+ 492.1500n -0.000548 492.1600n -0.000494 492.1700n -0.000443 492.1800n -0.000395 492.1900n -0.000350 492.2000n -0.000307 492.2100n -0.000266 492.2200n -0.000225 492.2300n -0.000184 492.2400n -0.000142 492.2500n -0.000100 492.2600n -0.000057 492.2700n -0.000012 492.2800n 0.000034 492.2900n 0.000082
+ 492.3000n 0.000132 492.3100n 0.000182 492.3200n 0.000232 492.3300n 0.000283 492.3400n 0.000332 492.3500n 0.000380 492.3600n 0.000424 492.3700n 0.000465 492.3800n 0.000500 492.3900n 0.000530 492.4000n 0.000553 492.4100n 0.000568 492.4200n 0.000574 492.4300n 0.000571 492.4400n 0.000559
+ 492.4500n 0.000536 492.4600n 0.000503 492.4700n 0.000461 492.4800n 0.000409 492.4900n 0.000349 492.5000n 0.000280 492.5100n 0.000206 492.5200n 0.000126 492.5300n 0.000042 492.5400n -0.000044 492.5500n -0.000130 492.5600n -0.000215 492.5700n -0.000296 492.5800n -0.000371 492.5900n -0.000439
+ 492.6000n -0.000498 492.6100n -0.000545 492.6200n -0.000581 492.6300n -0.000603 492.6400n -0.000610 492.6500n -0.000603 492.6600n -0.000579 492.6700n -0.000540 492.6800n -0.000486 492.6900n -0.000417 492.7000n -0.000335 492.7100n -0.000239 492.7200n -0.000134 492.7300n -0.000019 492.7400n 0.000103
+ 492.7500n 0.000230 492.7600n 0.000359 492.7700n 0.000487 492.7800n 0.000613 492.7900n 0.000734 492.8000n 0.000847 492.8100n 0.000950 492.8200n 0.001041 492.8300n 0.001118 492.8400n 0.001180 492.8500n 0.001225 492.8600n 0.001252 492.8700n 0.001261 492.8800n 0.001252 492.8900n 0.001225
+ 492.9000n 0.001180 492.9100n 0.001118 492.9200n 0.001041 492.9300n 0.000950 492.9400n 0.000848 492.9500n 0.000735 492.9600n 0.000616 492.9700n 0.000491 492.9800n 0.000365 492.9900n 0.000238 493.0000n 0.000113 493.0100n -0.000006 493.0200n -0.000118 493.0300n -0.000221 493.0400n -0.000313
+ 493.0500n -0.000393 493.0600n -0.000460 493.0700n -0.000513 493.0800n -0.000551 493.0900n -0.000575 493.1000n -0.000585 493.1100n -0.000582 493.1200n -0.000566 493.1300n -0.000540 493.1400n -0.000505 493.1500n -0.000463 493.1600n -0.000415 493.1700n -0.000365 493.1800n -0.000314 493.1900n -0.000264
+ 493.2000n -0.000218 493.2100n -0.000177 493.2200n -0.000144 493.2300n -0.000120 493.2400n -0.000106 493.2500n -0.000103 493.2600n -0.000113 493.2700n -0.000134 493.2800n -0.000167 493.2900n -0.000211 493.3000n -0.000267 493.3100n -0.000331 493.3200n -0.000403 493.3300n -0.000481 493.3400n -0.000562
+ 493.3500n -0.000645 493.3600n -0.000727 493.3700n -0.000806 493.3800n -0.000879 493.3900n -0.000944 493.4000n -0.000998 493.4100n -0.001040 493.4200n -0.001068 493.4300n -0.001081 493.4400n -0.001077 493.4500n -0.001056 493.4600n -0.001018 493.4700n -0.000963 493.4800n -0.000891 493.4900n -0.000805
+ 493.5000n -0.000705 493.5100n -0.000594 493.5200n -0.000473 493.5300n -0.000347 493.5400n -0.000217 493.5500n -0.000088 493.5600n 0.000039 493.5700n 0.000159 493.5800n 0.000269 493.5900n 0.000366 493.6000n 0.000448 493.6100n 0.000511 493.6200n 0.000553 493.6300n 0.000573 493.6400n 0.000569
+ 493.6500n 0.000540 493.6600n 0.000486 493.6700n 0.000408 493.6800n 0.000306 493.6900n 0.000182 493.7000n 0.000039 493.7100n -0.000123 493.7200n -0.000298 493.7300n -0.000484 493.7400n -0.000677 493.7500n -0.000872 493.7600n -0.001066 493.7700n -0.001254 493.7800n -0.001430 493.7900n -0.001592
+ 493.8000n -0.001736 493.8100n -0.001856 493.8200n -0.001950 493.8300n -0.002016 493.8400n -0.002050 493.8500n -0.002051 493.8600n -0.002019 493.8700n -0.001953 493.8800n -0.001853 493.8900n -0.001721 493.9000n -0.001559 493.9100n -0.001369 493.9200n -0.001155 493.9300n -0.000921 493.9400n -0.000672
+ 493.9500n -0.000411 493.9600n -0.000145 493.9700n 0.000122 493.9800n 0.000384 493.9900n 0.000634 494.0000n 0.000869 494.0100n 0.001083 494.0200n 0.001271 494.0300n 0.001429 494.0400n 0.001553 494.0500n 0.001641 494.0600n 0.001690 494.0700n 0.001699 494.0800n 0.001668 494.0900n 0.001597
+ 494.1000n 0.001486 494.1100n 0.001339 494.1200n 0.001158 494.1300n 0.000947 494.1400n 0.000711 494.1500n 0.000454 494.1600n 0.000182 494.1700n -0.000099 494.1800n -0.000383 494.1900n -0.000663 494.2000n -0.000933 494.2100n -0.001186 494.2200n -0.001416 494.2300n -0.001619 494.2400n -0.001787
+ 494.2500n -0.001918 494.2600n -0.002006 494.2700n -0.002050 494.2800n -0.002046 494.2900n -0.001994 494.3000n -0.001894 494.3100n -0.001746 494.3200n -0.001552 494.3300n -0.001315 494.3400n -0.001038 494.3500n -0.000725 494.3600n -0.000383 494.3700n -0.000016 494.3800n 0.000369 494.3900n 0.000765
+ 494.4000n 0.001165 494.4100n 0.001562 494.4200n 0.001950 494.4300n 0.002320 494.4400n 0.002667 494.4500n 0.002985 494.4600n 0.003267 494.4700n 0.003509 494.4800n 0.003707 494.4900n 0.003857 494.5000n 0.003957 494.5100n 0.004006 494.5200n 0.004003 494.5300n 0.003949 494.5400n 0.003846
+ 494.5500n 0.003695 494.5600n 0.003501 494.5700n 0.003268 494.5800n 0.003000 494.5900n 0.002704 494.6000n 0.002384 494.6100n 0.002049 494.6200n 0.001703 494.6300n 0.001355 494.6400n 0.001010 494.6500n 0.000675 494.6600n 0.000357 494.6700n 0.000061 494.6800n -0.000207 494.6900n -0.000444
+ 494.7000n -0.000645 494.7100n -0.000808 494.7200n -0.000929 494.7300n -0.001008 494.7400n -0.001045 494.7500n -0.001040 494.7600n -0.000995 494.7700n -0.000911 494.7800n -0.000792 494.7900n -0.000641 494.8000n -0.000463 494.8100n -0.000262 494.8200n -0.000045 494.8300n 0.000185 494.8400n 0.000421
+ 494.8500n 0.000658 494.8600n 0.000890 494.8700n 0.001113 494.8800n 0.001320 494.8900n 0.001507 494.9000n 0.001671 494.9100n 0.001807 494.9200n 0.001914 494.9300n 0.001989 494.9400n 0.002031 494.9500n 0.002039 494.9600n 0.002013 494.9700n 0.001954 494.9800n 0.001864 494.9900n 0.001745
+ 495.0000n 0.001599 495.0100n 0.001431 495.0200n 0.001243 495.0300n 0.001040 495.0400n 0.000826 495.0500n 0.000606 495.0600n 0.000383 495.0700n 0.000163 495.0800n -0.000051 495.0900n -0.000255 495.1000n -0.000445 495.1100n -0.000617 495.1200n -0.000770 495.1300n -0.000900 495.1400n -0.001006
+ 495.1500n -0.001088 495.1600n -0.001143 495.1700n -0.001174 495.1800n -0.001179 495.1900n -0.001161 495.2000n -0.001120 495.2100n -0.001059 495.2200n -0.000981 495.2300n -0.000887 495.2400n -0.000781 495.2500n -0.000666 495.2600n -0.000544 495.2700n -0.000420 495.2800n -0.000295 495.2900n -0.000174
+ 495.3000n -0.000057 495.3100n 0.000052 495.3200n 0.000151 495.3300n 0.000238 495.3400n 0.000313 495.3500n 0.000375 495.3600n 0.000422 495.3700n 0.000456 495.3800n 0.000476 495.3900n 0.000484 495.4000n 0.000479 495.4100n 0.000464 495.4200n 0.000440 495.4300n 0.000409 495.4400n 0.000372
+ 495.4500n 0.000331 495.4600n 0.000289 495.4700n 0.000246 495.4800n 0.000205 495.4900n 0.000167 495.5000n 0.000133 495.5100n 0.000104 495.5200n 0.000081 495.5300n 0.000064 495.5400n 0.000052 495.5500n 0.000047 495.5600n 0.000045 495.5700n 0.000048 495.5800n 0.000053 495.5900n 0.000059
+ 495.6000n 0.000064 495.6100n 0.000066 495.6200n 0.000064 495.6300n 0.000054 495.6400n 0.000036 495.6500n 0.000007 495.6600n -0.000034 495.6700n -0.000089 495.6800n -0.000160 495.6900n -0.000246 495.7000n -0.000349 495.7100n -0.000469 495.7200n -0.000605 495.7300n -0.000756 495.7400n -0.000922
+ 495.7500n -0.001100 495.7600n -0.001290 495.7700n -0.001487 495.7800n -0.001689 495.7900n -0.001893 495.8000n -0.002096 495.8100n -0.002294 495.8200n -0.002483 495.8300n -0.002660 495.8400n -0.002820 495.8500n -0.002959 495.8600n -0.003076 495.8700n -0.003165 495.8800n -0.003225 495.8900n -0.003253
+ 495.9000n -0.003247 495.9100n -0.003205 495.9200n -0.003126 495.9300n -0.003010 495.9400n -0.002858 495.9500n -0.002669 495.9600n -0.002446 495.9700n -0.002190 495.9800n -0.001904 495.9900n -0.001592 496.0000n -0.001256 496.0100n -0.000901 496.0200n -0.000531 496.0300n -0.000150 496.0400n 0.000236
+ 496.0500n 0.000622 496.0600n 0.001003 496.0700n 0.001376 496.0800n 0.001733 496.0900n 0.002072 496.1000n 0.002388 496.1100n 0.002677 496.1200n 0.002935 496.1300n 0.003159 496.1400n 0.003348 496.1500n 0.003498 496.1600n 0.003608 496.1700n 0.003679 496.1800n 0.003708 496.1900n 0.003698
+ 496.2000n 0.003649 496.2100n 0.003563 496.2200n 0.003442 496.2300n 0.003288 496.2400n 0.003104 496.2500n 0.002894 496.2600n 0.002661 496.2700n 0.002410 496.2800n 0.002144 496.2900n 0.001868 496.3000n 0.001586 496.3100n 0.001301 496.3200n 0.001018 496.3300n 0.000741 496.3400n 0.000474
+ 496.3500n 0.000219 496.3600n -0.000019 496.3700n -0.000239 496.3800n -0.000438 496.3900n -0.000614 496.4000n -0.000766 496.4100n -0.000892 496.4200n -0.000992 496.4300n -0.001065 496.4400n -0.001112 496.4500n -0.001133 496.4600n -0.001129 496.4700n -0.001100 496.4800n -0.001050 496.4900n -0.000978
+ 496.5000n -0.000888 496.5100n -0.000780 496.5200n -0.000658 496.5300n -0.000524 496.5400n -0.000379 496.5500n -0.000227 496.5600n -0.000069 496.5700n 0.000092 496.5800n 0.000254 496.5900n 0.000415 496.6000n 0.000573 496.6100n 0.000725 496.6200n 0.000871 496.6300n 0.001009 496.6400n 0.001138
+ 496.6500n 0.001255 496.6600n 0.001361 496.6700n 0.001455 496.6800n 0.001535 496.6900n 0.001602 496.7000n 0.001656 496.7100n 0.001695 496.7200n 0.001720 496.7300n 0.001732 496.7400n 0.001731 496.7500n 0.001717 496.7600n 0.001691 496.7700n 0.001653 496.7800n 0.001605 496.7900n 0.001547
+ 496.8000n 0.001480 496.8100n 0.001406 496.8200n 0.001326 496.8300n 0.001240 496.8400n 0.001151 496.8500n 0.001058 496.8600n 0.000965 496.8700n 0.000871 496.8800n 0.000779 496.8900n 0.000689 496.9000n 0.000603 496.9100n 0.000523 496.9200n 0.000448 496.9300n 0.000380 496.9400n 0.000321
+ 496.9500n 0.000271 496.9600n 0.000230 496.9700n 0.000199 496.9800n 0.000179 496.9900n 0.000169 497.0000n 0.000170 497.0100n 0.000182 497.0200n 0.000204 497.0300n 0.000236 497.0400n 0.000276 497.0500n 0.000325 497.0600n 0.000380 497.0700n 0.000441 497.0800n 0.000506 497.0900n 0.000574
+ 497.1000n 0.000643 497.1100n 0.000712 497.1200n 0.000778 497.1300n 0.000840 497.1400n 0.000896 497.1500n 0.000944 497.1600n 0.000984 497.1700n 0.001012 497.1800n 0.001029 497.1900n 0.001032 497.2000n 0.001020 497.2100n 0.000994 497.2200n 0.000952 497.2300n 0.000894 497.2400n 0.000820
+ 497.2500n 0.000730 497.2600n 0.000625 497.2700n 0.000506 497.2800n 0.000374 497.2900n 0.000229 497.3000n 0.000075 497.3100n -0.000089 497.3200n -0.000259 497.3300n -0.000434 497.3400n -0.000611 497.3500n -0.000789 497.3600n -0.000964 497.3700n -0.001135 497.3800n -0.001300 497.3900n -0.001456
+ 497.4000n -0.001602 497.4100n -0.001735 497.4200n -0.001854 497.4300n -0.001958 497.4400n -0.002045 497.4500n -0.002115 497.4600n -0.002167 497.4700n -0.002201 497.4800n -0.002217 497.4900n -0.002215 497.5000n -0.002196 497.5100n -0.002161 497.5200n -0.002111 497.5300n -0.002047 497.5400n -0.001971
+ 497.5500n -0.001884 497.5600n -0.001789 497.5700n -0.001687 497.5800n -0.001580 497.5900n -0.001470 497.6000n -0.001359 497.6100n -0.001248 497.6200n -0.001140 497.6300n -0.001036 497.6400n -0.000937 497.6500n -0.000844 497.6600n -0.000759 497.6700n -0.000681 497.6800n -0.000612 497.6900n -0.000552
+ 497.7000n -0.000501 497.7100n -0.000458 497.7200n -0.000423 497.7300n -0.000396 497.7400n -0.000375 497.7500n -0.000360 497.7600n -0.000349 497.7700n -0.000342 497.7800n -0.000338 497.7900n -0.000335 497.8000n -0.000333 497.8100n -0.000329 497.8200n -0.000324 497.8300n -0.000317 497.8400n -0.000306
+ 497.8500n -0.000292 497.8600n -0.000274 497.8700n -0.000252 497.8800n -0.000226 497.8900n -0.000197 497.9000n -0.000164 497.9100n -0.000129 497.9200n -0.000092 497.9300n -0.000054 497.9400n -0.000016 497.9500n 0.000020 497.9600n 0.000054 497.9700n 0.000084 497.9800n 0.000109 497.9900n 0.000129
+ 498.0000n 0.000142 498.0100n 0.000147 498.0200n 0.000143 498.0300n 0.000131 498.0400n 0.000109 498.0500n 0.000077 498.0600n 0.000037 498.0700n -0.000013 498.0800n -0.000072 498.0900n -0.000139 498.1000n -0.000212 498.1100n -0.000291 498.1200n -0.000375 498.1300n -0.000462 498.1400n -0.000551
+ 498.1500n -0.000640 498.1600n -0.000727 498.1700n -0.000810 498.1800n -0.000889 498.1900n -0.000962 498.2000n -0.001027 498.2100n -0.001083 498.2200n -0.001129 498.2300n -0.001165 498.2400n -0.001189 498.2500n -0.001202 498.2600n -0.001203 498.2700n -0.001192 498.2800n -0.001171 498.2900n -0.001139
+ 498.3000n -0.001099 498.3100n -0.001050 498.3200n -0.000995 498.3300n -0.000935 498.3400n -0.000871 498.3500n -0.000807 498.3600n -0.000742 498.3700n -0.000680 498.3800n -0.000623 498.3900n -0.000571 498.4000n -0.000527 498.4100n -0.000491 498.4200n -0.000466 498.4300n -0.000452 498.4400n -0.000450
+ 498.4500n -0.000461 498.4600n -0.000484 498.4700n -0.000519 498.4800n -0.000566 498.4900n -0.000624 498.5000n -0.000693 498.5100n -0.000769 498.5200n -0.000853 498.5300n -0.000942 498.5400n -0.001033 498.5500n -0.001126 498.5600n -0.001217 498.5700n -0.001304 498.5800n -0.001386 498.5900n -0.001458
+ 498.6000n -0.001521 498.6100n -0.001571 498.6200n -0.001606 498.6300n -0.001626 498.6400n -0.001628 498.6500n -0.001613 498.6600n -0.001578 498.6700n -0.001525 498.6800n -0.001453 498.6900n -0.001362 498.7000n -0.001254 498.7100n -0.001129 498.7200n -0.000990 498.7300n -0.000837 498.7400n -0.000674
+ 498.7500n -0.000502 498.7600n -0.000324 498.7700n -0.000143 498.7800n 0.000039 498.7900n 0.000218 498.8000n 0.000392 498.8100n 0.000558 498.8200n 0.000714 498.8300n 0.000857 498.8400n 0.000984 498.8500n 0.001095 498.8600n 0.001186 498.8700n 0.001257 498.8800n 0.001307 498.8900n 0.001335
+ 498.9000n 0.001340 498.9100n 0.001324 498.9200n 0.001286 498.9300n 0.001228 498.9400n 0.001150 498.9500n 0.001054 498.9600n 0.000942 498.9700n 0.000815 498.9800n 0.000678 498.9900n 0.000530 499.0000n 0.000376 499.0100n 0.000218 499.0200n 0.000058 499.0300n -0.000100 499.0400n -0.000255
+ 499.0500n -0.000404 499.0600n -0.000544 499.0700n -0.000675 499.0800n -0.000793 499.0900n -0.000897 499.1000n -0.000987 499.1100n -0.001061 499.1200n -0.001119 499.1300n -0.001160 499.1400n -0.001184 499.1500n -0.001192 499.1600n -0.001185 499.1700n -0.001163 499.1800n -0.001128 499.1900n -0.001080
+ 499.2000n -0.001023 499.2100n -0.000956 499.2200n -0.000884 499.2300n -0.000806 499.2400n -0.000726 499.2500n -0.000645 499.2600n -0.000565 499.2700n -0.000489 499.2800n -0.000417 499.2900n -0.000353 499.3000n -0.000296 499.3100n -0.000250 499.3200n -0.000214 499.3300n -0.000189 499.3400n -0.000177
+ 499.3500n -0.000177 499.3600n -0.000190 499.3700n -0.000216 499.3800n -0.000254 499.3900n -0.000304 499.4000n -0.000365 499.4100n -0.000437 499.4200n -0.000518 499.4300n -0.000606 499.4400n -0.000702 499.4500n -0.000802 499.4600n -0.000906 499.4700n -0.001012 499.4800n -0.001119 499.4900n -0.001224
+ 499.5000n -0.001327 499.5100n -0.001426 499.5200n -0.001519 499.5300n -0.001606 499.5400n -0.001684 499.5500n -0.001754 499.5600n -0.001813 499.5700n -0.001862 499.5800n -0.001900 499.5900n -0.001925 499.6000n -0.001939 499.6100n -0.001941 499.6200n -0.001931 499.6300n -0.001909 499.6400n -0.001875
+ 499.6500n -0.001831 499.6600n -0.001777 499.6700n -0.001713 499.6800n -0.001641 499.6900n -0.001562 499.7000n -0.001476 499.7100n -0.001384 499.7200n -0.001289 499.7300n -0.001191 499.7400n -0.001091 499.7500n -0.000991 499.7600n -0.000891 499.7700n -0.000794 499.7800n -0.000699 499.7900n -0.000609
+ 499.8000n -0.000523 499.8100n -0.000443 499.8200n -0.000370 499.8300n -0.000304 499.8400n -0.000245 499.8500n -0.000195 499.8600n -0.000152 499.8700n -0.000118 499.8800n -0.000091 499.8900n -0.000073 499.9000n -0.000061 499.9100n -0.000057 499.9200n -0.000058 499.9300n -0.000065 499.9400n -0.000076
+ 499.9500n -0.000090 499.9600n -0.000106 499.9700n -0.000123 499.9800n -0.000140 499.9900n -0.000155 500.0000n -0.000167 500.0100n -0.000175 500.0200n -0.000178 500.0300n -0.000175 500.0400n -0.000164 )

R1_DAMP b1_src b1_q1 100
R2_DAMP b2_src b2_q2 100
.ends

.subckt p1_noise_amp OUT_P OUT_N IN_P IN_N VCC VSS
R_DAMP_IN1 IN_P in_p_q1 100
R_DAMP_IN2 IN_N in_n_q2 100

XQ1 c1_n in_p_q1 e1_1 VSS npn13G2 Nx=2
XQ2 c1_p in_n_q2 e1_2 VSS npn13G2 Nx=2
RE1_1 e1_1 e1_common 15
RE1_2 e1_2 e1_common 15
RC1_1 VCC c1_n 240 m=1
RC1_2 VCC c1_p 240 m=1
R_TAIL1 e1_common VSS 316

XQEF1 VCC c1_p b2_p VSS npn13G2 Nx=1
XQEF2 VCC c1_n b2_n VSS npn13G2 Nx=1
REF1 b2_p VSS 5k m=1
REF2 b2_n VSS 5k m=1

* Stage 2
XQ3 OUT_N b2_p e2_1 VSS npn13G2 Nx=1
XQ4 OUT_P b2_n e2_2 VSS npn13G2 Nx=1
RE2_1 e2_1 e2_common 15
RE2_2 e2_2 e2_common 15
RC2_1 VCC OUT_N 240 m=1
RC2_2 VCC OUT_P 240 m=1
R_TAIL2 e2_common VSS 316
.ends

.subckt p1_comparator PBIT_OUT PBIT_RAW CLK_OUT_DIV IN_P IN_N CLK_P CLK_N VCC_HBT VDD VSS params: trim_val=512
RIN1 IN_P in_p_int 100
RIN2 IN_N in_n_int 100

RCLK1 CLK_P clk_p_int 100
RCLK2 CLK_N clk_n_int 100

XQEF_IN1 VCC_HBT in_p_int b_latch_p VSS npn13G2 Nx=1
XQEF_IN2 VCC_HBT in_n_int b_latch_n VSS npn13G2 Nx=1
REF_IN1 b_latch_p VSS 5k m=1
REF_IN2 b_latch_n VSS 5k m=1

XQCLK_TRACK e_track clk_p_int e_tail VSS npn13G2 Nx=1
XQCLK_LATCH e_latch clk_n_int e_tail VSS npn13G2 Nx=1
ISET e_tail VSS DC 2.0m

C_ETRACK e_track VSS 50f
C_ELATCH e_latch VSS 50f

XQ1 c_n b_latch_p e_track VSS npn13G2 Nx=1
XQ2 c_p b_latch_n e_track VSS npn13G2 Nx=1

XQ3 c_n c_p e_latch VSS npn13G2 Nx=1
XQ4 c_p c_n e_latch VSS npn13G2 Nx=1

RC1 VCC_HBT c_n 150 m=1
RC2 VCC_HBT c_p 150 m=1

ITRIM_P c_p VSS DC '66.85u + (trim_val - 512) * 0.1307u'
ITRIM_N c_n VSS DC '66.85u - (trim_val - 512) * 0.1307u'

XQEF1 VCC_HBT c_p ef_p VSS npn13G2 Nx=1
XQEF2 VCC_HBT c_n ef_n VSS npn13G2 Nx=1
REF1 ef_p VSS 5k m=1
REF2 ef_n VSS 5k m=1

R1_P ef_p g_p 10k m=1
R2_P g_p VSS 10k m=1
R1_N ef_n g_n 10k m=1
R2_N g_n VSS 10k m=1

XQBUF1 VCC_HBT g_p cml_out_p VSS npn13G2 Nx=1
XQBUF2 VCC_HBT g_n cml_out_n VSS npn13G2 Nx=1
RBUF1 cml_out_p VSS 5k m=1
RBUF2 cml_out_n VSS 5k m=1
.ends

XGEN gen_p gen_n vcc_hbt 0 p1_noise_gen
XAMP amp_p amp_n gen_p gen_n vcc_hbt 0 p1_noise_amp
XCOMP pbit_out raw clk_div amp_p amp_n clk_p clk_n vcc_hbt vdd 0 p1_comparator trim_val=512

VCC_HBT vcc_hbt 0 DC 2.50
VDD vdd 0 DC 1.20

VCLK_P clk_p 0 PULSE(0.775 0.925 0p 20p 20p 80p 200p)
VCLK_N clk_n 0 PULSE(0.925 0.775 0p 20p 20p 80p 200p)

.options method=gear reltol=1e-3

.control
op
wrdata run/pbit_op_5g_p12_selft0_seg1.txt v(xgen.xq1.t) v(xamp.xq1.t) v(gen_p) v(amp_p) v(xcomp.b_latch_p)
tran 20p 500n 0 20p
setplot tran1
wrdata run/pbit_raw_5g_p12_selft0_seg1.txt v(amp_p) v(amp_n) v(xcomp.c_p) v(xcomp.c_n) v(xcomp.b_latch_p) v(xcomp.b_latch_n)
quit
.endc
.end
