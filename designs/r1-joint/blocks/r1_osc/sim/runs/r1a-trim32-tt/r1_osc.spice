* R1_OSC schematic-level source, revision r1, written by schematic/gen_r1_osc.py
* 30 MHz nominal ping-pong RC relaxation oscillator, 5-bit cmim trim; lineage G1 g1_osc R0.95
* sizes: L_R=48.3u C_fix=28.55x28.55 um C_unit=4.03x4.03 um SW_W=0.5u,0.5u,1u,2u,4u L_RBIAS=80u M_TAIL=2
.subckt r1_osc en trim0 trim1 trim2 trim3 trim4 osc_clk vdd vss
XRA vdd va sub! rppd w=1u l=48.3u m=1 b=0 mm_ok=1
XRB vdd vb sub! rppd w=1u l=48.3u m=1 b=0 mm_ok=1
XCA trim0 trim1 trim2 trim3 trim4 va vss r1_osc_cbank
XCB trim0 trim1 trim2 trim3 trim4 vb vss r1_osc_cbank
XMRA va rsta vss vss sg13_lv_nmos w=4u l=0.13u ng=1 m=1 mm_ok=1
XMRB vb rstb vss vss sg13_lv_nmos w=4u l=0.13u ng=1 m=1 mm_ok=1
XRT1 vdd vth sub! rppd w=1u l=384.3u m=1 b=0 mm_ok=1
XRT2 vth vss sub! rppd w=1u l=384.3u m=1 b=0 mm_ok=1
XCTH vth vss cap_cmim w=26u l=26u m=1 mm_ok=1
XDANT vth vdd dpantenna l=0.78u w=0.78u
XRBIAS vdd vbn sub! rppd w=1u l=80u m=1 b=0 mm_ok=1
XMBD vbn vbn vss vss sg13_lv_nmos w=2u l=0.5u ng=1 m=1 mm_ok=1
XCMPA va vth vbn ca vdd vss r1_osc_cmp
XCMPB vb vth vbn cb vdd vss r1_osc_cmp
XEN en en_n vdd vss r1_osc_inv
XNQ ca en_n qb q vdd vss r1_osc_nor3
XNQB cb q qb vdd vss r1_osc_nor2
XRSTB qb en rstb vdd vss r1_osc_nand2
XRSTA q rsta vdd vss r1_osc_inv
XB1 q qn_b vdd vss r1_osc_inv
XB2 qn_b osc_clk vdd vss r1_osc_buf4
.ends

.subckt r1_osc_cbank t0 t1 t2 t3 t4 top vss
* fixed cmim + 5-bit binary trim; bit i = 2**i unit cmim in parallel (m), NMOS switch to vss
XCF top vss cap_cmim w=28.55u l=28.55u m=1 mm_ok=1
XCT0 top b0 cap_cmim w=4.03u l=4.03u m=1 mm_ok=1
XMS0 b0 t0 vss vss sg13_lv_nmos w=0.5u l=0.13u ng=1 m=1 mm_ok=1
XCT1 top b1 cap_cmim w=4.03u l=4.03u m=2 mm_ok=1
XMS1 b1 t1 vss vss sg13_lv_nmos w=0.5u l=0.13u ng=1 m=1 mm_ok=1
XCT2 top b2 cap_cmim w=4.03u l=4.03u m=4 mm_ok=1
XMS2 b2 t2 vss vss sg13_lv_nmos w=1u l=0.13u ng=1 m=1 mm_ok=1
XCT3 top b3 cap_cmim w=4.03u l=4.03u m=8 mm_ok=1
XMS3 b3 t3 vss vss sg13_lv_nmos w=2u l=0.13u ng=1 m=1 mm_ok=1
XCT4 top b4 cap_cmim w=4.03u l=4.03u m=16 mm_ok=1
XMS4 b4 t4 vss vss sg13_lv_nmos w=4u l=0.13u ng=1 m=1 mm_ok=1
.ends

.subckt r1_osc_cmp inp inn vbn out vdd vss
* continuous-time comparator: NMOS-input 5-T pair, PMOS mirror, two inverters (G1 g1_osc_cmp, tail x2)
XMT tail vbn vss vss sg13_lv_nmos w=2u l=0.5u ng=1 m=2 mm_ok=1
XM1 d1 inp tail vss sg13_lv_nmos w=4u l=0.3u ng=1 m=1 mm_ok=1
XM2 o1 inn tail vss sg13_lv_nmos w=4u l=0.3u ng=1 m=1 mm_ok=1
XM3 d1 d1 vdd vdd sg13_lv_pmos w=2u l=0.3u ng=1 m=1 mm_ok=1
XM4 o1 d1 vdd vdd sg13_lv_pmos w=2u l=0.3u ng=1 m=1 mm_ok=1
XI1 o1 o2 vdd vss r1_osc_inv
XI2 o2 out vdd vss r1_osc_inv
.ends

.subckt r1_osc_inv a y vdd vss
XMP y a vdd vdd sg13_lv_pmos w=1u l=0.13u ng=1 m=1 mm_ok=1
XMN y a vss vss sg13_lv_nmos w=0.5u l=0.13u ng=1 m=1 mm_ok=1
.ends
.subckt r1_osc_buf4 a y vdd vss
* output inverter, 4x the unit inverter
XMP y a vdd vdd sg13_lv_pmos w=4u l=0.13u ng=1 m=1 mm_ok=1
XMN y a vss vss sg13_lv_nmos w=2u l=0.13u ng=1 m=1 mm_ok=1
.ends
.subckt r1_osc_nor3 a0 a1 a2 y vdd vss
XMP0 p0 a0 vdd vdd sg13_lv_pmos w=3u l=0.13u ng=1 m=1 mm_ok=1
XMP1 p1 a1 p0 vdd sg13_lv_pmos w=3u l=0.13u ng=1 m=1 mm_ok=1
XMP2 y a2 p1 vdd sg13_lv_pmos w=3u l=0.13u ng=1 m=1 mm_ok=1
XMN0 y a0 vss vss sg13_lv_nmos w=0.5u l=0.13u ng=1 m=1 mm_ok=1
XMN1 y a1 vss vss sg13_lv_nmos w=0.5u l=0.13u ng=1 m=1 mm_ok=1
XMN2 y a2 vss vss sg13_lv_nmos w=0.5u l=0.13u ng=1 m=1 mm_ok=1
.ends
.subckt r1_osc_nor2 a0 a1 y vdd vss
XMP0 p0 a0 vdd vdd sg13_lv_pmos w=2u l=0.13u ng=1 m=1 mm_ok=1
XMP1 y a1 p0 vdd sg13_lv_pmos w=2u l=0.13u ng=1 m=1 mm_ok=1
XMN0 y a0 vss vss sg13_lv_nmos w=0.5u l=0.13u ng=1 m=1 mm_ok=1
XMN1 y a1 vss vss sg13_lv_nmos w=0.5u l=0.13u ng=1 m=1 mm_ok=1
.ends
.subckt r1_osc_nand2 a0 a1 y vdd vss
XMP0 y a0 vdd vdd sg13_lv_pmos w=1u l=0.13u ng=1 m=1 mm_ok=1
XMP1 y a1 vdd vdd sg13_lv_pmos w=1u l=0.13u ng=1 m=1 mm_ok=1
XMN0 y a0 n0 vss sg13_lv_nmos w=1u l=0.13u ng=1 m=1 mm_ok=1
XMN1 n0 a1 vss vss sg13_lv_nmos w=1u l=0.13u ng=1 m=1 mm_ok=1
.ends
