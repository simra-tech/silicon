* r1_safe LVS reference netlist (flat), written by layout/make_cdl.py from schematic/r1_safe.spice (netlist of record). Format conversion only; see the script header.
.subckt r1_safe outa_p outa_n outb_p outb_n vref oa_p0 oa_p1 oa_p2 oa_p3 oa_p4 oa_p5 oa_p6 oa_p7 oa_n0 oa_n1 oa_n2 oa_n3 oa_n4 oa_n5 oa_n6 oa_n7 na_p0 na_p1 na_p2 na_p3 na_p4 na_p5 na_p6 na_p7 na_n0 na_n1 na_n2 na_n3 na_n4 na_n5 na_n6 na_n7 ob_p0 ob_p1 ob_p2 ob_p3 ob_p4 ob_p5 ob_p6 ob_p7 ob_n0 ob_n1 ob_n2 ob_n3 ob_n4 ob_n5 ob_n6 ob_n7 nb_p0 nb_p1 nb_p2 nb_p3 nb_p4 nb_p5 nb_p6 nb_p7 nb_n0 nb_n1 nb_n2 nb_n3 nb_n4 nb_n5 nb_n6 nb_n7 oc_a neg_a oc_b neg_b ibias_oa ibias_na ibias_ob ibias_nb vdda vdd vss
RSTR_RS0 t1 vss vss rppd w=2u l=7.7u b=0 m=1
RSTR_RS1 t2 t1 vss rppd w=2u l=7.7u b=0 m=1
RSTR_RS2 t3 t2 vss rppd w=2u l=7.7u b=0 m=1
RSTR_RS3 t4 t3 vss rppd w=2u l=7.7u b=0 m=1
RSTR_RS4 t5 t4 vss rppd w=2u l=7.7u b=0 m=1
RSTR_RS5 t6 t5 vss rppd w=2u l=7.7u b=0 m=1
RSTR_RS6 t7 t6 vss rppd w=2u l=7.7u b=0 m=1
RSTR_RS7 t8 t7 vss rppd w=2u l=7.7u b=0 m=1
RSTR_RS8 t9 t8 vss rppd w=2u l=7.7u b=0 m=1
RSTR_RS9 t10 t9 vss rppd w=2u l=7.7u b=0 m=1
RSTR_RS10 t11 t10 vss rppd w=2u l=7.7u b=0 m=1
RSTR_RS11 t12 t11 vss rppd w=2u l=7.7u b=0 m=1
RSTR_RS12 t13 t12 vss rppd w=2u l=7.7u b=0 m=1
RSTR_RS13 t14 t13 vss rppd w=2u l=7.7u b=0 m=1
RSTR_RS14 t15 t14 vss rppd w=2u l=7.7u b=0 m=1
RSTR_RS15 t16 t15 vss rppd w=2u l=7.7u b=0 m=1
RSTR_RS16 t17 t16 vss rppd w=2u l=7.7u b=0 m=1
RSTR_RS17 t18 t17 vss rppd w=2u l=7.7u b=0 m=1
RSTR_RS18 t19 t18 vss rppd w=2u l=7.7u b=0 m=1
RSTR_RS19 t20 t19 vss rppd w=2u l=7.7u b=0 m=1
RSTR_RS20 t21 t20 vss rppd w=2u l=7.7u b=0 m=1
RSTR_RS21 t22 t21 vss rppd w=2u l=7.7u b=0 m=1
RSTR_RS22 t23 t22 vss rppd w=2u l=7.7u b=0 m=1
RSTR_RS23 t24 t23 vss rppd w=2u l=7.7u b=0 m=1
RSTR_RS24 t25 t24 vss rppd w=2u l=7.7u b=0 m=1
RSTR_RS25 t26 t25 vss rppd w=2u l=7.7u b=0 m=1
RSTR_RS26 t27 t26 vss rppd w=2u l=7.7u b=0 m=1
RSTR_RS27 t28 t27 vss rppd w=2u l=7.7u b=0 m=1
RSTR_RS28 t29 t28 vss rppd w=2u l=7.7u b=0 m=1
RSTR_RS29 t30 t29 vss rppd w=2u l=7.7u b=0 m=1
RSTR_RS30 t31 t30 vss rppd w=2u l=7.7u b=0 m=1
RSTR_RS31 t32 t31 vss rppd w=2u l=7.7u b=0 m=1
RSTR_RS32 t33 t32 vss rppd w=2u l=7.7u b=0 m=1
RSTR_RS33 t34 t33 vss rppd w=2u l=7.7u b=0 m=1
RSTR_RS34 t35 t34 vss rppd w=2u l=7.7u b=0 m=1
RSTR_RS35 t36 t35 vss rppd w=2u l=7.7u b=0 m=1
RSTR_RS36 t37 t36 vss rppd w=2u l=7.7u b=0 m=1
RSTR_RS37 t38 t37 vss rppd w=2u l=7.7u b=0 m=1
RSTR_RS38 t39 t38 vss rppd w=2u l=7.7u b=0 m=1
RSTR_RS39 t40 t39 vss rppd w=2u l=7.7u b=0 m=1
RSTR_RS40 t41 t40 vss rppd w=2u l=7.7u b=0 m=1
RSTR_RS41 t42 t41 vss rppd w=2u l=7.7u b=0 m=1
RSTR_RS42 t43 t42 vss rppd w=2u l=7.7u b=0 m=1
RSTR_RS43 t44 t43 vss rppd w=2u l=7.7u b=0 m=1
RSTR_RS44 t45 t44 vss rppd w=2u l=7.7u b=0 m=1
RSTR_RS45 t46 t45 vss rppd w=2u l=7.7u b=0 m=1
RSTR_RS46 t47 t46 vss rppd w=2u l=7.7u b=0 m=1
RSTR_RS47 t48 t47 vss rppd w=2u l=7.7u b=0 m=1
RSTR_RS48 t49 t48 vss rppd w=2u l=7.7u b=0 m=1
RSTR_RS49 t50 t49 vss rppd w=2u l=7.7u b=0 m=1
RSTR_RS50 t51 t50 vss rppd w=2u l=7.7u b=0 m=1
RSTR_RS51 t52 t51 vss rppd w=2u l=7.7u b=0 m=1
RSTR_RS52 t53 t52 vss rppd w=2u l=7.7u b=0 m=1
RSTR_RS53 t54 t53 vss rppd w=2u l=7.7u b=0 m=1
RSTR_RS54 t55 t54 vss rppd w=2u l=7.7u b=0 m=1
RSTR_RS55 t56 t55 vss rppd w=2u l=7.7u b=0 m=1
RSTR_RS56 t57 t56 vss rppd w=2u l=7.7u b=0 m=1
RSTR_RS57 t58 t57 vss rppd w=2u l=7.7u b=0 m=1
RSTR_RS58 t59 t58 vss rppd w=2u l=7.7u b=0 m=1
RSTR_RS59 t60 t59 vss rppd w=2u l=7.7u b=0 m=1
RSTR_RS60 t61 t60 vss rppd w=2u l=7.7u b=0 m=1
RSTR_RS61 t62 t61 vss rppd w=2u l=7.7u b=0 m=1
RSTR_RS62 t63 t62 vss rppd w=2u l=7.7u b=0 m=1
RSTR_RS63 t64 t63 vss rppd w=2u l=7.7u b=0 m=1
RSTR_RS64 t65 t64 vss rppd w=2u l=7.7u b=0 m=1
RSTR_RS65 t66 t65 vss rppd w=2u l=7.7u b=0 m=1
RSTR_RS66 t67 t66 vss rppd w=2u l=7.7u b=0 m=1
RSTR_RS67 t68 t67 vss rppd w=2u l=7.7u b=0 m=1
RSTR_RS68 t69 t68 vss rppd w=2u l=7.7u b=0 m=1
RSTR_RS69 t70 t69 vss rppd w=2u l=7.7u b=0 m=1
RSTR_RS70 t71 t70 vss rppd w=2u l=7.7u b=0 m=1
RSTR_RS71 t72 t71 vss rppd w=2u l=7.7u b=0 m=1
RSTR_RS72 t73 t72 vss rppd w=2u l=7.7u b=0 m=1
RSTR_RS73 t74 t73 vss rppd w=2u l=7.7u b=0 m=1
RSTR_RS74 t75 t74 vss rppd w=2u l=7.7u b=0 m=1
RSTR_RS75 t76 t75 vss rppd w=2u l=7.7u b=0 m=1
RSTR_RS76 t77 t76 vss rppd w=2u l=7.7u b=0 m=1
RSTR_RS77 t78 t77 vss rppd w=2u l=7.7u b=0 m=1
RSTR_RS78 t79 t78 vss rppd w=2u l=7.7u b=0 m=1
RSTR_RS79 t80 t79 vss rppd w=2u l=7.7u b=0 m=1
RSTR_RS80 t81 t80 vss rppd w=2u l=7.7u b=0 m=1
RSTR_RS81 t82 t81 vss rppd w=2u l=7.7u b=0 m=1
RSTR_RS82 t83 t82 vss rppd w=2u l=7.7u b=0 m=1
RSTR_RS83 t84 t83 vss rppd w=2u l=7.7u b=0 m=1
RSTR_RS84 t85 t84 vss rppd w=2u l=7.7u b=0 m=1
RSTR_RS85 t86 t85 vss rppd w=2u l=7.7u b=0 m=1
RSTR_RS86 t87 t86 vss rppd w=2u l=7.7u b=0 m=1
RSTR_RS87 t88 t87 vss rppd w=2u l=7.7u b=0 m=1
RSTR_RS88 t89 t88 vss rppd w=2u l=7.7u b=0 m=1
RSTR_RS89 t90 t89 vss rppd w=2u l=7.7u b=0 m=1
RSTR_RS90 t91 t90 vss rppd w=2u l=7.7u b=0 m=1
RSTR_RS91 t92 t91 vss rppd w=2u l=7.7u b=0 m=1
RSTR_RS92 t93 t92 vss rppd w=2u l=7.7u b=0 m=1
RSTR_RS93 t94 t93 vss rppd w=2u l=7.7u b=0 m=1
RSTR_RS94 t95 t94 vss rppd w=2u l=7.7u b=0 m=1
RSTR_RS95 t96 t95 vss rppd w=2u l=7.7u b=0 m=1
RSTR_RS96 t97 t96 vss rppd w=2u l=7.7u b=0 m=1
RSTR_RS97 t98 t97 vss rppd w=2u l=7.7u b=0 m=1
RSTR_RS98 t99 t98 vss rppd w=2u l=7.7u b=0 m=1
RSTR_RS99 t100 t99 vss rppd w=2u l=7.7u b=0 m=1
RSTR_RS100 t101 t100 vss rppd w=2u l=7.7u b=0 m=1
RSTR_RS101 t102 t101 vss rppd w=2u l=7.7u b=0 m=1
RSTR_RS102 t103 t102 vss rppd w=2u l=7.7u b=0 m=1
RSTR_RS103 t104 t103 vss rppd w=2u l=7.7u b=0 m=1
RSTR_RS104 t105 t104 vss rppd w=2u l=7.7u b=0 m=1
RSTR_RS105 t106 t105 vss rppd w=2u l=7.7u b=0 m=1
RSTR_RS106 t107 t106 vss rppd w=2u l=7.7u b=0 m=1
RSTR_RS107 t108 t107 vss rppd w=2u l=7.7u b=0 m=1
RSTR_RS108 t109 t108 vss rppd w=2u l=7.7u b=0 m=1
RSTR_RS109 t110 t109 vss rppd w=2u l=7.7u b=0 m=1
RSTR_RS110 t111 t110 vss rppd w=2u l=7.7u b=0 m=1
RSTR_RS111 t112 t111 vss rppd w=2u l=7.7u b=0 m=1
RSTR_RS112 t113 t112 vss rppd w=2u l=7.7u b=0 m=1
RSTR_RS113 t114 t113 vss rppd w=2u l=7.7u b=0 m=1
RSTR_RS114 t115 t114 vss rppd w=2u l=7.7u b=0 m=1
RSTR_RS115 t116 t115 vss rppd w=2u l=7.7u b=0 m=1
RSTR_RS116 t117 t116 vss rppd w=2u l=7.7u b=0 m=1
RSTR_RS117 t118 t117 vss rppd w=2u l=7.7u b=0 m=1
RSTR_RS118 t119 t118 vss rppd w=2u l=7.7u b=0 m=1
RSTR_RS119 t120 t119 vss rppd w=2u l=7.7u b=0 m=1
RSTR_RS120 t121 t120 vss rppd w=2u l=7.7u b=0 m=1
RSTR_RS121 t122 t121 vss rppd w=2u l=7.7u b=0 m=1
RSTR_RS122 t123 t122 vss rppd w=2u l=7.7u b=0 m=1
RSTR_RS123 t124 t123 vss rppd w=2u l=7.7u b=0 m=1
RSTR_RS124 t125 t124 vss rppd w=2u l=7.7u b=0 m=1
RSTR_RS125 t126 t125 vss rppd w=2u l=7.7u b=0 m=1
RSTR_RS126 t127 t126 vss rppd w=2u l=7.7u b=0 m=1
RSTR_RS127 t128 t127 vss rppd w=2u l=7.7u b=0 m=1
RSTR_RS128 t129 t128 vss rppd w=2u l=7.7u b=0 m=1
RSTR_RS129 t130 t129 vss rppd w=2u l=7.7u b=0 m=1
RSTR_RS130 t131 t130 vss rppd w=2u l=7.7u b=0 m=1
RSTR_RS131 t132 t131 vss rppd w=2u l=7.7u b=0 m=1
RSTR_RS132 t133 t132 vss rppd w=2u l=7.7u b=0 m=1
RSTR_RS133 t134 t133 vss rppd w=2u l=7.7u b=0 m=1
RSTR_RS134 t135 t134 vss rppd w=2u l=7.7u b=0 m=1
RSTR_RS135 t136 t135 vss rppd w=2u l=7.7u b=0 m=1
RSTR_RS136 t137 t136 vss rppd w=2u l=7.7u b=0 m=1
RSTR_RS137 t138 t137 vss rppd w=2u l=7.7u b=0 m=1
RSTR_RS138 t139 t138 vss rppd w=2u l=7.7u b=0 m=1
RSTR_RS139 t140 t139 vss rppd w=2u l=7.7u b=0 m=1
RSTR_RS140 t141 t140 vss rppd w=2u l=7.7u b=0 m=1
RSTR_RS141 t142 t141 vss rppd w=2u l=7.7u b=0 m=1
RSTR_RS142 t143 t142 vss rppd w=2u l=7.7u b=0 m=1
RSTR_RS143 t144 t143 vss rppd w=2u l=7.7u b=0 m=1
RSTR_RS144 t145 t144 vss rppd w=2u l=7.7u b=0 m=1
RSTR_RS145 t146 t145 vss rppd w=2u l=7.7u b=0 m=1
RSTR_RS146 t147 t146 vss rppd w=2u l=7.7u b=0 m=1
RSTR_RS147 t148 t147 vss rppd w=2u l=7.7u b=0 m=1
RSTR_RS148 t149 t148 vss rppd w=2u l=7.7u b=0 m=1
RSTR_RS149 t150 t149 vss rppd w=2u l=7.7u b=0 m=1
RSTR_RS150 t151 t150 vss rppd w=2u l=7.7u b=0 m=1
RSTR_RS151 t152 t151 vss rppd w=2u l=7.7u b=0 m=1
RSTR_RS152 t153 t152 vss rppd w=2u l=7.7u b=0 m=1
RSTR_RS153 t154 t153 vss rppd w=2u l=7.7u b=0 m=1
RSTR_RS154 t155 t154 vss rppd w=2u l=7.7u b=0 m=1
RSTR_RS155 t156 t155 vss rppd w=2u l=7.7u b=0 m=1
RSTR_RS156 t157 t156 vss rppd w=2u l=7.7u b=0 m=1
RSTR_RS157 t158 t157 vss rppd w=2u l=7.7u b=0 m=1
RSTR_RS158 t159 t158 vss rppd w=2u l=7.7u b=0 m=1
RSTR_RS159 t160 t159 vss rppd w=2u l=7.7u b=0 m=1
RSTR_RS160 t161 t160 vss rppd w=2u l=7.7u b=0 m=1
RSTR_RS161 t162 t161 vss rppd w=2u l=7.7u b=0 m=1
RSTR_RS162 t163 t162 vss rppd w=2u l=7.7u b=0 m=1
RSTR_RS163 t164 t163 vss rppd w=2u l=7.7u b=0 m=1
RSTR_RS164 t165 t164 vss rppd w=2u l=7.7u b=0 m=1
RSTR_RS165 t166 t165 vss rppd w=2u l=7.7u b=0 m=1
RSTR_RS166 t167 t166 vss rppd w=2u l=7.7u b=0 m=1
RSTR_RS167 t168 t167 vss rppd w=2u l=7.7u b=0 m=1
RSTR_RS168 t169 t168 vss rppd w=2u l=7.7u b=0 m=1
RSTR_RS169 t170 t169 vss rppd w=2u l=7.7u b=0 m=1
RSTR_RS170 t171 t170 vss rppd w=2u l=7.7u b=0 m=1
RSTR_RS171 t172 t171 vss rppd w=2u l=7.7u b=0 m=1
RSTR_RS172 t173 t172 vss rppd w=2u l=7.7u b=0 m=1
RSTR_RS173 t174 t173 vss rppd w=2u l=7.7u b=0 m=1
RSTR_RS174 t175 t174 vss rppd w=2u l=7.7u b=0 m=1
RSTR_RS175 t176 t175 vss rppd w=2u l=7.7u b=0 m=1
RSTR_RS176 t177 t176 vss rppd w=2u l=7.7u b=0 m=1
RSTR_RS177 t178 t177 vss rppd w=2u l=7.7u b=0 m=1
RSTR_RS178 t179 t178 vss rppd w=2u l=7.7u b=0 m=1
RSTR_RS179 t180 t179 vss rppd w=2u l=7.7u b=0 m=1
RSTR_RS180 t181 t180 vss rppd w=2u l=7.7u b=0 m=1
RSTR_RS181 t182 t181 vss rppd w=2u l=7.7u b=0 m=1
RSTR_RS182 t183 t182 vss rppd w=2u l=7.7u b=0 m=1
RSTR_RS183 t184 t183 vss rppd w=2u l=7.7u b=0 m=1
RSTR_RS184 t185 t184 vss rppd w=2u l=7.7u b=0 m=1
RSTR_RS185 t186 t185 vss rppd w=2u l=7.7u b=0 m=1
RSTR_RS186 t187 t186 vss rppd w=2u l=7.7u b=0 m=1
RSTR_RS187 t188 t187 vss rppd w=2u l=7.7u b=0 m=1
RSTR_RS188 t189 t188 vss rppd w=2u l=7.7u b=0 m=1
RSTR_RS189 t190 t189 vss rppd w=2u l=7.7u b=0 m=1
RSTR_RS190 t191 t190 vss rppd w=2u l=7.7u b=0 m=1
RSTR_RS191 t192 t191 vss rppd w=2u l=7.7u b=0 m=1
RSTR_RS192 t193 t192 vss rppd w=2u l=7.7u b=0 m=1
RSTR_RS193 t194 t193 vss rppd w=2u l=7.7u b=0 m=1
RSTR_RS194 t195 t194 vss rppd w=2u l=7.7u b=0 m=1
RSTR_RS195 t196 t195 vss rppd w=2u l=7.7u b=0 m=1
RSTR_RS196 t197 t196 vss rppd w=2u l=7.7u b=0 m=1
RSTR_RS197 t198 t197 vss rppd w=2u l=7.7u b=0 m=1
RSTR_RS198 t199 t198 vss rppd w=2u l=7.7u b=0 m=1
RSTR_RS199 t200 t199 vss rppd w=2u l=7.7u b=0 m=1
RSTR_RS200 t201 t200 vss rppd w=2u l=7.7u b=0 m=1
RSTR_RS201 t202 t201 vss rppd w=2u l=7.7u b=0 m=1
RSTR_RS202 t203 t202 vss rppd w=2u l=7.7u b=0 m=1
RSTR_RS203 t204 t203 vss rppd w=2u l=7.7u b=0 m=1
RSTR_RS204 t205 t204 vss rppd w=2u l=7.7u b=0 m=1
RSTR_RS205 t206 t205 vss rppd w=2u l=7.7u b=0 m=1
RSTR_RS206 t207 t206 vss rppd w=2u l=7.7u b=0 m=1
RSTR_RS207 t208 t207 vss rppd w=2u l=7.7u b=0 m=1
RSTR_RS208 t209 t208 vss rppd w=2u l=7.7u b=0 m=1
RSTR_RS209 t210 t209 vss rppd w=2u l=7.7u b=0 m=1
RSTR_RS210 t211 t210 vss rppd w=2u l=7.7u b=0 m=1
RSTR_RS211 t212 t211 vss rppd w=2u l=7.7u b=0 m=1
RSTR_RS212 t213 t212 vss rppd w=2u l=7.7u b=0 m=1
RSTR_RS213 t214 t213 vss rppd w=2u l=7.7u b=0 m=1
RSTR_RS214 t215 t214 vss rppd w=2u l=7.7u b=0 m=1
RSTR_RS215 t216 t215 vss rppd w=2u l=7.7u b=0 m=1
RSTR_RS216 t217 t216 vss rppd w=2u l=7.7u b=0 m=1
RSTR_RS217 t218 t217 vss rppd w=2u l=7.7u b=0 m=1
RSTR_RS218 t219 t218 vss rppd w=2u l=7.7u b=0 m=1
RSTR_RS219 t220 t219 vss rppd w=2u l=7.7u b=0 m=1
RSTR_RS220 t221 t220 vss rppd w=2u l=7.7u b=0 m=1
RSTR_RS221 t222 t221 vss rppd w=2u l=7.7u b=0 m=1
RSTR_RS222 t223 t222 vss rppd w=2u l=7.7u b=0 m=1
RSTR_RS223 t224 t223 vss rppd w=2u l=7.7u b=0 m=1
RSTR_RS224 t225 t224 vss rppd w=2u l=7.7u b=0 m=1
RSTR_RS225 t226 t225 vss rppd w=2u l=7.7u b=0 m=1
RSTR_RS226 t227 t226 vss rppd w=2u l=7.7u b=0 m=1
RSTR_RS227 t228 t227 vss rppd w=2u l=7.7u b=0 m=1
RSTR_RS228 t229 t228 vss rppd w=2u l=7.7u b=0 m=1
RSTR_RS229 t230 t229 vss rppd w=2u l=7.7u b=0 m=1
RSTR_RS230 t231 t230 vss rppd w=2u l=7.7u b=0 m=1
RSTR_RS231 t232 t231 vss rppd w=2u l=7.7u b=0 m=1
RSTR_RS232 t233 t232 vss rppd w=2u l=7.7u b=0 m=1
RSTR_RS233 t234 t233 vss rppd w=2u l=7.7u b=0 m=1
RSTR_RS234 t235 t234 vss rppd w=2u l=7.7u b=0 m=1
RSTR_RS235 t236 t235 vss rppd w=2u l=7.7u b=0 m=1
RSTR_RS236 t237 t236 vss rppd w=2u l=7.7u b=0 m=1
RSTR_RS237 t238 t237 vss rppd w=2u l=7.7u b=0 m=1
RSTR_RS238 t239 t238 vss rppd w=2u l=7.7u b=0 m=1
RSTR_RS239 t240 t239 vss rppd w=2u l=7.7u b=0 m=1
RSTR_RS240 t241 t240 vss rppd w=2u l=7.7u b=0 m=1
RSTR_RS241 t242 t241 vss rppd w=2u l=7.7u b=0 m=1
RSTR_RS242 t243 t242 vss rppd w=2u l=7.7u b=0 m=1
RSTR_RS243 t244 t243 vss rppd w=2u l=7.7u b=0 m=1
RSTR_RS244 t245 t244 vss rppd w=2u l=7.7u b=0 m=1
RSTR_RS245 t246 t245 vss rppd w=2u l=7.7u b=0 m=1
RSTR_RS246 t247 t246 vss rppd w=2u l=7.7u b=0 m=1
RSTR_RS247 t248 t247 vss rppd w=2u l=7.7u b=0 m=1
RSTR_RS248 t249 t248 vss rppd w=2u l=7.7u b=0 m=1
RSTR_RS249 t250 t249 vss rppd w=2u l=7.7u b=0 m=1
RSTR_RS250 t251 t250 vss rppd w=2u l=7.7u b=0 m=1
RSTR_RS251 vref t251 vss rppd w=2u l=7.7u b=0 m=1
MOCa_LSP0_MIP OCa_LSP0_inb oa_p0 vdd vdd sg13_lv_pmos w=1u l=0.13u m=1
MOCa_LSP0_MIN OCa_LSP0_inb oa_p0 vss vss sg13_lv_nmos w=0.5u l=0.13u m=1
MOCa_LSP0_MN1 OCa_LSP0_a oa_p0 vss vss sg13_hv_nmos w=4u l=0.45u m=1
MOCa_LSP0_MN2 OCa_LSP0_b OCa_LSP0_inb vss vss sg13_hv_nmos w=4u l=0.45u m=1
MOCa_LSP0_MP1 OCa_LSP0_a OCa_LSP0_b vdda vdda sg13_hv_pmos w=0.6u l=0.5u m=1
MOCa_LSP0_MP2 OCa_LSP0_b OCa_LSP0_a vdda vdda sg13_hv_pmos w=0.6u l=0.5u m=1
MOCa_LSP0_MB1P OCa_bbp0 OCa_LSP0_b vdda vdda sg13_hv_pmos w=2u l=0.5u m=1
MOCa_LSP0_MB1N OCa_bbp0 OCa_LSP0_b vss vss sg13_hv_nmos w=1u l=0.45u m=1
MOCa_LSP0_MB2P OCa_bp0 OCa_bbp0 vdda vdda sg13_hv_pmos w=2u l=0.5u m=1
MOCa_LSP0_MB2N OCa_bp0 OCa_bbp0 vss vss sg13_hv_nmos w=1u l=0.45u m=1
MOCa_LSN0_MIP OCa_LSN0_inb oa_n0 vdd vdd sg13_lv_pmos w=1u l=0.13u m=1
MOCa_LSN0_MIN OCa_LSN0_inb oa_n0 vss vss sg13_lv_nmos w=0.5u l=0.13u m=1
MOCa_LSN0_MN1 OCa_LSN0_a oa_n0 vss vss sg13_hv_nmos w=4u l=0.45u m=1
MOCa_LSN0_MN2 OCa_LSN0_b OCa_LSN0_inb vss vss sg13_hv_nmos w=4u l=0.45u m=1
MOCa_LSN0_MP1 OCa_LSN0_a OCa_LSN0_b vdda vdda sg13_hv_pmos w=0.6u l=0.5u m=1
MOCa_LSN0_MP2 OCa_LSN0_b OCa_LSN0_a vdda vdda sg13_hv_pmos w=0.6u l=0.5u m=1
MOCa_LSN0_MB1P OCa_bbn0 OCa_LSN0_b vdda vdda sg13_hv_pmos w=2u l=0.5u m=1
MOCa_LSN0_MB1N OCa_bbn0 OCa_LSN0_b vss vss sg13_hv_nmos w=1u l=0.45u m=1
MOCa_LSN0_MB2P OCa_bn0 OCa_bbn0 vdda vdda sg13_hv_pmos w=2u l=0.5u m=1
MOCa_LSN0_MB2N OCa_bn0 OCa_bbn0 vss vss sg13_hv_nmos w=1u l=0.45u m=1
MOCa_LSP1_MIP OCa_LSP1_inb oa_p1 vdd vdd sg13_lv_pmos w=1u l=0.13u m=1
MOCa_LSP1_MIN OCa_LSP1_inb oa_p1 vss vss sg13_lv_nmos w=0.5u l=0.13u m=1
MOCa_LSP1_MN1 OCa_LSP1_a oa_p1 vss vss sg13_hv_nmos w=4u l=0.45u m=1
MOCa_LSP1_MN2 OCa_LSP1_b OCa_LSP1_inb vss vss sg13_hv_nmos w=4u l=0.45u m=1
MOCa_LSP1_MP1 OCa_LSP1_a OCa_LSP1_b vdda vdda sg13_hv_pmos w=0.6u l=0.5u m=1
MOCa_LSP1_MP2 OCa_LSP1_b OCa_LSP1_a vdda vdda sg13_hv_pmos w=0.6u l=0.5u m=1
MOCa_LSP1_MB1P OCa_bbp1 OCa_LSP1_b vdda vdda sg13_hv_pmos w=2u l=0.5u m=1
MOCa_LSP1_MB1N OCa_bbp1 OCa_LSP1_b vss vss sg13_hv_nmos w=1u l=0.45u m=1
MOCa_LSP1_MB2P OCa_bp1 OCa_bbp1 vdda vdda sg13_hv_pmos w=2u l=0.5u m=1
MOCa_LSP1_MB2N OCa_bp1 OCa_bbp1 vss vss sg13_hv_nmos w=1u l=0.45u m=1
MOCa_LSN1_MIP OCa_LSN1_inb oa_n1 vdd vdd sg13_lv_pmos w=1u l=0.13u m=1
MOCa_LSN1_MIN OCa_LSN1_inb oa_n1 vss vss sg13_lv_nmos w=0.5u l=0.13u m=1
MOCa_LSN1_MN1 OCa_LSN1_a oa_n1 vss vss sg13_hv_nmos w=4u l=0.45u m=1
MOCa_LSN1_MN2 OCa_LSN1_b OCa_LSN1_inb vss vss sg13_hv_nmos w=4u l=0.45u m=1
MOCa_LSN1_MP1 OCa_LSN1_a OCa_LSN1_b vdda vdda sg13_hv_pmos w=0.6u l=0.5u m=1
MOCa_LSN1_MP2 OCa_LSN1_b OCa_LSN1_a vdda vdda sg13_hv_pmos w=0.6u l=0.5u m=1
MOCa_LSN1_MB1P OCa_bbn1 OCa_LSN1_b vdda vdda sg13_hv_pmos w=2u l=0.5u m=1
MOCa_LSN1_MB1N OCa_bbn1 OCa_LSN1_b vss vss sg13_hv_nmos w=1u l=0.45u m=1
MOCa_LSN1_MB2P OCa_bn1 OCa_bbn1 vdda vdda sg13_hv_pmos w=2u l=0.5u m=1
MOCa_LSN1_MB2N OCa_bn1 OCa_bbn1 vss vss sg13_hv_nmos w=1u l=0.45u m=1
MOCa_LSP2_MIP OCa_LSP2_inb oa_p2 vdd vdd sg13_lv_pmos w=1u l=0.13u m=1
MOCa_LSP2_MIN OCa_LSP2_inb oa_p2 vss vss sg13_lv_nmos w=0.5u l=0.13u m=1
MOCa_LSP2_MN1 OCa_LSP2_a oa_p2 vss vss sg13_hv_nmos w=4u l=0.45u m=1
MOCa_LSP2_MN2 OCa_LSP2_b OCa_LSP2_inb vss vss sg13_hv_nmos w=4u l=0.45u m=1
MOCa_LSP2_MP1 OCa_LSP2_a OCa_LSP2_b vdda vdda sg13_hv_pmos w=0.6u l=0.5u m=1
MOCa_LSP2_MP2 OCa_LSP2_b OCa_LSP2_a vdda vdda sg13_hv_pmos w=0.6u l=0.5u m=1
MOCa_LSP2_MB1P OCa_bbp2 OCa_LSP2_b vdda vdda sg13_hv_pmos w=2u l=0.5u m=1
MOCa_LSP2_MB1N OCa_bbp2 OCa_LSP2_b vss vss sg13_hv_nmos w=1u l=0.45u m=1
MOCa_LSP2_MB2P OCa_bp2 OCa_bbp2 vdda vdda sg13_hv_pmos w=2u l=0.5u m=1
MOCa_LSP2_MB2N OCa_bp2 OCa_bbp2 vss vss sg13_hv_nmos w=1u l=0.45u m=1
MOCa_LSN2_MIP OCa_LSN2_inb oa_n2 vdd vdd sg13_lv_pmos w=1u l=0.13u m=1
MOCa_LSN2_MIN OCa_LSN2_inb oa_n2 vss vss sg13_lv_nmos w=0.5u l=0.13u m=1
MOCa_LSN2_MN1 OCa_LSN2_a oa_n2 vss vss sg13_hv_nmos w=4u l=0.45u m=1
MOCa_LSN2_MN2 OCa_LSN2_b OCa_LSN2_inb vss vss sg13_hv_nmos w=4u l=0.45u m=1
MOCa_LSN2_MP1 OCa_LSN2_a OCa_LSN2_b vdda vdda sg13_hv_pmos w=0.6u l=0.5u m=1
MOCa_LSN2_MP2 OCa_LSN2_b OCa_LSN2_a vdda vdda sg13_hv_pmos w=0.6u l=0.5u m=1
MOCa_LSN2_MB1P OCa_bbn2 OCa_LSN2_b vdda vdda sg13_hv_pmos w=2u l=0.5u m=1
MOCa_LSN2_MB1N OCa_bbn2 OCa_LSN2_b vss vss sg13_hv_nmos w=1u l=0.45u m=1
MOCa_LSN2_MB2P OCa_bn2 OCa_bbn2 vdda vdda sg13_hv_pmos w=2u l=0.5u m=1
MOCa_LSN2_MB2N OCa_bn2 OCa_bbn2 vss vss sg13_hv_nmos w=1u l=0.45u m=1
MOCa_LSP3_MIP OCa_LSP3_inb oa_p3 vdd vdd sg13_lv_pmos w=1u l=0.13u m=1
MOCa_LSP3_MIN OCa_LSP3_inb oa_p3 vss vss sg13_lv_nmos w=0.5u l=0.13u m=1
MOCa_LSP3_MN1 OCa_LSP3_a oa_p3 vss vss sg13_hv_nmos w=4u l=0.45u m=1
MOCa_LSP3_MN2 OCa_LSP3_b OCa_LSP3_inb vss vss sg13_hv_nmos w=4u l=0.45u m=1
MOCa_LSP3_MP1 OCa_LSP3_a OCa_LSP3_b vdda vdda sg13_hv_pmos w=0.6u l=0.5u m=1
MOCa_LSP3_MP2 OCa_LSP3_b OCa_LSP3_a vdda vdda sg13_hv_pmos w=0.6u l=0.5u m=1
MOCa_LSP3_MB1P OCa_bbp3 OCa_LSP3_b vdda vdda sg13_hv_pmos w=2u l=0.5u m=1
MOCa_LSP3_MB1N OCa_bbp3 OCa_LSP3_b vss vss sg13_hv_nmos w=1u l=0.45u m=1
MOCa_LSP3_MB2P OCa_bp3 OCa_bbp3 vdda vdda sg13_hv_pmos w=2u l=0.5u m=1
MOCa_LSP3_MB2N OCa_bp3 OCa_bbp3 vss vss sg13_hv_nmos w=1u l=0.45u m=1
MOCa_LSN3_MIP OCa_LSN3_inb oa_n3 vdd vdd sg13_lv_pmos w=1u l=0.13u m=1
MOCa_LSN3_MIN OCa_LSN3_inb oa_n3 vss vss sg13_lv_nmos w=0.5u l=0.13u m=1
MOCa_LSN3_MN1 OCa_LSN3_a oa_n3 vss vss sg13_hv_nmos w=4u l=0.45u m=1
MOCa_LSN3_MN2 OCa_LSN3_b OCa_LSN3_inb vss vss sg13_hv_nmos w=4u l=0.45u m=1
MOCa_LSN3_MP1 OCa_LSN3_a OCa_LSN3_b vdda vdda sg13_hv_pmos w=0.6u l=0.5u m=1
MOCa_LSN3_MP2 OCa_LSN3_b OCa_LSN3_a vdda vdda sg13_hv_pmos w=0.6u l=0.5u m=1
MOCa_LSN3_MB1P OCa_bbn3 OCa_LSN3_b vdda vdda sg13_hv_pmos w=2u l=0.5u m=1
MOCa_LSN3_MB1N OCa_bbn3 OCa_LSN3_b vss vss sg13_hv_nmos w=1u l=0.45u m=1
MOCa_LSN3_MB2P OCa_bn3 OCa_bbn3 vdda vdda sg13_hv_pmos w=2u l=0.5u m=1
MOCa_LSN3_MB2N OCa_bn3 OCa_bbn3 vss vss sg13_hv_nmos w=1u l=0.45u m=1
MOCa_LSP4_MIP OCa_LSP4_inb oa_p4 vdd vdd sg13_lv_pmos w=1u l=0.13u m=1
MOCa_LSP4_MIN OCa_LSP4_inb oa_p4 vss vss sg13_lv_nmos w=0.5u l=0.13u m=1
MOCa_LSP4_MN1 OCa_LSP4_a oa_p4 vss vss sg13_hv_nmos w=4u l=0.45u m=1
MOCa_LSP4_MN2 OCa_LSP4_b OCa_LSP4_inb vss vss sg13_hv_nmos w=4u l=0.45u m=1
MOCa_LSP4_MP1 OCa_LSP4_a OCa_LSP4_b vdda vdda sg13_hv_pmos w=0.6u l=0.5u m=1
MOCa_LSP4_MP2 OCa_LSP4_b OCa_LSP4_a vdda vdda sg13_hv_pmos w=0.6u l=0.5u m=1
MOCa_LSP4_MB1P OCa_bbp4 OCa_LSP4_b vdda vdda sg13_hv_pmos w=2u l=0.5u m=1
MOCa_LSP4_MB1N OCa_bbp4 OCa_LSP4_b vss vss sg13_hv_nmos w=1u l=0.45u m=1
MOCa_LSP4_MB2P OCa_bp4 OCa_bbp4 vdda vdda sg13_hv_pmos w=2u l=0.5u m=1
MOCa_LSP4_MB2N OCa_bp4 OCa_bbp4 vss vss sg13_hv_nmos w=1u l=0.45u m=1
MOCa_LSN4_MIP OCa_LSN4_inb oa_n4 vdd vdd sg13_lv_pmos w=1u l=0.13u m=1
MOCa_LSN4_MIN OCa_LSN4_inb oa_n4 vss vss sg13_lv_nmos w=0.5u l=0.13u m=1
MOCa_LSN4_MN1 OCa_LSN4_a oa_n4 vss vss sg13_hv_nmos w=4u l=0.45u m=1
MOCa_LSN4_MN2 OCa_LSN4_b OCa_LSN4_inb vss vss sg13_hv_nmos w=4u l=0.45u m=1
MOCa_LSN4_MP1 OCa_LSN4_a OCa_LSN4_b vdda vdda sg13_hv_pmos w=0.6u l=0.5u m=1
MOCa_LSN4_MP2 OCa_LSN4_b OCa_LSN4_a vdda vdda sg13_hv_pmos w=0.6u l=0.5u m=1
MOCa_LSN4_MB1P OCa_bbn4 OCa_LSN4_b vdda vdda sg13_hv_pmos w=2u l=0.5u m=1
MOCa_LSN4_MB1N OCa_bbn4 OCa_LSN4_b vss vss sg13_hv_nmos w=1u l=0.45u m=1
MOCa_LSN4_MB2P OCa_bn4 OCa_bbn4 vdda vdda sg13_hv_pmos w=2u l=0.5u m=1
MOCa_LSN4_MB2N OCa_bn4 OCa_bbn4 vss vss sg13_hv_nmos w=1u l=0.45u m=1
MOCa_LSP5_MIP OCa_LSP5_inb oa_p5 vdd vdd sg13_lv_pmos w=1u l=0.13u m=1
MOCa_LSP5_MIN OCa_LSP5_inb oa_p5 vss vss sg13_lv_nmos w=0.5u l=0.13u m=1
MOCa_LSP5_MN1 OCa_LSP5_a oa_p5 vss vss sg13_hv_nmos w=4u l=0.45u m=1
MOCa_LSP5_MN2 OCa_LSP5_b OCa_LSP5_inb vss vss sg13_hv_nmos w=4u l=0.45u m=1
MOCa_LSP5_MP1 OCa_LSP5_a OCa_LSP5_b vdda vdda sg13_hv_pmos w=0.6u l=0.5u m=1
MOCa_LSP5_MP2 OCa_LSP5_b OCa_LSP5_a vdda vdda sg13_hv_pmos w=0.6u l=0.5u m=1
MOCa_LSP5_MB1P OCa_bbp5 OCa_LSP5_b vdda vdda sg13_hv_pmos w=2u l=0.5u m=1
MOCa_LSP5_MB1N OCa_bbp5 OCa_LSP5_b vss vss sg13_hv_nmos w=1u l=0.45u m=1
MOCa_LSP5_MB2P OCa_bp5 OCa_bbp5 vdda vdda sg13_hv_pmos w=2u l=0.5u m=1
MOCa_LSP5_MB2N OCa_bp5 OCa_bbp5 vss vss sg13_hv_nmos w=1u l=0.45u m=1
MOCa_LSN5_MIP OCa_LSN5_inb oa_n5 vdd vdd sg13_lv_pmos w=1u l=0.13u m=1
MOCa_LSN5_MIN OCa_LSN5_inb oa_n5 vss vss sg13_lv_nmos w=0.5u l=0.13u m=1
MOCa_LSN5_MN1 OCa_LSN5_a oa_n5 vss vss sg13_hv_nmos w=4u l=0.45u m=1
MOCa_LSN5_MN2 OCa_LSN5_b OCa_LSN5_inb vss vss sg13_hv_nmos w=4u l=0.45u m=1
MOCa_LSN5_MP1 OCa_LSN5_a OCa_LSN5_b vdda vdda sg13_hv_pmos w=0.6u l=0.5u m=1
MOCa_LSN5_MP2 OCa_LSN5_b OCa_LSN5_a vdda vdda sg13_hv_pmos w=0.6u l=0.5u m=1
MOCa_LSN5_MB1P OCa_bbn5 OCa_LSN5_b vdda vdda sg13_hv_pmos w=2u l=0.5u m=1
MOCa_LSN5_MB1N OCa_bbn5 OCa_LSN5_b vss vss sg13_hv_nmos w=1u l=0.45u m=1
MOCa_LSN5_MB2P OCa_bn5 OCa_bbn5 vdda vdda sg13_hv_pmos w=2u l=0.5u m=1
MOCa_LSN5_MB2N OCa_bn5 OCa_bbn5 vss vss sg13_hv_nmos w=1u l=0.45u m=1
MOCa_LSP6_MIP OCa_LSP6_inb oa_p6 vdd vdd sg13_lv_pmos w=1u l=0.13u m=1
MOCa_LSP6_MIN OCa_LSP6_inb oa_p6 vss vss sg13_lv_nmos w=0.5u l=0.13u m=1
MOCa_LSP6_MN1 OCa_LSP6_a oa_p6 vss vss sg13_hv_nmos w=4u l=0.45u m=1
MOCa_LSP6_MN2 OCa_LSP6_b OCa_LSP6_inb vss vss sg13_hv_nmos w=4u l=0.45u m=1
MOCa_LSP6_MP1 OCa_LSP6_a OCa_LSP6_b vdda vdda sg13_hv_pmos w=0.6u l=0.5u m=1
MOCa_LSP6_MP2 OCa_LSP6_b OCa_LSP6_a vdda vdda sg13_hv_pmos w=0.6u l=0.5u m=1
MOCa_LSP6_MB1P OCa_bbp6 OCa_LSP6_b vdda vdda sg13_hv_pmos w=2u l=0.5u m=1
MOCa_LSP6_MB1N OCa_bbp6 OCa_LSP6_b vss vss sg13_hv_nmos w=1u l=0.45u m=1
MOCa_LSP6_MB2P OCa_bp6 OCa_bbp6 vdda vdda sg13_hv_pmos w=2u l=0.5u m=1
MOCa_LSP6_MB2N OCa_bp6 OCa_bbp6 vss vss sg13_hv_nmos w=1u l=0.45u m=1
MOCa_LSN6_MIP OCa_LSN6_inb oa_n6 vdd vdd sg13_lv_pmos w=1u l=0.13u m=1
MOCa_LSN6_MIN OCa_LSN6_inb oa_n6 vss vss sg13_lv_nmos w=0.5u l=0.13u m=1
MOCa_LSN6_MN1 OCa_LSN6_a oa_n6 vss vss sg13_hv_nmos w=4u l=0.45u m=1
MOCa_LSN6_MN2 OCa_LSN6_b OCa_LSN6_inb vss vss sg13_hv_nmos w=4u l=0.45u m=1
MOCa_LSN6_MP1 OCa_LSN6_a OCa_LSN6_b vdda vdda sg13_hv_pmos w=0.6u l=0.5u m=1
MOCa_LSN6_MP2 OCa_LSN6_b OCa_LSN6_a vdda vdda sg13_hv_pmos w=0.6u l=0.5u m=1
MOCa_LSN6_MB1P OCa_bbn6 OCa_LSN6_b vdda vdda sg13_hv_pmos w=2u l=0.5u m=1
MOCa_LSN6_MB1N OCa_bbn6 OCa_LSN6_b vss vss sg13_hv_nmos w=1u l=0.45u m=1
MOCa_LSN6_MB2P OCa_bn6 OCa_bbn6 vdda vdda sg13_hv_pmos w=2u l=0.5u m=1
MOCa_LSN6_MB2N OCa_bn6 OCa_bbn6 vss vss sg13_hv_nmos w=1u l=0.45u m=1
MOCa_LSP7_MIP OCa_LSP7_inb oa_p7 vdd vdd sg13_lv_pmos w=1u l=0.13u m=1
MOCa_LSP7_MIN OCa_LSP7_inb oa_p7 vss vss sg13_lv_nmos w=0.5u l=0.13u m=1
MOCa_LSP7_MN1 OCa_LSP7_a oa_p7 vss vss sg13_hv_nmos w=4u l=0.45u m=1
MOCa_LSP7_MN2 OCa_LSP7_b OCa_LSP7_inb vss vss sg13_hv_nmos w=4u l=0.45u m=1
MOCa_LSP7_MP1 OCa_LSP7_a OCa_LSP7_b vdda vdda sg13_hv_pmos w=0.6u l=0.5u m=1
MOCa_LSP7_MP2 OCa_LSP7_b OCa_LSP7_a vdda vdda sg13_hv_pmos w=0.6u l=0.5u m=1
MOCa_LSP7_MB1P OCa_bbp7 OCa_LSP7_b vdda vdda sg13_hv_pmos w=2u l=0.5u m=1
MOCa_LSP7_MB1N OCa_bbp7 OCa_LSP7_b vss vss sg13_hv_nmos w=1u l=0.45u m=1
MOCa_LSP7_MB2P OCa_bp7 OCa_bbp7 vdda vdda sg13_hv_pmos w=2u l=0.5u m=1
MOCa_LSP7_MB2N OCa_bp7 OCa_bbp7 vss vss sg13_hv_nmos w=1u l=0.45u m=1
MOCa_LSN7_MIP OCa_LSN7_inb oa_n7 vdd vdd sg13_lv_pmos w=1u l=0.13u m=1
MOCa_LSN7_MIN OCa_LSN7_inb oa_n7 vss vss sg13_lv_nmos w=0.5u l=0.13u m=1
MOCa_LSN7_MN1 OCa_LSN7_a oa_n7 vss vss sg13_hv_nmos w=4u l=0.45u m=1
MOCa_LSN7_MN2 OCa_LSN7_b OCa_LSN7_inb vss vss sg13_hv_nmos w=4u l=0.45u m=1
MOCa_LSN7_MP1 OCa_LSN7_a OCa_LSN7_b vdda vdda sg13_hv_pmos w=0.6u l=0.5u m=1
MOCa_LSN7_MP2 OCa_LSN7_b OCa_LSN7_a vdda vdda sg13_hv_pmos w=0.6u l=0.5u m=1
MOCa_LSN7_MB1P OCa_bbn7 OCa_LSN7_b vdda vdda sg13_hv_pmos w=2u l=0.5u m=1
MOCa_LSN7_MB1N OCa_bbn7 OCa_LSN7_b vss vss sg13_hv_nmos w=1u l=0.45u m=1
MOCa_LSN7_MB2P OCa_bn7 OCa_bbn7 vdda vdda sg13_hv_pmos w=2u l=0.5u m=1
MOCa_LSN7_MB2N OCa_bn7 OCa_bbn7 vss vss sg13_hv_nmos w=1u l=0.45u m=1
MOCa_MXP_S0_0_0 vss OCa_bbp0 OCa_MXP_n0_0 vss sg13_hv_nmos w=0.5u l=0.45u m=1
MOCa_MXP_S0_0_1 t1 OCa_bp0 OCa_MXP_n0_0 vss sg13_hv_nmos w=0.5u l=0.45u m=1
MOCa_MXP_S0_1_0 t2 OCa_bbp0 OCa_MXP_n0_1 vss sg13_hv_nmos w=0.5u l=0.45u m=1
MOCa_MXP_S0_1_1 t3 OCa_bp0 OCa_MXP_n0_1 vss sg13_hv_nmos w=0.5u l=0.45u m=1
MOCa_MXP_S0_2_0 t4 OCa_bbp0 OCa_MXP_n0_2 vss sg13_hv_nmos w=0.5u l=0.45u m=1
MOCa_MXP_S0_2_1 t5 OCa_bp0 OCa_MXP_n0_2 vss sg13_hv_nmos w=0.5u l=0.45u m=1
MOCa_MXP_S0_3_0 t6 OCa_bbp0 OCa_MXP_n0_3 vss sg13_hv_nmos w=0.5u l=0.45u m=1
MOCa_MXP_S0_3_1 t7 OCa_bp0 OCa_MXP_n0_3 vss sg13_hv_nmos w=0.5u l=0.45u m=1
MOCa_MXP_S0_4_0 t8 OCa_bbp0 OCa_MXP_n0_4 vss sg13_hv_nmos w=0.5u l=0.45u m=1
MOCa_MXP_S0_4_1 t9 OCa_bp0 OCa_MXP_n0_4 vss sg13_hv_nmos w=0.5u l=0.45u m=1
MOCa_MXP_S0_5_0 t10 OCa_bbp0 OCa_MXP_n0_5 vss sg13_hv_nmos w=0.5u l=0.45u m=1
MOCa_MXP_S0_5_1 t11 OCa_bp0 OCa_MXP_n0_5 vss sg13_hv_nmos w=0.5u l=0.45u m=1
MOCa_MXP_S0_6_0 t12 OCa_bbp0 OCa_MXP_n0_6 vss sg13_hv_nmos w=0.5u l=0.45u m=1
MOCa_MXP_S0_6_1 t13 OCa_bp0 OCa_MXP_n0_6 vss sg13_hv_nmos w=0.5u l=0.45u m=1
MOCa_MXP_S0_7_0 t14 OCa_bbp0 OCa_MXP_n0_7 vss sg13_hv_nmos w=0.5u l=0.45u m=1
MOCa_MXP_S0_7_1 t15 OCa_bp0 OCa_MXP_n0_7 vss sg13_hv_nmos w=0.5u l=0.45u m=1
MOCa_MXP_S0_8_0 t16 OCa_bbp0 OCa_MXP_n0_8 vss sg13_hv_nmos w=0.5u l=0.45u m=1
MOCa_MXP_S0_8_1 t17 OCa_bp0 OCa_MXP_n0_8 vss sg13_hv_nmos w=0.5u l=0.45u m=1
MOCa_MXP_S0_9_0 t18 OCa_bbp0 OCa_MXP_n0_9 vss sg13_hv_nmos w=0.5u l=0.45u m=1
MOCa_MXP_S0_9_1 t19 OCa_bp0 OCa_MXP_n0_9 vss sg13_hv_nmos w=0.5u l=0.45u m=1
MOCa_MXP_S0_10_0 t20 OCa_bbp0 OCa_MXP_n0_10 vss sg13_hv_nmos w=0.5u l=0.45u m=1
MOCa_MXP_S0_10_1 t21 OCa_bp0 OCa_MXP_n0_10 vss sg13_hv_nmos w=0.5u l=0.45u m=1
MOCa_MXP_S0_11_0 t22 OCa_bbp0 OCa_MXP_n0_11 vss sg13_hv_nmos w=0.5u l=0.45u m=1
MOCa_MXP_S0_11_1 t23 OCa_bp0 OCa_MXP_n0_11 vss sg13_hv_nmos w=0.5u l=0.45u m=1
MOCa_MXP_S0_12_0 t24 OCa_bbp0 OCa_MXP_n0_12 vss sg13_hv_nmos w=0.5u l=0.45u m=1
MOCa_MXP_S0_12_1 t25 OCa_bp0 OCa_MXP_n0_12 vss sg13_hv_nmos w=0.5u l=0.45u m=1
MOCa_MXP_S0_13_0 t26 OCa_bbp0 OCa_MXP_n0_13 vss sg13_hv_nmos w=0.5u l=0.45u m=1
MOCa_MXP_S0_13_1 t27 OCa_bp0 OCa_MXP_n0_13 vss sg13_hv_nmos w=0.5u l=0.45u m=1
MOCa_MXP_S0_14_0 t28 OCa_bbp0 OCa_MXP_n0_14 vss sg13_hv_nmos w=0.5u l=0.45u m=1
MOCa_MXP_S0_14_1 t29 OCa_bp0 OCa_MXP_n0_14 vss sg13_hv_nmos w=0.5u l=0.45u m=1
MOCa_MXP_S0_15_0 t30 OCa_bbp0 OCa_MXP_n0_15 vss sg13_hv_nmos w=0.5u l=0.45u m=1
MOCa_MXP_S0_15_1 t31 OCa_bp0 OCa_MXP_n0_15 vss sg13_hv_nmos w=0.5u l=0.45u m=1
MOCa_MXP_S0_16_0 t32 OCa_bbp0 OCa_MXP_n0_16 vss sg13_hv_nmos w=0.5u l=0.45u m=1
MOCa_MXP_S0_16_1 t33 OCa_bp0 OCa_MXP_n0_16 vss sg13_hv_nmos w=0.5u l=0.45u m=1
MOCa_MXP_S0_17_0 t34 OCa_bbp0 OCa_MXP_n0_17 vss sg13_hv_nmos w=0.5u l=0.45u m=1
MOCa_MXP_S0_17_1 t35 OCa_bp0 OCa_MXP_n0_17 vss sg13_hv_nmos w=0.5u l=0.45u m=1
MOCa_MXP_S0_18_0 t36 OCa_bbp0 OCa_MXP_n0_18 vss sg13_hv_nmos w=0.5u l=0.45u m=1
MOCa_MXP_S0_18_1 t37 OCa_bp0 OCa_MXP_n0_18 vss sg13_hv_nmos w=0.5u l=0.45u m=1
MOCa_MXP_S0_19_0 t38 OCa_bbp0 OCa_MXP_n0_19 vss sg13_hv_nmos w=0.5u l=0.45u m=1
MOCa_MXP_S0_19_1 t39 OCa_bp0 OCa_MXP_n0_19 vss sg13_hv_nmos w=0.5u l=0.45u m=1
MOCa_MXP_S0_20_0 t40 OCa_bbp0 OCa_MXP_n0_20 vss sg13_hv_nmos w=0.5u l=0.45u m=1
MOCa_MXP_S0_20_1 t41 OCa_bp0 OCa_MXP_n0_20 vss sg13_hv_nmos w=0.5u l=0.45u m=1
MOCa_MXP_S0_21_0 t42 OCa_bbp0 OCa_MXP_n0_21 vss sg13_hv_nmos w=0.5u l=0.45u m=1
MOCa_MXP_S0_21_1 t43 OCa_bp0 OCa_MXP_n0_21 vss sg13_hv_nmos w=0.5u l=0.45u m=1
MOCa_MXP_S0_22_0 t44 OCa_bbp0 OCa_MXP_n0_22 vss sg13_hv_nmos w=0.5u l=0.45u m=1
MOCa_MXP_S0_22_1 t45 OCa_bp0 OCa_MXP_n0_22 vss sg13_hv_nmos w=0.5u l=0.45u m=1
MOCa_MXP_S0_23_0 t46 OCa_bbp0 OCa_MXP_n0_23 vss sg13_hv_nmos w=0.5u l=0.45u m=1
MOCa_MXP_S0_23_1 t47 OCa_bp0 OCa_MXP_n0_23 vss sg13_hv_nmos w=0.5u l=0.45u m=1
MOCa_MXP_S0_24_0 t48 OCa_bbp0 OCa_MXP_n0_24 vss sg13_hv_nmos w=0.5u l=0.45u m=1
MOCa_MXP_S0_24_1 t49 OCa_bp0 OCa_MXP_n0_24 vss sg13_hv_nmos w=0.5u l=0.45u m=1
MOCa_MXP_S0_25_0 t50 OCa_bbp0 OCa_MXP_n0_25 vss sg13_hv_nmos w=0.5u l=0.45u m=1
MOCa_MXP_S0_25_1 t51 OCa_bp0 OCa_MXP_n0_25 vss sg13_hv_nmos w=0.5u l=0.45u m=1
MOCa_MXP_S0_26_0 t52 OCa_bbp0 OCa_MXP_n0_26 vss sg13_hv_nmos w=0.5u l=0.45u m=1
MOCa_MXP_S0_26_1 t53 OCa_bp0 OCa_MXP_n0_26 vss sg13_hv_nmos w=0.5u l=0.45u m=1
MOCa_MXP_S0_27_0 t54 OCa_bbp0 OCa_MXP_n0_27 vss sg13_hv_nmos w=0.5u l=0.45u m=1
MOCa_MXP_S0_27_1 t55 OCa_bp0 OCa_MXP_n0_27 vss sg13_hv_nmos w=0.5u l=0.45u m=1
MOCa_MXP_S0_28_0 t56 OCa_bbp0 OCa_MXP_n0_28 vss sg13_hv_nmos w=0.5u l=0.45u m=1
MOCa_MXP_S0_28_1 t57 OCa_bp0 OCa_MXP_n0_28 vss sg13_hv_nmos w=0.5u l=0.45u m=1
MOCa_MXP_S0_29_0 t58 OCa_bbp0 OCa_MXP_n0_29 vss sg13_hv_nmos w=0.5u l=0.45u m=1
MOCa_MXP_S0_29_1 t59 OCa_bp0 OCa_MXP_n0_29 vss sg13_hv_nmos w=0.5u l=0.45u m=1
MOCa_MXP_S0_30_0 t60 OCa_bbp0 OCa_MXP_n0_30 vss sg13_hv_nmos w=0.5u l=0.45u m=1
MOCa_MXP_S0_30_1 t61 OCa_bp0 OCa_MXP_n0_30 vss sg13_hv_nmos w=0.5u l=0.45u m=1
MOCa_MXP_S0_31_0 t62 OCa_bbp0 OCa_MXP_n0_31 vss sg13_hv_nmos w=0.5u l=0.45u m=1
MOCa_MXP_S0_31_1 t63 OCa_bp0 OCa_MXP_n0_31 vss sg13_hv_nmos w=0.5u l=0.45u m=1
MOCa_MXP_S0_32_0 t64 OCa_bbp0 OCa_MXP_n0_32 vss sg13_hv_nmos w=0.5u l=0.45u m=1
MOCa_MXP_S0_32_1 t65 OCa_bp0 OCa_MXP_n0_32 vss sg13_hv_nmos w=0.5u l=0.45u m=1
MOCa_MXP_S0_33_0 t66 OCa_bbp0 OCa_MXP_n0_33 vss sg13_hv_nmos w=0.5u l=0.45u m=1
MOCa_MXP_S0_33_1 t67 OCa_bp0 OCa_MXP_n0_33 vss sg13_hv_nmos w=0.5u l=0.45u m=1
MOCa_MXP_S0_34_0 t68 OCa_bbp0 OCa_MXP_n0_34 vss sg13_hv_nmos w=0.5u l=0.45u m=1
MOCa_MXP_S0_34_1 t69 OCa_bp0 OCa_MXP_n0_34 vss sg13_hv_nmos w=0.5u l=0.45u m=1
MOCa_MXP_S0_35_0 t70 OCa_bbp0 OCa_MXP_n0_35 vss sg13_hv_nmos w=0.5u l=0.45u m=1
MOCa_MXP_S0_35_1 t71 OCa_bp0 OCa_MXP_n0_35 vss sg13_hv_nmos w=0.5u l=0.45u m=1
MOCa_MXP_S0_36_0 t72 OCa_bbp0 OCa_MXP_n0_36 vss sg13_hv_nmos w=0.5u l=0.45u m=1
MOCa_MXP_S0_36_1 t73 OCa_bp0 OCa_MXP_n0_36 vss sg13_hv_nmos w=0.5u l=0.45u m=1
MOCa_MXP_S0_37_0 t74 OCa_bbp0 OCa_MXP_n0_37 vss sg13_hv_nmos w=0.5u l=0.45u m=1
MOCa_MXP_S0_37_1 t75 OCa_bp0 OCa_MXP_n0_37 vss sg13_hv_nmos w=0.5u l=0.45u m=1
MOCa_MXP_S0_38_0 t76 OCa_bbp0 OCa_MXP_n0_38 vss sg13_hv_nmos w=0.5u l=0.45u m=1
MOCa_MXP_S0_38_1 t77 OCa_bp0 OCa_MXP_n0_38 vss sg13_hv_nmos w=0.5u l=0.45u m=1
MOCa_MXP_S0_39_0 t78 OCa_bbp0 OCa_MXP_n0_39 vss sg13_hv_nmos w=0.5u l=0.45u m=1
MOCa_MXP_S0_39_1 t79 OCa_bp0 OCa_MXP_n0_39 vss sg13_hv_nmos w=0.5u l=0.45u m=1
MOCa_MXP_S0_40_0 t80 OCa_bbp0 OCa_MXP_n0_40 vss sg13_hv_nmos w=0.5u l=0.45u m=1
MOCa_MXP_S0_40_1 t81 OCa_bp0 OCa_MXP_n0_40 vss sg13_hv_nmos w=0.5u l=0.45u m=1
MOCa_MXP_S0_41_0 t82 OCa_bbp0 OCa_MXP_n0_41 vss sg13_hv_nmos w=0.5u l=0.45u m=1
MOCa_MXP_S0_41_1 t83 OCa_bp0 OCa_MXP_n0_41 vss sg13_hv_nmos w=0.5u l=0.45u m=1
MOCa_MXP_S0_42_0 t84 OCa_bbp0 OCa_MXP_n0_42 vss sg13_hv_nmos w=0.5u l=0.45u m=1
MOCa_MXP_S0_42_1 t85 OCa_bp0 OCa_MXP_n0_42 vss sg13_hv_nmos w=0.5u l=0.45u m=1
MOCa_MXP_S0_43_0 t86 OCa_bbp0 OCa_MXP_n0_43 vss sg13_hv_nmos w=0.5u l=0.45u m=1
MOCa_MXP_S0_43_1 t87 OCa_bp0 OCa_MXP_n0_43 vss sg13_hv_nmos w=0.5u l=0.45u m=1
MOCa_MXP_S0_44_0 t88 OCa_bbp0 OCa_MXP_n0_44 vss sg13_hv_nmos w=0.5u l=0.45u m=1
MOCa_MXP_S0_44_1 t89 OCa_bp0 OCa_MXP_n0_44 vss sg13_hv_nmos w=0.5u l=0.45u m=1
MOCa_MXP_S0_45_0 t90 OCa_bbp0 OCa_MXP_n0_45 vss sg13_hv_nmos w=0.5u l=0.45u m=1
MOCa_MXP_S0_45_1 t91 OCa_bp0 OCa_MXP_n0_45 vss sg13_hv_nmos w=0.5u l=0.45u m=1
MOCa_MXP_S0_46_0 t92 OCa_bbp0 OCa_MXP_n0_46 vss sg13_hv_nmos w=0.5u l=0.45u m=1
MOCa_MXP_S0_46_1 t93 OCa_bp0 OCa_MXP_n0_46 vss sg13_hv_nmos w=0.5u l=0.45u m=1
MOCa_MXP_S0_47_0 t94 OCa_bbp0 OCa_MXP_n0_47 vss sg13_hv_nmos w=0.5u l=0.45u m=1
MOCa_MXP_S0_47_1 t95 OCa_bp0 OCa_MXP_n0_47 vss sg13_hv_nmos w=0.5u l=0.45u m=1
MOCa_MXP_S0_48_0 t96 OCa_bbp0 OCa_MXP_n0_48 vss sg13_hv_nmos w=0.5u l=0.45u m=1
MOCa_MXP_S0_48_1 t97 OCa_bp0 OCa_MXP_n0_48 vss sg13_hv_nmos w=0.5u l=0.45u m=1
MOCa_MXP_S0_49_0 t98 OCa_bbp0 OCa_MXP_n0_49 vss sg13_hv_nmos w=0.5u l=0.45u m=1
MOCa_MXP_S0_49_1 t99 OCa_bp0 OCa_MXP_n0_49 vss sg13_hv_nmos w=0.5u l=0.45u m=1
MOCa_MXP_S0_50_0 t100 OCa_bbp0 OCa_MXP_n0_50 vss sg13_hv_nmos w=0.5u l=0.45u m=1
MOCa_MXP_S0_50_1 t101 OCa_bp0 OCa_MXP_n0_50 vss sg13_hv_nmos w=0.5u l=0.45u m=1
MOCa_MXP_S0_51_0 t102 OCa_bbp0 OCa_MXP_n0_51 vss sg13_hv_nmos w=0.5u l=0.45u m=1
MOCa_MXP_S0_51_1 t103 OCa_bp0 OCa_MXP_n0_51 vss sg13_hv_nmos w=0.5u l=0.45u m=1
MOCa_MXP_S0_52_0 t104 OCa_bbp0 OCa_MXP_n0_52 vss sg13_hv_nmos w=0.5u l=0.45u m=1
MOCa_MXP_S0_52_1 t105 OCa_bp0 OCa_MXP_n0_52 vss sg13_hv_nmos w=0.5u l=0.45u m=1
MOCa_MXP_S0_53_0 t106 OCa_bbp0 OCa_MXP_n0_53 vss sg13_hv_nmos w=0.5u l=0.45u m=1
MOCa_MXP_S0_53_1 t107 OCa_bp0 OCa_MXP_n0_53 vss sg13_hv_nmos w=0.5u l=0.45u m=1
MOCa_MXP_S0_54_0 t108 OCa_bbp0 OCa_MXP_n0_54 vss sg13_hv_nmos w=0.5u l=0.45u m=1
MOCa_MXP_S0_54_1 t109 OCa_bp0 OCa_MXP_n0_54 vss sg13_hv_nmos w=0.5u l=0.45u m=1
MOCa_MXP_S0_55_0 t110 OCa_bbp0 OCa_MXP_n0_55 vss sg13_hv_nmos w=0.5u l=0.45u m=1
MOCa_MXP_S0_55_1 t111 OCa_bp0 OCa_MXP_n0_55 vss sg13_hv_nmos w=0.5u l=0.45u m=1
MOCa_MXP_S0_56_0 t112 OCa_bbp0 OCa_MXP_n0_56 vss sg13_hv_nmos w=0.5u l=0.45u m=1
MOCa_MXP_S0_56_1 t113 OCa_bp0 OCa_MXP_n0_56 vss sg13_hv_nmos w=0.5u l=0.45u m=1
MOCa_MXP_S0_57_0 t114 OCa_bbp0 OCa_MXP_n0_57 vss sg13_hv_nmos w=0.5u l=0.45u m=1
MOCa_MXP_S0_57_1 t115 OCa_bp0 OCa_MXP_n0_57 vss sg13_hv_nmos w=0.5u l=0.45u m=1
MOCa_MXP_S0_58_0 t116 OCa_bbp0 OCa_MXP_n0_58 vss sg13_hv_nmos w=0.5u l=0.45u m=1
MOCa_MXP_S0_58_1 t117 OCa_bp0 OCa_MXP_n0_58 vss sg13_hv_nmos w=0.5u l=0.45u m=1
MOCa_MXP_S0_59_0 t118 OCa_bbp0 OCa_MXP_n0_59 vss sg13_hv_nmos w=0.5u l=0.45u m=1
MOCa_MXP_S0_59_1 t119 OCa_bp0 OCa_MXP_n0_59 vss sg13_hv_nmos w=0.5u l=0.45u m=1
MOCa_MXP_S0_60_0 t120 OCa_bbp0 OCa_MXP_n0_60 vss sg13_hv_nmos w=0.5u l=0.45u m=1
MOCa_MXP_S0_60_1 t121 OCa_bp0 OCa_MXP_n0_60 vss sg13_hv_nmos w=0.5u l=0.45u m=1
MOCa_MXP_S0_61_0 t122 OCa_bbp0 OCa_MXP_n0_61 vss sg13_hv_nmos w=0.5u l=0.45u m=1
MOCa_MXP_S0_61_1 t123 OCa_bp0 OCa_MXP_n0_61 vss sg13_hv_nmos w=0.5u l=0.45u m=1
MOCa_MXP_S0_62_0 t124 OCa_bbp0 OCa_MXP_n0_62 vss sg13_hv_nmos w=0.5u l=0.45u m=1
MOCa_MXP_S0_62_1 t125 OCa_bp0 OCa_MXP_n0_62 vss sg13_hv_nmos w=0.5u l=0.45u m=1
MOCa_MXP_S0_63_0 t126 OCa_bbp0 OCa_MXP_n0_63 vss sg13_hv_nmos w=0.5u l=0.45u m=1
MOCa_MXP_S0_63_1 t127 OCa_bp0 OCa_MXP_n0_63 vss sg13_hv_nmos w=0.5u l=0.45u m=1
MOCa_MXP_S0_64_0 t128 OCa_bbp0 OCa_MXP_n0_64 vss sg13_hv_nmos w=0.5u l=0.45u m=1
MOCa_MXP_S0_64_1 t129 OCa_bp0 OCa_MXP_n0_64 vss sg13_hv_nmos w=0.5u l=0.45u m=1
MOCa_MXP_S0_65_0 t130 OCa_bbp0 OCa_MXP_n0_65 vss sg13_hv_nmos w=0.5u l=0.45u m=1
MOCa_MXP_S0_65_1 t131 OCa_bp0 OCa_MXP_n0_65 vss sg13_hv_nmos w=0.5u l=0.45u m=1
MOCa_MXP_S0_66_0 t132 OCa_bbp0 OCa_MXP_n0_66 vss sg13_hv_nmos w=0.5u l=0.45u m=1
MOCa_MXP_S0_66_1 t133 OCa_bp0 OCa_MXP_n0_66 vss sg13_hv_nmos w=0.5u l=0.45u m=1
MOCa_MXP_S0_67_0 t134 OCa_bbp0 OCa_MXP_n0_67 vss sg13_hv_nmos w=0.5u l=0.45u m=1
MOCa_MXP_S0_67_1 t135 OCa_bp0 OCa_MXP_n0_67 vss sg13_hv_nmos w=0.5u l=0.45u m=1
MOCa_MXP_S0_68_0 t136 OCa_bbp0 OCa_MXP_n0_68 vss sg13_hv_nmos w=0.5u l=0.45u m=1
MOCa_MXP_S0_68_1 t137 OCa_bp0 OCa_MXP_n0_68 vss sg13_hv_nmos w=0.5u l=0.45u m=1
MOCa_MXP_S0_69_0 t138 OCa_bbp0 OCa_MXP_n0_69 vss sg13_hv_nmos w=0.5u l=0.45u m=1
MOCa_MXP_S0_69_1 t139 OCa_bp0 OCa_MXP_n0_69 vss sg13_hv_nmos w=0.5u l=0.45u m=1
MOCa_MXP_S0_70_0 t140 OCa_bbp0 OCa_MXP_n0_70 vss sg13_hv_nmos w=0.5u l=0.45u m=1
MOCa_MXP_S0_70_1 t141 OCa_bp0 OCa_MXP_n0_70 vss sg13_hv_nmos w=0.5u l=0.45u m=1
MOCa_MXP_S0_71_0 t142 OCa_bbp0 OCa_MXP_n0_71 vss sg13_hv_nmos w=0.5u l=0.45u m=1
MOCa_MXP_S0_71_1 t143 OCa_bp0 OCa_MXP_n0_71 vss sg13_hv_nmos w=0.5u l=0.45u m=1
MOCa_MXP_S0_72_0 t144 OCa_bbp0 OCa_MXP_n0_72 vss sg13_hv_nmos w=0.5u l=0.45u m=1
MOCa_MXP_S0_72_1 t145 OCa_bp0 OCa_MXP_n0_72 vss sg13_hv_nmos w=0.5u l=0.45u m=1
MOCa_MXP_S0_73_0 t146 OCa_bbp0 OCa_MXP_n0_73 vss sg13_hv_nmos w=0.5u l=0.45u m=1
MOCa_MXP_S0_73_1 t147 OCa_bp0 OCa_MXP_n0_73 vss sg13_hv_nmos w=0.5u l=0.45u m=1
MOCa_MXP_S0_74_0 t148 OCa_bbp0 OCa_MXP_n0_74 vss sg13_hv_nmos w=0.5u l=0.45u m=1
MOCa_MXP_S0_74_1 t149 OCa_bp0 OCa_MXP_n0_74 vss sg13_hv_nmos w=0.5u l=0.45u m=1
MOCa_MXP_S0_75_0 t150 OCa_bbp0 OCa_MXP_n0_75 vss sg13_hv_nmos w=0.5u l=0.45u m=1
MOCa_MXP_S0_75_1 t151 OCa_bp0 OCa_MXP_n0_75 vss sg13_hv_nmos w=0.5u l=0.45u m=1
MOCa_MXP_S0_76_0 t152 OCa_bbp0 OCa_MXP_n0_76 vss sg13_hv_nmos w=0.5u l=0.45u m=1
MOCa_MXP_S0_76_1 t153 OCa_bp0 OCa_MXP_n0_76 vss sg13_hv_nmos w=0.5u l=0.45u m=1
MOCa_MXP_S0_77_0 t154 OCa_bbp0 OCa_MXP_n0_77 vss sg13_hv_nmos w=0.5u l=0.45u m=1
MOCa_MXP_S0_77_1 t155 OCa_bp0 OCa_MXP_n0_77 vss sg13_hv_nmos w=0.5u l=0.45u m=1
MOCa_MXP_S0_78_0 t156 OCa_bbp0 OCa_MXP_n0_78 vss sg13_hv_nmos w=0.5u l=0.45u m=1
MOCa_MXP_S0_78_1 t157 OCa_bp0 OCa_MXP_n0_78 vss sg13_hv_nmos w=0.5u l=0.45u m=1
MOCa_MXP_S0_79_0 t158 OCa_bbp0 OCa_MXP_n0_79 vss sg13_hv_nmos w=0.5u l=0.45u m=1
MOCa_MXP_S0_79_1 t159 OCa_bp0 OCa_MXP_n0_79 vss sg13_hv_nmos w=0.5u l=0.45u m=1
MOCa_MXP_S0_80_0 t160 OCa_bbp0 OCa_MXP_n0_80 vss sg13_hv_nmos w=0.5u l=0.45u m=1
MOCa_MXP_S0_80_1 t161 OCa_bp0 OCa_MXP_n0_80 vss sg13_hv_nmos w=0.5u l=0.45u m=1
MOCa_MXP_S0_81_0 t162 OCa_bbp0 OCa_MXP_n0_81 vss sg13_hv_nmos w=0.5u l=0.45u m=1
MOCa_MXP_S0_81_1 t163 OCa_bp0 OCa_MXP_n0_81 vss sg13_hv_nmos w=0.5u l=0.45u m=1
MOCa_MXP_S0_82_0 t164 OCa_bbp0 OCa_MXP_n0_82 vss sg13_hv_nmos w=0.5u l=0.45u m=1
MOCa_MXP_S0_82_1 t165 OCa_bp0 OCa_MXP_n0_82 vss sg13_hv_nmos w=0.5u l=0.45u m=1
MOCa_MXP_S0_83_0 t166 OCa_bbp0 OCa_MXP_n0_83 vss sg13_hv_nmos w=0.5u l=0.45u m=1
MOCa_MXP_S0_83_1 t167 OCa_bp0 OCa_MXP_n0_83 vss sg13_hv_nmos w=0.5u l=0.45u m=1
MOCa_MXP_S0_84_0 t168 OCa_bbp0 OCa_MXP_n0_84 vss sg13_hv_nmos w=0.5u l=0.45u m=1
MOCa_MXP_S0_84_1 t169 OCa_bp0 OCa_MXP_n0_84 vss sg13_hv_nmos w=0.5u l=0.45u m=1
MOCa_MXP_S0_85_0 t170 OCa_bbp0 OCa_MXP_n0_85 vss sg13_hv_nmos w=0.5u l=0.45u m=1
MOCa_MXP_S0_85_1 t171 OCa_bp0 OCa_MXP_n0_85 vss sg13_hv_nmos w=0.5u l=0.45u m=1
MOCa_MXP_S0_86_0 t172 OCa_bbp0 OCa_MXP_n0_86 vss sg13_hv_nmos w=0.5u l=0.45u m=1
MOCa_MXP_S0_86_1 t173 OCa_bp0 OCa_MXP_n0_86 vss sg13_hv_nmos w=0.5u l=0.45u m=1
MOCa_MXP_S0_87_0 t174 OCa_bbp0 OCa_MXP_n0_87 vss sg13_hv_nmos w=0.5u l=0.45u m=1
MOCa_MXP_S0_87_1 t175 OCa_bp0 OCa_MXP_n0_87 vss sg13_hv_nmos w=0.5u l=0.45u m=1
MOCa_MXP_S0_88_0 t176 OCa_bbp0 OCa_MXP_n0_88 vss sg13_hv_nmos w=0.5u l=0.45u m=1
MOCa_MXP_S0_88_1 t177 OCa_bp0 OCa_MXP_n0_88 vss sg13_hv_nmos w=0.5u l=0.45u m=1
MOCa_MXP_S0_89_0 t178 OCa_bbp0 OCa_MXP_n0_89 vss sg13_hv_nmos w=0.5u l=0.45u m=1
MOCa_MXP_S0_89_1 t179 OCa_bp0 OCa_MXP_n0_89 vss sg13_hv_nmos w=0.5u l=0.45u m=1
MOCa_MXP_S0_90_0 t180 OCa_bbp0 OCa_MXP_n0_90 vss sg13_hv_nmos w=0.5u l=0.45u m=1
MOCa_MXP_S0_90_1 t181 OCa_bp0 OCa_MXP_n0_90 vss sg13_hv_nmos w=0.5u l=0.45u m=1
MOCa_MXP_S0_91_0 t182 OCa_bbp0 OCa_MXP_n0_91 vss sg13_hv_nmos w=0.5u l=0.45u m=1
MOCa_MXP_S0_91_1 t183 OCa_bp0 OCa_MXP_n0_91 vss sg13_hv_nmos w=0.5u l=0.45u m=1
MOCa_MXP_S0_92_0 t184 OCa_bbp0 OCa_MXP_n0_92 vss sg13_hv_nmos w=0.5u l=0.45u m=1
MOCa_MXP_S0_92_1 t185 OCa_bp0 OCa_MXP_n0_92 vss sg13_hv_nmos w=0.5u l=0.45u m=1
MOCa_MXP_S0_93_0 t186 OCa_bbp0 OCa_MXP_n0_93 vss sg13_hv_nmos w=0.5u l=0.45u m=1
MOCa_MXP_S0_93_1 t187 OCa_bp0 OCa_MXP_n0_93 vss sg13_hv_nmos w=0.5u l=0.45u m=1
MOCa_MXP_S0_94_0 t188 OCa_bbp0 OCa_MXP_n0_94 vss sg13_hv_nmos w=0.5u l=0.45u m=1
MOCa_MXP_S0_94_1 t189 OCa_bp0 OCa_MXP_n0_94 vss sg13_hv_nmos w=0.5u l=0.45u m=1
MOCa_MXP_S0_95_0 t190 OCa_bbp0 OCa_MXP_n0_95 vss sg13_hv_nmos w=0.5u l=0.45u m=1
MOCa_MXP_S0_95_1 t191 OCa_bp0 OCa_MXP_n0_95 vss sg13_hv_nmos w=0.5u l=0.45u m=1
MOCa_MXP_S0_96_0 t192 OCa_bbp0 OCa_MXP_n0_96 vss sg13_hv_nmos w=0.5u l=0.45u m=1
MOCa_MXP_S0_96_1 t193 OCa_bp0 OCa_MXP_n0_96 vss sg13_hv_nmos w=0.5u l=0.45u m=1
MOCa_MXP_S0_97_0 t194 OCa_bbp0 OCa_MXP_n0_97 vss sg13_hv_nmos w=0.5u l=0.45u m=1
MOCa_MXP_S0_97_1 t195 OCa_bp0 OCa_MXP_n0_97 vss sg13_hv_nmos w=0.5u l=0.45u m=1
MOCa_MXP_S0_98_0 t196 OCa_bbp0 OCa_MXP_n0_98 vss sg13_hv_nmos w=0.5u l=0.45u m=1
MOCa_MXP_S0_98_1 t197 OCa_bp0 OCa_MXP_n0_98 vss sg13_hv_nmos w=0.5u l=0.45u m=1
MOCa_MXP_S0_99_0 t198 OCa_bbp0 OCa_MXP_n0_99 vss sg13_hv_nmos w=0.5u l=0.45u m=1
MOCa_MXP_S0_99_1 t199 OCa_bp0 OCa_MXP_n0_99 vss sg13_hv_nmos w=0.5u l=0.45u m=1
MOCa_MXP_S0_100_0 t200 OCa_bbp0 OCa_MXP_n0_100 vss sg13_hv_nmos w=0.5u l=0.45u m=1
MOCa_MXP_S0_100_1 t201 OCa_bp0 OCa_MXP_n0_100 vss sg13_hv_nmos w=0.5u l=0.45u m=1
MOCa_MXP_S0_101_0 t202 OCa_bbp0 OCa_MXP_n0_101 vss sg13_hv_nmos w=0.5u l=0.45u m=1
MOCa_MXP_S0_101_1 t203 OCa_bp0 OCa_MXP_n0_101 vss sg13_hv_nmos w=0.5u l=0.45u m=1
MOCa_MXP_S0_102_0 t204 OCa_bbp0 OCa_MXP_n0_102 vss sg13_hv_nmos w=0.5u l=0.45u m=1
MOCa_MXP_S0_102_1 t205 OCa_bp0 OCa_MXP_n0_102 vss sg13_hv_nmos w=0.5u l=0.45u m=1
MOCa_MXP_S0_103_0 t206 OCa_bbp0 OCa_MXP_n0_103 vss sg13_hv_nmos w=0.5u l=0.45u m=1
MOCa_MXP_S0_103_1 t207 OCa_bp0 OCa_MXP_n0_103 vss sg13_hv_nmos w=0.5u l=0.45u m=1
MOCa_MXP_S0_104_0 t208 OCa_bbp0 OCa_MXP_n0_104 vss sg13_hv_nmos w=0.5u l=0.45u m=1
MOCa_MXP_S0_104_1 t209 OCa_bp0 OCa_MXP_n0_104 vss sg13_hv_nmos w=0.5u l=0.45u m=1
MOCa_MXP_S0_105_0 t210 OCa_bbp0 OCa_MXP_n0_105 vss sg13_hv_nmos w=0.5u l=0.45u m=1
MOCa_MXP_S0_105_1 t211 OCa_bp0 OCa_MXP_n0_105 vss sg13_hv_nmos w=0.5u l=0.45u m=1
MOCa_MXP_S0_106_0 t212 OCa_bbp0 OCa_MXP_n0_106 vss sg13_hv_nmos w=0.5u l=0.45u m=1
MOCa_MXP_S0_106_1 t213 OCa_bp0 OCa_MXP_n0_106 vss sg13_hv_nmos w=0.5u l=0.45u m=1
MOCa_MXP_S0_107_0 t214 OCa_bbp0 OCa_MXP_n0_107 vss sg13_hv_nmos w=0.5u l=0.45u m=1
MOCa_MXP_S0_107_1 t215 OCa_bp0 OCa_MXP_n0_107 vss sg13_hv_nmos w=0.5u l=0.45u m=1
MOCa_MXP_S0_108_0 t216 OCa_bbp0 OCa_MXP_n0_108 vss sg13_hv_nmos w=0.5u l=0.45u m=1
MOCa_MXP_S0_108_1 t217 OCa_bp0 OCa_MXP_n0_108 vss sg13_hv_nmos w=0.5u l=0.45u m=1
MOCa_MXP_S0_109_0 t218 OCa_bbp0 OCa_MXP_n0_109 vss sg13_hv_nmos w=0.5u l=0.45u m=1
MOCa_MXP_S0_109_1 t219 OCa_bp0 OCa_MXP_n0_109 vss sg13_hv_nmos w=0.5u l=0.45u m=1
MOCa_MXP_S0_110_0 t220 OCa_bbp0 OCa_MXP_n0_110 vss sg13_hv_nmos w=0.5u l=0.45u m=1
MOCa_MXP_S0_110_1 t221 OCa_bp0 OCa_MXP_n0_110 vss sg13_hv_nmos w=0.5u l=0.45u m=1
MOCa_MXP_S0_111_0 t222 OCa_bbp0 OCa_MXP_n0_111 vss sg13_hv_nmos w=0.5u l=0.45u m=1
MOCa_MXP_S0_111_1 t223 OCa_bp0 OCa_MXP_n0_111 vss sg13_hv_nmos w=0.5u l=0.45u m=1
MOCa_MXP_S0_112_0 t224 OCa_bbp0 OCa_MXP_n0_112 vss sg13_hv_nmos w=0.5u l=0.45u m=1
MOCa_MXP_S0_112_1 t225 OCa_bp0 OCa_MXP_n0_112 vss sg13_hv_nmos w=0.5u l=0.45u m=1
MOCa_MXP_S0_113_0 t226 OCa_bbp0 OCa_MXP_n0_113 vss sg13_hv_nmos w=0.5u l=0.45u m=1
MOCa_MXP_S0_113_1 t227 OCa_bp0 OCa_MXP_n0_113 vss sg13_hv_nmos w=0.5u l=0.45u m=1
MOCa_MXP_S0_114_0 t228 OCa_bbp0 OCa_MXP_n0_114 vss sg13_hv_nmos w=0.5u l=0.45u m=1
MOCa_MXP_S0_114_1 t229 OCa_bp0 OCa_MXP_n0_114 vss sg13_hv_nmos w=0.5u l=0.45u m=1
MOCa_MXP_S0_115_0 t230 OCa_bbp0 OCa_MXP_n0_115 vss sg13_hv_nmos w=0.5u l=0.45u m=1
MOCa_MXP_S0_115_1 t231 OCa_bp0 OCa_MXP_n0_115 vss sg13_hv_nmos w=0.5u l=0.45u m=1
MOCa_MXP_S0_116_0 t232 OCa_bbp0 OCa_MXP_n0_116 vss sg13_hv_nmos w=0.5u l=0.45u m=1
MOCa_MXP_S0_116_1 t233 OCa_bp0 OCa_MXP_n0_116 vss sg13_hv_nmos w=0.5u l=0.45u m=1
MOCa_MXP_S0_117_0 t234 OCa_bbp0 OCa_MXP_n0_117 vss sg13_hv_nmos w=0.5u l=0.45u m=1
MOCa_MXP_S0_117_1 t235 OCa_bp0 OCa_MXP_n0_117 vss sg13_hv_nmos w=0.5u l=0.45u m=1
MOCa_MXP_S0_118_0 t236 OCa_bbp0 OCa_MXP_n0_118 vss sg13_hv_nmos w=0.5u l=0.45u m=1
MOCa_MXP_S0_118_1 t237 OCa_bp0 OCa_MXP_n0_118 vss sg13_hv_nmos w=0.5u l=0.45u m=1
MOCa_MXP_S0_119_0 t238 OCa_bbp0 OCa_MXP_n0_119 vss sg13_hv_nmos w=0.5u l=0.45u m=1
MOCa_MXP_S0_119_1 t239 OCa_bp0 OCa_MXP_n0_119 vss sg13_hv_nmos w=0.5u l=0.45u m=1
MOCa_MXP_S0_120_0 t240 OCa_bbp0 OCa_MXP_n0_120 vss sg13_hv_nmos w=0.5u l=0.45u m=1
MOCa_MXP_S0_120_1 t241 OCa_bp0 OCa_MXP_n0_120 vss sg13_hv_nmos w=0.5u l=0.45u m=1
MOCa_MXP_S0_121_0 t242 OCa_bbp0 OCa_MXP_n0_121 vss sg13_hv_nmos w=0.5u l=0.45u m=1
MOCa_MXP_S0_121_1 t243 OCa_bp0 OCa_MXP_n0_121 vss sg13_hv_nmos w=0.5u l=0.45u m=1
MOCa_MXP_S0_122_0 t244 OCa_bbp0 OCa_MXP_n0_122 vss sg13_hv_nmos w=0.5u l=0.45u m=1
MOCa_MXP_S0_122_1 t245 OCa_bp0 OCa_MXP_n0_122 vss sg13_hv_nmos w=0.5u l=0.45u m=1
MOCa_MXP_S0_123_0 t246 OCa_bbp0 OCa_MXP_n0_123 vss sg13_hv_nmos w=0.5u l=0.45u m=1
MOCa_MXP_S0_123_1 t247 OCa_bp0 OCa_MXP_n0_123 vss sg13_hv_nmos w=0.5u l=0.45u m=1
MOCa_MXP_S0_124_0 t248 OCa_bbp0 OCa_MXP_n0_124 vss sg13_hv_nmos w=0.5u l=0.45u m=1
MOCa_MXP_S0_124_1 t249 OCa_bp0 OCa_MXP_n0_124 vss sg13_hv_nmos w=0.5u l=0.45u m=1
MOCa_MXP_S0_125_0 t250 OCa_bbp0 OCa_MXP_n0_125 vss sg13_hv_nmos w=0.5u l=0.45u m=1
MOCa_MXP_S0_125_1 t251 OCa_bp0 OCa_MXP_n0_125 vss sg13_hv_nmos w=0.5u l=0.45u m=1
MOCa_MXP_S0_126_0 vref OCa_bbp0 OCa_MXP_n0_126 vss sg13_hv_nmos w=0.5u l=0.45u m=1
MOCa_MXP_S0_126_1 vref OCa_bp0 OCa_MXP_n0_126 vss sg13_hv_nmos w=0.5u l=0.45u m=1
MOCa_MXP_S0_127_0 vref OCa_bbp0 OCa_MXP_n0_127 vss sg13_hv_nmos w=0.5u l=0.45u m=1
MOCa_MXP_S0_127_1 vref OCa_bp0 OCa_MXP_n0_127 vss sg13_hv_nmos w=0.5u l=0.45u m=1
MOCa_MXP_S1_0_0 OCa_MXP_n0_0 OCa_bbp1 OCa_MXP_n1_0 vss sg13_hv_nmos w=0.5u l=0.45u m=1
MOCa_MXP_S1_0_1 OCa_MXP_n0_1 OCa_bp1 OCa_MXP_n1_0 vss sg13_hv_nmos w=0.5u l=0.45u m=1
MOCa_MXP_S1_1_0 OCa_MXP_n0_2 OCa_bbp1 OCa_MXP_n1_1 vss sg13_hv_nmos w=0.5u l=0.45u m=1
MOCa_MXP_S1_1_1 OCa_MXP_n0_3 OCa_bp1 OCa_MXP_n1_1 vss sg13_hv_nmos w=0.5u l=0.45u m=1
MOCa_MXP_S1_2_0 OCa_MXP_n0_4 OCa_bbp1 OCa_MXP_n1_2 vss sg13_hv_nmos w=0.5u l=0.45u m=1
MOCa_MXP_S1_2_1 OCa_MXP_n0_5 OCa_bp1 OCa_MXP_n1_2 vss sg13_hv_nmos w=0.5u l=0.45u m=1
MOCa_MXP_S1_3_0 OCa_MXP_n0_6 OCa_bbp1 OCa_MXP_n1_3 vss sg13_hv_nmos w=0.5u l=0.45u m=1
MOCa_MXP_S1_3_1 OCa_MXP_n0_7 OCa_bp1 OCa_MXP_n1_3 vss sg13_hv_nmos w=0.5u l=0.45u m=1
MOCa_MXP_S1_4_0 OCa_MXP_n0_8 OCa_bbp1 OCa_MXP_n1_4 vss sg13_hv_nmos w=0.5u l=0.45u m=1
MOCa_MXP_S1_4_1 OCa_MXP_n0_9 OCa_bp1 OCa_MXP_n1_4 vss sg13_hv_nmos w=0.5u l=0.45u m=1
MOCa_MXP_S1_5_0 OCa_MXP_n0_10 OCa_bbp1 OCa_MXP_n1_5 vss sg13_hv_nmos w=0.5u l=0.45u m=1
MOCa_MXP_S1_5_1 OCa_MXP_n0_11 OCa_bp1 OCa_MXP_n1_5 vss sg13_hv_nmos w=0.5u l=0.45u m=1
MOCa_MXP_S1_6_0 OCa_MXP_n0_12 OCa_bbp1 OCa_MXP_n1_6 vss sg13_hv_nmos w=0.5u l=0.45u m=1
MOCa_MXP_S1_6_1 OCa_MXP_n0_13 OCa_bp1 OCa_MXP_n1_6 vss sg13_hv_nmos w=0.5u l=0.45u m=1
MOCa_MXP_S1_7_0 OCa_MXP_n0_14 OCa_bbp1 OCa_MXP_n1_7 vss sg13_hv_nmos w=0.5u l=0.45u m=1
MOCa_MXP_S1_7_1 OCa_MXP_n0_15 OCa_bp1 OCa_MXP_n1_7 vss sg13_hv_nmos w=0.5u l=0.45u m=1
MOCa_MXP_S1_8_0 OCa_MXP_n0_16 OCa_bbp1 OCa_MXP_n1_8 vss sg13_hv_nmos w=0.5u l=0.45u m=1
MOCa_MXP_S1_8_1 OCa_MXP_n0_17 OCa_bp1 OCa_MXP_n1_8 vss sg13_hv_nmos w=0.5u l=0.45u m=1
MOCa_MXP_S1_9_0 OCa_MXP_n0_18 OCa_bbp1 OCa_MXP_n1_9 vss sg13_hv_nmos w=0.5u l=0.45u m=1
MOCa_MXP_S1_9_1 OCa_MXP_n0_19 OCa_bp1 OCa_MXP_n1_9 vss sg13_hv_nmos w=0.5u l=0.45u m=1
MOCa_MXP_S1_10_0 OCa_MXP_n0_20 OCa_bbp1 OCa_MXP_n1_10 vss sg13_hv_nmos w=0.5u l=0.45u m=1
MOCa_MXP_S1_10_1 OCa_MXP_n0_21 OCa_bp1 OCa_MXP_n1_10 vss sg13_hv_nmos w=0.5u l=0.45u m=1
MOCa_MXP_S1_11_0 OCa_MXP_n0_22 OCa_bbp1 OCa_MXP_n1_11 vss sg13_hv_nmos w=0.5u l=0.45u m=1
MOCa_MXP_S1_11_1 OCa_MXP_n0_23 OCa_bp1 OCa_MXP_n1_11 vss sg13_hv_nmos w=0.5u l=0.45u m=1
MOCa_MXP_S1_12_0 OCa_MXP_n0_24 OCa_bbp1 OCa_MXP_n1_12 vss sg13_hv_nmos w=0.5u l=0.45u m=1
MOCa_MXP_S1_12_1 OCa_MXP_n0_25 OCa_bp1 OCa_MXP_n1_12 vss sg13_hv_nmos w=0.5u l=0.45u m=1
MOCa_MXP_S1_13_0 OCa_MXP_n0_26 OCa_bbp1 OCa_MXP_n1_13 vss sg13_hv_nmos w=0.5u l=0.45u m=1
MOCa_MXP_S1_13_1 OCa_MXP_n0_27 OCa_bp1 OCa_MXP_n1_13 vss sg13_hv_nmos w=0.5u l=0.45u m=1
MOCa_MXP_S1_14_0 OCa_MXP_n0_28 OCa_bbp1 OCa_MXP_n1_14 vss sg13_hv_nmos w=0.5u l=0.45u m=1
MOCa_MXP_S1_14_1 OCa_MXP_n0_29 OCa_bp1 OCa_MXP_n1_14 vss sg13_hv_nmos w=0.5u l=0.45u m=1
MOCa_MXP_S1_15_0 OCa_MXP_n0_30 OCa_bbp1 OCa_MXP_n1_15 vss sg13_hv_nmos w=0.5u l=0.45u m=1
MOCa_MXP_S1_15_1 OCa_MXP_n0_31 OCa_bp1 OCa_MXP_n1_15 vss sg13_hv_nmos w=0.5u l=0.45u m=1
MOCa_MXP_S1_16_0 OCa_MXP_n0_32 OCa_bbp1 OCa_MXP_n1_16 vss sg13_hv_nmos w=0.5u l=0.45u m=1
MOCa_MXP_S1_16_1 OCa_MXP_n0_33 OCa_bp1 OCa_MXP_n1_16 vss sg13_hv_nmos w=0.5u l=0.45u m=1
MOCa_MXP_S1_17_0 OCa_MXP_n0_34 OCa_bbp1 OCa_MXP_n1_17 vss sg13_hv_nmos w=0.5u l=0.45u m=1
MOCa_MXP_S1_17_1 OCa_MXP_n0_35 OCa_bp1 OCa_MXP_n1_17 vss sg13_hv_nmos w=0.5u l=0.45u m=1
MOCa_MXP_S1_18_0 OCa_MXP_n0_36 OCa_bbp1 OCa_MXP_n1_18 vss sg13_hv_nmos w=0.5u l=0.45u m=1
MOCa_MXP_S1_18_1 OCa_MXP_n0_37 OCa_bp1 OCa_MXP_n1_18 vss sg13_hv_nmos w=0.5u l=0.45u m=1
MOCa_MXP_S1_19_0 OCa_MXP_n0_38 OCa_bbp1 OCa_MXP_n1_19 vss sg13_hv_nmos w=0.5u l=0.45u m=1
MOCa_MXP_S1_19_1 OCa_MXP_n0_39 OCa_bp1 OCa_MXP_n1_19 vss sg13_hv_nmos w=0.5u l=0.45u m=1
MOCa_MXP_S1_20_0 OCa_MXP_n0_40 OCa_bbp1 OCa_MXP_n1_20 vss sg13_hv_nmos w=0.5u l=0.45u m=1
MOCa_MXP_S1_20_1 OCa_MXP_n0_41 OCa_bp1 OCa_MXP_n1_20 vss sg13_hv_nmos w=0.5u l=0.45u m=1
MOCa_MXP_S1_21_0 OCa_MXP_n0_42 OCa_bbp1 OCa_MXP_n1_21 vss sg13_hv_nmos w=0.5u l=0.45u m=1
MOCa_MXP_S1_21_1 OCa_MXP_n0_43 OCa_bp1 OCa_MXP_n1_21 vss sg13_hv_nmos w=0.5u l=0.45u m=1
MOCa_MXP_S1_22_0 OCa_MXP_n0_44 OCa_bbp1 OCa_MXP_n1_22 vss sg13_hv_nmos w=0.5u l=0.45u m=1
MOCa_MXP_S1_22_1 OCa_MXP_n0_45 OCa_bp1 OCa_MXP_n1_22 vss sg13_hv_nmos w=0.5u l=0.45u m=1
MOCa_MXP_S1_23_0 OCa_MXP_n0_46 OCa_bbp1 OCa_MXP_n1_23 vss sg13_hv_nmos w=0.5u l=0.45u m=1
MOCa_MXP_S1_23_1 OCa_MXP_n0_47 OCa_bp1 OCa_MXP_n1_23 vss sg13_hv_nmos w=0.5u l=0.45u m=1
MOCa_MXP_S1_24_0 OCa_MXP_n0_48 OCa_bbp1 OCa_MXP_n1_24 vss sg13_hv_nmos w=0.5u l=0.45u m=1
MOCa_MXP_S1_24_1 OCa_MXP_n0_49 OCa_bp1 OCa_MXP_n1_24 vss sg13_hv_nmos w=0.5u l=0.45u m=1
MOCa_MXP_S1_25_0 OCa_MXP_n0_50 OCa_bbp1 OCa_MXP_n1_25 vss sg13_hv_nmos w=0.5u l=0.45u m=1
MOCa_MXP_S1_25_1 OCa_MXP_n0_51 OCa_bp1 OCa_MXP_n1_25 vss sg13_hv_nmos w=0.5u l=0.45u m=1
MOCa_MXP_S1_26_0 OCa_MXP_n0_52 OCa_bbp1 OCa_MXP_n1_26 vss sg13_hv_nmos w=0.5u l=0.45u m=1
MOCa_MXP_S1_26_1 OCa_MXP_n0_53 OCa_bp1 OCa_MXP_n1_26 vss sg13_hv_nmos w=0.5u l=0.45u m=1
MOCa_MXP_S1_27_0 OCa_MXP_n0_54 OCa_bbp1 OCa_MXP_n1_27 vss sg13_hv_nmos w=0.5u l=0.45u m=1
MOCa_MXP_S1_27_1 OCa_MXP_n0_55 OCa_bp1 OCa_MXP_n1_27 vss sg13_hv_nmos w=0.5u l=0.45u m=1
MOCa_MXP_S1_28_0 OCa_MXP_n0_56 OCa_bbp1 OCa_MXP_n1_28 vss sg13_hv_nmos w=0.5u l=0.45u m=1
MOCa_MXP_S1_28_1 OCa_MXP_n0_57 OCa_bp1 OCa_MXP_n1_28 vss sg13_hv_nmos w=0.5u l=0.45u m=1
MOCa_MXP_S1_29_0 OCa_MXP_n0_58 OCa_bbp1 OCa_MXP_n1_29 vss sg13_hv_nmos w=0.5u l=0.45u m=1
MOCa_MXP_S1_29_1 OCa_MXP_n0_59 OCa_bp1 OCa_MXP_n1_29 vss sg13_hv_nmos w=0.5u l=0.45u m=1
MOCa_MXP_S1_30_0 OCa_MXP_n0_60 OCa_bbp1 OCa_MXP_n1_30 vss sg13_hv_nmos w=0.5u l=0.45u m=1
MOCa_MXP_S1_30_1 OCa_MXP_n0_61 OCa_bp1 OCa_MXP_n1_30 vss sg13_hv_nmos w=0.5u l=0.45u m=1
MOCa_MXP_S1_31_0 OCa_MXP_n0_62 OCa_bbp1 OCa_MXP_n1_31 vss sg13_hv_nmos w=0.5u l=0.45u m=1
MOCa_MXP_S1_31_1 OCa_MXP_n0_63 OCa_bp1 OCa_MXP_n1_31 vss sg13_hv_nmos w=0.5u l=0.45u m=1
MOCa_MXP_S1_32_0 OCa_MXP_n0_64 OCa_bbp1 OCa_MXP_n1_32 vss sg13_hv_nmos w=0.5u l=0.45u m=1
MOCa_MXP_S1_32_1 OCa_MXP_n0_65 OCa_bp1 OCa_MXP_n1_32 vss sg13_hv_nmos w=0.5u l=0.45u m=1
MOCa_MXP_S1_33_0 OCa_MXP_n0_66 OCa_bbp1 OCa_MXP_n1_33 vss sg13_hv_nmos w=0.5u l=0.45u m=1
MOCa_MXP_S1_33_1 OCa_MXP_n0_67 OCa_bp1 OCa_MXP_n1_33 vss sg13_hv_nmos w=0.5u l=0.45u m=1
MOCa_MXP_S1_34_0 OCa_MXP_n0_68 OCa_bbp1 OCa_MXP_n1_34 vss sg13_hv_nmos w=0.5u l=0.45u m=1
MOCa_MXP_S1_34_1 OCa_MXP_n0_69 OCa_bp1 OCa_MXP_n1_34 vss sg13_hv_nmos w=0.5u l=0.45u m=1
MOCa_MXP_S1_35_0 OCa_MXP_n0_70 OCa_bbp1 OCa_MXP_n1_35 vss sg13_hv_nmos w=0.5u l=0.45u m=1
MOCa_MXP_S1_35_1 OCa_MXP_n0_71 OCa_bp1 OCa_MXP_n1_35 vss sg13_hv_nmos w=0.5u l=0.45u m=1
MOCa_MXP_S1_36_0 OCa_MXP_n0_72 OCa_bbp1 OCa_MXP_n1_36 vss sg13_hv_nmos w=0.5u l=0.45u m=1
MOCa_MXP_S1_36_1 OCa_MXP_n0_73 OCa_bp1 OCa_MXP_n1_36 vss sg13_hv_nmos w=0.5u l=0.45u m=1
MOCa_MXP_S1_37_0 OCa_MXP_n0_74 OCa_bbp1 OCa_MXP_n1_37 vss sg13_hv_nmos w=0.5u l=0.45u m=1
MOCa_MXP_S1_37_1 OCa_MXP_n0_75 OCa_bp1 OCa_MXP_n1_37 vss sg13_hv_nmos w=0.5u l=0.45u m=1
MOCa_MXP_S1_38_0 OCa_MXP_n0_76 OCa_bbp1 OCa_MXP_n1_38 vss sg13_hv_nmos w=0.5u l=0.45u m=1
MOCa_MXP_S1_38_1 OCa_MXP_n0_77 OCa_bp1 OCa_MXP_n1_38 vss sg13_hv_nmos w=0.5u l=0.45u m=1
MOCa_MXP_S1_39_0 OCa_MXP_n0_78 OCa_bbp1 OCa_MXP_n1_39 vss sg13_hv_nmos w=0.5u l=0.45u m=1
MOCa_MXP_S1_39_1 OCa_MXP_n0_79 OCa_bp1 OCa_MXP_n1_39 vss sg13_hv_nmos w=0.5u l=0.45u m=1
MOCa_MXP_S1_40_0 OCa_MXP_n0_80 OCa_bbp1 OCa_MXP_n1_40 vss sg13_hv_nmos w=0.5u l=0.45u m=1
MOCa_MXP_S1_40_1 OCa_MXP_n0_81 OCa_bp1 OCa_MXP_n1_40 vss sg13_hv_nmos w=0.5u l=0.45u m=1
MOCa_MXP_S1_41_0 OCa_MXP_n0_82 OCa_bbp1 OCa_MXP_n1_41 vss sg13_hv_nmos w=0.5u l=0.45u m=1
MOCa_MXP_S1_41_1 OCa_MXP_n0_83 OCa_bp1 OCa_MXP_n1_41 vss sg13_hv_nmos w=0.5u l=0.45u m=1
MOCa_MXP_S1_42_0 OCa_MXP_n0_84 OCa_bbp1 OCa_MXP_n1_42 vss sg13_hv_nmos w=0.5u l=0.45u m=1
MOCa_MXP_S1_42_1 OCa_MXP_n0_85 OCa_bp1 OCa_MXP_n1_42 vss sg13_hv_nmos w=0.5u l=0.45u m=1
MOCa_MXP_S1_43_0 OCa_MXP_n0_86 OCa_bbp1 OCa_MXP_n1_43 vss sg13_hv_nmos w=0.5u l=0.45u m=1
MOCa_MXP_S1_43_1 OCa_MXP_n0_87 OCa_bp1 OCa_MXP_n1_43 vss sg13_hv_nmos w=0.5u l=0.45u m=1
MOCa_MXP_S1_44_0 OCa_MXP_n0_88 OCa_bbp1 OCa_MXP_n1_44 vss sg13_hv_nmos w=0.5u l=0.45u m=1
MOCa_MXP_S1_44_1 OCa_MXP_n0_89 OCa_bp1 OCa_MXP_n1_44 vss sg13_hv_nmos w=0.5u l=0.45u m=1
MOCa_MXP_S1_45_0 OCa_MXP_n0_90 OCa_bbp1 OCa_MXP_n1_45 vss sg13_hv_nmos w=0.5u l=0.45u m=1
MOCa_MXP_S1_45_1 OCa_MXP_n0_91 OCa_bp1 OCa_MXP_n1_45 vss sg13_hv_nmos w=0.5u l=0.45u m=1
MOCa_MXP_S1_46_0 OCa_MXP_n0_92 OCa_bbp1 OCa_MXP_n1_46 vss sg13_hv_nmos w=0.5u l=0.45u m=1
MOCa_MXP_S1_46_1 OCa_MXP_n0_93 OCa_bp1 OCa_MXP_n1_46 vss sg13_hv_nmos w=0.5u l=0.45u m=1
MOCa_MXP_S1_47_0 OCa_MXP_n0_94 OCa_bbp1 OCa_MXP_n1_47 vss sg13_hv_nmos w=0.5u l=0.45u m=1
MOCa_MXP_S1_47_1 OCa_MXP_n0_95 OCa_bp1 OCa_MXP_n1_47 vss sg13_hv_nmos w=0.5u l=0.45u m=1
MOCa_MXP_S1_48_0 OCa_MXP_n0_96 OCa_bbp1 OCa_MXP_n1_48 vss sg13_hv_nmos w=0.5u l=0.45u m=1
MOCa_MXP_S1_48_1 OCa_MXP_n0_97 OCa_bp1 OCa_MXP_n1_48 vss sg13_hv_nmos w=0.5u l=0.45u m=1
MOCa_MXP_S1_49_0 OCa_MXP_n0_98 OCa_bbp1 OCa_MXP_n1_49 vss sg13_hv_nmos w=0.5u l=0.45u m=1
MOCa_MXP_S1_49_1 OCa_MXP_n0_99 OCa_bp1 OCa_MXP_n1_49 vss sg13_hv_nmos w=0.5u l=0.45u m=1
MOCa_MXP_S1_50_0 OCa_MXP_n0_100 OCa_bbp1 OCa_MXP_n1_50 vss sg13_hv_nmos w=0.5u l=0.45u m=1
MOCa_MXP_S1_50_1 OCa_MXP_n0_101 OCa_bp1 OCa_MXP_n1_50 vss sg13_hv_nmos w=0.5u l=0.45u m=1
MOCa_MXP_S1_51_0 OCa_MXP_n0_102 OCa_bbp1 OCa_MXP_n1_51 vss sg13_hv_nmos w=0.5u l=0.45u m=1
MOCa_MXP_S1_51_1 OCa_MXP_n0_103 OCa_bp1 OCa_MXP_n1_51 vss sg13_hv_nmos w=0.5u l=0.45u m=1
MOCa_MXP_S1_52_0 OCa_MXP_n0_104 OCa_bbp1 OCa_MXP_n1_52 vss sg13_hv_nmos w=0.5u l=0.45u m=1
MOCa_MXP_S1_52_1 OCa_MXP_n0_105 OCa_bp1 OCa_MXP_n1_52 vss sg13_hv_nmos w=0.5u l=0.45u m=1
MOCa_MXP_S1_53_0 OCa_MXP_n0_106 OCa_bbp1 OCa_MXP_n1_53 vss sg13_hv_nmos w=0.5u l=0.45u m=1
MOCa_MXP_S1_53_1 OCa_MXP_n0_107 OCa_bp1 OCa_MXP_n1_53 vss sg13_hv_nmos w=0.5u l=0.45u m=1
MOCa_MXP_S1_54_0 OCa_MXP_n0_108 OCa_bbp1 OCa_MXP_n1_54 vss sg13_hv_nmos w=0.5u l=0.45u m=1
MOCa_MXP_S1_54_1 OCa_MXP_n0_109 OCa_bp1 OCa_MXP_n1_54 vss sg13_hv_nmos w=0.5u l=0.45u m=1
MOCa_MXP_S1_55_0 OCa_MXP_n0_110 OCa_bbp1 OCa_MXP_n1_55 vss sg13_hv_nmos w=0.5u l=0.45u m=1
MOCa_MXP_S1_55_1 OCa_MXP_n0_111 OCa_bp1 OCa_MXP_n1_55 vss sg13_hv_nmos w=0.5u l=0.45u m=1
MOCa_MXP_S1_56_0 OCa_MXP_n0_112 OCa_bbp1 OCa_MXP_n1_56 vss sg13_hv_nmos w=0.5u l=0.45u m=1
MOCa_MXP_S1_56_1 OCa_MXP_n0_113 OCa_bp1 OCa_MXP_n1_56 vss sg13_hv_nmos w=0.5u l=0.45u m=1
MOCa_MXP_S1_57_0 OCa_MXP_n0_114 OCa_bbp1 OCa_MXP_n1_57 vss sg13_hv_nmos w=0.5u l=0.45u m=1
MOCa_MXP_S1_57_1 OCa_MXP_n0_115 OCa_bp1 OCa_MXP_n1_57 vss sg13_hv_nmos w=0.5u l=0.45u m=1
MOCa_MXP_S1_58_0 OCa_MXP_n0_116 OCa_bbp1 OCa_MXP_n1_58 vss sg13_hv_nmos w=0.5u l=0.45u m=1
MOCa_MXP_S1_58_1 OCa_MXP_n0_117 OCa_bp1 OCa_MXP_n1_58 vss sg13_hv_nmos w=0.5u l=0.45u m=1
MOCa_MXP_S1_59_0 OCa_MXP_n0_118 OCa_bbp1 OCa_MXP_n1_59 vss sg13_hv_nmos w=0.5u l=0.45u m=1
MOCa_MXP_S1_59_1 OCa_MXP_n0_119 OCa_bp1 OCa_MXP_n1_59 vss sg13_hv_nmos w=0.5u l=0.45u m=1
MOCa_MXP_S1_60_0 OCa_MXP_n0_120 OCa_bbp1 OCa_MXP_n1_60 vss sg13_hv_nmos w=0.5u l=0.45u m=1
MOCa_MXP_S1_60_1 OCa_MXP_n0_121 OCa_bp1 OCa_MXP_n1_60 vss sg13_hv_nmos w=0.5u l=0.45u m=1
MOCa_MXP_S1_61_0 OCa_MXP_n0_122 OCa_bbp1 OCa_MXP_n1_61 vss sg13_hv_nmos w=0.5u l=0.45u m=1
MOCa_MXP_S1_61_1 OCa_MXP_n0_123 OCa_bp1 OCa_MXP_n1_61 vss sg13_hv_nmos w=0.5u l=0.45u m=1
MOCa_MXP_S1_62_0 OCa_MXP_n0_124 OCa_bbp1 OCa_MXP_n1_62 vss sg13_hv_nmos w=0.5u l=0.45u m=1
MOCa_MXP_S1_62_1 OCa_MXP_n0_125 OCa_bp1 OCa_MXP_n1_62 vss sg13_hv_nmos w=0.5u l=0.45u m=1
MOCa_MXP_S1_63_0 OCa_MXP_n0_126 OCa_bbp1 OCa_MXP_n1_63 vss sg13_hv_nmos w=0.5u l=0.45u m=1
MOCa_MXP_S1_63_1 OCa_MXP_n0_127 OCa_bp1 OCa_MXP_n1_63 vss sg13_hv_nmos w=0.5u l=0.45u m=1
MOCa_MXP_S2_0_0 OCa_MXP_n1_0 OCa_bbp2 OCa_MXP_n2_0 vss sg13_hv_nmos w=0.5u l=0.45u m=1
MOCa_MXP_S2_0_1 OCa_MXP_n1_1 OCa_bp2 OCa_MXP_n2_0 vss sg13_hv_nmos w=0.5u l=0.45u m=1
MOCa_MXP_S2_1_0 OCa_MXP_n1_2 OCa_bbp2 OCa_MXP_n2_1 vss sg13_hv_nmos w=0.5u l=0.45u m=1
MOCa_MXP_S2_1_1 OCa_MXP_n1_3 OCa_bp2 OCa_MXP_n2_1 vss sg13_hv_nmos w=0.5u l=0.45u m=1
MOCa_MXP_S2_2_0 OCa_MXP_n1_4 OCa_bbp2 OCa_MXP_n2_2 vss sg13_hv_nmos w=0.5u l=0.45u m=1
MOCa_MXP_S2_2_1 OCa_MXP_n1_5 OCa_bp2 OCa_MXP_n2_2 vss sg13_hv_nmos w=0.5u l=0.45u m=1
MOCa_MXP_S2_3_0 OCa_MXP_n1_6 OCa_bbp2 OCa_MXP_n2_3 vss sg13_hv_nmos w=0.5u l=0.45u m=1
MOCa_MXP_S2_3_1 OCa_MXP_n1_7 OCa_bp2 OCa_MXP_n2_3 vss sg13_hv_nmos w=0.5u l=0.45u m=1
MOCa_MXP_S2_4_0 OCa_MXP_n1_8 OCa_bbp2 OCa_MXP_n2_4 vss sg13_hv_nmos w=0.5u l=0.45u m=1
MOCa_MXP_S2_4_1 OCa_MXP_n1_9 OCa_bp2 OCa_MXP_n2_4 vss sg13_hv_nmos w=0.5u l=0.45u m=1
MOCa_MXP_S2_5_0 OCa_MXP_n1_10 OCa_bbp2 OCa_MXP_n2_5 vss sg13_hv_nmos w=0.5u l=0.45u m=1
MOCa_MXP_S2_5_1 OCa_MXP_n1_11 OCa_bp2 OCa_MXP_n2_5 vss sg13_hv_nmos w=0.5u l=0.45u m=1
MOCa_MXP_S2_6_0 OCa_MXP_n1_12 OCa_bbp2 OCa_MXP_n2_6 vss sg13_hv_nmos w=0.5u l=0.45u m=1
MOCa_MXP_S2_6_1 OCa_MXP_n1_13 OCa_bp2 OCa_MXP_n2_6 vss sg13_hv_nmos w=0.5u l=0.45u m=1
MOCa_MXP_S2_7_0 OCa_MXP_n1_14 OCa_bbp2 OCa_MXP_n2_7 vss sg13_hv_nmos w=0.5u l=0.45u m=1
MOCa_MXP_S2_7_1 OCa_MXP_n1_15 OCa_bp2 OCa_MXP_n2_7 vss sg13_hv_nmos w=0.5u l=0.45u m=1
MOCa_MXP_S2_8_0 OCa_MXP_n1_16 OCa_bbp2 OCa_MXP_n2_8 vss sg13_hv_nmos w=0.5u l=0.45u m=1
MOCa_MXP_S2_8_1 OCa_MXP_n1_17 OCa_bp2 OCa_MXP_n2_8 vss sg13_hv_nmos w=0.5u l=0.45u m=1
MOCa_MXP_S2_9_0 OCa_MXP_n1_18 OCa_bbp2 OCa_MXP_n2_9 vss sg13_hv_nmos w=0.5u l=0.45u m=1
MOCa_MXP_S2_9_1 OCa_MXP_n1_19 OCa_bp2 OCa_MXP_n2_9 vss sg13_hv_nmos w=0.5u l=0.45u m=1
MOCa_MXP_S2_10_0 OCa_MXP_n1_20 OCa_bbp2 OCa_MXP_n2_10 vss sg13_hv_nmos w=0.5u l=0.45u m=1
MOCa_MXP_S2_10_1 OCa_MXP_n1_21 OCa_bp2 OCa_MXP_n2_10 vss sg13_hv_nmos w=0.5u l=0.45u m=1
MOCa_MXP_S2_11_0 OCa_MXP_n1_22 OCa_bbp2 OCa_MXP_n2_11 vss sg13_hv_nmos w=0.5u l=0.45u m=1
MOCa_MXP_S2_11_1 OCa_MXP_n1_23 OCa_bp2 OCa_MXP_n2_11 vss sg13_hv_nmos w=0.5u l=0.45u m=1
MOCa_MXP_S2_12_0 OCa_MXP_n1_24 OCa_bbp2 OCa_MXP_n2_12 vss sg13_hv_nmos w=0.5u l=0.45u m=1
MOCa_MXP_S2_12_1 OCa_MXP_n1_25 OCa_bp2 OCa_MXP_n2_12 vss sg13_hv_nmos w=0.5u l=0.45u m=1
MOCa_MXP_S2_13_0 OCa_MXP_n1_26 OCa_bbp2 OCa_MXP_n2_13 vss sg13_hv_nmos w=0.5u l=0.45u m=1
MOCa_MXP_S2_13_1 OCa_MXP_n1_27 OCa_bp2 OCa_MXP_n2_13 vss sg13_hv_nmos w=0.5u l=0.45u m=1
MOCa_MXP_S2_14_0 OCa_MXP_n1_28 OCa_bbp2 OCa_MXP_n2_14 vss sg13_hv_nmos w=0.5u l=0.45u m=1
MOCa_MXP_S2_14_1 OCa_MXP_n1_29 OCa_bp2 OCa_MXP_n2_14 vss sg13_hv_nmos w=0.5u l=0.45u m=1
MOCa_MXP_S2_15_0 OCa_MXP_n1_30 OCa_bbp2 OCa_MXP_n2_15 vss sg13_hv_nmos w=0.5u l=0.45u m=1
MOCa_MXP_S2_15_1 OCa_MXP_n1_31 OCa_bp2 OCa_MXP_n2_15 vss sg13_hv_nmos w=0.5u l=0.45u m=1
MOCa_MXP_S2_16_0 OCa_MXP_n1_32 OCa_bbp2 OCa_MXP_n2_16 vss sg13_hv_nmos w=0.5u l=0.45u m=1
MOCa_MXP_S2_16_1 OCa_MXP_n1_33 OCa_bp2 OCa_MXP_n2_16 vss sg13_hv_nmos w=0.5u l=0.45u m=1
MOCa_MXP_S2_17_0 OCa_MXP_n1_34 OCa_bbp2 OCa_MXP_n2_17 vss sg13_hv_nmos w=0.5u l=0.45u m=1
MOCa_MXP_S2_17_1 OCa_MXP_n1_35 OCa_bp2 OCa_MXP_n2_17 vss sg13_hv_nmos w=0.5u l=0.45u m=1
MOCa_MXP_S2_18_0 OCa_MXP_n1_36 OCa_bbp2 OCa_MXP_n2_18 vss sg13_hv_nmos w=0.5u l=0.45u m=1
MOCa_MXP_S2_18_1 OCa_MXP_n1_37 OCa_bp2 OCa_MXP_n2_18 vss sg13_hv_nmos w=0.5u l=0.45u m=1
MOCa_MXP_S2_19_0 OCa_MXP_n1_38 OCa_bbp2 OCa_MXP_n2_19 vss sg13_hv_nmos w=0.5u l=0.45u m=1
MOCa_MXP_S2_19_1 OCa_MXP_n1_39 OCa_bp2 OCa_MXP_n2_19 vss sg13_hv_nmos w=0.5u l=0.45u m=1
MOCa_MXP_S2_20_0 OCa_MXP_n1_40 OCa_bbp2 OCa_MXP_n2_20 vss sg13_hv_nmos w=0.5u l=0.45u m=1
MOCa_MXP_S2_20_1 OCa_MXP_n1_41 OCa_bp2 OCa_MXP_n2_20 vss sg13_hv_nmos w=0.5u l=0.45u m=1
MOCa_MXP_S2_21_0 OCa_MXP_n1_42 OCa_bbp2 OCa_MXP_n2_21 vss sg13_hv_nmos w=0.5u l=0.45u m=1
MOCa_MXP_S2_21_1 OCa_MXP_n1_43 OCa_bp2 OCa_MXP_n2_21 vss sg13_hv_nmos w=0.5u l=0.45u m=1
MOCa_MXP_S2_22_0 OCa_MXP_n1_44 OCa_bbp2 OCa_MXP_n2_22 vss sg13_hv_nmos w=0.5u l=0.45u m=1
MOCa_MXP_S2_22_1 OCa_MXP_n1_45 OCa_bp2 OCa_MXP_n2_22 vss sg13_hv_nmos w=0.5u l=0.45u m=1
MOCa_MXP_S2_23_0 OCa_MXP_n1_46 OCa_bbp2 OCa_MXP_n2_23 vss sg13_hv_nmos w=0.5u l=0.45u m=1
MOCa_MXP_S2_23_1 OCa_MXP_n1_47 OCa_bp2 OCa_MXP_n2_23 vss sg13_hv_nmos w=0.5u l=0.45u m=1
MOCa_MXP_S2_24_0 OCa_MXP_n1_48 OCa_bbp2 OCa_MXP_n2_24 vss sg13_hv_nmos w=0.5u l=0.45u m=1
MOCa_MXP_S2_24_1 OCa_MXP_n1_49 OCa_bp2 OCa_MXP_n2_24 vss sg13_hv_nmos w=0.5u l=0.45u m=1
MOCa_MXP_S2_25_0 OCa_MXP_n1_50 OCa_bbp2 OCa_MXP_n2_25 vss sg13_hv_nmos w=0.5u l=0.45u m=1
MOCa_MXP_S2_25_1 OCa_MXP_n1_51 OCa_bp2 OCa_MXP_n2_25 vss sg13_hv_nmos w=0.5u l=0.45u m=1
MOCa_MXP_S2_26_0 OCa_MXP_n1_52 OCa_bbp2 OCa_MXP_n2_26 vss sg13_hv_nmos w=0.5u l=0.45u m=1
MOCa_MXP_S2_26_1 OCa_MXP_n1_53 OCa_bp2 OCa_MXP_n2_26 vss sg13_hv_nmos w=0.5u l=0.45u m=1
MOCa_MXP_S2_27_0 OCa_MXP_n1_54 OCa_bbp2 OCa_MXP_n2_27 vss sg13_hv_nmos w=0.5u l=0.45u m=1
MOCa_MXP_S2_27_1 OCa_MXP_n1_55 OCa_bp2 OCa_MXP_n2_27 vss sg13_hv_nmos w=0.5u l=0.45u m=1
MOCa_MXP_S2_28_0 OCa_MXP_n1_56 OCa_bbp2 OCa_MXP_n2_28 vss sg13_hv_nmos w=0.5u l=0.45u m=1
MOCa_MXP_S2_28_1 OCa_MXP_n1_57 OCa_bp2 OCa_MXP_n2_28 vss sg13_hv_nmos w=0.5u l=0.45u m=1
MOCa_MXP_S2_29_0 OCa_MXP_n1_58 OCa_bbp2 OCa_MXP_n2_29 vss sg13_hv_nmos w=0.5u l=0.45u m=1
MOCa_MXP_S2_29_1 OCa_MXP_n1_59 OCa_bp2 OCa_MXP_n2_29 vss sg13_hv_nmos w=0.5u l=0.45u m=1
MOCa_MXP_S2_30_0 OCa_MXP_n1_60 OCa_bbp2 OCa_MXP_n2_30 vss sg13_hv_nmos w=0.5u l=0.45u m=1
MOCa_MXP_S2_30_1 OCa_MXP_n1_61 OCa_bp2 OCa_MXP_n2_30 vss sg13_hv_nmos w=0.5u l=0.45u m=1
MOCa_MXP_S2_31_0 OCa_MXP_n1_62 OCa_bbp2 OCa_MXP_n2_31 vss sg13_hv_nmos w=0.5u l=0.45u m=1
MOCa_MXP_S2_31_1 OCa_MXP_n1_63 OCa_bp2 OCa_MXP_n2_31 vss sg13_hv_nmos w=0.5u l=0.45u m=1
MOCa_MXP_S3_0_0 OCa_MXP_n2_0 OCa_bbp3 OCa_MXP_n3_0 vss sg13_hv_nmos w=0.5u l=0.45u m=1
MOCa_MXP_S3_0_1 OCa_MXP_n2_1 OCa_bp3 OCa_MXP_n3_0 vss sg13_hv_nmos w=0.5u l=0.45u m=1
MOCa_MXP_S3_1_0 OCa_MXP_n2_2 OCa_bbp3 OCa_MXP_n3_1 vss sg13_hv_nmos w=0.5u l=0.45u m=1
MOCa_MXP_S3_1_1 OCa_MXP_n2_3 OCa_bp3 OCa_MXP_n3_1 vss sg13_hv_nmos w=0.5u l=0.45u m=1
MOCa_MXP_S3_2_0 OCa_MXP_n2_4 OCa_bbp3 OCa_MXP_n3_2 vss sg13_hv_nmos w=0.5u l=0.45u m=1
MOCa_MXP_S3_2_1 OCa_MXP_n2_5 OCa_bp3 OCa_MXP_n3_2 vss sg13_hv_nmos w=0.5u l=0.45u m=1
MOCa_MXP_S3_3_0 OCa_MXP_n2_6 OCa_bbp3 OCa_MXP_n3_3 vss sg13_hv_nmos w=0.5u l=0.45u m=1
MOCa_MXP_S3_3_1 OCa_MXP_n2_7 OCa_bp3 OCa_MXP_n3_3 vss sg13_hv_nmos w=0.5u l=0.45u m=1
MOCa_MXP_S3_4_0 OCa_MXP_n2_8 OCa_bbp3 OCa_MXP_n3_4 vss sg13_hv_nmos w=0.5u l=0.45u m=1
MOCa_MXP_S3_4_1 OCa_MXP_n2_9 OCa_bp3 OCa_MXP_n3_4 vss sg13_hv_nmos w=0.5u l=0.45u m=1
MOCa_MXP_S3_5_0 OCa_MXP_n2_10 OCa_bbp3 OCa_MXP_n3_5 vss sg13_hv_nmos w=0.5u l=0.45u m=1
MOCa_MXP_S3_5_1 OCa_MXP_n2_11 OCa_bp3 OCa_MXP_n3_5 vss sg13_hv_nmos w=0.5u l=0.45u m=1
MOCa_MXP_S3_6_0 OCa_MXP_n2_12 OCa_bbp3 OCa_MXP_n3_6 vss sg13_hv_nmos w=0.5u l=0.45u m=1
MOCa_MXP_S3_6_1 OCa_MXP_n2_13 OCa_bp3 OCa_MXP_n3_6 vss sg13_hv_nmos w=0.5u l=0.45u m=1
MOCa_MXP_S3_7_0 OCa_MXP_n2_14 OCa_bbp3 OCa_MXP_n3_7 vss sg13_hv_nmos w=0.5u l=0.45u m=1
MOCa_MXP_S3_7_1 OCa_MXP_n2_15 OCa_bp3 OCa_MXP_n3_7 vss sg13_hv_nmos w=0.5u l=0.45u m=1
MOCa_MXP_S3_8_0 OCa_MXP_n2_16 OCa_bbp3 OCa_MXP_n3_8 vss sg13_hv_nmos w=0.5u l=0.45u m=1
MOCa_MXP_S3_8_1 OCa_MXP_n2_17 OCa_bp3 OCa_MXP_n3_8 vss sg13_hv_nmos w=0.5u l=0.45u m=1
MOCa_MXP_S3_9_0 OCa_MXP_n2_18 OCa_bbp3 OCa_MXP_n3_9 vss sg13_hv_nmos w=0.5u l=0.45u m=1
MOCa_MXP_S3_9_1 OCa_MXP_n2_19 OCa_bp3 OCa_MXP_n3_9 vss sg13_hv_nmos w=0.5u l=0.45u m=1
MOCa_MXP_S3_10_0 OCa_MXP_n2_20 OCa_bbp3 OCa_MXP_n3_10 vss sg13_hv_nmos w=0.5u l=0.45u m=1
MOCa_MXP_S3_10_1 OCa_MXP_n2_21 OCa_bp3 OCa_MXP_n3_10 vss sg13_hv_nmos w=0.5u l=0.45u m=1
MOCa_MXP_S3_11_0 OCa_MXP_n2_22 OCa_bbp3 OCa_MXP_n3_11 vss sg13_hv_nmos w=0.5u l=0.45u m=1
MOCa_MXP_S3_11_1 OCa_MXP_n2_23 OCa_bp3 OCa_MXP_n3_11 vss sg13_hv_nmos w=0.5u l=0.45u m=1
MOCa_MXP_S3_12_0 OCa_MXP_n2_24 OCa_bbp3 OCa_MXP_n3_12 vss sg13_hv_nmos w=0.5u l=0.45u m=1
MOCa_MXP_S3_12_1 OCa_MXP_n2_25 OCa_bp3 OCa_MXP_n3_12 vss sg13_hv_nmos w=0.5u l=0.45u m=1
MOCa_MXP_S3_13_0 OCa_MXP_n2_26 OCa_bbp3 OCa_MXP_n3_13 vss sg13_hv_nmos w=0.5u l=0.45u m=1
MOCa_MXP_S3_13_1 OCa_MXP_n2_27 OCa_bp3 OCa_MXP_n3_13 vss sg13_hv_nmos w=0.5u l=0.45u m=1
MOCa_MXP_S3_14_0 OCa_MXP_n2_28 OCa_bbp3 OCa_MXP_n3_14 vss sg13_hv_nmos w=0.5u l=0.45u m=1
MOCa_MXP_S3_14_1 OCa_MXP_n2_29 OCa_bp3 OCa_MXP_n3_14 vss sg13_hv_nmos w=0.5u l=0.45u m=1
MOCa_MXP_S3_15_0 OCa_MXP_n2_30 OCa_bbp3 OCa_MXP_n3_15 vss sg13_hv_nmos w=0.5u l=0.45u m=1
MOCa_MXP_S3_15_1 OCa_MXP_n2_31 OCa_bp3 OCa_MXP_n3_15 vss sg13_hv_nmos w=0.5u l=0.45u m=1
MOCa_MXP_S4_0_0 OCa_MXP_n3_0 OCa_bbp4 OCa_MXP_n4_0 vss sg13_hv_nmos w=0.5u l=0.45u m=1
MOCa_MXP_S4_0_1 OCa_MXP_n3_1 OCa_bp4 OCa_MXP_n4_0 vss sg13_hv_nmos w=0.5u l=0.45u m=1
MOCa_MXP_S4_1_0 OCa_MXP_n3_2 OCa_bbp4 OCa_MXP_n4_1 vss sg13_hv_nmos w=0.5u l=0.45u m=1
MOCa_MXP_S4_1_1 OCa_MXP_n3_3 OCa_bp4 OCa_MXP_n4_1 vss sg13_hv_nmos w=0.5u l=0.45u m=1
MOCa_MXP_S4_2_0 OCa_MXP_n3_4 OCa_bbp4 OCa_MXP_n4_2 vss sg13_hv_nmos w=0.5u l=0.45u m=1
MOCa_MXP_S4_2_1 OCa_MXP_n3_5 OCa_bp4 OCa_MXP_n4_2 vss sg13_hv_nmos w=0.5u l=0.45u m=1
MOCa_MXP_S4_3_0 OCa_MXP_n3_6 OCa_bbp4 OCa_MXP_n4_3 vss sg13_hv_nmos w=0.5u l=0.45u m=1
MOCa_MXP_S4_3_1 OCa_MXP_n3_7 OCa_bp4 OCa_MXP_n4_3 vss sg13_hv_nmos w=0.5u l=0.45u m=1
MOCa_MXP_S4_4_0 OCa_MXP_n3_8 OCa_bbp4 OCa_MXP_n4_4 vss sg13_hv_nmos w=0.5u l=0.45u m=1
MOCa_MXP_S4_4_1 OCa_MXP_n3_9 OCa_bp4 OCa_MXP_n4_4 vss sg13_hv_nmos w=0.5u l=0.45u m=1
MOCa_MXP_S4_5_0 OCa_MXP_n3_10 OCa_bbp4 OCa_MXP_n4_5 vss sg13_hv_nmos w=0.5u l=0.45u m=1
MOCa_MXP_S4_5_1 OCa_MXP_n3_11 OCa_bp4 OCa_MXP_n4_5 vss sg13_hv_nmos w=0.5u l=0.45u m=1
MOCa_MXP_S4_6_0 OCa_MXP_n3_12 OCa_bbp4 OCa_MXP_n4_6 vss sg13_hv_nmos w=0.5u l=0.45u m=1
MOCa_MXP_S4_6_1 OCa_MXP_n3_13 OCa_bp4 OCa_MXP_n4_6 vss sg13_hv_nmos w=0.5u l=0.45u m=1
MOCa_MXP_S4_7_0 OCa_MXP_n3_14 OCa_bbp4 OCa_MXP_n4_7 vss sg13_hv_nmos w=0.5u l=0.45u m=1
MOCa_MXP_S4_7_1 OCa_MXP_n3_15 OCa_bp4 OCa_MXP_n4_7 vss sg13_hv_nmos w=0.5u l=0.45u m=1
MOCa_MXP_S5_0_0 OCa_MXP_n4_0 OCa_bbp5 OCa_MXP_n5_0 vss sg13_hv_nmos w=0.5u l=0.45u m=1
MOCa_MXP_S5_0_1 OCa_MXP_n4_1 OCa_bp5 OCa_MXP_n5_0 vss sg13_hv_nmos w=0.5u l=0.45u m=1
MOCa_MXP_S5_1_0 OCa_MXP_n4_2 OCa_bbp5 OCa_MXP_n5_1 vss sg13_hv_nmos w=0.5u l=0.45u m=1
MOCa_MXP_S5_1_1 OCa_MXP_n4_3 OCa_bp5 OCa_MXP_n5_1 vss sg13_hv_nmos w=0.5u l=0.45u m=1
MOCa_MXP_S5_2_0 OCa_MXP_n4_4 OCa_bbp5 OCa_MXP_n5_2 vss sg13_hv_nmos w=0.5u l=0.45u m=1
MOCa_MXP_S5_2_1 OCa_MXP_n4_5 OCa_bp5 OCa_MXP_n5_2 vss sg13_hv_nmos w=0.5u l=0.45u m=1
MOCa_MXP_S5_3_0 OCa_MXP_n4_6 OCa_bbp5 OCa_MXP_n5_3 vss sg13_hv_nmos w=0.5u l=0.45u m=1
MOCa_MXP_S5_3_1 OCa_MXP_n4_7 OCa_bp5 OCa_MXP_n5_3 vss sg13_hv_nmos w=0.5u l=0.45u m=1
MOCa_MXP_S6_0_0 OCa_MXP_n5_0 OCa_bbp6 OCa_MXP_n6_0 vss sg13_hv_nmos w=0.5u l=0.45u m=1
MOCa_MXP_S6_0_1 OCa_MXP_n5_1 OCa_bp6 OCa_MXP_n6_0 vss sg13_hv_nmos w=0.5u l=0.45u m=1
MOCa_MXP_S6_1_0 OCa_MXP_n5_2 OCa_bbp6 OCa_MXP_n6_1 vss sg13_hv_nmos w=0.5u l=0.45u m=1
MOCa_MXP_S6_1_1 OCa_MXP_n5_3 OCa_bp6 OCa_MXP_n6_1 vss sg13_hv_nmos w=0.5u l=0.45u m=1
MOCa_MXP_S7_0_0 OCa_MXP_n6_0 OCa_bbp7 OCa_refp vss sg13_hv_nmos w=0.5u l=0.45u m=1
MOCa_MXP_S7_0_1 OCa_MXP_n6_1 OCa_bp7 OCa_refp vss sg13_hv_nmos w=0.5u l=0.45u m=1
MOCa_MXN_S0_0_0 vss OCa_bbn0 OCa_MXN_n0_0 vss sg13_hv_nmos w=0.5u l=0.45u m=1
MOCa_MXN_S0_0_1 t1 OCa_bn0 OCa_MXN_n0_0 vss sg13_hv_nmos w=0.5u l=0.45u m=1
MOCa_MXN_S0_1_0 t2 OCa_bbn0 OCa_MXN_n0_1 vss sg13_hv_nmos w=0.5u l=0.45u m=1
MOCa_MXN_S0_1_1 t3 OCa_bn0 OCa_MXN_n0_1 vss sg13_hv_nmos w=0.5u l=0.45u m=1
MOCa_MXN_S0_2_0 t4 OCa_bbn0 OCa_MXN_n0_2 vss sg13_hv_nmos w=0.5u l=0.45u m=1
MOCa_MXN_S0_2_1 t5 OCa_bn0 OCa_MXN_n0_2 vss sg13_hv_nmos w=0.5u l=0.45u m=1
MOCa_MXN_S0_3_0 t6 OCa_bbn0 OCa_MXN_n0_3 vss sg13_hv_nmos w=0.5u l=0.45u m=1
MOCa_MXN_S0_3_1 t7 OCa_bn0 OCa_MXN_n0_3 vss sg13_hv_nmos w=0.5u l=0.45u m=1
MOCa_MXN_S0_4_0 t8 OCa_bbn0 OCa_MXN_n0_4 vss sg13_hv_nmos w=0.5u l=0.45u m=1
MOCa_MXN_S0_4_1 t9 OCa_bn0 OCa_MXN_n0_4 vss sg13_hv_nmos w=0.5u l=0.45u m=1
MOCa_MXN_S0_5_0 t10 OCa_bbn0 OCa_MXN_n0_5 vss sg13_hv_nmos w=0.5u l=0.45u m=1
MOCa_MXN_S0_5_1 t11 OCa_bn0 OCa_MXN_n0_5 vss sg13_hv_nmos w=0.5u l=0.45u m=1
MOCa_MXN_S0_6_0 t12 OCa_bbn0 OCa_MXN_n0_6 vss sg13_hv_nmos w=0.5u l=0.45u m=1
MOCa_MXN_S0_6_1 t13 OCa_bn0 OCa_MXN_n0_6 vss sg13_hv_nmos w=0.5u l=0.45u m=1
MOCa_MXN_S0_7_0 t14 OCa_bbn0 OCa_MXN_n0_7 vss sg13_hv_nmos w=0.5u l=0.45u m=1
MOCa_MXN_S0_7_1 t15 OCa_bn0 OCa_MXN_n0_7 vss sg13_hv_nmos w=0.5u l=0.45u m=1
MOCa_MXN_S0_8_0 t16 OCa_bbn0 OCa_MXN_n0_8 vss sg13_hv_nmos w=0.5u l=0.45u m=1
MOCa_MXN_S0_8_1 t17 OCa_bn0 OCa_MXN_n0_8 vss sg13_hv_nmos w=0.5u l=0.45u m=1
MOCa_MXN_S0_9_0 t18 OCa_bbn0 OCa_MXN_n0_9 vss sg13_hv_nmos w=0.5u l=0.45u m=1
MOCa_MXN_S0_9_1 t19 OCa_bn0 OCa_MXN_n0_9 vss sg13_hv_nmos w=0.5u l=0.45u m=1
MOCa_MXN_S0_10_0 t20 OCa_bbn0 OCa_MXN_n0_10 vss sg13_hv_nmos w=0.5u l=0.45u m=1
MOCa_MXN_S0_10_1 t21 OCa_bn0 OCa_MXN_n0_10 vss sg13_hv_nmos w=0.5u l=0.45u m=1
MOCa_MXN_S0_11_0 t22 OCa_bbn0 OCa_MXN_n0_11 vss sg13_hv_nmos w=0.5u l=0.45u m=1
MOCa_MXN_S0_11_1 t23 OCa_bn0 OCa_MXN_n0_11 vss sg13_hv_nmos w=0.5u l=0.45u m=1
MOCa_MXN_S0_12_0 t24 OCa_bbn0 OCa_MXN_n0_12 vss sg13_hv_nmos w=0.5u l=0.45u m=1
MOCa_MXN_S0_12_1 t25 OCa_bn0 OCa_MXN_n0_12 vss sg13_hv_nmos w=0.5u l=0.45u m=1
MOCa_MXN_S0_13_0 t26 OCa_bbn0 OCa_MXN_n0_13 vss sg13_hv_nmos w=0.5u l=0.45u m=1
MOCa_MXN_S0_13_1 t27 OCa_bn0 OCa_MXN_n0_13 vss sg13_hv_nmos w=0.5u l=0.45u m=1
MOCa_MXN_S0_14_0 t28 OCa_bbn0 OCa_MXN_n0_14 vss sg13_hv_nmos w=0.5u l=0.45u m=1
MOCa_MXN_S0_14_1 t29 OCa_bn0 OCa_MXN_n0_14 vss sg13_hv_nmos w=0.5u l=0.45u m=1
MOCa_MXN_S0_15_0 t30 OCa_bbn0 OCa_MXN_n0_15 vss sg13_hv_nmos w=0.5u l=0.45u m=1
MOCa_MXN_S0_15_1 t31 OCa_bn0 OCa_MXN_n0_15 vss sg13_hv_nmos w=0.5u l=0.45u m=1
MOCa_MXN_S0_16_0 t32 OCa_bbn0 OCa_MXN_n0_16 vss sg13_hv_nmos w=0.5u l=0.45u m=1
MOCa_MXN_S0_16_1 t33 OCa_bn0 OCa_MXN_n0_16 vss sg13_hv_nmos w=0.5u l=0.45u m=1
MOCa_MXN_S0_17_0 t34 OCa_bbn0 OCa_MXN_n0_17 vss sg13_hv_nmos w=0.5u l=0.45u m=1
MOCa_MXN_S0_17_1 t35 OCa_bn0 OCa_MXN_n0_17 vss sg13_hv_nmos w=0.5u l=0.45u m=1
MOCa_MXN_S0_18_0 t36 OCa_bbn0 OCa_MXN_n0_18 vss sg13_hv_nmos w=0.5u l=0.45u m=1
MOCa_MXN_S0_18_1 t37 OCa_bn0 OCa_MXN_n0_18 vss sg13_hv_nmos w=0.5u l=0.45u m=1
MOCa_MXN_S0_19_0 t38 OCa_bbn0 OCa_MXN_n0_19 vss sg13_hv_nmos w=0.5u l=0.45u m=1
MOCa_MXN_S0_19_1 t39 OCa_bn0 OCa_MXN_n0_19 vss sg13_hv_nmos w=0.5u l=0.45u m=1
MOCa_MXN_S0_20_0 t40 OCa_bbn0 OCa_MXN_n0_20 vss sg13_hv_nmos w=0.5u l=0.45u m=1
MOCa_MXN_S0_20_1 t41 OCa_bn0 OCa_MXN_n0_20 vss sg13_hv_nmos w=0.5u l=0.45u m=1
MOCa_MXN_S0_21_0 t42 OCa_bbn0 OCa_MXN_n0_21 vss sg13_hv_nmos w=0.5u l=0.45u m=1
MOCa_MXN_S0_21_1 t43 OCa_bn0 OCa_MXN_n0_21 vss sg13_hv_nmos w=0.5u l=0.45u m=1
MOCa_MXN_S0_22_0 t44 OCa_bbn0 OCa_MXN_n0_22 vss sg13_hv_nmos w=0.5u l=0.45u m=1
MOCa_MXN_S0_22_1 t45 OCa_bn0 OCa_MXN_n0_22 vss sg13_hv_nmos w=0.5u l=0.45u m=1
MOCa_MXN_S0_23_0 t46 OCa_bbn0 OCa_MXN_n0_23 vss sg13_hv_nmos w=0.5u l=0.45u m=1
MOCa_MXN_S0_23_1 t47 OCa_bn0 OCa_MXN_n0_23 vss sg13_hv_nmos w=0.5u l=0.45u m=1
MOCa_MXN_S0_24_0 t48 OCa_bbn0 OCa_MXN_n0_24 vss sg13_hv_nmos w=0.5u l=0.45u m=1
MOCa_MXN_S0_24_1 t49 OCa_bn0 OCa_MXN_n0_24 vss sg13_hv_nmos w=0.5u l=0.45u m=1
MOCa_MXN_S0_25_0 t50 OCa_bbn0 OCa_MXN_n0_25 vss sg13_hv_nmos w=0.5u l=0.45u m=1
MOCa_MXN_S0_25_1 t51 OCa_bn0 OCa_MXN_n0_25 vss sg13_hv_nmos w=0.5u l=0.45u m=1
MOCa_MXN_S0_26_0 t52 OCa_bbn0 OCa_MXN_n0_26 vss sg13_hv_nmos w=0.5u l=0.45u m=1
MOCa_MXN_S0_26_1 t53 OCa_bn0 OCa_MXN_n0_26 vss sg13_hv_nmos w=0.5u l=0.45u m=1
MOCa_MXN_S0_27_0 t54 OCa_bbn0 OCa_MXN_n0_27 vss sg13_hv_nmos w=0.5u l=0.45u m=1
MOCa_MXN_S0_27_1 t55 OCa_bn0 OCa_MXN_n0_27 vss sg13_hv_nmos w=0.5u l=0.45u m=1
MOCa_MXN_S0_28_0 t56 OCa_bbn0 OCa_MXN_n0_28 vss sg13_hv_nmos w=0.5u l=0.45u m=1
MOCa_MXN_S0_28_1 t57 OCa_bn0 OCa_MXN_n0_28 vss sg13_hv_nmos w=0.5u l=0.45u m=1
MOCa_MXN_S0_29_0 t58 OCa_bbn0 OCa_MXN_n0_29 vss sg13_hv_nmos w=0.5u l=0.45u m=1
MOCa_MXN_S0_29_1 t59 OCa_bn0 OCa_MXN_n0_29 vss sg13_hv_nmos w=0.5u l=0.45u m=1
MOCa_MXN_S0_30_0 t60 OCa_bbn0 OCa_MXN_n0_30 vss sg13_hv_nmos w=0.5u l=0.45u m=1
MOCa_MXN_S0_30_1 t61 OCa_bn0 OCa_MXN_n0_30 vss sg13_hv_nmos w=0.5u l=0.45u m=1
MOCa_MXN_S0_31_0 t62 OCa_bbn0 OCa_MXN_n0_31 vss sg13_hv_nmos w=0.5u l=0.45u m=1
MOCa_MXN_S0_31_1 t63 OCa_bn0 OCa_MXN_n0_31 vss sg13_hv_nmos w=0.5u l=0.45u m=1
MOCa_MXN_S0_32_0 t64 OCa_bbn0 OCa_MXN_n0_32 vss sg13_hv_nmos w=0.5u l=0.45u m=1
MOCa_MXN_S0_32_1 t65 OCa_bn0 OCa_MXN_n0_32 vss sg13_hv_nmos w=0.5u l=0.45u m=1
MOCa_MXN_S0_33_0 t66 OCa_bbn0 OCa_MXN_n0_33 vss sg13_hv_nmos w=0.5u l=0.45u m=1
MOCa_MXN_S0_33_1 t67 OCa_bn0 OCa_MXN_n0_33 vss sg13_hv_nmos w=0.5u l=0.45u m=1
MOCa_MXN_S0_34_0 t68 OCa_bbn0 OCa_MXN_n0_34 vss sg13_hv_nmos w=0.5u l=0.45u m=1
MOCa_MXN_S0_34_1 t69 OCa_bn0 OCa_MXN_n0_34 vss sg13_hv_nmos w=0.5u l=0.45u m=1
MOCa_MXN_S0_35_0 t70 OCa_bbn0 OCa_MXN_n0_35 vss sg13_hv_nmos w=0.5u l=0.45u m=1
MOCa_MXN_S0_35_1 t71 OCa_bn0 OCa_MXN_n0_35 vss sg13_hv_nmos w=0.5u l=0.45u m=1
MOCa_MXN_S0_36_0 t72 OCa_bbn0 OCa_MXN_n0_36 vss sg13_hv_nmos w=0.5u l=0.45u m=1
MOCa_MXN_S0_36_1 t73 OCa_bn0 OCa_MXN_n0_36 vss sg13_hv_nmos w=0.5u l=0.45u m=1
MOCa_MXN_S0_37_0 t74 OCa_bbn0 OCa_MXN_n0_37 vss sg13_hv_nmos w=0.5u l=0.45u m=1
MOCa_MXN_S0_37_1 t75 OCa_bn0 OCa_MXN_n0_37 vss sg13_hv_nmos w=0.5u l=0.45u m=1
MOCa_MXN_S0_38_0 t76 OCa_bbn0 OCa_MXN_n0_38 vss sg13_hv_nmos w=0.5u l=0.45u m=1
MOCa_MXN_S0_38_1 t77 OCa_bn0 OCa_MXN_n0_38 vss sg13_hv_nmos w=0.5u l=0.45u m=1
MOCa_MXN_S0_39_0 t78 OCa_bbn0 OCa_MXN_n0_39 vss sg13_hv_nmos w=0.5u l=0.45u m=1
MOCa_MXN_S0_39_1 t79 OCa_bn0 OCa_MXN_n0_39 vss sg13_hv_nmos w=0.5u l=0.45u m=1
MOCa_MXN_S0_40_0 t80 OCa_bbn0 OCa_MXN_n0_40 vss sg13_hv_nmos w=0.5u l=0.45u m=1
MOCa_MXN_S0_40_1 t81 OCa_bn0 OCa_MXN_n0_40 vss sg13_hv_nmos w=0.5u l=0.45u m=1
MOCa_MXN_S0_41_0 t82 OCa_bbn0 OCa_MXN_n0_41 vss sg13_hv_nmos w=0.5u l=0.45u m=1
MOCa_MXN_S0_41_1 t83 OCa_bn0 OCa_MXN_n0_41 vss sg13_hv_nmos w=0.5u l=0.45u m=1
MOCa_MXN_S0_42_0 t84 OCa_bbn0 OCa_MXN_n0_42 vss sg13_hv_nmos w=0.5u l=0.45u m=1
MOCa_MXN_S0_42_1 t85 OCa_bn0 OCa_MXN_n0_42 vss sg13_hv_nmos w=0.5u l=0.45u m=1
MOCa_MXN_S0_43_0 t86 OCa_bbn0 OCa_MXN_n0_43 vss sg13_hv_nmos w=0.5u l=0.45u m=1
MOCa_MXN_S0_43_1 t87 OCa_bn0 OCa_MXN_n0_43 vss sg13_hv_nmos w=0.5u l=0.45u m=1
MOCa_MXN_S0_44_0 t88 OCa_bbn0 OCa_MXN_n0_44 vss sg13_hv_nmos w=0.5u l=0.45u m=1
MOCa_MXN_S0_44_1 t89 OCa_bn0 OCa_MXN_n0_44 vss sg13_hv_nmos w=0.5u l=0.45u m=1
MOCa_MXN_S0_45_0 t90 OCa_bbn0 OCa_MXN_n0_45 vss sg13_hv_nmos w=0.5u l=0.45u m=1
MOCa_MXN_S0_45_1 t91 OCa_bn0 OCa_MXN_n0_45 vss sg13_hv_nmos w=0.5u l=0.45u m=1
MOCa_MXN_S0_46_0 t92 OCa_bbn0 OCa_MXN_n0_46 vss sg13_hv_nmos w=0.5u l=0.45u m=1
MOCa_MXN_S0_46_1 t93 OCa_bn0 OCa_MXN_n0_46 vss sg13_hv_nmos w=0.5u l=0.45u m=1
MOCa_MXN_S0_47_0 t94 OCa_bbn0 OCa_MXN_n0_47 vss sg13_hv_nmos w=0.5u l=0.45u m=1
MOCa_MXN_S0_47_1 t95 OCa_bn0 OCa_MXN_n0_47 vss sg13_hv_nmos w=0.5u l=0.45u m=1
MOCa_MXN_S0_48_0 t96 OCa_bbn0 OCa_MXN_n0_48 vss sg13_hv_nmos w=0.5u l=0.45u m=1
MOCa_MXN_S0_48_1 t97 OCa_bn0 OCa_MXN_n0_48 vss sg13_hv_nmos w=0.5u l=0.45u m=1
MOCa_MXN_S0_49_0 t98 OCa_bbn0 OCa_MXN_n0_49 vss sg13_hv_nmos w=0.5u l=0.45u m=1
MOCa_MXN_S0_49_1 t99 OCa_bn0 OCa_MXN_n0_49 vss sg13_hv_nmos w=0.5u l=0.45u m=1
MOCa_MXN_S0_50_0 t100 OCa_bbn0 OCa_MXN_n0_50 vss sg13_hv_nmos w=0.5u l=0.45u m=1
MOCa_MXN_S0_50_1 t101 OCa_bn0 OCa_MXN_n0_50 vss sg13_hv_nmos w=0.5u l=0.45u m=1
MOCa_MXN_S0_51_0 t102 OCa_bbn0 OCa_MXN_n0_51 vss sg13_hv_nmos w=0.5u l=0.45u m=1
MOCa_MXN_S0_51_1 t103 OCa_bn0 OCa_MXN_n0_51 vss sg13_hv_nmos w=0.5u l=0.45u m=1
MOCa_MXN_S0_52_0 t104 OCa_bbn0 OCa_MXN_n0_52 vss sg13_hv_nmos w=0.5u l=0.45u m=1
MOCa_MXN_S0_52_1 t105 OCa_bn0 OCa_MXN_n0_52 vss sg13_hv_nmos w=0.5u l=0.45u m=1
MOCa_MXN_S0_53_0 t106 OCa_bbn0 OCa_MXN_n0_53 vss sg13_hv_nmos w=0.5u l=0.45u m=1
MOCa_MXN_S0_53_1 t107 OCa_bn0 OCa_MXN_n0_53 vss sg13_hv_nmos w=0.5u l=0.45u m=1
MOCa_MXN_S0_54_0 t108 OCa_bbn0 OCa_MXN_n0_54 vss sg13_hv_nmos w=0.5u l=0.45u m=1
MOCa_MXN_S0_54_1 t109 OCa_bn0 OCa_MXN_n0_54 vss sg13_hv_nmos w=0.5u l=0.45u m=1
MOCa_MXN_S0_55_0 t110 OCa_bbn0 OCa_MXN_n0_55 vss sg13_hv_nmos w=0.5u l=0.45u m=1
MOCa_MXN_S0_55_1 t111 OCa_bn0 OCa_MXN_n0_55 vss sg13_hv_nmos w=0.5u l=0.45u m=1
MOCa_MXN_S0_56_0 t112 OCa_bbn0 OCa_MXN_n0_56 vss sg13_hv_nmos w=0.5u l=0.45u m=1
MOCa_MXN_S0_56_1 t113 OCa_bn0 OCa_MXN_n0_56 vss sg13_hv_nmos w=0.5u l=0.45u m=1
MOCa_MXN_S0_57_0 t114 OCa_bbn0 OCa_MXN_n0_57 vss sg13_hv_nmos w=0.5u l=0.45u m=1
MOCa_MXN_S0_57_1 t115 OCa_bn0 OCa_MXN_n0_57 vss sg13_hv_nmos w=0.5u l=0.45u m=1
MOCa_MXN_S0_58_0 t116 OCa_bbn0 OCa_MXN_n0_58 vss sg13_hv_nmos w=0.5u l=0.45u m=1
MOCa_MXN_S0_58_1 t117 OCa_bn0 OCa_MXN_n0_58 vss sg13_hv_nmos w=0.5u l=0.45u m=1
MOCa_MXN_S0_59_0 t118 OCa_bbn0 OCa_MXN_n0_59 vss sg13_hv_nmos w=0.5u l=0.45u m=1
MOCa_MXN_S0_59_1 t119 OCa_bn0 OCa_MXN_n0_59 vss sg13_hv_nmos w=0.5u l=0.45u m=1
MOCa_MXN_S0_60_0 t120 OCa_bbn0 OCa_MXN_n0_60 vss sg13_hv_nmos w=0.5u l=0.45u m=1
MOCa_MXN_S0_60_1 t121 OCa_bn0 OCa_MXN_n0_60 vss sg13_hv_nmos w=0.5u l=0.45u m=1
MOCa_MXN_S0_61_0 t122 OCa_bbn0 OCa_MXN_n0_61 vss sg13_hv_nmos w=0.5u l=0.45u m=1
MOCa_MXN_S0_61_1 t123 OCa_bn0 OCa_MXN_n0_61 vss sg13_hv_nmos w=0.5u l=0.45u m=1
MOCa_MXN_S0_62_0 t124 OCa_bbn0 OCa_MXN_n0_62 vss sg13_hv_nmos w=0.5u l=0.45u m=1
MOCa_MXN_S0_62_1 t125 OCa_bn0 OCa_MXN_n0_62 vss sg13_hv_nmos w=0.5u l=0.45u m=1
MOCa_MXN_S0_63_0 t126 OCa_bbn0 OCa_MXN_n0_63 vss sg13_hv_nmos w=0.5u l=0.45u m=1
MOCa_MXN_S0_63_1 t127 OCa_bn0 OCa_MXN_n0_63 vss sg13_hv_nmos w=0.5u l=0.45u m=1
MOCa_MXN_S0_64_0 t128 OCa_bbn0 OCa_MXN_n0_64 vss sg13_hv_nmos w=0.5u l=0.45u m=1
MOCa_MXN_S0_64_1 t129 OCa_bn0 OCa_MXN_n0_64 vss sg13_hv_nmos w=0.5u l=0.45u m=1
MOCa_MXN_S0_65_0 t130 OCa_bbn0 OCa_MXN_n0_65 vss sg13_hv_nmos w=0.5u l=0.45u m=1
MOCa_MXN_S0_65_1 t131 OCa_bn0 OCa_MXN_n0_65 vss sg13_hv_nmos w=0.5u l=0.45u m=1
MOCa_MXN_S0_66_0 t132 OCa_bbn0 OCa_MXN_n0_66 vss sg13_hv_nmos w=0.5u l=0.45u m=1
MOCa_MXN_S0_66_1 t133 OCa_bn0 OCa_MXN_n0_66 vss sg13_hv_nmos w=0.5u l=0.45u m=1
MOCa_MXN_S0_67_0 t134 OCa_bbn0 OCa_MXN_n0_67 vss sg13_hv_nmos w=0.5u l=0.45u m=1
MOCa_MXN_S0_67_1 t135 OCa_bn0 OCa_MXN_n0_67 vss sg13_hv_nmos w=0.5u l=0.45u m=1
MOCa_MXN_S0_68_0 t136 OCa_bbn0 OCa_MXN_n0_68 vss sg13_hv_nmos w=0.5u l=0.45u m=1
MOCa_MXN_S0_68_1 t137 OCa_bn0 OCa_MXN_n0_68 vss sg13_hv_nmos w=0.5u l=0.45u m=1
MOCa_MXN_S0_69_0 t138 OCa_bbn0 OCa_MXN_n0_69 vss sg13_hv_nmos w=0.5u l=0.45u m=1
MOCa_MXN_S0_69_1 t139 OCa_bn0 OCa_MXN_n0_69 vss sg13_hv_nmos w=0.5u l=0.45u m=1
MOCa_MXN_S0_70_0 t140 OCa_bbn0 OCa_MXN_n0_70 vss sg13_hv_nmos w=0.5u l=0.45u m=1
MOCa_MXN_S0_70_1 t141 OCa_bn0 OCa_MXN_n0_70 vss sg13_hv_nmos w=0.5u l=0.45u m=1
MOCa_MXN_S0_71_0 t142 OCa_bbn0 OCa_MXN_n0_71 vss sg13_hv_nmos w=0.5u l=0.45u m=1
MOCa_MXN_S0_71_1 t143 OCa_bn0 OCa_MXN_n0_71 vss sg13_hv_nmos w=0.5u l=0.45u m=1
MOCa_MXN_S0_72_0 t144 OCa_bbn0 OCa_MXN_n0_72 vss sg13_hv_nmos w=0.5u l=0.45u m=1
MOCa_MXN_S0_72_1 t145 OCa_bn0 OCa_MXN_n0_72 vss sg13_hv_nmos w=0.5u l=0.45u m=1
MOCa_MXN_S0_73_0 t146 OCa_bbn0 OCa_MXN_n0_73 vss sg13_hv_nmos w=0.5u l=0.45u m=1
MOCa_MXN_S0_73_1 t147 OCa_bn0 OCa_MXN_n0_73 vss sg13_hv_nmos w=0.5u l=0.45u m=1
MOCa_MXN_S0_74_0 t148 OCa_bbn0 OCa_MXN_n0_74 vss sg13_hv_nmos w=0.5u l=0.45u m=1
MOCa_MXN_S0_74_1 t149 OCa_bn0 OCa_MXN_n0_74 vss sg13_hv_nmos w=0.5u l=0.45u m=1
MOCa_MXN_S0_75_0 t150 OCa_bbn0 OCa_MXN_n0_75 vss sg13_hv_nmos w=0.5u l=0.45u m=1
MOCa_MXN_S0_75_1 t151 OCa_bn0 OCa_MXN_n0_75 vss sg13_hv_nmos w=0.5u l=0.45u m=1
MOCa_MXN_S0_76_0 t152 OCa_bbn0 OCa_MXN_n0_76 vss sg13_hv_nmos w=0.5u l=0.45u m=1
MOCa_MXN_S0_76_1 t153 OCa_bn0 OCa_MXN_n0_76 vss sg13_hv_nmos w=0.5u l=0.45u m=1
MOCa_MXN_S0_77_0 t154 OCa_bbn0 OCa_MXN_n0_77 vss sg13_hv_nmos w=0.5u l=0.45u m=1
MOCa_MXN_S0_77_1 t155 OCa_bn0 OCa_MXN_n0_77 vss sg13_hv_nmos w=0.5u l=0.45u m=1
MOCa_MXN_S0_78_0 t156 OCa_bbn0 OCa_MXN_n0_78 vss sg13_hv_nmos w=0.5u l=0.45u m=1
MOCa_MXN_S0_78_1 t157 OCa_bn0 OCa_MXN_n0_78 vss sg13_hv_nmos w=0.5u l=0.45u m=1
MOCa_MXN_S0_79_0 t158 OCa_bbn0 OCa_MXN_n0_79 vss sg13_hv_nmos w=0.5u l=0.45u m=1
MOCa_MXN_S0_79_1 t159 OCa_bn0 OCa_MXN_n0_79 vss sg13_hv_nmos w=0.5u l=0.45u m=1
MOCa_MXN_S0_80_0 t160 OCa_bbn0 OCa_MXN_n0_80 vss sg13_hv_nmos w=0.5u l=0.45u m=1
MOCa_MXN_S0_80_1 t161 OCa_bn0 OCa_MXN_n0_80 vss sg13_hv_nmos w=0.5u l=0.45u m=1
MOCa_MXN_S0_81_0 t162 OCa_bbn0 OCa_MXN_n0_81 vss sg13_hv_nmos w=0.5u l=0.45u m=1
MOCa_MXN_S0_81_1 t163 OCa_bn0 OCa_MXN_n0_81 vss sg13_hv_nmos w=0.5u l=0.45u m=1
MOCa_MXN_S0_82_0 t164 OCa_bbn0 OCa_MXN_n0_82 vss sg13_hv_nmos w=0.5u l=0.45u m=1
MOCa_MXN_S0_82_1 t165 OCa_bn0 OCa_MXN_n0_82 vss sg13_hv_nmos w=0.5u l=0.45u m=1
MOCa_MXN_S0_83_0 t166 OCa_bbn0 OCa_MXN_n0_83 vss sg13_hv_nmos w=0.5u l=0.45u m=1
MOCa_MXN_S0_83_1 t167 OCa_bn0 OCa_MXN_n0_83 vss sg13_hv_nmos w=0.5u l=0.45u m=1
MOCa_MXN_S0_84_0 t168 OCa_bbn0 OCa_MXN_n0_84 vss sg13_hv_nmos w=0.5u l=0.45u m=1
MOCa_MXN_S0_84_1 t169 OCa_bn0 OCa_MXN_n0_84 vss sg13_hv_nmos w=0.5u l=0.45u m=1
MOCa_MXN_S0_85_0 t170 OCa_bbn0 OCa_MXN_n0_85 vss sg13_hv_nmos w=0.5u l=0.45u m=1
MOCa_MXN_S0_85_1 t171 OCa_bn0 OCa_MXN_n0_85 vss sg13_hv_nmos w=0.5u l=0.45u m=1
MOCa_MXN_S0_86_0 t172 OCa_bbn0 OCa_MXN_n0_86 vss sg13_hv_nmos w=0.5u l=0.45u m=1
MOCa_MXN_S0_86_1 t173 OCa_bn0 OCa_MXN_n0_86 vss sg13_hv_nmos w=0.5u l=0.45u m=1
MOCa_MXN_S0_87_0 t174 OCa_bbn0 OCa_MXN_n0_87 vss sg13_hv_nmos w=0.5u l=0.45u m=1
MOCa_MXN_S0_87_1 t175 OCa_bn0 OCa_MXN_n0_87 vss sg13_hv_nmos w=0.5u l=0.45u m=1
MOCa_MXN_S0_88_0 t176 OCa_bbn0 OCa_MXN_n0_88 vss sg13_hv_nmos w=0.5u l=0.45u m=1
MOCa_MXN_S0_88_1 t177 OCa_bn0 OCa_MXN_n0_88 vss sg13_hv_nmos w=0.5u l=0.45u m=1
MOCa_MXN_S0_89_0 t178 OCa_bbn0 OCa_MXN_n0_89 vss sg13_hv_nmos w=0.5u l=0.45u m=1
MOCa_MXN_S0_89_1 t179 OCa_bn0 OCa_MXN_n0_89 vss sg13_hv_nmos w=0.5u l=0.45u m=1
MOCa_MXN_S0_90_0 t180 OCa_bbn0 OCa_MXN_n0_90 vss sg13_hv_nmos w=0.5u l=0.45u m=1
MOCa_MXN_S0_90_1 t181 OCa_bn0 OCa_MXN_n0_90 vss sg13_hv_nmos w=0.5u l=0.45u m=1
MOCa_MXN_S0_91_0 t182 OCa_bbn0 OCa_MXN_n0_91 vss sg13_hv_nmos w=0.5u l=0.45u m=1
MOCa_MXN_S0_91_1 t183 OCa_bn0 OCa_MXN_n0_91 vss sg13_hv_nmos w=0.5u l=0.45u m=1
MOCa_MXN_S0_92_0 t184 OCa_bbn0 OCa_MXN_n0_92 vss sg13_hv_nmos w=0.5u l=0.45u m=1
MOCa_MXN_S0_92_1 t185 OCa_bn0 OCa_MXN_n0_92 vss sg13_hv_nmos w=0.5u l=0.45u m=1
MOCa_MXN_S0_93_0 t186 OCa_bbn0 OCa_MXN_n0_93 vss sg13_hv_nmos w=0.5u l=0.45u m=1
MOCa_MXN_S0_93_1 t187 OCa_bn0 OCa_MXN_n0_93 vss sg13_hv_nmos w=0.5u l=0.45u m=1
MOCa_MXN_S0_94_0 t188 OCa_bbn0 OCa_MXN_n0_94 vss sg13_hv_nmos w=0.5u l=0.45u m=1
MOCa_MXN_S0_94_1 t189 OCa_bn0 OCa_MXN_n0_94 vss sg13_hv_nmos w=0.5u l=0.45u m=1
MOCa_MXN_S0_95_0 t190 OCa_bbn0 OCa_MXN_n0_95 vss sg13_hv_nmos w=0.5u l=0.45u m=1
MOCa_MXN_S0_95_1 t191 OCa_bn0 OCa_MXN_n0_95 vss sg13_hv_nmos w=0.5u l=0.45u m=1
MOCa_MXN_S0_96_0 t192 OCa_bbn0 OCa_MXN_n0_96 vss sg13_hv_nmos w=0.5u l=0.45u m=1
MOCa_MXN_S0_96_1 t193 OCa_bn0 OCa_MXN_n0_96 vss sg13_hv_nmos w=0.5u l=0.45u m=1
MOCa_MXN_S0_97_0 t194 OCa_bbn0 OCa_MXN_n0_97 vss sg13_hv_nmos w=0.5u l=0.45u m=1
MOCa_MXN_S0_97_1 t195 OCa_bn0 OCa_MXN_n0_97 vss sg13_hv_nmos w=0.5u l=0.45u m=1
MOCa_MXN_S0_98_0 t196 OCa_bbn0 OCa_MXN_n0_98 vss sg13_hv_nmos w=0.5u l=0.45u m=1
MOCa_MXN_S0_98_1 t197 OCa_bn0 OCa_MXN_n0_98 vss sg13_hv_nmos w=0.5u l=0.45u m=1
MOCa_MXN_S0_99_0 t198 OCa_bbn0 OCa_MXN_n0_99 vss sg13_hv_nmos w=0.5u l=0.45u m=1
MOCa_MXN_S0_99_1 t199 OCa_bn0 OCa_MXN_n0_99 vss sg13_hv_nmos w=0.5u l=0.45u m=1
MOCa_MXN_S0_100_0 t200 OCa_bbn0 OCa_MXN_n0_100 vss sg13_hv_nmos w=0.5u l=0.45u m=1
MOCa_MXN_S0_100_1 t201 OCa_bn0 OCa_MXN_n0_100 vss sg13_hv_nmos w=0.5u l=0.45u m=1
MOCa_MXN_S0_101_0 t202 OCa_bbn0 OCa_MXN_n0_101 vss sg13_hv_nmos w=0.5u l=0.45u m=1
MOCa_MXN_S0_101_1 t203 OCa_bn0 OCa_MXN_n0_101 vss sg13_hv_nmos w=0.5u l=0.45u m=1
MOCa_MXN_S0_102_0 t204 OCa_bbn0 OCa_MXN_n0_102 vss sg13_hv_nmos w=0.5u l=0.45u m=1
MOCa_MXN_S0_102_1 t205 OCa_bn0 OCa_MXN_n0_102 vss sg13_hv_nmos w=0.5u l=0.45u m=1
MOCa_MXN_S0_103_0 t206 OCa_bbn0 OCa_MXN_n0_103 vss sg13_hv_nmos w=0.5u l=0.45u m=1
MOCa_MXN_S0_103_1 t207 OCa_bn0 OCa_MXN_n0_103 vss sg13_hv_nmos w=0.5u l=0.45u m=1
MOCa_MXN_S0_104_0 t208 OCa_bbn0 OCa_MXN_n0_104 vss sg13_hv_nmos w=0.5u l=0.45u m=1
MOCa_MXN_S0_104_1 t209 OCa_bn0 OCa_MXN_n0_104 vss sg13_hv_nmos w=0.5u l=0.45u m=1
MOCa_MXN_S0_105_0 t210 OCa_bbn0 OCa_MXN_n0_105 vss sg13_hv_nmos w=0.5u l=0.45u m=1
MOCa_MXN_S0_105_1 t211 OCa_bn0 OCa_MXN_n0_105 vss sg13_hv_nmos w=0.5u l=0.45u m=1
MOCa_MXN_S0_106_0 t212 OCa_bbn0 OCa_MXN_n0_106 vss sg13_hv_nmos w=0.5u l=0.45u m=1
MOCa_MXN_S0_106_1 t213 OCa_bn0 OCa_MXN_n0_106 vss sg13_hv_nmos w=0.5u l=0.45u m=1
MOCa_MXN_S0_107_0 t214 OCa_bbn0 OCa_MXN_n0_107 vss sg13_hv_nmos w=0.5u l=0.45u m=1
MOCa_MXN_S0_107_1 t215 OCa_bn0 OCa_MXN_n0_107 vss sg13_hv_nmos w=0.5u l=0.45u m=1
MOCa_MXN_S0_108_0 t216 OCa_bbn0 OCa_MXN_n0_108 vss sg13_hv_nmos w=0.5u l=0.45u m=1
MOCa_MXN_S0_108_1 t217 OCa_bn0 OCa_MXN_n0_108 vss sg13_hv_nmos w=0.5u l=0.45u m=1
MOCa_MXN_S0_109_0 t218 OCa_bbn0 OCa_MXN_n0_109 vss sg13_hv_nmos w=0.5u l=0.45u m=1
MOCa_MXN_S0_109_1 t219 OCa_bn0 OCa_MXN_n0_109 vss sg13_hv_nmos w=0.5u l=0.45u m=1
MOCa_MXN_S0_110_0 t220 OCa_bbn0 OCa_MXN_n0_110 vss sg13_hv_nmos w=0.5u l=0.45u m=1
MOCa_MXN_S0_110_1 t221 OCa_bn0 OCa_MXN_n0_110 vss sg13_hv_nmos w=0.5u l=0.45u m=1
MOCa_MXN_S0_111_0 t222 OCa_bbn0 OCa_MXN_n0_111 vss sg13_hv_nmos w=0.5u l=0.45u m=1
MOCa_MXN_S0_111_1 t223 OCa_bn0 OCa_MXN_n0_111 vss sg13_hv_nmos w=0.5u l=0.45u m=1
MOCa_MXN_S0_112_0 t224 OCa_bbn0 OCa_MXN_n0_112 vss sg13_hv_nmos w=0.5u l=0.45u m=1
MOCa_MXN_S0_112_1 t225 OCa_bn0 OCa_MXN_n0_112 vss sg13_hv_nmos w=0.5u l=0.45u m=1
MOCa_MXN_S0_113_0 t226 OCa_bbn0 OCa_MXN_n0_113 vss sg13_hv_nmos w=0.5u l=0.45u m=1
MOCa_MXN_S0_113_1 t227 OCa_bn0 OCa_MXN_n0_113 vss sg13_hv_nmos w=0.5u l=0.45u m=1
MOCa_MXN_S0_114_0 t228 OCa_bbn0 OCa_MXN_n0_114 vss sg13_hv_nmos w=0.5u l=0.45u m=1
MOCa_MXN_S0_114_1 t229 OCa_bn0 OCa_MXN_n0_114 vss sg13_hv_nmos w=0.5u l=0.45u m=1
MOCa_MXN_S0_115_0 t230 OCa_bbn0 OCa_MXN_n0_115 vss sg13_hv_nmos w=0.5u l=0.45u m=1
MOCa_MXN_S0_115_1 t231 OCa_bn0 OCa_MXN_n0_115 vss sg13_hv_nmos w=0.5u l=0.45u m=1
MOCa_MXN_S0_116_0 t232 OCa_bbn0 OCa_MXN_n0_116 vss sg13_hv_nmos w=0.5u l=0.45u m=1
MOCa_MXN_S0_116_1 t233 OCa_bn0 OCa_MXN_n0_116 vss sg13_hv_nmos w=0.5u l=0.45u m=1
MOCa_MXN_S0_117_0 t234 OCa_bbn0 OCa_MXN_n0_117 vss sg13_hv_nmos w=0.5u l=0.45u m=1
MOCa_MXN_S0_117_1 t235 OCa_bn0 OCa_MXN_n0_117 vss sg13_hv_nmos w=0.5u l=0.45u m=1
MOCa_MXN_S0_118_0 t236 OCa_bbn0 OCa_MXN_n0_118 vss sg13_hv_nmos w=0.5u l=0.45u m=1
MOCa_MXN_S0_118_1 t237 OCa_bn0 OCa_MXN_n0_118 vss sg13_hv_nmos w=0.5u l=0.45u m=1
MOCa_MXN_S0_119_0 t238 OCa_bbn0 OCa_MXN_n0_119 vss sg13_hv_nmos w=0.5u l=0.45u m=1
MOCa_MXN_S0_119_1 t239 OCa_bn0 OCa_MXN_n0_119 vss sg13_hv_nmos w=0.5u l=0.45u m=1
MOCa_MXN_S0_120_0 t240 OCa_bbn0 OCa_MXN_n0_120 vss sg13_hv_nmos w=0.5u l=0.45u m=1
MOCa_MXN_S0_120_1 t241 OCa_bn0 OCa_MXN_n0_120 vss sg13_hv_nmos w=0.5u l=0.45u m=1
MOCa_MXN_S0_121_0 t242 OCa_bbn0 OCa_MXN_n0_121 vss sg13_hv_nmos w=0.5u l=0.45u m=1
MOCa_MXN_S0_121_1 t243 OCa_bn0 OCa_MXN_n0_121 vss sg13_hv_nmos w=0.5u l=0.45u m=1
MOCa_MXN_S0_122_0 t244 OCa_bbn0 OCa_MXN_n0_122 vss sg13_hv_nmos w=0.5u l=0.45u m=1
MOCa_MXN_S0_122_1 t245 OCa_bn0 OCa_MXN_n0_122 vss sg13_hv_nmos w=0.5u l=0.45u m=1
MOCa_MXN_S0_123_0 t246 OCa_bbn0 OCa_MXN_n0_123 vss sg13_hv_nmos w=0.5u l=0.45u m=1
MOCa_MXN_S0_123_1 t247 OCa_bn0 OCa_MXN_n0_123 vss sg13_hv_nmos w=0.5u l=0.45u m=1
MOCa_MXN_S0_124_0 t248 OCa_bbn0 OCa_MXN_n0_124 vss sg13_hv_nmos w=0.5u l=0.45u m=1
MOCa_MXN_S0_124_1 t249 OCa_bn0 OCa_MXN_n0_124 vss sg13_hv_nmos w=0.5u l=0.45u m=1
MOCa_MXN_S0_125_0 t250 OCa_bbn0 OCa_MXN_n0_125 vss sg13_hv_nmos w=0.5u l=0.45u m=1
MOCa_MXN_S0_125_1 t251 OCa_bn0 OCa_MXN_n0_125 vss sg13_hv_nmos w=0.5u l=0.45u m=1
MOCa_MXN_S0_126_0 vref OCa_bbn0 OCa_MXN_n0_126 vss sg13_hv_nmos w=0.5u l=0.45u m=1
MOCa_MXN_S0_126_1 vref OCa_bn0 OCa_MXN_n0_126 vss sg13_hv_nmos w=0.5u l=0.45u m=1
MOCa_MXN_S0_127_0 vref OCa_bbn0 OCa_MXN_n0_127 vss sg13_hv_nmos w=0.5u l=0.45u m=1
MOCa_MXN_S0_127_1 vref OCa_bn0 OCa_MXN_n0_127 vss sg13_hv_nmos w=0.5u l=0.45u m=1
MOCa_MXN_S1_0_0 OCa_MXN_n0_0 OCa_bbn1 OCa_MXN_n1_0 vss sg13_hv_nmos w=0.5u l=0.45u m=1
MOCa_MXN_S1_0_1 OCa_MXN_n0_1 OCa_bn1 OCa_MXN_n1_0 vss sg13_hv_nmos w=0.5u l=0.45u m=1
MOCa_MXN_S1_1_0 OCa_MXN_n0_2 OCa_bbn1 OCa_MXN_n1_1 vss sg13_hv_nmos w=0.5u l=0.45u m=1
MOCa_MXN_S1_1_1 OCa_MXN_n0_3 OCa_bn1 OCa_MXN_n1_1 vss sg13_hv_nmos w=0.5u l=0.45u m=1
MOCa_MXN_S1_2_0 OCa_MXN_n0_4 OCa_bbn1 OCa_MXN_n1_2 vss sg13_hv_nmos w=0.5u l=0.45u m=1
MOCa_MXN_S1_2_1 OCa_MXN_n0_5 OCa_bn1 OCa_MXN_n1_2 vss sg13_hv_nmos w=0.5u l=0.45u m=1
MOCa_MXN_S1_3_0 OCa_MXN_n0_6 OCa_bbn1 OCa_MXN_n1_3 vss sg13_hv_nmos w=0.5u l=0.45u m=1
MOCa_MXN_S1_3_1 OCa_MXN_n0_7 OCa_bn1 OCa_MXN_n1_3 vss sg13_hv_nmos w=0.5u l=0.45u m=1
MOCa_MXN_S1_4_0 OCa_MXN_n0_8 OCa_bbn1 OCa_MXN_n1_4 vss sg13_hv_nmos w=0.5u l=0.45u m=1
MOCa_MXN_S1_4_1 OCa_MXN_n0_9 OCa_bn1 OCa_MXN_n1_4 vss sg13_hv_nmos w=0.5u l=0.45u m=1
MOCa_MXN_S1_5_0 OCa_MXN_n0_10 OCa_bbn1 OCa_MXN_n1_5 vss sg13_hv_nmos w=0.5u l=0.45u m=1
MOCa_MXN_S1_5_1 OCa_MXN_n0_11 OCa_bn1 OCa_MXN_n1_5 vss sg13_hv_nmos w=0.5u l=0.45u m=1
MOCa_MXN_S1_6_0 OCa_MXN_n0_12 OCa_bbn1 OCa_MXN_n1_6 vss sg13_hv_nmos w=0.5u l=0.45u m=1
MOCa_MXN_S1_6_1 OCa_MXN_n0_13 OCa_bn1 OCa_MXN_n1_6 vss sg13_hv_nmos w=0.5u l=0.45u m=1
MOCa_MXN_S1_7_0 OCa_MXN_n0_14 OCa_bbn1 OCa_MXN_n1_7 vss sg13_hv_nmos w=0.5u l=0.45u m=1
MOCa_MXN_S1_7_1 OCa_MXN_n0_15 OCa_bn1 OCa_MXN_n1_7 vss sg13_hv_nmos w=0.5u l=0.45u m=1
MOCa_MXN_S1_8_0 OCa_MXN_n0_16 OCa_bbn1 OCa_MXN_n1_8 vss sg13_hv_nmos w=0.5u l=0.45u m=1
MOCa_MXN_S1_8_1 OCa_MXN_n0_17 OCa_bn1 OCa_MXN_n1_8 vss sg13_hv_nmos w=0.5u l=0.45u m=1
MOCa_MXN_S1_9_0 OCa_MXN_n0_18 OCa_bbn1 OCa_MXN_n1_9 vss sg13_hv_nmos w=0.5u l=0.45u m=1
MOCa_MXN_S1_9_1 OCa_MXN_n0_19 OCa_bn1 OCa_MXN_n1_9 vss sg13_hv_nmos w=0.5u l=0.45u m=1
MOCa_MXN_S1_10_0 OCa_MXN_n0_20 OCa_bbn1 OCa_MXN_n1_10 vss sg13_hv_nmos w=0.5u l=0.45u m=1
MOCa_MXN_S1_10_1 OCa_MXN_n0_21 OCa_bn1 OCa_MXN_n1_10 vss sg13_hv_nmos w=0.5u l=0.45u m=1
MOCa_MXN_S1_11_0 OCa_MXN_n0_22 OCa_bbn1 OCa_MXN_n1_11 vss sg13_hv_nmos w=0.5u l=0.45u m=1
MOCa_MXN_S1_11_1 OCa_MXN_n0_23 OCa_bn1 OCa_MXN_n1_11 vss sg13_hv_nmos w=0.5u l=0.45u m=1
MOCa_MXN_S1_12_0 OCa_MXN_n0_24 OCa_bbn1 OCa_MXN_n1_12 vss sg13_hv_nmos w=0.5u l=0.45u m=1
MOCa_MXN_S1_12_1 OCa_MXN_n0_25 OCa_bn1 OCa_MXN_n1_12 vss sg13_hv_nmos w=0.5u l=0.45u m=1
MOCa_MXN_S1_13_0 OCa_MXN_n0_26 OCa_bbn1 OCa_MXN_n1_13 vss sg13_hv_nmos w=0.5u l=0.45u m=1
MOCa_MXN_S1_13_1 OCa_MXN_n0_27 OCa_bn1 OCa_MXN_n1_13 vss sg13_hv_nmos w=0.5u l=0.45u m=1
MOCa_MXN_S1_14_0 OCa_MXN_n0_28 OCa_bbn1 OCa_MXN_n1_14 vss sg13_hv_nmos w=0.5u l=0.45u m=1
MOCa_MXN_S1_14_1 OCa_MXN_n0_29 OCa_bn1 OCa_MXN_n1_14 vss sg13_hv_nmos w=0.5u l=0.45u m=1
MOCa_MXN_S1_15_0 OCa_MXN_n0_30 OCa_bbn1 OCa_MXN_n1_15 vss sg13_hv_nmos w=0.5u l=0.45u m=1
MOCa_MXN_S1_15_1 OCa_MXN_n0_31 OCa_bn1 OCa_MXN_n1_15 vss sg13_hv_nmos w=0.5u l=0.45u m=1
MOCa_MXN_S1_16_0 OCa_MXN_n0_32 OCa_bbn1 OCa_MXN_n1_16 vss sg13_hv_nmos w=0.5u l=0.45u m=1
MOCa_MXN_S1_16_1 OCa_MXN_n0_33 OCa_bn1 OCa_MXN_n1_16 vss sg13_hv_nmos w=0.5u l=0.45u m=1
MOCa_MXN_S1_17_0 OCa_MXN_n0_34 OCa_bbn1 OCa_MXN_n1_17 vss sg13_hv_nmos w=0.5u l=0.45u m=1
MOCa_MXN_S1_17_1 OCa_MXN_n0_35 OCa_bn1 OCa_MXN_n1_17 vss sg13_hv_nmos w=0.5u l=0.45u m=1
MOCa_MXN_S1_18_0 OCa_MXN_n0_36 OCa_bbn1 OCa_MXN_n1_18 vss sg13_hv_nmos w=0.5u l=0.45u m=1
MOCa_MXN_S1_18_1 OCa_MXN_n0_37 OCa_bn1 OCa_MXN_n1_18 vss sg13_hv_nmos w=0.5u l=0.45u m=1
MOCa_MXN_S1_19_0 OCa_MXN_n0_38 OCa_bbn1 OCa_MXN_n1_19 vss sg13_hv_nmos w=0.5u l=0.45u m=1
MOCa_MXN_S1_19_1 OCa_MXN_n0_39 OCa_bn1 OCa_MXN_n1_19 vss sg13_hv_nmos w=0.5u l=0.45u m=1
MOCa_MXN_S1_20_0 OCa_MXN_n0_40 OCa_bbn1 OCa_MXN_n1_20 vss sg13_hv_nmos w=0.5u l=0.45u m=1
MOCa_MXN_S1_20_1 OCa_MXN_n0_41 OCa_bn1 OCa_MXN_n1_20 vss sg13_hv_nmos w=0.5u l=0.45u m=1
MOCa_MXN_S1_21_0 OCa_MXN_n0_42 OCa_bbn1 OCa_MXN_n1_21 vss sg13_hv_nmos w=0.5u l=0.45u m=1
MOCa_MXN_S1_21_1 OCa_MXN_n0_43 OCa_bn1 OCa_MXN_n1_21 vss sg13_hv_nmos w=0.5u l=0.45u m=1
MOCa_MXN_S1_22_0 OCa_MXN_n0_44 OCa_bbn1 OCa_MXN_n1_22 vss sg13_hv_nmos w=0.5u l=0.45u m=1
MOCa_MXN_S1_22_1 OCa_MXN_n0_45 OCa_bn1 OCa_MXN_n1_22 vss sg13_hv_nmos w=0.5u l=0.45u m=1
MOCa_MXN_S1_23_0 OCa_MXN_n0_46 OCa_bbn1 OCa_MXN_n1_23 vss sg13_hv_nmos w=0.5u l=0.45u m=1
MOCa_MXN_S1_23_1 OCa_MXN_n0_47 OCa_bn1 OCa_MXN_n1_23 vss sg13_hv_nmos w=0.5u l=0.45u m=1
MOCa_MXN_S1_24_0 OCa_MXN_n0_48 OCa_bbn1 OCa_MXN_n1_24 vss sg13_hv_nmos w=0.5u l=0.45u m=1
MOCa_MXN_S1_24_1 OCa_MXN_n0_49 OCa_bn1 OCa_MXN_n1_24 vss sg13_hv_nmos w=0.5u l=0.45u m=1
MOCa_MXN_S1_25_0 OCa_MXN_n0_50 OCa_bbn1 OCa_MXN_n1_25 vss sg13_hv_nmos w=0.5u l=0.45u m=1
MOCa_MXN_S1_25_1 OCa_MXN_n0_51 OCa_bn1 OCa_MXN_n1_25 vss sg13_hv_nmos w=0.5u l=0.45u m=1
MOCa_MXN_S1_26_0 OCa_MXN_n0_52 OCa_bbn1 OCa_MXN_n1_26 vss sg13_hv_nmos w=0.5u l=0.45u m=1
MOCa_MXN_S1_26_1 OCa_MXN_n0_53 OCa_bn1 OCa_MXN_n1_26 vss sg13_hv_nmos w=0.5u l=0.45u m=1
MOCa_MXN_S1_27_0 OCa_MXN_n0_54 OCa_bbn1 OCa_MXN_n1_27 vss sg13_hv_nmos w=0.5u l=0.45u m=1
MOCa_MXN_S1_27_1 OCa_MXN_n0_55 OCa_bn1 OCa_MXN_n1_27 vss sg13_hv_nmos w=0.5u l=0.45u m=1
MOCa_MXN_S1_28_0 OCa_MXN_n0_56 OCa_bbn1 OCa_MXN_n1_28 vss sg13_hv_nmos w=0.5u l=0.45u m=1
MOCa_MXN_S1_28_1 OCa_MXN_n0_57 OCa_bn1 OCa_MXN_n1_28 vss sg13_hv_nmos w=0.5u l=0.45u m=1
MOCa_MXN_S1_29_0 OCa_MXN_n0_58 OCa_bbn1 OCa_MXN_n1_29 vss sg13_hv_nmos w=0.5u l=0.45u m=1
MOCa_MXN_S1_29_1 OCa_MXN_n0_59 OCa_bn1 OCa_MXN_n1_29 vss sg13_hv_nmos w=0.5u l=0.45u m=1
MOCa_MXN_S1_30_0 OCa_MXN_n0_60 OCa_bbn1 OCa_MXN_n1_30 vss sg13_hv_nmos w=0.5u l=0.45u m=1
MOCa_MXN_S1_30_1 OCa_MXN_n0_61 OCa_bn1 OCa_MXN_n1_30 vss sg13_hv_nmos w=0.5u l=0.45u m=1
MOCa_MXN_S1_31_0 OCa_MXN_n0_62 OCa_bbn1 OCa_MXN_n1_31 vss sg13_hv_nmos w=0.5u l=0.45u m=1
MOCa_MXN_S1_31_1 OCa_MXN_n0_63 OCa_bn1 OCa_MXN_n1_31 vss sg13_hv_nmos w=0.5u l=0.45u m=1
MOCa_MXN_S1_32_0 OCa_MXN_n0_64 OCa_bbn1 OCa_MXN_n1_32 vss sg13_hv_nmos w=0.5u l=0.45u m=1
MOCa_MXN_S1_32_1 OCa_MXN_n0_65 OCa_bn1 OCa_MXN_n1_32 vss sg13_hv_nmos w=0.5u l=0.45u m=1
MOCa_MXN_S1_33_0 OCa_MXN_n0_66 OCa_bbn1 OCa_MXN_n1_33 vss sg13_hv_nmos w=0.5u l=0.45u m=1
MOCa_MXN_S1_33_1 OCa_MXN_n0_67 OCa_bn1 OCa_MXN_n1_33 vss sg13_hv_nmos w=0.5u l=0.45u m=1
MOCa_MXN_S1_34_0 OCa_MXN_n0_68 OCa_bbn1 OCa_MXN_n1_34 vss sg13_hv_nmos w=0.5u l=0.45u m=1
MOCa_MXN_S1_34_1 OCa_MXN_n0_69 OCa_bn1 OCa_MXN_n1_34 vss sg13_hv_nmos w=0.5u l=0.45u m=1
MOCa_MXN_S1_35_0 OCa_MXN_n0_70 OCa_bbn1 OCa_MXN_n1_35 vss sg13_hv_nmos w=0.5u l=0.45u m=1
MOCa_MXN_S1_35_1 OCa_MXN_n0_71 OCa_bn1 OCa_MXN_n1_35 vss sg13_hv_nmos w=0.5u l=0.45u m=1
MOCa_MXN_S1_36_0 OCa_MXN_n0_72 OCa_bbn1 OCa_MXN_n1_36 vss sg13_hv_nmos w=0.5u l=0.45u m=1
MOCa_MXN_S1_36_1 OCa_MXN_n0_73 OCa_bn1 OCa_MXN_n1_36 vss sg13_hv_nmos w=0.5u l=0.45u m=1
MOCa_MXN_S1_37_0 OCa_MXN_n0_74 OCa_bbn1 OCa_MXN_n1_37 vss sg13_hv_nmos w=0.5u l=0.45u m=1
MOCa_MXN_S1_37_1 OCa_MXN_n0_75 OCa_bn1 OCa_MXN_n1_37 vss sg13_hv_nmos w=0.5u l=0.45u m=1
MOCa_MXN_S1_38_0 OCa_MXN_n0_76 OCa_bbn1 OCa_MXN_n1_38 vss sg13_hv_nmos w=0.5u l=0.45u m=1
MOCa_MXN_S1_38_1 OCa_MXN_n0_77 OCa_bn1 OCa_MXN_n1_38 vss sg13_hv_nmos w=0.5u l=0.45u m=1
MOCa_MXN_S1_39_0 OCa_MXN_n0_78 OCa_bbn1 OCa_MXN_n1_39 vss sg13_hv_nmos w=0.5u l=0.45u m=1
MOCa_MXN_S1_39_1 OCa_MXN_n0_79 OCa_bn1 OCa_MXN_n1_39 vss sg13_hv_nmos w=0.5u l=0.45u m=1
MOCa_MXN_S1_40_0 OCa_MXN_n0_80 OCa_bbn1 OCa_MXN_n1_40 vss sg13_hv_nmos w=0.5u l=0.45u m=1
MOCa_MXN_S1_40_1 OCa_MXN_n0_81 OCa_bn1 OCa_MXN_n1_40 vss sg13_hv_nmos w=0.5u l=0.45u m=1
MOCa_MXN_S1_41_0 OCa_MXN_n0_82 OCa_bbn1 OCa_MXN_n1_41 vss sg13_hv_nmos w=0.5u l=0.45u m=1
MOCa_MXN_S1_41_1 OCa_MXN_n0_83 OCa_bn1 OCa_MXN_n1_41 vss sg13_hv_nmos w=0.5u l=0.45u m=1
MOCa_MXN_S1_42_0 OCa_MXN_n0_84 OCa_bbn1 OCa_MXN_n1_42 vss sg13_hv_nmos w=0.5u l=0.45u m=1
MOCa_MXN_S1_42_1 OCa_MXN_n0_85 OCa_bn1 OCa_MXN_n1_42 vss sg13_hv_nmos w=0.5u l=0.45u m=1
MOCa_MXN_S1_43_0 OCa_MXN_n0_86 OCa_bbn1 OCa_MXN_n1_43 vss sg13_hv_nmos w=0.5u l=0.45u m=1
MOCa_MXN_S1_43_1 OCa_MXN_n0_87 OCa_bn1 OCa_MXN_n1_43 vss sg13_hv_nmos w=0.5u l=0.45u m=1
MOCa_MXN_S1_44_0 OCa_MXN_n0_88 OCa_bbn1 OCa_MXN_n1_44 vss sg13_hv_nmos w=0.5u l=0.45u m=1
MOCa_MXN_S1_44_1 OCa_MXN_n0_89 OCa_bn1 OCa_MXN_n1_44 vss sg13_hv_nmos w=0.5u l=0.45u m=1
MOCa_MXN_S1_45_0 OCa_MXN_n0_90 OCa_bbn1 OCa_MXN_n1_45 vss sg13_hv_nmos w=0.5u l=0.45u m=1
MOCa_MXN_S1_45_1 OCa_MXN_n0_91 OCa_bn1 OCa_MXN_n1_45 vss sg13_hv_nmos w=0.5u l=0.45u m=1
MOCa_MXN_S1_46_0 OCa_MXN_n0_92 OCa_bbn1 OCa_MXN_n1_46 vss sg13_hv_nmos w=0.5u l=0.45u m=1
MOCa_MXN_S1_46_1 OCa_MXN_n0_93 OCa_bn1 OCa_MXN_n1_46 vss sg13_hv_nmos w=0.5u l=0.45u m=1
MOCa_MXN_S1_47_0 OCa_MXN_n0_94 OCa_bbn1 OCa_MXN_n1_47 vss sg13_hv_nmos w=0.5u l=0.45u m=1
MOCa_MXN_S1_47_1 OCa_MXN_n0_95 OCa_bn1 OCa_MXN_n1_47 vss sg13_hv_nmos w=0.5u l=0.45u m=1
MOCa_MXN_S1_48_0 OCa_MXN_n0_96 OCa_bbn1 OCa_MXN_n1_48 vss sg13_hv_nmos w=0.5u l=0.45u m=1
MOCa_MXN_S1_48_1 OCa_MXN_n0_97 OCa_bn1 OCa_MXN_n1_48 vss sg13_hv_nmos w=0.5u l=0.45u m=1
MOCa_MXN_S1_49_0 OCa_MXN_n0_98 OCa_bbn1 OCa_MXN_n1_49 vss sg13_hv_nmos w=0.5u l=0.45u m=1
MOCa_MXN_S1_49_1 OCa_MXN_n0_99 OCa_bn1 OCa_MXN_n1_49 vss sg13_hv_nmos w=0.5u l=0.45u m=1
MOCa_MXN_S1_50_0 OCa_MXN_n0_100 OCa_bbn1 OCa_MXN_n1_50 vss sg13_hv_nmos w=0.5u l=0.45u m=1
MOCa_MXN_S1_50_1 OCa_MXN_n0_101 OCa_bn1 OCa_MXN_n1_50 vss sg13_hv_nmos w=0.5u l=0.45u m=1
MOCa_MXN_S1_51_0 OCa_MXN_n0_102 OCa_bbn1 OCa_MXN_n1_51 vss sg13_hv_nmos w=0.5u l=0.45u m=1
MOCa_MXN_S1_51_1 OCa_MXN_n0_103 OCa_bn1 OCa_MXN_n1_51 vss sg13_hv_nmos w=0.5u l=0.45u m=1
MOCa_MXN_S1_52_0 OCa_MXN_n0_104 OCa_bbn1 OCa_MXN_n1_52 vss sg13_hv_nmos w=0.5u l=0.45u m=1
MOCa_MXN_S1_52_1 OCa_MXN_n0_105 OCa_bn1 OCa_MXN_n1_52 vss sg13_hv_nmos w=0.5u l=0.45u m=1
MOCa_MXN_S1_53_0 OCa_MXN_n0_106 OCa_bbn1 OCa_MXN_n1_53 vss sg13_hv_nmos w=0.5u l=0.45u m=1
MOCa_MXN_S1_53_1 OCa_MXN_n0_107 OCa_bn1 OCa_MXN_n1_53 vss sg13_hv_nmos w=0.5u l=0.45u m=1
MOCa_MXN_S1_54_0 OCa_MXN_n0_108 OCa_bbn1 OCa_MXN_n1_54 vss sg13_hv_nmos w=0.5u l=0.45u m=1
MOCa_MXN_S1_54_1 OCa_MXN_n0_109 OCa_bn1 OCa_MXN_n1_54 vss sg13_hv_nmos w=0.5u l=0.45u m=1
MOCa_MXN_S1_55_0 OCa_MXN_n0_110 OCa_bbn1 OCa_MXN_n1_55 vss sg13_hv_nmos w=0.5u l=0.45u m=1
MOCa_MXN_S1_55_1 OCa_MXN_n0_111 OCa_bn1 OCa_MXN_n1_55 vss sg13_hv_nmos w=0.5u l=0.45u m=1
MOCa_MXN_S1_56_0 OCa_MXN_n0_112 OCa_bbn1 OCa_MXN_n1_56 vss sg13_hv_nmos w=0.5u l=0.45u m=1
MOCa_MXN_S1_56_1 OCa_MXN_n0_113 OCa_bn1 OCa_MXN_n1_56 vss sg13_hv_nmos w=0.5u l=0.45u m=1
MOCa_MXN_S1_57_0 OCa_MXN_n0_114 OCa_bbn1 OCa_MXN_n1_57 vss sg13_hv_nmos w=0.5u l=0.45u m=1
MOCa_MXN_S1_57_1 OCa_MXN_n0_115 OCa_bn1 OCa_MXN_n1_57 vss sg13_hv_nmos w=0.5u l=0.45u m=1
MOCa_MXN_S1_58_0 OCa_MXN_n0_116 OCa_bbn1 OCa_MXN_n1_58 vss sg13_hv_nmos w=0.5u l=0.45u m=1
MOCa_MXN_S1_58_1 OCa_MXN_n0_117 OCa_bn1 OCa_MXN_n1_58 vss sg13_hv_nmos w=0.5u l=0.45u m=1
MOCa_MXN_S1_59_0 OCa_MXN_n0_118 OCa_bbn1 OCa_MXN_n1_59 vss sg13_hv_nmos w=0.5u l=0.45u m=1
MOCa_MXN_S1_59_1 OCa_MXN_n0_119 OCa_bn1 OCa_MXN_n1_59 vss sg13_hv_nmos w=0.5u l=0.45u m=1
MOCa_MXN_S1_60_0 OCa_MXN_n0_120 OCa_bbn1 OCa_MXN_n1_60 vss sg13_hv_nmos w=0.5u l=0.45u m=1
MOCa_MXN_S1_60_1 OCa_MXN_n0_121 OCa_bn1 OCa_MXN_n1_60 vss sg13_hv_nmos w=0.5u l=0.45u m=1
MOCa_MXN_S1_61_0 OCa_MXN_n0_122 OCa_bbn1 OCa_MXN_n1_61 vss sg13_hv_nmos w=0.5u l=0.45u m=1
MOCa_MXN_S1_61_1 OCa_MXN_n0_123 OCa_bn1 OCa_MXN_n1_61 vss sg13_hv_nmos w=0.5u l=0.45u m=1
MOCa_MXN_S1_62_0 OCa_MXN_n0_124 OCa_bbn1 OCa_MXN_n1_62 vss sg13_hv_nmos w=0.5u l=0.45u m=1
MOCa_MXN_S1_62_1 OCa_MXN_n0_125 OCa_bn1 OCa_MXN_n1_62 vss sg13_hv_nmos w=0.5u l=0.45u m=1
MOCa_MXN_S1_63_0 OCa_MXN_n0_126 OCa_bbn1 OCa_MXN_n1_63 vss sg13_hv_nmos w=0.5u l=0.45u m=1
MOCa_MXN_S1_63_1 OCa_MXN_n0_127 OCa_bn1 OCa_MXN_n1_63 vss sg13_hv_nmos w=0.5u l=0.45u m=1
MOCa_MXN_S2_0_0 OCa_MXN_n1_0 OCa_bbn2 OCa_MXN_n2_0 vss sg13_hv_nmos w=0.5u l=0.45u m=1
MOCa_MXN_S2_0_1 OCa_MXN_n1_1 OCa_bn2 OCa_MXN_n2_0 vss sg13_hv_nmos w=0.5u l=0.45u m=1
MOCa_MXN_S2_1_0 OCa_MXN_n1_2 OCa_bbn2 OCa_MXN_n2_1 vss sg13_hv_nmos w=0.5u l=0.45u m=1
MOCa_MXN_S2_1_1 OCa_MXN_n1_3 OCa_bn2 OCa_MXN_n2_1 vss sg13_hv_nmos w=0.5u l=0.45u m=1
MOCa_MXN_S2_2_0 OCa_MXN_n1_4 OCa_bbn2 OCa_MXN_n2_2 vss sg13_hv_nmos w=0.5u l=0.45u m=1
MOCa_MXN_S2_2_1 OCa_MXN_n1_5 OCa_bn2 OCa_MXN_n2_2 vss sg13_hv_nmos w=0.5u l=0.45u m=1
MOCa_MXN_S2_3_0 OCa_MXN_n1_6 OCa_bbn2 OCa_MXN_n2_3 vss sg13_hv_nmos w=0.5u l=0.45u m=1
MOCa_MXN_S2_3_1 OCa_MXN_n1_7 OCa_bn2 OCa_MXN_n2_3 vss sg13_hv_nmos w=0.5u l=0.45u m=1
MOCa_MXN_S2_4_0 OCa_MXN_n1_8 OCa_bbn2 OCa_MXN_n2_4 vss sg13_hv_nmos w=0.5u l=0.45u m=1
MOCa_MXN_S2_4_1 OCa_MXN_n1_9 OCa_bn2 OCa_MXN_n2_4 vss sg13_hv_nmos w=0.5u l=0.45u m=1
MOCa_MXN_S2_5_0 OCa_MXN_n1_10 OCa_bbn2 OCa_MXN_n2_5 vss sg13_hv_nmos w=0.5u l=0.45u m=1
MOCa_MXN_S2_5_1 OCa_MXN_n1_11 OCa_bn2 OCa_MXN_n2_5 vss sg13_hv_nmos w=0.5u l=0.45u m=1
MOCa_MXN_S2_6_0 OCa_MXN_n1_12 OCa_bbn2 OCa_MXN_n2_6 vss sg13_hv_nmos w=0.5u l=0.45u m=1
MOCa_MXN_S2_6_1 OCa_MXN_n1_13 OCa_bn2 OCa_MXN_n2_6 vss sg13_hv_nmos w=0.5u l=0.45u m=1
MOCa_MXN_S2_7_0 OCa_MXN_n1_14 OCa_bbn2 OCa_MXN_n2_7 vss sg13_hv_nmos w=0.5u l=0.45u m=1
MOCa_MXN_S2_7_1 OCa_MXN_n1_15 OCa_bn2 OCa_MXN_n2_7 vss sg13_hv_nmos w=0.5u l=0.45u m=1
MOCa_MXN_S2_8_0 OCa_MXN_n1_16 OCa_bbn2 OCa_MXN_n2_8 vss sg13_hv_nmos w=0.5u l=0.45u m=1
MOCa_MXN_S2_8_1 OCa_MXN_n1_17 OCa_bn2 OCa_MXN_n2_8 vss sg13_hv_nmos w=0.5u l=0.45u m=1
MOCa_MXN_S2_9_0 OCa_MXN_n1_18 OCa_bbn2 OCa_MXN_n2_9 vss sg13_hv_nmos w=0.5u l=0.45u m=1
MOCa_MXN_S2_9_1 OCa_MXN_n1_19 OCa_bn2 OCa_MXN_n2_9 vss sg13_hv_nmos w=0.5u l=0.45u m=1
MOCa_MXN_S2_10_0 OCa_MXN_n1_20 OCa_bbn2 OCa_MXN_n2_10 vss sg13_hv_nmos w=0.5u l=0.45u m=1
MOCa_MXN_S2_10_1 OCa_MXN_n1_21 OCa_bn2 OCa_MXN_n2_10 vss sg13_hv_nmos w=0.5u l=0.45u m=1
MOCa_MXN_S2_11_0 OCa_MXN_n1_22 OCa_bbn2 OCa_MXN_n2_11 vss sg13_hv_nmos w=0.5u l=0.45u m=1
MOCa_MXN_S2_11_1 OCa_MXN_n1_23 OCa_bn2 OCa_MXN_n2_11 vss sg13_hv_nmos w=0.5u l=0.45u m=1
MOCa_MXN_S2_12_0 OCa_MXN_n1_24 OCa_bbn2 OCa_MXN_n2_12 vss sg13_hv_nmos w=0.5u l=0.45u m=1
MOCa_MXN_S2_12_1 OCa_MXN_n1_25 OCa_bn2 OCa_MXN_n2_12 vss sg13_hv_nmos w=0.5u l=0.45u m=1
MOCa_MXN_S2_13_0 OCa_MXN_n1_26 OCa_bbn2 OCa_MXN_n2_13 vss sg13_hv_nmos w=0.5u l=0.45u m=1
MOCa_MXN_S2_13_1 OCa_MXN_n1_27 OCa_bn2 OCa_MXN_n2_13 vss sg13_hv_nmos w=0.5u l=0.45u m=1
MOCa_MXN_S2_14_0 OCa_MXN_n1_28 OCa_bbn2 OCa_MXN_n2_14 vss sg13_hv_nmos w=0.5u l=0.45u m=1
MOCa_MXN_S2_14_1 OCa_MXN_n1_29 OCa_bn2 OCa_MXN_n2_14 vss sg13_hv_nmos w=0.5u l=0.45u m=1
MOCa_MXN_S2_15_0 OCa_MXN_n1_30 OCa_bbn2 OCa_MXN_n2_15 vss sg13_hv_nmos w=0.5u l=0.45u m=1
MOCa_MXN_S2_15_1 OCa_MXN_n1_31 OCa_bn2 OCa_MXN_n2_15 vss sg13_hv_nmos w=0.5u l=0.45u m=1
MOCa_MXN_S2_16_0 OCa_MXN_n1_32 OCa_bbn2 OCa_MXN_n2_16 vss sg13_hv_nmos w=0.5u l=0.45u m=1
MOCa_MXN_S2_16_1 OCa_MXN_n1_33 OCa_bn2 OCa_MXN_n2_16 vss sg13_hv_nmos w=0.5u l=0.45u m=1
MOCa_MXN_S2_17_0 OCa_MXN_n1_34 OCa_bbn2 OCa_MXN_n2_17 vss sg13_hv_nmos w=0.5u l=0.45u m=1
MOCa_MXN_S2_17_1 OCa_MXN_n1_35 OCa_bn2 OCa_MXN_n2_17 vss sg13_hv_nmos w=0.5u l=0.45u m=1
MOCa_MXN_S2_18_0 OCa_MXN_n1_36 OCa_bbn2 OCa_MXN_n2_18 vss sg13_hv_nmos w=0.5u l=0.45u m=1
MOCa_MXN_S2_18_1 OCa_MXN_n1_37 OCa_bn2 OCa_MXN_n2_18 vss sg13_hv_nmos w=0.5u l=0.45u m=1
MOCa_MXN_S2_19_0 OCa_MXN_n1_38 OCa_bbn2 OCa_MXN_n2_19 vss sg13_hv_nmos w=0.5u l=0.45u m=1
MOCa_MXN_S2_19_1 OCa_MXN_n1_39 OCa_bn2 OCa_MXN_n2_19 vss sg13_hv_nmos w=0.5u l=0.45u m=1
MOCa_MXN_S2_20_0 OCa_MXN_n1_40 OCa_bbn2 OCa_MXN_n2_20 vss sg13_hv_nmos w=0.5u l=0.45u m=1
MOCa_MXN_S2_20_1 OCa_MXN_n1_41 OCa_bn2 OCa_MXN_n2_20 vss sg13_hv_nmos w=0.5u l=0.45u m=1
MOCa_MXN_S2_21_0 OCa_MXN_n1_42 OCa_bbn2 OCa_MXN_n2_21 vss sg13_hv_nmos w=0.5u l=0.45u m=1
MOCa_MXN_S2_21_1 OCa_MXN_n1_43 OCa_bn2 OCa_MXN_n2_21 vss sg13_hv_nmos w=0.5u l=0.45u m=1
MOCa_MXN_S2_22_0 OCa_MXN_n1_44 OCa_bbn2 OCa_MXN_n2_22 vss sg13_hv_nmos w=0.5u l=0.45u m=1
MOCa_MXN_S2_22_1 OCa_MXN_n1_45 OCa_bn2 OCa_MXN_n2_22 vss sg13_hv_nmos w=0.5u l=0.45u m=1
MOCa_MXN_S2_23_0 OCa_MXN_n1_46 OCa_bbn2 OCa_MXN_n2_23 vss sg13_hv_nmos w=0.5u l=0.45u m=1
MOCa_MXN_S2_23_1 OCa_MXN_n1_47 OCa_bn2 OCa_MXN_n2_23 vss sg13_hv_nmos w=0.5u l=0.45u m=1
MOCa_MXN_S2_24_0 OCa_MXN_n1_48 OCa_bbn2 OCa_MXN_n2_24 vss sg13_hv_nmos w=0.5u l=0.45u m=1
MOCa_MXN_S2_24_1 OCa_MXN_n1_49 OCa_bn2 OCa_MXN_n2_24 vss sg13_hv_nmos w=0.5u l=0.45u m=1
MOCa_MXN_S2_25_0 OCa_MXN_n1_50 OCa_bbn2 OCa_MXN_n2_25 vss sg13_hv_nmos w=0.5u l=0.45u m=1
MOCa_MXN_S2_25_1 OCa_MXN_n1_51 OCa_bn2 OCa_MXN_n2_25 vss sg13_hv_nmos w=0.5u l=0.45u m=1
MOCa_MXN_S2_26_0 OCa_MXN_n1_52 OCa_bbn2 OCa_MXN_n2_26 vss sg13_hv_nmos w=0.5u l=0.45u m=1
MOCa_MXN_S2_26_1 OCa_MXN_n1_53 OCa_bn2 OCa_MXN_n2_26 vss sg13_hv_nmos w=0.5u l=0.45u m=1
MOCa_MXN_S2_27_0 OCa_MXN_n1_54 OCa_bbn2 OCa_MXN_n2_27 vss sg13_hv_nmos w=0.5u l=0.45u m=1
MOCa_MXN_S2_27_1 OCa_MXN_n1_55 OCa_bn2 OCa_MXN_n2_27 vss sg13_hv_nmos w=0.5u l=0.45u m=1
MOCa_MXN_S2_28_0 OCa_MXN_n1_56 OCa_bbn2 OCa_MXN_n2_28 vss sg13_hv_nmos w=0.5u l=0.45u m=1
MOCa_MXN_S2_28_1 OCa_MXN_n1_57 OCa_bn2 OCa_MXN_n2_28 vss sg13_hv_nmos w=0.5u l=0.45u m=1
MOCa_MXN_S2_29_0 OCa_MXN_n1_58 OCa_bbn2 OCa_MXN_n2_29 vss sg13_hv_nmos w=0.5u l=0.45u m=1
MOCa_MXN_S2_29_1 OCa_MXN_n1_59 OCa_bn2 OCa_MXN_n2_29 vss sg13_hv_nmos w=0.5u l=0.45u m=1
MOCa_MXN_S2_30_0 OCa_MXN_n1_60 OCa_bbn2 OCa_MXN_n2_30 vss sg13_hv_nmos w=0.5u l=0.45u m=1
MOCa_MXN_S2_30_1 OCa_MXN_n1_61 OCa_bn2 OCa_MXN_n2_30 vss sg13_hv_nmos w=0.5u l=0.45u m=1
MOCa_MXN_S2_31_0 OCa_MXN_n1_62 OCa_bbn2 OCa_MXN_n2_31 vss sg13_hv_nmos w=0.5u l=0.45u m=1
MOCa_MXN_S2_31_1 OCa_MXN_n1_63 OCa_bn2 OCa_MXN_n2_31 vss sg13_hv_nmos w=0.5u l=0.45u m=1
MOCa_MXN_S3_0_0 OCa_MXN_n2_0 OCa_bbn3 OCa_MXN_n3_0 vss sg13_hv_nmos w=0.5u l=0.45u m=1
MOCa_MXN_S3_0_1 OCa_MXN_n2_1 OCa_bn3 OCa_MXN_n3_0 vss sg13_hv_nmos w=0.5u l=0.45u m=1
MOCa_MXN_S3_1_0 OCa_MXN_n2_2 OCa_bbn3 OCa_MXN_n3_1 vss sg13_hv_nmos w=0.5u l=0.45u m=1
MOCa_MXN_S3_1_1 OCa_MXN_n2_3 OCa_bn3 OCa_MXN_n3_1 vss sg13_hv_nmos w=0.5u l=0.45u m=1
MOCa_MXN_S3_2_0 OCa_MXN_n2_4 OCa_bbn3 OCa_MXN_n3_2 vss sg13_hv_nmos w=0.5u l=0.45u m=1
MOCa_MXN_S3_2_1 OCa_MXN_n2_5 OCa_bn3 OCa_MXN_n3_2 vss sg13_hv_nmos w=0.5u l=0.45u m=1
MOCa_MXN_S3_3_0 OCa_MXN_n2_6 OCa_bbn3 OCa_MXN_n3_3 vss sg13_hv_nmos w=0.5u l=0.45u m=1
MOCa_MXN_S3_3_1 OCa_MXN_n2_7 OCa_bn3 OCa_MXN_n3_3 vss sg13_hv_nmos w=0.5u l=0.45u m=1
MOCa_MXN_S3_4_0 OCa_MXN_n2_8 OCa_bbn3 OCa_MXN_n3_4 vss sg13_hv_nmos w=0.5u l=0.45u m=1
MOCa_MXN_S3_4_1 OCa_MXN_n2_9 OCa_bn3 OCa_MXN_n3_4 vss sg13_hv_nmos w=0.5u l=0.45u m=1
MOCa_MXN_S3_5_0 OCa_MXN_n2_10 OCa_bbn3 OCa_MXN_n3_5 vss sg13_hv_nmos w=0.5u l=0.45u m=1
MOCa_MXN_S3_5_1 OCa_MXN_n2_11 OCa_bn3 OCa_MXN_n3_5 vss sg13_hv_nmos w=0.5u l=0.45u m=1
MOCa_MXN_S3_6_0 OCa_MXN_n2_12 OCa_bbn3 OCa_MXN_n3_6 vss sg13_hv_nmos w=0.5u l=0.45u m=1
MOCa_MXN_S3_6_1 OCa_MXN_n2_13 OCa_bn3 OCa_MXN_n3_6 vss sg13_hv_nmos w=0.5u l=0.45u m=1
MOCa_MXN_S3_7_0 OCa_MXN_n2_14 OCa_bbn3 OCa_MXN_n3_7 vss sg13_hv_nmos w=0.5u l=0.45u m=1
MOCa_MXN_S3_7_1 OCa_MXN_n2_15 OCa_bn3 OCa_MXN_n3_7 vss sg13_hv_nmos w=0.5u l=0.45u m=1
MOCa_MXN_S3_8_0 OCa_MXN_n2_16 OCa_bbn3 OCa_MXN_n3_8 vss sg13_hv_nmos w=0.5u l=0.45u m=1
MOCa_MXN_S3_8_1 OCa_MXN_n2_17 OCa_bn3 OCa_MXN_n3_8 vss sg13_hv_nmos w=0.5u l=0.45u m=1
MOCa_MXN_S3_9_0 OCa_MXN_n2_18 OCa_bbn3 OCa_MXN_n3_9 vss sg13_hv_nmos w=0.5u l=0.45u m=1
MOCa_MXN_S3_9_1 OCa_MXN_n2_19 OCa_bn3 OCa_MXN_n3_9 vss sg13_hv_nmos w=0.5u l=0.45u m=1
MOCa_MXN_S3_10_0 OCa_MXN_n2_20 OCa_bbn3 OCa_MXN_n3_10 vss sg13_hv_nmos w=0.5u l=0.45u m=1
MOCa_MXN_S3_10_1 OCa_MXN_n2_21 OCa_bn3 OCa_MXN_n3_10 vss sg13_hv_nmos w=0.5u l=0.45u m=1
MOCa_MXN_S3_11_0 OCa_MXN_n2_22 OCa_bbn3 OCa_MXN_n3_11 vss sg13_hv_nmos w=0.5u l=0.45u m=1
MOCa_MXN_S3_11_1 OCa_MXN_n2_23 OCa_bn3 OCa_MXN_n3_11 vss sg13_hv_nmos w=0.5u l=0.45u m=1
MOCa_MXN_S3_12_0 OCa_MXN_n2_24 OCa_bbn3 OCa_MXN_n3_12 vss sg13_hv_nmos w=0.5u l=0.45u m=1
MOCa_MXN_S3_12_1 OCa_MXN_n2_25 OCa_bn3 OCa_MXN_n3_12 vss sg13_hv_nmos w=0.5u l=0.45u m=1
MOCa_MXN_S3_13_0 OCa_MXN_n2_26 OCa_bbn3 OCa_MXN_n3_13 vss sg13_hv_nmos w=0.5u l=0.45u m=1
MOCa_MXN_S3_13_1 OCa_MXN_n2_27 OCa_bn3 OCa_MXN_n3_13 vss sg13_hv_nmos w=0.5u l=0.45u m=1
MOCa_MXN_S3_14_0 OCa_MXN_n2_28 OCa_bbn3 OCa_MXN_n3_14 vss sg13_hv_nmos w=0.5u l=0.45u m=1
MOCa_MXN_S3_14_1 OCa_MXN_n2_29 OCa_bn3 OCa_MXN_n3_14 vss sg13_hv_nmos w=0.5u l=0.45u m=1
MOCa_MXN_S3_15_0 OCa_MXN_n2_30 OCa_bbn3 OCa_MXN_n3_15 vss sg13_hv_nmos w=0.5u l=0.45u m=1
MOCa_MXN_S3_15_1 OCa_MXN_n2_31 OCa_bn3 OCa_MXN_n3_15 vss sg13_hv_nmos w=0.5u l=0.45u m=1
MOCa_MXN_S4_0_0 OCa_MXN_n3_0 OCa_bbn4 OCa_MXN_n4_0 vss sg13_hv_nmos w=0.5u l=0.45u m=1
MOCa_MXN_S4_0_1 OCa_MXN_n3_1 OCa_bn4 OCa_MXN_n4_0 vss sg13_hv_nmos w=0.5u l=0.45u m=1
MOCa_MXN_S4_1_0 OCa_MXN_n3_2 OCa_bbn4 OCa_MXN_n4_1 vss sg13_hv_nmos w=0.5u l=0.45u m=1
MOCa_MXN_S4_1_1 OCa_MXN_n3_3 OCa_bn4 OCa_MXN_n4_1 vss sg13_hv_nmos w=0.5u l=0.45u m=1
MOCa_MXN_S4_2_0 OCa_MXN_n3_4 OCa_bbn4 OCa_MXN_n4_2 vss sg13_hv_nmos w=0.5u l=0.45u m=1
MOCa_MXN_S4_2_1 OCa_MXN_n3_5 OCa_bn4 OCa_MXN_n4_2 vss sg13_hv_nmos w=0.5u l=0.45u m=1
MOCa_MXN_S4_3_0 OCa_MXN_n3_6 OCa_bbn4 OCa_MXN_n4_3 vss sg13_hv_nmos w=0.5u l=0.45u m=1
MOCa_MXN_S4_3_1 OCa_MXN_n3_7 OCa_bn4 OCa_MXN_n4_3 vss sg13_hv_nmos w=0.5u l=0.45u m=1
MOCa_MXN_S4_4_0 OCa_MXN_n3_8 OCa_bbn4 OCa_MXN_n4_4 vss sg13_hv_nmos w=0.5u l=0.45u m=1
MOCa_MXN_S4_4_1 OCa_MXN_n3_9 OCa_bn4 OCa_MXN_n4_4 vss sg13_hv_nmos w=0.5u l=0.45u m=1
MOCa_MXN_S4_5_0 OCa_MXN_n3_10 OCa_bbn4 OCa_MXN_n4_5 vss sg13_hv_nmos w=0.5u l=0.45u m=1
MOCa_MXN_S4_5_1 OCa_MXN_n3_11 OCa_bn4 OCa_MXN_n4_5 vss sg13_hv_nmos w=0.5u l=0.45u m=1
MOCa_MXN_S4_6_0 OCa_MXN_n3_12 OCa_bbn4 OCa_MXN_n4_6 vss sg13_hv_nmos w=0.5u l=0.45u m=1
MOCa_MXN_S4_6_1 OCa_MXN_n3_13 OCa_bn4 OCa_MXN_n4_6 vss sg13_hv_nmos w=0.5u l=0.45u m=1
MOCa_MXN_S4_7_0 OCa_MXN_n3_14 OCa_bbn4 OCa_MXN_n4_7 vss sg13_hv_nmos w=0.5u l=0.45u m=1
MOCa_MXN_S4_7_1 OCa_MXN_n3_15 OCa_bn4 OCa_MXN_n4_7 vss sg13_hv_nmos w=0.5u l=0.45u m=1
MOCa_MXN_S5_0_0 OCa_MXN_n4_0 OCa_bbn5 OCa_MXN_n5_0 vss sg13_hv_nmos w=0.5u l=0.45u m=1
MOCa_MXN_S5_0_1 OCa_MXN_n4_1 OCa_bn5 OCa_MXN_n5_0 vss sg13_hv_nmos w=0.5u l=0.45u m=1
MOCa_MXN_S5_1_0 OCa_MXN_n4_2 OCa_bbn5 OCa_MXN_n5_1 vss sg13_hv_nmos w=0.5u l=0.45u m=1
MOCa_MXN_S5_1_1 OCa_MXN_n4_3 OCa_bn5 OCa_MXN_n5_1 vss sg13_hv_nmos w=0.5u l=0.45u m=1
MOCa_MXN_S5_2_0 OCa_MXN_n4_4 OCa_bbn5 OCa_MXN_n5_2 vss sg13_hv_nmos w=0.5u l=0.45u m=1
MOCa_MXN_S5_2_1 OCa_MXN_n4_5 OCa_bn5 OCa_MXN_n5_2 vss sg13_hv_nmos w=0.5u l=0.45u m=1
MOCa_MXN_S5_3_0 OCa_MXN_n4_6 OCa_bbn5 OCa_MXN_n5_3 vss sg13_hv_nmos w=0.5u l=0.45u m=1
MOCa_MXN_S5_3_1 OCa_MXN_n4_7 OCa_bn5 OCa_MXN_n5_3 vss sg13_hv_nmos w=0.5u l=0.45u m=1
MOCa_MXN_S6_0_0 OCa_MXN_n5_0 OCa_bbn6 OCa_MXN_n6_0 vss sg13_hv_nmos w=0.5u l=0.45u m=1
MOCa_MXN_S6_0_1 OCa_MXN_n5_1 OCa_bn6 OCa_MXN_n6_0 vss sg13_hv_nmos w=0.5u l=0.45u m=1
MOCa_MXN_S6_1_0 OCa_MXN_n5_2 OCa_bbn6 OCa_MXN_n6_1 vss sg13_hv_nmos w=0.5u l=0.45u m=1
MOCa_MXN_S6_1_1 OCa_MXN_n5_3 OCa_bn6 OCa_MXN_n6_1 vss sg13_hv_nmos w=0.5u l=0.45u m=1
MOCa_MXN_S7_0_0 OCa_MXN_n6_0 OCa_bbn7 OCa_refn vss sg13_hv_nmos w=0.5u l=0.45u m=1
MOCa_MXN_S7_0_1 OCa_MXN_n6_1 OCa_bn7 OCa_refn vss sg13_hv_nmos w=0.5u l=0.45u m=1
MOCa_CMP_MBN ibias_oa ibias_oa vss vss sg13_hv_nmos w=4u l=1u m=1
MOCa_CMP_MB2 OCa_CMP_vbp ibias_oa vss vss sg13_hv_nmos w=4u l=1u m=1
MOCa_CMP_MBP OCa_CMP_vbp OCa_CMP_vbp vdda vdda sg13_hv_pmos w=4u l=2u m=1
MOCa_CMP_MTA_m0 OCa_CMP_ta OCa_CMP_vbp vdda vdda sg13_hv_pmos w=4u l=2u m=1
MOCa_CMP_MTA_m1 OCa_CMP_ta OCa_CMP_vbp vdda vdda sg13_hv_pmos w=4u l=2u m=1
MOCa_CMP_MTA_m2 OCa_CMP_ta OCa_CMP_vbp vdda vdda sg13_hv_pmos w=4u l=2u m=1
MOCa_CMP_MTA_m3 OCa_CMP_ta OCa_CMP_vbp vdda vdda sg13_hv_pmos w=4u l=2u m=1
MOCa_CMP_MTA_m4 OCa_CMP_ta OCa_CMP_vbp vdda vdda sg13_hv_pmos w=4u l=2u m=1
MOCa_CMP_MTA_m5 OCa_CMP_ta OCa_CMP_vbp vdda vdda sg13_hv_pmos w=4u l=2u m=1
MOCa_CMP_MTA_m6 OCa_CMP_ta OCa_CMP_vbp vdda vdda sg13_hv_pmos w=4u l=2u m=1
MOCa_CMP_MTA_m7 OCa_CMP_ta OCa_CMP_vbp vdda vdda sg13_hv_pmos w=4u l=2u m=1
MOCa_CMP_MTB_m0 OCa_CMP_tb OCa_CMP_vbp vdda vdda sg13_hv_pmos w=4u l=2u m=1
MOCa_CMP_MTB_m1 OCa_CMP_tb OCa_CMP_vbp vdda vdda sg13_hv_pmos w=4u l=2u m=1
MOCa_CMP_MTB_m2 OCa_CMP_tb OCa_CMP_vbp vdda vdda sg13_hv_pmos w=4u l=2u m=1
MOCa_CMP_MTB_m3 OCa_CMP_tb OCa_CMP_vbp vdda vdda sg13_hv_pmos w=4u l=2u m=1
MOCa_CMP_MTB_m4 OCa_CMP_tb OCa_CMP_vbp vdda vdda sg13_hv_pmos w=4u l=2u m=1
MOCa_CMP_MTB_m5 OCa_CMP_tb OCa_CMP_vbp vdda vdda sg13_hv_pmos w=4u l=2u m=1
MOCa_CMP_MTB_m6 OCa_CMP_tb OCa_CMP_vbp vdda vdda sg13_hv_pmos w=4u l=2u m=1
MOCa_CMP_MTB_m7 OCa_CMP_tb OCa_CMP_vbp vdda vdda sg13_hv_pmos w=4u l=2u m=1
MOCa_CMP_MA1 OCa_CMP_d1 outa_p OCa_CMP_sa1 OCa_CMP_ta sg13_hv_pmos w=20u l=2u m=1
MOCa_CMP_MA2 OCa_CMP_d2 outa_n OCa_CMP_sa2 OCa_CMP_ta sg13_hv_pmos w=20u l=2u m=1
ROCa_CMP_RA1 OCa_CMP_ta OCa_CMP_sa1 vss rppd w=2u l=308u b=0 m=1
ROCa_CMP_RA2 OCa_CMP_ta OCa_CMP_sa2 vss rppd w=2u l=308u b=0 m=1
MOCa_CMP_MB1 OCa_CMP_d1 OCa_refn OCa_CMP_sb1 OCa_CMP_tb sg13_hv_pmos w=20u l=2u m=1
MOCa_CMP_MB2I OCa_CMP_d2 OCa_refp OCa_CMP_sb2 OCa_CMP_tb sg13_hv_pmos w=20u l=2u m=1
ROCa_CMP_RB1 OCa_CMP_tb OCa_CMP_sb1 vss rppd w=2u l=308u b=0 m=1
ROCa_CMP_RB2 OCa_CMP_tb OCa_CMP_sb2 vss rppd w=2u l=308u b=0 m=1
MOCa_CMP_ML1 OCa_CMP_d1 OCa_CMP_d1 vss vss sg13_hv_nmos w=40u l=10u m=1
MOCa_CMP_ML2 OCa_CMP_d2 OCa_CMP_d1 vss vss sg13_hv_nmos w=40u l=10u m=1
MOCa_CMP_MG OCa_CMP_o1 OCa_CMP_d2 vss vss sg13_hv_nmos w=2u l=2u m=1
MOCa_CMP_MGL_m0 OCa_CMP_o1 OCa_CMP_vbp vdda vdda sg13_hv_pmos w=4u l=2u m=1
MOCa_CMP_MGL_m1 OCa_CMP_o1 OCa_CMP_vbp vdda vdda sg13_hv_pmos w=4u l=2u m=1
MOCa_CMP_MI1P OCa_CMP_o2 OCa_CMP_o1 vdda vdda sg13_hv_pmos w=2u l=0.5u m=1
MOCa_CMP_MI1N OCa_CMP_o2 OCa_CMP_o1 vss vss sg13_hv_nmos w=1u l=0.45u m=1
MOCa_CMP_MH1a OCa_CMP_hn1 OCa_CMP_vbp vdda vdda sg13_hv_pmos w=0.5u l=8u m=1
MOCa_CMP_MH1b OCa_CMP_hn2 OCa_CMP_vbp OCa_CMP_hn1 vdda sg13_hv_pmos w=0.5u l=8u m=1
MOCa_CMP_MH1c OCa_CMP_hs OCa_CMP_vbp OCa_CMP_hn2 vdda sg13_hv_pmos w=0.5u l=8u m=1
MOCa_CMP_MH2 OCa_CMP_d2 OCa_CMP_o1 OCa_CMP_hs vdda sg13_hv_pmos w=1u l=0.5u m=1
MOCa_CMP_MH3 OCa_CMP_d1 OCa_CMP_o2 OCa_CMP_hs vdda sg13_hv_pmos w=1u l=0.5u m=1
MOCa_CMP_MD1P OCa_CMP_o3 OCa_CMP_o2 vdd vdd sg13_hv_pmos w=2u l=0.5u m=1
MOCa_CMP_MD1N OCa_CMP_o3 OCa_CMP_o2 vss vss sg13_hv_nmos w=1u l=0.45u m=1
MOCa_CMP_MD2P oc_a OCa_CMP_o3 vdd vdd sg13_lv_pmos w=1u l=0.13u m=1
MOCa_CMP_MD2N oc_a OCa_CMP_o3 vss vss sg13_lv_nmos w=0.5u l=0.13u m=1
MNGa_LSP0_MIP NGa_LSP0_inb na_p0 vdd vdd sg13_lv_pmos w=1u l=0.13u m=1
MNGa_LSP0_MIN NGa_LSP0_inb na_p0 vss vss sg13_lv_nmos w=0.5u l=0.13u m=1
MNGa_LSP0_MN1 NGa_LSP0_a na_p0 vss vss sg13_hv_nmos w=4u l=0.45u m=1
MNGa_LSP0_MN2 NGa_LSP0_b NGa_LSP0_inb vss vss sg13_hv_nmos w=4u l=0.45u m=1
MNGa_LSP0_MP1 NGa_LSP0_a NGa_LSP0_b vdda vdda sg13_hv_pmos w=0.6u l=0.5u m=1
MNGa_LSP0_MP2 NGa_LSP0_b NGa_LSP0_a vdda vdda sg13_hv_pmos w=0.6u l=0.5u m=1
MNGa_LSP0_MB1P NGa_bbp0 NGa_LSP0_b vdda vdda sg13_hv_pmos w=2u l=0.5u m=1
MNGa_LSP0_MB1N NGa_bbp0 NGa_LSP0_b vss vss sg13_hv_nmos w=1u l=0.45u m=1
MNGa_LSP0_MB2P NGa_bp0 NGa_bbp0 vdda vdda sg13_hv_pmos w=2u l=0.5u m=1
MNGa_LSP0_MB2N NGa_bp0 NGa_bbp0 vss vss sg13_hv_nmos w=1u l=0.45u m=1
MNGa_LSN0_MIP NGa_LSN0_inb na_n0 vdd vdd sg13_lv_pmos w=1u l=0.13u m=1
MNGa_LSN0_MIN NGa_LSN0_inb na_n0 vss vss sg13_lv_nmos w=0.5u l=0.13u m=1
MNGa_LSN0_MN1 NGa_LSN0_a na_n0 vss vss sg13_hv_nmos w=4u l=0.45u m=1
MNGa_LSN0_MN2 NGa_LSN0_b NGa_LSN0_inb vss vss sg13_hv_nmos w=4u l=0.45u m=1
MNGa_LSN0_MP1 NGa_LSN0_a NGa_LSN0_b vdda vdda sg13_hv_pmos w=0.6u l=0.5u m=1
MNGa_LSN0_MP2 NGa_LSN0_b NGa_LSN0_a vdda vdda sg13_hv_pmos w=0.6u l=0.5u m=1
MNGa_LSN0_MB1P NGa_bbn0 NGa_LSN0_b vdda vdda sg13_hv_pmos w=2u l=0.5u m=1
MNGa_LSN0_MB1N NGa_bbn0 NGa_LSN0_b vss vss sg13_hv_nmos w=1u l=0.45u m=1
MNGa_LSN0_MB2P NGa_bn0 NGa_bbn0 vdda vdda sg13_hv_pmos w=2u l=0.5u m=1
MNGa_LSN0_MB2N NGa_bn0 NGa_bbn0 vss vss sg13_hv_nmos w=1u l=0.45u m=1
MNGa_LSP1_MIP NGa_LSP1_inb na_p1 vdd vdd sg13_lv_pmos w=1u l=0.13u m=1
MNGa_LSP1_MIN NGa_LSP1_inb na_p1 vss vss sg13_lv_nmos w=0.5u l=0.13u m=1
MNGa_LSP1_MN1 NGa_LSP1_a na_p1 vss vss sg13_hv_nmos w=4u l=0.45u m=1
MNGa_LSP1_MN2 NGa_LSP1_b NGa_LSP1_inb vss vss sg13_hv_nmos w=4u l=0.45u m=1
MNGa_LSP1_MP1 NGa_LSP1_a NGa_LSP1_b vdda vdda sg13_hv_pmos w=0.6u l=0.5u m=1
MNGa_LSP1_MP2 NGa_LSP1_b NGa_LSP1_a vdda vdda sg13_hv_pmos w=0.6u l=0.5u m=1
MNGa_LSP1_MB1P NGa_bbp1 NGa_LSP1_b vdda vdda sg13_hv_pmos w=2u l=0.5u m=1
MNGa_LSP1_MB1N NGa_bbp1 NGa_LSP1_b vss vss sg13_hv_nmos w=1u l=0.45u m=1
MNGa_LSP1_MB2P NGa_bp1 NGa_bbp1 vdda vdda sg13_hv_pmos w=2u l=0.5u m=1
MNGa_LSP1_MB2N NGa_bp1 NGa_bbp1 vss vss sg13_hv_nmos w=1u l=0.45u m=1
MNGa_LSN1_MIP NGa_LSN1_inb na_n1 vdd vdd sg13_lv_pmos w=1u l=0.13u m=1
MNGa_LSN1_MIN NGa_LSN1_inb na_n1 vss vss sg13_lv_nmos w=0.5u l=0.13u m=1
MNGa_LSN1_MN1 NGa_LSN1_a na_n1 vss vss sg13_hv_nmos w=4u l=0.45u m=1
MNGa_LSN1_MN2 NGa_LSN1_b NGa_LSN1_inb vss vss sg13_hv_nmos w=4u l=0.45u m=1
MNGa_LSN1_MP1 NGa_LSN1_a NGa_LSN1_b vdda vdda sg13_hv_pmos w=0.6u l=0.5u m=1
MNGa_LSN1_MP2 NGa_LSN1_b NGa_LSN1_a vdda vdda sg13_hv_pmos w=0.6u l=0.5u m=1
MNGa_LSN1_MB1P NGa_bbn1 NGa_LSN1_b vdda vdda sg13_hv_pmos w=2u l=0.5u m=1
MNGa_LSN1_MB1N NGa_bbn1 NGa_LSN1_b vss vss sg13_hv_nmos w=1u l=0.45u m=1
MNGa_LSN1_MB2P NGa_bn1 NGa_bbn1 vdda vdda sg13_hv_pmos w=2u l=0.5u m=1
MNGa_LSN1_MB2N NGa_bn1 NGa_bbn1 vss vss sg13_hv_nmos w=1u l=0.45u m=1
MNGa_LSP2_MIP NGa_LSP2_inb na_p2 vdd vdd sg13_lv_pmos w=1u l=0.13u m=1
MNGa_LSP2_MIN NGa_LSP2_inb na_p2 vss vss sg13_lv_nmos w=0.5u l=0.13u m=1
MNGa_LSP2_MN1 NGa_LSP2_a na_p2 vss vss sg13_hv_nmos w=4u l=0.45u m=1
MNGa_LSP2_MN2 NGa_LSP2_b NGa_LSP2_inb vss vss sg13_hv_nmos w=4u l=0.45u m=1
MNGa_LSP2_MP1 NGa_LSP2_a NGa_LSP2_b vdda vdda sg13_hv_pmos w=0.6u l=0.5u m=1
MNGa_LSP2_MP2 NGa_LSP2_b NGa_LSP2_a vdda vdda sg13_hv_pmos w=0.6u l=0.5u m=1
MNGa_LSP2_MB1P NGa_bbp2 NGa_LSP2_b vdda vdda sg13_hv_pmos w=2u l=0.5u m=1
MNGa_LSP2_MB1N NGa_bbp2 NGa_LSP2_b vss vss sg13_hv_nmos w=1u l=0.45u m=1
MNGa_LSP2_MB2P NGa_bp2 NGa_bbp2 vdda vdda sg13_hv_pmos w=2u l=0.5u m=1
MNGa_LSP2_MB2N NGa_bp2 NGa_bbp2 vss vss sg13_hv_nmos w=1u l=0.45u m=1
MNGa_LSN2_MIP NGa_LSN2_inb na_n2 vdd vdd sg13_lv_pmos w=1u l=0.13u m=1
MNGa_LSN2_MIN NGa_LSN2_inb na_n2 vss vss sg13_lv_nmos w=0.5u l=0.13u m=1
MNGa_LSN2_MN1 NGa_LSN2_a na_n2 vss vss sg13_hv_nmos w=4u l=0.45u m=1
MNGa_LSN2_MN2 NGa_LSN2_b NGa_LSN2_inb vss vss sg13_hv_nmos w=4u l=0.45u m=1
MNGa_LSN2_MP1 NGa_LSN2_a NGa_LSN2_b vdda vdda sg13_hv_pmos w=0.6u l=0.5u m=1
MNGa_LSN2_MP2 NGa_LSN2_b NGa_LSN2_a vdda vdda sg13_hv_pmos w=0.6u l=0.5u m=1
MNGa_LSN2_MB1P NGa_bbn2 NGa_LSN2_b vdda vdda sg13_hv_pmos w=2u l=0.5u m=1
MNGa_LSN2_MB1N NGa_bbn2 NGa_LSN2_b vss vss sg13_hv_nmos w=1u l=0.45u m=1
MNGa_LSN2_MB2P NGa_bn2 NGa_bbn2 vdda vdda sg13_hv_pmos w=2u l=0.5u m=1
MNGa_LSN2_MB2N NGa_bn2 NGa_bbn2 vss vss sg13_hv_nmos w=1u l=0.45u m=1
MNGa_LSP3_MIP NGa_LSP3_inb na_p3 vdd vdd sg13_lv_pmos w=1u l=0.13u m=1
MNGa_LSP3_MIN NGa_LSP3_inb na_p3 vss vss sg13_lv_nmos w=0.5u l=0.13u m=1
MNGa_LSP3_MN1 NGa_LSP3_a na_p3 vss vss sg13_hv_nmos w=4u l=0.45u m=1
MNGa_LSP3_MN2 NGa_LSP3_b NGa_LSP3_inb vss vss sg13_hv_nmos w=4u l=0.45u m=1
MNGa_LSP3_MP1 NGa_LSP3_a NGa_LSP3_b vdda vdda sg13_hv_pmos w=0.6u l=0.5u m=1
MNGa_LSP3_MP2 NGa_LSP3_b NGa_LSP3_a vdda vdda sg13_hv_pmos w=0.6u l=0.5u m=1
MNGa_LSP3_MB1P NGa_bbp3 NGa_LSP3_b vdda vdda sg13_hv_pmos w=2u l=0.5u m=1
MNGa_LSP3_MB1N NGa_bbp3 NGa_LSP3_b vss vss sg13_hv_nmos w=1u l=0.45u m=1
MNGa_LSP3_MB2P NGa_bp3 NGa_bbp3 vdda vdda sg13_hv_pmos w=2u l=0.5u m=1
MNGa_LSP3_MB2N NGa_bp3 NGa_bbp3 vss vss sg13_hv_nmos w=1u l=0.45u m=1
MNGa_LSN3_MIP NGa_LSN3_inb na_n3 vdd vdd sg13_lv_pmos w=1u l=0.13u m=1
MNGa_LSN3_MIN NGa_LSN3_inb na_n3 vss vss sg13_lv_nmos w=0.5u l=0.13u m=1
MNGa_LSN3_MN1 NGa_LSN3_a na_n3 vss vss sg13_hv_nmos w=4u l=0.45u m=1
MNGa_LSN3_MN2 NGa_LSN3_b NGa_LSN3_inb vss vss sg13_hv_nmos w=4u l=0.45u m=1
MNGa_LSN3_MP1 NGa_LSN3_a NGa_LSN3_b vdda vdda sg13_hv_pmos w=0.6u l=0.5u m=1
MNGa_LSN3_MP2 NGa_LSN3_b NGa_LSN3_a vdda vdda sg13_hv_pmos w=0.6u l=0.5u m=1
MNGa_LSN3_MB1P NGa_bbn3 NGa_LSN3_b vdda vdda sg13_hv_pmos w=2u l=0.5u m=1
MNGa_LSN3_MB1N NGa_bbn3 NGa_LSN3_b vss vss sg13_hv_nmos w=1u l=0.45u m=1
MNGa_LSN3_MB2P NGa_bn3 NGa_bbn3 vdda vdda sg13_hv_pmos w=2u l=0.5u m=1
MNGa_LSN3_MB2N NGa_bn3 NGa_bbn3 vss vss sg13_hv_nmos w=1u l=0.45u m=1
MNGa_LSP4_MIP NGa_LSP4_inb na_p4 vdd vdd sg13_lv_pmos w=1u l=0.13u m=1
MNGa_LSP4_MIN NGa_LSP4_inb na_p4 vss vss sg13_lv_nmos w=0.5u l=0.13u m=1
MNGa_LSP4_MN1 NGa_LSP4_a na_p4 vss vss sg13_hv_nmos w=4u l=0.45u m=1
MNGa_LSP4_MN2 NGa_LSP4_b NGa_LSP4_inb vss vss sg13_hv_nmos w=4u l=0.45u m=1
MNGa_LSP4_MP1 NGa_LSP4_a NGa_LSP4_b vdda vdda sg13_hv_pmos w=0.6u l=0.5u m=1
MNGa_LSP4_MP2 NGa_LSP4_b NGa_LSP4_a vdda vdda sg13_hv_pmos w=0.6u l=0.5u m=1
MNGa_LSP4_MB1P NGa_bbp4 NGa_LSP4_b vdda vdda sg13_hv_pmos w=2u l=0.5u m=1
MNGa_LSP4_MB1N NGa_bbp4 NGa_LSP4_b vss vss sg13_hv_nmos w=1u l=0.45u m=1
MNGa_LSP4_MB2P NGa_bp4 NGa_bbp4 vdda vdda sg13_hv_pmos w=2u l=0.5u m=1
MNGa_LSP4_MB2N NGa_bp4 NGa_bbp4 vss vss sg13_hv_nmos w=1u l=0.45u m=1
MNGa_LSN4_MIP NGa_LSN4_inb na_n4 vdd vdd sg13_lv_pmos w=1u l=0.13u m=1
MNGa_LSN4_MIN NGa_LSN4_inb na_n4 vss vss sg13_lv_nmos w=0.5u l=0.13u m=1
MNGa_LSN4_MN1 NGa_LSN4_a na_n4 vss vss sg13_hv_nmos w=4u l=0.45u m=1
MNGa_LSN4_MN2 NGa_LSN4_b NGa_LSN4_inb vss vss sg13_hv_nmos w=4u l=0.45u m=1
MNGa_LSN4_MP1 NGa_LSN4_a NGa_LSN4_b vdda vdda sg13_hv_pmos w=0.6u l=0.5u m=1
MNGa_LSN4_MP2 NGa_LSN4_b NGa_LSN4_a vdda vdda sg13_hv_pmos w=0.6u l=0.5u m=1
MNGa_LSN4_MB1P NGa_bbn4 NGa_LSN4_b vdda vdda sg13_hv_pmos w=2u l=0.5u m=1
MNGa_LSN4_MB1N NGa_bbn4 NGa_LSN4_b vss vss sg13_hv_nmos w=1u l=0.45u m=1
MNGa_LSN4_MB2P NGa_bn4 NGa_bbn4 vdda vdda sg13_hv_pmos w=2u l=0.5u m=1
MNGa_LSN4_MB2N NGa_bn4 NGa_bbn4 vss vss sg13_hv_nmos w=1u l=0.45u m=1
MNGa_LSP5_MIP NGa_LSP5_inb na_p5 vdd vdd sg13_lv_pmos w=1u l=0.13u m=1
MNGa_LSP5_MIN NGa_LSP5_inb na_p5 vss vss sg13_lv_nmos w=0.5u l=0.13u m=1
MNGa_LSP5_MN1 NGa_LSP5_a na_p5 vss vss sg13_hv_nmos w=4u l=0.45u m=1
MNGa_LSP5_MN2 NGa_LSP5_b NGa_LSP5_inb vss vss sg13_hv_nmos w=4u l=0.45u m=1
MNGa_LSP5_MP1 NGa_LSP5_a NGa_LSP5_b vdda vdda sg13_hv_pmos w=0.6u l=0.5u m=1
MNGa_LSP5_MP2 NGa_LSP5_b NGa_LSP5_a vdda vdda sg13_hv_pmos w=0.6u l=0.5u m=1
MNGa_LSP5_MB1P NGa_bbp5 NGa_LSP5_b vdda vdda sg13_hv_pmos w=2u l=0.5u m=1
MNGa_LSP5_MB1N NGa_bbp5 NGa_LSP5_b vss vss sg13_hv_nmos w=1u l=0.45u m=1
MNGa_LSP5_MB2P NGa_bp5 NGa_bbp5 vdda vdda sg13_hv_pmos w=2u l=0.5u m=1
MNGa_LSP5_MB2N NGa_bp5 NGa_bbp5 vss vss sg13_hv_nmos w=1u l=0.45u m=1
MNGa_LSN5_MIP NGa_LSN5_inb na_n5 vdd vdd sg13_lv_pmos w=1u l=0.13u m=1
MNGa_LSN5_MIN NGa_LSN5_inb na_n5 vss vss sg13_lv_nmos w=0.5u l=0.13u m=1
MNGa_LSN5_MN1 NGa_LSN5_a na_n5 vss vss sg13_hv_nmos w=4u l=0.45u m=1
MNGa_LSN5_MN2 NGa_LSN5_b NGa_LSN5_inb vss vss sg13_hv_nmos w=4u l=0.45u m=1
MNGa_LSN5_MP1 NGa_LSN5_a NGa_LSN5_b vdda vdda sg13_hv_pmos w=0.6u l=0.5u m=1
MNGa_LSN5_MP2 NGa_LSN5_b NGa_LSN5_a vdda vdda sg13_hv_pmos w=0.6u l=0.5u m=1
MNGa_LSN5_MB1P NGa_bbn5 NGa_LSN5_b vdda vdda sg13_hv_pmos w=2u l=0.5u m=1
MNGa_LSN5_MB1N NGa_bbn5 NGa_LSN5_b vss vss sg13_hv_nmos w=1u l=0.45u m=1
MNGa_LSN5_MB2P NGa_bn5 NGa_bbn5 vdda vdda sg13_hv_pmos w=2u l=0.5u m=1
MNGa_LSN5_MB2N NGa_bn5 NGa_bbn5 vss vss sg13_hv_nmos w=1u l=0.45u m=1
MNGa_LSP6_MIP NGa_LSP6_inb na_p6 vdd vdd sg13_lv_pmos w=1u l=0.13u m=1
MNGa_LSP6_MIN NGa_LSP6_inb na_p6 vss vss sg13_lv_nmos w=0.5u l=0.13u m=1
MNGa_LSP6_MN1 NGa_LSP6_a na_p6 vss vss sg13_hv_nmos w=4u l=0.45u m=1
MNGa_LSP6_MN2 NGa_LSP6_b NGa_LSP6_inb vss vss sg13_hv_nmos w=4u l=0.45u m=1
MNGa_LSP6_MP1 NGa_LSP6_a NGa_LSP6_b vdda vdda sg13_hv_pmos w=0.6u l=0.5u m=1
MNGa_LSP6_MP2 NGa_LSP6_b NGa_LSP6_a vdda vdda sg13_hv_pmos w=0.6u l=0.5u m=1
MNGa_LSP6_MB1P NGa_bbp6 NGa_LSP6_b vdda vdda sg13_hv_pmos w=2u l=0.5u m=1
MNGa_LSP6_MB1N NGa_bbp6 NGa_LSP6_b vss vss sg13_hv_nmos w=1u l=0.45u m=1
MNGa_LSP6_MB2P NGa_bp6 NGa_bbp6 vdda vdda sg13_hv_pmos w=2u l=0.5u m=1
MNGa_LSP6_MB2N NGa_bp6 NGa_bbp6 vss vss sg13_hv_nmos w=1u l=0.45u m=1
MNGa_LSN6_MIP NGa_LSN6_inb na_n6 vdd vdd sg13_lv_pmos w=1u l=0.13u m=1
MNGa_LSN6_MIN NGa_LSN6_inb na_n6 vss vss sg13_lv_nmos w=0.5u l=0.13u m=1
MNGa_LSN6_MN1 NGa_LSN6_a na_n6 vss vss sg13_hv_nmos w=4u l=0.45u m=1
MNGa_LSN6_MN2 NGa_LSN6_b NGa_LSN6_inb vss vss sg13_hv_nmos w=4u l=0.45u m=1
MNGa_LSN6_MP1 NGa_LSN6_a NGa_LSN6_b vdda vdda sg13_hv_pmos w=0.6u l=0.5u m=1
MNGa_LSN6_MP2 NGa_LSN6_b NGa_LSN6_a vdda vdda sg13_hv_pmos w=0.6u l=0.5u m=1
MNGa_LSN6_MB1P NGa_bbn6 NGa_LSN6_b vdda vdda sg13_hv_pmos w=2u l=0.5u m=1
MNGa_LSN6_MB1N NGa_bbn6 NGa_LSN6_b vss vss sg13_hv_nmos w=1u l=0.45u m=1
MNGa_LSN6_MB2P NGa_bn6 NGa_bbn6 vdda vdda sg13_hv_pmos w=2u l=0.5u m=1
MNGa_LSN6_MB2N NGa_bn6 NGa_bbn6 vss vss sg13_hv_nmos w=1u l=0.45u m=1
MNGa_LSP7_MIP NGa_LSP7_inb na_p7 vdd vdd sg13_lv_pmos w=1u l=0.13u m=1
MNGa_LSP7_MIN NGa_LSP7_inb na_p7 vss vss sg13_lv_nmos w=0.5u l=0.13u m=1
MNGa_LSP7_MN1 NGa_LSP7_a na_p7 vss vss sg13_hv_nmos w=4u l=0.45u m=1
MNGa_LSP7_MN2 NGa_LSP7_b NGa_LSP7_inb vss vss sg13_hv_nmos w=4u l=0.45u m=1
MNGa_LSP7_MP1 NGa_LSP7_a NGa_LSP7_b vdda vdda sg13_hv_pmos w=0.6u l=0.5u m=1
MNGa_LSP7_MP2 NGa_LSP7_b NGa_LSP7_a vdda vdda sg13_hv_pmos w=0.6u l=0.5u m=1
MNGa_LSP7_MB1P NGa_bbp7 NGa_LSP7_b vdda vdda sg13_hv_pmos w=2u l=0.5u m=1
MNGa_LSP7_MB1N NGa_bbp7 NGa_LSP7_b vss vss sg13_hv_nmos w=1u l=0.45u m=1
MNGa_LSP7_MB2P NGa_bp7 NGa_bbp7 vdda vdda sg13_hv_pmos w=2u l=0.5u m=1
MNGa_LSP7_MB2N NGa_bp7 NGa_bbp7 vss vss sg13_hv_nmos w=1u l=0.45u m=1
MNGa_LSN7_MIP NGa_LSN7_inb na_n7 vdd vdd sg13_lv_pmos w=1u l=0.13u m=1
MNGa_LSN7_MIN NGa_LSN7_inb na_n7 vss vss sg13_lv_nmos w=0.5u l=0.13u m=1
MNGa_LSN7_MN1 NGa_LSN7_a na_n7 vss vss sg13_hv_nmos w=4u l=0.45u m=1
MNGa_LSN7_MN2 NGa_LSN7_b NGa_LSN7_inb vss vss sg13_hv_nmos w=4u l=0.45u m=1
MNGa_LSN7_MP1 NGa_LSN7_a NGa_LSN7_b vdda vdda sg13_hv_pmos w=0.6u l=0.5u m=1
MNGa_LSN7_MP2 NGa_LSN7_b NGa_LSN7_a vdda vdda sg13_hv_pmos w=0.6u l=0.5u m=1
MNGa_LSN7_MB1P NGa_bbn7 NGa_LSN7_b vdda vdda sg13_hv_pmos w=2u l=0.5u m=1
MNGa_LSN7_MB1N NGa_bbn7 NGa_LSN7_b vss vss sg13_hv_nmos w=1u l=0.45u m=1
MNGa_LSN7_MB2P NGa_bn7 NGa_bbn7 vdda vdda sg13_hv_pmos w=2u l=0.5u m=1
MNGa_LSN7_MB2N NGa_bn7 NGa_bbn7 vss vss sg13_hv_nmos w=1u l=0.45u m=1
MNGa_MXP_S0_0_0 vss NGa_bbp0 NGa_MXP_n0_0 vss sg13_hv_nmos w=0.5u l=0.45u m=1
MNGa_MXP_S0_0_1 t1 NGa_bp0 NGa_MXP_n0_0 vss sg13_hv_nmos w=0.5u l=0.45u m=1
MNGa_MXP_S0_1_0 t2 NGa_bbp0 NGa_MXP_n0_1 vss sg13_hv_nmos w=0.5u l=0.45u m=1
MNGa_MXP_S0_1_1 t3 NGa_bp0 NGa_MXP_n0_1 vss sg13_hv_nmos w=0.5u l=0.45u m=1
MNGa_MXP_S0_2_0 t4 NGa_bbp0 NGa_MXP_n0_2 vss sg13_hv_nmos w=0.5u l=0.45u m=1
MNGa_MXP_S0_2_1 t5 NGa_bp0 NGa_MXP_n0_2 vss sg13_hv_nmos w=0.5u l=0.45u m=1
MNGa_MXP_S0_3_0 t6 NGa_bbp0 NGa_MXP_n0_3 vss sg13_hv_nmos w=0.5u l=0.45u m=1
MNGa_MXP_S0_3_1 t7 NGa_bp0 NGa_MXP_n0_3 vss sg13_hv_nmos w=0.5u l=0.45u m=1
MNGa_MXP_S0_4_0 t8 NGa_bbp0 NGa_MXP_n0_4 vss sg13_hv_nmos w=0.5u l=0.45u m=1
MNGa_MXP_S0_4_1 t9 NGa_bp0 NGa_MXP_n0_4 vss sg13_hv_nmos w=0.5u l=0.45u m=1
MNGa_MXP_S0_5_0 t10 NGa_bbp0 NGa_MXP_n0_5 vss sg13_hv_nmos w=0.5u l=0.45u m=1
MNGa_MXP_S0_5_1 t11 NGa_bp0 NGa_MXP_n0_5 vss sg13_hv_nmos w=0.5u l=0.45u m=1
MNGa_MXP_S0_6_0 t12 NGa_bbp0 NGa_MXP_n0_6 vss sg13_hv_nmos w=0.5u l=0.45u m=1
MNGa_MXP_S0_6_1 t13 NGa_bp0 NGa_MXP_n0_6 vss sg13_hv_nmos w=0.5u l=0.45u m=1
MNGa_MXP_S0_7_0 t14 NGa_bbp0 NGa_MXP_n0_7 vss sg13_hv_nmos w=0.5u l=0.45u m=1
MNGa_MXP_S0_7_1 t15 NGa_bp0 NGa_MXP_n0_7 vss sg13_hv_nmos w=0.5u l=0.45u m=1
MNGa_MXP_S0_8_0 t16 NGa_bbp0 NGa_MXP_n0_8 vss sg13_hv_nmos w=0.5u l=0.45u m=1
MNGa_MXP_S0_8_1 t17 NGa_bp0 NGa_MXP_n0_8 vss sg13_hv_nmos w=0.5u l=0.45u m=1
MNGa_MXP_S0_9_0 t18 NGa_bbp0 NGa_MXP_n0_9 vss sg13_hv_nmos w=0.5u l=0.45u m=1
MNGa_MXP_S0_9_1 t19 NGa_bp0 NGa_MXP_n0_9 vss sg13_hv_nmos w=0.5u l=0.45u m=1
MNGa_MXP_S0_10_0 t20 NGa_bbp0 NGa_MXP_n0_10 vss sg13_hv_nmos w=0.5u l=0.45u m=1
MNGa_MXP_S0_10_1 t21 NGa_bp0 NGa_MXP_n0_10 vss sg13_hv_nmos w=0.5u l=0.45u m=1
MNGa_MXP_S0_11_0 t22 NGa_bbp0 NGa_MXP_n0_11 vss sg13_hv_nmos w=0.5u l=0.45u m=1
MNGa_MXP_S0_11_1 t23 NGa_bp0 NGa_MXP_n0_11 vss sg13_hv_nmos w=0.5u l=0.45u m=1
MNGa_MXP_S0_12_0 t24 NGa_bbp0 NGa_MXP_n0_12 vss sg13_hv_nmos w=0.5u l=0.45u m=1
MNGa_MXP_S0_12_1 t25 NGa_bp0 NGa_MXP_n0_12 vss sg13_hv_nmos w=0.5u l=0.45u m=1
MNGa_MXP_S0_13_0 t26 NGa_bbp0 NGa_MXP_n0_13 vss sg13_hv_nmos w=0.5u l=0.45u m=1
MNGa_MXP_S0_13_1 t27 NGa_bp0 NGa_MXP_n0_13 vss sg13_hv_nmos w=0.5u l=0.45u m=1
MNGa_MXP_S0_14_0 t28 NGa_bbp0 NGa_MXP_n0_14 vss sg13_hv_nmos w=0.5u l=0.45u m=1
MNGa_MXP_S0_14_1 t29 NGa_bp0 NGa_MXP_n0_14 vss sg13_hv_nmos w=0.5u l=0.45u m=1
MNGa_MXP_S0_15_0 t30 NGa_bbp0 NGa_MXP_n0_15 vss sg13_hv_nmos w=0.5u l=0.45u m=1
MNGa_MXP_S0_15_1 t31 NGa_bp0 NGa_MXP_n0_15 vss sg13_hv_nmos w=0.5u l=0.45u m=1
MNGa_MXP_S0_16_0 t32 NGa_bbp0 NGa_MXP_n0_16 vss sg13_hv_nmos w=0.5u l=0.45u m=1
MNGa_MXP_S0_16_1 t33 NGa_bp0 NGa_MXP_n0_16 vss sg13_hv_nmos w=0.5u l=0.45u m=1
MNGa_MXP_S0_17_0 t34 NGa_bbp0 NGa_MXP_n0_17 vss sg13_hv_nmos w=0.5u l=0.45u m=1
MNGa_MXP_S0_17_1 t35 NGa_bp0 NGa_MXP_n0_17 vss sg13_hv_nmos w=0.5u l=0.45u m=1
MNGa_MXP_S0_18_0 t36 NGa_bbp0 NGa_MXP_n0_18 vss sg13_hv_nmos w=0.5u l=0.45u m=1
MNGa_MXP_S0_18_1 t37 NGa_bp0 NGa_MXP_n0_18 vss sg13_hv_nmos w=0.5u l=0.45u m=1
MNGa_MXP_S0_19_0 t38 NGa_bbp0 NGa_MXP_n0_19 vss sg13_hv_nmos w=0.5u l=0.45u m=1
MNGa_MXP_S0_19_1 t39 NGa_bp0 NGa_MXP_n0_19 vss sg13_hv_nmos w=0.5u l=0.45u m=1
MNGa_MXP_S0_20_0 t40 NGa_bbp0 NGa_MXP_n0_20 vss sg13_hv_nmos w=0.5u l=0.45u m=1
MNGa_MXP_S0_20_1 t41 NGa_bp0 NGa_MXP_n0_20 vss sg13_hv_nmos w=0.5u l=0.45u m=1
MNGa_MXP_S0_21_0 t42 NGa_bbp0 NGa_MXP_n0_21 vss sg13_hv_nmos w=0.5u l=0.45u m=1
MNGa_MXP_S0_21_1 t43 NGa_bp0 NGa_MXP_n0_21 vss sg13_hv_nmos w=0.5u l=0.45u m=1
MNGa_MXP_S0_22_0 t44 NGa_bbp0 NGa_MXP_n0_22 vss sg13_hv_nmos w=0.5u l=0.45u m=1
MNGa_MXP_S0_22_1 t45 NGa_bp0 NGa_MXP_n0_22 vss sg13_hv_nmos w=0.5u l=0.45u m=1
MNGa_MXP_S0_23_0 t46 NGa_bbp0 NGa_MXP_n0_23 vss sg13_hv_nmos w=0.5u l=0.45u m=1
MNGa_MXP_S0_23_1 t47 NGa_bp0 NGa_MXP_n0_23 vss sg13_hv_nmos w=0.5u l=0.45u m=1
MNGa_MXP_S0_24_0 t48 NGa_bbp0 NGa_MXP_n0_24 vss sg13_hv_nmos w=0.5u l=0.45u m=1
MNGa_MXP_S0_24_1 t49 NGa_bp0 NGa_MXP_n0_24 vss sg13_hv_nmos w=0.5u l=0.45u m=1
MNGa_MXP_S0_25_0 t50 NGa_bbp0 NGa_MXP_n0_25 vss sg13_hv_nmos w=0.5u l=0.45u m=1
MNGa_MXP_S0_25_1 t51 NGa_bp0 NGa_MXP_n0_25 vss sg13_hv_nmos w=0.5u l=0.45u m=1
MNGa_MXP_S0_26_0 t52 NGa_bbp0 NGa_MXP_n0_26 vss sg13_hv_nmos w=0.5u l=0.45u m=1
MNGa_MXP_S0_26_1 t53 NGa_bp0 NGa_MXP_n0_26 vss sg13_hv_nmos w=0.5u l=0.45u m=1
MNGa_MXP_S0_27_0 t54 NGa_bbp0 NGa_MXP_n0_27 vss sg13_hv_nmos w=0.5u l=0.45u m=1
MNGa_MXP_S0_27_1 t55 NGa_bp0 NGa_MXP_n0_27 vss sg13_hv_nmos w=0.5u l=0.45u m=1
MNGa_MXP_S0_28_0 t56 NGa_bbp0 NGa_MXP_n0_28 vss sg13_hv_nmos w=0.5u l=0.45u m=1
MNGa_MXP_S0_28_1 t57 NGa_bp0 NGa_MXP_n0_28 vss sg13_hv_nmos w=0.5u l=0.45u m=1
MNGa_MXP_S0_29_0 t58 NGa_bbp0 NGa_MXP_n0_29 vss sg13_hv_nmos w=0.5u l=0.45u m=1
MNGa_MXP_S0_29_1 t59 NGa_bp0 NGa_MXP_n0_29 vss sg13_hv_nmos w=0.5u l=0.45u m=1
MNGa_MXP_S0_30_0 t60 NGa_bbp0 NGa_MXP_n0_30 vss sg13_hv_nmos w=0.5u l=0.45u m=1
MNGa_MXP_S0_30_1 t61 NGa_bp0 NGa_MXP_n0_30 vss sg13_hv_nmos w=0.5u l=0.45u m=1
MNGa_MXP_S0_31_0 t62 NGa_bbp0 NGa_MXP_n0_31 vss sg13_hv_nmos w=0.5u l=0.45u m=1
MNGa_MXP_S0_31_1 t63 NGa_bp0 NGa_MXP_n0_31 vss sg13_hv_nmos w=0.5u l=0.45u m=1
MNGa_MXP_S0_32_0 t64 NGa_bbp0 NGa_MXP_n0_32 vss sg13_hv_nmos w=0.5u l=0.45u m=1
MNGa_MXP_S0_32_1 t65 NGa_bp0 NGa_MXP_n0_32 vss sg13_hv_nmos w=0.5u l=0.45u m=1
MNGa_MXP_S0_33_0 t66 NGa_bbp0 NGa_MXP_n0_33 vss sg13_hv_nmos w=0.5u l=0.45u m=1
MNGa_MXP_S0_33_1 t67 NGa_bp0 NGa_MXP_n0_33 vss sg13_hv_nmos w=0.5u l=0.45u m=1
MNGa_MXP_S0_34_0 t68 NGa_bbp0 NGa_MXP_n0_34 vss sg13_hv_nmos w=0.5u l=0.45u m=1
MNGa_MXP_S0_34_1 t69 NGa_bp0 NGa_MXP_n0_34 vss sg13_hv_nmos w=0.5u l=0.45u m=1
MNGa_MXP_S0_35_0 t70 NGa_bbp0 NGa_MXP_n0_35 vss sg13_hv_nmos w=0.5u l=0.45u m=1
MNGa_MXP_S0_35_1 t71 NGa_bp0 NGa_MXP_n0_35 vss sg13_hv_nmos w=0.5u l=0.45u m=1
MNGa_MXP_S0_36_0 t72 NGa_bbp0 NGa_MXP_n0_36 vss sg13_hv_nmos w=0.5u l=0.45u m=1
MNGa_MXP_S0_36_1 t73 NGa_bp0 NGa_MXP_n0_36 vss sg13_hv_nmos w=0.5u l=0.45u m=1
MNGa_MXP_S0_37_0 t74 NGa_bbp0 NGa_MXP_n0_37 vss sg13_hv_nmos w=0.5u l=0.45u m=1
MNGa_MXP_S0_37_1 t75 NGa_bp0 NGa_MXP_n0_37 vss sg13_hv_nmos w=0.5u l=0.45u m=1
MNGa_MXP_S0_38_0 t76 NGa_bbp0 NGa_MXP_n0_38 vss sg13_hv_nmos w=0.5u l=0.45u m=1
MNGa_MXP_S0_38_1 t77 NGa_bp0 NGa_MXP_n0_38 vss sg13_hv_nmos w=0.5u l=0.45u m=1
MNGa_MXP_S0_39_0 t78 NGa_bbp0 NGa_MXP_n0_39 vss sg13_hv_nmos w=0.5u l=0.45u m=1
MNGa_MXP_S0_39_1 t79 NGa_bp0 NGa_MXP_n0_39 vss sg13_hv_nmos w=0.5u l=0.45u m=1
MNGa_MXP_S0_40_0 t80 NGa_bbp0 NGa_MXP_n0_40 vss sg13_hv_nmos w=0.5u l=0.45u m=1
MNGa_MXP_S0_40_1 t81 NGa_bp0 NGa_MXP_n0_40 vss sg13_hv_nmos w=0.5u l=0.45u m=1
MNGa_MXP_S0_41_0 t82 NGa_bbp0 NGa_MXP_n0_41 vss sg13_hv_nmos w=0.5u l=0.45u m=1
MNGa_MXP_S0_41_1 t83 NGa_bp0 NGa_MXP_n0_41 vss sg13_hv_nmos w=0.5u l=0.45u m=1
MNGa_MXP_S0_42_0 t84 NGa_bbp0 NGa_MXP_n0_42 vss sg13_hv_nmos w=0.5u l=0.45u m=1
MNGa_MXP_S0_42_1 t85 NGa_bp0 NGa_MXP_n0_42 vss sg13_hv_nmos w=0.5u l=0.45u m=1
MNGa_MXP_S0_43_0 t86 NGa_bbp0 NGa_MXP_n0_43 vss sg13_hv_nmos w=0.5u l=0.45u m=1
MNGa_MXP_S0_43_1 t87 NGa_bp0 NGa_MXP_n0_43 vss sg13_hv_nmos w=0.5u l=0.45u m=1
MNGa_MXP_S0_44_0 t88 NGa_bbp0 NGa_MXP_n0_44 vss sg13_hv_nmos w=0.5u l=0.45u m=1
MNGa_MXP_S0_44_1 t89 NGa_bp0 NGa_MXP_n0_44 vss sg13_hv_nmos w=0.5u l=0.45u m=1
MNGa_MXP_S0_45_0 t90 NGa_bbp0 NGa_MXP_n0_45 vss sg13_hv_nmos w=0.5u l=0.45u m=1
MNGa_MXP_S0_45_1 t91 NGa_bp0 NGa_MXP_n0_45 vss sg13_hv_nmos w=0.5u l=0.45u m=1
MNGa_MXP_S0_46_0 t92 NGa_bbp0 NGa_MXP_n0_46 vss sg13_hv_nmos w=0.5u l=0.45u m=1
MNGa_MXP_S0_46_1 t93 NGa_bp0 NGa_MXP_n0_46 vss sg13_hv_nmos w=0.5u l=0.45u m=1
MNGa_MXP_S0_47_0 t94 NGa_bbp0 NGa_MXP_n0_47 vss sg13_hv_nmos w=0.5u l=0.45u m=1
MNGa_MXP_S0_47_1 t95 NGa_bp0 NGa_MXP_n0_47 vss sg13_hv_nmos w=0.5u l=0.45u m=1
MNGa_MXP_S0_48_0 t96 NGa_bbp0 NGa_MXP_n0_48 vss sg13_hv_nmos w=0.5u l=0.45u m=1
MNGa_MXP_S0_48_1 t97 NGa_bp0 NGa_MXP_n0_48 vss sg13_hv_nmos w=0.5u l=0.45u m=1
MNGa_MXP_S0_49_0 t98 NGa_bbp0 NGa_MXP_n0_49 vss sg13_hv_nmos w=0.5u l=0.45u m=1
MNGa_MXP_S0_49_1 t99 NGa_bp0 NGa_MXP_n0_49 vss sg13_hv_nmos w=0.5u l=0.45u m=1
MNGa_MXP_S0_50_0 t100 NGa_bbp0 NGa_MXP_n0_50 vss sg13_hv_nmos w=0.5u l=0.45u m=1
MNGa_MXP_S0_50_1 t101 NGa_bp0 NGa_MXP_n0_50 vss sg13_hv_nmos w=0.5u l=0.45u m=1
MNGa_MXP_S0_51_0 t102 NGa_bbp0 NGa_MXP_n0_51 vss sg13_hv_nmos w=0.5u l=0.45u m=1
MNGa_MXP_S0_51_1 t103 NGa_bp0 NGa_MXP_n0_51 vss sg13_hv_nmos w=0.5u l=0.45u m=1
MNGa_MXP_S0_52_0 t104 NGa_bbp0 NGa_MXP_n0_52 vss sg13_hv_nmos w=0.5u l=0.45u m=1
MNGa_MXP_S0_52_1 t105 NGa_bp0 NGa_MXP_n0_52 vss sg13_hv_nmos w=0.5u l=0.45u m=1
MNGa_MXP_S0_53_0 t106 NGa_bbp0 NGa_MXP_n0_53 vss sg13_hv_nmos w=0.5u l=0.45u m=1
MNGa_MXP_S0_53_1 t107 NGa_bp0 NGa_MXP_n0_53 vss sg13_hv_nmos w=0.5u l=0.45u m=1
MNGa_MXP_S0_54_0 t108 NGa_bbp0 NGa_MXP_n0_54 vss sg13_hv_nmos w=0.5u l=0.45u m=1
MNGa_MXP_S0_54_1 t109 NGa_bp0 NGa_MXP_n0_54 vss sg13_hv_nmos w=0.5u l=0.45u m=1
MNGa_MXP_S0_55_0 t110 NGa_bbp0 NGa_MXP_n0_55 vss sg13_hv_nmos w=0.5u l=0.45u m=1
MNGa_MXP_S0_55_1 t111 NGa_bp0 NGa_MXP_n0_55 vss sg13_hv_nmos w=0.5u l=0.45u m=1
MNGa_MXP_S0_56_0 t112 NGa_bbp0 NGa_MXP_n0_56 vss sg13_hv_nmos w=0.5u l=0.45u m=1
MNGa_MXP_S0_56_1 t113 NGa_bp0 NGa_MXP_n0_56 vss sg13_hv_nmos w=0.5u l=0.45u m=1
MNGa_MXP_S0_57_0 t114 NGa_bbp0 NGa_MXP_n0_57 vss sg13_hv_nmos w=0.5u l=0.45u m=1
MNGa_MXP_S0_57_1 t115 NGa_bp0 NGa_MXP_n0_57 vss sg13_hv_nmos w=0.5u l=0.45u m=1
MNGa_MXP_S0_58_0 t116 NGa_bbp0 NGa_MXP_n0_58 vss sg13_hv_nmos w=0.5u l=0.45u m=1
MNGa_MXP_S0_58_1 t117 NGa_bp0 NGa_MXP_n0_58 vss sg13_hv_nmos w=0.5u l=0.45u m=1
MNGa_MXP_S0_59_0 t118 NGa_bbp0 NGa_MXP_n0_59 vss sg13_hv_nmos w=0.5u l=0.45u m=1
MNGa_MXP_S0_59_1 t119 NGa_bp0 NGa_MXP_n0_59 vss sg13_hv_nmos w=0.5u l=0.45u m=1
MNGa_MXP_S0_60_0 t120 NGa_bbp0 NGa_MXP_n0_60 vss sg13_hv_nmos w=0.5u l=0.45u m=1
MNGa_MXP_S0_60_1 t121 NGa_bp0 NGa_MXP_n0_60 vss sg13_hv_nmos w=0.5u l=0.45u m=1
MNGa_MXP_S0_61_0 t122 NGa_bbp0 NGa_MXP_n0_61 vss sg13_hv_nmos w=0.5u l=0.45u m=1
MNGa_MXP_S0_61_1 t123 NGa_bp0 NGa_MXP_n0_61 vss sg13_hv_nmos w=0.5u l=0.45u m=1
MNGa_MXP_S0_62_0 t124 NGa_bbp0 NGa_MXP_n0_62 vss sg13_hv_nmos w=0.5u l=0.45u m=1
MNGa_MXP_S0_62_1 t125 NGa_bp0 NGa_MXP_n0_62 vss sg13_hv_nmos w=0.5u l=0.45u m=1
MNGa_MXP_S0_63_0 t126 NGa_bbp0 NGa_MXP_n0_63 vss sg13_hv_nmos w=0.5u l=0.45u m=1
MNGa_MXP_S0_63_1 t127 NGa_bp0 NGa_MXP_n0_63 vss sg13_hv_nmos w=0.5u l=0.45u m=1
MNGa_MXP_S0_64_0 t128 NGa_bbp0 NGa_MXP_n0_64 vss sg13_hv_nmos w=0.5u l=0.45u m=1
MNGa_MXP_S0_64_1 t129 NGa_bp0 NGa_MXP_n0_64 vss sg13_hv_nmos w=0.5u l=0.45u m=1
MNGa_MXP_S0_65_0 t130 NGa_bbp0 NGa_MXP_n0_65 vss sg13_hv_nmos w=0.5u l=0.45u m=1
MNGa_MXP_S0_65_1 t131 NGa_bp0 NGa_MXP_n0_65 vss sg13_hv_nmos w=0.5u l=0.45u m=1
MNGa_MXP_S0_66_0 t132 NGa_bbp0 NGa_MXP_n0_66 vss sg13_hv_nmos w=0.5u l=0.45u m=1
MNGa_MXP_S0_66_1 t133 NGa_bp0 NGa_MXP_n0_66 vss sg13_hv_nmos w=0.5u l=0.45u m=1
MNGa_MXP_S0_67_0 t134 NGa_bbp0 NGa_MXP_n0_67 vss sg13_hv_nmos w=0.5u l=0.45u m=1
MNGa_MXP_S0_67_1 t135 NGa_bp0 NGa_MXP_n0_67 vss sg13_hv_nmos w=0.5u l=0.45u m=1
MNGa_MXP_S0_68_0 t136 NGa_bbp0 NGa_MXP_n0_68 vss sg13_hv_nmos w=0.5u l=0.45u m=1
MNGa_MXP_S0_68_1 t137 NGa_bp0 NGa_MXP_n0_68 vss sg13_hv_nmos w=0.5u l=0.45u m=1
MNGa_MXP_S0_69_0 t138 NGa_bbp0 NGa_MXP_n0_69 vss sg13_hv_nmos w=0.5u l=0.45u m=1
MNGa_MXP_S0_69_1 t139 NGa_bp0 NGa_MXP_n0_69 vss sg13_hv_nmos w=0.5u l=0.45u m=1
MNGa_MXP_S0_70_0 t140 NGa_bbp0 NGa_MXP_n0_70 vss sg13_hv_nmos w=0.5u l=0.45u m=1
MNGa_MXP_S0_70_1 t141 NGa_bp0 NGa_MXP_n0_70 vss sg13_hv_nmos w=0.5u l=0.45u m=1
MNGa_MXP_S0_71_0 t142 NGa_bbp0 NGa_MXP_n0_71 vss sg13_hv_nmos w=0.5u l=0.45u m=1
MNGa_MXP_S0_71_1 t143 NGa_bp0 NGa_MXP_n0_71 vss sg13_hv_nmos w=0.5u l=0.45u m=1
MNGa_MXP_S0_72_0 t144 NGa_bbp0 NGa_MXP_n0_72 vss sg13_hv_nmos w=0.5u l=0.45u m=1
MNGa_MXP_S0_72_1 t145 NGa_bp0 NGa_MXP_n0_72 vss sg13_hv_nmos w=0.5u l=0.45u m=1
MNGa_MXP_S0_73_0 t146 NGa_bbp0 NGa_MXP_n0_73 vss sg13_hv_nmos w=0.5u l=0.45u m=1
MNGa_MXP_S0_73_1 t147 NGa_bp0 NGa_MXP_n0_73 vss sg13_hv_nmos w=0.5u l=0.45u m=1
MNGa_MXP_S0_74_0 t148 NGa_bbp0 NGa_MXP_n0_74 vss sg13_hv_nmos w=0.5u l=0.45u m=1
MNGa_MXP_S0_74_1 t149 NGa_bp0 NGa_MXP_n0_74 vss sg13_hv_nmos w=0.5u l=0.45u m=1
MNGa_MXP_S0_75_0 t150 NGa_bbp0 NGa_MXP_n0_75 vss sg13_hv_nmos w=0.5u l=0.45u m=1
MNGa_MXP_S0_75_1 t151 NGa_bp0 NGa_MXP_n0_75 vss sg13_hv_nmos w=0.5u l=0.45u m=1
MNGa_MXP_S0_76_0 t152 NGa_bbp0 NGa_MXP_n0_76 vss sg13_hv_nmos w=0.5u l=0.45u m=1
MNGa_MXP_S0_76_1 t153 NGa_bp0 NGa_MXP_n0_76 vss sg13_hv_nmos w=0.5u l=0.45u m=1
MNGa_MXP_S0_77_0 t154 NGa_bbp0 NGa_MXP_n0_77 vss sg13_hv_nmos w=0.5u l=0.45u m=1
MNGa_MXP_S0_77_1 t155 NGa_bp0 NGa_MXP_n0_77 vss sg13_hv_nmos w=0.5u l=0.45u m=1
MNGa_MXP_S0_78_0 t156 NGa_bbp0 NGa_MXP_n0_78 vss sg13_hv_nmos w=0.5u l=0.45u m=1
MNGa_MXP_S0_78_1 t157 NGa_bp0 NGa_MXP_n0_78 vss sg13_hv_nmos w=0.5u l=0.45u m=1
MNGa_MXP_S0_79_0 t158 NGa_bbp0 NGa_MXP_n0_79 vss sg13_hv_nmos w=0.5u l=0.45u m=1
MNGa_MXP_S0_79_1 t159 NGa_bp0 NGa_MXP_n0_79 vss sg13_hv_nmos w=0.5u l=0.45u m=1
MNGa_MXP_S0_80_0 t160 NGa_bbp0 NGa_MXP_n0_80 vss sg13_hv_nmos w=0.5u l=0.45u m=1
MNGa_MXP_S0_80_1 t161 NGa_bp0 NGa_MXP_n0_80 vss sg13_hv_nmos w=0.5u l=0.45u m=1
MNGa_MXP_S0_81_0 t162 NGa_bbp0 NGa_MXP_n0_81 vss sg13_hv_nmos w=0.5u l=0.45u m=1
MNGa_MXP_S0_81_1 t163 NGa_bp0 NGa_MXP_n0_81 vss sg13_hv_nmos w=0.5u l=0.45u m=1
MNGa_MXP_S0_82_0 t164 NGa_bbp0 NGa_MXP_n0_82 vss sg13_hv_nmos w=0.5u l=0.45u m=1
MNGa_MXP_S0_82_1 t165 NGa_bp0 NGa_MXP_n0_82 vss sg13_hv_nmos w=0.5u l=0.45u m=1
MNGa_MXP_S0_83_0 t166 NGa_bbp0 NGa_MXP_n0_83 vss sg13_hv_nmos w=0.5u l=0.45u m=1
MNGa_MXP_S0_83_1 t167 NGa_bp0 NGa_MXP_n0_83 vss sg13_hv_nmos w=0.5u l=0.45u m=1
MNGa_MXP_S0_84_0 t168 NGa_bbp0 NGa_MXP_n0_84 vss sg13_hv_nmos w=0.5u l=0.45u m=1
MNGa_MXP_S0_84_1 t169 NGa_bp0 NGa_MXP_n0_84 vss sg13_hv_nmos w=0.5u l=0.45u m=1
MNGa_MXP_S0_85_0 t170 NGa_bbp0 NGa_MXP_n0_85 vss sg13_hv_nmos w=0.5u l=0.45u m=1
MNGa_MXP_S0_85_1 t171 NGa_bp0 NGa_MXP_n0_85 vss sg13_hv_nmos w=0.5u l=0.45u m=1
MNGa_MXP_S0_86_0 t172 NGa_bbp0 NGa_MXP_n0_86 vss sg13_hv_nmos w=0.5u l=0.45u m=1
MNGa_MXP_S0_86_1 t173 NGa_bp0 NGa_MXP_n0_86 vss sg13_hv_nmos w=0.5u l=0.45u m=1
MNGa_MXP_S0_87_0 t174 NGa_bbp0 NGa_MXP_n0_87 vss sg13_hv_nmos w=0.5u l=0.45u m=1
MNGa_MXP_S0_87_1 t175 NGa_bp0 NGa_MXP_n0_87 vss sg13_hv_nmos w=0.5u l=0.45u m=1
MNGa_MXP_S0_88_0 t176 NGa_bbp0 NGa_MXP_n0_88 vss sg13_hv_nmos w=0.5u l=0.45u m=1
MNGa_MXP_S0_88_1 t177 NGa_bp0 NGa_MXP_n0_88 vss sg13_hv_nmos w=0.5u l=0.45u m=1
MNGa_MXP_S0_89_0 t178 NGa_bbp0 NGa_MXP_n0_89 vss sg13_hv_nmos w=0.5u l=0.45u m=1
MNGa_MXP_S0_89_1 t179 NGa_bp0 NGa_MXP_n0_89 vss sg13_hv_nmos w=0.5u l=0.45u m=1
MNGa_MXP_S0_90_0 t180 NGa_bbp0 NGa_MXP_n0_90 vss sg13_hv_nmos w=0.5u l=0.45u m=1
MNGa_MXP_S0_90_1 t181 NGa_bp0 NGa_MXP_n0_90 vss sg13_hv_nmos w=0.5u l=0.45u m=1
MNGa_MXP_S0_91_0 t182 NGa_bbp0 NGa_MXP_n0_91 vss sg13_hv_nmos w=0.5u l=0.45u m=1
MNGa_MXP_S0_91_1 t183 NGa_bp0 NGa_MXP_n0_91 vss sg13_hv_nmos w=0.5u l=0.45u m=1
MNGa_MXP_S0_92_0 t184 NGa_bbp0 NGa_MXP_n0_92 vss sg13_hv_nmos w=0.5u l=0.45u m=1
MNGa_MXP_S0_92_1 t185 NGa_bp0 NGa_MXP_n0_92 vss sg13_hv_nmos w=0.5u l=0.45u m=1
MNGa_MXP_S0_93_0 t186 NGa_bbp0 NGa_MXP_n0_93 vss sg13_hv_nmos w=0.5u l=0.45u m=1
MNGa_MXP_S0_93_1 t187 NGa_bp0 NGa_MXP_n0_93 vss sg13_hv_nmos w=0.5u l=0.45u m=1
MNGa_MXP_S0_94_0 t188 NGa_bbp0 NGa_MXP_n0_94 vss sg13_hv_nmos w=0.5u l=0.45u m=1
MNGa_MXP_S0_94_1 t189 NGa_bp0 NGa_MXP_n0_94 vss sg13_hv_nmos w=0.5u l=0.45u m=1
MNGa_MXP_S0_95_0 t190 NGa_bbp0 NGa_MXP_n0_95 vss sg13_hv_nmos w=0.5u l=0.45u m=1
MNGa_MXP_S0_95_1 t191 NGa_bp0 NGa_MXP_n0_95 vss sg13_hv_nmos w=0.5u l=0.45u m=1
MNGa_MXP_S0_96_0 t192 NGa_bbp0 NGa_MXP_n0_96 vss sg13_hv_nmos w=0.5u l=0.45u m=1
MNGa_MXP_S0_96_1 t193 NGa_bp0 NGa_MXP_n0_96 vss sg13_hv_nmos w=0.5u l=0.45u m=1
MNGa_MXP_S0_97_0 t194 NGa_bbp0 NGa_MXP_n0_97 vss sg13_hv_nmos w=0.5u l=0.45u m=1
MNGa_MXP_S0_97_1 t195 NGa_bp0 NGa_MXP_n0_97 vss sg13_hv_nmos w=0.5u l=0.45u m=1
MNGa_MXP_S0_98_0 t196 NGa_bbp0 NGa_MXP_n0_98 vss sg13_hv_nmos w=0.5u l=0.45u m=1
MNGa_MXP_S0_98_1 t197 NGa_bp0 NGa_MXP_n0_98 vss sg13_hv_nmos w=0.5u l=0.45u m=1
MNGa_MXP_S0_99_0 t198 NGa_bbp0 NGa_MXP_n0_99 vss sg13_hv_nmos w=0.5u l=0.45u m=1
MNGa_MXP_S0_99_1 t199 NGa_bp0 NGa_MXP_n0_99 vss sg13_hv_nmos w=0.5u l=0.45u m=1
MNGa_MXP_S0_100_0 t200 NGa_bbp0 NGa_MXP_n0_100 vss sg13_hv_nmos w=0.5u l=0.45u m=1
MNGa_MXP_S0_100_1 t201 NGa_bp0 NGa_MXP_n0_100 vss sg13_hv_nmos w=0.5u l=0.45u m=1
MNGa_MXP_S0_101_0 t202 NGa_bbp0 NGa_MXP_n0_101 vss sg13_hv_nmos w=0.5u l=0.45u m=1
MNGa_MXP_S0_101_1 t203 NGa_bp0 NGa_MXP_n0_101 vss sg13_hv_nmos w=0.5u l=0.45u m=1
MNGa_MXP_S0_102_0 t204 NGa_bbp0 NGa_MXP_n0_102 vss sg13_hv_nmos w=0.5u l=0.45u m=1
MNGa_MXP_S0_102_1 t205 NGa_bp0 NGa_MXP_n0_102 vss sg13_hv_nmos w=0.5u l=0.45u m=1
MNGa_MXP_S0_103_0 t206 NGa_bbp0 NGa_MXP_n0_103 vss sg13_hv_nmos w=0.5u l=0.45u m=1
MNGa_MXP_S0_103_1 t207 NGa_bp0 NGa_MXP_n0_103 vss sg13_hv_nmos w=0.5u l=0.45u m=1
MNGa_MXP_S0_104_0 t208 NGa_bbp0 NGa_MXP_n0_104 vss sg13_hv_nmos w=0.5u l=0.45u m=1
MNGa_MXP_S0_104_1 t209 NGa_bp0 NGa_MXP_n0_104 vss sg13_hv_nmos w=0.5u l=0.45u m=1
MNGa_MXP_S0_105_0 t210 NGa_bbp0 NGa_MXP_n0_105 vss sg13_hv_nmos w=0.5u l=0.45u m=1
MNGa_MXP_S0_105_1 t211 NGa_bp0 NGa_MXP_n0_105 vss sg13_hv_nmos w=0.5u l=0.45u m=1
MNGa_MXP_S0_106_0 t212 NGa_bbp0 NGa_MXP_n0_106 vss sg13_hv_nmos w=0.5u l=0.45u m=1
MNGa_MXP_S0_106_1 t213 NGa_bp0 NGa_MXP_n0_106 vss sg13_hv_nmos w=0.5u l=0.45u m=1
MNGa_MXP_S0_107_0 t214 NGa_bbp0 NGa_MXP_n0_107 vss sg13_hv_nmos w=0.5u l=0.45u m=1
MNGa_MXP_S0_107_1 t215 NGa_bp0 NGa_MXP_n0_107 vss sg13_hv_nmos w=0.5u l=0.45u m=1
MNGa_MXP_S0_108_0 t216 NGa_bbp0 NGa_MXP_n0_108 vss sg13_hv_nmos w=0.5u l=0.45u m=1
MNGa_MXP_S0_108_1 t217 NGa_bp0 NGa_MXP_n0_108 vss sg13_hv_nmos w=0.5u l=0.45u m=1
MNGa_MXP_S0_109_0 t218 NGa_bbp0 NGa_MXP_n0_109 vss sg13_hv_nmos w=0.5u l=0.45u m=1
MNGa_MXP_S0_109_1 t219 NGa_bp0 NGa_MXP_n0_109 vss sg13_hv_nmos w=0.5u l=0.45u m=1
MNGa_MXP_S0_110_0 t220 NGa_bbp0 NGa_MXP_n0_110 vss sg13_hv_nmos w=0.5u l=0.45u m=1
MNGa_MXP_S0_110_1 t221 NGa_bp0 NGa_MXP_n0_110 vss sg13_hv_nmos w=0.5u l=0.45u m=1
MNGa_MXP_S0_111_0 t222 NGa_bbp0 NGa_MXP_n0_111 vss sg13_hv_nmos w=0.5u l=0.45u m=1
MNGa_MXP_S0_111_1 t223 NGa_bp0 NGa_MXP_n0_111 vss sg13_hv_nmos w=0.5u l=0.45u m=1
MNGa_MXP_S0_112_0 t224 NGa_bbp0 NGa_MXP_n0_112 vss sg13_hv_nmos w=0.5u l=0.45u m=1
MNGa_MXP_S0_112_1 t225 NGa_bp0 NGa_MXP_n0_112 vss sg13_hv_nmos w=0.5u l=0.45u m=1
MNGa_MXP_S0_113_0 t226 NGa_bbp0 NGa_MXP_n0_113 vss sg13_hv_nmos w=0.5u l=0.45u m=1
MNGa_MXP_S0_113_1 t227 NGa_bp0 NGa_MXP_n0_113 vss sg13_hv_nmos w=0.5u l=0.45u m=1
MNGa_MXP_S0_114_0 t228 NGa_bbp0 NGa_MXP_n0_114 vss sg13_hv_nmos w=0.5u l=0.45u m=1
MNGa_MXP_S0_114_1 t229 NGa_bp0 NGa_MXP_n0_114 vss sg13_hv_nmos w=0.5u l=0.45u m=1
MNGa_MXP_S0_115_0 t230 NGa_bbp0 NGa_MXP_n0_115 vss sg13_hv_nmos w=0.5u l=0.45u m=1
MNGa_MXP_S0_115_1 t231 NGa_bp0 NGa_MXP_n0_115 vss sg13_hv_nmos w=0.5u l=0.45u m=1
MNGa_MXP_S0_116_0 t232 NGa_bbp0 NGa_MXP_n0_116 vss sg13_hv_nmos w=0.5u l=0.45u m=1
MNGa_MXP_S0_116_1 t233 NGa_bp0 NGa_MXP_n0_116 vss sg13_hv_nmos w=0.5u l=0.45u m=1
MNGa_MXP_S0_117_0 t234 NGa_bbp0 NGa_MXP_n0_117 vss sg13_hv_nmos w=0.5u l=0.45u m=1
MNGa_MXP_S0_117_1 t235 NGa_bp0 NGa_MXP_n0_117 vss sg13_hv_nmos w=0.5u l=0.45u m=1
MNGa_MXP_S0_118_0 t236 NGa_bbp0 NGa_MXP_n0_118 vss sg13_hv_nmos w=0.5u l=0.45u m=1
MNGa_MXP_S0_118_1 t237 NGa_bp0 NGa_MXP_n0_118 vss sg13_hv_nmos w=0.5u l=0.45u m=1
MNGa_MXP_S0_119_0 t238 NGa_bbp0 NGa_MXP_n0_119 vss sg13_hv_nmos w=0.5u l=0.45u m=1
MNGa_MXP_S0_119_1 t239 NGa_bp0 NGa_MXP_n0_119 vss sg13_hv_nmos w=0.5u l=0.45u m=1
MNGa_MXP_S0_120_0 t240 NGa_bbp0 NGa_MXP_n0_120 vss sg13_hv_nmos w=0.5u l=0.45u m=1
MNGa_MXP_S0_120_1 t241 NGa_bp0 NGa_MXP_n0_120 vss sg13_hv_nmos w=0.5u l=0.45u m=1
MNGa_MXP_S0_121_0 t242 NGa_bbp0 NGa_MXP_n0_121 vss sg13_hv_nmos w=0.5u l=0.45u m=1
MNGa_MXP_S0_121_1 t243 NGa_bp0 NGa_MXP_n0_121 vss sg13_hv_nmos w=0.5u l=0.45u m=1
MNGa_MXP_S0_122_0 t244 NGa_bbp0 NGa_MXP_n0_122 vss sg13_hv_nmos w=0.5u l=0.45u m=1
MNGa_MXP_S0_122_1 t245 NGa_bp0 NGa_MXP_n0_122 vss sg13_hv_nmos w=0.5u l=0.45u m=1
MNGa_MXP_S0_123_0 t246 NGa_bbp0 NGa_MXP_n0_123 vss sg13_hv_nmos w=0.5u l=0.45u m=1
MNGa_MXP_S0_123_1 t247 NGa_bp0 NGa_MXP_n0_123 vss sg13_hv_nmos w=0.5u l=0.45u m=1
MNGa_MXP_S0_124_0 t248 NGa_bbp0 NGa_MXP_n0_124 vss sg13_hv_nmos w=0.5u l=0.45u m=1
MNGa_MXP_S0_124_1 t249 NGa_bp0 NGa_MXP_n0_124 vss sg13_hv_nmos w=0.5u l=0.45u m=1
MNGa_MXP_S0_125_0 t250 NGa_bbp0 NGa_MXP_n0_125 vss sg13_hv_nmos w=0.5u l=0.45u m=1
MNGa_MXP_S0_125_1 t251 NGa_bp0 NGa_MXP_n0_125 vss sg13_hv_nmos w=0.5u l=0.45u m=1
MNGa_MXP_S0_126_0 vref NGa_bbp0 NGa_MXP_n0_126 vss sg13_hv_nmos w=0.5u l=0.45u m=1
MNGa_MXP_S0_126_1 vref NGa_bp0 NGa_MXP_n0_126 vss sg13_hv_nmos w=0.5u l=0.45u m=1
MNGa_MXP_S0_127_0 vref NGa_bbp0 NGa_MXP_n0_127 vss sg13_hv_nmos w=0.5u l=0.45u m=1
MNGa_MXP_S0_127_1 vref NGa_bp0 NGa_MXP_n0_127 vss sg13_hv_nmos w=0.5u l=0.45u m=1
MNGa_MXP_S1_0_0 NGa_MXP_n0_0 NGa_bbp1 NGa_MXP_n1_0 vss sg13_hv_nmos w=0.5u l=0.45u m=1
MNGa_MXP_S1_0_1 NGa_MXP_n0_1 NGa_bp1 NGa_MXP_n1_0 vss sg13_hv_nmos w=0.5u l=0.45u m=1
MNGa_MXP_S1_1_0 NGa_MXP_n0_2 NGa_bbp1 NGa_MXP_n1_1 vss sg13_hv_nmos w=0.5u l=0.45u m=1
MNGa_MXP_S1_1_1 NGa_MXP_n0_3 NGa_bp1 NGa_MXP_n1_1 vss sg13_hv_nmos w=0.5u l=0.45u m=1
MNGa_MXP_S1_2_0 NGa_MXP_n0_4 NGa_bbp1 NGa_MXP_n1_2 vss sg13_hv_nmos w=0.5u l=0.45u m=1
MNGa_MXP_S1_2_1 NGa_MXP_n0_5 NGa_bp1 NGa_MXP_n1_2 vss sg13_hv_nmos w=0.5u l=0.45u m=1
MNGa_MXP_S1_3_0 NGa_MXP_n0_6 NGa_bbp1 NGa_MXP_n1_3 vss sg13_hv_nmos w=0.5u l=0.45u m=1
MNGa_MXP_S1_3_1 NGa_MXP_n0_7 NGa_bp1 NGa_MXP_n1_3 vss sg13_hv_nmos w=0.5u l=0.45u m=1
MNGa_MXP_S1_4_0 NGa_MXP_n0_8 NGa_bbp1 NGa_MXP_n1_4 vss sg13_hv_nmos w=0.5u l=0.45u m=1
MNGa_MXP_S1_4_1 NGa_MXP_n0_9 NGa_bp1 NGa_MXP_n1_4 vss sg13_hv_nmos w=0.5u l=0.45u m=1
MNGa_MXP_S1_5_0 NGa_MXP_n0_10 NGa_bbp1 NGa_MXP_n1_5 vss sg13_hv_nmos w=0.5u l=0.45u m=1
MNGa_MXP_S1_5_1 NGa_MXP_n0_11 NGa_bp1 NGa_MXP_n1_5 vss sg13_hv_nmos w=0.5u l=0.45u m=1
MNGa_MXP_S1_6_0 NGa_MXP_n0_12 NGa_bbp1 NGa_MXP_n1_6 vss sg13_hv_nmos w=0.5u l=0.45u m=1
MNGa_MXP_S1_6_1 NGa_MXP_n0_13 NGa_bp1 NGa_MXP_n1_6 vss sg13_hv_nmos w=0.5u l=0.45u m=1
MNGa_MXP_S1_7_0 NGa_MXP_n0_14 NGa_bbp1 NGa_MXP_n1_7 vss sg13_hv_nmos w=0.5u l=0.45u m=1
MNGa_MXP_S1_7_1 NGa_MXP_n0_15 NGa_bp1 NGa_MXP_n1_7 vss sg13_hv_nmos w=0.5u l=0.45u m=1
MNGa_MXP_S1_8_0 NGa_MXP_n0_16 NGa_bbp1 NGa_MXP_n1_8 vss sg13_hv_nmos w=0.5u l=0.45u m=1
MNGa_MXP_S1_8_1 NGa_MXP_n0_17 NGa_bp1 NGa_MXP_n1_8 vss sg13_hv_nmos w=0.5u l=0.45u m=1
MNGa_MXP_S1_9_0 NGa_MXP_n0_18 NGa_bbp1 NGa_MXP_n1_9 vss sg13_hv_nmos w=0.5u l=0.45u m=1
MNGa_MXP_S1_9_1 NGa_MXP_n0_19 NGa_bp1 NGa_MXP_n1_9 vss sg13_hv_nmos w=0.5u l=0.45u m=1
MNGa_MXP_S1_10_0 NGa_MXP_n0_20 NGa_bbp1 NGa_MXP_n1_10 vss sg13_hv_nmos w=0.5u l=0.45u m=1
MNGa_MXP_S1_10_1 NGa_MXP_n0_21 NGa_bp1 NGa_MXP_n1_10 vss sg13_hv_nmos w=0.5u l=0.45u m=1
MNGa_MXP_S1_11_0 NGa_MXP_n0_22 NGa_bbp1 NGa_MXP_n1_11 vss sg13_hv_nmos w=0.5u l=0.45u m=1
MNGa_MXP_S1_11_1 NGa_MXP_n0_23 NGa_bp1 NGa_MXP_n1_11 vss sg13_hv_nmos w=0.5u l=0.45u m=1
MNGa_MXP_S1_12_0 NGa_MXP_n0_24 NGa_bbp1 NGa_MXP_n1_12 vss sg13_hv_nmos w=0.5u l=0.45u m=1
MNGa_MXP_S1_12_1 NGa_MXP_n0_25 NGa_bp1 NGa_MXP_n1_12 vss sg13_hv_nmos w=0.5u l=0.45u m=1
MNGa_MXP_S1_13_0 NGa_MXP_n0_26 NGa_bbp1 NGa_MXP_n1_13 vss sg13_hv_nmos w=0.5u l=0.45u m=1
MNGa_MXP_S1_13_1 NGa_MXP_n0_27 NGa_bp1 NGa_MXP_n1_13 vss sg13_hv_nmos w=0.5u l=0.45u m=1
MNGa_MXP_S1_14_0 NGa_MXP_n0_28 NGa_bbp1 NGa_MXP_n1_14 vss sg13_hv_nmos w=0.5u l=0.45u m=1
MNGa_MXP_S1_14_1 NGa_MXP_n0_29 NGa_bp1 NGa_MXP_n1_14 vss sg13_hv_nmos w=0.5u l=0.45u m=1
MNGa_MXP_S1_15_0 NGa_MXP_n0_30 NGa_bbp1 NGa_MXP_n1_15 vss sg13_hv_nmos w=0.5u l=0.45u m=1
MNGa_MXP_S1_15_1 NGa_MXP_n0_31 NGa_bp1 NGa_MXP_n1_15 vss sg13_hv_nmos w=0.5u l=0.45u m=1
MNGa_MXP_S1_16_0 NGa_MXP_n0_32 NGa_bbp1 NGa_MXP_n1_16 vss sg13_hv_nmos w=0.5u l=0.45u m=1
MNGa_MXP_S1_16_1 NGa_MXP_n0_33 NGa_bp1 NGa_MXP_n1_16 vss sg13_hv_nmos w=0.5u l=0.45u m=1
MNGa_MXP_S1_17_0 NGa_MXP_n0_34 NGa_bbp1 NGa_MXP_n1_17 vss sg13_hv_nmos w=0.5u l=0.45u m=1
MNGa_MXP_S1_17_1 NGa_MXP_n0_35 NGa_bp1 NGa_MXP_n1_17 vss sg13_hv_nmos w=0.5u l=0.45u m=1
MNGa_MXP_S1_18_0 NGa_MXP_n0_36 NGa_bbp1 NGa_MXP_n1_18 vss sg13_hv_nmos w=0.5u l=0.45u m=1
MNGa_MXP_S1_18_1 NGa_MXP_n0_37 NGa_bp1 NGa_MXP_n1_18 vss sg13_hv_nmos w=0.5u l=0.45u m=1
MNGa_MXP_S1_19_0 NGa_MXP_n0_38 NGa_bbp1 NGa_MXP_n1_19 vss sg13_hv_nmos w=0.5u l=0.45u m=1
MNGa_MXP_S1_19_1 NGa_MXP_n0_39 NGa_bp1 NGa_MXP_n1_19 vss sg13_hv_nmos w=0.5u l=0.45u m=1
MNGa_MXP_S1_20_0 NGa_MXP_n0_40 NGa_bbp1 NGa_MXP_n1_20 vss sg13_hv_nmos w=0.5u l=0.45u m=1
MNGa_MXP_S1_20_1 NGa_MXP_n0_41 NGa_bp1 NGa_MXP_n1_20 vss sg13_hv_nmos w=0.5u l=0.45u m=1
MNGa_MXP_S1_21_0 NGa_MXP_n0_42 NGa_bbp1 NGa_MXP_n1_21 vss sg13_hv_nmos w=0.5u l=0.45u m=1
MNGa_MXP_S1_21_1 NGa_MXP_n0_43 NGa_bp1 NGa_MXP_n1_21 vss sg13_hv_nmos w=0.5u l=0.45u m=1
MNGa_MXP_S1_22_0 NGa_MXP_n0_44 NGa_bbp1 NGa_MXP_n1_22 vss sg13_hv_nmos w=0.5u l=0.45u m=1
MNGa_MXP_S1_22_1 NGa_MXP_n0_45 NGa_bp1 NGa_MXP_n1_22 vss sg13_hv_nmos w=0.5u l=0.45u m=1
MNGa_MXP_S1_23_0 NGa_MXP_n0_46 NGa_bbp1 NGa_MXP_n1_23 vss sg13_hv_nmos w=0.5u l=0.45u m=1
MNGa_MXP_S1_23_1 NGa_MXP_n0_47 NGa_bp1 NGa_MXP_n1_23 vss sg13_hv_nmos w=0.5u l=0.45u m=1
MNGa_MXP_S1_24_0 NGa_MXP_n0_48 NGa_bbp1 NGa_MXP_n1_24 vss sg13_hv_nmos w=0.5u l=0.45u m=1
MNGa_MXP_S1_24_1 NGa_MXP_n0_49 NGa_bp1 NGa_MXP_n1_24 vss sg13_hv_nmos w=0.5u l=0.45u m=1
MNGa_MXP_S1_25_0 NGa_MXP_n0_50 NGa_bbp1 NGa_MXP_n1_25 vss sg13_hv_nmos w=0.5u l=0.45u m=1
MNGa_MXP_S1_25_1 NGa_MXP_n0_51 NGa_bp1 NGa_MXP_n1_25 vss sg13_hv_nmos w=0.5u l=0.45u m=1
MNGa_MXP_S1_26_0 NGa_MXP_n0_52 NGa_bbp1 NGa_MXP_n1_26 vss sg13_hv_nmos w=0.5u l=0.45u m=1
MNGa_MXP_S1_26_1 NGa_MXP_n0_53 NGa_bp1 NGa_MXP_n1_26 vss sg13_hv_nmos w=0.5u l=0.45u m=1
MNGa_MXP_S1_27_0 NGa_MXP_n0_54 NGa_bbp1 NGa_MXP_n1_27 vss sg13_hv_nmos w=0.5u l=0.45u m=1
MNGa_MXP_S1_27_1 NGa_MXP_n0_55 NGa_bp1 NGa_MXP_n1_27 vss sg13_hv_nmos w=0.5u l=0.45u m=1
MNGa_MXP_S1_28_0 NGa_MXP_n0_56 NGa_bbp1 NGa_MXP_n1_28 vss sg13_hv_nmos w=0.5u l=0.45u m=1
MNGa_MXP_S1_28_1 NGa_MXP_n0_57 NGa_bp1 NGa_MXP_n1_28 vss sg13_hv_nmos w=0.5u l=0.45u m=1
MNGa_MXP_S1_29_0 NGa_MXP_n0_58 NGa_bbp1 NGa_MXP_n1_29 vss sg13_hv_nmos w=0.5u l=0.45u m=1
MNGa_MXP_S1_29_1 NGa_MXP_n0_59 NGa_bp1 NGa_MXP_n1_29 vss sg13_hv_nmos w=0.5u l=0.45u m=1
MNGa_MXP_S1_30_0 NGa_MXP_n0_60 NGa_bbp1 NGa_MXP_n1_30 vss sg13_hv_nmos w=0.5u l=0.45u m=1
MNGa_MXP_S1_30_1 NGa_MXP_n0_61 NGa_bp1 NGa_MXP_n1_30 vss sg13_hv_nmos w=0.5u l=0.45u m=1
MNGa_MXP_S1_31_0 NGa_MXP_n0_62 NGa_bbp1 NGa_MXP_n1_31 vss sg13_hv_nmos w=0.5u l=0.45u m=1
MNGa_MXP_S1_31_1 NGa_MXP_n0_63 NGa_bp1 NGa_MXP_n1_31 vss sg13_hv_nmos w=0.5u l=0.45u m=1
MNGa_MXP_S1_32_0 NGa_MXP_n0_64 NGa_bbp1 NGa_MXP_n1_32 vss sg13_hv_nmos w=0.5u l=0.45u m=1
MNGa_MXP_S1_32_1 NGa_MXP_n0_65 NGa_bp1 NGa_MXP_n1_32 vss sg13_hv_nmos w=0.5u l=0.45u m=1
MNGa_MXP_S1_33_0 NGa_MXP_n0_66 NGa_bbp1 NGa_MXP_n1_33 vss sg13_hv_nmos w=0.5u l=0.45u m=1
MNGa_MXP_S1_33_1 NGa_MXP_n0_67 NGa_bp1 NGa_MXP_n1_33 vss sg13_hv_nmos w=0.5u l=0.45u m=1
MNGa_MXP_S1_34_0 NGa_MXP_n0_68 NGa_bbp1 NGa_MXP_n1_34 vss sg13_hv_nmos w=0.5u l=0.45u m=1
MNGa_MXP_S1_34_1 NGa_MXP_n0_69 NGa_bp1 NGa_MXP_n1_34 vss sg13_hv_nmos w=0.5u l=0.45u m=1
MNGa_MXP_S1_35_0 NGa_MXP_n0_70 NGa_bbp1 NGa_MXP_n1_35 vss sg13_hv_nmos w=0.5u l=0.45u m=1
MNGa_MXP_S1_35_1 NGa_MXP_n0_71 NGa_bp1 NGa_MXP_n1_35 vss sg13_hv_nmos w=0.5u l=0.45u m=1
MNGa_MXP_S1_36_0 NGa_MXP_n0_72 NGa_bbp1 NGa_MXP_n1_36 vss sg13_hv_nmos w=0.5u l=0.45u m=1
MNGa_MXP_S1_36_1 NGa_MXP_n0_73 NGa_bp1 NGa_MXP_n1_36 vss sg13_hv_nmos w=0.5u l=0.45u m=1
MNGa_MXP_S1_37_0 NGa_MXP_n0_74 NGa_bbp1 NGa_MXP_n1_37 vss sg13_hv_nmos w=0.5u l=0.45u m=1
MNGa_MXP_S1_37_1 NGa_MXP_n0_75 NGa_bp1 NGa_MXP_n1_37 vss sg13_hv_nmos w=0.5u l=0.45u m=1
MNGa_MXP_S1_38_0 NGa_MXP_n0_76 NGa_bbp1 NGa_MXP_n1_38 vss sg13_hv_nmos w=0.5u l=0.45u m=1
MNGa_MXP_S1_38_1 NGa_MXP_n0_77 NGa_bp1 NGa_MXP_n1_38 vss sg13_hv_nmos w=0.5u l=0.45u m=1
MNGa_MXP_S1_39_0 NGa_MXP_n0_78 NGa_bbp1 NGa_MXP_n1_39 vss sg13_hv_nmos w=0.5u l=0.45u m=1
MNGa_MXP_S1_39_1 NGa_MXP_n0_79 NGa_bp1 NGa_MXP_n1_39 vss sg13_hv_nmos w=0.5u l=0.45u m=1
MNGa_MXP_S1_40_0 NGa_MXP_n0_80 NGa_bbp1 NGa_MXP_n1_40 vss sg13_hv_nmos w=0.5u l=0.45u m=1
MNGa_MXP_S1_40_1 NGa_MXP_n0_81 NGa_bp1 NGa_MXP_n1_40 vss sg13_hv_nmos w=0.5u l=0.45u m=1
MNGa_MXP_S1_41_0 NGa_MXP_n0_82 NGa_bbp1 NGa_MXP_n1_41 vss sg13_hv_nmos w=0.5u l=0.45u m=1
MNGa_MXP_S1_41_1 NGa_MXP_n0_83 NGa_bp1 NGa_MXP_n1_41 vss sg13_hv_nmos w=0.5u l=0.45u m=1
MNGa_MXP_S1_42_0 NGa_MXP_n0_84 NGa_bbp1 NGa_MXP_n1_42 vss sg13_hv_nmos w=0.5u l=0.45u m=1
MNGa_MXP_S1_42_1 NGa_MXP_n0_85 NGa_bp1 NGa_MXP_n1_42 vss sg13_hv_nmos w=0.5u l=0.45u m=1
MNGa_MXP_S1_43_0 NGa_MXP_n0_86 NGa_bbp1 NGa_MXP_n1_43 vss sg13_hv_nmos w=0.5u l=0.45u m=1
MNGa_MXP_S1_43_1 NGa_MXP_n0_87 NGa_bp1 NGa_MXP_n1_43 vss sg13_hv_nmos w=0.5u l=0.45u m=1
MNGa_MXP_S1_44_0 NGa_MXP_n0_88 NGa_bbp1 NGa_MXP_n1_44 vss sg13_hv_nmos w=0.5u l=0.45u m=1
MNGa_MXP_S1_44_1 NGa_MXP_n0_89 NGa_bp1 NGa_MXP_n1_44 vss sg13_hv_nmos w=0.5u l=0.45u m=1
MNGa_MXP_S1_45_0 NGa_MXP_n0_90 NGa_bbp1 NGa_MXP_n1_45 vss sg13_hv_nmos w=0.5u l=0.45u m=1
MNGa_MXP_S1_45_1 NGa_MXP_n0_91 NGa_bp1 NGa_MXP_n1_45 vss sg13_hv_nmos w=0.5u l=0.45u m=1
MNGa_MXP_S1_46_0 NGa_MXP_n0_92 NGa_bbp1 NGa_MXP_n1_46 vss sg13_hv_nmos w=0.5u l=0.45u m=1
MNGa_MXP_S1_46_1 NGa_MXP_n0_93 NGa_bp1 NGa_MXP_n1_46 vss sg13_hv_nmos w=0.5u l=0.45u m=1
MNGa_MXP_S1_47_0 NGa_MXP_n0_94 NGa_bbp1 NGa_MXP_n1_47 vss sg13_hv_nmos w=0.5u l=0.45u m=1
MNGa_MXP_S1_47_1 NGa_MXP_n0_95 NGa_bp1 NGa_MXP_n1_47 vss sg13_hv_nmos w=0.5u l=0.45u m=1
MNGa_MXP_S1_48_0 NGa_MXP_n0_96 NGa_bbp1 NGa_MXP_n1_48 vss sg13_hv_nmos w=0.5u l=0.45u m=1
MNGa_MXP_S1_48_1 NGa_MXP_n0_97 NGa_bp1 NGa_MXP_n1_48 vss sg13_hv_nmos w=0.5u l=0.45u m=1
MNGa_MXP_S1_49_0 NGa_MXP_n0_98 NGa_bbp1 NGa_MXP_n1_49 vss sg13_hv_nmos w=0.5u l=0.45u m=1
MNGa_MXP_S1_49_1 NGa_MXP_n0_99 NGa_bp1 NGa_MXP_n1_49 vss sg13_hv_nmos w=0.5u l=0.45u m=1
MNGa_MXP_S1_50_0 NGa_MXP_n0_100 NGa_bbp1 NGa_MXP_n1_50 vss sg13_hv_nmos w=0.5u l=0.45u m=1
MNGa_MXP_S1_50_1 NGa_MXP_n0_101 NGa_bp1 NGa_MXP_n1_50 vss sg13_hv_nmos w=0.5u l=0.45u m=1
MNGa_MXP_S1_51_0 NGa_MXP_n0_102 NGa_bbp1 NGa_MXP_n1_51 vss sg13_hv_nmos w=0.5u l=0.45u m=1
MNGa_MXP_S1_51_1 NGa_MXP_n0_103 NGa_bp1 NGa_MXP_n1_51 vss sg13_hv_nmos w=0.5u l=0.45u m=1
MNGa_MXP_S1_52_0 NGa_MXP_n0_104 NGa_bbp1 NGa_MXP_n1_52 vss sg13_hv_nmos w=0.5u l=0.45u m=1
MNGa_MXP_S1_52_1 NGa_MXP_n0_105 NGa_bp1 NGa_MXP_n1_52 vss sg13_hv_nmos w=0.5u l=0.45u m=1
MNGa_MXP_S1_53_0 NGa_MXP_n0_106 NGa_bbp1 NGa_MXP_n1_53 vss sg13_hv_nmos w=0.5u l=0.45u m=1
MNGa_MXP_S1_53_1 NGa_MXP_n0_107 NGa_bp1 NGa_MXP_n1_53 vss sg13_hv_nmos w=0.5u l=0.45u m=1
MNGa_MXP_S1_54_0 NGa_MXP_n0_108 NGa_bbp1 NGa_MXP_n1_54 vss sg13_hv_nmos w=0.5u l=0.45u m=1
MNGa_MXP_S1_54_1 NGa_MXP_n0_109 NGa_bp1 NGa_MXP_n1_54 vss sg13_hv_nmos w=0.5u l=0.45u m=1
MNGa_MXP_S1_55_0 NGa_MXP_n0_110 NGa_bbp1 NGa_MXP_n1_55 vss sg13_hv_nmos w=0.5u l=0.45u m=1
MNGa_MXP_S1_55_1 NGa_MXP_n0_111 NGa_bp1 NGa_MXP_n1_55 vss sg13_hv_nmos w=0.5u l=0.45u m=1
MNGa_MXP_S1_56_0 NGa_MXP_n0_112 NGa_bbp1 NGa_MXP_n1_56 vss sg13_hv_nmos w=0.5u l=0.45u m=1
MNGa_MXP_S1_56_1 NGa_MXP_n0_113 NGa_bp1 NGa_MXP_n1_56 vss sg13_hv_nmos w=0.5u l=0.45u m=1
MNGa_MXP_S1_57_0 NGa_MXP_n0_114 NGa_bbp1 NGa_MXP_n1_57 vss sg13_hv_nmos w=0.5u l=0.45u m=1
MNGa_MXP_S1_57_1 NGa_MXP_n0_115 NGa_bp1 NGa_MXP_n1_57 vss sg13_hv_nmos w=0.5u l=0.45u m=1
MNGa_MXP_S1_58_0 NGa_MXP_n0_116 NGa_bbp1 NGa_MXP_n1_58 vss sg13_hv_nmos w=0.5u l=0.45u m=1
MNGa_MXP_S1_58_1 NGa_MXP_n0_117 NGa_bp1 NGa_MXP_n1_58 vss sg13_hv_nmos w=0.5u l=0.45u m=1
MNGa_MXP_S1_59_0 NGa_MXP_n0_118 NGa_bbp1 NGa_MXP_n1_59 vss sg13_hv_nmos w=0.5u l=0.45u m=1
MNGa_MXP_S1_59_1 NGa_MXP_n0_119 NGa_bp1 NGa_MXP_n1_59 vss sg13_hv_nmos w=0.5u l=0.45u m=1
MNGa_MXP_S1_60_0 NGa_MXP_n0_120 NGa_bbp1 NGa_MXP_n1_60 vss sg13_hv_nmos w=0.5u l=0.45u m=1
MNGa_MXP_S1_60_1 NGa_MXP_n0_121 NGa_bp1 NGa_MXP_n1_60 vss sg13_hv_nmos w=0.5u l=0.45u m=1
MNGa_MXP_S1_61_0 NGa_MXP_n0_122 NGa_bbp1 NGa_MXP_n1_61 vss sg13_hv_nmos w=0.5u l=0.45u m=1
MNGa_MXP_S1_61_1 NGa_MXP_n0_123 NGa_bp1 NGa_MXP_n1_61 vss sg13_hv_nmos w=0.5u l=0.45u m=1
MNGa_MXP_S1_62_0 NGa_MXP_n0_124 NGa_bbp1 NGa_MXP_n1_62 vss sg13_hv_nmos w=0.5u l=0.45u m=1
MNGa_MXP_S1_62_1 NGa_MXP_n0_125 NGa_bp1 NGa_MXP_n1_62 vss sg13_hv_nmos w=0.5u l=0.45u m=1
MNGa_MXP_S1_63_0 NGa_MXP_n0_126 NGa_bbp1 NGa_MXP_n1_63 vss sg13_hv_nmos w=0.5u l=0.45u m=1
MNGa_MXP_S1_63_1 NGa_MXP_n0_127 NGa_bp1 NGa_MXP_n1_63 vss sg13_hv_nmos w=0.5u l=0.45u m=1
MNGa_MXP_S2_0_0 NGa_MXP_n1_0 NGa_bbp2 NGa_MXP_n2_0 vss sg13_hv_nmos w=0.5u l=0.45u m=1
MNGa_MXP_S2_0_1 NGa_MXP_n1_1 NGa_bp2 NGa_MXP_n2_0 vss sg13_hv_nmos w=0.5u l=0.45u m=1
MNGa_MXP_S2_1_0 NGa_MXP_n1_2 NGa_bbp2 NGa_MXP_n2_1 vss sg13_hv_nmos w=0.5u l=0.45u m=1
MNGa_MXP_S2_1_1 NGa_MXP_n1_3 NGa_bp2 NGa_MXP_n2_1 vss sg13_hv_nmos w=0.5u l=0.45u m=1
MNGa_MXP_S2_2_0 NGa_MXP_n1_4 NGa_bbp2 NGa_MXP_n2_2 vss sg13_hv_nmos w=0.5u l=0.45u m=1
MNGa_MXP_S2_2_1 NGa_MXP_n1_5 NGa_bp2 NGa_MXP_n2_2 vss sg13_hv_nmos w=0.5u l=0.45u m=1
MNGa_MXP_S2_3_0 NGa_MXP_n1_6 NGa_bbp2 NGa_MXP_n2_3 vss sg13_hv_nmos w=0.5u l=0.45u m=1
MNGa_MXP_S2_3_1 NGa_MXP_n1_7 NGa_bp2 NGa_MXP_n2_3 vss sg13_hv_nmos w=0.5u l=0.45u m=1
MNGa_MXP_S2_4_0 NGa_MXP_n1_8 NGa_bbp2 NGa_MXP_n2_4 vss sg13_hv_nmos w=0.5u l=0.45u m=1
MNGa_MXP_S2_4_1 NGa_MXP_n1_9 NGa_bp2 NGa_MXP_n2_4 vss sg13_hv_nmos w=0.5u l=0.45u m=1
MNGa_MXP_S2_5_0 NGa_MXP_n1_10 NGa_bbp2 NGa_MXP_n2_5 vss sg13_hv_nmos w=0.5u l=0.45u m=1
MNGa_MXP_S2_5_1 NGa_MXP_n1_11 NGa_bp2 NGa_MXP_n2_5 vss sg13_hv_nmos w=0.5u l=0.45u m=1
MNGa_MXP_S2_6_0 NGa_MXP_n1_12 NGa_bbp2 NGa_MXP_n2_6 vss sg13_hv_nmos w=0.5u l=0.45u m=1
MNGa_MXP_S2_6_1 NGa_MXP_n1_13 NGa_bp2 NGa_MXP_n2_6 vss sg13_hv_nmos w=0.5u l=0.45u m=1
MNGa_MXP_S2_7_0 NGa_MXP_n1_14 NGa_bbp2 NGa_MXP_n2_7 vss sg13_hv_nmos w=0.5u l=0.45u m=1
MNGa_MXP_S2_7_1 NGa_MXP_n1_15 NGa_bp2 NGa_MXP_n2_7 vss sg13_hv_nmos w=0.5u l=0.45u m=1
MNGa_MXP_S2_8_0 NGa_MXP_n1_16 NGa_bbp2 NGa_MXP_n2_8 vss sg13_hv_nmos w=0.5u l=0.45u m=1
MNGa_MXP_S2_8_1 NGa_MXP_n1_17 NGa_bp2 NGa_MXP_n2_8 vss sg13_hv_nmos w=0.5u l=0.45u m=1
MNGa_MXP_S2_9_0 NGa_MXP_n1_18 NGa_bbp2 NGa_MXP_n2_9 vss sg13_hv_nmos w=0.5u l=0.45u m=1
MNGa_MXP_S2_9_1 NGa_MXP_n1_19 NGa_bp2 NGa_MXP_n2_9 vss sg13_hv_nmos w=0.5u l=0.45u m=1
MNGa_MXP_S2_10_0 NGa_MXP_n1_20 NGa_bbp2 NGa_MXP_n2_10 vss sg13_hv_nmos w=0.5u l=0.45u m=1
MNGa_MXP_S2_10_1 NGa_MXP_n1_21 NGa_bp2 NGa_MXP_n2_10 vss sg13_hv_nmos w=0.5u l=0.45u m=1
MNGa_MXP_S2_11_0 NGa_MXP_n1_22 NGa_bbp2 NGa_MXP_n2_11 vss sg13_hv_nmos w=0.5u l=0.45u m=1
MNGa_MXP_S2_11_1 NGa_MXP_n1_23 NGa_bp2 NGa_MXP_n2_11 vss sg13_hv_nmos w=0.5u l=0.45u m=1
MNGa_MXP_S2_12_0 NGa_MXP_n1_24 NGa_bbp2 NGa_MXP_n2_12 vss sg13_hv_nmos w=0.5u l=0.45u m=1
MNGa_MXP_S2_12_1 NGa_MXP_n1_25 NGa_bp2 NGa_MXP_n2_12 vss sg13_hv_nmos w=0.5u l=0.45u m=1
MNGa_MXP_S2_13_0 NGa_MXP_n1_26 NGa_bbp2 NGa_MXP_n2_13 vss sg13_hv_nmos w=0.5u l=0.45u m=1
MNGa_MXP_S2_13_1 NGa_MXP_n1_27 NGa_bp2 NGa_MXP_n2_13 vss sg13_hv_nmos w=0.5u l=0.45u m=1
MNGa_MXP_S2_14_0 NGa_MXP_n1_28 NGa_bbp2 NGa_MXP_n2_14 vss sg13_hv_nmos w=0.5u l=0.45u m=1
MNGa_MXP_S2_14_1 NGa_MXP_n1_29 NGa_bp2 NGa_MXP_n2_14 vss sg13_hv_nmos w=0.5u l=0.45u m=1
MNGa_MXP_S2_15_0 NGa_MXP_n1_30 NGa_bbp2 NGa_MXP_n2_15 vss sg13_hv_nmos w=0.5u l=0.45u m=1
MNGa_MXP_S2_15_1 NGa_MXP_n1_31 NGa_bp2 NGa_MXP_n2_15 vss sg13_hv_nmos w=0.5u l=0.45u m=1
MNGa_MXP_S2_16_0 NGa_MXP_n1_32 NGa_bbp2 NGa_MXP_n2_16 vss sg13_hv_nmos w=0.5u l=0.45u m=1
MNGa_MXP_S2_16_1 NGa_MXP_n1_33 NGa_bp2 NGa_MXP_n2_16 vss sg13_hv_nmos w=0.5u l=0.45u m=1
MNGa_MXP_S2_17_0 NGa_MXP_n1_34 NGa_bbp2 NGa_MXP_n2_17 vss sg13_hv_nmos w=0.5u l=0.45u m=1
MNGa_MXP_S2_17_1 NGa_MXP_n1_35 NGa_bp2 NGa_MXP_n2_17 vss sg13_hv_nmos w=0.5u l=0.45u m=1
MNGa_MXP_S2_18_0 NGa_MXP_n1_36 NGa_bbp2 NGa_MXP_n2_18 vss sg13_hv_nmos w=0.5u l=0.45u m=1
MNGa_MXP_S2_18_1 NGa_MXP_n1_37 NGa_bp2 NGa_MXP_n2_18 vss sg13_hv_nmos w=0.5u l=0.45u m=1
MNGa_MXP_S2_19_0 NGa_MXP_n1_38 NGa_bbp2 NGa_MXP_n2_19 vss sg13_hv_nmos w=0.5u l=0.45u m=1
MNGa_MXP_S2_19_1 NGa_MXP_n1_39 NGa_bp2 NGa_MXP_n2_19 vss sg13_hv_nmos w=0.5u l=0.45u m=1
MNGa_MXP_S2_20_0 NGa_MXP_n1_40 NGa_bbp2 NGa_MXP_n2_20 vss sg13_hv_nmos w=0.5u l=0.45u m=1
MNGa_MXP_S2_20_1 NGa_MXP_n1_41 NGa_bp2 NGa_MXP_n2_20 vss sg13_hv_nmos w=0.5u l=0.45u m=1
MNGa_MXP_S2_21_0 NGa_MXP_n1_42 NGa_bbp2 NGa_MXP_n2_21 vss sg13_hv_nmos w=0.5u l=0.45u m=1
MNGa_MXP_S2_21_1 NGa_MXP_n1_43 NGa_bp2 NGa_MXP_n2_21 vss sg13_hv_nmos w=0.5u l=0.45u m=1
MNGa_MXP_S2_22_0 NGa_MXP_n1_44 NGa_bbp2 NGa_MXP_n2_22 vss sg13_hv_nmos w=0.5u l=0.45u m=1
MNGa_MXP_S2_22_1 NGa_MXP_n1_45 NGa_bp2 NGa_MXP_n2_22 vss sg13_hv_nmos w=0.5u l=0.45u m=1
MNGa_MXP_S2_23_0 NGa_MXP_n1_46 NGa_bbp2 NGa_MXP_n2_23 vss sg13_hv_nmos w=0.5u l=0.45u m=1
MNGa_MXP_S2_23_1 NGa_MXP_n1_47 NGa_bp2 NGa_MXP_n2_23 vss sg13_hv_nmos w=0.5u l=0.45u m=1
MNGa_MXP_S2_24_0 NGa_MXP_n1_48 NGa_bbp2 NGa_MXP_n2_24 vss sg13_hv_nmos w=0.5u l=0.45u m=1
MNGa_MXP_S2_24_1 NGa_MXP_n1_49 NGa_bp2 NGa_MXP_n2_24 vss sg13_hv_nmos w=0.5u l=0.45u m=1
MNGa_MXP_S2_25_0 NGa_MXP_n1_50 NGa_bbp2 NGa_MXP_n2_25 vss sg13_hv_nmos w=0.5u l=0.45u m=1
MNGa_MXP_S2_25_1 NGa_MXP_n1_51 NGa_bp2 NGa_MXP_n2_25 vss sg13_hv_nmos w=0.5u l=0.45u m=1
MNGa_MXP_S2_26_0 NGa_MXP_n1_52 NGa_bbp2 NGa_MXP_n2_26 vss sg13_hv_nmos w=0.5u l=0.45u m=1
MNGa_MXP_S2_26_1 NGa_MXP_n1_53 NGa_bp2 NGa_MXP_n2_26 vss sg13_hv_nmos w=0.5u l=0.45u m=1
MNGa_MXP_S2_27_0 NGa_MXP_n1_54 NGa_bbp2 NGa_MXP_n2_27 vss sg13_hv_nmos w=0.5u l=0.45u m=1
MNGa_MXP_S2_27_1 NGa_MXP_n1_55 NGa_bp2 NGa_MXP_n2_27 vss sg13_hv_nmos w=0.5u l=0.45u m=1
MNGa_MXP_S2_28_0 NGa_MXP_n1_56 NGa_bbp2 NGa_MXP_n2_28 vss sg13_hv_nmos w=0.5u l=0.45u m=1
MNGa_MXP_S2_28_1 NGa_MXP_n1_57 NGa_bp2 NGa_MXP_n2_28 vss sg13_hv_nmos w=0.5u l=0.45u m=1
MNGa_MXP_S2_29_0 NGa_MXP_n1_58 NGa_bbp2 NGa_MXP_n2_29 vss sg13_hv_nmos w=0.5u l=0.45u m=1
MNGa_MXP_S2_29_1 NGa_MXP_n1_59 NGa_bp2 NGa_MXP_n2_29 vss sg13_hv_nmos w=0.5u l=0.45u m=1
MNGa_MXP_S2_30_0 NGa_MXP_n1_60 NGa_bbp2 NGa_MXP_n2_30 vss sg13_hv_nmos w=0.5u l=0.45u m=1
MNGa_MXP_S2_30_1 NGa_MXP_n1_61 NGa_bp2 NGa_MXP_n2_30 vss sg13_hv_nmos w=0.5u l=0.45u m=1
MNGa_MXP_S2_31_0 NGa_MXP_n1_62 NGa_bbp2 NGa_MXP_n2_31 vss sg13_hv_nmos w=0.5u l=0.45u m=1
MNGa_MXP_S2_31_1 NGa_MXP_n1_63 NGa_bp2 NGa_MXP_n2_31 vss sg13_hv_nmos w=0.5u l=0.45u m=1
MNGa_MXP_S3_0_0 NGa_MXP_n2_0 NGa_bbp3 NGa_MXP_n3_0 vss sg13_hv_nmos w=0.5u l=0.45u m=1
MNGa_MXP_S3_0_1 NGa_MXP_n2_1 NGa_bp3 NGa_MXP_n3_0 vss sg13_hv_nmos w=0.5u l=0.45u m=1
MNGa_MXP_S3_1_0 NGa_MXP_n2_2 NGa_bbp3 NGa_MXP_n3_1 vss sg13_hv_nmos w=0.5u l=0.45u m=1
MNGa_MXP_S3_1_1 NGa_MXP_n2_3 NGa_bp3 NGa_MXP_n3_1 vss sg13_hv_nmos w=0.5u l=0.45u m=1
MNGa_MXP_S3_2_0 NGa_MXP_n2_4 NGa_bbp3 NGa_MXP_n3_2 vss sg13_hv_nmos w=0.5u l=0.45u m=1
MNGa_MXP_S3_2_1 NGa_MXP_n2_5 NGa_bp3 NGa_MXP_n3_2 vss sg13_hv_nmos w=0.5u l=0.45u m=1
MNGa_MXP_S3_3_0 NGa_MXP_n2_6 NGa_bbp3 NGa_MXP_n3_3 vss sg13_hv_nmos w=0.5u l=0.45u m=1
MNGa_MXP_S3_3_1 NGa_MXP_n2_7 NGa_bp3 NGa_MXP_n3_3 vss sg13_hv_nmos w=0.5u l=0.45u m=1
MNGa_MXP_S3_4_0 NGa_MXP_n2_8 NGa_bbp3 NGa_MXP_n3_4 vss sg13_hv_nmos w=0.5u l=0.45u m=1
MNGa_MXP_S3_4_1 NGa_MXP_n2_9 NGa_bp3 NGa_MXP_n3_4 vss sg13_hv_nmos w=0.5u l=0.45u m=1
MNGa_MXP_S3_5_0 NGa_MXP_n2_10 NGa_bbp3 NGa_MXP_n3_5 vss sg13_hv_nmos w=0.5u l=0.45u m=1
MNGa_MXP_S3_5_1 NGa_MXP_n2_11 NGa_bp3 NGa_MXP_n3_5 vss sg13_hv_nmos w=0.5u l=0.45u m=1
MNGa_MXP_S3_6_0 NGa_MXP_n2_12 NGa_bbp3 NGa_MXP_n3_6 vss sg13_hv_nmos w=0.5u l=0.45u m=1
MNGa_MXP_S3_6_1 NGa_MXP_n2_13 NGa_bp3 NGa_MXP_n3_6 vss sg13_hv_nmos w=0.5u l=0.45u m=1
MNGa_MXP_S3_7_0 NGa_MXP_n2_14 NGa_bbp3 NGa_MXP_n3_7 vss sg13_hv_nmos w=0.5u l=0.45u m=1
MNGa_MXP_S3_7_1 NGa_MXP_n2_15 NGa_bp3 NGa_MXP_n3_7 vss sg13_hv_nmos w=0.5u l=0.45u m=1
MNGa_MXP_S3_8_0 NGa_MXP_n2_16 NGa_bbp3 NGa_MXP_n3_8 vss sg13_hv_nmos w=0.5u l=0.45u m=1
MNGa_MXP_S3_8_1 NGa_MXP_n2_17 NGa_bp3 NGa_MXP_n3_8 vss sg13_hv_nmos w=0.5u l=0.45u m=1
MNGa_MXP_S3_9_0 NGa_MXP_n2_18 NGa_bbp3 NGa_MXP_n3_9 vss sg13_hv_nmos w=0.5u l=0.45u m=1
MNGa_MXP_S3_9_1 NGa_MXP_n2_19 NGa_bp3 NGa_MXP_n3_9 vss sg13_hv_nmos w=0.5u l=0.45u m=1
MNGa_MXP_S3_10_0 NGa_MXP_n2_20 NGa_bbp3 NGa_MXP_n3_10 vss sg13_hv_nmos w=0.5u l=0.45u m=1
MNGa_MXP_S3_10_1 NGa_MXP_n2_21 NGa_bp3 NGa_MXP_n3_10 vss sg13_hv_nmos w=0.5u l=0.45u m=1
MNGa_MXP_S3_11_0 NGa_MXP_n2_22 NGa_bbp3 NGa_MXP_n3_11 vss sg13_hv_nmos w=0.5u l=0.45u m=1
MNGa_MXP_S3_11_1 NGa_MXP_n2_23 NGa_bp3 NGa_MXP_n3_11 vss sg13_hv_nmos w=0.5u l=0.45u m=1
MNGa_MXP_S3_12_0 NGa_MXP_n2_24 NGa_bbp3 NGa_MXP_n3_12 vss sg13_hv_nmos w=0.5u l=0.45u m=1
MNGa_MXP_S3_12_1 NGa_MXP_n2_25 NGa_bp3 NGa_MXP_n3_12 vss sg13_hv_nmos w=0.5u l=0.45u m=1
MNGa_MXP_S3_13_0 NGa_MXP_n2_26 NGa_bbp3 NGa_MXP_n3_13 vss sg13_hv_nmos w=0.5u l=0.45u m=1
MNGa_MXP_S3_13_1 NGa_MXP_n2_27 NGa_bp3 NGa_MXP_n3_13 vss sg13_hv_nmos w=0.5u l=0.45u m=1
MNGa_MXP_S3_14_0 NGa_MXP_n2_28 NGa_bbp3 NGa_MXP_n3_14 vss sg13_hv_nmos w=0.5u l=0.45u m=1
MNGa_MXP_S3_14_1 NGa_MXP_n2_29 NGa_bp3 NGa_MXP_n3_14 vss sg13_hv_nmos w=0.5u l=0.45u m=1
MNGa_MXP_S3_15_0 NGa_MXP_n2_30 NGa_bbp3 NGa_MXP_n3_15 vss sg13_hv_nmos w=0.5u l=0.45u m=1
MNGa_MXP_S3_15_1 NGa_MXP_n2_31 NGa_bp3 NGa_MXP_n3_15 vss sg13_hv_nmos w=0.5u l=0.45u m=1
MNGa_MXP_S4_0_0 NGa_MXP_n3_0 NGa_bbp4 NGa_MXP_n4_0 vss sg13_hv_nmos w=0.5u l=0.45u m=1
MNGa_MXP_S4_0_1 NGa_MXP_n3_1 NGa_bp4 NGa_MXP_n4_0 vss sg13_hv_nmos w=0.5u l=0.45u m=1
MNGa_MXP_S4_1_0 NGa_MXP_n3_2 NGa_bbp4 NGa_MXP_n4_1 vss sg13_hv_nmos w=0.5u l=0.45u m=1
MNGa_MXP_S4_1_1 NGa_MXP_n3_3 NGa_bp4 NGa_MXP_n4_1 vss sg13_hv_nmos w=0.5u l=0.45u m=1
MNGa_MXP_S4_2_0 NGa_MXP_n3_4 NGa_bbp4 NGa_MXP_n4_2 vss sg13_hv_nmos w=0.5u l=0.45u m=1
MNGa_MXP_S4_2_1 NGa_MXP_n3_5 NGa_bp4 NGa_MXP_n4_2 vss sg13_hv_nmos w=0.5u l=0.45u m=1
MNGa_MXP_S4_3_0 NGa_MXP_n3_6 NGa_bbp4 NGa_MXP_n4_3 vss sg13_hv_nmos w=0.5u l=0.45u m=1
MNGa_MXP_S4_3_1 NGa_MXP_n3_7 NGa_bp4 NGa_MXP_n4_3 vss sg13_hv_nmos w=0.5u l=0.45u m=1
MNGa_MXP_S4_4_0 NGa_MXP_n3_8 NGa_bbp4 NGa_MXP_n4_4 vss sg13_hv_nmos w=0.5u l=0.45u m=1
MNGa_MXP_S4_4_1 NGa_MXP_n3_9 NGa_bp4 NGa_MXP_n4_4 vss sg13_hv_nmos w=0.5u l=0.45u m=1
MNGa_MXP_S4_5_0 NGa_MXP_n3_10 NGa_bbp4 NGa_MXP_n4_5 vss sg13_hv_nmos w=0.5u l=0.45u m=1
MNGa_MXP_S4_5_1 NGa_MXP_n3_11 NGa_bp4 NGa_MXP_n4_5 vss sg13_hv_nmos w=0.5u l=0.45u m=1
MNGa_MXP_S4_6_0 NGa_MXP_n3_12 NGa_bbp4 NGa_MXP_n4_6 vss sg13_hv_nmos w=0.5u l=0.45u m=1
MNGa_MXP_S4_6_1 NGa_MXP_n3_13 NGa_bp4 NGa_MXP_n4_6 vss sg13_hv_nmos w=0.5u l=0.45u m=1
MNGa_MXP_S4_7_0 NGa_MXP_n3_14 NGa_bbp4 NGa_MXP_n4_7 vss sg13_hv_nmos w=0.5u l=0.45u m=1
MNGa_MXP_S4_7_1 NGa_MXP_n3_15 NGa_bp4 NGa_MXP_n4_7 vss sg13_hv_nmos w=0.5u l=0.45u m=1
MNGa_MXP_S5_0_0 NGa_MXP_n4_0 NGa_bbp5 NGa_MXP_n5_0 vss sg13_hv_nmos w=0.5u l=0.45u m=1
MNGa_MXP_S5_0_1 NGa_MXP_n4_1 NGa_bp5 NGa_MXP_n5_0 vss sg13_hv_nmos w=0.5u l=0.45u m=1
MNGa_MXP_S5_1_0 NGa_MXP_n4_2 NGa_bbp5 NGa_MXP_n5_1 vss sg13_hv_nmos w=0.5u l=0.45u m=1
MNGa_MXP_S5_1_1 NGa_MXP_n4_3 NGa_bp5 NGa_MXP_n5_1 vss sg13_hv_nmos w=0.5u l=0.45u m=1
MNGa_MXP_S5_2_0 NGa_MXP_n4_4 NGa_bbp5 NGa_MXP_n5_2 vss sg13_hv_nmos w=0.5u l=0.45u m=1
MNGa_MXP_S5_2_1 NGa_MXP_n4_5 NGa_bp5 NGa_MXP_n5_2 vss sg13_hv_nmos w=0.5u l=0.45u m=1
MNGa_MXP_S5_3_0 NGa_MXP_n4_6 NGa_bbp5 NGa_MXP_n5_3 vss sg13_hv_nmos w=0.5u l=0.45u m=1
MNGa_MXP_S5_3_1 NGa_MXP_n4_7 NGa_bp5 NGa_MXP_n5_3 vss sg13_hv_nmos w=0.5u l=0.45u m=1
MNGa_MXP_S6_0_0 NGa_MXP_n5_0 NGa_bbp6 NGa_MXP_n6_0 vss sg13_hv_nmos w=0.5u l=0.45u m=1
MNGa_MXP_S6_0_1 NGa_MXP_n5_1 NGa_bp6 NGa_MXP_n6_0 vss sg13_hv_nmos w=0.5u l=0.45u m=1
MNGa_MXP_S6_1_0 NGa_MXP_n5_2 NGa_bbp6 NGa_MXP_n6_1 vss sg13_hv_nmos w=0.5u l=0.45u m=1
MNGa_MXP_S6_1_1 NGa_MXP_n5_3 NGa_bp6 NGa_MXP_n6_1 vss sg13_hv_nmos w=0.5u l=0.45u m=1
MNGa_MXP_S7_0_0 NGa_MXP_n6_0 NGa_bbp7 NGa_refp vss sg13_hv_nmos w=0.5u l=0.45u m=1
MNGa_MXP_S7_0_1 NGa_MXP_n6_1 NGa_bp7 NGa_refp vss sg13_hv_nmos w=0.5u l=0.45u m=1
MNGa_MXN_S0_0_0 vss NGa_bbn0 NGa_MXN_n0_0 vss sg13_hv_nmos w=0.5u l=0.45u m=1
MNGa_MXN_S0_0_1 t1 NGa_bn0 NGa_MXN_n0_0 vss sg13_hv_nmos w=0.5u l=0.45u m=1
MNGa_MXN_S0_1_0 t2 NGa_bbn0 NGa_MXN_n0_1 vss sg13_hv_nmos w=0.5u l=0.45u m=1
MNGa_MXN_S0_1_1 t3 NGa_bn0 NGa_MXN_n0_1 vss sg13_hv_nmos w=0.5u l=0.45u m=1
MNGa_MXN_S0_2_0 t4 NGa_bbn0 NGa_MXN_n0_2 vss sg13_hv_nmos w=0.5u l=0.45u m=1
MNGa_MXN_S0_2_1 t5 NGa_bn0 NGa_MXN_n0_2 vss sg13_hv_nmos w=0.5u l=0.45u m=1
MNGa_MXN_S0_3_0 t6 NGa_bbn0 NGa_MXN_n0_3 vss sg13_hv_nmos w=0.5u l=0.45u m=1
MNGa_MXN_S0_3_1 t7 NGa_bn0 NGa_MXN_n0_3 vss sg13_hv_nmos w=0.5u l=0.45u m=1
MNGa_MXN_S0_4_0 t8 NGa_bbn0 NGa_MXN_n0_4 vss sg13_hv_nmos w=0.5u l=0.45u m=1
MNGa_MXN_S0_4_1 t9 NGa_bn0 NGa_MXN_n0_4 vss sg13_hv_nmos w=0.5u l=0.45u m=1
MNGa_MXN_S0_5_0 t10 NGa_bbn0 NGa_MXN_n0_5 vss sg13_hv_nmos w=0.5u l=0.45u m=1
MNGa_MXN_S0_5_1 t11 NGa_bn0 NGa_MXN_n0_5 vss sg13_hv_nmos w=0.5u l=0.45u m=1
MNGa_MXN_S0_6_0 t12 NGa_bbn0 NGa_MXN_n0_6 vss sg13_hv_nmos w=0.5u l=0.45u m=1
MNGa_MXN_S0_6_1 t13 NGa_bn0 NGa_MXN_n0_6 vss sg13_hv_nmos w=0.5u l=0.45u m=1
MNGa_MXN_S0_7_0 t14 NGa_bbn0 NGa_MXN_n0_7 vss sg13_hv_nmos w=0.5u l=0.45u m=1
MNGa_MXN_S0_7_1 t15 NGa_bn0 NGa_MXN_n0_7 vss sg13_hv_nmos w=0.5u l=0.45u m=1
MNGa_MXN_S0_8_0 t16 NGa_bbn0 NGa_MXN_n0_8 vss sg13_hv_nmos w=0.5u l=0.45u m=1
MNGa_MXN_S0_8_1 t17 NGa_bn0 NGa_MXN_n0_8 vss sg13_hv_nmos w=0.5u l=0.45u m=1
MNGa_MXN_S0_9_0 t18 NGa_bbn0 NGa_MXN_n0_9 vss sg13_hv_nmos w=0.5u l=0.45u m=1
MNGa_MXN_S0_9_1 t19 NGa_bn0 NGa_MXN_n0_9 vss sg13_hv_nmos w=0.5u l=0.45u m=1
MNGa_MXN_S0_10_0 t20 NGa_bbn0 NGa_MXN_n0_10 vss sg13_hv_nmos w=0.5u l=0.45u m=1
MNGa_MXN_S0_10_1 t21 NGa_bn0 NGa_MXN_n0_10 vss sg13_hv_nmos w=0.5u l=0.45u m=1
MNGa_MXN_S0_11_0 t22 NGa_bbn0 NGa_MXN_n0_11 vss sg13_hv_nmos w=0.5u l=0.45u m=1
MNGa_MXN_S0_11_1 t23 NGa_bn0 NGa_MXN_n0_11 vss sg13_hv_nmos w=0.5u l=0.45u m=1
MNGa_MXN_S0_12_0 t24 NGa_bbn0 NGa_MXN_n0_12 vss sg13_hv_nmos w=0.5u l=0.45u m=1
MNGa_MXN_S0_12_1 t25 NGa_bn0 NGa_MXN_n0_12 vss sg13_hv_nmos w=0.5u l=0.45u m=1
MNGa_MXN_S0_13_0 t26 NGa_bbn0 NGa_MXN_n0_13 vss sg13_hv_nmos w=0.5u l=0.45u m=1
MNGa_MXN_S0_13_1 t27 NGa_bn0 NGa_MXN_n0_13 vss sg13_hv_nmos w=0.5u l=0.45u m=1
MNGa_MXN_S0_14_0 t28 NGa_bbn0 NGa_MXN_n0_14 vss sg13_hv_nmos w=0.5u l=0.45u m=1
MNGa_MXN_S0_14_1 t29 NGa_bn0 NGa_MXN_n0_14 vss sg13_hv_nmos w=0.5u l=0.45u m=1
MNGa_MXN_S0_15_0 t30 NGa_bbn0 NGa_MXN_n0_15 vss sg13_hv_nmos w=0.5u l=0.45u m=1
MNGa_MXN_S0_15_1 t31 NGa_bn0 NGa_MXN_n0_15 vss sg13_hv_nmos w=0.5u l=0.45u m=1
MNGa_MXN_S0_16_0 t32 NGa_bbn0 NGa_MXN_n0_16 vss sg13_hv_nmos w=0.5u l=0.45u m=1
MNGa_MXN_S0_16_1 t33 NGa_bn0 NGa_MXN_n0_16 vss sg13_hv_nmos w=0.5u l=0.45u m=1
MNGa_MXN_S0_17_0 t34 NGa_bbn0 NGa_MXN_n0_17 vss sg13_hv_nmos w=0.5u l=0.45u m=1
MNGa_MXN_S0_17_1 t35 NGa_bn0 NGa_MXN_n0_17 vss sg13_hv_nmos w=0.5u l=0.45u m=1
MNGa_MXN_S0_18_0 t36 NGa_bbn0 NGa_MXN_n0_18 vss sg13_hv_nmos w=0.5u l=0.45u m=1
MNGa_MXN_S0_18_1 t37 NGa_bn0 NGa_MXN_n0_18 vss sg13_hv_nmos w=0.5u l=0.45u m=1
MNGa_MXN_S0_19_0 t38 NGa_bbn0 NGa_MXN_n0_19 vss sg13_hv_nmos w=0.5u l=0.45u m=1
MNGa_MXN_S0_19_1 t39 NGa_bn0 NGa_MXN_n0_19 vss sg13_hv_nmos w=0.5u l=0.45u m=1
MNGa_MXN_S0_20_0 t40 NGa_bbn0 NGa_MXN_n0_20 vss sg13_hv_nmos w=0.5u l=0.45u m=1
MNGa_MXN_S0_20_1 t41 NGa_bn0 NGa_MXN_n0_20 vss sg13_hv_nmos w=0.5u l=0.45u m=1
MNGa_MXN_S0_21_0 t42 NGa_bbn0 NGa_MXN_n0_21 vss sg13_hv_nmos w=0.5u l=0.45u m=1
MNGa_MXN_S0_21_1 t43 NGa_bn0 NGa_MXN_n0_21 vss sg13_hv_nmos w=0.5u l=0.45u m=1
MNGa_MXN_S0_22_0 t44 NGa_bbn0 NGa_MXN_n0_22 vss sg13_hv_nmos w=0.5u l=0.45u m=1
MNGa_MXN_S0_22_1 t45 NGa_bn0 NGa_MXN_n0_22 vss sg13_hv_nmos w=0.5u l=0.45u m=1
MNGa_MXN_S0_23_0 t46 NGa_bbn0 NGa_MXN_n0_23 vss sg13_hv_nmos w=0.5u l=0.45u m=1
MNGa_MXN_S0_23_1 t47 NGa_bn0 NGa_MXN_n0_23 vss sg13_hv_nmos w=0.5u l=0.45u m=1
MNGa_MXN_S0_24_0 t48 NGa_bbn0 NGa_MXN_n0_24 vss sg13_hv_nmos w=0.5u l=0.45u m=1
MNGa_MXN_S0_24_1 t49 NGa_bn0 NGa_MXN_n0_24 vss sg13_hv_nmos w=0.5u l=0.45u m=1
MNGa_MXN_S0_25_0 t50 NGa_bbn0 NGa_MXN_n0_25 vss sg13_hv_nmos w=0.5u l=0.45u m=1
MNGa_MXN_S0_25_1 t51 NGa_bn0 NGa_MXN_n0_25 vss sg13_hv_nmos w=0.5u l=0.45u m=1
MNGa_MXN_S0_26_0 t52 NGa_bbn0 NGa_MXN_n0_26 vss sg13_hv_nmos w=0.5u l=0.45u m=1
MNGa_MXN_S0_26_1 t53 NGa_bn0 NGa_MXN_n0_26 vss sg13_hv_nmos w=0.5u l=0.45u m=1
MNGa_MXN_S0_27_0 t54 NGa_bbn0 NGa_MXN_n0_27 vss sg13_hv_nmos w=0.5u l=0.45u m=1
MNGa_MXN_S0_27_1 t55 NGa_bn0 NGa_MXN_n0_27 vss sg13_hv_nmos w=0.5u l=0.45u m=1
MNGa_MXN_S0_28_0 t56 NGa_bbn0 NGa_MXN_n0_28 vss sg13_hv_nmos w=0.5u l=0.45u m=1
MNGa_MXN_S0_28_1 t57 NGa_bn0 NGa_MXN_n0_28 vss sg13_hv_nmos w=0.5u l=0.45u m=1
MNGa_MXN_S0_29_0 t58 NGa_bbn0 NGa_MXN_n0_29 vss sg13_hv_nmos w=0.5u l=0.45u m=1
MNGa_MXN_S0_29_1 t59 NGa_bn0 NGa_MXN_n0_29 vss sg13_hv_nmos w=0.5u l=0.45u m=1
MNGa_MXN_S0_30_0 t60 NGa_bbn0 NGa_MXN_n0_30 vss sg13_hv_nmos w=0.5u l=0.45u m=1
MNGa_MXN_S0_30_1 t61 NGa_bn0 NGa_MXN_n0_30 vss sg13_hv_nmos w=0.5u l=0.45u m=1
MNGa_MXN_S0_31_0 t62 NGa_bbn0 NGa_MXN_n0_31 vss sg13_hv_nmos w=0.5u l=0.45u m=1
MNGa_MXN_S0_31_1 t63 NGa_bn0 NGa_MXN_n0_31 vss sg13_hv_nmos w=0.5u l=0.45u m=1
MNGa_MXN_S0_32_0 t64 NGa_bbn0 NGa_MXN_n0_32 vss sg13_hv_nmos w=0.5u l=0.45u m=1
MNGa_MXN_S0_32_1 t65 NGa_bn0 NGa_MXN_n0_32 vss sg13_hv_nmos w=0.5u l=0.45u m=1
MNGa_MXN_S0_33_0 t66 NGa_bbn0 NGa_MXN_n0_33 vss sg13_hv_nmos w=0.5u l=0.45u m=1
MNGa_MXN_S0_33_1 t67 NGa_bn0 NGa_MXN_n0_33 vss sg13_hv_nmos w=0.5u l=0.45u m=1
MNGa_MXN_S0_34_0 t68 NGa_bbn0 NGa_MXN_n0_34 vss sg13_hv_nmos w=0.5u l=0.45u m=1
MNGa_MXN_S0_34_1 t69 NGa_bn0 NGa_MXN_n0_34 vss sg13_hv_nmos w=0.5u l=0.45u m=1
MNGa_MXN_S0_35_0 t70 NGa_bbn0 NGa_MXN_n0_35 vss sg13_hv_nmos w=0.5u l=0.45u m=1
MNGa_MXN_S0_35_1 t71 NGa_bn0 NGa_MXN_n0_35 vss sg13_hv_nmos w=0.5u l=0.45u m=1
MNGa_MXN_S0_36_0 t72 NGa_bbn0 NGa_MXN_n0_36 vss sg13_hv_nmos w=0.5u l=0.45u m=1
MNGa_MXN_S0_36_1 t73 NGa_bn0 NGa_MXN_n0_36 vss sg13_hv_nmos w=0.5u l=0.45u m=1
MNGa_MXN_S0_37_0 t74 NGa_bbn0 NGa_MXN_n0_37 vss sg13_hv_nmos w=0.5u l=0.45u m=1
MNGa_MXN_S0_37_1 t75 NGa_bn0 NGa_MXN_n0_37 vss sg13_hv_nmos w=0.5u l=0.45u m=1
MNGa_MXN_S0_38_0 t76 NGa_bbn0 NGa_MXN_n0_38 vss sg13_hv_nmos w=0.5u l=0.45u m=1
MNGa_MXN_S0_38_1 t77 NGa_bn0 NGa_MXN_n0_38 vss sg13_hv_nmos w=0.5u l=0.45u m=1
MNGa_MXN_S0_39_0 t78 NGa_bbn0 NGa_MXN_n0_39 vss sg13_hv_nmos w=0.5u l=0.45u m=1
MNGa_MXN_S0_39_1 t79 NGa_bn0 NGa_MXN_n0_39 vss sg13_hv_nmos w=0.5u l=0.45u m=1
MNGa_MXN_S0_40_0 t80 NGa_bbn0 NGa_MXN_n0_40 vss sg13_hv_nmos w=0.5u l=0.45u m=1
MNGa_MXN_S0_40_1 t81 NGa_bn0 NGa_MXN_n0_40 vss sg13_hv_nmos w=0.5u l=0.45u m=1
MNGa_MXN_S0_41_0 t82 NGa_bbn0 NGa_MXN_n0_41 vss sg13_hv_nmos w=0.5u l=0.45u m=1
MNGa_MXN_S0_41_1 t83 NGa_bn0 NGa_MXN_n0_41 vss sg13_hv_nmos w=0.5u l=0.45u m=1
MNGa_MXN_S0_42_0 t84 NGa_bbn0 NGa_MXN_n0_42 vss sg13_hv_nmos w=0.5u l=0.45u m=1
MNGa_MXN_S0_42_1 t85 NGa_bn0 NGa_MXN_n0_42 vss sg13_hv_nmos w=0.5u l=0.45u m=1
MNGa_MXN_S0_43_0 t86 NGa_bbn0 NGa_MXN_n0_43 vss sg13_hv_nmos w=0.5u l=0.45u m=1
MNGa_MXN_S0_43_1 t87 NGa_bn0 NGa_MXN_n0_43 vss sg13_hv_nmos w=0.5u l=0.45u m=1
MNGa_MXN_S0_44_0 t88 NGa_bbn0 NGa_MXN_n0_44 vss sg13_hv_nmos w=0.5u l=0.45u m=1
MNGa_MXN_S0_44_1 t89 NGa_bn0 NGa_MXN_n0_44 vss sg13_hv_nmos w=0.5u l=0.45u m=1
MNGa_MXN_S0_45_0 t90 NGa_bbn0 NGa_MXN_n0_45 vss sg13_hv_nmos w=0.5u l=0.45u m=1
MNGa_MXN_S0_45_1 t91 NGa_bn0 NGa_MXN_n0_45 vss sg13_hv_nmos w=0.5u l=0.45u m=1
MNGa_MXN_S0_46_0 t92 NGa_bbn0 NGa_MXN_n0_46 vss sg13_hv_nmos w=0.5u l=0.45u m=1
MNGa_MXN_S0_46_1 t93 NGa_bn0 NGa_MXN_n0_46 vss sg13_hv_nmos w=0.5u l=0.45u m=1
MNGa_MXN_S0_47_0 t94 NGa_bbn0 NGa_MXN_n0_47 vss sg13_hv_nmos w=0.5u l=0.45u m=1
MNGa_MXN_S0_47_1 t95 NGa_bn0 NGa_MXN_n0_47 vss sg13_hv_nmos w=0.5u l=0.45u m=1
MNGa_MXN_S0_48_0 t96 NGa_bbn0 NGa_MXN_n0_48 vss sg13_hv_nmos w=0.5u l=0.45u m=1
MNGa_MXN_S0_48_1 t97 NGa_bn0 NGa_MXN_n0_48 vss sg13_hv_nmos w=0.5u l=0.45u m=1
MNGa_MXN_S0_49_0 t98 NGa_bbn0 NGa_MXN_n0_49 vss sg13_hv_nmos w=0.5u l=0.45u m=1
MNGa_MXN_S0_49_1 t99 NGa_bn0 NGa_MXN_n0_49 vss sg13_hv_nmos w=0.5u l=0.45u m=1
MNGa_MXN_S0_50_0 t100 NGa_bbn0 NGa_MXN_n0_50 vss sg13_hv_nmos w=0.5u l=0.45u m=1
MNGa_MXN_S0_50_1 t101 NGa_bn0 NGa_MXN_n0_50 vss sg13_hv_nmos w=0.5u l=0.45u m=1
MNGa_MXN_S0_51_0 t102 NGa_bbn0 NGa_MXN_n0_51 vss sg13_hv_nmos w=0.5u l=0.45u m=1
MNGa_MXN_S0_51_1 t103 NGa_bn0 NGa_MXN_n0_51 vss sg13_hv_nmos w=0.5u l=0.45u m=1
MNGa_MXN_S0_52_0 t104 NGa_bbn0 NGa_MXN_n0_52 vss sg13_hv_nmos w=0.5u l=0.45u m=1
MNGa_MXN_S0_52_1 t105 NGa_bn0 NGa_MXN_n0_52 vss sg13_hv_nmos w=0.5u l=0.45u m=1
MNGa_MXN_S0_53_0 t106 NGa_bbn0 NGa_MXN_n0_53 vss sg13_hv_nmos w=0.5u l=0.45u m=1
MNGa_MXN_S0_53_1 t107 NGa_bn0 NGa_MXN_n0_53 vss sg13_hv_nmos w=0.5u l=0.45u m=1
MNGa_MXN_S0_54_0 t108 NGa_bbn0 NGa_MXN_n0_54 vss sg13_hv_nmos w=0.5u l=0.45u m=1
MNGa_MXN_S0_54_1 t109 NGa_bn0 NGa_MXN_n0_54 vss sg13_hv_nmos w=0.5u l=0.45u m=1
MNGa_MXN_S0_55_0 t110 NGa_bbn0 NGa_MXN_n0_55 vss sg13_hv_nmos w=0.5u l=0.45u m=1
MNGa_MXN_S0_55_1 t111 NGa_bn0 NGa_MXN_n0_55 vss sg13_hv_nmos w=0.5u l=0.45u m=1
MNGa_MXN_S0_56_0 t112 NGa_bbn0 NGa_MXN_n0_56 vss sg13_hv_nmos w=0.5u l=0.45u m=1
MNGa_MXN_S0_56_1 t113 NGa_bn0 NGa_MXN_n0_56 vss sg13_hv_nmos w=0.5u l=0.45u m=1
MNGa_MXN_S0_57_0 t114 NGa_bbn0 NGa_MXN_n0_57 vss sg13_hv_nmos w=0.5u l=0.45u m=1
MNGa_MXN_S0_57_1 t115 NGa_bn0 NGa_MXN_n0_57 vss sg13_hv_nmos w=0.5u l=0.45u m=1
MNGa_MXN_S0_58_0 t116 NGa_bbn0 NGa_MXN_n0_58 vss sg13_hv_nmos w=0.5u l=0.45u m=1
MNGa_MXN_S0_58_1 t117 NGa_bn0 NGa_MXN_n0_58 vss sg13_hv_nmos w=0.5u l=0.45u m=1
MNGa_MXN_S0_59_0 t118 NGa_bbn0 NGa_MXN_n0_59 vss sg13_hv_nmos w=0.5u l=0.45u m=1
MNGa_MXN_S0_59_1 t119 NGa_bn0 NGa_MXN_n0_59 vss sg13_hv_nmos w=0.5u l=0.45u m=1
MNGa_MXN_S0_60_0 t120 NGa_bbn0 NGa_MXN_n0_60 vss sg13_hv_nmos w=0.5u l=0.45u m=1
MNGa_MXN_S0_60_1 t121 NGa_bn0 NGa_MXN_n0_60 vss sg13_hv_nmos w=0.5u l=0.45u m=1
MNGa_MXN_S0_61_0 t122 NGa_bbn0 NGa_MXN_n0_61 vss sg13_hv_nmos w=0.5u l=0.45u m=1
MNGa_MXN_S0_61_1 t123 NGa_bn0 NGa_MXN_n0_61 vss sg13_hv_nmos w=0.5u l=0.45u m=1
MNGa_MXN_S0_62_0 t124 NGa_bbn0 NGa_MXN_n0_62 vss sg13_hv_nmos w=0.5u l=0.45u m=1
MNGa_MXN_S0_62_1 t125 NGa_bn0 NGa_MXN_n0_62 vss sg13_hv_nmos w=0.5u l=0.45u m=1
MNGa_MXN_S0_63_0 t126 NGa_bbn0 NGa_MXN_n0_63 vss sg13_hv_nmos w=0.5u l=0.45u m=1
MNGa_MXN_S0_63_1 t127 NGa_bn0 NGa_MXN_n0_63 vss sg13_hv_nmos w=0.5u l=0.45u m=1
MNGa_MXN_S0_64_0 t128 NGa_bbn0 NGa_MXN_n0_64 vss sg13_hv_nmos w=0.5u l=0.45u m=1
MNGa_MXN_S0_64_1 t129 NGa_bn0 NGa_MXN_n0_64 vss sg13_hv_nmos w=0.5u l=0.45u m=1
MNGa_MXN_S0_65_0 t130 NGa_bbn0 NGa_MXN_n0_65 vss sg13_hv_nmos w=0.5u l=0.45u m=1
MNGa_MXN_S0_65_1 t131 NGa_bn0 NGa_MXN_n0_65 vss sg13_hv_nmos w=0.5u l=0.45u m=1
MNGa_MXN_S0_66_0 t132 NGa_bbn0 NGa_MXN_n0_66 vss sg13_hv_nmos w=0.5u l=0.45u m=1
MNGa_MXN_S0_66_1 t133 NGa_bn0 NGa_MXN_n0_66 vss sg13_hv_nmos w=0.5u l=0.45u m=1
MNGa_MXN_S0_67_0 t134 NGa_bbn0 NGa_MXN_n0_67 vss sg13_hv_nmos w=0.5u l=0.45u m=1
MNGa_MXN_S0_67_1 t135 NGa_bn0 NGa_MXN_n0_67 vss sg13_hv_nmos w=0.5u l=0.45u m=1
MNGa_MXN_S0_68_0 t136 NGa_bbn0 NGa_MXN_n0_68 vss sg13_hv_nmos w=0.5u l=0.45u m=1
MNGa_MXN_S0_68_1 t137 NGa_bn0 NGa_MXN_n0_68 vss sg13_hv_nmos w=0.5u l=0.45u m=1
MNGa_MXN_S0_69_0 t138 NGa_bbn0 NGa_MXN_n0_69 vss sg13_hv_nmos w=0.5u l=0.45u m=1
MNGa_MXN_S0_69_1 t139 NGa_bn0 NGa_MXN_n0_69 vss sg13_hv_nmos w=0.5u l=0.45u m=1
MNGa_MXN_S0_70_0 t140 NGa_bbn0 NGa_MXN_n0_70 vss sg13_hv_nmos w=0.5u l=0.45u m=1
MNGa_MXN_S0_70_1 t141 NGa_bn0 NGa_MXN_n0_70 vss sg13_hv_nmos w=0.5u l=0.45u m=1
MNGa_MXN_S0_71_0 t142 NGa_bbn0 NGa_MXN_n0_71 vss sg13_hv_nmos w=0.5u l=0.45u m=1
MNGa_MXN_S0_71_1 t143 NGa_bn0 NGa_MXN_n0_71 vss sg13_hv_nmos w=0.5u l=0.45u m=1
MNGa_MXN_S0_72_0 t144 NGa_bbn0 NGa_MXN_n0_72 vss sg13_hv_nmos w=0.5u l=0.45u m=1
MNGa_MXN_S0_72_1 t145 NGa_bn0 NGa_MXN_n0_72 vss sg13_hv_nmos w=0.5u l=0.45u m=1
MNGa_MXN_S0_73_0 t146 NGa_bbn0 NGa_MXN_n0_73 vss sg13_hv_nmos w=0.5u l=0.45u m=1
MNGa_MXN_S0_73_1 t147 NGa_bn0 NGa_MXN_n0_73 vss sg13_hv_nmos w=0.5u l=0.45u m=1
MNGa_MXN_S0_74_0 t148 NGa_bbn0 NGa_MXN_n0_74 vss sg13_hv_nmos w=0.5u l=0.45u m=1
MNGa_MXN_S0_74_1 t149 NGa_bn0 NGa_MXN_n0_74 vss sg13_hv_nmos w=0.5u l=0.45u m=1
MNGa_MXN_S0_75_0 t150 NGa_bbn0 NGa_MXN_n0_75 vss sg13_hv_nmos w=0.5u l=0.45u m=1
MNGa_MXN_S0_75_1 t151 NGa_bn0 NGa_MXN_n0_75 vss sg13_hv_nmos w=0.5u l=0.45u m=1
MNGa_MXN_S0_76_0 t152 NGa_bbn0 NGa_MXN_n0_76 vss sg13_hv_nmos w=0.5u l=0.45u m=1
MNGa_MXN_S0_76_1 t153 NGa_bn0 NGa_MXN_n0_76 vss sg13_hv_nmos w=0.5u l=0.45u m=1
MNGa_MXN_S0_77_0 t154 NGa_bbn0 NGa_MXN_n0_77 vss sg13_hv_nmos w=0.5u l=0.45u m=1
MNGa_MXN_S0_77_1 t155 NGa_bn0 NGa_MXN_n0_77 vss sg13_hv_nmos w=0.5u l=0.45u m=1
MNGa_MXN_S0_78_0 t156 NGa_bbn0 NGa_MXN_n0_78 vss sg13_hv_nmos w=0.5u l=0.45u m=1
MNGa_MXN_S0_78_1 t157 NGa_bn0 NGa_MXN_n0_78 vss sg13_hv_nmos w=0.5u l=0.45u m=1
MNGa_MXN_S0_79_0 t158 NGa_bbn0 NGa_MXN_n0_79 vss sg13_hv_nmos w=0.5u l=0.45u m=1
MNGa_MXN_S0_79_1 t159 NGa_bn0 NGa_MXN_n0_79 vss sg13_hv_nmos w=0.5u l=0.45u m=1
MNGa_MXN_S0_80_0 t160 NGa_bbn0 NGa_MXN_n0_80 vss sg13_hv_nmos w=0.5u l=0.45u m=1
MNGa_MXN_S0_80_1 t161 NGa_bn0 NGa_MXN_n0_80 vss sg13_hv_nmos w=0.5u l=0.45u m=1
MNGa_MXN_S0_81_0 t162 NGa_bbn0 NGa_MXN_n0_81 vss sg13_hv_nmos w=0.5u l=0.45u m=1
MNGa_MXN_S0_81_1 t163 NGa_bn0 NGa_MXN_n0_81 vss sg13_hv_nmos w=0.5u l=0.45u m=1
MNGa_MXN_S0_82_0 t164 NGa_bbn0 NGa_MXN_n0_82 vss sg13_hv_nmos w=0.5u l=0.45u m=1
MNGa_MXN_S0_82_1 t165 NGa_bn0 NGa_MXN_n0_82 vss sg13_hv_nmos w=0.5u l=0.45u m=1
MNGa_MXN_S0_83_0 t166 NGa_bbn0 NGa_MXN_n0_83 vss sg13_hv_nmos w=0.5u l=0.45u m=1
MNGa_MXN_S0_83_1 t167 NGa_bn0 NGa_MXN_n0_83 vss sg13_hv_nmos w=0.5u l=0.45u m=1
MNGa_MXN_S0_84_0 t168 NGa_bbn0 NGa_MXN_n0_84 vss sg13_hv_nmos w=0.5u l=0.45u m=1
MNGa_MXN_S0_84_1 t169 NGa_bn0 NGa_MXN_n0_84 vss sg13_hv_nmos w=0.5u l=0.45u m=1
MNGa_MXN_S0_85_0 t170 NGa_bbn0 NGa_MXN_n0_85 vss sg13_hv_nmos w=0.5u l=0.45u m=1
MNGa_MXN_S0_85_1 t171 NGa_bn0 NGa_MXN_n0_85 vss sg13_hv_nmos w=0.5u l=0.45u m=1
MNGa_MXN_S0_86_0 t172 NGa_bbn0 NGa_MXN_n0_86 vss sg13_hv_nmos w=0.5u l=0.45u m=1
MNGa_MXN_S0_86_1 t173 NGa_bn0 NGa_MXN_n0_86 vss sg13_hv_nmos w=0.5u l=0.45u m=1
MNGa_MXN_S0_87_0 t174 NGa_bbn0 NGa_MXN_n0_87 vss sg13_hv_nmos w=0.5u l=0.45u m=1
MNGa_MXN_S0_87_1 t175 NGa_bn0 NGa_MXN_n0_87 vss sg13_hv_nmos w=0.5u l=0.45u m=1
MNGa_MXN_S0_88_0 t176 NGa_bbn0 NGa_MXN_n0_88 vss sg13_hv_nmos w=0.5u l=0.45u m=1
MNGa_MXN_S0_88_1 t177 NGa_bn0 NGa_MXN_n0_88 vss sg13_hv_nmos w=0.5u l=0.45u m=1
MNGa_MXN_S0_89_0 t178 NGa_bbn0 NGa_MXN_n0_89 vss sg13_hv_nmos w=0.5u l=0.45u m=1
MNGa_MXN_S0_89_1 t179 NGa_bn0 NGa_MXN_n0_89 vss sg13_hv_nmos w=0.5u l=0.45u m=1
MNGa_MXN_S0_90_0 t180 NGa_bbn0 NGa_MXN_n0_90 vss sg13_hv_nmos w=0.5u l=0.45u m=1
MNGa_MXN_S0_90_1 t181 NGa_bn0 NGa_MXN_n0_90 vss sg13_hv_nmos w=0.5u l=0.45u m=1
MNGa_MXN_S0_91_0 t182 NGa_bbn0 NGa_MXN_n0_91 vss sg13_hv_nmos w=0.5u l=0.45u m=1
MNGa_MXN_S0_91_1 t183 NGa_bn0 NGa_MXN_n0_91 vss sg13_hv_nmos w=0.5u l=0.45u m=1
MNGa_MXN_S0_92_0 t184 NGa_bbn0 NGa_MXN_n0_92 vss sg13_hv_nmos w=0.5u l=0.45u m=1
MNGa_MXN_S0_92_1 t185 NGa_bn0 NGa_MXN_n0_92 vss sg13_hv_nmos w=0.5u l=0.45u m=1
MNGa_MXN_S0_93_0 t186 NGa_bbn0 NGa_MXN_n0_93 vss sg13_hv_nmos w=0.5u l=0.45u m=1
MNGa_MXN_S0_93_1 t187 NGa_bn0 NGa_MXN_n0_93 vss sg13_hv_nmos w=0.5u l=0.45u m=1
MNGa_MXN_S0_94_0 t188 NGa_bbn0 NGa_MXN_n0_94 vss sg13_hv_nmos w=0.5u l=0.45u m=1
MNGa_MXN_S0_94_1 t189 NGa_bn0 NGa_MXN_n0_94 vss sg13_hv_nmos w=0.5u l=0.45u m=1
MNGa_MXN_S0_95_0 t190 NGa_bbn0 NGa_MXN_n0_95 vss sg13_hv_nmos w=0.5u l=0.45u m=1
MNGa_MXN_S0_95_1 t191 NGa_bn0 NGa_MXN_n0_95 vss sg13_hv_nmos w=0.5u l=0.45u m=1
MNGa_MXN_S0_96_0 t192 NGa_bbn0 NGa_MXN_n0_96 vss sg13_hv_nmos w=0.5u l=0.45u m=1
MNGa_MXN_S0_96_1 t193 NGa_bn0 NGa_MXN_n0_96 vss sg13_hv_nmos w=0.5u l=0.45u m=1
MNGa_MXN_S0_97_0 t194 NGa_bbn0 NGa_MXN_n0_97 vss sg13_hv_nmos w=0.5u l=0.45u m=1
MNGa_MXN_S0_97_1 t195 NGa_bn0 NGa_MXN_n0_97 vss sg13_hv_nmos w=0.5u l=0.45u m=1
MNGa_MXN_S0_98_0 t196 NGa_bbn0 NGa_MXN_n0_98 vss sg13_hv_nmos w=0.5u l=0.45u m=1
MNGa_MXN_S0_98_1 t197 NGa_bn0 NGa_MXN_n0_98 vss sg13_hv_nmos w=0.5u l=0.45u m=1
MNGa_MXN_S0_99_0 t198 NGa_bbn0 NGa_MXN_n0_99 vss sg13_hv_nmos w=0.5u l=0.45u m=1
MNGa_MXN_S0_99_1 t199 NGa_bn0 NGa_MXN_n0_99 vss sg13_hv_nmos w=0.5u l=0.45u m=1
MNGa_MXN_S0_100_0 t200 NGa_bbn0 NGa_MXN_n0_100 vss sg13_hv_nmos w=0.5u l=0.45u m=1
MNGa_MXN_S0_100_1 t201 NGa_bn0 NGa_MXN_n0_100 vss sg13_hv_nmos w=0.5u l=0.45u m=1
MNGa_MXN_S0_101_0 t202 NGa_bbn0 NGa_MXN_n0_101 vss sg13_hv_nmos w=0.5u l=0.45u m=1
MNGa_MXN_S0_101_1 t203 NGa_bn0 NGa_MXN_n0_101 vss sg13_hv_nmos w=0.5u l=0.45u m=1
MNGa_MXN_S0_102_0 t204 NGa_bbn0 NGa_MXN_n0_102 vss sg13_hv_nmos w=0.5u l=0.45u m=1
MNGa_MXN_S0_102_1 t205 NGa_bn0 NGa_MXN_n0_102 vss sg13_hv_nmos w=0.5u l=0.45u m=1
MNGa_MXN_S0_103_0 t206 NGa_bbn0 NGa_MXN_n0_103 vss sg13_hv_nmos w=0.5u l=0.45u m=1
MNGa_MXN_S0_103_1 t207 NGa_bn0 NGa_MXN_n0_103 vss sg13_hv_nmos w=0.5u l=0.45u m=1
MNGa_MXN_S0_104_0 t208 NGa_bbn0 NGa_MXN_n0_104 vss sg13_hv_nmos w=0.5u l=0.45u m=1
MNGa_MXN_S0_104_1 t209 NGa_bn0 NGa_MXN_n0_104 vss sg13_hv_nmos w=0.5u l=0.45u m=1
MNGa_MXN_S0_105_0 t210 NGa_bbn0 NGa_MXN_n0_105 vss sg13_hv_nmos w=0.5u l=0.45u m=1
MNGa_MXN_S0_105_1 t211 NGa_bn0 NGa_MXN_n0_105 vss sg13_hv_nmos w=0.5u l=0.45u m=1
MNGa_MXN_S0_106_0 t212 NGa_bbn0 NGa_MXN_n0_106 vss sg13_hv_nmos w=0.5u l=0.45u m=1
MNGa_MXN_S0_106_1 t213 NGa_bn0 NGa_MXN_n0_106 vss sg13_hv_nmos w=0.5u l=0.45u m=1
MNGa_MXN_S0_107_0 t214 NGa_bbn0 NGa_MXN_n0_107 vss sg13_hv_nmos w=0.5u l=0.45u m=1
MNGa_MXN_S0_107_1 t215 NGa_bn0 NGa_MXN_n0_107 vss sg13_hv_nmos w=0.5u l=0.45u m=1
MNGa_MXN_S0_108_0 t216 NGa_bbn0 NGa_MXN_n0_108 vss sg13_hv_nmos w=0.5u l=0.45u m=1
MNGa_MXN_S0_108_1 t217 NGa_bn0 NGa_MXN_n0_108 vss sg13_hv_nmos w=0.5u l=0.45u m=1
MNGa_MXN_S0_109_0 t218 NGa_bbn0 NGa_MXN_n0_109 vss sg13_hv_nmos w=0.5u l=0.45u m=1
MNGa_MXN_S0_109_1 t219 NGa_bn0 NGa_MXN_n0_109 vss sg13_hv_nmos w=0.5u l=0.45u m=1
MNGa_MXN_S0_110_0 t220 NGa_bbn0 NGa_MXN_n0_110 vss sg13_hv_nmos w=0.5u l=0.45u m=1
MNGa_MXN_S0_110_1 t221 NGa_bn0 NGa_MXN_n0_110 vss sg13_hv_nmos w=0.5u l=0.45u m=1
MNGa_MXN_S0_111_0 t222 NGa_bbn0 NGa_MXN_n0_111 vss sg13_hv_nmos w=0.5u l=0.45u m=1
MNGa_MXN_S0_111_1 t223 NGa_bn0 NGa_MXN_n0_111 vss sg13_hv_nmos w=0.5u l=0.45u m=1
MNGa_MXN_S0_112_0 t224 NGa_bbn0 NGa_MXN_n0_112 vss sg13_hv_nmos w=0.5u l=0.45u m=1
MNGa_MXN_S0_112_1 t225 NGa_bn0 NGa_MXN_n0_112 vss sg13_hv_nmos w=0.5u l=0.45u m=1
MNGa_MXN_S0_113_0 t226 NGa_bbn0 NGa_MXN_n0_113 vss sg13_hv_nmos w=0.5u l=0.45u m=1
MNGa_MXN_S0_113_1 t227 NGa_bn0 NGa_MXN_n0_113 vss sg13_hv_nmos w=0.5u l=0.45u m=1
MNGa_MXN_S0_114_0 t228 NGa_bbn0 NGa_MXN_n0_114 vss sg13_hv_nmos w=0.5u l=0.45u m=1
MNGa_MXN_S0_114_1 t229 NGa_bn0 NGa_MXN_n0_114 vss sg13_hv_nmos w=0.5u l=0.45u m=1
MNGa_MXN_S0_115_0 t230 NGa_bbn0 NGa_MXN_n0_115 vss sg13_hv_nmos w=0.5u l=0.45u m=1
MNGa_MXN_S0_115_1 t231 NGa_bn0 NGa_MXN_n0_115 vss sg13_hv_nmos w=0.5u l=0.45u m=1
MNGa_MXN_S0_116_0 t232 NGa_bbn0 NGa_MXN_n0_116 vss sg13_hv_nmos w=0.5u l=0.45u m=1
MNGa_MXN_S0_116_1 t233 NGa_bn0 NGa_MXN_n0_116 vss sg13_hv_nmos w=0.5u l=0.45u m=1
MNGa_MXN_S0_117_0 t234 NGa_bbn0 NGa_MXN_n0_117 vss sg13_hv_nmos w=0.5u l=0.45u m=1
MNGa_MXN_S0_117_1 t235 NGa_bn0 NGa_MXN_n0_117 vss sg13_hv_nmos w=0.5u l=0.45u m=1
MNGa_MXN_S0_118_0 t236 NGa_bbn0 NGa_MXN_n0_118 vss sg13_hv_nmos w=0.5u l=0.45u m=1
MNGa_MXN_S0_118_1 t237 NGa_bn0 NGa_MXN_n0_118 vss sg13_hv_nmos w=0.5u l=0.45u m=1
MNGa_MXN_S0_119_0 t238 NGa_bbn0 NGa_MXN_n0_119 vss sg13_hv_nmos w=0.5u l=0.45u m=1
MNGa_MXN_S0_119_1 t239 NGa_bn0 NGa_MXN_n0_119 vss sg13_hv_nmos w=0.5u l=0.45u m=1
MNGa_MXN_S0_120_0 t240 NGa_bbn0 NGa_MXN_n0_120 vss sg13_hv_nmos w=0.5u l=0.45u m=1
MNGa_MXN_S0_120_1 t241 NGa_bn0 NGa_MXN_n0_120 vss sg13_hv_nmos w=0.5u l=0.45u m=1
MNGa_MXN_S0_121_0 t242 NGa_bbn0 NGa_MXN_n0_121 vss sg13_hv_nmos w=0.5u l=0.45u m=1
MNGa_MXN_S0_121_1 t243 NGa_bn0 NGa_MXN_n0_121 vss sg13_hv_nmos w=0.5u l=0.45u m=1
MNGa_MXN_S0_122_0 t244 NGa_bbn0 NGa_MXN_n0_122 vss sg13_hv_nmos w=0.5u l=0.45u m=1
MNGa_MXN_S0_122_1 t245 NGa_bn0 NGa_MXN_n0_122 vss sg13_hv_nmos w=0.5u l=0.45u m=1
MNGa_MXN_S0_123_0 t246 NGa_bbn0 NGa_MXN_n0_123 vss sg13_hv_nmos w=0.5u l=0.45u m=1
MNGa_MXN_S0_123_1 t247 NGa_bn0 NGa_MXN_n0_123 vss sg13_hv_nmos w=0.5u l=0.45u m=1
MNGa_MXN_S0_124_0 t248 NGa_bbn0 NGa_MXN_n0_124 vss sg13_hv_nmos w=0.5u l=0.45u m=1
MNGa_MXN_S0_124_1 t249 NGa_bn0 NGa_MXN_n0_124 vss sg13_hv_nmos w=0.5u l=0.45u m=1
MNGa_MXN_S0_125_0 t250 NGa_bbn0 NGa_MXN_n0_125 vss sg13_hv_nmos w=0.5u l=0.45u m=1
MNGa_MXN_S0_125_1 t251 NGa_bn0 NGa_MXN_n0_125 vss sg13_hv_nmos w=0.5u l=0.45u m=1
MNGa_MXN_S0_126_0 vref NGa_bbn0 NGa_MXN_n0_126 vss sg13_hv_nmos w=0.5u l=0.45u m=1
MNGa_MXN_S0_126_1 vref NGa_bn0 NGa_MXN_n0_126 vss sg13_hv_nmos w=0.5u l=0.45u m=1
MNGa_MXN_S0_127_0 vref NGa_bbn0 NGa_MXN_n0_127 vss sg13_hv_nmos w=0.5u l=0.45u m=1
MNGa_MXN_S0_127_1 vref NGa_bn0 NGa_MXN_n0_127 vss sg13_hv_nmos w=0.5u l=0.45u m=1
MNGa_MXN_S1_0_0 NGa_MXN_n0_0 NGa_bbn1 NGa_MXN_n1_0 vss sg13_hv_nmos w=0.5u l=0.45u m=1
MNGa_MXN_S1_0_1 NGa_MXN_n0_1 NGa_bn1 NGa_MXN_n1_0 vss sg13_hv_nmos w=0.5u l=0.45u m=1
MNGa_MXN_S1_1_0 NGa_MXN_n0_2 NGa_bbn1 NGa_MXN_n1_1 vss sg13_hv_nmos w=0.5u l=0.45u m=1
MNGa_MXN_S1_1_1 NGa_MXN_n0_3 NGa_bn1 NGa_MXN_n1_1 vss sg13_hv_nmos w=0.5u l=0.45u m=1
MNGa_MXN_S1_2_0 NGa_MXN_n0_4 NGa_bbn1 NGa_MXN_n1_2 vss sg13_hv_nmos w=0.5u l=0.45u m=1
MNGa_MXN_S1_2_1 NGa_MXN_n0_5 NGa_bn1 NGa_MXN_n1_2 vss sg13_hv_nmos w=0.5u l=0.45u m=1
MNGa_MXN_S1_3_0 NGa_MXN_n0_6 NGa_bbn1 NGa_MXN_n1_3 vss sg13_hv_nmos w=0.5u l=0.45u m=1
MNGa_MXN_S1_3_1 NGa_MXN_n0_7 NGa_bn1 NGa_MXN_n1_3 vss sg13_hv_nmos w=0.5u l=0.45u m=1
MNGa_MXN_S1_4_0 NGa_MXN_n0_8 NGa_bbn1 NGa_MXN_n1_4 vss sg13_hv_nmos w=0.5u l=0.45u m=1
MNGa_MXN_S1_4_1 NGa_MXN_n0_9 NGa_bn1 NGa_MXN_n1_4 vss sg13_hv_nmos w=0.5u l=0.45u m=1
MNGa_MXN_S1_5_0 NGa_MXN_n0_10 NGa_bbn1 NGa_MXN_n1_5 vss sg13_hv_nmos w=0.5u l=0.45u m=1
MNGa_MXN_S1_5_1 NGa_MXN_n0_11 NGa_bn1 NGa_MXN_n1_5 vss sg13_hv_nmos w=0.5u l=0.45u m=1
MNGa_MXN_S1_6_0 NGa_MXN_n0_12 NGa_bbn1 NGa_MXN_n1_6 vss sg13_hv_nmos w=0.5u l=0.45u m=1
MNGa_MXN_S1_6_1 NGa_MXN_n0_13 NGa_bn1 NGa_MXN_n1_6 vss sg13_hv_nmos w=0.5u l=0.45u m=1
MNGa_MXN_S1_7_0 NGa_MXN_n0_14 NGa_bbn1 NGa_MXN_n1_7 vss sg13_hv_nmos w=0.5u l=0.45u m=1
MNGa_MXN_S1_7_1 NGa_MXN_n0_15 NGa_bn1 NGa_MXN_n1_7 vss sg13_hv_nmos w=0.5u l=0.45u m=1
MNGa_MXN_S1_8_0 NGa_MXN_n0_16 NGa_bbn1 NGa_MXN_n1_8 vss sg13_hv_nmos w=0.5u l=0.45u m=1
MNGa_MXN_S1_8_1 NGa_MXN_n0_17 NGa_bn1 NGa_MXN_n1_8 vss sg13_hv_nmos w=0.5u l=0.45u m=1
MNGa_MXN_S1_9_0 NGa_MXN_n0_18 NGa_bbn1 NGa_MXN_n1_9 vss sg13_hv_nmos w=0.5u l=0.45u m=1
MNGa_MXN_S1_9_1 NGa_MXN_n0_19 NGa_bn1 NGa_MXN_n1_9 vss sg13_hv_nmos w=0.5u l=0.45u m=1
MNGa_MXN_S1_10_0 NGa_MXN_n0_20 NGa_bbn1 NGa_MXN_n1_10 vss sg13_hv_nmos w=0.5u l=0.45u m=1
MNGa_MXN_S1_10_1 NGa_MXN_n0_21 NGa_bn1 NGa_MXN_n1_10 vss sg13_hv_nmos w=0.5u l=0.45u m=1
MNGa_MXN_S1_11_0 NGa_MXN_n0_22 NGa_bbn1 NGa_MXN_n1_11 vss sg13_hv_nmos w=0.5u l=0.45u m=1
MNGa_MXN_S1_11_1 NGa_MXN_n0_23 NGa_bn1 NGa_MXN_n1_11 vss sg13_hv_nmos w=0.5u l=0.45u m=1
MNGa_MXN_S1_12_0 NGa_MXN_n0_24 NGa_bbn1 NGa_MXN_n1_12 vss sg13_hv_nmos w=0.5u l=0.45u m=1
MNGa_MXN_S1_12_1 NGa_MXN_n0_25 NGa_bn1 NGa_MXN_n1_12 vss sg13_hv_nmos w=0.5u l=0.45u m=1
MNGa_MXN_S1_13_0 NGa_MXN_n0_26 NGa_bbn1 NGa_MXN_n1_13 vss sg13_hv_nmos w=0.5u l=0.45u m=1
MNGa_MXN_S1_13_1 NGa_MXN_n0_27 NGa_bn1 NGa_MXN_n1_13 vss sg13_hv_nmos w=0.5u l=0.45u m=1
MNGa_MXN_S1_14_0 NGa_MXN_n0_28 NGa_bbn1 NGa_MXN_n1_14 vss sg13_hv_nmos w=0.5u l=0.45u m=1
MNGa_MXN_S1_14_1 NGa_MXN_n0_29 NGa_bn1 NGa_MXN_n1_14 vss sg13_hv_nmos w=0.5u l=0.45u m=1
MNGa_MXN_S1_15_0 NGa_MXN_n0_30 NGa_bbn1 NGa_MXN_n1_15 vss sg13_hv_nmos w=0.5u l=0.45u m=1
MNGa_MXN_S1_15_1 NGa_MXN_n0_31 NGa_bn1 NGa_MXN_n1_15 vss sg13_hv_nmos w=0.5u l=0.45u m=1
MNGa_MXN_S1_16_0 NGa_MXN_n0_32 NGa_bbn1 NGa_MXN_n1_16 vss sg13_hv_nmos w=0.5u l=0.45u m=1
MNGa_MXN_S1_16_1 NGa_MXN_n0_33 NGa_bn1 NGa_MXN_n1_16 vss sg13_hv_nmos w=0.5u l=0.45u m=1
MNGa_MXN_S1_17_0 NGa_MXN_n0_34 NGa_bbn1 NGa_MXN_n1_17 vss sg13_hv_nmos w=0.5u l=0.45u m=1
MNGa_MXN_S1_17_1 NGa_MXN_n0_35 NGa_bn1 NGa_MXN_n1_17 vss sg13_hv_nmos w=0.5u l=0.45u m=1
MNGa_MXN_S1_18_0 NGa_MXN_n0_36 NGa_bbn1 NGa_MXN_n1_18 vss sg13_hv_nmos w=0.5u l=0.45u m=1
MNGa_MXN_S1_18_1 NGa_MXN_n0_37 NGa_bn1 NGa_MXN_n1_18 vss sg13_hv_nmos w=0.5u l=0.45u m=1
MNGa_MXN_S1_19_0 NGa_MXN_n0_38 NGa_bbn1 NGa_MXN_n1_19 vss sg13_hv_nmos w=0.5u l=0.45u m=1
MNGa_MXN_S1_19_1 NGa_MXN_n0_39 NGa_bn1 NGa_MXN_n1_19 vss sg13_hv_nmos w=0.5u l=0.45u m=1
MNGa_MXN_S1_20_0 NGa_MXN_n0_40 NGa_bbn1 NGa_MXN_n1_20 vss sg13_hv_nmos w=0.5u l=0.45u m=1
MNGa_MXN_S1_20_1 NGa_MXN_n0_41 NGa_bn1 NGa_MXN_n1_20 vss sg13_hv_nmos w=0.5u l=0.45u m=1
MNGa_MXN_S1_21_0 NGa_MXN_n0_42 NGa_bbn1 NGa_MXN_n1_21 vss sg13_hv_nmos w=0.5u l=0.45u m=1
MNGa_MXN_S1_21_1 NGa_MXN_n0_43 NGa_bn1 NGa_MXN_n1_21 vss sg13_hv_nmos w=0.5u l=0.45u m=1
MNGa_MXN_S1_22_0 NGa_MXN_n0_44 NGa_bbn1 NGa_MXN_n1_22 vss sg13_hv_nmos w=0.5u l=0.45u m=1
MNGa_MXN_S1_22_1 NGa_MXN_n0_45 NGa_bn1 NGa_MXN_n1_22 vss sg13_hv_nmos w=0.5u l=0.45u m=1
MNGa_MXN_S1_23_0 NGa_MXN_n0_46 NGa_bbn1 NGa_MXN_n1_23 vss sg13_hv_nmos w=0.5u l=0.45u m=1
MNGa_MXN_S1_23_1 NGa_MXN_n0_47 NGa_bn1 NGa_MXN_n1_23 vss sg13_hv_nmos w=0.5u l=0.45u m=1
MNGa_MXN_S1_24_0 NGa_MXN_n0_48 NGa_bbn1 NGa_MXN_n1_24 vss sg13_hv_nmos w=0.5u l=0.45u m=1
MNGa_MXN_S1_24_1 NGa_MXN_n0_49 NGa_bn1 NGa_MXN_n1_24 vss sg13_hv_nmos w=0.5u l=0.45u m=1
MNGa_MXN_S1_25_0 NGa_MXN_n0_50 NGa_bbn1 NGa_MXN_n1_25 vss sg13_hv_nmos w=0.5u l=0.45u m=1
MNGa_MXN_S1_25_1 NGa_MXN_n0_51 NGa_bn1 NGa_MXN_n1_25 vss sg13_hv_nmos w=0.5u l=0.45u m=1
MNGa_MXN_S1_26_0 NGa_MXN_n0_52 NGa_bbn1 NGa_MXN_n1_26 vss sg13_hv_nmos w=0.5u l=0.45u m=1
MNGa_MXN_S1_26_1 NGa_MXN_n0_53 NGa_bn1 NGa_MXN_n1_26 vss sg13_hv_nmos w=0.5u l=0.45u m=1
MNGa_MXN_S1_27_0 NGa_MXN_n0_54 NGa_bbn1 NGa_MXN_n1_27 vss sg13_hv_nmos w=0.5u l=0.45u m=1
MNGa_MXN_S1_27_1 NGa_MXN_n0_55 NGa_bn1 NGa_MXN_n1_27 vss sg13_hv_nmos w=0.5u l=0.45u m=1
MNGa_MXN_S1_28_0 NGa_MXN_n0_56 NGa_bbn1 NGa_MXN_n1_28 vss sg13_hv_nmos w=0.5u l=0.45u m=1
MNGa_MXN_S1_28_1 NGa_MXN_n0_57 NGa_bn1 NGa_MXN_n1_28 vss sg13_hv_nmos w=0.5u l=0.45u m=1
MNGa_MXN_S1_29_0 NGa_MXN_n0_58 NGa_bbn1 NGa_MXN_n1_29 vss sg13_hv_nmos w=0.5u l=0.45u m=1
MNGa_MXN_S1_29_1 NGa_MXN_n0_59 NGa_bn1 NGa_MXN_n1_29 vss sg13_hv_nmos w=0.5u l=0.45u m=1
MNGa_MXN_S1_30_0 NGa_MXN_n0_60 NGa_bbn1 NGa_MXN_n1_30 vss sg13_hv_nmos w=0.5u l=0.45u m=1
MNGa_MXN_S1_30_1 NGa_MXN_n0_61 NGa_bn1 NGa_MXN_n1_30 vss sg13_hv_nmos w=0.5u l=0.45u m=1
MNGa_MXN_S1_31_0 NGa_MXN_n0_62 NGa_bbn1 NGa_MXN_n1_31 vss sg13_hv_nmos w=0.5u l=0.45u m=1
MNGa_MXN_S1_31_1 NGa_MXN_n0_63 NGa_bn1 NGa_MXN_n1_31 vss sg13_hv_nmos w=0.5u l=0.45u m=1
MNGa_MXN_S1_32_0 NGa_MXN_n0_64 NGa_bbn1 NGa_MXN_n1_32 vss sg13_hv_nmos w=0.5u l=0.45u m=1
MNGa_MXN_S1_32_1 NGa_MXN_n0_65 NGa_bn1 NGa_MXN_n1_32 vss sg13_hv_nmos w=0.5u l=0.45u m=1
MNGa_MXN_S1_33_0 NGa_MXN_n0_66 NGa_bbn1 NGa_MXN_n1_33 vss sg13_hv_nmos w=0.5u l=0.45u m=1
MNGa_MXN_S1_33_1 NGa_MXN_n0_67 NGa_bn1 NGa_MXN_n1_33 vss sg13_hv_nmos w=0.5u l=0.45u m=1
MNGa_MXN_S1_34_0 NGa_MXN_n0_68 NGa_bbn1 NGa_MXN_n1_34 vss sg13_hv_nmos w=0.5u l=0.45u m=1
MNGa_MXN_S1_34_1 NGa_MXN_n0_69 NGa_bn1 NGa_MXN_n1_34 vss sg13_hv_nmos w=0.5u l=0.45u m=1
MNGa_MXN_S1_35_0 NGa_MXN_n0_70 NGa_bbn1 NGa_MXN_n1_35 vss sg13_hv_nmos w=0.5u l=0.45u m=1
MNGa_MXN_S1_35_1 NGa_MXN_n0_71 NGa_bn1 NGa_MXN_n1_35 vss sg13_hv_nmos w=0.5u l=0.45u m=1
MNGa_MXN_S1_36_0 NGa_MXN_n0_72 NGa_bbn1 NGa_MXN_n1_36 vss sg13_hv_nmos w=0.5u l=0.45u m=1
MNGa_MXN_S1_36_1 NGa_MXN_n0_73 NGa_bn1 NGa_MXN_n1_36 vss sg13_hv_nmos w=0.5u l=0.45u m=1
MNGa_MXN_S1_37_0 NGa_MXN_n0_74 NGa_bbn1 NGa_MXN_n1_37 vss sg13_hv_nmos w=0.5u l=0.45u m=1
MNGa_MXN_S1_37_1 NGa_MXN_n0_75 NGa_bn1 NGa_MXN_n1_37 vss sg13_hv_nmos w=0.5u l=0.45u m=1
MNGa_MXN_S1_38_0 NGa_MXN_n0_76 NGa_bbn1 NGa_MXN_n1_38 vss sg13_hv_nmos w=0.5u l=0.45u m=1
MNGa_MXN_S1_38_1 NGa_MXN_n0_77 NGa_bn1 NGa_MXN_n1_38 vss sg13_hv_nmos w=0.5u l=0.45u m=1
MNGa_MXN_S1_39_0 NGa_MXN_n0_78 NGa_bbn1 NGa_MXN_n1_39 vss sg13_hv_nmos w=0.5u l=0.45u m=1
MNGa_MXN_S1_39_1 NGa_MXN_n0_79 NGa_bn1 NGa_MXN_n1_39 vss sg13_hv_nmos w=0.5u l=0.45u m=1
MNGa_MXN_S1_40_0 NGa_MXN_n0_80 NGa_bbn1 NGa_MXN_n1_40 vss sg13_hv_nmos w=0.5u l=0.45u m=1
MNGa_MXN_S1_40_1 NGa_MXN_n0_81 NGa_bn1 NGa_MXN_n1_40 vss sg13_hv_nmos w=0.5u l=0.45u m=1
MNGa_MXN_S1_41_0 NGa_MXN_n0_82 NGa_bbn1 NGa_MXN_n1_41 vss sg13_hv_nmos w=0.5u l=0.45u m=1
MNGa_MXN_S1_41_1 NGa_MXN_n0_83 NGa_bn1 NGa_MXN_n1_41 vss sg13_hv_nmos w=0.5u l=0.45u m=1
MNGa_MXN_S1_42_0 NGa_MXN_n0_84 NGa_bbn1 NGa_MXN_n1_42 vss sg13_hv_nmos w=0.5u l=0.45u m=1
MNGa_MXN_S1_42_1 NGa_MXN_n0_85 NGa_bn1 NGa_MXN_n1_42 vss sg13_hv_nmos w=0.5u l=0.45u m=1
MNGa_MXN_S1_43_0 NGa_MXN_n0_86 NGa_bbn1 NGa_MXN_n1_43 vss sg13_hv_nmos w=0.5u l=0.45u m=1
MNGa_MXN_S1_43_1 NGa_MXN_n0_87 NGa_bn1 NGa_MXN_n1_43 vss sg13_hv_nmos w=0.5u l=0.45u m=1
MNGa_MXN_S1_44_0 NGa_MXN_n0_88 NGa_bbn1 NGa_MXN_n1_44 vss sg13_hv_nmos w=0.5u l=0.45u m=1
MNGa_MXN_S1_44_1 NGa_MXN_n0_89 NGa_bn1 NGa_MXN_n1_44 vss sg13_hv_nmos w=0.5u l=0.45u m=1
MNGa_MXN_S1_45_0 NGa_MXN_n0_90 NGa_bbn1 NGa_MXN_n1_45 vss sg13_hv_nmos w=0.5u l=0.45u m=1
MNGa_MXN_S1_45_1 NGa_MXN_n0_91 NGa_bn1 NGa_MXN_n1_45 vss sg13_hv_nmos w=0.5u l=0.45u m=1
MNGa_MXN_S1_46_0 NGa_MXN_n0_92 NGa_bbn1 NGa_MXN_n1_46 vss sg13_hv_nmos w=0.5u l=0.45u m=1
MNGa_MXN_S1_46_1 NGa_MXN_n0_93 NGa_bn1 NGa_MXN_n1_46 vss sg13_hv_nmos w=0.5u l=0.45u m=1
MNGa_MXN_S1_47_0 NGa_MXN_n0_94 NGa_bbn1 NGa_MXN_n1_47 vss sg13_hv_nmos w=0.5u l=0.45u m=1
MNGa_MXN_S1_47_1 NGa_MXN_n0_95 NGa_bn1 NGa_MXN_n1_47 vss sg13_hv_nmos w=0.5u l=0.45u m=1
MNGa_MXN_S1_48_0 NGa_MXN_n0_96 NGa_bbn1 NGa_MXN_n1_48 vss sg13_hv_nmos w=0.5u l=0.45u m=1
MNGa_MXN_S1_48_1 NGa_MXN_n0_97 NGa_bn1 NGa_MXN_n1_48 vss sg13_hv_nmos w=0.5u l=0.45u m=1
MNGa_MXN_S1_49_0 NGa_MXN_n0_98 NGa_bbn1 NGa_MXN_n1_49 vss sg13_hv_nmos w=0.5u l=0.45u m=1
MNGa_MXN_S1_49_1 NGa_MXN_n0_99 NGa_bn1 NGa_MXN_n1_49 vss sg13_hv_nmos w=0.5u l=0.45u m=1
MNGa_MXN_S1_50_0 NGa_MXN_n0_100 NGa_bbn1 NGa_MXN_n1_50 vss sg13_hv_nmos w=0.5u l=0.45u m=1
MNGa_MXN_S1_50_1 NGa_MXN_n0_101 NGa_bn1 NGa_MXN_n1_50 vss sg13_hv_nmos w=0.5u l=0.45u m=1
MNGa_MXN_S1_51_0 NGa_MXN_n0_102 NGa_bbn1 NGa_MXN_n1_51 vss sg13_hv_nmos w=0.5u l=0.45u m=1
MNGa_MXN_S1_51_1 NGa_MXN_n0_103 NGa_bn1 NGa_MXN_n1_51 vss sg13_hv_nmos w=0.5u l=0.45u m=1
MNGa_MXN_S1_52_0 NGa_MXN_n0_104 NGa_bbn1 NGa_MXN_n1_52 vss sg13_hv_nmos w=0.5u l=0.45u m=1
MNGa_MXN_S1_52_1 NGa_MXN_n0_105 NGa_bn1 NGa_MXN_n1_52 vss sg13_hv_nmos w=0.5u l=0.45u m=1
MNGa_MXN_S1_53_0 NGa_MXN_n0_106 NGa_bbn1 NGa_MXN_n1_53 vss sg13_hv_nmos w=0.5u l=0.45u m=1
MNGa_MXN_S1_53_1 NGa_MXN_n0_107 NGa_bn1 NGa_MXN_n1_53 vss sg13_hv_nmos w=0.5u l=0.45u m=1
MNGa_MXN_S1_54_0 NGa_MXN_n0_108 NGa_bbn1 NGa_MXN_n1_54 vss sg13_hv_nmos w=0.5u l=0.45u m=1
MNGa_MXN_S1_54_1 NGa_MXN_n0_109 NGa_bn1 NGa_MXN_n1_54 vss sg13_hv_nmos w=0.5u l=0.45u m=1
MNGa_MXN_S1_55_0 NGa_MXN_n0_110 NGa_bbn1 NGa_MXN_n1_55 vss sg13_hv_nmos w=0.5u l=0.45u m=1
MNGa_MXN_S1_55_1 NGa_MXN_n0_111 NGa_bn1 NGa_MXN_n1_55 vss sg13_hv_nmos w=0.5u l=0.45u m=1
MNGa_MXN_S1_56_0 NGa_MXN_n0_112 NGa_bbn1 NGa_MXN_n1_56 vss sg13_hv_nmos w=0.5u l=0.45u m=1
MNGa_MXN_S1_56_1 NGa_MXN_n0_113 NGa_bn1 NGa_MXN_n1_56 vss sg13_hv_nmos w=0.5u l=0.45u m=1
MNGa_MXN_S1_57_0 NGa_MXN_n0_114 NGa_bbn1 NGa_MXN_n1_57 vss sg13_hv_nmos w=0.5u l=0.45u m=1
MNGa_MXN_S1_57_1 NGa_MXN_n0_115 NGa_bn1 NGa_MXN_n1_57 vss sg13_hv_nmos w=0.5u l=0.45u m=1
MNGa_MXN_S1_58_0 NGa_MXN_n0_116 NGa_bbn1 NGa_MXN_n1_58 vss sg13_hv_nmos w=0.5u l=0.45u m=1
MNGa_MXN_S1_58_1 NGa_MXN_n0_117 NGa_bn1 NGa_MXN_n1_58 vss sg13_hv_nmos w=0.5u l=0.45u m=1
MNGa_MXN_S1_59_0 NGa_MXN_n0_118 NGa_bbn1 NGa_MXN_n1_59 vss sg13_hv_nmos w=0.5u l=0.45u m=1
MNGa_MXN_S1_59_1 NGa_MXN_n0_119 NGa_bn1 NGa_MXN_n1_59 vss sg13_hv_nmos w=0.5u l=0.45u m=1
MNGa_MXN_S1_60_0 NGa_MXN_n0_120 NGa_bbn1 NGa_MXN_n1_60 vss sg13_hv_nmos w=0.5u l=0.45u m=1
MNGa_MXN_S1_60_1 NGa_MXN_n0_121 NGa_bn1 NGa_MXN_n1_60 vss sg13_hv_nmos w=0.5u l=0.45u m=1
MNGa_MXN_S1_61_0 NGa_MXN_n0_122 NGa_bbn1 NGa_MXN_n1_61 vss sg13_hv_nmos w=0.5u l=0.45u m=1
MNGa_MXN_S1_61_1 NGa_MXN_n0_123 NGa_bn1 NGa_MXN_n1_61 vss sg13_hv_nmos w=0.5u l=0.45u m=1
MNGa_MXN_S1_62_0 NGa_MXN_n0_124 NGa_bbn1 NGa_MXN_n1_62 vss sg13_hv_nmos w=0.5u l=0.45u m=1
MNGa_MXN_S1_62_1 NGa_MXN_n0_125 NGa_bn1 NGa_MXN_n1_62 vss sg13_hv_nmos w=0.5u l=0.45u m=1
MNGa_MXN_S1_63_0 NGa_MXN_n0_126 NGa_bbn1 NGa_MXN_n1_63 vss sg13_hv_nmos w=0.5u l=0.45u m=1
MNGa_MXN_S1_63_1 NGa_MXN_n0_127 NGa_bn1 NGa_MXN_n1_63 vss sg13_hv_nmos w=0.5u l=0.45u m=1
MNGa_MXN_S2_0_0 NGa_MXN_n1_0 NGa_bbn2 NGa_MXN_n2_0 vss sg13_hv_nmos w=0.5u l=0.45u m=1
MNGa_MXN_S2_0_1 NGa_MXN_n1_1 NGa_bn2 NGa_MXN_n2_0 vss sg13_hv_nmos w=0.5u l=0.45u m=1
MNGa_MXN_S2_1_0 NGa_MXN_n1_2 NGa_bbn2 NGa_MXN_n2_1 vss sg13_hv_nmos w=0.5u l=0.45u m=1
MNGa_MXN_S2_1_1 NGa_MXN_n1_3 NGa_bn2 NGa_MXN_n2_1 vss sg13_hv_nmos w=0.5u l=0.45u m=1
MNGa_MXN_S2_2_0 NGa_MXN_n1_4 NGa_bbn2 NGa_MXN_n2_2 vss sg13_hv_nmos w=0.5u l=0.45u m=1
MNGa_MXN_S2_2_1 NGa_MXN_n1_5 NGa_bn2 NGa_MXN_n2_2 vss sg13_hv_nmos w=0.5u l=0.45u m=1
MNGa_MXN_S2_3_0 NGa_MXN_n1_6 NGa_bbn2 NGa_MXN_n2_3 vss sg13_hv_nmos w=0.5u l=0.45u m=1
MNGa_MXN_S2_3_1 NGa_MXN_n1_7 NGa_bn2 NGa_MXN_n2_3 vss sg13_hv_nmos w=0.5u l=0.45u m=1
MNGa_MXN_S2_4_0 NGa_MXN_n1_8 NGa_bbn2 NGa_MXN_n2_4 vss sg13_hv_nmos w=0.5u l=0.45u m=1
MNGa_MXN_S2_4_1 NGa_MXN_n1_9 NGa_bn2 NGa_MXN_n2_4 vss sg13_hv_nmos w=0.5u l=0.45u m=1
MNGa_MXN_S2_5_0 NGa_MXN_n1_10 NGa_bbn2 NGa_MXN_n2_5 vss sg13_hv_nmos w=0.5u l=0.45u m=1
MNGa_MXN_S2_5_1 NGa_MXN_n1_11 NGa_bn2 NGa_MXN_n2_5 vss sg13_hv_nmos w=0.5u l=0.45u m=1
MNGa_MXN_S2_6_0 NGa_MXN_n1_12 NGa_bbn2 NGa_MXN_n2_6 vss sg13_hv_nmos w=0.5u l=0.45u m=1
MNGa_MXN_S2_6_1 NGa_MXN_n1_13 NGa_bn2 NGa_MXN_n2_6 vss sg13_hv_nmos w=0.5u l=0.45u m=1
MNGa_MXN_S2_7_0 NGa_MXN_n1_14 NGa_bbn2 NGa_MXN_n2_7 vss sg13_hv_nmos w=0.5u l=0.45u m=1
MNGa_MXN_S2_7_1 NGa_MXN_n1_15 NGa_bn2 NGa_MXN_n2_7 vss sg13_hv_nmos w=0.5u l=0.45u m=1
MNGa_MXN_S2_8_0 NGa_MXN_n1_16 NGa_bbn2 NGa_MXN_n2_8 vss sg13_hv_nmos w=0.5u l=0.45u m=1
MNGa_MXN_S2_8_1 NGa_MXN_n1_17 NGa_bn2 NGa_MXN_n2_8 vss sg13_hv_nmos w=0.5u l=0.45u m=1
MNGa_MXN_S2_9_0 NGa_MXN_n1_18 NGa_bbn2 NGa_MXN_n2_9 vss sg13_hv_nmos w=0.5u l=0.45u m=1
MNGa_MXN_S2_9_1 NGa_MXN_n1_19 NGa_bn2 NGa_MXN_n2_9 vss sg13_hv_nmos w=0.5u l=0.45u m=1
MNGa_MXN_S2_10_0 NGa_MXN_n1_20 NGa_bbn2 NGa_MXN_n2_10 vss sg13_hv_nmos w=0.5u l=0.45u m=1
MNGa_MXN_S2_10_1 NGa_MXN_n1_21 NGa_bn2 NGa_MXN_n2_10 vss sg13_hv_nmos w=0.5u l=0.45u m=1
MNGa_MXN_S2_11_0 NGa_MXN_n1_22 NGa_bbn2 NGa_MXN_n2_11 vss sg13_hv_nmos w=0.5u l=0.45u m=1
MNGa_MXN_S2_11_1 NGa_MXN_n1_23 NGa_bn2 NGa_MXN_n2_11 vss sg13_hv_nmos w=0.5u l=0.45u m=1
MNGa_MXN_S2_12_0 NGa_MXN_n1_24 NGa_bbn2 NGa_MXN_n2_12 vss sg13_hv_nmos w=0.5u l=0.45u m=1
MNGa_MXN_S2_12_1 NGa_MXN_n1_25 NGa_bn2 NGa_MXN_n2_12 vss sg13_hv_nmos w=0.5u l=0.45u m=1
MNGa_MXN_S2_13_0 NGa_MXN_n1_26 NGa_bbn2 NGa_MXN_n2_13 vss sg13_hv_nmos w=0.5u l=0.45u m=1
MNGa_MXN_S2_13_1 NGa_MXN_n1_27 NGa_bn2 NGa_MXN_n2_13 vss sg13_hv_nmos w=0.5u l=0.45u m=1
MNGa_MXN_S2_14_0 NGa_MXN_n1_28 NGa_bbn2 NGa_MXN_n2_14 vss sg13_hv_nmos w=0.5u l=0.45u m=1
MNGa_MXN_S2_14_1 NGa_MXN_n1_29 NGa_bn2 NGa_MXN_n2_14 vss sg13_hv_nmos w=0.5u l=0.45u m=1
MNGa_MXN_S2_15_0 NGa_MXN_n1_30 NGa_bbn2 NGa_MXN_n2_15 vss sg13_hv_nmos w=0.5u l=0.45u m=1
MNGa_MXN_S2_15_1 NGa_MXN_n1_31 NGa_bn2 NGa_MXN_n2_15 vss sg13_hv_nmos w=0.5u l=0.45u m=1
MNGa_MXN_S2_16_0 NGa_MXN_n1_32 NGa_bbn2 NGa_MXN_n2_16 vss sg13_hv_nmos w=0.5u l=0.45u m=1
MNGa_MXN_S2_16_1 NGa_MXN_n1_33 NGa_bn2 NGa_MXN_n2_16 vss sg13_hv_nmos w=0.5u l=0.45u m=1
MNGa_MXN_S2_17_0 NGa_MXN_n1_34 NGa_bbn2 NGa_MXN_n2_17 vss sg13_hv_nmos w=0.5u l=0.45u m=1
MNGa_MXN_S2_17_1 NGa_MXN_n1_35 NGa_bn2 NGa_MXN_n2_17 vss sg13_hv_nmos w=0.5u l=0.45u m=1
MNGa_MXN_S2_18_0 NGa_MXN_n1_36 NGa_bbn2 NGa_MXN_n2_18 vss sg13_hv_nmos w=0.5u l=0.45u m=1
MNGa_MXN_S2_18_1 NGa_MXN_n1_37 NGa_bn2 NGa_MXN_n2_18 vss sg13_hv_nmos w=0.5u l=0.45u m=1
MNGa_MXN_S2_19_0 NGa_MXN_n1_38 NGa_bbn2 NGa_MXN_n2_19 vss sg13_hv_nmos w=0.5u l=0.45u m=1
MNGa_MXN_S2_19_1 NGa_MXN_n1_39 NGa_bn2 NGa_MXN_n2_19 vss sg13_hv_nmos w=0.5u l=0.45u m=1
MNGa_MXN_S2_20_0 NGa_MXN_n1_40 NGa_bbn2 NGa_MXN_n2_20 vss sg13_hv_nmos w=0.5u l=0.45u m=1
MNGa_MXN_S2_20_1 NGa_MXN_n1_41 NGa_bn2 NGa_MXN_n2_20 vss sg13_hv_nmos w=0.5u l=0.45u m=1
MNGa_MXN_S2_21_0 NGa_MXN_n1_42 NGa_bbn2 NGa_MXN_n2_21 vss sg13_hv_nmos w=0.5u l=0.45u m=1
MNGa_MXN_S2_21_1 NGa_MXN_n1_43 NGa_bn2 NGa_MXN_n2_21 vss sg13_hv_nmos w=0.5u l=0.45u m=1
MNGa_MXN_S2_22_0 NGa_MXN_n1_44 NGa_bbn2 NGa_MXN_n2_22 vss sg13_hv_nmos w=0.5u l=0.45u m=1
MNGa_MXN_S2_22_1 NGa_MXN_n1_45 NGa_bn2 NGa_MXN_n2_22 vss sg13_hv_nmos w=0.5u l=0.45u m=1
MNGa_MXN_S2_23_0 NGa_MXN_n1_46 NGa_bbn2 NGa_MXN_n2_23 vss sg13_hv_nmos w=0.5u l=0.45u m=1
MNGa_MXN_S2_23_1 NGa_MXN_n1_47 NGa_bn2 NGa_MXN_n2_23 vss sg13_hv_nmos w=0.5u l=0.45u m=1
MNGa_MXN_S2_24_0 NGa_MXN_n1_48 NGa_bbn2 NGa_MXN_n2_24 vss sg13_hv_nmos w=0.5u l=0.45u m=1
MNGa_MXN_S2_24_1 NGa_MXN_n1_49 NGa_bn2 NGa_MXN_n2_24 vss sg13_hv_nmos w=0.5u l=0.45u m=1
MNGa_MXN_S2_25_0 NGa_MXN_n1_50 NGa_bbn2 NGa_MXN_n2_25 vss sg13_hv_nmos w=0.5u l=0.45u m=1
MNGa_MXN_S2_25_1 NGa_MXN_n1_51 NGa_bn2 NGa_MXN_n2_25 vss sg13_hv_nmos w=0.5u l=0.45u m=1
MNGa_MXN_S2_26_0 NGa_MXN_n1_52 NGa_bbn2 NGa_MXN_n2_26 vss sg13_hv_nmos w=0.5u l=0.45u m=1
MNGa_MXN_S2_26_1 NGa_MXN_n1_53 NGa_bn2 NGa_MXN_n2_26 vss sg13_hv_nmos w=0.5u l=0.45u m=1
MNGa_MXN_S2_27_0 NGa_MXN_n1_54 NGa_bbn2 NGa_MXN_n2_27 vss sg13_hv_nmos w=0.5u l=0.45u m=1
MNGa_MXN_S2_27_1 NGa_MXN_n1_55 NGa_bn2 NGa_MXN_n2_27 vss sg13_hv_nmos w=0.5u l=0.45u m=1
MNGa_MXN_S2_28_0 NGa_MXN_n1_56 NGa_bbn2 NGa_MXN_n2_28 vss sg13_hv_nmos w=0.5u l=0.45u m=1
MNGa_MXN_S2_28_1 NGa_MXN_n1_57 NGa_bn2 NGa_MXN_n2_28 vss sg13_hv_nmos w=0.5u l=0.45u m=1
MNGa_MXN_S2_29_0 NGa_MXN_n1_58 NGa_bbn2 NGa_MXN_n2_29 vss sg13_hv_nmos w=0.5u l=0.45u m=1
MNGa_MXN_S2_29_1 NGa_MXN_n1_59 NGa_bn2 NGa_MXN_n2_29 vss sg13_hv_nmos w=0.5u l=0.45u m=1
MNGa_MXN_S2_30_0 NGa_MXN_n1_60 NGa_bbn2 NGa_MXN_n2_30 vss sg13_hv_nmos w=0.5u l=0.45u m=1
MNGa_MXN_S2_30_1 NGa_MXN_n1_61 NGa_bn2 NGa_MXN_n2_30 vss sg13_hv_nmos w=0.5u l=0.45u m=1
MNGa_MXN_S2_31_0 NGa_MXN_n1_62 NGa_bbn2 NGa_MXN_n2_31 vss sg13_hv_nmos w=0.5u l=0.45u m=1
MNGa_MXN_S2_31_1 NGa_MXN_n1_63 NGa_bn2 NGa_MXN_n2_31 vss sg13_hv_nmos w=0.5u l=0.45u m=1
MNGa_MXN_S3_0_0 NGa_MXN_n2_0 NGa_bbn3 NGa_MXN_n3_0 vss sg13_hv_nmos w=0.5u l=0.45u m=1
MNGa_MXN_S3_0_1 NGa_MXN_n2_1 NGa_bn3 NGa_MXN_n3_0 vss sg13_hv_nmos w=0.5u l=0.45u m=1
MNGa_MXN_S3_1_0 NGa_MXN_n2_2 NGa_bbn3 NGa_MXN_n3_1 vss sg13_hv_nmos w=0.5u l=0.45u m=1
MNGa_MXN_S3_1_1 NGa_MXN_n2_3 NGa_bn3 NGa_MXN_n3_1 vss sg13_hv_nmos w=0.5u l=0.45u m=1
MNGa_MXN_S3_2_0 NGa_MXN_n2_4 NGa_bbn3 NGa_MXN_n3_2 vss sg13_hv_nmos w=0.5u l=0.45u m=1
MNGa_MXN_S3_2_1 NGa_MXN_n2_5 NGa_bn3 NGa_MXN_n3_2 vss sg13_hv_nmos w=0.5u l=0.45u m=1
MNGa_MXN_S3_3_0 NGa_MXN_n2_6 NGa_bbn3 NGa_MXN_n3_3 vss sg13_hv_nmos w=0.5u l=0.45u m=1
MNGa_MXN_S3_3_1 NGa_MXN_n2_7 NGa_bn3 NGa_MXN_n3_3 vss sg13_hv_nmos w=0.5u l=0.45u m=1
MNGa_MXN_S3_4_0 NGa_MXN_n2_8 NGa_bbn3 NGa_MXN_n3_4 vss sg13_hv_nmos w=0.5u l=0.45u m=1
MNGa_MXN_S3_4_1 NGa_MXN_n2_9 NGa_bn3 NGa_MXN_n3_4 vss sg13_hv_nmos w=0.5u l=0.45u m=1
MNGa_MXN_S3_5_0 NGa_MXN_n2_10 NGa_bbn3 NGa_MXN_n3_5 vss sg13_hv_nmos w=0.5u l=0.45u m=1
MNGa_MXN_S3_5_1 NGa_MXN_n2_11 NGa_bn3 NGa_MXN_n3_5 vss sg13_hv_nmos w=0.5u l=0.45u m=1
MNGa_MXN_S3_6_0 NGa_MXN_n2_12 NGa_bbn3 NGa_MXN_n3_6 vss sg13_hv_nmos w=0.5u l=0.45u m=1
MNGa_MXN_S3_6_1 NGa_MXN_n2_13 NGa_bn3 NGa_MXN_n3_6 vss sg13_hv_nmos w=0.5u l=0.45u m=1
MNGa_MXN_S3_7_0 NGa_MXN_n2_14 NGa_bbn3 NGa_MXN_n3_7 vss sg13_hv_nmos w=0.5u l=0.45u m=1
MNGa_MXN_S3_7_1 NGa_MXN_n2_15 NGa_bn3 NGa_MXN_n3_7 vss sg13_hv_nmos w=0.5u l=0.45u m=1
MNGa_MXN_S3_8_0 NGa_MXN_n2_16 NGa_bbn3 NGa_MXN_n3_8 vss sg13_hv_nmos w=0.5u l=0.45u m=1
MNGa_MXN_S3_8_1 NGa_MXN_n2_17 NGa_bn3 NGa_MXN_n3_8 vss sg13_hv_nmos w=0.5u l=0.45u m=1
MNGa_MXN_S3_9_0 NGa_MXN_n2_18 NGa_bbn3 NGa_MXN_n3_9 vss sg13_hv_nmos w=0.5u l=0.45u m=1
MNGa_MXN_S3_9_1 NGa_MXN_n2_19 NGa_bn3 NGa_MXN_n3_9 vss sg13_hv_nmos w=0.5u l=0.45u m=1
MNGa_MXN_S3_10_0 NGa_MXN_n2_20 NGa_bbn3 NGa_MXN_n3_10 vss sg13_hv_nmos w=0.5u l=0.45u m=1
MNGa_MXN_S3_10_1 NGa_MXN_n2_21 NGa_bn3 NGa_MXN_n3_10 vss sg13_hv_nmos w=0.5u l=0.45u m=1
MNGa_MXN_S3_11_0 NGa_MXN_n2_22 NGa_bbn3 NGa_MXN_n3_11 vss sg13_hv_nmos w=0.5u l=0.45u m=1
MNGa_MXN_S3_11_1 NGa_MXN_n2_23 NGa_bn3 NGa_MXN_n3_11 vss sg13_hv_nmos w=0.5u l=0.45u m=1
MNGa_MXN_S3_12_0 NGa_MXN_n2_24 NGa_bbn3 NGa_MXN_n3_12 vss sg13_hv_nmos w=0.5u l=0.45u m=1
MNGa_MXN_S3_12_1 NGa_MXN_n2_25 NGa_bn3 NGa_MXN_n3_12 vss sg13_hv_nmos w=0.5u l=0.45u m=1
MNGa_MXN_S3_13_0 NGa_MXN_n2_26 NGa_bbn3 NGa_MXN_n3_13 vss sg13_hv_nmos w=0.5u l=0.45u m=1
MNGa_MXN_S3_13_1 NGa_MXN_n2_27 NGa_bn3 NGa_MXN_n3_13 vss sg13_hv_nmos w=0.5u l=0.45u m=1
MNGa_MXN_S3_14_0 NGa_MXN_n2_28 NGa_bbn3 NGa_MXN_n3_14 vss sg13_hv_nmos w=0.5u l=0.45u m=1
MNGa_MXN_S3_14_1 NGa_MXN_n2_29 NGa_bn3 NGa_MXN_n3_14 vss sg13_hv_nmos w=0.5u l=0.45u m=1
MNGa_MXN_S3_15_0 NGa_MXN_n2_30 NGa_bbn3 NGa_MXN_n3_15 vss sg13_hv_nmos w=0.5u l=0.45u m=1
MNGa_MXN_S3_15_1 NGa_MXN_n2_31 NGa_bn3 NGa_MXN_n3_15 vss sg13_hv_nmos w=0.5u l=0.45u m=1
MNGa_MXN_S4_0_0 NGa_MXN_n3_0 NGa_bbn4 NGa_MXN_n4_0 vss sg13_hv_nmos w=0.5u l=0.45u m=1
MNGa_MXN_S4_0_1 NGa_MXN_n3_1 NGa_bn4 NGa_MXN_n4_0 vss sg13_hv_nmos w=0.5u l=0.45u m=1
MNGa_MXN_S4_1_0 NGa_MXN_n3_2 NGa_bbn4 NGa_MXN_n4_1 vss sg13_hv_nmos w=0.5u l=0.45u m=1
MNGa_MXN_S4_1_1 NGa_MXN_n3_3 NGa_bn4 NGa_MXN_n4_1 vss sg13_hv_nmos w=0.5u l=0.45u m=1
MNGa_MXN_S4_2_0 NGa_MXN_n3_4 NGa_bbn4 NGa_MXN_n4_2 vss sg13_hv_nmos w=0.5u l=0.45u m=1
MNGa_MXN_S4_2_1 NGa_MXN_n3_5 NGa_bn4 NGa_MXN_n4_2 vss sg13_hv_nmos w=0.5u l=0.45u m=1
MNGa_MXN_S4_3_0 NGa_MXN_n3_6 NGa_bbn4 NGa_MXN_n4_3 vss sg13_hv_nmos w=0.5u l=0.45u m=1
MNGa_MXN_S4_3_1 NGa_MXN_n3_7 NGa_bn4 NGa_MXN_n4_3 vss sg13_hv_nmos w=0.5u l=0.45u m=1
MNGa_MXN_S4_4_0 NGa_MXN_n3_8 NGa_bbn4 NGa_MXN_n4_4 vss sg13_hv_nmos w=0.5u l=0.45u m=1
MNGa_MXN_S4_4_1 NGa_MXN_n3_9 NGa_bn4 NGa_MXN_n4_4 vss sg13_hv_nmos w=0.5u l=0.45u m=1
MNGa_MXN_S4_5_0 NGa_MXN_n3_10 NGa_bbn4 NGa_MXN_n4_5 vss sg13_hv_nmos w=0.5u l=0.45u m=1
MNGa_MXN_S4_5_1 NGa_MXN_n3_11 NGa_bn4 NGa_MXN_n4_5 vss sg13_hv_nmos w=0.5u l=0.45u m=1
MNGa_MXN_S4_6_0 NGa_MXN_n3_12 NGa_bbn4 NGa_MXN_n4_6 vss sg13_hv_nmos w=0.5u l=0.45u m=1
MNGa_MXN_S4_6_1 NGa_MXN_n3_13 NGa_bn4 NGa_MXN_n4_6 vss sg13_hv_nmos w=0.5u l=0.45u m=1
MNGa_MXN_S4_7_0 NGa_MXN_n3_14 NGa_bbn4 NGa_MXN_n4_7 vss sg13_hv_nmos w=0.5u l=0.45u m=1
MNGa_MXN_S4_7_1 NGa_MXN_n3_15 NGa_bn4 NGa_MXN_n4_7 vss sg13_hv_nmos w=0.5u l=0.45u m=1
MNGa_MXN_S5_0_0 NGa_MXN_n4_0 NGa_bbn5 NGa_MXN_n5_0 vss sg13_hv_nmos w=0.5u l=0.45u m=1
MNGa_MXN_S5_0_1 NGa_MXN_n4_1 NGa_bn5 NGa_MXN_n5_0 vss sg13_hv_nmos w=0.5u l=0.45u m=1
MNGa_MXN_S5_1_0 NGa_MXN_n4_2 NGa_bbn5 NGa_MXN_n5_1 vss sg13_hv_nmos w=0.5u l=0.45u m=1
MNGa_MXN_S5_1_1 NGa_MXN_n4_3 NGa_bn5 NGa_MXN_n5_1 vss sg13_hv_nmos w=0.5u l=0.45u m=1
MNGa_MXN_S5_2_0 NGa_MXN_n4_4 NGa_bbn5 NGa_MXN_n5_2 vss sg13_hv_nmos w=0.5u l=0.45u m=1
MNGa_MXN_S5_2_1 NGa_MXN_n4_5 NGa_bn5 NGa_MXN_n5_2 vss sg13_hv_nmos w=0.5u l=0.45u m=1
MNGa_MXN_S5_3_0 NGa_MXN_n4_6 NGa_bbn5 NGa_MXN_n5_3 vss sg13_hv_nmos w=0.5u l=0.45u m=1
MNGa_MXN_S5_3_1 NGa_MXN_n4_7 NGa_bn5 NGa_MXN_n5_3 vss sg13_hv_nmos w=0.5u l=0.45u m=1
MNGa_MXN_S6_0_0 NGa_MXN_n5_0 NGa_bbn6 NGa_MXN_n6_0 vss sg13_hv_nmos w=0.5u l=0.45u m=1
MNGa_MXN_S6_0_1 NGa_MXN_n5_1 NGa_bn6 NGa_MXN_n6_0 vss sg13_hv_nmos w=0.5u l=0.45u m=1
MNGa_MXN_S6_1_0 NGa_MXN_n5_2 NGa_bbn6 NGa_MXN_n6_1 vss sg13_hv_nmos w=0.5u l=0.45u m=1
MNGa_MXN_S6_1_1 NGa_MXN_n5_3 NGa_bn6 NGa_MXN_n6_1 vss sg13_hv_nmos w=0.5u l=0.45u m=1
MNGa_MXN_S7_0_0 NGa_MXN_n6_0 NGa_bbn7 NGa_refn vss sg13_hv_nmos w=0.5u l=0.45u m=1
MNGa_MXN_S7_0_1 NGa_MXN_n6_1 NGa_bn7 NGa_refn vss sg13_hv_nmos w=0.5u l=0.45u m=1
MNGa_CMP_MBN ibias_na ibias_na vss vss sg13_hv_nmos w=4u l=1u m=1
MNGa_CMP_MB2 NGa_CMP_vbp ibias_na vss vss sg13_hv_nmos w=4u l=1u m=1
MNGa_CMP_MBP NGa_CMP_vbp NGa_CMP_vbp vdda vdda sg13_hv_pmos w=4u l=2u m=1
MNGa_CMP_MTA_m0 NGa_CMP_ta NGa_CMP_vbp vdda vdda sg13_hv_pmos w=4u l=2u m=1
MNGa_CMP_MTA_m1 NGa_CMP_ta NGa_CMP_vbp vdda vdda sg13_hv_pmos w=4u l=2u m=1
MNGa_CMP_MTA_m2 NGa_CMP_ta NGa_CMP_vbp vdda vdda sg13_hv_pmos w=4u l=2u m=1
MNGa_CMP_MTA_m3 NGa_CMP_ta NGa_CMP_vbp vdda vdda sg13_hv_pmos w=4u l=2u m=1
MNGa_CMP_MTA_m4 NGa_CMP_ta NGa_CMP_vbp vdda vdda sg13_hv_pmos w=4u l=2u m=1
MNGa_CMP_MTA_m5 NGa_CMP_ta NGa_CMP_vbp vdda vdda sg13_hv_pmos w=4u l=2u m=1
MNGa_CMP_MTA_m6 NGa_CMP_ta NGa_CMP_vbp vdda vdda sg13_hv_pmos w=4u l=2u m=1
MNGa_CMP_MTA_m7 NGa_CMP_ta NGa_CMP_vbp vdda vdda sg13_hv_pmos w=4u l=2u m=1
MNGa_CMP_MTB_m0 NGa_CMP_tb NGa_CMP_vbp vdda vdda sg13_hv_pmos w=4u l=2u m=1
MNGa_CMP_MTB_m1 NGa_CMP_tb NGa_CMP_vbp vdda vdda sg13_hv_pmos w=4u l=2u m=1
MNGa_CMP_MTB_m2 NGa_CMP_tb NGa_CMP_vbp vdda vdda sg13_hv_pmos w=4u l=2u m=1
MNGa_CMP_MTB_m3 NGa_CMP_tb NGa_CMP_vbp vdda vdda sg13_hv_pmos w=4u l=2u m=1
MNGa_CMP_MTB_m4 NGa_CMP_tb NGa_CMP_vbp vdda vdda sg13_hv_pmos w=4u l=2u m=1
MNGa_CMP_MTB_m5 NGa_CMP_tb NGa_CMP_vbp vdda vdda sg13_hv_pmos w=4u l=2u m=1
MNGa_CMP_MTB_m6 NGa_CMP_tb NGa_CMP_vbp vdda vdda sg13_hv_pmos w=4u l=2u m=1
MNGa_CMP_MTB_m7 NGa_CMP_tb NGa_CMP_vbp vdda vdda sg13_hv_pmos w=4u l=2u m=1
MNGa_CMP_MA1 NGa_CMP_d1 outa_n NGa_CMP_sa1 NGa_CMP_ta sg13_hv_pmos w=20u l=2u m=1
MNGa_CMP_MA2 NGa_CMP_d2 outa_p NGa_CMP_sa2 NGa_CMP_ta sg13_hv_pmos w=20u l=2u m=1
RNGa_CMP_RA1 NGa_CMP_ta NGa_CMP_sa1 vss rppd w=2u l=308u b=0 m=1
RNGa_CMP_RA2 NGa_CMP_ta NGa_CMP_sa2 vss rppd w=2u l=308u b=0 m=1
MNGa_CMP_MB1 NGa_CMP_d1 NGa_refn NGa_CMP_sb1 NGa_CMP_tb sg13_hv_pmos w=20u l=2u m=1
MNGa_CMP_MB2I NGa_CMP_d2 NGa_refp NGa_CMP_sb2 NGa_CMP_tb sg13_hv_pmos w=20u l=2u m=1
RNGa_CMP_RB1 NGa_CMP_tb NGa_CMP_sb1 vss rppd w=2u l=308u b=0 m=1
RNGa_CMP_RB2 NGa_CMP_tb NGa_CMP_sb2 vss rppd w=2u l=308u b=0 m=1
MNGa_CMP_ML1 NGa_CMP_d1 NGa_CMP_d1 vss vss sg13_hv_nmos w=40u l=10u m=1
MNGa_CMP_ML2 NGa_CMP_d2 NGa_CMP_d1 vss vss sg13_hv_nmos w=40u l=10u m=1
MNGa_CMP_MG NGa_CMP_o1 NGa_CMP_d2 vss vss sg13_hv_nmos w=2u l=2u m=1
MNGa_CMP_MGL_m0 NGa_CMP_o1 NGa_CMP_vbp vdda vdda sg13_hv_pmos w=4u l=2u m=1
MNGa_CMP_MGL_m1 NGa_CMP_o1 NGa_CMP_vbp vdda vdda sg13_hv_pmos w=4u l=2u m=1
MNGa_CMP_MI1P NGa_CMP_o2 NGa_CMP_o1 vdda vdda sg13_hv_pmos w=2u l=0.5u m=1
MNGa_CMP_MI1N NGa_CMP_o2 NGa_CMP_o1 vss vss sg13_hv_nmos w=1u l=0.45u m=1
MNGa_CMP_MH1a NGa_CMP_hn1 NGa_CMP_vbp vdda vdda sg13_hv_pmos w=0.5u l=8u m=1
MNGa_CMP_MH1b NGa_CMP_hn2 NGa_CMP_vbp NGa_CMP_hn1 vdda sg13_hv_pmos w=0.5u l=8u m=1
MNGa_CMP_MH1c NGa_CMP_hs NGa_CMP_vbp NGa_CMP_hn2 vdda sg13_hv_pmos w=0.5u l=8u m=1
MNGa_CMP_MH2 NGa_CMP_d2 NGa_CMP_o1 NGa_CMP_hs vdda sg13_hv_pmos w=1u l=0.5u m=1
MNGa_CMP_MH3 NGa_CMP_d1 NGa_CMP_o2 NGa_CMP_hs vdda sg13_hv_pmos w=1u l=0.5u m=1
MNGa_CMP_MD1P NGa_CMP_o3 NGa_CMP_o2 vdd vdd sg13_hv_pmos w=2u l=0.5u m=1
MNGa_CMP_MD1N NGa_CMP_o3 NGa_CMP_o2 vss vss sg13_hv_nmos w=1u l=0.45u m=1
MNGa_CMP_MD2P neg_a NGa_CMP_o3 vdd vdd sg13_lv_pmos w=1u l=0.13u m=1
MNGa_CMP_MD2N neg_a NGa_CMP_o3 vss vss sg13_lv_nmos w=0.5u l=0.13u m=1
MOCb_LSP0_MIP OCb_LSP0_inb ob_p0 vdd vdd sg13_lv_pmos w=1u l=0.13u m=1
MOCb_LSP0_MIN OCb_LSP0_inb ob_p0 vss vss sg13_lv_nmos w=0.5u l=0.13u m=1
MOCb_LSP0_MN1 OCb_LSP0_a ob_p0 vss vss sg13_hv_nmos w=4u l=0.45u m=1
MOCb_LSP0_MN2 OCb_LSP0_b OCb_LSP0_inb vss vss sg13_hv_nmos w=4u l=0.45u m=1
MOCb_LSP0_MP1 OCb_LSP0_a OCb_LSP0_b vdda vdda sg13_hv_pmos w=0.6u l=0.5u m=1
MOCb_LSP0_MP2 OCb_LSP0_b OCb_LSP0_a vdda vdda sg13_hv_pmos w=0.6u l=0.5u m=1
MOCb_LSP0_MB1P OCb_bbp0 OCb_LSP0_b vdda vdda sg13_hv_pmos w=2u l=0.5u m=1
MOCb_LSP0_MB1N OCb_bbp0 OCb_LSP0_b vss vss sg13_hv_nmos w=1u l=0.45u m=1
MOCb_LSP0_MB2P OCb_bp0 OCb_bbp0 vdda vdda sg13_hv_pmos w=2u l=0.5u m=1
MOCb_LSP0_MB2N OCb_bp0 OCb_bbp0 vss vss sg13_hv_nmos w=1u l=0.45u m=1
MOCb_LSN0_MIP OCb_LSN0_inb ob_n0 vdd vdd sg13_lv_pmos w=1u l=0.13u m=1
MOCb_LSN0_MIN OCb_LSN0_inb ob_n0 vss vss sg13_lv_nmos w=0.5u l=0.13u m=1
MOCb_LSN0_MN1 OCb_LSN0_a ob_n0 vss vss sg13_hv_nmos w=4u l=0.45u m=1
MOCb_LSN0_MN2 OCb_LSN0_b OCb_LSN0_inb vss vss sg13_hv_nmos w=4u l=0.45u m=1
MOCb_LSN0_MP1 OCb_LSN0_a OCb_LSN0_b vdda vdda sg13_hv_pmos w=0.6u l=0.5u m=1
MOCb_LSN0_MP2 OCb_LSN0_b OCb_LSN0_a vdda vdda sg13_hv_pmos w=0.6u l=0.5u m=1
MOCb_LSN0_MB1P OCb_bbn0 OCb_LSN0_b vdda vdda sg13_hv_pmos w=2u l=0.5u m=1
MOCb_LSN0_MB1N OCb_bbn0 OCb_LSN0_b vss vss sg13_hv_nmos w=1u l=0.45u m=1
MOCb_LSN0_MB2P OCb_bn0 OCb_bbn0 vdda vdda sg13_hv_pmos w=2u l=0.5u m=1
MOCb_LSN0_MB2N OCb_bn0 OCb_bbn0 vss vss sg13_hv_nmos w=1u l=0.45u m=1
MOCb_LSP1_MIP OCb_LSP1_inb ob_p1 vdd vdd sg13_lv_pmos w=1u l=0.13u m=1
MOCb_LSP1_MIN OCb_LSP1_inb ob_p1 vss vss sg13_lv_nmos w=0.5u l=0.13u m=1
MOCb_LSP1_MN1 OCb_LSP1_a ob_p1 vss vss sg13_hv_nmos w=4u l=0.45u m=1
MOCb_LSP1_MN2 OCb_LSP1_b OCb_LSP1_inb vss vss sg13_hv_nmos w=4u l=0.45u m=1
MOCb_LSP1_MP1 OCb_LSP1_a OCb_LSP1_b vdda vdda sg13_hv_pmos w=0.6u l=0.5u m=1
MOCb_LSP1_MP2 OCb_LSP1_b OCb_LSP1_a vdda vdda sg13_hv_pmos w=0.6u l=0.5u m=1
MOCb_LSP1_MB1P OCb_bbp1 OCb_LSP1_b vdda vdda sg13_hv_pmos w=2u l=0.5u m=1
MOCb_LSP1_MB1N OCb_bbp1 OCb_LSP1_b vss vss sg13_hv_nmos w=1u l=0.45u m=1
MOCb_LSP1_MB2P OCb_bp1 OCb_bbp1 vdda vdda sg13_hv_pmos w=2u l=0.5u m=1
MOCb_LSP1_MB2N OCb_bp1 OCb_bbp1 vss vss sg13_hv_nmos w=1u l=0.45u m=1
MOCb_LSN1_MIP OCb_LSN1_inb ob_n1 vdd vdd sg13_lv_pmos w=1u l=0.13u m=1
MOCb_LSN1_MIN OCb_LSN1_inb ob_n1 vss vss sg13_lv_nmos w=0.5u l=0.13u m=1
MOCb_LSN1_MN1 OCb_LSN1_a ob_n1 vss vss sg13_hv_nmos w=4u l=0.45u m=1
MOCb_LSN1_MN2 OCb_LSN1_b OCb_LSN1_inb vss vss sg13_hv_nmos w=4u l=0.45u m=1
MOCb_LSN1_MP1 OCb_LSN1_a OCb_LSN1_b vdda vdda sg13_hv_pmos w=0.6u l=0.5u m=1
MOCb_LSN1_MP2 OCb_LSN1_b OCb_LSN1_a vdda vdda sg13_hv_pmos w=0.6u l=0.5u m=1
MOCb_LSN1_MB1P OCb_bbn1 OCb_LSN1_b vdda vdda sg13_hv_pmos w=2u l=0.5u m=1
MOCb_LSN1_MB1N OCb_bbn1 OCb_LSN1_b vss vss sg13_hv_nmos w=1u l=0.45u m=1
MOCb_LSN1_MB2P OCb_bn1 OCb_bbn1 vdda vdda sg13_hv_pmos w=2u l=0.5u m=1
MOCb_LSN1_MB2N OCb_bn1 OCb_bbn1 vss vss sg13_hv_nmos w=1u l=0.45u m=1
MOCb_LSP2_MIP OCb_LSP2_inb ob_p2 vdd vdd sg13_lv_pmos w=1u l=0.13u m=1
MOCb_LSP2_MIN OCb_LSP2_inb ob_p2 vss vss sg13_lv_nmos w=0.5u l=0.13u m=1
MOCb_LSP2_MN1 OCb_LSP2_a ob_p2 vss vss sg13_hv_nmos w=4u l=0.45u m=1
MOCb_LSP2_MN2 OCb_LSP2_b OCb_LSP2_inb vss vss sg13_hv_nmos w=4u l=0.45u m=1
MOCb_LSP2_MP1 OCb_LSP2_a OCb_LSP2_b vdda vdda sg13_hv_pmos w=0.6u l=0.5u m=1
MOCb_LSP2_MP2 OCb_LSP2_b OCb_LSP2_a vdda vdda sg13_hv_pmos w=0.6u l=0.5u m=1
MOCb_LSP2_MB1P OCb_bbp2 OCb_LSP2_b vdda vdda sg13_hv_pmos w=2u l=0.5u m=1
MOCb_LSP2_MB1N OCb_bbp2 OCb_LSP2_b vss vss sg13_hv_nmos w=1u l=0.45u m=1
MOCb_LSP2_MB2P OCb_bp2 OCb_bbp2 vdda vdda sg13_hv_pmos w=2u l=0.5u m=1
MOCb_LSP2_MB2N OCb_bp2 OCb_bbp2 vss vss sg13_hv_nmos w=1u l=0.45u m=1
MOCb_LSN2_MIP OCb_LSN2_inb ob_n2 vdd vdd sg13_lv_pmos w=1u l=0.13u m=1
MOCb_LSN2_MIN OCb_LSN2_inb ob_n2 vss vss sg13_lv_nmos w=0.5u l=0.13u m=1
MOCb_LSN2_MN1 OCb_LSN2_a ob_n2 vss vss sg13_hv_nmos w=4u l=0.45u m=1
MOCb_LSN2_MN2 OCb_LSN2_b OCb_LSN2_inb vss vss sg13_hv_nmos w=4u l=0.45u m=1
MOCb_LSN2_MP1 OCb_LSN2_a OCb_LSN2_b vdda vdda sg13_hv_pmos w=0.6u l=0.5u m=1
MOCb_LSN2_MP2 OCb_LSN2_b OCb_LSN2_a vdda vdda sg13_hv_pmos w=0.6u l=0.5u m=1
MOCb_LSN2_MB1P OCb_bbn2 OCb_LSN2_b vdda vdda sg13_hv_pmos w=2u l=0.5u m=1
MOCb_LSN2_MB1N OCb_bbn2 OCb_LSN2_b vss vss sg13_hv_nmos w=1u l=0.45u m=1
MOCb_LSN2_MB2P OCb_bn2 OCb_bbn2 vdda vdda sg13_hv_pmos w=2u l=0.5u m=1
MOCb_LSN2_MB2N OCb_bn2 OCb_bbn2 vss vss sg13_hv_nmos w=1u l=0.45u m=1
MOCb_LSP3_MIP OCb_LSP3_inb ob_p3 vdd vdd sg13_lv_pmos w=1u l=0.13u m=1
MOCb_LSP3_MIN OCb_LSP3_inb ob_p3 vss vss sg13_lv_nmos w=0.5u l=0.13u m=1
MOCb_LSP3_MN1 OCb_LSP3_a ob_p3 vss vss sg13_hv_nmos w=4u l=0.45u m=1
MOCb_LSP3_MN2 OCb_LSP3_b OCb_LSP3_inb vss vss sg13_hv_nmos w=4u l=0.45u m=1
MOCb_LSP3_MP1 OCb_LSP3_a OCb_LSP3_b vdda vdda sg13_hv_pmos w=0.6u l=0.5u m=1
MOCb_LSP3_MP2 OCb_LSP3_b OCb_LSP3_a vdda vdda sg13_hv_pmos w=0.6u l=0.5u m=1
MOCb_LSP3_MB1P OCb_bbp3 OCb_LSP3_b vdda vdda sg13_hv_pmos w=2u l=0.5u m=1
MOCb_LSP3_MB1N OCb_bbp3 OCb_LSP3_b vss vss sg13_hv_nmos w=1u l=0.45u m=1
MOCb_LSP3_MB2P OCb_bp3 OCb_bbp3 vdda vdda sg13_hv_pmos w=2u l=0.5u m=1
MOCb_LSP3_MB2N OCb_bp3 OCb_bbp3 vss vss sg13_hv_nmos w=1u l=0.45u m=1
MOCb_LSN3_MIP OCb_LSN3_inb ob_n3 vdd vdd sg13_lv_pmos w=1u l=0.13u m=1
MOCb_LSN3_MIN OCb_LSN3_inb ob_n3 vss vss sg13_lv_nmos w=0.5u l=0.13u m=1
MOCb_LSN3_MN1 OCb_LSN3_a ob_n3 vss vss sg13_hv_nmos w=4u l=0.45u m=1
MOCb_LSN3_MN2 OCb_LSN3_b OCb_LSN3_inb vss vss sg13_hv_nmos w=4u l=0.45u m=1
MOCb_LSN3_MP1 OCb_LSN3_a OCb_LSN3_b vdda vdda sg13_hv_pmos w=0.6u l=0.5u m=1
MOCb_LSN3_MP2 OCb_LSN3_b OCb_LSN3_a vdda vdda sg13_hv_pmos w=0.6u l=0.5u m=1
MOCb_LSN3_MB1P OCb_bbn3 OCb_LSN3_b vdda vdda sg13_hv_pmos w=2u l=0.5u m=1
MOCb_LSN3_MB1N OCb_bbn3 OCb_LSN3_b vss vss sg13_hv_nmos w=1u l=0.45u m=1
MOCb_LSN3_MB2P OCb_bn3 OCb_bbn3 vdda vdda sg13_hv_pmos w=2u l=0.5u m=1
MOCb_LSN3_MB2N OCb_bn3 OCb_bbn3 vss vss sg13_hv_nmos w=1u l=0.45u m=1
MOCb_LSP4_MIP OCb_LSP4_inb ob_p4 vdd vdd sg13_lv_pmos w=1u l=0.13u m=1
MOCb_LSP4_MIN OCb_LSP4_inb ob_p4 vss vss sg13_lv_nmos w=0.5u l=0.13u m=1
MOCb_LSP4_MN1 OCb_LSP4_a ob_p4 vss vss sg13_hv_nmos w=4u l=0.45u m=1
MOCb_LSP4_MN2 OCb_LSP4_b OCb_LSP4_inb vss vss sg13_hv_nmos w=4u l=0.45u m=1
MOCb_LSP4_MP1 OCb_LSP4_a OCb_LSP4_b vdda vdda sg13_hv_pmos w=0.6u l=0.5u m=1
MOCb_LSP4_MP2 OCb_LSP4_b OCb_LSP4_a vdda vdda sg13_hv_pmos w=0.6u l=0.5u m=1
MOCb_LSP4_MB1P OCb_bbp4 OCb_LSP4_b vdda vdda sg13_hv_pmos w=2u l=0.5u m=1
MOCb_LSP4_MB1N OCb_bbp4 OCb_LSP4_b vss vss sg13_hv_nmos w=1u l=0.45u m=1
MOCb_LSP4_MB2P OCb_bp4 OCb_bbp4 vdda vdda sg13_hv_pmos w=2u l=0.5u m=1
MOCb_LSP4_MB2N OCb_bp4 OCb_bbp4 vss vss sg13_hv_nmos w=1u l=0.45u m=1
MOCb_LSN4_MIP OCb_LSN4_inb ob_n4 vdd vdd sg13_lv_pmos w=1u l=0.13u m=1
MOCb_LSN4_MIN OCb_LSN4_inb ob_n4 vss vss sg13_lv_nmos w=0.5u l=0.13u m=1
MOCb_LSN4_MN1 OCb_LSN4_a ob_n4 vss vss sg13_hv_nmos w=4u l=0.45u m=1
MOCb_LSN4_MN2 OCb_LSN4_b OCb_LSN4_inb vss vss sg13_hv_nmos w=4u l=0.45u m=1
MOCb_LSN4_MP1 OCb_LSN4_a OCb_LSN4_b vdda vdda sg13_hv_pmos w=0.6u l=0.5u m=1
MOCb_LSN4_MP2 OCb_LSN4_b OCb_LSN4_a vdda vdda sg13_hv_pmos w=0.6u l=0.5u m=1
MOCb_LSN4_MB1P OCb_bbn4 OCb_LSN4_b vdda vdda sg13_hv_pmos w=2u l=0.5u m=1
MOCb_LSN4_MB1N OCb_bbn4 OCb_LSN4_b vss vss sg13_hv_nmos w=1u l=0.45u m=1
MOCb_LSN4_MB2P OCb_bn4 OCb_bbn4 vdda vdda sg13_hv_pmos w=2u l=0.5u m=1
MOCb_LSN4_MB2N OCb_bn4 OCb_bbn4 vss vss sg13_hv_nmos w=1u l=0.45u m=1
MOCb_LSP5_MIP OCb_LSP5_inb ob_p5 vdd vdd sg13_lv_pmos w=1u l=0.13u m=1
MOCb_LSP5_MIN OCb_LSP5_inb ob_p5 vss vss sg13_lv_nmos w=0.5u l=0.13u m=1
MOCb_LSP5_MN1 OCb_LSP5_a ob_p5 vss vss sg13_hv_nmos w=4u l=0.45u m=1
MOCb_LSP5_MN2 OCb_LSP5_b OCb_LSP5_inb vss vss sg13_hv_nmos w=4u l=0.45u m=1
MOCb_LSP5_MP1 OCb_LSP5_a OCb_LSP5_b vdda vdda sg13_hv_pmos w=0.6u l=0.5u m=1
MOCb_LSP5_MP2 OCb_LSP5_b OCb_LSP5_a vdda vdda sg13_hv_pmos w=0.6u l=0.5u m=1
MOCb_LSP5_MB1P OCb_bbp5 OCb_LSP5_b vdda vdda sg13_hv_pmos w=2u l=0.5u m=1
MOCb_LSP5_MB1N OCb_bbp5 OCb_LSP5_b vss vss sg13_hv_nmos w=1u l=0.45u m=1
MOCb_LSP5_MB2P OCb_bp5 OCb_bbp5 vdda vdda sg13_hv_pmos w=2u l=0.5u m=1
MOCb_LSP5_MB2N OCb_bp5 OCb_bbp5 vss vss sg13_hv_nmos w=1u l=0.45u m=1
MOCb_LSN5_MIP OCb_LSN5_inb ob_n5 vdd vdd sg13_lv_pmos w=1u l=0.13u m=1
MOCb_LSN5_MIN OCb_LSN5_inb ob_n5 vss vss sg13_lv_nmos w=0.5u l=0.13u m=1
MOCb_LSN5_MN1 OCb_LSN5_a ob_n5 vss vss sg13_hv_nmos w=4u l=0.45u m=1
MOCb_LSN5_MN2 OCb_LSN5_b OCb_LSN5_inb vss vss sg13_hv_nmos w=4u l=0.45u m=1
MOCb_LSN5_MP1 OCb_LSN5_a OCb_LSN5_b vdda vdda sg13_hv_pmos w=0.6u l=0.5u m=1
MOCb_LSN5_MP2 OCb_LSN5_b OCb_LSN5_a vdda vdda sg13_hv_pmos w=0.6u l=0.5u m=1
MOCb_LSN5_MB1P OCb_bbn5 OCb_LSN5_b vdda vdda sg13_hv_pmos w=2u l=0.5u m=1
MOCb_LSN5_MB1N OCb_bbn5 OCb_LSN5_b vss vss sg13_hv_nmos w=1u l=0.45u m=1
MOCb_LSN5_MB2P OCb_bn5 OCb_bbn5 vdda vdda sg13_hv_pmos w=2u l=0.5u m=1
MOCb_LSN5_MB2N OCb_bn5 OCb_bbn5 vss vss sg13_hv_nmos w=1u l=0.45u m=1
MOCb_LSP6_MIP OCb_LSP6_inb ob_p6 vdd vdd sg13_lv_pmos w=1u l=0.13u m=1
MOCb_LSP6_MIN OCb_LSP6_inb ob_p6 vss vss sg13_lv_nmos w=0.5u l=0.13u m=1
MOCb_LSP6_MN1 OCb_LSP6_a ob_p6 vss vss sg13_hv_nmos w=4u l=0.45u m=1
MOCb_LSP6_MN2 OCb_LSP6_b OCb_LSP6_inb vss vss sg13_hv_nmos w=4u l=0.45u m=1
MOCb_LSP6_MP1 OCb_LSP6_a OCb_LSP6_b vdda vdda sg13_hv_pmos w=0.6u l=0.5u m=1
MOCb_LSP6_MP2 OCb_LSP6_b OCb_LSP6_a vdda vdda sg13_hv_pmos w=0.6u l=0.5u m=1
MOCb_LSP6_MB1P OCb_bbp6 OCb_LSP6_b vdda vdda sg13_hv_pmos w=2u l=0.5u m=1
MOCb_LSP6_MB1N OCb_bbp6 OCb_LSP6_b vss vss sg13_hv_nmos w=1u l=0.45u m=1
MOCb_LSP6_MB2P OCb_bp6 OCb_bbp6 vdda vdda sg13_hv_pmos w=2u l=0.5u m=1
MOCb_LSP6_MB2N OCb_bp6 OCb_bbp6 vss vss sg13_hv_nmos w=1u l=0.45u m=1
MOCb_LSN6_MIP OCb_LSN6_inb ob_n6 vdd vdd sg13_lv_pmos w=1u l=0.13u m=1
MOCb_LSN6_MIN OCb_LSN6_inb ob_n6 vss vss sg13_lv_nmos w=0.5u l=0.13u m=1
MOCb_LSN6_MN1 OCb_LSN6_a ob_n6 vss vss sg13_hv_nmos w=4u l=0.45u m=1
MOCb_LSN6_MN2 OCb_LSN6_b OCb_LSN6_inb vss vss sg13_hv_nmos w=4u l=0.45u m=1
MOCb_LSN6_MP1 OCb_LSN6_a OCb_LSN6_b vdda vdda sg13_hv_pmos w=0.6u l=0.5u m=1
MOCb_LSN6_MP2 OCb_LSN6_b OCb_LSN6_a vdda vdda sg13_hv_pmos w=0.6u l=0.5u m=1
MOCb_LSN6_MB1P OCb_bbn6 OCb_LSN6_b vdda vdda sg13_hv_pmos w=2u l=0.5u m=1
MOCb_LSN6_MB1N OCb_bbn6 OCb_LSN6_b vss vss sg13_hv_nmos w=1u l=0.45u m=1
MOCb_LSN6_MB2P OCb_bn6 OCb_bbn6 vdda vdda sg13_hv_pmos w=2u l=0.5u m=1
MOCb_LSN6_MB2N OCb_bn6 OCb_bbn6 vss vss sg13_hv_nmos w=1u l=0.45u m=1
MOCb_LSP7_MIP OCb_LSP7_inb ob_p7 vdd vdd sg13_lv_pmos w=1u l=0.13u m=1
MOCb_LSP7_MIN OCb_LSP7_inb ob_p7 vss vss sg13_lv_nmos w=0.5u l=0.13u m=1
MOCb_LSP7_MN1 OCb_LSP7_a ob_p7 vss vss sg13_hv_nmos w=4u l=0.45u m=1
MOCb_LSP7_MN2 OCb_LSP7_b OCb_LSP7_inb vss vss sg13_hv_nmos w=4u l=0.45u m=1
MOCb_LSP7_MP1 OCb_LSP7_a OCb_LSP7_b vdda vdda sg13_hv_pmos w=0.6u l=0.5u m=1
MOCb_LSP7_MP2 OCb_LSP7_b OCb_LSP7_a vdda vdda sg13_hv_pmos w=0.6u l=0.5u m=1
MOCb_LSP7_MB1P OCb_bbp7 OCb_LSP7_b vdda vdda sg13_hv_pmos w=2u l=0.5u m=1
MOCb_LSP7_MB1N OCb_bbp7 OCb_LSP7_b vss vss sg13_hv_nmos w=1u l=0.45u m=1
MOCb_LSP7_MB2P OCb_bp7 OCb_bbp7 vdda vdda sg13_hv_pmos w=2u l=0.5u m=1
MOCb_LSP7_MB2N OCb_bp7 OCb_bbp7 vss vss sg13_hv_nmos w=1u l=0.45u m=1
MOCb_LSN7_MIP OCb_LSN7_inb ob_n7 vdd vdd sg13_lv_pmos w=1u l=0.13u m=1
MOCb_LSN7_MIN OCb_LSN7_inb ob_n7 vss vss sg13_lv_nmos w=0.5u l=0.13u m=1
MOCb_LSN7_MN1 OCb_LSN7_a ob_n7 vss vss sg13_hv_nmos w=4u l=0.45u m=1
MOCb_LSN7_MN2 OCb_LSN7_b OCb_LSN7_inb vss vss sg13_hv_nmos w=4u l=0.45u m=1
MOCb_LSN7_MP1 OCb_LSN7_a OCb_LSN7_b vdda vdda sg13_hv_pmos w=0.6u l=0.5u m=1
MOCb_LSN7_MP2 OCb_LSN7_b OCb_LSN7_a vdda vdda sg13_hv_pmos w=0.6u l=0.5u m=1
MOCb_LSN7_MB1P OCb_bbn7 OCb_LSN7_b vdda vdda sg13_hv_pmos w=2u l=0.5u m=1
MOCb_LSN7_MB1N OCb_bbn7 OCb_LSN7_b vss vss sg13_hv_nmos w=1u l=0.45u m=1
MOCb_LSN7_MB2P OCb_bn7 OCb_bbn7 vdda vdda sg13_hv_pmos w=2u l=0.5u m=1
MOCb_LSN7_MB2N OCb_bn7 OCb_bbn7 vss vss sg13_hv_nmos w=1u l=0.45u m=1
MOCb_MXP_S0_0_0 vss OCb_bbp0 OCb_MXP_n0_0 vss sg13_hv_nmos w=0.5u l=0.45u m=1
MOCb_MXP_S0_0_1 t1 OCb_bp0 OCb_MXP_n0_0 vss sg13_hv_nmos w=0.5u l=0.45u m=1
MOCb_MXP_S0_1_0 t2 OCb_bbp0 OCb_MXP_n0_1 vss sg13_hv_nmos w=0.5u l=0.45u m=1
MOCb_MXP_S0_1_1 t3 OCb_bp0 OCb_MXP_n0_1 vss sg13_hv_nmos w=0.5u l=0.45u m=1
MOCb_MXP_S0_2_0 t4 OCb_bbp0 OCb_MXP_n0_2 vss sg13_hv_nmos w=0.5u l=0.45u m=1
MOCb_MXP_S0_2_1 t5 OCb_bp0 OCb_MXP_n0_2 vss sg13_hv_nmos w=0.5u l=0.45u m=1
MOCb_MXP_S0_3_0 t6 OCb_bbp0 OCb_MXP_n0_3 vss sg13_hv_nmos w=0.5u l=0.45u m=1
MOCb_MXP_S0_3_1 t7 OCb_bp0 OCb_MXP_n0_3 vss sg13_hv_nmos w=0.5u l=0.45u m=1
MOCb_MXP_S0_4_0 t8 OCb_bbp0 OCb_MXP_n0_4 vss sg13_hv_nmos w=0.5u l=0.45u m=1
MOCb_MXP_S0_4_1 t9 OCb_bp0 OCb_MXP_n0_4 vss sg13_hv_nmos w=0.5u l=0.45u m=1
MOCb_MXP_S0_5_0 t10 OCb_bbp0 OCb_MXP_n0_5 vss sg13_hv_nmos w=0.5u l=0.45u m=1
MOCb_MXP_S0_5_1 t11 OCb_bp0 OCb_MXP_n0_5 vss sg13_hv_nmos w=0.5u l=0.45u m=1
MOCb_MXP_S0_6_0 t12 OCb_bbp0 OCb_MXP_n0_6 vss sg13_hv_nmos w=0.5u l=0.45u m=1
MOCb_MXP_S0_6_1 t13 OCb_bp0 OCb_MXP_n0_6 vss sg13_hv_nmos w=0.5u l=0.45u m=1
MOCb_MXP_S0_7_0 t14 OCb_bbp0 OCb_MXP_n0_7 vss sg13_hv_nmos w=0.5u l=0.45u m=1
MOCb_MXP_S0_7_1 t15 OCb_bp0 OCb_MXP_n0_7 vss sg13_hv_nmos w=0.5u l=0.45u m=1
MOCb_MXP_S0_8_0 t16 OCb_bbp0 OCb_MXP_n0_8 vss sg13_hv_nmos w=0.5u l=0.45u m=1
MOCb_MXP_S0_8_1 t17 OCb_bp0 OCb_MXP_n0_8 vss sg13_hv_nmos w=0.5u l=0.45u m=1
MOCb_MXP_S0_9_0 t18 OCb_bbp0 OCb_MXP_n0_9 vss sg13_hv_nmos w=0.5u l=0.45u m=1
MOCb_MXP_S0_9_1 t19 OCb_bp0 OCb_MXP_n0_9 vss sg13_hv_nmos w=0.5u l=0.45u m=1
MOCb_MXP_S0_10_0 t20 OCb_bbp0 OCb_MXP_n0_10 vss sg13_hv_nmos w=0.5u l=0.45u m=1
MOCb_MXP_S0_10_1 t21 OCb_bp0 OCb_MXP_n0_10 vss sg13_hv_nmos w=0.5u l=0.45u m=1
MOCb_MXP_S0_11_0 t22 OCb_bbp0 OCb_MXP_n0_11 vss sg13_hv_nmos w=0.5u l=0.45u m=1
MOCb_MXP_S0_11_1 t23 OCb_bp0 OCb_MXP_n0_11 vss sg13_hv_nmos w=0.5u l=0.45u m=1
MOCb_MXP_S0_12_0 t24 OCb_bbp0 OCb_MXP_n0_12 vss sg13_hv_nmos w=0.5u l=0.45u m=1
MOCb_MXP_S0_12_1 t25 OCb_bp0 OCb_MXP_n0_12 vss sg13_hv_nmos w=0.5u l=0.45u m=1
MOCb_MXP_S0_13_0 t26 OCb_bbp0 OCb_MXP_n0_13 vss sg13_hv_nmos w=0.5u l=0.45u m=1
MOCb_MXP_S0_13_1 t27 OCb_bp0 OCb_MXP_n0_13 vss sg13_hv_nmos w=0.5u l=0.45u m=1
MOCb_MXP_S0_14_0 t28 OCb_bbp0 OCb_MXP_n0_14 vss sg13_hv_nmos w=0.5u l=0.45u m=1
MOCb_MXP_S0_14_1 t29 OCb_bp0 OCb_MXP_n0_14 vss sg13_hv_nmos w=0.5u l=0.45u m=1
MOCb_MXP_S0_15_0 t30 OCb_bbp0 OCb_MXP_n0_15 vss sg13_hv_nmos w=0.5u l=0.45u m=1
MOCb_MXP_S0_15_1 t31 OCb_bp0 OCb_MXP_n0_15 vss sg13_hv_nmos w=0.5u l=0.45u m=1
MOCb_MXP_S0_16_0 t32 OCb_bbp0 OCb_MXP_n0_16 vss sg13_hv_nmos w=0.5u l=0.45u m=1
MOCb_MXP_S0_16_1 t33 OCb_bp0 OCb_MXP_n0_16 vss sg13_hv_nmos w=0.5u l=0.45u m=1
MOCb_MXP_S0_17_0 t34 OCb_bbp0 OCb_MXP_n0_17 vss sg13_hv_nmos w=0.5u l=0.45u m=1
MOCb_MXP_S0_17_1 t35 OCb_bp0 OCb_MXP_n0_17 vss sg13_hv_nmos w=0.5u l=0.45u m=1
MOCb_MXP_S0_18_0 t36 OCb_bbp0 OCb_MXP_n0_18 vss sg13_hv_nmos w=0.5u l=0.45u m=1
MOCb_MXP_S0_18_1 t37 OCb_bp0 OCb_MXP_n0_18 vss sg13_hv_nmos w=0.5u l=0.45u m=1
MOCb_MXP_S0_19_0 t38 OCb_bbp0 OCb_MXP_n0_19 vss sg13_hv_nmos w=0.5u l=0.45u m=1
MOCb_MXP_S0_19_1 t39 OCb_bp0 OCb_MXP_n0_19 vss sg13_hv_nmos w=0.5u l=0.45u m=1
MOCb_MXP_S0_20_0 t40 OCb_bbp0 OCb_MXP_n0_20 vss sg13_hv_nmos w=0.5u l=0.45u m=1
MOCb_MXP_S0_20_1 t41 OCb_bp0 OCb_MXP_n0_20 vss sg13_hv_nmos w=0.5u l=0.45u m=1
MOCb_MXP_S0_21_0 t42 OCb_bbp0 OCb_MXP_n0_21 vss sg13_hv_nmos w=0.5u l=0.45u m=1
MOCb_MXP_S0_21_1 t43 OCb_bp0 OCb_MXP_n0_21 vss sg13_hv_nmos w=0.5u l=0.45u m=1
MOCb_MXP_S0_22_0 t44 OCb_bbp0 OCb_MXP_n0_22 vss sg13_hv_nmos w=0.5u l=0.45u m=1
MOCb_MXP_S0_22_1 t45 OCb_bp0 OCb_MXP_n0_22 vss sg13_hv_nmos w=0.5u l=0.45u m=1
MOCb_MXP_S0_23_0 t46 OCb_bbp0 OCb_MXP_n0_23 vss sg13_hv_nmos w=0.5u l=0.45u m=1
MOCb_MXP_S0_23_1 t47 OCb_bp0 OCb_MXP_n0_23 vss sg13_hv_nmos w=0.5u l=0.45u m=1
MOCb_MXP_S0_24_0 t48 OCb_bbp0 OCb_MXP_n0_24 vss sg13_hv_nmos w=0.5u l=0.45u m=1
MOCb_MXP_S0_24_1 t49 OCb_bp0 OCb_MXP_n0_24 vss sg13_hv_nmos w=0.5u l=0.45u m=1
MOCb_MXP_S0_25_0 t50 OCb_bbp0 OCb_MXP_n0_25 vss sg13_hv_nmos w=0.5u l=0.45u m=1
MOCb_MXP_S0_25_1 t51 OCb_bp0 OCb_MXP_n0_25 vss sg13_hv_nmos w=0.5u l=0.45u m=1
MOCb_MXP_S0_26_0 t52 OCb_bbp0 OCb_MXP_n0_26 vss sg13_hv_nmos w=0.5u l=0.45u m=1
MOCb_MXP_S0_26_1 t53 OCb_bp0 OCb_MXP_n0_26 vss sg13_hv_nmos w=0.5u l=0.45u m=1
MOCb_MXP_S0_27_0 t54 OCb_bbp0 OCb_MXP_n0_27 vss sg13_hv_nmos w=0.5u l=0.45u m=1
MOCb_MXP_S0_27_1 t55 OCb_bp0 OCb_MXP_n0_27 vss sg13_hv_nmos w=0.5u l=0.45u m=1
MOCb_MXP_S0_28_0 t56 OCb_bbp0 OCb_MXP_n0_28 vss sg13_hv_nmos w=0.5u l=0.45u m=1
MOCb_MXP_S0_28_1 t57 OCb_bp0 OCb_MXP_n0_28 vss sg13_hv_nmos w=0.5u l=0.45u m=1
MOCb_MXP_S0_29_0 t58 OCb_bbp0 OCb_MXP_n0_29 vss sg13_hv_nmos w=0.5u l=0.45u m=1
MOCb_MXP_S0_29_1 t59 OCb_bp0 OCb_MXP_n0_29 vss sg13_hv_nmos w=0.5u l=0.45u m=1
MOCb_MXP_S0_30_0 t60 OCb_bbp0 OCb_MXP_n0_30 vss sg13_hv_nmos w=0.5u l=0.45u m=1
MOCb_MXP_S0_30_1 t61 OCb_bp0 OCb_MXP_n0_30 vss sg13_hv_nmos w=0.5u l=0.45u m=1
MOCb_MXP_S0_31_0 t62 OCb_bbp0 OCb_MXP_n0_31 vss sg13_hv_nmos w=0.5u l=0.45u m=1
MOCb_MXP_S0_31_1 t63 OCb_bp0 OCb_MXP_n0_31 vss sg13_hv_nmos w=0.5u l=0.45u m=1
MOCb_MXP_S0_32_0 t64 OCb_bbp0 OCb_MXP_n0_32 vss sg13_hv_nmos w=0.5u l=0.45u m=1
MOCb_MXP_S0_32_1 t65 OCb_bp0 OCb_MXP_n0_32 vss sg13_hv_nmos w=0.5u l=0.45u m=1
MOCb_MXP_S0_33_0 t66 OCb_bbp0 OCb_MXP_n0_33 vss sg13_hv_nmos w=0.5u l=0.45u m=1
MOCb_MXP_S0_33_1 t67 OCb_bp0 OCb_MXP_n0_33 vss sg13_hv_nmos w=0.5u l=0.45u m=1
MOCb_MXP_S0_34_0 t68 OCb_bbp0 OCb_MXP_n0_34 vss sg13_hv_nmos w=0.5u l=0.45u m=1
MOCb_MXP_S0_34_1 t69 OCb_bp0 OCb_MXP_n0_34 vss sg13_hv_nmos w=0.5u l=0.45u m=1
MOCb_MXP_S0_35_0 t70 OCb_bbp0 OCb_MXP_n0_35 vss sg13_hv_nmos w=0.5u l=0.45u m=1
MOCb_MXP_S0_35_1 t71 OCb_bp0 OCb_MXP_n0_35 vss sg13_hv_nmos w=0.5u l=0.45u m=1
MOCb_MXP_S0_36_0 t72 OCb_bbp0 OCb_MXP_n0_36 vss sg13_hv_nmos w=0.5u l=0.45u m=1
MOCb_MXP_S0_36_1 t73 OCb_bp0 OCb_MXP_n0_36 vss sg13_hv_nmos w=0.5u l=0.45u m=1
MOCb_MXP_S0_37_0 t74 OCb_bbp0 OCb_MXP_n0_37 vss sg13_hv_nmos w=0.5u l=0.45u m=1
MOCb_MXP_S0_37_1 t75 OCb_bp0 OCb_MXP_n0_37 vss sg13_hv_nmos w=0.5u l=0.45u m=1
MOCb_MXP_S0_38_0 t76 OCb_bbp0 OCb_MXP_n0_38 vss sg13_hv_nmos w=0.5u l=0.45u m=1
MOCb_MXP_S0_38_1 t77 OCb_bp0 OCb_MXP_n0_38 vss sg13_hv_nmos w=0.5u l=0.45u m=1
MOCb_MXP_S0_39_0 t78 OCb_bbp0 OCb_MXP_n0_39 vss sg13_hv_nmos w=0.5u l=0.45u m=1
MOCb_MXP_S0_39_1 t79 OCb_bp0 OCb_MXP_n0_39 vss sg13_hv_nmos w=0.5u l=0.45u m=1
MOCb_MXP_S0_40_0 t80 OCb_bbp0 OCb_MXP_n0_40 vss sg13_hv_nmos w=0.5u l=0.45u m=1
MOCb_MXP_S0_40_1 t81 OCb_bp0 OCb_MXP_n0_40 vss sg13_hv_nmos w=0.5u l=0.45u m=1
MOCb_MXP_S0_41_0 t82 OCb_bbp0 OCb_MXP_n0_41 vss sg13_hv_nmos w=0.5u l=0.45u m=1
MOCb_MXP_S0_41_1 t83 OCb_bp0 OCb_MXP_n0_41 vss sg13_hv_nmos w=0.5u l=0.45u m=1
MOCb_MXP_S0_42_0 t84 OCb_bbp0 OCb_MXP_n0_42 vss sg13_hv_nmos w=0.5u l=0.45u m=1
MOCb_MXP_S0_42_1 t85 OCb_bp0 OCb_MXP_n0_42 vss sg13_hv_nmos w=0.5u l=0.45u m=1
MOCb_MXP_S0_43_0 t86 OCb_bbp0 OCb_MXP_n0_43 vss sg13_hv_nmos w=0.5u l=0.45u m=1
MOCb_MXP_S0_43_1 t87 OCb_bp0 OCb_MXP_n0_43 vss sg13_hv_nmos w=0.5u l=0.45u m=1
MOCb_MXP_S0_44_0 t88 OCb_bbp0 OCb_MXP_n0_44 vss sg13_hv_nmos w=0.5u l=0.45u m=1
MOCb_MXP_S0_44_1 t89 OCb_bp0 OCb_MXP_n0_44 vss sg13_hv_nmos w=0.5u l=0.45u m=1
MOCb_MXP_S0_45_0 t90 OCb_bbp0 OCb_MXP_n0_45 vss sg13_hv_nmos w=0.5u l=0.45u m=1
MOCb_MXP_S0_45_1 t91 OCb_bp0 OCb_MXP_n0_45 vss sg13_hv_nmos w=0.5u l=0.45u m=1
MOCb_MXP_S0_46_0 t92 OCb_bbp0 OCb_MXP_n0_46 vss sg13_hv_nmos w=0.5u l=0.45u m=1
MOCb_MXP_S0_46_1 t93 OCb_bp0 OCb_MXP_n0_46 vss sg13_hv_nmos w=0.5u l=0.45u m=1
MOCb_MXP_S0_47_0 t94 OCb_bbp0 OCb_MXP_n0_47 vss sg13_hv_nmos w=0.5u l=0.45u m=1
MOCb_MXP_S0_47_1 t95 OCb_bp0 OCb_MXP_n0_47 vss sg13_hv_nmos w=0.5u l=0.45u m=1
MOCb_MXP_S0_48_0 t96 OCb_bbp0 OCb_MXP_n0_48 vss sg13_hv_nmos w=0.5u l=0.45u m=1
MOCb_MXP_S0_48_1 t97 OCb_bp0 OCb_MXP_n0_48 vss sg13_hv_nmos w=0.5u l=0.45u m=1
MOCb_MXP_S0_49_0 t98 OCb_bbp0 OCb_MXP_n0_49 vss sg13_hv_nmos w=0.5u l=0.45u m=1
MOCb_MXP_S0_49_1 t99 OCb_bp0 OCb_MXP_n0_49 vss sg13_hv_nmos w=0.5u l=0.45u m=1
MOCb_MXP_S0_50_0 t100 OCb_bbp0 OCb_MXP_n0_50 vss sg13_hv_nmos w=0.5u l=0.45u m=1
MOCb_MXP_S0_50_1 t101 OCb_bp0 OCb_MXP_n0_50 vss sg13_hv_nmos w=0.5u l=0.45u m=1
MOCb_MXP_S0_51_0 t102 OCb_bbp0 OCb_MXP_n0_51 vss sg13_hv_nmos w=0.5u l=0.45u m=1
MOCb_MXP_S0_51_1 t103 OCb_bp0 OCb_MXP_n0_51 vss sg13_hv_nmos w=0.5u l=0.45u m=1
MOCb_MXP_S0_52_0 t104 OCb_bbp0 OCb_MXP_n0_52 vss sg13_hv_nmos w=0.5u l=0.45u m=1
MOCb_MXP_S0_52_1 t105 OCb_bp0 OCb_MXP_n0_52 vss sg13_hv_nmos w=0.5u l=0.45u m=1
MOCb_MXP_S0_53_0 t106 OCb_bbp0 OCb_MXP_n0_53 vss sg13_hv_nmos w=0.5u l=0.45u m=1
MOCb_MXP_S0_53_1 t107 OCb_bp0 OCb_MXP_n0_53 vss sg13_hv_nmos w=0.5u l=0.45u m=1
MOCb_MXP_S0_54_0 t108 OCb_bbp0 OCb_MXP_n0_54 vss sg13_hv_nmos w=0.5u l=0.45u m=1
MOCb_MXP_S0_54_1 t109 OCb_bp0 OCb_MXP_n0_54 vss sg13_hv_nmos w=0.5u l=0.45u m=1
MOCb_MXP_S0_55_0 t110 OCb_bbp0 OCb_MXP_n0_55 vss sg13_hv_nmos w=0.5u l=0.45u m=1
MOCb_MXP_S0_55_1 t111 OCb_bp0 OCb_MXP_n0_55 vss sg13_hv_nmos w=0.5u l=0.45u m=1
MOCb_MXP_S0_56_0 t112 OCb_bbp0 OCb_MXP_n0_56 vss sg13_hv_nmos w=0.5u l=0.45u m=1
MOCb_MXP_S0_56_1 t113 OCb_bp0 OCb_MXP_n0_56 vss sg13_hv_nmos w=0.5u l=0.45u m=1
MOCb_MXP_S0_57_0 t114 OCb_bbp0 OCb_MXP_n0_57 vss sg13_hv_nmos w=0.5u l=0.45u m=1
MOCb_MXP_S0_57_1 t115 OCb_bp0 OCb_MXP_n0_57 vss sg13_hv_nmos w=0.5u l=0.45u m=1
MOCb_MXP_S0_58_0 t116 OCb_bbp0 OCb_MXP_n0_58 vss sg13_hv_nmos w=0.5u l=0.45u m=1
MOCb_MXP_S0_58_1 t117 OCb_bp0 OCb_MXP_n0_58 vss sg13_hv_nmos w=0.5u l=0.45u m=1
MOCb_MXP_S0_59_0 t118 OCb_bbp0 OCb_MXP_n0_59 vss sg13_hv_nmos w=0.5u l=0.45u m=1
MOCb_MXP_S0_59_1 t119 OCb_bp0 OCb_MXP_n0_59 vss sg13_hv_nmos w=0.5u l=0.45u m=1
MOCb_MXP_S0_60_0 t120 OCb_bbp0 OCb_MXP_n0_60 vss sg13_hv_nmos w=0.5u l=0.45u m=1
MOCb_MXP_S0_60_1 t121 OCb_bp0 OCb_MXP_n0_60 vss sg13_hv_nmos w=0.5u l=0.45u m=1
MOCb_MXP_S0_61_0 t122 OCb_bbp0 OCb_MXP_n0_61 vss sg13_hv_nmos w=0.5u l=0.45u m=1
MOCb_MXP_S0_61_1 t123 OCb_bp0 OCb_MXP_n0_61 vss sg13_hv_nmos w=0.5u l=0.45u m=1
MOCb_MXP_S0_62_0 t124 OCb_bbp0 OCb_MXP_n0_62 vss sg13_hv_nmos w=0.5u l=0.45u m=1
MOCb_MXP_S0_62_1 t125 OCb_bp0 OCb_MXP_n0_62 vss sg13_hv_nmos w=0.5u l=0.45u m=1
MOCb_MXP_S0_63_0 t126 OCb_bbp0 OCb_MXP_n0_63 vss sg13_hv_nmos w=0.5u l=0.45u m=1
MOCb_MXP_S0_63_1 t127 OCb_bp0 OCb_MXP_n0_63 vss sg13_hv_nmos w=0.5u l=0.45u m=1
MOCb_MXP_S0_64_0 t128 OCb_bbp0 OCb_MXP_n0_64 vss sg13_hv_nmos w=0.5u l=0.45u m=1
MOCb_MXP_S0_64_1 t129 OCb_bp0 OCb_MXP_n0_64 vss sg13_hv_nmos w=0.5u l=0.45u m=1
MOCb_MXP_S0_65_0 t130 OCb_bbp0 OCb_MXP_n0_65 vss sg13_hv_nmos w=0.5u l=0.45u m=1
MOCb_MXP_S0_65_1 t131 OCb_bp0 OCb_MXP_n0_65 vss sg13_hv_nmos w=0.5u l=0.45u m=1
MOCb_MXP_S0_66_0 t132 OCb_bbp0 OCb_MXP_n0_66 vss sg13_hv_nmos w=0.5u l=0.45u m=1
MOCb_MXP_S0_66_1 t133 OCb_bp0 OCb_MXP_n0_66 vss sg13_hv_nmos w=0.5u l=0.45u m=1
MOCb_MXP_S0_67_0 t134 OCb_bbp0 OCb_MXP_n0_67 vss sg13_hv_nmos w=0.5u l=0.45u m=1
MOCb_MXP_S0_67_1 t135 OCb_bp0 OCb_MXP_n0_67 vss sg13_hv_nmos w=0.5u l=0.45u m=1
MOCb_MXP_S0_68_0 t136 OCb_bbp0 OCb_MXP_n0_68 vss sg13_hv_nmos w=0.5u l=0.45u m=1
MOCb_MXP_S0_68_1 t137 OCb_bp0 OCb_MXP_n0_68 vss sg13_hv_nmos w=0.5u l=0.45u m=1
MOCb_MXP_S0_69_0 t138 OCb_bbp0 OCb_MXP_n0_69 vss sg13_hv_nmos w=0.5u l=0.45u m=1
MOCb_MXP_S0_69_1 t139 OCb_bp0 OCb_MXP_n0_69 vss sg13_hv_nmos w=0.5u l=0.45u m=1
MOCb_MXP_S0_70_0 t140 OCb_bbp0 OCb_MXP_n0_70 vss sg13_hv_nmos w=0.5u l=0.45u m=1
MOCb_MXP_S0_70_1 t141 OCb_bp0 OCb_MXP_n0_70 vss sg13_hv_nmos w=0.5u l=0.45u m=1
MOCb_MXP_S0_71_0 t142 OCb_bbp0 OCb_MXP_n0_71 vss sg13_hv_nmos w=0.5u l=0.45u m=1
MOCb_MXP_S0_71_1 t143 OCb_bp0 OCb_MXP_n0_71 vss sg13_hv_nmos w=0.5u l=0.45u m=1
MOCb_MXP_S0_72_0 t144 OCb_bbp0 OCb_MXP_n0_72 vss sg13_hv_nmos w=0.5u l=0.45u m=1
MOCb_MXP_S0_72_1 t145 OCb_bp0 OCb_MXP_n0_72 vss sg13_hv_nmos w=0.5u l=0.45u m=1
MOCb_MXP_S0_73_0 t146 OCb_bbp0 OCb_MXP_n0_73 vss sg13_hv_nmos w=0.5u l=0.45u m=1
MOCb_MXP_S0_73_1 t147 OCb_bp0 OCb_MXP_n0_73 vss sg13_hv_nmos w=0.5u l=0.45u m=1
MOCb_MXP_S0_74_0 t148 OCb_bbp0 OCb_MXP_n0_74 vss sg13_hv_nmos w=0.5u l=0.45u m=1
MOCb_MXP_S0_74_1 t149 OCb_bp0 OCb_MXP_n0_74 vss sg13_hv_nmos w=0.5u l=0.45u m=1
MOCb_MXP_S0_75_0 t150 OCb_bbp0 OCb_MXP_n0_75 vss sg13_hv_nmos w=0.5u l=0.45u m=1
MOCb_MXP_S0_75_1 t151 OCb_bp0 OCb_MXP_n0_75 vss sg13_hv_nmos w=0.5u l=0.45u m=1
MOCb_MXP_S0_76_0 t152 OCb_bbp0 OCb_MXP_n0_76 vss sg13_hv_nmos w=0.5u l=0.45u m=1
MOCb_MXP_S0_76_1 t153 OCb_bp0 OCb_MXP_n0_76 vss sg13_hv_nmos w=0.5u l=0.45u m=1
MOCb_MXP_S0_77_0 t154 OCb_bbp0 OCb_MXP_n0_77 vss sg13_hv_nmos w=0.5u l=0.45u m=1
MOCb_MXP_S0_77_1 t155 OCb_bp0 OCb_MXP_n0_77 vss sg13_hv_nmos w=0.5u l=0.45u m=1
MOCb_MXP_S0_78_0 t156 OCb_bbp0 OCb_MXP_n0_78 vss sg13_hv_nmos w=0.5u l=0.45u m=1
MOCb_MXP_S0_78_1 t157 OCb_bp0 OCb_MXP_n0_78 vss sg13_hv_nmos w=0.5u l=0.45u m=1
MOCb_MXP_S0_79_0 t158 OCb_bbp0 OCb_MXP_n0_79 vss sg13_hv_nmos w=0.5u l=0.45u m=1
MOCb_MXP_S0_79_1 t159 OCb_bp0 OCb_MXP_n0_79 vss sg13_hv_nmos w=0.5u l=0.45u m=1
MOCb_MXP_S0_80_0 t160 OCb_bbp0 OCb_MXP_n0_80 vss sg13_hv_nmos w=0.5u l=0.45u m=1
MOCb_MXP_S0_80_1 t161 OCb_bp0 OCb_MXP_n0_80 vss sg13_hv_nmos w=0.5u l=0.45u m=1
MOCb_MXP_S0_81_0 t162 OCb_bbp0 OCb_MXP_n0_81 vss sg13_hv_nmos w=0.5u l=0.45u m=1
MOCb_MXP_S0_81_1 t163 OCb_bp0 OCb_MXP_n0_81 vss sg13_hv_nmos w=0.5u l=0.45u m=1
MOCb_MXP_S0_82_0 t164 OCb_bbp0 OCb_MXP_n0_82 vss sg13_hv_nmos w=0.5u l=0.45u m=1
MOCb_MXP_S0_82_1 t165 OCb_bp0 OCb_MXP_n0_82 vss sg13_hv_nmos w=0.5u l=0.45u m=1
MOCb_MXP_S0_83_0 t166 OCb_bbp0 OCb_MXP_n0_83 vss sg13_hv_nmos w=0.5u l=0.45u m=1
MOCb_MXP_S0_83_1 t167 OCb_bp0 OCb_MXP_n0_83 vss sg13_hv_nmos w=0.5u l=0.45u m=1
MOCb_MXP_S0_84_0 t168 OCb_bbp0 OCb_MXP_n0_84 vss sg13_hv_nmos w=0.5u l=0.45u m=1
MOCb_MXP_S0_84_1 t169 OCb_bp0 OCb_MXP_n0_84 vss sg13_hv_nmos w=0.5u l=0.45u m=1
MOCb_MXP_S0_85_0 t170 OCb_bbp0 OCb_MXP_n0_85 vss sg13_hv_nmos w=0.5u l=0.45u m=1
MOCb_MXP_S0_85_1 t171 OCb_bp0 OCb_MXP_n0_85 vss sg13_hv_nmos w=0.5u l=0.45u m=1
MOCb_MXP_S0_86_0 t172 OCb_bbp0 OCb_MXP_n0_86 vss sg13_hv_nmos w=0.5u l=0.45u m=1
MOCb_MXP_S0_86_1 t173 OCb_bp0 OCb_MXP_n0_86 vss sg13_hv_nmos w=0.5u l=0.45u m=1
MOCb_MXP_S0_87_0 t174 OCb_bbp0 OCb_MXP_n0_87 vss sg13_hv_nmos w=0.5u l=0.45u m=1
MOCb_MXP_S0_87_1 t175 OCb_bp0 OCb_MXP_n0_87 vss sg13_hv_nmos w=0.5u l=0.45u m=1
MOCb_MXP_S0_88_0 t176 OCb_bbp0 OCb_MXP_n0_88 vss sg13_hv_nmos w=0.5u l=0.45u m=1
MOCb_MXP_S0_88_1 t177 OCb_bp0 OCb_MXP_n0_88 vss sg13_hv_nmos w=0.5u l=0.45u m=1
MOCb_MXP_S0_89_0 t178 OCb_bbp0 OCb_MXP_n0_89 vss sg13_hv_nmos w=0.5u l=0.45u m=1
MOCb_MXP_S0_89_1 t179 OCb_bp0 OCb_MXP_n0_89 vss sg13_hv_nmos w=0.5u l=0.45u m=1
MOCb_MXP_S0_90_0 t180 OCb_bbp0 OCb_MXP_n0_90 vss sg13_hv_nmos w=0.5u l=0.45u m=1
MOCb_MXP_S0_90_1 t181 OCb_bp0 OCb_MXP_n0_90 vss sg13_hv_nmos w=0.5u l=0.45u m=1
MOCb_MXP_S0_91_0 t182 OCb_bbp0 OCb_MXP_n0_91 vss sg13_hv_nmos w=0.5u l=0.45u m=1
MOCb_MXP_S0_91_1 t183 OCb_bp0 OCb_MXP_n0_91 vss sg13_hv_nmos w=0.5u l=0.45u m=1
MOCb_MXP_S0_92_0 t184 OCb_bbp0 OCb_MXP_n0_92 vss sg13_hv_nmos w=0.5u l=0.45u m=1
MOCb_MXP_S0_92_1 t185 OCb_bp0 OCb_MXP_n0_92 vss sg13_hv_nmos w=0.5u l=0.45u m=1
MOCb_MXP_S0_93_0 t186 OCb_bbp0 OCb_MXP_n0_93 vss sg13_hv_nmos w=0.5u l=0.45u m=1
MOCb_MXP_S0_93_1 t187 OCb_bp0 OCb_MXP_n0_93 vss sg13_hv_nmos w=0.5u l=0.45u m=1
MOCb_MXP_S0_94_0 t188 OCb_bbp0 OCb_MXP_n0_94 vss sg13_hv_nmos w=0.5u l=0.45u m=1
MOCb_MXP_S0_94_1 t189 OCb_bp0 OCb_MXP_n0_94 vss sg13_hv_nmos w=0.5u l=0.45u m=1
MOCb_MXP_S0_95_0 t190 OCb_bbp0 OCb_MXP_n0_95 vss sg13_hv_nmos w=0.5u l=0.45u m=1
MOCb_MXP_S0_95_1 t191 OCb_bp0 OCb_MXP_n0_95 vss sg13_hv_nmos w=0.5u l=0.45u m=1
MOCb_MXP_S0_96_0 t192 OCb_bbp0 OCb_MXP_n0_96 vss sg13_hv_nmos w=0.5u l=0.45u m=1
MOCb_MXP_S0_96_1 t193 OCb_bp0 OCb_MXP_n0_96 vss sg13_hv_nmos w=0.5u l=0.45u m=1
MOCb_MXP_S0_97_0 t194 OCb_bbp0 OCb_MXP_n0_97 vss sg13_hv_nmos w=0.5u l=0.45u m=1
MOCb_MXP_S0_97_1 t195 OCb_bp0 OCb_MXP_n0_97 vss sg13_hv_nmos w=0.5u l=0.45u m=1
MOCb_MXP_S0_98_0 t196 OCb_bbp0 OCb_MXP_n0_98 vss sg13_hv_nmos w=0.5u l=0.45u m=1
MOCb_MXP_S0_98_1 t197 OCb_bp0 OCb_MXP_n0_98 vss sg13_hv_nmos w=0.5u l=0.45u m=1
MOCb_MXP_S0_99_0 t198 OCb_bbp0 OCb_MXP_n0_99 vss sg13_hv_nmos w=0.5u l=0.45u m=1
MOCb_MXP_S0_99_1 t199 OCb_bp0 OCb_MXP_n0_99 vss sg13_hv_nmos w=0.5u l=0.45u m=1
MOCb_MXP_S0_100_0 t200 OCb_bbp0 OCb_MXP_n0_100 vss sg13_hv_nmos w=0.5u l=0.45u m=1
MOCb_MXP_S0_100_1 t201 OCb_bp0 OCb_MXP_n0_100 vss sg13_hv_nmos w=0.5u l=0.45u m=1
MOCb_MXP_S0_101_0 t202 OCb_bbp0 OCb_MXP_n0_101 vss sg13_hv_nmos w=0.5u l=0.45u m=1
MOCb_MXP_S0_101_1 t203 OCb_bp0 OCb_MXP_n0_101 vss sg13_hv_nmos w=0.5u l=0.45u m=1
MOCb_MXP_S0_102_0 t204 OCb_bbp0 OCb_MXP_n0_102 vss sg13_hv_nmos w=0.5u l=0.45u m=1
MOCb_MXP_S0_102_1 t205 OCb_bp0 OCb_MXP_n0_102 vss sg13_hv_nmos w=0.5u l=0.45u m=1
MOCb_MXP_S0_103_0 t206 OCb_bbp0 OCb_MXP_n0_103 vss sg13_hv_nmos w=0.5u l=0.45u m=1
MOCb_MXP_S0_103_1 t207 OCb_bp0 OCb_MXP_n0_103 vss sg13_hv_nmos w=0.5u l=0.45u m=1
MOCb_MXP_S0_104_0 t208 OCb_bbp0 OCb_MXP_n0_104 vss sg13_hv_nmos w=0.5u l=0.45u m=1
MOCb_MXP_S0_104_1 t209 OCb_bp0 OCb_MXP_n0_104 vss sg13_hv_nmos w=0.5u l=0.45u m=1
MOCb_MXP_S0_105_0 t210 OCb_bbp0 OCb_MXP_n0_105 vss sg13_hv_nmos w=0.5u l=0.45u m=1
MOCb_MXP_S0_105_1 t211 OCb_bp0 OCb_MXP_n0_105 vss sg13_hv_nmos w=0.5u l=0.45u m=1
MOCb_MXP_S0_106_0 t212 OCb_bbp0 OCb_MXP_n0_106 vss sg13_hv_nmos w=0.5u l=0.45u m=1
MOCb_MXP_S0_106_1 t213 OCb_bp0 OCb_MXP_n0_106 vss sg13_hv_nmos w=0.5u l=0.45u m=1
MOCb_MXP_S0_107_0 t214 OCb_bbp0 OCb_MXP_n0_107 vss sg13_hv_nmos w=0.5u l=0.45u m=1
MOCb_MXP_S0_107_1 t215 OCb_bp0 OCb_MXP_n0_107 vss sg13_hv_nmos w=0.5u l=0.45u m=1
MOCb_MXP_S0_108_0 t216 OCb_bbp0 OCb_MXP_n0_108 vss sg13_hv_nmos w=0.5u l=0.45u m=1
MOCb_MXP_S0_108_1 t217 OCb_bp0 OCb_MXP_n0_108 vss sg13_hv_nmos w=0.5u l=0.45u m=1
MOCb_MXP_S0_109_0 t218 OCb_bbp0 OCb_MXP_n0_109 vss sg13_hv_nmos w=0.5u l=0.45u m=1
MOCb_MXP_S0_109_1 t219 OCb_bp0 OCb_MXP_n0_109 vss sg13_hv_nmos w=0.5u l=0.45u m=1
MOCb_MXP_S0_110_0 t220 OCb_bbp0 OCb_MXP_n0_110 vss sg13_hv_nmos w=0.5u l=0.45u m=1
MOCb_MXP_S0_110_1 t221 OCb_bp0 OCb_MXP_n0_110 vss sg13_hv_nmos w=0.5u l=0.45u m=1
MOCb_MXP_S0_111_0 t222 OCb_bbp0 OCb_MXP_n0_111 vss sg13_hv_nmos w=0.5u l=0.45u m=1
MOCb_MXP_S0_111_1 t223 OCb_bp0 OCb_MXP_n0_111 vss sg13_hv_nmos w=0.5u l=0.45u m=1
MOCb_MXP_S0_112_0 t224 OCb_bbp0 OCb_MXP_n0_112 vss sg13_hv_nmos w=0.5u l=0.45u m=1
MOCb_MXP_S0_112_1 t225 OCb_bp0 OCb_MXP_n0_112 vss sg13_hv_nmos w=0.5u l=0.45u m=1
MOCb_MXP_S0_113_0 t226 OCb_bbp0 OCb_MXP_n0_113 vss sg13_hv_nmos w=0.5u l=0.45u m=1
MOCb_MXP_S0_113_1 t227 OCb_bp0 OCb_MXP_n0_113 vss sg13_hv_nmos w=0.5u l=0.45u m=1
MOCb_MXP_S0_114_0 t228 OCb_bbp0 OCb_MXP_n0_114 vss sg13_hv_nmos w=0.5u l=0.45u m=1
MOCb_MXP_S0_114_1 t229 OCb_bp0 OCb_MXP_n0_114 vss sg13_hv_nmos w=0.5u l=0.45u m=1
MOCb_MXP_S0_115_0 t230 OCb_bbp0 OCb_MXP_n0_115 vss sg13_hv_nmos w=0.5u l=0.45u m=1
MOCb_MXP_S0_115_1 t231 OCb_bp0 OCb_MXP_n0_115 vss sg13_hv_nmos w=0.5u l=0.45u m=1
MOCb_MXP_S0_116_0 t232 OCb_bbp0 OCb_MXP_n0_116 vss sg13_hv_nmos w=0.5u l=0.45u m=1
MOCb_MXP_S0_116_1 t233 OCb_bp0 OCb_MXP_n0_116 vss sg13_hv_nmos w=0.5u l=0.45u m=1
MOCb_MXP_S0_117_0 t234 OCb_bbp0 OCb_MXP_n0_117 vss sg13_hv_nmos w=0.5u l=0.45u m=1
MOCb_MXP_S0_117_1 t235 OCb_bp0 OCb_MXP_n0_117 vss sg13_hv_nmos w=0.5u l=0.45u m=1
MOCb_MXP_S0_118_0 t236 OCb_bbp0 OCb_MXP_n0_118 vss sg13_hv_nmos w=0.5u l=0.45u m=1
MOCb_MXP_S0_118_1 t237 OCb_bp0 OCb_MXP_n0_118 vss sg13_hv_nmos w=0.5u l=0.45u m=1
MOCb_MXP_S0_119_0 t238 OCb_bbp0 OCb_MXP_n0_119 vss sg13_hv_nmos w=0.5u l=0.45u m=1
MOCb_MXP_S0_119_1 t239 OCb_bp0 OCb_MXP_n0_119 vss sg13_hv_nmos w=0.5u l=0.45u m=1
MOCb_MXP_S0_120_0 t240 OCb_bbp0 OCb_MXP_n0_120 vss sg13_hv_nmos w=0.5u l=0.45u m=1
MOCb_MXP_S0_120_1 t241 OCb_bp0 OCb_MXP_n0_120 vss sg13_hv_nmos w=0.5u l=0.45u m=1
MOCb_MXP_S0_121_0 t242 OCb_bbp0 OCb_MXP_n0_121 vss sg13_hv_nmos w=0.5u l=0.45u m=1
MOCb_MXP_S0_121_1 t243 OCb_bp0 OCb_MXP_n0_121 vss sg13_hv_nmos w=0.5u l=0.45u m=1
MOCb_MXP_S0_122_0 t244 OCb_bbp0 OCb_MXP_n0_122 vss sg13_hv_nmos w=0.5u l=0.45u m=1
MOCb_MXP_S0_122_1 t245 OCb_bp0 OCb_MXP_n0_122 vss sg13_hv_nmos w=0.5u l=0.45u m=1
MOCb_MXP_S0_123_0 t246 OCb_bbp0 OCb_MXP_n0_123 vss sg13_hv_nmos w=0.5u l=0.45u m=1
MOCb_MXP_S0_123_1 t247 OCb_bp0 OCb_MXP_n0_123 vss sg13_hv_nmos w=0.5u l=0.45u m=1
MOCb_MXP_S0_124_0 t248 OCb_bbp0 OCb_MXP_n0_124 vss sg13_hv_nmos w=0.5u l=0.45u m=1
MOCb_MXP_S0_124_1 t249 OCb_bp0 OCb_MXP_n0_124 vss sg13_hv_nmos w=0.5u l=0.45u m=1
MOCb_MXP_S0_125_0 t250 OCb_bbp0 OCb_MXP_n0_125 vss sg13_hv_nmos w=0.5u l=0.45u m=1
MOCb_MXP_S0_125_1 t251 OCb_bp0 OCb_MXP_n0_125 vss sg13_hv_nmos w=0.5u l=0.45u m=1
MOCb_MXP_S0_126_0 vref OCb_bbp0 OCb_MXP_n0_126 vss sg13_hv_nmos w=0.5u l=0.45u m=1
MOCb_MXP_S0_126_1 vref OCb_bp0 OCb_MXP_n0_126 vss sg13_hv_nmos w=0.5u l=0.45u m=1
MOCb_MXP_S0_127_0 vref OCb_bbp0 OCb_MXP_n0_127 vss sg13_hv_nmos w=0.5u l=0.45u m=1
MOCb_MXP_S0_127_1 vref OCb_bp0 OCb_MXP_n0_127 vss sg13_hv_nmos w=0.5u l=0.45u m=1
MOCb_MXP_S1_0_0 OCb_MXP_n0_0 OCb_bbp1 OCb_MXP_n1_0 vss sg13_hv_nmos w=0.5u l=0.45u m=1
MOCb_MXP_S1_0_1 OCb_MXP_n0_1 OCb_bp1 OCb_MXP_n1_0 vss sg13_hv_nmos w=0.5u l=0.45u m=1
MOCb_MXP_S1_1_0 OCb_MXP_n0_2 OCb_bbp1 OCb_MXP_n1_1 vss sg13_hv_nmos w=0.5u l=0.45u m=1
MOCb_MXP_S1_1_1 OCb_MXP_n0_3 OCb_bp1 OCb_MXP_n1_1 vss sg13_hv_nmos w=0.5u l=0.45u m=1
MOCb_MXP_S1_2_0 OCb_MXP_n0_4 OCb_bbp1 OCb_MXP_n1_2 vss sg13_hv_nmos w=0.5u l=0.45u m=1
MOCb_MXP_S1_2_1 OCb_MXP_n0_5 OCb_bp1 OCb_MXP_n1_2 vss sg13_hv_nmos w=0.5u l=0.45u m=1
MOCb_MXP_S1_3_0 OCb_MXP_n0_6 OCb_bbp1 OCb_MXP_n1_3 vss sg13_hv_nmos w=0.5u l=0.45u m=1
MOCb_MXP_S1_3_1 OCb_MXP_n0_7 OCb_bp1 OCb_MXP_n1_3 vss sg13_hv_nmos w=0.5u l=0.45u m=1
MOCb_MXP_S1_4_0 OCb_MXP_n0_8 OCb_bbp1 OCb_MXP_n1_4 vss sg13_hv_nmos w=0.5u l=0.45u m=1
MOCb_MXP_S1_4_1 OCb_MXP_n0_9 OCb_bp1 OCb_MXP_n1_4 vss sg13_hv_nmos w=0.5u l=0.45u m=1
MOCb_MXP_S1_5_0 OCb_MXP_n0_10 OCb_bbp1 OCb_MXP_n1_5 vss sg13_hv_nmos w=0.5u l=0.45u m=1
MOCb_MXP_S1_5_1 OCb_MXP_n0_11 OCb_bp1 OCb_MXP_n1_5 vss sg13_hv_nmos w=0.5u l=0.45u m=1
MOCb_MXP_S1_6_0 OCb_MXP_n0_12 OCb_bbp1 OCb_MXP_n1_6 vss sg13_hv_nmos w=0.5u l=0.45u m=1
MOCb_MXP_S1_6_1 OCb_MXP_n0_13 OCb_bp1 OCb_MXP_n1_6 vss sg13_hv_nmos w=0.5u l=0.45u m=1
MOCb_MXP_S1_7_0 OCb_MXP_n0_14 OCb_bbp1 OCb_MXP_n1_7 vss sg13_hv_nmos w=0.5u l=0.45u m=1
MOCb_MXP_S1_7_1 OCb_MXP_n0_15 OCb_bp1 OCb_MXP_n1_7 vss sg13_hv_nmos w=0.5u l=0.45u m=1
MOCb_MXP_S1_8_0 OCb_MXP_n0_16 OCb_bbp1 OCb_MXP_n1_8 vss sg13_hv_nmos w=0.5u l=0.45u m=1
MOCb_MXP_S1_8_1 OCb_MXP_n0_17 OCb_bp1 OCb_MXP_n1_8 vss sg13_hv_nmos w=0.5u l=0.45u m=1
MOCb_MXP_S1_9_0 OCb_MXP_n0_18 OCb_bbp1 OCb_MXP_n1_9 vss sg13_hv_nmos w=0.5u l=0.45u m=1
MOCb_MXP_S1_9_1 OCb_MXP_n0_19 OCb_bp1 OCb_MXP_n1_9 vss sg13_hv_nmos w=0.5u l=0.45u m=1
MOCb_MXP_S1_10_0 OCb_MXP_n0_20 OCb_bbp1 OCb_MXP_n1_10 vss sg13_hv_nmos w=0.5u l=0.45u m=1
MOCb_MXP_S1_10_1 OCb_MXP_n0_21 OCb_bp1 OCb_MXP_n1_10 vss sg13_hv_nmos w=0.5u l=0.45u m=1
MOCb_MXP_S1_11_0 OCb_MXP_n0_22 OCb_bbp1 OCb_MXP_n1_11 vss sg13_hv_nmos w=0.5u l=0.45u m=1
MOCb_MXP_S1_11_1 OCb_MXP_n0_23 OCb_bp1 OCb_MXP_n1_11 vss sg13_hv_nmos w=0.5u l=0.45u m=1
MOCb_MXP_S1_12_0 OCb_MXP_n0_24 OCb_bbp1 OCb_MXP_n1_12 vss sg13_hv_nmos w=0.5u l=0.45u m=1
MOCb_MXP_S1_12_1 OCb_MXP_n0_25 OCb_bp1 OCb_MXP_n1_12 vss sg13_hv_nmos w=0.5u l=0.45u m=1
MOCb_MXP_S1_13_0 OCb_MXP_n0_26 OCb_bbp1 OCb_MXP_n1_13 vss sg13_hv_nmos w=0.5u l=0.45u m=1
MOCb_MXP_S1_13_1 OCb_MXP_n0_27 OCb_bp1 OCb_MXP_n1_13 vss sg13_hv_nmos w=0.5u l=0.45u m=1
MOCb_MXP_S1_14_0 OCb_MXP_n0_28 OCb_bbp1 OCb_MXP_n1_14 vss sg13_hv_nmos w=0.5u l=0.45u m=1
MOCb_MXP_S1_14_1 OCb_MXP_n0_29 OCb_bp1 OCb_MXP_n1_14 vss sg13_hv_nmos w=0.5u l=0.45u m=1
MOCb_MXP_S1_15_0 OCb_MXP_n0_30 OCb_bbp1 OCb_MXP_n1_15 vss sg13_hv_nmos w=0.5u l=0.45u m=1
MOCb_MXP_S1_15_1 OCb_MXP_n0_31 OCb_bp1 OCb_MXP_n1_15 vss sg13_hv_nmos w=0.5u l=0.45u m=1
MOCb_MXP_S1_16_0 OCb_MXP_n0_32 OCb_bbp1 OCb_MXP_n1_16 vss sg13_hv_nmos w=0.5u l=0.45u m=1
MOCb_MXP_S1_16_1 OCb_MXP_n0_33 OCb_bp1 OCb_MXP_n1_16 vss sg13_hv_nmos w=0.5u l=0.45u m=1
MOCb_MXP_S1_17_0 OCb_MXP_n0_34 OCb_bbp1 OCb_MXP_n1_17 vss sg13_hv_nmos w=0.5u l=0.45u m=1
MOCb_MXP_S1_17_1 OCb_MXP_n0_35 OCb_bp1 OCb_MXP_n1_17 vss sg13_hv_nmos w=0.5u l=0.45u m=1
MOCb_MXP_S1_18_0 OCb_MXP_n0_36 OCb_bbp1 OCb_MXP_n1_18 vss sg13_hv_nmos w=0.5u l=0.45u m=1
MOCb_MXP_S1_18_1 OCb_MXP_n0_37 OCb_bp1 OCb_MXP_n1_18 vss sg13_hv_nmos w=0.5u l=0.45u m=1
MOCb_MXP_S1_19_0 OCb_MXP_n0_38 OCb_bbp1 OCb_MXP_n1_19 vss sg13_hv_nmos w=0.5u l=0.45u m=1
MOCb_MXP_S1_19_1 OCb_MXP_n0_39 OCb_bp1 OCb_MXP_n1_19 vss sg13_hv_nmos w=0.5u l=0.45u m=1
MOCb_MXP_S1_20_0 OCb_MXP_n0_40 OCb_bbp1 OCb_MXP_n1_20 vss sg13_hv_nmos w=0.5u l=0.45u m=1
MOCb_MXP_S1_20_1 OCb_MXP_n0_41 OCb_bp1 OCb_MXP_n1_20 vss sg13_hv_nmos w=0.5u l=0.45u m=1
MOCb_MXP_S1_21_0 OCb_MXP_n0_42 OCb_bbp1 OCb_MXP_n1_21 vss sg13_hv_nmos w=0.5u l=0.45u m=1
MOCb_MXP_S1_21_1 OCb_MXP_n0_43 OCb_bp1 OCb_MXP_n1_21 vss sg13_hv_nmos w=0.5u l=0.45u m=1
MOCb_MXP_S1_22_0 OCb_MXP_n0_44 OCb_bbp1 OCb_MXP_n1_22 vss sg13_hv_nmos w=0.5u l=0.45u m=1
MOCb_MXP_S1_22_1 OCb_MXP_n0_45 OCb_bp1 OCb_MXP_n1_22 vss sg13_hv_nmos w=0.5u l=0.45u m=1
MOCb_MXP_S1_23_0 OCb_MXP_n0_46 OCb_bbp1 OCb_MXP_n1_23 vss sg13_hv_nmos w=0.5u l=0.45u m=1
MOCb_MXP_S1_23_1 OCb_MXP_n0_47 OCb_bp1 OCb_MXP_n1_23 vss sg13_hv_nmos w=0.5u l=0.45u m=1
MOCb_MXP_S1_24_0 OCb_MXP_n0_48 OCb_bbp1 OCb_MXP_n1_24 vss sg13_hv_nmos w=0.5u l=0.45u m=1
MOCb_MXP_S1_24_1 OCb_MXP_n0_49 OCb_bp1 OCb_MXP_n1_24 vss sg13_hv_nmos w=0.5u l=0.45u m=1
MOCb_MXP_S1_25_0 OCb_MXP_n0_50 OCb_bbp1 OCb_MXP_n1_25 vss sg13_hv_nmos w=0.5u l=0.45u m=1
MOCb_MXP_S1_25_1 OCb_MXP_n0_51 OCb_bp1 OCb_MXP_n1_25 vss sg13_hv_nmos w=0.5u l=0.45u m=1
MOCb_MXP_S1_26_0 OCb_MXP_n0_52 OCb_bbp1 OCb_MXP_n1_26 vss sg13_hv_nmos w=0.5u l=0.45u m=1
MOCb_MXP_S1_26_1 OCb_MXP_n0_53 OCb_bp1 OCb_MXP_n1_26 vss sg13_hv_nmos w=0.5u l=0.45u m=1
MOCb_MXP_S1_27_0 OCb_MXP_n0_54 OCb_bbp1 OCb_MXP_n1_27 vss sg13_hv_nmos w=0.5u l=0.45u m=1
MOCb_MXP_S1_27_1 OCb_MXP_n0_55 OCb_bp1 OCb_MXP_n1_27 vss sg13_hv_nmos w=0.5u l=0.45u m=1
MOCb_MXP_S1_28_0 OCb_MXP_n0_56 OCb_bbp1 OCb_MXP_n1_28 vss sg13_hv_nmos w=0.5u l=0.45u m=1
MOCb_MXP_S1_28_1 OCb_MXP_n0_57 OCb_bp1 OCb_MXP_n1_28 vss sg13_hv_nmos w=0.5u l=0.45u m=1
MOCb_MXP_S1_29_0 OCb_MXP_n0_58 OCb_bbp1 OCb_MXP_n1_29 vss sg13_hv_nmos w=0.5u l=0.45u m=1
MOCb_MXP_S1_29_1 OCb_MXP_n0_59 OCb_bp1 OCb_MXP_n1_29 vss sg13_hv_nmos w=0.5u l=0.45u m=1
MOCb_MXP_S1_30_0 OCb_MXP_n0_60 OCb_bbp1 OCb_MXP_n1_30 vss sg13_hv_nmos w=0.5u l=0.45u m=1
MOCb_MXP_S1_30_1 OCb_MXP_n0_61 OCb_bp1 OCb_MXP_n1_30 vss sg13_hv_nmos w=0.5u l=0.45u m=1
MOCb_MXP_S1_31_0 OCb_MXP_n0_62 OCb_bbp1 OCb_MXP_n1_31 vss sg13_hv_nmos w=0.5u l=0.45u m=1
MOCb_MXP_S1_31_1 OCb_MXP_n0_63 OCb_bp1 OCb_MXP_n1_31 vss sg13_hv_nmos w=0.5u l=0.45u m=1
MOCb_MXP_S1_32_0 OCb_MXP_n0_64 OCb_bbp1 OCb_MXP_n1_32 vss sg13_hv_nmos w=0.5u l=0.45u m=1
MOCb_MXP_S1_32_1 OCb_MXP_n0_65 OCb_bp1 OCb_MXP_n1_32 vss sg13_hv_nmos w=0.5u l=0.45u m=1
MOCb_MXP_S1_33_0 OCb_MXP_n0_66 OCb_bbp1 OCb_MXP_n1_33 vss sg13_hv_nmos w=0.5u l=0.45u m=1
MOCb_MXP_S1_33_1 OCb_MXP_n0_67 OCb_bp1 OCb_MXP_n1_33 vss sg13_hv_nmos w=0.5u l=0.45u m=1
MOCb_MXP_S1_34_0 OCb_MXP_n0_68 OCb_bbp1 OCb_MXP_n1_34 vss sg13_hv_nmos w=0.5u l=0.45u m=1
MOCb_MXP_S1_34_1 OCb_MXP_n0_69 OCb_bp1 OCb_MXP_n1_34 vss sg13_hv_nmos w=0.5u l=0.45u m=1
MOCb_MXP_S1_35_0 OCb_MXP_n0_70 OCb_bbp1 OCb_MXP_n1_35 vss sg13_hv_nmos w=0.5u l=0.45u m=1
MOCb_MXP_S1_35_1 OCb_MXP_n0_71 OCb_bp1 OCb_MXP_n1_35 vss sg13_hv_nmos w=0.5u l=0.45u m=1
MOCb_MXP_S1_36_0 OCb_MXP_n0_72 OCb_bbp1 OCb_MXP_n1_36 vss sg13_hv_nmos w=0.5u l=0.45u m=1
MOCb_MXP_S1_36_1 OCb_MXP_n0_73 OCb_bp1 OCb_MXP_n1_36 vss sg13_hv_nmos w=0.5u l=0.45u m=1
MOCb_MXP_S1_37_0 OCb_MXP_n0_74 OCb_bbp1 OCb_MXP_n1_37 vss sg13_hv_nmos w=0.5u l=0.45u m=1
MOCb_MXP_S1_37_1 OCb_MXP_n0_75 OCb_bp1 OCb_MXP_n1_37 vss sg13_hv_nmos w=0.5u l=0.45u m=1
MOCb_MXP_S1_38_0 OCb_MXP_n0_76 OCb_bbp1 OCb_MXP_n1_38 vss sg13_hv_nmos w=0.5u l=0.45u m=1
MOCb_MXP_S1_38_1 OCb_MXP_n0_77 OCb_bp1 OCb_MXP_n1_38 vss sg13_hv_nmos w=0.5u l=0.45u m=1
MOCb_MXP_S1_39_0 OCb_MXP_n0_78 OCb_bbp1 OCb_MXP_n1_39 vss sg13_hv_nmos w=0.5u l=0.45u m=1
MOCb_MXP_S1_39_1 OCb_MXP_n0_79 OCb_bp1 OCb_MXP_n1_39 vss sg13_hv_nmos w=0.5u l=0.45u m=1
MOCb_MXP_S1_40_0 OCb_MXP_n0_80 OCb_bbp1 OCb_MXP_n1_40 vss sg13_hv_nmos w=0.5u l=0.45u m=1
MOCb_MXP_S1_40_1 OCb_MXP_n0_81 OCb_bp1 OCb_MXP_n1_40 vss sg13_hv_nmos w=0.5u l=0.45u m=1
MOCb_MXP_S1_41_0 OCb_MXP_n0_82 OCb_bbp1 OCb_MXP_n1_41 vss sg13_hv_nmos w=0.5u l=0.45u m=1
MOCb_MXP_S1_41_1 OCb_MXP_n0_83 OCb_bp1 OCb_MXP_n1_41 vss sg13_hv_nmos w=0.5u l=0.45u m=1
MOCb_MXP_S1_42_0 OCb_MXP_n0_84 OCb_bbp1 OCb_MXP_n1_42 vss sg13_hv_nmos w=0.5u l=0.45u m=1
MOCb_MXP_S1_42_1 OCb_MXP_n0_85 OCb_bp1 OCb_MXP_n1_42 vss sg13_hv_nmos w=0.5u l=0.45u m=1
MOCb_MXP_S1_43_0 OCb_MXP_n0_86 OCb_bbp1 OCb_MXP_n1_43 vss sg13_hv_nmos w=0.5u l=0.45u m=1
MOCb_MXP_S1_43_1 OCb_MXP_n0_87 OCb_bp1 OCb_MXP_n1_43 vss sg13_hv_nmos w=0.5u l=0.45u m=1
MOCb_MXP_S1_44_0 OCb_MXP_n0_88 OCb_bbp1 OCb_MXP_n1_44 vss sg13_hv_nmos w=0.5u l=0.45u m=1
MOCb_MXP_S1_44_1 OCb_MXP_n0_89 OCb_bp1 OCb_MXP_n1_44 vss sg13_hv_nmos w=0.5u l=0.45u m=1
MOCb_MXP_S1_45_0 OCb_MXP_n0_90 OCb_bbp1 OCb_MXP_n1_45 vss sg13_hv_nmos w=0.5u l=0.45u m=1
MOCb_MXP_S1_45_1 OCb_MXP_n0_91 OCb_bp1 OCb_MXP_n1_45 vss sg13_hv_nmos w=0.5u l=0.45u m=1
MOCb_MXP_S1_46_0 OCb_MXP_n0_92 OCb_bbp1 OCb_MXP_n1_46 vss sg13_hv_nmos w=0.5u l=0.45u m=1
MOCb_MXP_S1_46_1 OCb_MXP_n0_93 OCb_bp1 OCb_MXP_n1_46 vss sg13_hv_nmos w=0.5u l=0.45u m=1
MOCb_MXP_S1_47_0 OCb_MXP_n0_94 OCb_bbp1 OCb_MXP_n1_47 vss sg13_hv_nmos w=0.5u l=0.45u m=1
MOCb_MXP_S1_47_1 OCb_MXP_n0_95 OCb_bp1 OCb_MXP_n1_47 vss sg13_hv_nmos w=0.5u l=0.45u m=1
MOCb_MXP_S1_48_0 OCb_MXP_n0_96 OCb_bbp1 OCb_MXP_n1_48 vss sg13_hv_nmos w=0.5u l=0.45u m=1
MOCb_MXP_S1_48_1 OCb_MXP_n0_97 OCb_bp1 OCb_MXP_n1_48 vss sg13_hv_nmos w=0.5u l=0.45u m=1
MOCb_MXP_S1_49_0 OCb_MXP_n0_98 OCb_bbp1 OCb_MXP_n1_49 vss sg13_hv_nmos w=0.5u l=0.45u m=1
MOCb_MXP_S1_49_1 OCb_MXP_n0_99 OCb_bp1 OCb_MXP_n1_49 vss sg13_hv_nmos w=0.5u l=0.45u m=1
MOCb_MXP_S1_50_0 OCb_MXP_n0_100 OCb_bbp1 OCb_MXP_n1_50 vss sg13_hv_nmos w=0.5u l=0.45u m=1
MOCb_MXP_S1_50_1 OCb_MXP_n0_101 OCb_bp1 OCb_MXP_n1_50 vss sg13_hv_nmos w=0.5u l=0.45u m=1
MOCb_MXP_S1_51_0 OCb_MXP_n0_102 OCb_bbp1 OCb_MXP_n1_51 vss sg13_hv_nmos w=0.5u l=0.45u m=1
MOCb_MXP_S1_51_1 OCb_MXP_n0_103 OCb_bp1 OCb_MXP_n1_51 vss sg13_hv_nmos w=0.5u l=0.45u m=1
MOCb_MXP_S1_52_0 OCb_MXP_n0_104 OCb_bbp1 OCb_MXP_n1_52 vss sg13_hv_nmos w=0.5u l=0.45u m=1
MOCb_MXP_S1_52_1 OCb_MXP_n0_105 OCb_bp1 OCb_MXP_n1_52 vss sg13_hv_nmos w=0.5u l=0.45u m=1
MOCb_MXP_S1_53_0 OCb_MXP_n0_106 OCb_bbp1 OCb_MXP_n1_53 vss sg13_hv_nmos w=0.5u l=0.45u m=1
MOCb_MXP_S1_53_1 OCb_MXP_n0_107 OCb_bp1 OCb_MXP_n1_53 vss sg13_hv_nmos w=0.5u l=0.45u m=1
MOCb_MXP_S1_54_0 OCb_MXP_n0_108 OCb_bbp1 OCb_MXP_n1_54 vss sg13_hv_nmos w=0.5u l=0.45u m=1
MOCb_MXP_S1_54_1 OCb_MXP_n0_109 OCb_bp1 OCb_MXP_n1_54 vss sg13_hv_nmos w=0.5u l=0.45u m=1
MOCb_MXP_S1_55_0 OCb_MXP_n0_110 OCb_bbp1 OCb_MXP_n1_55 vss sg13_hv_nmos w=0.5u l=0.45u m=1
MOCb_MXP_S1_55_1 OCb_MXP_n0_111 OCb_bp1 OCb_MXP_n1_55 vss sg13_hv_nmos w=0.5u l=0.45u m=1
MOCb_MXP_S1_56_0 OCb_MXP_n0_112 OCb_bbp1 OCb_MXP_n1_56 vss sg13_hv_nmos w=0.5u l=0.45u m=1
MOCb_MXP_S1_56_1 OCb_MXP_n0_113 OCb_bp1 OCb_MXP_n1_56 vss sg13_hv_nmos w=0.5u l=0.45u m=1
MOCb_MXP_S1_57_0 OCb_MXP_n0_114 OCb_bbp1 OCb_MXP_n1_57 vss sg13_hv_nmos w=0.5u l=0.45u m=1
MOCb_MXP_S1_57_1 OCb_MXP_n0_115 OCb_bp1 OCb_MXP_n1_57 vss sg13_hv_nmos w=0.5u l=0.45u m=1
MOCb_MXP_S1_58_0 OCb_MXP_n0_116 OCb_bbp1 OCb_MXP_n1_58 vss sg13_hv_nmos w=0.5u l=0.45u m=1
MOCb_MXP_S1_58_1 OCb_MXP_n0_117 OCb_bp1 OCb_MXP_n1_58 vss sg13_hv_nmos w=0.5u l=0.45u m=1
MOCb_MXP_S1_59_0 OCb_MXP_n0_118 OCb_bbp1 OCb_MXP_n1_59 vss sg13_hv_nmos w=0.5u l=0.45u m=1
MOCb_MXP_S1_59_1 OCb_MXP_n0_119 OCb_bp1 OCb_MXP_n1_59 vss sg13_hv_nmos w=0.5u l=0.45u m=1
MOCb_MXP_S1_60_0 OCb_MXP_n0_120 OCb_bbp1 OCb_MXP_n1_60 vss sg13_hv_nmos w=0.5u l=0.45u m=1
MOCb_MXP_S1_60_1 OCb_MXP_n0_121 OCb_bp1 OCb_MXP_n1_60 vss sg13_hv_nmos w=0.5u l=0.45u m=1
MOCb_MXP_S1_61_0 OCb_MXP_n0_122 OCb_bbp1 OCb_MXP_n1_61 vss sg13_hv_nmos w=0.5u l=0.45u m=1
MOCb_MXP_S1_61_1 OCb_MXP_n0_123 OCb_bp1 OCb_MXP_n1_61 vss sg13_hv_nmos w=0.5u l=0.45u m=1
MOCb_MXP_S1_62_0 OCb_MXP_n0_124 OCb_bbp1 OCb_MXP_n1_62 vss sg13_hv_nmos w=0.5u l=0.45u m=1
MOCb_MXP_S1_62_1 OCb_MXP_n0_125 OCb_bp1 OCb_MXP_n1_62 vss sg13_hv_nmos w=0.5u l=0.45u m=1
MOCb_MXP_S1_63_0 OCb_MXP_n0_126 OCb_bbp1 OCb_MXP_n1_63 vss sg13_hv_nmos w=0.5u l=0.45u m=1
MOCb_MXP_S1_63_1 OCb_MXP_n0_127 OCb_bp1 OCb_MXP_n1_63 vss sg13_hv_nmos w=0.5u l=0.45u m=1
MOCb_MXP_S2_0_0 OCb_MXP_n1_0 OCb_bbp2 OCb_MXP_n2_0 vss sg13_hv_nmos w=0.5u l=0.45u m=1
MOCb_MXP_S2_0_1 OCb_MXP_n1_1 OCb_bp2 OCb_MXP_n2_0 vss sg13_hv_nmos w=0.5u l=0.45u m=1
MOCb_MXP_S2_1_0 OCb_MXP_n1_2 OCb_bbp2 OCb_MXP_n2_1 vss sg13_hv_nmos w=0.5u l=0.45u m=1
MOCb_MXP_S2_1_1 OCb_MXP_n1_3 OCb_bp2 OCb_MXP_n2_1 vss sg13_hv_nmos w=0.5u l=0.45u m=1
MOCb_MXP_S2_2_0 OCb_MXP_n1_4 OCb_bbp2 OCb_MXP_n2_2 vss sg13_hv_nmos w=0.5u l=0.45u m=1
MOCb_MXP_S2_2_1 OCb_MXP_n1_5 OCb_bp2 OCb_MXP_n2_2 vss sg13_hv_nmos w=0.5u l=0.45u m=1
MOCb_MXP_S2_3_0 OCb_MXP_n1_6 OCb_bbp2 OCb_MXP_n2_3 vss sg13_hv_nmos w=0.5u l=0.45u m=1
MOCb_MXP_S2_3_1 OCb_MXP_n1_7 OCb_bp2 OCb_MXP_n2_3 vss sg13_hv_nmos w=0.5u l=0.45u m=1
MOCb_MXP_S2_4_0 OCb_MXP_n1_8 OCb_bbp2 OCb_MXP_n2_4 vss sg13_hv_nmos w=0.5u l=0.45u m=1
MOCb_MXP_S2_4_1 OCb_MXP_n1_9 OCb_bp2 OCb_MXP_n2_4 vss sg13_hv_nmos w=0.5u l=0.45u m=1
MOCb_MXP_S2_5_0 OCb_MXP_n1_10 OCb_bbp2 OCb_MXP_n2_5 vss sg13_hv_nmos w=0.5u l=0.45u m=1
MOCb_MXP_S2_5_1 OCb_MXP_n1_11 OCb_bp2 OCb_MXP_n2_5 vss sg13_hv_nmos w=0.5u l=0.45u m=1
MOCb_MXP_S2_6_0 OCb_MXP_n1_12 OCb_bbp2 OCb_MXP_n2_6 vss sg13_hv_nmos w=0.5u l=0.45u m=1
MOCb_MXP_S2_6_1 OCb_MXP_n1_13 OCb_bp2 OCb_MXP_n2_6 vss sg13_hv_nmos w=0.5u l=0.45u m=1
MOCb_MXP_S2_7_0 OCb_MXP_n1_14 OCb_bbp2 OCb_MXP_n2_7 vss sg13_hv_nmos w=0.5u l=0.45u m=1
MOCb_MXP_S2_7_1 OCb_MXP_n1_15 OCb_bp2 OCb_MXP_n2_7 vss sg13_hv_nmos w=0.5u l=0.45u m=1
MOCb_MXP_S2_8_0 OCb_MXP_n1_16 OCb_bbp2 OCb_MXP_n2_8 vss sg13_hv_nmos w=0.5u l=0.45u m=1
MOCb_MXP_S2_8_1 OCb_MXP_n1_17 OCb_bp2 OCb_MXP_n2_8 vss sg13_hv_nmos w=0.5u l=0.45u m=1
MOCb_MXP_S2_9_0 OCb_MXP_n1_18 OCb_bbp2 OCb_MXP_n2_9 vss sg13_hv_nmos w=0.5u l=0.45u m=1
MOCb_MXP_S2_9_1 OCb_MXP_n1_19 OCb_bp2 OCb_MXP_n2_9 vss sg13_hv_nmos w=0.5u l=0.45u m=1
MOCb_MXP_S2_10_0 OCb_MXP_n1_20 OCb_bbp2 OCb_MXP_n2_10 vss sg13_hv_nmos w=0.5u l=0.45u m=1
MOCb_MXP_S2_10_1 OCb_MXP_n1_21 OCb_bp2 OCb_MXP_n2_10 vss sg13_hv_nmos w=0.5u l=0.45u m=1
MOCb_MXP_S2_11_0 OCb_MXP_n1_22 OCb_bbp2 OCb_MXP_n2_11 vss sg13_hv_nmos w=0.5u l=0.45u m=1
MOCb_MXP_S2_11_1 OCb_MXP_n1_23 OCb_bp2 OCb_MXP_n2_11 vss sg13_hv_nmos w=0.5u l=0.45u m=1
MOCb_MXP_S2_12_0 OCb_MXP_n1_24 OCb_bbp2 OCb_MXP_n2_12 vss sg13_hv_nmos w=0.5u l=0.45u m=1
MOCb_MXP_S2_12_1 OCb_MXP_n1_25 OCb_bp2 OCb_MXP_n2_12 vss sg13_hv_nmos w=0.5u l=0.45u m=1
MOCb_MXP_S2_13_0 OCb_MXP_n1_26 OCb_bbp2 OCb_MXP_n2_13 vss sg13_hv_nmos w=0.5u l=0.45u m=1
MOCb_MXP_S2_13_1 OCb_MXP_n1_27 OCb_bp2 OCb_MXP_n2_13 vss sg13_hv_nmos w=0.5u l=0.45u m=1
MOCb_MXP_S2_14_0 OCb_MXP_n1_28 OCb_bbp2 OCb_MXP_n2_14 vss sg13_hv_nmos w=0.5u l=0.45u m=1
MOCb_MXP_S2_14_1 OCb_MXP_n1_29 OCb_bp2 OCb_MXP_n2_14 vss sg13_hv_nmos w=0.5u l=0.45u m=1
MOCb_MXP_S2_15_0 OCb_MXP_n1_30 OCb_bbp2 OCb_MXP_n2_15 vss sg13_hv_nmos w=0.5u l=0.45u m=1
MOCb_MXP_S2_15_1 OCb_MXP_n1_31 OCb_bp2 OCb_MXP_n2_15 vss sg13_hv_nmos w=0.5u l=0.45u m=1
MOCb_MXP_S2_16_0 OCb_MXP_n1_32 OCb_bbp2 OCb_MXP_n2_16 vss sg13_hv_nmos w=0.5u l=0.45u m=1
MOCb_MXP_S2_16_1 OCb_MXP_n1_33 OCb_bp2 OCb_MXP_n2_16 vss sg13_hv_nmos w=0.5u l=0.45u m=1
MOCb_MXP_S2_17_0 OCb_MXP_n1_34 OCb_bbp2 OCb_MXP_n2_17 vss sg13_hv_nmos w=0.5u l=0.45u m=1
MOCb_MXP_S2_17_1 OCb_MXP_n1_35 OCb_bp2 OCb_MXP_n2_17 vss sg13_hv_nmos w=0.5u l=0.45u m=1
MOCb_MXP_S2_18_0 OCb_MXP_n1_36 OCb_bbp2 OCb_MXP_n2_18 vss sg13_hv_nmos w=0.5u l=0.45u m=1
MOCb_MXP_S2_18_1 OCb_MXP_n1_37 OCb_bp2 OCb_MXP_n2_18 vss sg13_hv_nmos w=0.5u l=0.45u m=1
MOCb_MXP_S2_19_0 OCb_MXP_n1_38 OCb_bbp2 OCb_MXP_n2_19 vss sg13_hv_nmos w=0.5u l=0.45u m=1
MOCb_MXP_S2_19_1 OCb_MXP_n1_39 OCb_bp2 OCb_MXP_n2_19 vss sg13_hv_nmos w=0.5u l=0.45u m=1
MOCb_MXP_S2_20_0 OCb_MXP_n1_40 OCb_bbp2 OCb_MXP_n2_20 vss sg13_hv_nmos w=0.5u l=0.45u m=1
MOCb_MXP_S2_20_1 OCb_MXP_n1_41 OCb_bp2 OCb_MXP_n2_20 vss sg13_hv_nmos w=0.5u l=0.45u m=1
MOCb_MXP_S2_21_0 OCb_MXP_n1_42 OCb_bbp2 OCb_MXP_n2_21 vss sg13_hv_nmos w=0.5u l=0.45u m=1
MOCb_MXP_S2_21_1 OCb_MXP_n1_43 OCb_bp2 OCb_MXP_n2_21 vss sg13_hv_nmos w=0.5u l=0.45u m=1
MOCb_MXP_S2_22_0 OCb_MXP_n1_44 OCb_bbp2 OCb_MXP_n2_22 vss sg13_hv_nmos w=0.5u l=0.45u m=1
MOCb_MXP_S2_22_1 OCb_MXP_n1_45 OCb_bp2 OCb_MXP_n2_22 vss sg13_hv_nmos w=0.5u l=0.45u m=1
MOCb_MXP_S2_23_0 OCb_MXP_n1_46 OCb_bbp2 OCb_MXP_n2_23 vss sg13_hv_nmos w=0.5u l=0.45u m=1
MOCb_MXP_S2_23_1 OCb_MXP_n1_47 OCb_bp2 OCb_MXP_n2_23 vss sg13_hv_nmos w=0.5u l=0.45u m=1
MOCb_MXP_S2_24_0 OCb_MXP_n1_48 OCb_bbp2 OCb_MXP_n2_24 vss sg13_hv_nmos w=0.5u l=0.45u m=1
MOCb_MXP_S2_24_1 OCb_MXP_n1_49 OCb_bp2 OCb_MXP_n2_24 vss sg13_hv_nmos w=0.5u l=0.45u m=1
MOCb_MXP_S2_25_0 OCb_MXP_n1_50 OCb_bbp2 OCb_MXP_n2_25 vss sg13_hv_nmos w=0.5u l=0.45u m=1
MOCb_MXP_S2_25_1 OCb_MXP_n1_51 OCb_bp2 OCb_MXP_n2_25 vss sg13_hv_nmos w=0.5u l=0.45u m=1
MOCb_MXP_S2_26_0 OCb_MXP_n1_52 OCb_bbp2 OCb_MXP_n2_26 vss sg13_hv_nmos w=0.5u l=0.45u m=1
MOCb_MXP_S2_26_1 OCb_MXP_n1_53 OCb_bp2 OCb_MXP_n2_26 vss sg13_hv_nmos w=0.5u l=0.45u m=1
MOCb_MXP_S2_27_0 OCb_MXP_n1_54 OCb_bbp2 OCb_MXP_n2_27 vss sg13_hv_nmos w=0.5u l=0.45u m=1
MOCb_MXP_S2_27_1 OCb_MXP_n1_55 OCb_bp2 OCb_MXP_n2_27 vss sg13_hv_nmos w=0.5u l=0.45u m=1
MOCb_MXP_S2_28_0 OCb_MXP_n1_56 OCb_bbp2 OCb_MXP_n2_28 vss sg13_hv_nmos w=0.5u l=0.45u m=1
MOCb_MXP_S2_28_1 OCb_MXP_n1_57 OCb_bp2 OCb_MXP_n2_28 vss sg13_hv_nmos w=0.5u l=0.45u m=1
MOCb_MXP_S2_29_0 OCb_MXP_n1_58 OCb_bbp2 OCb_MXP_n2_29 vss sg13_hv_nmos w=0.5u l=0.45u m=1
MOCb_MXP_S2_29_1 OCb_MXP_n1_59 OCb_bp2 OCb_MXP_n2_29 vss sg13_hv_nmos w=0.5u l=0.45u m=1
MOCb_MXP_S2_30_0 OCb_MXP_n1_60 OCb_bbp2 OCb_MXP_n2_30 vss sg13_hv_nmos w=0.5u l=0.45u m=1
MOCb_MXP_S2_30_1 OCb_MXP_n1_61 OCb_bp2 OCb_MXP_n2_30 vss sg13_hv_nmos w=0.5u l=0.45u m=1
MOCb_MXP_S2_31_0 OCb_MXP_n1_62 OCb_bbp2 OCb_MXP_n2_31 vss sg13_hv_nmos w=0.5u l=0.45u m=1
MOCb_MXP_S2_31_1 OCb_MXP_n1_63 OCb_bp2 OCb_MXP_n2_31 vss sg13_hv_nmos w=0.5u l=0.45u m=1
MOCb_MXP_S3_0_0 OCb_MXP_n2_0 OCb_bbp3 OCb_MXP_n3_0 vss sg13_hv_nmos w=0.5u l=0.45u m=1
MOCb_MXP_S3_0_1 OCb_MXP_n2_1 OCb_bp3 OCb_MXP_n3_0 vss sg13_hv_nmos w=0.5u l=0.45u m=1
MOCb_MXP_S3_1_0 OCb_MXP_n2_2 OCb_bbp3 OCb_MXP_n3_1 vss sg13_hv_nmos w=0.5u l=0.45u m=1
MOCb_MXP_S3_1_1 OCb_MXP_n2_3 OCb_bp3 OCb_MXP_n3_1 vss sg13_hv_nmos w=0.5u l=0.45u m=1
MOCb_MXP_S3_2_0 OCb_MXP_n2_4 OCb_bbp3 OCb_MXP_n3_2 vss sg13_hv_nmos w=0.5u l=0.45u m=1
MOCb_MXP_S3_2_1 OCb_MXP_n2_5 OCb_bp3 OCb_MXP_n3_2 vss sg13_hv_nmos w=0.5u l=0.45u m=1
MOCb_MXP_S3_3_0 OCb_MXP_n2_6 OCb_bbp3 OCb_MXP_n3_3 vss sg13_hv_nmos w=0.5u l=0.45u m=1
MOCb_MXP_S3_3_1 OCb_MXP_n2_7 OCb_bp3 OCb_MXP_n3_3 vss sg13_hv_nmos w=0.5u l=0.45u m=1
MOCb_MXP_S3_4_0 OCb_MXP_n2_8 OCb_bbp3 OCb_MXP_n3_4 vss sg13_hv_nmos w=0.5u l=0.45u m=1
MOCb_MXP_S3_4_1 OCb_MXP_n2_9 OCb_bp3 OCb_MXP_n3_4 vss sg13_hv_nmos w=0.5u l=0.45u m=1
MOCb_MXP_S3_5_0 OCb_MXP_n2_10 OCb_bbp3 OCb_MXP_n3_5 vss sg13_hv_nmos w=0.5u l=0.45u m=1
MOCb_MXP_S3_5_1 OCb_MXP_n2_11 OCb_bp3 OCb_MXP_n3_5 vss sg13_hv_nmos w=0.5u l=0.45u m=1
MOCb_MXP_S3_6_0 OCb_MXP_n2_12 OCb_bbp3 OCb_MXP_n3_6 vss sg13_hv_nmos w=0.5u l=0.45u m=1
MOCb_MXP_S3_6_1 OCb_MXP_n2_13 OCb_bp3 OCb_MXP_n3_6 vss sg13_hv_nmos w=0.5u l=0.45u m=1
MOCb_MXP_S3_7_0 OCb_MXP_n2_14 OCb_bbp3 OCb_MXP_n3_7 vss sg13_hv_nmos w=0.5u l=0.45u m=1
MOCb_MXP_S3_7_1 OCb_MXP_n2_15 OCb_bp3 OCb_MXP_n3_7 vss sg13_hv_nmos w=0.5u l=0.45u m=1
MOCb_MXP_S3_8_0 OCb_MXP_n2_16 OCb_bbp3 OCb_MXP_n3_8 vss sg13_hv_nmos w=0.5u l=0.45u m=1
MOCb_MXP_S3_8_1 OCb_MXP_n2_17 OCb_bp3 OCb_MXP_n3_8 vss sg13_hv_nmos w=0.5u l=0.45u m=1
MOCb_MXP_S3_9_0 OCb_MXP_n2_18 OCb_bbp3 OCb_MXP_n3_9 vss sg13_hv_nmos w=0.5u l=0.45u m=1
MOCb_MXP_S3_9_1 OCb_MXP_n2_19 OCb_bp3 OCb_MXP_n3_9 vss sg13_hv_nmos w=0.5u l=0.45u m=1
MOCb_MXP_S3_10_0 OCb_MXP_n2_20 OCb_bbp3 OCb_MXP_n3_10 vss sg13_hv_nmos w=0.5u l=0.45u m=1
MOCb_MXP_S3_10_1 OCb_MXP_n2_21 OCb_bp3 OCb_MXP_n3_10 vss sg13_hv_nmos w=0.5u l=0.45u m=1
MOCb_MXP_S3_11_0 OCb_MXP_n2_22 OCb_bbp3 OCb_MXP_n3_11 vss sg13_hv_nmos w=0.5u l=0.45u m=1
MOCb_MXP_S3_11_1 OCb_MXP_n2_23 OCb_bp3 OCb_MXP_n3_11 vss sg13_hv_nmos w=0.5u l=0.45u m=1
MOCb_MXP_S3_12_0 OCb_MXP_n2_24 OCb_bbp3 OCb_MXP_n3_12 vss sg13_hv_nmos w=0.5u l=0.45u m=1
MOCb_MXP_S3_12_1 OCb_MXP_n2_25 OCb_bp3 OCb_MXP_n3_12 vss sg13_hv_nmos w=0.5u l=0.45u m=1
MOCb_MXP_S3_13_0 OCb_MXP_n2_26 OCb_bbp3 OCb_MXP_n3_13 vss sg13_hv_nmos w=0.5u l=0.45u m=1
MOCb_MXP_S3_13_1 OCb_MXP_n2_27 OCb_bp3 OCb_MXP_n3_13 vss sg13_hv_nmos w=0.5u l=0.45u m=1
MOCb_MXP_S3_14_0 OCb_MXP_n2_28 OCb_bbp3 OCb_MXP_n3_14 vss sg13_hv_nmos w=0.5u l=0.45u m=1
MOCb_MXP_S3_14_1 OCb_MXP_n2_29 OCb_bp3 OCb_MXP_n3_14 vss sg13_hv_nmos w=0.5u l=0.45u m=1
MOCb_MXP_S3_15_0 OCb_MXP_n2_30 OCb_bbp3 OCb_MXP_n3_15 vss sg13_hv_nmos w=0.5u l=0.45u m=1
MOCb_MXP_S3_15_1 OCb_MXP_n2_31 OCb_bp3 OCb_MXP_n3_15 vss sg13_hv_nmos w=0.5u l=0.45u m=1
MOCb_MXP_S4_0_0 OCb_MXP_n3_0 OCb_bbp4 OCb_MXP_n4_0 vss sg13_hv_nmos w=0.5u l=0.45u m=1
MOCb_MXP_S4_0_1 OCb_MXP_n3_1 OCb_bp4 OCb_MXP_n4_0 vss sg13_hv_nmos w=0.5u l=0.45u m=1
MOCb_MXP_S4_1_0 OCb_MXP_n3_2 OCb_bbp4 OCb_MXP_n4_1 vss sg13_hv_nmos w=0.5u l=0.45u m=1
MOCb_MXP_S4_1_1 OCb_MXP_n3_3 OCb_bp4 OCb_MXP_n4_1 vss sg13_hv_nmos w=0.5u l=0.45u m=1
MOCb_MXP_S4_2_0 OCb_MXP_n3_4 OCb_bbp4 OCb_MXP_n4_2 vss sg13_hv_nmos w=0.5u l=0.45u m=1
MOCb_MXP_S4_2_1 OCb_MXP_n3_5 OCb_bp4 OCb_MXP_n4_2 vss sg13_hv_nmos w=0.5u l=0.45u m=1
MOCb_MXP_S4_3_0 OCb_MXP_n3_6 OCb_bbp4 OCb_MXP_n4_3 vss sg13_hv_nmos w=0.5u l=0.45u m=1
MOCb_MXP_S4_3_1 OCb_MXP_n3_7 OCb_bp4 OCb_MXP_n4_3 vss sg13_hv_nmos w=0.5u l=0.45u m=1
MOCb_MXP_S4_4_0 OCb_MXP_n3_8 OCb_bbp4 OCb_MXP_n4_4 vss sg13_hv_nmos w=0.5u l=0.45u m=1
MOCb_MXP_S4_4_1 OCb_MXP_n3_9 OCb_bp4 OCb_MXP_n4_4 vss sg13_hv_nmos w=0.5u l=0.45u m=1
MOCb_MXP_S4_5_0 OCb_MXP_n3_10 OCb_bbp4 OCb_MXP_n4_5 vss sg13_hv_nmos w=0.5u l=0.45u m=1
MOCb_MXP_S4_5_1 OCb_MXP_n3_11 OCb_bp4 OCb_MXP_n4_5 vss sg13_hv_nmos w=0.5u l=0.45u m=1
MOCb_MXP_S4_6_0 OCb_MXP_n3_12 OCb_bbp4 OCb_MXP_n4_6 vss sg13_hv_nmos w=0.5u l=0.45u m=1
MOCb_MXP_S4_6_1 OCb_MXP_n3_13 OCb_bp4 OCb_MXP_n4_6 vss sg13_hv_nmos w=0.5u l=0.45u m=1
MOCb_MXP_S4_7_0 OCb_MXP_n3_14 OCb_bbp4 OCb_MXP_n4_7 vss sg13_hv_nmos w=0.5u l=0.45u m=1
MOCb_MXP_S4_7_1 OCb_MXP_n3_15 OCb_bp4 OCb_MXP_n4_7 vss sg13_hv_nmos w=0.5u l=0.45u m=1
MOCb_MXP_S5_0_0 OCb_MXP_n4_0 OCb_bbp5 OCb_MXP_n5_0 vss sg13_hv_nmos w=0.5u l=0.45u m=1
MOCb_MXP_S5_0_1 OCb_MXP_n4_1 OCb_bp5 OCb_MXP_n5_0 vss sg13_hv_nmos w=0.5u l=0.45u m=1
MOCb_MXP_S5_1_0 OCb_MXP_n4_2 OCb_bbp5 OCb_MXP_n5_1 vss sg13_hv_nmos w=0.5u l=0.45u m=1
MOCb_MXP_S5_1_1 OCb_MXP_n4_3 OCb_bp5 OCb_MXP_n5_1 vss sg13_hv_nmos w=0.5u l=0.45u m=1
MOCb_MXP_S5_2_0 OCb_MXP_n4_4 OCb_bbp5 OCb_MXP_n5_2 vss sg13_hv_nmos w=0.5u l=0.45u m=1
MOCb_MXP_S5_2_1 OCb_MXP_n4_5 OCb_bp5 OCb_MXP_n5_2 vss sg13_hv_nmos w=0.5u l=0.45u m=1
MOCb_MXP_S5_3_0 OCb_MXP_n4_6 OCb_bbp5 OCb_MXP_n5_3 vss sg13_hv_nmos w=0.5u l=0.45u m=1
MOCb_MXP_S5_3_1 OCb_MXP_n4_7 OCb_bp5 OCb_MXP_n5_3 vss sg13_hv_nmos w=0.5u l=0.45u m=1
MOCb_MXP_S6_0_0 OCb_MXP_n5_0 OCb_bbp6 OCb_MXP_n6_0 vss sg13_hv_nmos w=0.5u l=0.45u m=1
MOCb_MXP_S6_0_1 OCb_MXP_n5_1 OCb_bp6 OCb_MXP_n6_0 vss sg13_hv_nmos w=0.5u l=0.45u m=1
MOCb_MXP_S6_1_0 OCb_MXP_n5_2 OCb_bbp6 OCb_MXP_n6_1 vss sg13_hv_nmos w=0.5u l=0.45u m=1
MOCb_MXP_S6_1_1 OCb_MXP_n5_3 OCb_bp6 OCb_MXP_n6_1 vss sg13_hv_nmos w=0.5u l=0.45u m=1
MOCb_MXP_S7_0_0 OCb_MXP_n6_0 OCb_bbp7 OCb_refp vss sg13_hv_nmos w=0.5u l=0.45u m=1
MOCb_MXP_S7_0_1 OCb_MXP_n6_1 OCb_bp7 OCb_refp vss sg13_hv_nmos w=0.5u l=0.45u m=1
MOCb_MXN_S0_0_0 vss OCb_bbn0 OCb_MXN_n0_0 vss sg13_hv_nmos w=0.5u l=0.45u m=1
MOCb_MXN_S0_0_1 t1 OCb_bn0 OCb_MXN_n0_0 vss sg13_hv_nmos w=0.5u l=0.45u m=1
MOCb_MXN_S0_1_0 t2 OCb_bbn0 OCb_MXN_n0_1 vss sg13_hv_nmos w=0.5u l=0.45u m=1
MOCb_MXN_S0_1_1 t3 OCb_bn0 OCb_MXN_n0_1 vss sg13_hv_nmos w=0.5u l=0.45u m=1
MOCb_MXN_S0_2_0 t4 OCb_bbn0 OCb_MXN_n0_2 vss sg13_hv_nmos w=0.5u l=0.45u m=1
MOCb_MXN_S0_2_1 t5 OCb_bn0 OCb_MXN_n0_2 vss sg13_hv_nmos w=0.5u l=0.45u m=1
MOCb_MXN_S0_3_0 t6 OCb_bbn0 OCb_MXN_n0_3 vss sg13_hv_nmos w=0.5u l=0.45u m=1
MOCb_MXN_S0_3_1 t7 OCb_bn0 OCb_MXN_n0_3 vss sg13_hv_nmos w=0.5u l=0.45u m=1
MOCb_MXN_S0_4_0 t8 OCb_bbn0 OCb_MXN_n0_4 vss sg13_hv_nmos w=0.5u l=0.45u m=1
MOCb_MXN_S0_4_1 t9 OCb_bn0 OCb_MXN_n0_4 vss sg13_hv_nmos w=0.5u l=0.45u m=1
MOCb_MXN_S0_5_0 t10 OCb_bbn0 OCb_MXN_n0_5 vss sg13_hv_nmos w=0.5u l=0.45u m=1
MOCb_MXN_S0_5_1 t11 OCb_bn0 OCb_MXN_n0_5 vss sg13_hv_nmos w=0.5u l=0.45u m=1
MOCb_MXN_S0_6_0 t12 OCb_bbn0 OCb_MXN_n0_6 vss sg13_hv_nmos w=0.5u l=0.45u m=1
MOCb_MXN_S0_6_1 t13 OCb_bn0 OCb_MXN_n0_6 vss sg13_hv_nmos w=0.5u l=0.45u m=1
MOCb_MXN_S0_7_0 t14 OCb_bbn0 OCb_MXN_n0_7 vss sg13_hv_nmos w=0.5u l=0.45u m=1
MOCb_MXN_S0_7_1 t15 OCb_bn0 OCb_MXN_n0_7 vss sg13_hv_nmos w=0.5u l=0.45u m=1
MOCb_MXN_S0_8_0 t16 OCb_bbn0 OCb_MXN_n0_8 vss sg13_hv_nmos w=0.5u l=0.45u m=1
MOCb_MXN_S0_8_1 t17 OCb_bn0 OCb_MXN_n0_8 vss sg13_hv_nmos w=0.5u l=0.45u m=1
MOCb_MXN_S0_9_0 t18 OCb_bbn0 OCb_MXN_n0_9 vss sg13_hv_nmos w=0.5u l=0.45u m=1
MOCb_MXN_S0_9_1 t19 OCb_bn0 OCb_MXN_n0_9 vss sg13_hv_nmos w=0.5u l=0.45u m=1
MOCb_MXN_S0_10_0 t20 OCb_bbn0 OCb_MXN_n0_10 vss sg13_hv_nmos w=0.5u l=0.45u m=1
MOCb_MXN_S0_10_1 t21 OCb_bn0 OCb_MXN_n0_10 vss sg13_hv_nmos w=0.5u l=0.45u m=1
MOCb_MXN_S0_11_0 t22 OCb_bbn0 OCb_MXN_n0_11 vss sg13_hv_nmos w=0.5u l=0.45u m=1
MOCb_MXN_S0_11_1 t23 OCb_bn0 OCb_MXN_n0_11 vss sg13_hv_nmos w=0.5u l=0.45u m=1
MOCb_MXN_S0_12_0 t24 OCb_bbn0 OCb_MXN_n0_12 vss sg13_hv_nmos w=0.5u l=0.45u m=1
MOCb_MXN_S0_12_1 t25 OCb_bn0 OCb_MXN_n0_12 vss sg13_hv_nmos w=0.5u l=0.45u m=1
MOCb_MXN_S0_13_0 t26 OCb_bbn0 OCb_MXN_n0_13 vss sg13_hv_nmos w=0.5u l=0.45u m=1
MOCb_MXN_S0_13_1 t27 OCb_bn0 OCb_MXN_n0_13 vss sg13_hv_nmos w=0.5u l=0.45u m=1
MOCb_MXN_S0_14_0 t28 OCb_bbn0 OCb_MXN_n0_14 vss sg13_hv_nmos w=0.5u l=0.45u m=1
MOCb_MXN_S0_14_1 t29 OCb_bn0 OCb_MXN_n0_14 vss sg13_hv_nmos w=0.5u l=0.45u m=1
MOCb_MXN_S0_15_0 t30 OCb_bbn0 OCb_MXN_n0_15 vss sg13_hv_nmos w=0.5u l=0.45u m=1
MOCb_MXN_S0_15_1 t31 OCb_bn0 OCb_MXN_n0_15 vss sg13_hv_nmos w=0.5u l=0.45u m=1
MOCb_MXN_S0_16_0 t32 OCb_bbn0 OCb_MXN_n0_16 vss sg13_hv_nmos w=0.5u l=0.45u m=1
MOCb_MXN_S0_16_1 t33 OCb_bn0 OCb_MXN_n0_16 vss sg13_hv_nmos w=0.5u l=0.45u m=1
MOCb_MXN_S0_17_0 t34 OCb_bbn0 OCb_MXN_n0_17 vss sg13_hv_nmos w=0.5u l=0.45u m=1
MOCb_MXN_S0_17_1 t35 OCb_bn0 OCb_MXN_n0_17 vss sg13_hv_nmos w=0.5u l=0.45u m=1
MOCb_MXN_S0_18_0 t36 OCb_bbn0 OCb_MXN_n0_18 vss sg13_hv_nmos w=0.5u l=0.45u m=1
MOCb_MXN_S0_18_1 t37 OCb_bn0 OCb_MXN_n0_18 vss sg13_hv_nmos w=0.5u l=0.45u m=1
MOCb_MXN_S0_19_0 t38 OCb_bbn0 OCb_MXN_n0_19 vss sg13_hv_nmos w=0.5u l=0.45u m=1
MOCb_MXN_S0_19_1 t39 OCb_bn0 OCb_MXN_n0_19 vss sg13_hv_nmos w=0.5u l=0.45u m=1
MOCb_MXN_S0_20_0 t40 OCb_bbn0 OCb_MXN_n0_20 vss sg13_hv_nmos w=0.5u l=0.45u m=1
MOCb_MXN_S0_20_1 t41 OCb_bn0 OCb_MXN_n0_20 vss sg13_hv_nmos w=0.5u l=0.45u m=1
MOCb_MXN_S0_21_0 t42 OCb_bbn0 OCb_MXN_n0_21 vss sg13_hv_nmos w=0.5u l=0.45u m=1
MOCb_MXN_S0_21_1 t43 OCb_bn0 OCb_MXN_n0_21 vss sg13_hv_nmos w=0.5u l=0.45u m=1
MOCb_MXN_S0_22_0 t44 OCb_bbn0 OCb_MXN_n0_22 vss sg13_hv_nmos w=0.5u l=0.45u m=1
MOCb_MXN_S0_22_1 t45 OCb_bn0 OCb_MXN_n0_22 vss sg13_hv_nmos w=0.5u l=0.45u m=1
MOCb_MXN_S0_23_0 t46 OCb_bbn0 OCb_MXN_n0_23 vss sg13_hv_nmos w=0.5u l=0.45u m=1
MOCb_MXN_S0_23_1 t47 OCb_bn0 OCb_MXN_n0_23 vss sg13_hv_nmos w=0.5u l=0.45u m=1
MOCb_MXN_S0_24_0 t48 OCb_bbn0 OCb_MXN_n0_24 vss sg13_hv_nmos w=0.5u l=0.45u m=1
MOCb_MXN_S0_24_1 t49 OCb_bn0 OCb_MXN_n0_24 vss sg13_hv_nmos w=0.5u l=0.45u m=1
MOCb_MXN_S0_25_0 t50 OCb_bbn0 OCb_MXN_n0_25 vss sg13_hv_nmos w=0.5u l=0.45u m=1
MOCb_MXN_S0_25_1 t51 OCb_bn0 OCb_MXN_n0_25 vss sg13_hv_nmos w=0.5u l=0.45u m=1
MOCb_MXN_S0_26_0 t52 OCb_bbn0 OCb_MXN_n0_26 vss sg13_hv_nmos w=0.5u l=0.45u m=1
MOCb_MXN_S0_26_1 t53 OCb_bn0 OCb_MXN_n0_26 vss sg13_hv_nmos w=0.5u l=0.45u m=1
MOCb_MXN_S0_27_0 t54 OCb_bbn0 OCb_MXN_n0_27 vss sg13_hv_nmos w=0.5u l=0.45u m=1
MOCb_MXN_S0_27_1 t55 OCb_bn0 OCb_MXN_n0_27 vss sg13_hv_nmos w=0.5u l=0.45u m=1
MOCb_MXN_S0_28_0 t56 OCb_bbn0 OCb_MXN_n0_28 vss sg13_hv_nmos w=0.5u l=0.45u m=1
MOCb_MXN_S0_28_1 t57 OCb_bn0 OCb_MXN_n0_28 vss sg13_hv_nmos w=0.5u l=0.45u m=1
MOCb_MXN_S0_29_0 t58 OCb_bbn0 OCb_MXN_n0_29 vss sg13_hv_nmos w=0.5u l=0.45u m=1
MOCb_MXN_S0_29_1 t59 OCb_bn0 OCb_MXN_n0_29 vss sg13_hv_nmos w=0.5u l=0.45u m=1
MOCb_MXN_S0_30_0 t60 OCb_bbn0 OCb_MXN_n0_30 vss sg13_hv_nmos w=0.5u l=0.45u m=1
MOCb_MXN_S0_30_1 t61 OCb_bn0 OCb_MXN_n0_30 vss sg13_hv_nmos w=0.5u l=0.45u m=1
MOCb_MXN_S0_31_0 t62 OCb_bbn0 OCb_MXN_n0_31 vss sg13_hv_nmos w=0.5u l=0.45u m=1
MOCb_MXN_S0_31_1 t63 OCb_bn0 OCb_MXN_n0_31 vss sg13_hv_nmos w=0.5u l=0.45u m=1
MOCb_MXN_S0_32_0 t64 OCb_bbn0 OCb_MXN_n0_32 vss sg13_hv_nmos w=0.5u l=0.45u m=1
MOCb_MXN_S0_32_1 t65 OCb_bn0 OCb_MXN_n0_32 vss sg13_hv_nmos w=0.5u l=0.45u m=1
MOCb_MXN_S0_33_0 t66 OCb_bbn0 OCb_MXN_n0_33 vss sg13_hv_nmos w=0.5u l=0.45u m=1
MOCb_MXN_S0_33_1 t67 OCb_bn0 OCb_MXN_n0_33 vss sg13_hv_nmos w=0.5u l=0.45u m=1
MOCb_MXN_S0_34_0 t68 OCb_bbn0 OCb_MXN_n0_34 vss sg13_hv_nmos w=0.5u l=0.45u m=1
MOCb_MXN_S0_34_1 t69 OCb_bn0 OCb_MXN_n0_34 vss sg13_hv_nmos w=0.5u l=0.45u m=1
MOCb_MXN_S0_35_0 t70 OCb_bbn0 OCb_MXN_n0_35 vss sg13_hv_nmos w=0.5u l=0.45u m=1
MOCb_MXN_S0_35_1 t71 OCb_bn0 OCb_MXN_n0_35 vss sg13_hv_nmos w=0.5u l=0.45u m=1
MOCb_MXN_S0_36_0 t72 OCb_bbn0 OCb_MXN_n0_36 vss sg13_hv_nmos w=0.5u l=0.45u m=1
MOCb_MXN_S0_36_1 t73 OCb_bn0 OCb_MXN_n0_36 vss sg13_hv_nmos w=0.5u l=0.45u m=1
MOCb_MXN_S0_37_0 t74 OCb_bbn0 OCb_MXN_n0_37 vss sg13_hv_nmos w=0.5u l=0.45u m=1
MOCb_MXN_S0_37_1 t75 OCb_bn0 OCb_MXN_n0_37 vss sg13_hv_nmos w=0.5u l=0.45u m=1
MOCb_MXN_S0_38_0 t76 OCb_bbn0 OCb_MXN_n0_38 vss sg13_hv_nmos w=0.5u l=0.45u m=1
MOCb_MXN_S0_38_1 t77 OCb_bn0 OCb_MXN_n0_38 vss sg13_hv_nmos w=0.5u l=0.45u m=1
MOCb_MXN_S0_39_0 t78 OCb_bbn0 OCb_MXN_n0_39 vss sg13_hv_nmos w=0.5u l=0.45u m=1
MOCb_MXN_S0_39_1 t79 OCb_bn0 OCb_MXN_n0_39 vss sg13_hv_nmos w=0.5u l=0.45u m=1
MOCb_MXN_S0_40_0 t80 OCb_bbn0 OCb_MXN_n0_40 vss sg13_hv_nmos w=0.5u l=0.45u m=1
MOCb_MXN_S0_40_1 t81 OCb_bn0 OCb_MXN_n0_40 vss sg13_hv_nmos w=0.5u l=0.45u m=1
MOCb_MXN_S0_41_0 t82 OCb_bbn0 OCb_MXN_n0_41 vss sg13_hv_nmos w=0.5u l=0.45u m=1
MOCb_MXN_S0_41_1 t83 OCb_bn0 OCb_MXN_n0_41 vss sg13_hv_nmos w=0.5u l=0.45u m=1
MOCb_MXN_S0_42_0 t84 OCb_bbn0 OCb_MXN_n0_42 vss sg13_hv_nmos w=0.5u l=0.45u m=1
MOCb_MXN_S0_42_1 t85 OCb_bn0 OCb_MXN_n0_42 vss sg13_hv_nmos w=0.5u l=0.45u m=1
MOCb_MXN_S0_43_0 t86 OCb_bbn0 OCb_MXN_n0_43 vss sg13_hv_nmos w=0.5u l=0.45u m=1
MOCb_MXN_S0_43_1 t87 OCb_bn0 OCb_MXN_n0_43 vss sg13_hv_nmos w=0.5u l=0.45u m=1
MOCb_MXN_S0_44_0 t88 OCb_bbn0 OCb_MXN_n0_44 vss sg13_hv_nmos w=0.5u l=0.45u m=1
MOCb_MXN_S0_44_1 t89 OCb_bn0 OCb_MXN_n0_44 vss sg13_hv_nmos w=0.5u l=0.45u m=1
MOCb_MXN_S0_45_0 t90 OCb_bbn0 OCb_MXN_n0_45 vss sg13_hv_nmos w=0.5u l=0.45u m=1
MOCb_MXN_S0_45_1 t91 OCb_bn0 OCb_MXN_n0_45 vss sg13_hv_nmos w=0.5u l=0.45u m=1
MOCb_MXN_S0_46_0 t92 OCb_bbn0 OCb_MXN_n0_46 vss sg13_hv_nmos w=0.5u l=0.45u m=1
MOCb_MXN_S0_46_1 t93 OCb_bn0 OCb_MXN_n0_46 vss sg13_hv_nmos w=0.5u l=0.45u m=1
MOCb_MXN_S0_47_0 t94 OCb_bbn0 OCb_MXN_n0_47 vss sg13_hv_nmos w=0.5u l=0.45u m=1
MOCb_MXN_S0_47_1 t95 OCb_bn0 OCb_MXN_n0_47 vss sg13_hv_nmos w=0.5u l=0.45u m=1
MOCb_MXN_S0_48_0 t96 OCb_bbn0 OCb_MXN_n0_48 vss sg13_hv_nmos w=0.5u l=0.45u m=1
MOCb_MXN_S0_48_1 t97 OCb_bn0 OCb_MXN_n0_48 vss sg13_hv_nmos w=0.5u l=0.45u m=1
MOCb_MXN_S0_49_0 t98 OCb_bbn0 OCb_MXN_n0_49 vss sg13_hv_nmos w=0.5u l=0.45u m=1
MOCb_MXN_S0_49_1 t99 OCb_bn0 OCb_MXN_n0_49 vss sg13_hv_nmos w=0.5u l=0.45u m=1
MOCb_MXN_S0_50_0 t100 OCb_bbn0 OCb_MXN_n0_50 vss sg13_hv_nmos w=0.5u l=0.45u m=1
MOCb_MXN_S0_50_1 t101 OCb_bn0 OCb_MXN_n0_50 vss sg13_hv_nmos w=0.5u l=0.45u m=1
MOCb_MXN_S0_51_0 t102 OCb_bbn0 OCb_MXN_n0_51 vss sg13_hv_nmos w=0.5u l=0.45u m=1
MOCb_MXN_S0_51_1 t103 OCb_bn0 OCb_MXN_n0_51 vss sg13_hv_nmos w=0.5u l=0.45u m=1
MOCb_MXN_S0_52_0 t104 OCb_bbn0 OCb_MXN_n0_52 vss sg13_hv_nmos w=0.5u l=0.45u m=1
MOCb_MXN_S0_52_1 t105 OCb_bn0 OCb_MXN_n0_52 vss sg13_hv_nmos w=0.5u l=0.45u m=1
MOCb_MXN_S0_53_0 t106 OCb_bbn0 OCb_MXN_n0_53 vss sg13_hv_nmos w=0.5u l=0.45u m=1
MOCb_MXN_S0_53_1 t107 OCb_bn0 OCb_MXN_n0_53 vss sg13_hv_nmos w=0.5u l=0.45u m=1
MOCb_MXN_S0_54_0 t108 OCb_bbn0 OCb_MXN_n0_54 vss sg13_hv_nmos w=0.5u l=0.45u m=1
MOCb_MXN_S0_54_1 t109 OCb_bn0 OCb_MXN_n0_54 vss sg13_hv_nmos w=0.5u l=0.45u m=1
MOCb_MXN_S0_55_0 t110 OCb_bbn0 OCb_MXN_n0_55 vss sg13_hv_nmos w=0.5u l=0.45u m=1
MOCb_MXN_S0_55_1 t111 OCb_bn0 OCb_MXN_n0_55 vss sg13_hv_nmos w=0.5u l=0.45u m=1
MOCb_MXN_S0_56_0 t112 OCb_bbn0 OCb_MXN_n0_56 vss sg13_hv_nmos w=0.5u l=0.45u m=1
MOCb_MXN_S0_56_1 t113 OCb_bn0 OCb_MXN_n0_56 vss sg13_hv_nmos w=0.5u l=0.45u m=1
MOCb_MXN_S0_57_0 t114 OCb_bbn0 OCb_MXN_n0_57 vss sg13_hv_nmos w=0.5u l=0.45u m=1
MOCb_MXN_S0_57_1 t115 OCb_bn0 OCb_MXN_n0_57 vss sg13_hv_nmos w=0.5u l=0.45u m=1
MOCb_MXN_S0_58_0 t116 OCb_bbn0 OCb_MXN_n0_58 vss sg13_hv_nmos w=0.5u l=0.45u m=1
MOCb_MXN_S0_58_1 t117 OCb_bn0 OCb_MXN_n0_58 vss sg13_hv_nmos w=0.5u l=0.45u m=1
MOCb_MXN_S0_59_0 t118 OCb_bbn0 OCb_MXN_n0_59 vss sg13_hv_nmos w=0.5u l=0.45u m=1
MOCb_MXN_S0_59_1 t119 OCb_bn0 OCb_MXN_n0_59 vss sg13_hv_nmos w=0.5u l=0.45u m=1
MOCb_MXN_S0_60_0 t120 OCb_bbn0 OCb_MXN_n0_60 vss sg13_hv_nmos w=0.5u l=0.45u m=1
MOCb_MXN_S0_60_1 t121 OCb_bn0 OCb_MXN_n0_60 vss sg13_hv_nmos w=0.5u l=0.45u m=1
MOCb_MXN_S0_61_0 t122 OCb_bbn0 OCb_MXN_n0_61 vss sg13_hv_nmos w=0.5u l=0.45u m=1
MOCb_MXN_S0_61_1 t123 OCb_bn0 OCb_MXN_n0_61 vss sg13_hv_nmos w=0.5u l=0.45u m=1
MOCb_MXN_S0_62_0 t124 OCb_bbn0 OCb_MXN_n0_62 vss sg13_hv_nmos w=0.5u l=0.45u m=1
MOCb_MXN_S0_62_1 t125 OCb_bn0 OCb_MXN_n0_62 vss sg13_hv_nmos w=0.5u l=0.45u m=1
MOCb_MXN_S0_63_0 t126 OCb_bbn0 OCb_MXN_n0_63 vss sg13_hv_nmos w=0.5u l=0.45u m=1
MOCb_MXN_S0_63_1 t127 OCb_bn0 OCb_MXN_n0_63 vss sg13_hv_nmos w=0.5u l=0.45u m=1
MOCb_MXN_S0_64_0 t128 OCb_bbn0 OCb_MXN_n0_64 vss sg13_hv_nmos w=0.5u l=0.45u m=1
MOCb_MXN_S0_64_1 t129 OCb_bn0 OCb_MXN_n0_64 vss sg13_hv_nmos w=0.5u l=0.45u m=1
MOCb_MXN_S0_65_0 t130 OCb_bbn0 OCb_MXN_n0_65 vss sg13_hv_nmos w=0.5u l=0.45u m=1
MOCb_MXN_S0_65_1 t131 OCb_bn0 OCb_MXN_n0_65 vss sg13_hv_nmos w=0.5u l=0.45u m=1
MOCb_MXN_S0_66_0 t132 OCb_bbn0 OCb_MXN_n0_66 vss sg13_hv_nmos w=0.5u l=0.45u m=1
MOCb_MXN_S0_66_1 t133 OCb_bn0 OCb_MXN_n0_66 vss sg13_hv_nmos w=0.5u l=0.45u m=1
MOCb_MXN_S0_67_0 t134 OCb_bbn0 OCb_MXN_n0_67 vss sg13_hv_nmos w=0.5u l=0.45u m=1
MOCb_MXN_S0_67_1 t135 OCb_bn0 OCb_MXN_n0_67 vss sg13_hv_nmos w=0.5u l=0.45u m=1
MOCb_MXN_S0_68_0 t136 OCb_bbn0 OCb_MXN_n0_68 vss sg13_hv_nmos w=0.5u l=0.45u m=1
MOCb_MXN_S0_68_1 t137 OCb_bn0 OCb_MXN_n0_68 vss sg13_hv_nmos w=0.5u l=0.45u m=1
MOCb_MXN_S0_69_0 t138 OCb_bbn0 OCb_MXN_n0_69 vss sg13_hv_nmos w=0.5u l=0.45u m=1
MOCb_MXN_S0_69_1 t139 OCb_bn0 OCb_MXN_n0_69 vss sg13_hv_nmos w=0.5u l=0.45u m=1
MOCb_MXN_S0_70_0 t140 OCb_bbn0 OCb_MXN_n0_70 vss sg13_hv_nmos w=0.5u l=0.45u m=1
MOCb_MXN_S0_70_1 t141 OCb_bn0 OCb_MXN_n0_70 vss sg13_hv_nmos w=0.5u l=0.45u m=1
MOCb_MXN_S0_71_0 t142 OCb_bbn0 OCb_MXN_n0_71 vss sg13_hv_nmos w=0.5u l=0.45u m=1
MOCb_MXN_S0_71_1 t143 OCb_bn0 OCb_MXN_n0_71 vss sg13_hv_nmos w=0.5u l=0.45u m=1
MOCb_MXN_S0_72_0 t144 OCb_bbn0 OCb_MXN_n0_72 vss sg13_hv_nmos w=0.5u l=0.45u m=1
MOCb_MXN_S0_72_1 t145 OCb_bn0 OCb_MXN_n0_72 vss sg13_hv_nmos w=0.5u l=0.45u m=1
MOCb_MXN_S0_73_0 t146 OCb_bbn0 OCb_MXN_n0_73 vss sg13_hv_nmos w=0.5u l=0.45u m=1
MOCb_MXN_S0_73_1 t147 OCb_bn0 OCb_MXN_n0_73 vss sg13_hv_nmos w=0.5u l=0.45u m=1
MOCb_MXN_S0_74_0 t148 OCb_bbn0 OCb_MXN_n0_74 vss sg13_hv_nmos w=0.5u l=0.45u m=1
MOCb_MXN_S0_74_1 t149 OCb_bn0 OCb_MXN_n0_74 vss sg13_hv_nmos w=0.5u l=0.45u m=1
MOCb_MXN_S0_75_0 t150 OCb_bbn0 OCb_MXN_n0_75 vss sg13_hv_nmos w=0.5u l=0.45u m=1
MOCb_MXN_S0_75_1 t151 OCb_bn0 OCb_MXN_n0_75 vss sg13_hv_nmos w=0.5u l=0.45u m=1
MOCb_MXN_S0_76_0 t152 OCb_bbn0 OCb_MXN_n0_76 vss sg13_hv_nmos w=0.5u l=0.45u m=1
MOCb_MXN_S0_76_1 t153 OCb_bn0 OCb_MXN_n0_76 vss sg13_hv_nmos w=0.5u l=0.45u m=1
MOCb_MXN_S0_77_0 t154 OCb_bbn0 OCb_MXN_n0_77 vss sg13_hv_nmos w=0.5u l=0.45u m=1
MOCb_MXN_S0_77_1 t155 OCb_bn0 OCb_MXN_n0_77 vss sg13_hv_nmos w=0.5u l=0.45u m=1
MOCb_MXN_S0_78_0 t156 OCb_bbn0 OCb_MXN_n0_78 vss sg13_hv_nmos w=0.5u l=0.45u m=1
MOCb_MXN_S0_78_1 t157 OCb_bn0 OCb_MXN_n0_78 vss sg13_hv_nmos w=0.5u l=0.45u m=1
MOCb_MXN_S0_79_0 t158 OCb_bbn0 OCb_MXN_n0_79 vss sg13_hv_nmos w=0.5u l=0.45u m=1
MOCb_MXN_S0_79_1 t159 OCb_bn0 OCb_MXN_n0_79 vss sg13_hv_nmos w=0.5u l=0.45u m=1
MOCb_MXN_S0_80_0 t160 OCb_bbn0 OCb_MXN_n0_80 vss sg13_hv_nmos w=0.5u l=0.45u m=1
MOCb_MXN_S0_80_1 t161 OCb_bn0 OCb_MXN_n0_80 vss sg13_hv_nmos w=0.5u l=0.45u m=1
MOCb_MXN_S0_81_0 t162 OCb_bbn0 OCb_MXN_n0_81 vss sg13_hv_nmos w=0.5u l=0.45u m=1
MOCb_MXN_S0_81_1 t163 OCb_bn0 OCb_MXN_n0_81 vss sg13_hv_nmos w=0.5u l=0.45u m=1
MOCb_MXN_S0_82_0 t164 OCb_bbn0 OCb_MXN_n0_82 vss sg13_hv_nmos w=0.5u l=0.45u m=1
MOCb_MXN_S0_82_1 t165 OCb_bn0 OCb_MXN_n0_82 vss sg13_hv_nmos w=0.5u l=0.45u m=1
MOCb_MXN_S0_83_0 t166 OCb_bbn0 OCb_MXN_n0_83 vss sg13_hv_nmos w=0.5u l=0.45u m=1
MOCb_MXN_S0_83_1 t167 OCb_bn0 OCb_MXN_n0_83 vss sg13_hv_nmos w=0.5u l=0.45u m=1
MOCb_MXN_S0_84_0 t168 OCb_bbn0 OCb_MXN_n0_84 vss sg13_hv_nmos w=0.5u l=0.45u m=1
MOCb_MXN_S0_84_1 t169 OCb_bn0 OCb_MXN_n0_84 vss sg13_hv_nmos w=0.5u l=0.45u m=1
MOCb_MXN_S0_85_0 t170 OCb_bbn0 OCb_MXN_n0_85 vss sg13_hv_nmos w=0.5u l=0.45u m=1
MOCb_MXN_S0_85_1 t171 OCb_bn0 OCb_MXN_n0_85 vss sg13_hv_nmos w=0.5u l=0.45u m=1
MOCb_MXN_S0_86_0 t172 OCb_bbn0 OCb_MXN_n0_86 vss sg13_hv_nmos w=0.5u l=0.45u m=1
MOCb_MXN_S0_86_1 t173 OCb_bn0 OCb_MXN_n0_86 vss sg13_hv_nmos w=0.5u l=0.45u m=1
MOCb_MXN_S0_87_0 t174 OCb_bbn0 OCb_MXN_n0_87 vss sg13_hv_nmos w=0.5u l=0.45u m=1
MOCb_MXN_S0_87_1 t175 OCb_bn0 OCb_MXN_n0_87 vss sg13_hv_nmos w=0.5u l=0.45u m=1
MOCb_MXN_S0_88_0 t176 OCb_bbn0 OCb_MXN_n0_88 vss sg13_hv_nmos w=0.5u l=0.45u m=1
MOCb_MXN_S0_88_1 t177 OCb_bn0 OCb_MXN_n0_88 vss sg13_hv_nmos w=0.5u l=0.45u m=1
MOCb_MXN_S0_89_0 t178 OCb_bbn0 OCb_MXN_n0_89 vss sg13_hv_nmos w=0.5u l=0.45u m=1
MOCb_MXN_S0_89_1 t179 OCb_bn0 OCb_MXN_n0_89 vss sg13_hv_nmos w=0.5u l=0.45u m=1
MOCb_MXN_S0_90_0 t180 OCb_bbn0 OCb_MXN_n0_90 vss sg13_hv_nmos w=0.5u l=0.45u m=1
MOCb_MXN_S0_90_1 t181 OCb_bn0 OCb_MXN_n0_90 vss sg13_hv_nmos w=0.5u l=0.45u m=1
MOCb_MXN_S0_91_0 t182 OCb_bbn0 OCb_MXN_n0_91 vss sg13_hv_nmos w=0.5u l=0.45u m=1
MOCb_MXN_S0_91_1 t183 OCb_bn0 OCb_MXN_n0_91 vss sg13_hv_nmos w=0.5u l=0.45u m=1
MOCb_MXN_S0_92_0 t184 OCb_bbn0 OCb_MXN_n0_92 vss sg13_hv_nmos w=0.5u l=0.45u m=1
MOCb_MXN_S0_92_1 t185 OCb_bn0 OCb_MXN_n0_92 vss sg13_hv_nmos w=0.5u l=0.45u m=1
MOCb_MXN_S0_93_0 t186 OCb_bbn0 OCb_MXN_n0_93 vss sg13_hv_nmos w=0.5u l=0.45u m=1
MOCb_MXN_S0_93_1 t187 OCb_bn0 OCb_MXN_n0_93 vss sg13_hv_nmos w=0.5u l=0.45u m=1
MOCb_MXN_S0_94_0 t188 OCb_bbn0 OCb_MXN_n0_94 vss sg13_hv_nmos w=0.5u l=0.45u m=1
MOCb_MXN_S0_94_1 t189 OCb_bn0 OCb_MXN_n0_94 vss sg13_hv_nmos w=0.5u l=0.45u m=1
MOCb_MXN_S0_95_0 t190 OCb_bbn0 OCb_MXN_n0_95 vss sg13_hv_nmos w=0.5u l=0.45u m=1
MOCb_MXN_S0_95_1 t191 OCb_bn0 OCb_MXN_n0_95 vss sg13_hv_nmos w=0.5u l=0.45u m=1
MOCb_MXN_S0_96_0 t192 OCb_bbn0 OCb_MXN_n0_96 vss sg13_hv_nmos w=0.5u l=0.45u m=1
MOCb_MXN_S0_96_1 t193 OCb_bn0 OCb_MXN_n0_96 vss sg13_hv_nmos w=0.5u l=0.45u m=1
MOCb_MXN_S0_97_0 t194 OCb_bbn0 OCb_MXN_n0_97 vss sg13_hv_nmos w=0.5u l=0.45u m=1
MOCb_MXN_S0_97_1 t195 OCb_bn0 OCb_MXN_n0_97 vss sg13_hv_nmos w=0.5u l=0.45u m=1
MOCb_MXN_S0_98_0 t196 OCb_bbn0 OCb_MXN_n0_98 vss sg13_hv_nmos w=0.5u l=0.45u m=1
MOCb_MXN_S0_98_1 t197 OCb_bn0 OCb_MXN_n0_98 vss sg13_hv_nmos w=0.5u l=0.45u m=1
MOCb_MXN_S0_99_0 t198 OCb_bbn0 OCb_MXN_n0_99 vss sg13_hv_nmos w=0.5u l=0.45u m=1
MOCb_MXN_S0_99_1 t199 OCb_bn0 OCb_MXN_n0_99 vss sg13_hv_nmos w=0.5u l=0.45u m=1
MOCb_MXN_S0_100_0 t200 OCb_bbn0 OCb_MXN_n0_100 vss sg13_hv_nmos w=0.5u l=0.45u m=1
MOCb_MXN_S0_100_1 t201 OCb_bn0 OCb_MXN_n0_100 vss sg13_hv_nmos w=0.5u l=0.45u m=1
MOCb_MXN_S0_101_0 t202 OCb_bbn0 OCb_MXN_n0_101 vss sg13_hv_nmos w=0.5u l=0.45u m=1
MOCb_MXN_S0_101_1 t203 OCb_bn0 OCb_MXN_n0_101 vss sg13_hv_nmos w=0.5u l=0.45u m=1
MOCb_MXN_S0_102_0 t204 OCb_bbn0 OCb_MXN_n0_102 vss sg13_hv_nmos w=0.5u l=0.45u m=1
MOCb_MXN_S0_102_1 t205 OCb_bn0 OCb_MXN_n0_102 vss sg13_hv_nmos w=0.5u l=0.45u m=1
MOCb_MXN_S0_103_0 t206 OCb_bbn0 OCb_MXN_n0_103 vss sg13_hv_nmos w=0.5u l=0.45u m=1
MOCb_MXN_S0_103_1 t207 OCb_bn0 OCb_MXN_n0_103 vss sg13_hv_nmos w=0.5u l=0.45u m=1
MOCb_MXN_S0_104_0 t208 OCb_bbn0 OCb_MXN_n0_104 vss sg13_hv_nmos w=0.5u l=0.45u m=1
MOCb_MXN_S0_104_1 t209 OCb_bn0 OCb_MXN_n0_104 vss sg13_hv_nmos w=0.5u l=0.45u m=1
MOCb_MXN_S0_105_0 t210 OCb_bbn0 OCb_MXN_n0_105 vss sg13_hv_nmos w=0.5u l=0.45u m=1
MOCb_MXN_S0_105_1 t211 OCb_bn0 OCb_MXN_n0_105 vss sg13_hv_nmos w=0.5u l=0.45u m=1
MOCb_MXN_S0_106_0 t212 OCb_bbn0 OCb_MXN_n0_106 vss sg13_hv_nmos w=0.5u l=0.45u m=1
MOCb_MXN_S0_106_1 t213 OCb_bn0 OCb_MXN_n0_106 vss sg13_hv_nmos w=0.5u l=0.45u m=1
MOCb_MXN_S0_107_0 t214 OCb_bbn0 OCb_MXN_n0_107 vss sg13_hv_nmos w=0.5u l=0.45u m=1
MOCb_MXN_S0_107_1 t215 OCb_bn0 OCb_MXN_n0_107 vss sg13_hv_nmos w=0.5u l=0.45u m=1
MOCb_MXN_S0_108_0 t216 OCb_bbn0 OCb_MXN_n0_108 vss sg13_hv_nmos w=0.5u l=0.45u m=1
MOCb_MXN_S0_108_1 t217 OCb_bn0 OCb_MXN_n0_108 vss sg13_hv_nmos w=0.5u l=0.45u m=1
MOCb_MXN_S0_109_0 t218 OCb_bbn0 OCb_MXN_n0_109 vss sg13_hv_nmos w=0.5u l=0.45u m=1
MOCb_MXN_S0_109_1 t219 OCb_bn0 OCb_MXN_n0_109 vss sg13_hv_nmos w=0.5u l=0.45u m=1
MOCb_MXN_S0_110_0 t220 OCb_bbn0 OCb_MXN_n0_110 vss sg13_hv_nmos w=0.5u l=0.45u m=1
MOCb_MXN_S0_110_1 t221 OCb_bn0 OCb_MXN_n0_110 vss sg13_hv_nmos w=0.5u l=0.45u m=1
MOCb_MXN_S0_111_0 t222 OCb_bbn0 OCb_MXN_n0_111 vss sg13_hv_nmos w=0.5u l=0.45u m=1
MOCb_MXN_S0_111_1 t223 OCb_bn0 OCb_MXN_n0_111 vss sg13_hv_nmos w=0.5u l=0.45u m=1
MOCb_MXN_S0_112_0 t224 OCb_bbn0 OCb_MXN_n0_112 vss sg13_hv_nmos w=0.5u l=0.45u m=1
MOCb_MXN_S0_112_1 t225 OCb_bn0 OCb_MXN_n0_112 vss sg13_hv_nmos w=0.5u l=0.45u m=1
MOCb_MXN_S0_113_0 t226 OCb_bbn0 OCb_MXN_n0_113 vss sg13_hv_nmos w=0.5u l=0.45u m=1
MOCb_MXN_S0_113_1 t227 OCb_bn0 OCb_MXN_n0_113 vss sg13_hv_nmos w=0.5u l=0.45u m=1
MOCb_MXN_S0_114_0 t228 OCb_bbn0 OCb_MXN_n0_114 vss sg13_hv_nmos w=0.5u l=0.45u m=1
MOCb_MXN_S0_114_1 t229 OCb_bn0 OCb_MXN_n0_114 vss sg13_hv_nmos w=0.5u l=0.45u m=1
MOCb_MXN_S0_115_0 t230 OCb_bbn0 OCb_MXN_n0_115 vss sg13_hv_nmos w=0.5u l=0.45u m=1
MOCb_MXN_S0_115_1 t231 OCb_bn0 OCb_MXN_n0_115 vss sg13_hv_nmos w=0.5u l=0.45u m=1
MOCb_MXN_S0_116_0 t232 OCb_bbn0 OCb_MXN_n0_116 vss sg13_hv_nmos w=0.5u l=0.45u m=1
MOCb_MXN_S0_116_1 t233 OCb_bn0 OCb_MXN_n0_116 vss sg13_hv_nmos w=0.5u l=0.45u m=1
MOCb_MXN_S0_117_0 t234 OCb_bbn0 OCb_MXN_n0_117 vss sg13_hv_nmos w=0.5u l=0.45u m=1
MOCb_MXN_S0_117_1 t235 OCb_bn0 OCb_MXN_n0_117 vss sg13_hv_nmos w=0.5u l=0.45u m=1
MOCb_MXN_S0_118_0 t236 OCb_bbn0 OCb_MXN_n0_118 vss sg13_hv_nmos w=0.5u l=0.45u m=1
MOCb_MXN_S0_118_1 t237 OCb_bn0 OCb_MXN_n0_118 vss sg13_hv_nmos w=0.5u l=0.45u m=1
MOCb_MXN_S0_119_0 t238 OCb_bbn0 OCb_MXN_n0_119 vss sg13_hv_nmos w=0.5u l=0.45u m=1
MOCb_MXN_S0_119_1 t239 OCb_bn0 OCb_MXN_n0_119 vss sg13_hv_nmos w=0.5u l=0.45u m=1
MOCb_MXN_S0_120_0 t240 OCb_bbn0 OCb_MXN_n0_120 vss sg13_hv_nmos w=0.5u l=0.45u m=1
MOCb_MXN_S0_120_1 t241 OCb_bn0 OCb_MXN_n0_120 vss sg13_hv_nmos w=0.5u l=0.45u m=1
MOCb_MXN_S0_121_0 t242 OCb_bbn0 OCb_MXN_n0_121 vss sg13_hv_nmos w=0.5u l=0.45u m=1
MOCb_MXN_S0_121_1 t243 OCb_bn0 OCb_MXN_n0_121 vss sg13_hv_nmos w=0.5u l=0.45u m=1
MOCb_MXN_S0_122_0 t244 OCb_bbn0 OCb_MXN_n0_122 vss sg13_hv_nmos w=0.5u l=0.45u m=1
MOCb_MXN_S0_122_1 t245 OCb_bn0 OCb_MXN_n0_122 vss sg13_hv_nmos w=0.5u l=0.45u m=1
MOCb_MXN_S0_123_0 t246 OCb_bbn0 OCb_MXN_n0_123 vss sg13_hv_nmos w=0.5u l=0.45u m=1
MOCb_MXN_S0_123_1 t247 OCb_bn0 OCb_MXN_n0_123 vss sg13_hv_nmos w=0.5u l=0.45u m=1
MOCb_MXN_S0_124_0 t248 OCb_bbn0 OCb_MXN_n0_124 vss sg13_hv_nmos w=0.5u l=0.45u m=1
MOCb_MXN_S0_124_1 t249 OCb_bn0 OCb_MXN_n0_124 vss sg13_hv_nmos w=0.5u l=0.45u m=1
MOCb_MXN_S0_125_0 t250 OCb_bbn0 OCb_MXN_n0_125 vss sg13_hv_nmos w=0.5u l=0.45u m=1
MOCb_MXN_S0_125_1 t251 OCb_bn0 OCb_MXN_n0_125 vss sg13_hv_nmos w=0.5u l=0.45u m=1
MOCb_MXN_S0_126_0 vref OCb_bbn0 OCb_MXN_n0_126 vss sg13_hv_nmos w=0.5u l=0.45u m=1
MOCb_MXN_S0_126_1 vref OCb_bn0 OCb_MXN_n0_126 vss sg13_hv_nmos w=0.5u l=0.45u m=1
MOCb_MXN_S0_127_0 vref OCb_bbn0 OCb_MXN_n0_127 vss sg13_hv_nmos w=0.5u l=0.45u m=1
MOCb_MXN_S0_127_1 vref OCb_bn0 OCb_MXN_n0_127 vss sg13_hv_nmos w=0.5u l=0.45u m=1
MOCb_MXN_S1_0_0 OCb_MXN_n0_0 OCb_bbn1 OCb_MXN_n1_0 vss sg13_hv_nmos w=0.5u l=0.45u m=1
MOCb_MXN_S1_0_1 OCb_MXN_n0_1 OCb_bn1 OCb_MXN_n1_0 vss sg13_hv_nmos w=0.5u l=0.45u m=1
MOCb_MXN_S1_1_0 OCb_MXN_n0_2 OCb_bbn1 OCb_MXN_n1_1 vss sg13_hv_nmos w=0.5u l=0.45u m=1
MOCb_MXN_S1_1_1 OCb_MXN_n0_3 OCb_bn1 OCb_MXN_n1_1 vss sg13_hv_nmos w=0.5u l=0.45u m=1
MOCb_MXN_S1_2_0 OCb_MXN_n0_4 OCb_bbn1 OCb_MXN_n1_2 vss sg13_hv_nmos w=0.5u l=0.45u m=1
MOCb_MXN_S1_2_1 OCb_MXN_n0_5 OCb_bn1 OCb_MXN_n1_2 vss sg13_hv_nmos w=0.5u l=0.45u m=1
MOCb_MXN_S1_3_0 OCb_MXN_n0_6 OCb_bbn1 OCb_MXN_n1_3 vss sg13_hv_nmos w=0.5u l=0.45u m=1
MOCb_MXN_S1_3_1 OCb_MXN_n0_7 OCb_bn1 OCb_MXN_n1_3 vss sg13_hv_nmos w=0.5u l=0.45u m=1
MOCb_MXN_S1_4_0 OCb_MXN_n0_8 OCb_bbn1 OCb_MXN_n1_4 vss sg13_hv_nmos w=0.5u l=0.45u m=1
MOCb_MXN_S1_4_1 OCb_MXN_n0_9 OCb_bn1 OCb_MXN_n1_4 vss sg13_hv_nmos w=0.5u l=0.45u m=1
MOCb_MXN_S1_5_0 OCb_MXN_n0_10 OCb_bbn1 OCb_MXN_n1_5 vss sg13_hv_nmos w=0.5u l=0.45u m=1
MOCb_MXN_S1_5_1 OCb_MXN_n0_11 OCb_bn1 OCb_MXN_n1_5 vss sg13_hv_nmos w=0.5u l=0.45u m=1
MOCb_MXN_S1_6_0 OCb_MXN_n0_12 OCb_bbn1 OCb_MXN_n1_6 vss sg13_hv_nmos w=0.5u l=0.45u m=1
MOCb_MXN_S1_6_1 OCb_MXN_n0_13 OCb_bn1 OCb_MXN_n1_6 vss sg13_hv_nmos w=0.5u l=0.45u m=1
MOCb_MXN_S1_7_0 OCb_MXN_n0_14 OCb_bbn1 OCb_MXN_n1_7 vss sg13_hv_nmos w=0.5u l=0.45u m=1
MOCb_MXN_S1_7_1 OCb_MXN_n0_15 OCb_bn1 OCb_MXN_n1_7 vss sg13_hv_nmos w=0.5u l=0.45u m=1
MOCb_MXN_S1_8_0 OCb_MXN_n0_16 OCb_bbn1 OCb_MXN_n1_8 vss sg13_hv_nmos w=0.5u l=0.45u m=1
MOCb_MXN_S1_8_1 OCb_MXN_n0_17 OCb_bn1 OCb_MXN_n1_8 vss sg13_hv_nmos w=0.5u l=0.45u m=1
MOCb_MXN_S1_9_0 OCb_MXN_n0_18 OCb_bbn1 OCb_MXN_n1_9 vss sg13_hv_nmos w=0.5u l=0.45u m=1
MOCb_MXN_S1_9_1 OCb_MXN_n0_19 OCb_bn1 OCb_MXN_n1_9 vss sg13_hv_nmos w=0.5u l=0.45u m=1
MOCb_MXN_S1_10_0 OCb_MXN_n0_20 OCb_bbn1 OCb_MXN_n1_10 vss sg13_hv_nmos w=0.5u l=0.45u m=1
MOCb_MXN_S1_10_1 OCb_MXN_n0_21 OCb_bn1 OCb_MXN_n1_10 vss sg13_hv_nmos w=0.5u l=0.45u m=1
MOCb_MXN_S1_11_0 OCb_MXN_n0_22 OCb_bbn1 OCb_MXN_n1_11 vss sg13_hv_nmos w=0.5u l=0.45u m=1
MOCb_MXN_S1_11_1 OCb_MXN_n0_23 OCb_bn1 OCb_MXN_n1_11 vss sg13_hv_nmos w=0.5u l=0.45u m=1
MOCb_MXN_S1_12_0 OCb_MXN_n0_24 OCb_bbn1 OCb_MXN_n1_12 vss sg13_hv_nmos w=0.5u l=0.45u m=1
MOCb_MXN_S1_12_1 OCb_MXN_n0_25 OCb_bn1 OCb_MXN_n1_12 vss sg13_hv_nmos w=0.5u l=0.45u m=1
MOCb_MXN_S1_13_0 OCb_MXN_n0_26 OCb_bbn1 OCb_MXN_n1_13 vss sg13_hv_nmos w=0.5u l=0.45u m=1
MOCb_MXN_S1_13_1 OCb_MXN_n0_27 OCb_bn1 OCb_MXN_n1_13 vss sg13_hv_nmos w=0.5u l=0.45u m=1
MOCb_MXN_S1_14_0 OCb_MXN_n0_28 OCb_bbn1 OCb_MXN_n1_14 vss sg13_hv_nmos w=0.5u l=0.45u m=1
MOCb_MXN_S1_14_1 OCb_MXN_n0_29 OCb_bn1 OCb_MXN_n1_14 vss sg13_hv_nmos w=0.5u l=0.45u m=1
MOCb_MXN_S1_15_0 OCb_MXN_n0_30 OCb_bbn1 OCb_MXN_n1_15 vss sg13_hv_nmos w=0.5u l=0.45u m=1
MOCb_MXN_S1_15_1 OCb_MXN_n0_31 OCb_bn1 OCb_MXN_n1_15 vss sg13_hv_nmos w=0.5u l=0.45u m=1
MOCb_MXN_S1_16_0 OCb_MXN_n0_32 OCb_bbn1 OCb_MXN_n1_16 vss sg13_hv_nmos w=0.5u l=0.45u m=1
MOCb_MXN_S1_16_1 OCb_MXN_n0_33 OCb_bn1 OCb_MXN_n1_16 vss sg13_hv_nmos w=0.5u l=0.45u m=1
MOCb_MXN_S1_17_0 OCb_MXN_n0_34 OCb_bbn1 OCb_MXN_n1_17 vss sg13_hv_nmos w=0.5u l=0.45u m=1
MOCb_MXN_S1_17_1 OCb_MXN_n0_35 OCb_bn1 OCb_MXN_n1_17 vss sg13_hv_nmos w=0.5u l=0.45u m=1
MOCb_MXN_S1_18_0 OCb_MXN_n0_36 OCb_bbn1 OCb_MXN_n1_18 vss sg13_hv_nmos w=0.5u l=0.45u m=1
MOCb_MXN_S1_18_1 OCb_MXN_n0_37 OCb_bn1 OCb_MXN_n1_18 vss sg13_hv_nmos w=0.5u l=0.45u m=1
MOCb_MXN_S1_19_0 OCb_MXN_n0_38 OCb_bbn1 OCb_MXN_n1_19 vss sg13_hv_nmos w=0.5u l=0.45u m=1
MOCb_MXN_S1_19_1 OCb_MXN_n0_39 OCb_bn1 OCb_MXN_n1_19 vss sg13_hv_nmos w=0.5u l=0.45u m=1
MOCb_MXN_S1_20_0 OCb_MXN_n0_40 OCb_bbn1 OCb_MXN_n1_20 vss sg13_hv_nmos w=0.5u l=0.45u m=1
MOCb_MXN_S1_20_1 OCb_MXN_n0_41 OCb_bn1 OCb_MXN_n1_20 vss sg13_hv_nmos w=0.5u l=0.45u m=1
MOCb_MXN_S1_21_0 OCb_MXN_n0_42 OCb_bbn1 OCb_MXN_n1_21 vss sg13_hv_nmos w=0.5u l=0.45u m=1
MOCb_MXN_S1_21_1 OCb_MXN_n0_43 OCb_bn1 OCb_MXN_n1_21 vss sg13_hv_nmos w=0.5u l=0.45u m=1
MOCb_MXN_S1_22_0 OCb_MXN_n0_44 OCb_bbn1 OCb_MXN_n1_22 vss sg13_hv_nmos w=0.5u l=0.45u m=1
MOCb_MXN_S1_22_1 OCb_MXN_n0_45 OCb_bn1 OCb_MXN_n1_22 vss sg13_hv_nmos w=0.5u l=0.45u m=1
MOCb_MXN_S1_23_0 OCb_MXN_n0_46 OCb_bbn1 OCb_MXN_n1_23 vss sg13_hv_nmos w=0.5u l=0.45u m=1
MOCb_MXN_S1_23_1 OCb_MXN_n0_47 OCb_bn1 OCb_MXN_n1_23 vss sg13_hv_nmos w=0.5u l=0.45u m=1
MOCb_MXN_S1_24_0 OCb_MXN_n0_48 OCb_bbn1 OCb_MXN_n1_24 vss sg13_hv_nmos w=0.5u l=0.45u m=1
MOCb_MXN_S1_24_1 OCb_MXN_n0_49 OCb_bn1 OCb_MXN_n1_24 vss sg13_hv_nmos w=0.5u l=0.45u m=1
MOCb_MXN_S1_25_0 OCb_MXN_n0_50 OCb_bbn1 OCb_MXN_n1_25 vss sg13_hv_nmos w=0.5u l=0.45u m=1
MOCb_MXN_S1_25_1 OCb_MXN_n0_51 OCb_bn1 OCb_MXN_n1_25 vss sg13_hv_nmos w=0.5u l=0.45u m=1
MOCb_MXN_S1_26_0 OCb_MXN_n0_52 OCb_bbn1 OCb_MXN_n1_26 vss sg13_hv_nmos w=0.5u l=0.45u m=1
MOCb_MXN_S1_26_1 OCb_MXN_n0_53 OCb_bn1 OCb_MXN_n1_26 vss sg13_hv_nmos w=0.5u l=0.45u m=1
MOCb_MXN_S1_27_0 OCb_MXN_n0_54 OCb_bbn1 OCb_MXN_n1_27 vss sg13_hv_nmos w=0.5u l=0.45u m=1
MOCb_MXN_S1_27_1 OCb_MXN_n0_55 OCb_bn1 OCb_MXN_n1_27 vss sg13_hv_nmos w=0.5u l=0.45u m=1
MOCb_MXN_S1_28_0 OCb_MXN_n0_56 OCb_bbn1 OCb_MXN_n1_28 vss sg13_hv_nmos w=0.5u l=0.45u m=1
MOCb_MXN_S1_28_1 OCb_MXN_n0_57 OCb_bn1 OCb_MXN_n1_28 vss sg13_hv_nmos w=0.5u l=0.45u m=1
MOCb_MXN_S1_29_0 OCb_MXN_n0_58 OCb_bbn1 OCb_MXN_n1_29 vss sg13_hv_nmos w=0.5u l=0.45u m=1
MOCb_MXN_S1_29_1 OCb_MXN_n0_59 OCb_bn1 OCb_MXN_n1_29 vss sg13_hv_nmos w=0.5u l=0.45u m=1
MOCb_MXN_S1_30_0 OCb_MXN_n0_60 OCb_bbn1 OCb_MXN_n1_30 vss sg13_hv_nmos w=0.5u l=0.45u m=1
MOCb_MXN_S1_30_1 OCb_MXN_n0_61 OCb_bn1 OCb_MXN_n1_30 vss sg13_hv_nmos w=0.5u l=0.45u m=1
MOCb_MXN_S1_31_0 OCb_MXN_n0_62 OCb_bbn1 OCb_MXN_n1_31 vss sg13_hv_nmos w=0.5u l=0.45u m=1
MOCb_MXN_S1_31_1 OCb_MXN_n0_63 OCb_bn1 OCb_MXN_n1_31 vss sg13_hv_nmos w=0.5u l=0.45u m=1
MOCb_MXN_S1_32_0 OCb_MXN_n0_64 OCb_bbn1 OCb_MXN_n1_32 vss sg13_hv_nmos w=0.5u l=0.45u m=1
MOCb_MXN_S1_32_1 OCb_MXN_n0_65 OCb_bn1 OCb_MXN_n1_32 vss sg13_hv_nmos w=0.5u l=0.45u m=1
MOCb_MXN_S1_33_0 OCb_MXN_n0_66 OCb_bbn1 OCb_MXN_n1_33 vss sg13_hv_nmos w=0.5u l=0.45u m=1
MOCb_MXN_S1_33_1 OCb_MXN_n0_67 OCb_bn1 OCb_MXN_n1_33 vss sg13_hv_nmos w=0.5u l=0.45u m=1
MOCb_MXN_S1_34_0 OCb_MXN_n0_68 OCb_bbn1 OCb_MXN_n1_34 vss sg13_hv_nmos w=0.5u l=0.45u m=1
MOCb_MXN_S1_34_1 OCb_MXN_n0_69 OCb_bn1 OCb_MXN_n1_34 vss sg13_hv_nmos w=0.5u l=0.45u m=1
MOCb_MXN_S1_35_0 OCb_MXN_n0_70 OCb_bbn1 OCb_MXN_n1_35 vss sg13_hv_nmos w=0.5u l=0.45u m=1
MOCb_MXN_S1_35_1 OCb_MXN_n0_71 OCb_bn1 OCb_MXN_n1_35 vss sg13_hv_nmos w=0.5u l=0.45u m=1
MOCb_MXN_S1_36_0 OCb_MXN_n0_72 OCb_bbn1 OCb_MXN_n1_36 vss sg13_hv_nmos w=0.5u l=0.45u m=1
MOCb_MXN_S1_36_1 OCb_MXN_n0_73 OCb_bn1 OCb_MXN_n1_36 vss sg13_hv_nmos w=0.5u l=0.45u m=1
MOCb_MXN_S1_37_0 OCb_MXN_n0_74 OCb_bbn1 OCb_MXN_n1_37 vss sg13_hv_nmos w=0.5u l=0.45u m=1
MOCb_MXN_S1_37_1 OCb_MXN_n0_75 OCb_bn1 OCb_MXN_n1_37 vss sg13_hv_nmos w=0.5u l=0.45u m=1
MOCb_MXN_S1_38_0 OCb_MXN_n0_76 OCb_bbn1 OCb_MXN_n1_38 vss sg13_hv_nmos w=0.5u l=0.45u m=1
MOCb_MXN_S1_38_1 OCb_MXN_n0_77 OCb_bn1 OCb_MXN_n1_38 vss sg13_hv_nmos w=0.5u l=0.45u m=1
MOCb_MXN_S1_39_0 OCb_MXN_n0_78 OCb_bbn1 OCb_MXN_n1_39 vss sg13_hv_nmos w=0.5u l=0.45u m=1
MOCb_MXN_S1_39_1 OCb_MXN_n0_79 OCb_bn1 OCb_MXN_n1_39 vss sg13_hv_nmos w=0.5u l=0.45u m=1
MOCb_MXN_S1_40_0 OCb_MXN_n0_80 OCb_bbn1 OCb_MXN_n1_40 vss sg13_hv_nmos w=0.5u l=0.45u m=1
MOCb_MXN_S1_40_1 OCb_MXN_n0_81 OCb_bn1 OCb_MXN_n1_40 vss sg13_hv_nmos w=0.5u l=0.45u m=1
MOCb_MXN_S1_41_0 OCb_MXN_n0_82 OCb_bbn1 OCb_MXN_n1_41 vss sg13_hv_nmos w=0.5u l=0.45u m=1
MOCb_MXN_S1_41_1 OCb_MXN_n0_83 OCb_bn1 OCb_MXN_n1_41 vss sg13_hv_nmos w=0.5u l=0.45u m=1
MOCb_MXN_S1_42_0 OCb_MXN_n0_84 OCb_bbn1 OCb_MXN_n1_42 vss sg13_hv_nmos w=0.5u l=0.45u m=1
MOCb_MXN_S1_42_1 OCb_MXN_n0_85 OCb_bn1 OCb_MXN_n1_42 vss sg13_hv_nmos w=0.5u l=0.45u m=1
MOCb_MXN_S1_43_0 OCb_MXN_n0_86 OCb_bbn1 OCb_MXN_n1_43 vss sg13_hv_nmos w=0.5u l=0.45u m=1
MOCb_MXN_S1_43_1 OCb_MXN_n0_87 OCb_bn1 OCb_MXN_n1_43 vss sg13_hv_nmos w=0.5u l=0.45u m=1
MOCb_MXN_S1_44_0 OCb_MXN_n0_88 OCb_bbn1 OCb_MXN_n1_44 vss sg13_hv_nmos w=0.5u l=0.45u m=1
MOCb_MXN_S1_44_1 OCb_MXN_n0_89 OCb_bn1 OCb_MXN_n1_44 vss sg13_hv_nmos w=0.5u l=0.45u m=1
MOCb_MXN_S1_45_0 OCb_MXN_n0_90 OCb_bbn1 OCb_MXN_n1_45 vss sg13_hv_nmos w=0.5u l=0.45u m=1
MOCb_MXN_S1_45_1 OCb_MXN_n0_91 OCb_bn1 OCb_MXN_n1_45 vss sg13_hv_nmos w=0.5u l=0.45u m=1
MOCb_MXN_S1_46_0 OCb_MXN_n0_92 OCb_bbn1 OCb_MXN_n1_46 vss sg13_hv_nmos w=0.5u l=0.45u m=1
MOCb_MXN_S1_46_1 OCb_MXN_n0_93 OCb_bn1 OCb_MXN_n1_46 vss sg13_hv_nmos w=0.5u l=0.45u m=1
MOCb_MXN_S1_47_0 OCb_MXN_n0_94 OCb_bbn1 OCb_MXN_n1_47 vss sg13_hv_nmos w=0.5u l=0.45u m=1
MOCb_MXN_S1_47_1 OCb_MXN_n0_95 OCb_bn1 OCb_MXN_n1_47 vss sg13_hv_nmos w=0.5u l=0.45u m=1
MOCb_MXN_S1_48_0 OCb_MXN_n0_96 OCb_bbn1 OCb_MXN_n1_48 vss sg13_hv_nmos w=0.5u l=0.45u m=1
MOCb_MXN_S1_48_1 OCb_MXN_n0_97 OCb_bn1 OCb_MXN_n1_48 vss sg13_hv_nmos w=0.5u l=0.45u m=1
MOCb_MXN_S1_49_0 OCb_MXN_n0_98 OCb_bbn1 OCb_MXN_n1_49 vss sg13_hv_nmos w=0.5u l=0.45u m=1
MOCb_MXN_S1_49_1 OCb_MXN_n0_99 OCb_bn1 OCb_MXN_n1_49 vss sg13_hv_nmos w=0.5u l=0.45u m=1
MOCb_MXN_S1_50_0 OCb_MXN_n0_100 OCb_bbn1 OCb_MXN_n1_50 vss sg13_hv_nmos w=0.5u l=0.45u m=1
MOCb_MXN_S1_50_1 OCb_MXN_n0_101 OCb_bn1 OCb_MXN_n1_50 vss sg13_hv_nmos w=0.5u l=0.45u m=1
MOCb_MXN_S1_51_0 OCb_MXN_n0_102 OCb_bbn1 OCb_MXN_n1_51 vss sg13_hv_nmos w=0.5u l=0.45u m=1
MOCb_MXN_S1_51_1 OCb_MXN_n0_103 OCb_bn1 OCb_MXN_n1_51 vss sg13_hv_nmos w=0.5u l=0.45u m=1
MOCb_MXN_S1_52_0 OCb_MXN_n0_104 OCb_bbn1 OCb_MXN_n1_52 vss sg13_hv_nmos w=0.5u l=0.45u m=1
MOCb_MXN_S1_52_1 OCb_MXN_n0_105 OCb_bn1 OCb_MXN_n1_52 vss sg13_hv_nmos w=0.5u l=0.45u m=1
MOCb_MXN_S1_53_0 OCb_MXN_n0_106 OCb_bbn1 OCb_MXN_n1_53 vss sg13_hv_nmos w=0.5u l=0.45u m=1
MOCb_MXN_S1_53_1 OCb_MXN_n0_107 OCb_bn1 OCb_MXN_n1_53 vss sg13_hv_nmos w=0.5u l=0.45u m=1
MOCb_MXN_S1_54_0 OCb_MXN_n0_108 OCb_bbn1 OCb_MXN_n1_54 vss sg13_hv_nmos w=0.5u l=0.45u m=1
MOCb_MXN_S1_54_1 OCb_MXN_n0_109 OCb_bn1 OCb_MXN_n1_54 vss sg13_hv_nmos w=0.5u l=0.45u m=1
MOCb_MXN_S1_55_0 OCb_MXN_n0_110 OCb_bbn1 OCb_MXN_n1_55 vss sg13_hv_nmos w=0.5u l=0.45u m=1
MOCb_MXN_S1_55_1 OCb_MXN_n0_111 OCb_bn1 OCb_MXN_n1_55 vss sg13_hv_nmos w=0.5u l=0.45u m=1
MOCb_MXN_S1_56_0 OCb_MXN_n0_112 OCb_bbn1 OCb_MXN_n1_56 vss sg13_hv_nmos w=0.5u l=0.45u m=1
MOCb_MXN_S1_56_1 OCb_MXN_n0_113 OCb_bn1 OCb_MXN_n1_56 vss sg13_hv_nmos w=0.5u l=0.45u m=1
MOCb_MXN_S1_57_0 OCb_MXN_n0_114 OCb_bbn1 OCb_MXN_n1_57 vss sg13_hv_nmos w=0.5u l=0.45u m=1
MOCb_MXN_S1_57_1 OCb_MXN_n0_115 OCb_bn1 OCb_MXN_n1_57 vss sg13_hv_nmos w=0.5u l=0.45u m=1
MOCb_MXN_S1_58_0 OCb_MXN_n0_116 OCb_bbn1 OCb_MXN_n1_58 vss sg13_hv_nmos w=0.5u l=0.45u m=1
MOCb_MXN_S1_58_1 OCb_MXN_n0_117 OCb_bn1 OCb_MXN_n1_58 vss sg13_hv_nmos w=0.5u l=0.45u m=1
MOCb_MXN_S1_59_0 OCb_MXN_n0_118 OCb_bbn1 OCb_MXN_n1_59 vss sg13_hv_nmos w=0.5u l=0.45u m=1
MOCb_MXN_S1_59_1 OCb_MXN_n0_119 OCb_bn1 OCb_MXN_n1_59 vss sg13_hv_nmos w=0.5u l=0.45u m=1
MOCb_MXN_S1_60_0 OCb_MXN_n0_120 OCb_bbn1 OCb_MXN_n1_60 vss sg13_hv_nmos w=0.5u l=0.45u m=1
MOCb_MXN_S1_60_1 OCb_MXN_n0_121 OCb_bn1 OCb_MXN_n1_60 vss sg13_hv_nmos w=0.5u l=0.45u m=1
MOCb_MXN_S1_61_0 OCb_MXN_n0_122 OCb_bbn1 OCb_MXN_n1_61 vss sg13_hv_nmos w=0.5u l=0.45u m=1
MOCb_MXN_S1_61_1 OCb_MXN_n0_123 OCb_bn1 OCb_MXN_n1_61 vss sg13_hv_nmos w=0.5u l=0.45u m=1
MOCb_MXN_S1_62_0 OCb_MXN_n0_124 OCb_bbn1 OCb_MXN_n1_62 vss sg13_hv_nmos w=0.5u l=0.45u m=1
MOCb_MXN_S1_62_1 OCb_MXN_n0_125 OCb_bn1 OCb_MXN_n1_62 vss sg13_hv_nmos w=0.5u l=0.45u m=1
MOCb_MXN_S1_63_0 OCb_MXN_n0_126 OCb_bbn1 OCb_MXN_n1_63 vss sg13_hv_nmos w=0.5u l=0.45u m=1
MOCb_MXN_S1_63_1 OCb_MXN_n0_127 OCb_bn1 OCb_MXN_n1_63 vss sg13_hv_nmos w=0.5u l=0.45u m=1
MOCb_MXN_S2_0_0 OCb_MXN_n1_0 OCb_bbn2 OCb_MXN_n2_0 vss sg13_hv_nmos w=0.5u l=0.45u m=1
MOCb_MXN_S2_0_1 OCb_MXN_n1_1 OCb_bn2 OCb_MXN_n2_0 vss sg13_hv_nmos w=0.5u l=0.45u m=1
MOCb_MXN_S2_1_0 OCb_MXN_n1_2 OCb_bbn2 OCb_MXN_n2_1 vss sg13_hv_nmos w=0.5u l=0.45u m=1
MOCb_MXN_S2_1_1 OCb_MXN_n1_3 OCb_bn2 OCb_MXN_n2_1 vss sg13_hv_nmos w=0.5u l=0.45u m=1
MOCb_MXN_S2_2_0 OCb_MXN_n1_4 OCb_bbn2 OCb_MXN_n2_2 vss sg13_hv_nmos w=0.5u l=0.45u m=1
MOCb_MXN_S2_2_1 OCb_MXN_n1_5 OCb_bn2 OCb_MXN_n2_2 vss sg13_hv_nmos w=0.5u l=0.45u m=1
MOCb_MXN_S2_3_0 OCb_MXN_n1_6 OCb_bbn2 OCb_MXN_n2_3 vss sg13_hv_nmos w=0.5u l=0.45u m=1
MOCb_MXN_S2_3_1 OCb_MXN_n1_7 OCb_bn2 OCb_MXN_n2_3 vss sg13_hv_nmos w=0.5u l=0.45u m=1
MOCb_MXN_S2_4_0 OCb_MXN_n1_8 OCb_bbn2 OCb_MXN_n2_4 vss sg13_hv_nmos w=0.5u l=0.45u m=1
MOCb_MXN_S2_4_1 OCb_MXN_n1_9 OCb_bn2 OCb_MXN_n2_4 vss sg13_hv_nmos w=0.5u l=0.45u m=1
MOCb_MXN_S2_5_0 OCb_MXN_n1_10 OCb_bbn2 OCb_MXN_n2_5 vss sg13_hv_nmos w=0.5u l=0.45u m=1
MOCb_MXN_S2_5_1 OCb_MXN_n1_11 OCb_bn2 OCb_MXN_n2_5 vss sg13_hv_nmos w=0.5u l=0.45u m=1
MOCb_MXN_S2_6_0 OCb_MXN_n1_12 OCb_bbn2 OCb_MXN_n2_6 vss sg13_hv_nmos w=0.5u l=0.45u m=1
MOCb_MXN_S2_6_1 OCb_MXN_n1_13 OCb_bn2 OCb_MXN_n2_6 vss sg13_hv_nmos w=0.5u l=0.45u m=1
MOCb_MXN_S2_7_0 OCb_MXN_n1_14 OCb_bbn2 OCb_MXN_n2_7 vss sg13_hv_nmos w=0.5u l=0.45u m=1
MOCb_MXN_S2_7_1 OCb_MXN_n1_15 OCb_bn2 OCb_MXN_n2_7 vss sg13_hv_nmos w=0.5u l=0.45u m=1
MOCb_MXN_S2_8_0 OCb_MXN_n1_16 OCb_bbn2 OCb_MXN_n2_8 vss sg13_hv_nmos w=0.5u l=0.45u m=1
MOCb_MXN_S2_8_1 OCb_MXN_n1_17 OCb_bn2 OCb_MXN_n2_8 vss sg13_hv_nmos w=0.5u l=0.45u m=1
MOCb_MXN_S2_9_0 OCb_MXN_n1_18 OCb_bbn2 OCb_MXN_n2_9 vss sg13_hv_nmos w=0.5u l=0.45u m=1
MOCb_MXN_S2_9_1 OCb_MXN_n1_19 OCb_bn2 OCb_MXN_n2_9 vss sg13_hv_nmos w=0.5u l=0.45u m=1
MOCb_MXN_S2_10_0 OCb_MXN_n1_20 OCb_bbn2 OCb_MXN_n2_10 vss sg13_hv_nmos w=0.5u l=0.45u m=1
MOCb_MXN_S2_10_1 OCb_MXN_n1_21 OCb_bn2 OCb_MXN_n2_10 vss sg13_hv_nmos w=0.5u l=0.45u m=1
MOCb_MXN_S2_11_0 OCb_MXN_n1_22 OCb_bbn2 OCb_MXN_n2_11 vss sg13_hv_nmos w=0.5u l=0.45u m=1
MOCb_MXN_S2_11_1 OCb_MXN_n1_23 OCb_bn2 OCb_MXN_n2_11 vss sg13_hv_nmos w=0.5u l=0.45u m=1
MOCb_MXN_S2_12_0 OCb_MXN_n1_24 OCb_bbn2 OCb_MXN_n2_12 vss sg13_hv_nmos w=0.5u l=0.45u m=1
MOCb_MXN_S2_12_1 OCb_MXN_n1_25 OCb_bn2 OCb_MXN_n2_12 vss sg13_hv_nmos w=0.5u l=0.45u m=1
MOCb_MXN_S2_13_0 OCb_MXN_n1_26 OCb_bbn2 OCb_MXN_n2_13 vss sg13_hv_nmos w=0.5u l=0.45u m=1
MOCb_MXN_S2_13_1 OCb_MXN_n1_27 OCb_bn2 OCb_MXN_n2_13 vss sg13_hv_nmos w=0.5u l=0.45u m=1
MOCb_MXN_S2_14_0 OCb_MXN_n1_28 OCb_bbn2 OCb_MXN_n2_14 vss sg13_hv_nmos w=0.5u l=0.45u m=1
MOCb_MXN_S2_14_1 OCb_MXN_n1_29 OCb_bn2 OCb_MXN_n2_14 vss sg13_hv_nmos w=0.5u l=0.45u m=1
MOCb_MXN_S2_15_0 OCb_MXN_n1_30 OCb_bbn2 OCb_MXN_n2_15 vss sg13_hv_nmos w=0.5u l=0.45u m=1
MOCb_MXN_S2_15_1 OCb_MXN_n1_31 OCb_bn2 OCb_MXN_n2_15 vss sg13_hv_nmos w=0.5u l=0.45u m=1
MOCb_MXN_S2_16_0 OCb_MXN_n1_32 OCb_bbn2 OCb_MXN_n2_16 vss sg13_hv_nmos w=0.5u l=0.45u m=1
MOCb_MXN_S2_16_1 OCb_MXN_n1_33 OCb_bn2 OCb_MXN_n2_16 vss sg13_hv_nmos w=0.5u l=0.45u m=1
MOCb_MXN_S2_17_0 OCb_MXN_n1_34 OCb_bbn2 OCb_MXN_n2_17 vss sg13_hv_nmos w=0.5u l=0.45u m=1
MOCb_MXN_S2_17_1 OCb_MXN_n1_35 OCb_bn2 OCb_MXN_n2_17 vss sg13_hv_nmos w=0.5u l=0.45u m=1
MOCb_MXN_S2_18_0 OCb_MXN_n1_36 OCb_bbn2 OCb_MXN_n2_18 vss sg13_hv_nmos w=0.5u l=0.45u m=1
MOCb_MXN_S2_18_1 OCb_MXN_n1_37 OCb_bn2 OCb_MXN_n2_18 vss sg13_hv_nmos w=0.5u l=0.45u m=1
MOCb_MXN_S2_19_0 OCb_MXN_n1_38 OCb_bbn2 OCb_MXN_n2_19 vss sg13_hv_nmos w=0.5u l=0.45u m=1
MOCb_MXN_S2_19_1 OCb_MXN_n1_39 OCb_bn2 OCb_MXN_n2_19 vss sg13_hv_nmos w=0.5u l=0.45u m=1
MOCb_MXN_S2_20_0 OCb_MXN_n1_40 OCb_bbn2 OCb_MXN_n2_20 vss sg13_hv_nmos w=0.5u l=0.45u m=1
MOCb_MXN_S2_20_1 OCb_MXN_n1_41 OCb_bn2 OCb_MXN_n2_20 vss sg13_hv_nmos w=0.5u l=0.45u m=1
MOCb_MXN_S2_21_0 OCb_MXN_n1_42 OCb_bbn2 OCb_MXN_n2_21 vss sg13_hv_nmos w=0.5u l=0.45u m=1
MOCb_MXN_S2_21_1 OCb_MXN_n1_43 OCb_bn2 OCb_MXN_n2_21 vss sg13_hv_nmos w=0.5u l=0.45u m=1
MOCb_MXN_S2_22_0 OCb_MXN_n1_44 OCb_bbn2 OCb_MXN_n2_22 vss sg13_hv_nmos w=0.5u l=0.45u m=1
MOCb_MXN_S2_22_1 OCb_MXN_n1_45 OCb_bn2 OCb_MXN_n2_22 vss sg13_hv_nmos w=0.5u l=0.45u m=1
MOCb_MXN_S2_23_0 OCb_MXN_n1_46 OCb_bbn2 OCb_MXN_n2_23 vss sg13_hv_nmos w=0.5u l=0.45u m=1
MOCb_MXN_S2_23_1 OCb_MXN_n1_47 OCb_bn2 OCb_MXN_n2_23 vss sg13_hv_nmos w=0.5u l=0.45u m=1
MOCb_MXN_S2_24_0 OCb_MXN_n1_48 OCb_bbn2 OCb_MXN_n2_24 vss sg13_hv_nmos w=0.5u l=0.45u m=1
MOCb_MXN_S2_24_1 OCb_MXN_n1_49 OCb_bn2 OCb_MXN_n2_24 vss sg13_hv_nmos w=0.5u l=0.45u m=1
MOCb_MXN_S2_25_0 OCb_MXN_n1_50 OCb_bbn2 OCb_MXN_n2_25 vss sg13_hv_nmos w=0.5u l=0.45u m=1
MOCb_MXN_S2_25_1 OCb_MXN_n1_51 OCb_bn2 OCb_MXN_n2_25 vss sg13_hv_nmos w=0.5u l=0.45u m=1
MOCb_MXN_S2_26_0 OCb_MXN_n1_52 OCb_bbn2 OCb_MXN_n2_26 vss sg13_hv_nmos w=0.5u l=0.45u m=1
MOCb_MXN_S2_26_1 OCb_MXN_n1_53 OCb_bn2 OCb_MXN_n2_26 vss sg13_hv_nmos w=0.5u l=0.45u m=1
MOCb_MXN_S2_27_0 OCb_MXN_n1_54 OCb_bbn2 OCb_MXN_n2_27 vss sg13_hv_nmos w=0.5u l=0.45u m=1
MOCb_MXN_S2_27_1 OCb_MXN_n1_55 OCb_bn2 OCb_MXN_n2_27 vss sg13_hv_nmos w=0.5u l=0.45u m=1
MOCb_MXN_S2_28_0 OCb_MXN_n1_56 OCb_bbn2 OCb_MXN_n2_28 vss sg13_hv_nmos w=0.5u l=0.45u m=1
MOCb_MXN_S2_28_1 OCb_MXN_n1_57 OCb_bn2 OCb_MXN_n2_28 vss sg13_hv_nmos w=0.5u l=0.45u m=1
MOCb_MXN_S2_29_0 OCb_MXN_n1_58 OCb_bbn2 OCb_MXN_n2_29 vss sg13_hv_nmos w=0.5u l=0.45u m=1
MOCb_MXN_S2_29_1 OCb_MXN_n1_59 OCb_bn2 OCb_MXN_n2_29 vss sg13_hv_nmos w=0.5u l=0.45u m=1
MOCb_MXN_S2_30_0 OCb_MXN_n1_60 OCb_bbn2 OCb_MXN_n2_30 vss sg13_hv_nmos w=0.5u l=0.45u m=1
MOCb_MXN_S2_30_1 OCb_MXN_n1_61 OCb_bn2 OCb_MXN_n2_30 vss sg13_hv_nmos w=0.5u l=0.45u m=1
MOCb_MXN_S2_31_0 OCb_MXN_n1_62 OCb_bbn2 OCb_MXN_n2_31 vss sg13_hv_nmos w=0.5u l=0.45u m=1
MOCb_MXN_S2_31_1 OCb_MXN_n1_63 OCb_bn2 OCb_MXN_n2_31 vss sg13_hv_nmos w=0.5u l=0.45u m=1
MOCb_MXN_S3_0_0 OCb_MXN_n2_0 OCb_bbn3 OCb_MXN_n3_0 vss sg13_hv_nmos w=0.5u l=0.45u m=1
MOCb_MXN_S3_0_1 OCb_MXN_n2_1 OCb_bn3 OCb_MXN_n3_0 vss sg13_hv_nmos w=0.5u l=0.45u m=1
MOCb_MXN_S3_1_0 OCb_MXN_n2_2 OCb_bbn3 OCb_MXN_n3_1 vss sg13_hv_nmos w=0.5u l=0.45u m=1
MOCb_MXN_S3_1_1 OCb_MXN_n2_3 OCb_bn3 OCb_MXN_n3_1 vss sg13_hv_nmos w=0.5u l=0.45u m=1
MOCb_MXN_S3_2_0 OCb_MXN_n2_4 OCb_bbn3 OCb_MXN_n3_2 vss sg13_hv_nmos w=0.5u l=0.45u m=1
MOCb_MXN_S3_2_1 OCb_MXN_n2_5 OCb_bn3 OCb_MXN_n3_2 vss sg13_hv_nmos w=0.5u l=0.45u m=1
MOCb_MXN_S3_3_0 OCb_MXN_n2_6 OCb_bbn3 OCb_MXN_n3_3 vss sg13_hv_nmos w=0.5u l=0.45u m=1
MOCb_MXN_S3_3_1 OCb_MXN_n2_7 OCb_bn3 OCb_MXN_n3_3 vss sg13_hv_nmos w=0.5u l=0.45u m=1
MOCb_MXN_S3_4_0 OCb_MXN_n2_8 OCb_bbn3 OCb_MXN_n3_4 vss sg13_hv_nmos w=0.5u l=0.45u m=1
MOCb_MXN_S3_4_1 OCb_MXN_n2_9 OCb_bn3 OCb_MXN_n3_4 vss sg13_hv_nmos w=0.5u l=0.45u m=1
MOCb_MXN_S3_5_0 OCb_MXN_n2_10 OCb_bbn3 OCb_MXN_n3_5 vss sg13_hv_nmos w=0.5u l=0.45u m=1
MOCb_MXN_S3_5_1 OCb_MXN_n2_11 OCb_bn3 OCb_MXN_n3_5 vss sg13_hv_nmos w=0.5u l=0.45u m=1
MOCb_MXN_S3_6_0 OCb_MXN_n2_12 OCb_bbn3 OCb_MXN_n3_6 vss sg13_hv_nmos w=0.5u l=0.45u m=1
MOCb_MXN_S3_6_1 OCb_MXN_n2_13 OCb_bn3 OCb_MXN_n3_6 vss sg13_hv_nmos w=0.5u l=0.45u m=1
MOCb_MXN_S3_7_0 OCb_MXN_n2_14 OCb_bbn3 OCb_MXN_n3_7 vss sg13_hv_nmos w=0.5u l=0.45u m=1
MOCb_MXN_S3_7_1 OCb_MXN_n2_15 OCb_bn3 OCb_MXN_n3_7 vss sg13_hv_nmos w=0.5u l=0.45u m=1
MOCb_MXN_S3_8_0 OCb_MXN_n2_16 OCb_bbn3 OCb_MXN_n3_8 vss sg13_hv_nmos w=0.5u l=0.45u m=1
MOCb_MXN_S3_8_1 OCb_MXN_n2_17 OCb_bn3 OCb_MXN_n3_8 vss sg13_hv_nmos w=0.5u l=0.45u m=1
MOCb_MXN_S3_9_0 OCb_MXN_n2_18 OCb_bbn3 OCb_MXN_n3_9 vss sg13_hv_nmos w=0.5u l=0.45u m=1
MOCb_MXN_S3_9_1 OCb_MXN_n2_19 OCb_bn3 OCb_MXN_n3_9 vss sg13_hv_nmos w=0.5u l=0.45u m=1
MOCb_MXN_S3_10_0 OCb_MXN_n2_20 OCb_bbn3 OCb_MXN_n3_10 vss sg13_hv_nmos w=0.5u l=0.45u m=1
MOCb_MXN_S3_10_1 OCb_MXN_n2_21 OCb_bn3 OCb_MXN_n3_10 vss sg13_hv_nmos w=0.5u l=0.45u m=1
MOCb_MXN_S3_11_0 OCb_MXN_n2_22 OCb_bbn3 OCb_MXN_n3_11 vss sg13_hv_nmos w=0.5u l=0.45u m=1
MOCb_MXN_S3_11_1 OCb_MXN_n2_23 OCb_bn3 OCb_MXN_n3_11 vss sg13_hv_nmos w=0.5u l=0.45u m=1
MOCb_MXN_S3_12_0 OCb_MXN_n2_24 OCb_bbn3 OCb_MXN_n3_12 vss sg13_hv_nmos w=0.5u l=0.45u m=1
MOCb_MXN_S3_12_1 OCb_MXN_n2_25 OCb_bn3 OCb_MXN_n3_12 vss sg13_hv_nmos w=0.5u l=0.45u m=1
MOCb_MXN_S3_13_0 OCb_MXN_n2_26 OCb_bbn3 OCb_MXN_n3_13 vss sg13_hv_nmos w=0.5u l=0.45u m=1
MOCb_MXN_S3_13_1 OCb_MXN_n2_27 OCb_bn3 OCb_MXN_n3_13 vss sg13_hv_nmos w=0.5u l=0.45u m=1
MOCb_MXN_S3_14_0 OCb_MXN_n2_28 OCb_bbn3 OCb_MXN_n3_14 vss sg13_hv_nmos w=0.5u l=0.45u m=1
MOCb_MXN_S3_14_1 OCb_MXN_n2_29 OCb_bn3 OCb_MXN_n3_14 vss sg13_hv_nmos w=0.5u l=0.45u m=1
MOCb_MXN_S3_15_0 OCb_MXN_n2_30 OCb_bbn3 OCb_MXN_n3_15 vss sg13_hv_nmos w=0.5u l=0.45u m=1
MOCb_MXN_S3_15_1 OCb_MXN_n2_31 OCb_bn3 OCb_MXN_n3_15 vss sg13_hv_nmos w=0.5u l=0.45u m=1
MOCb_MXN_S4_0_0 OCb_MXN_n3_0 OCb_bbn4 OCb_MXN_n4_0 vss sg13_hv_nmos w=0.5u l=0.45u m=1
MOCb_MXN_S4_0_1 OCb_MXN_n3_1 OCb_bn4 OCb_MXN_n4_0 vss sg13_hv_nmos w=0.5u l=0.45u m=1
MOCb_MXN_S4_1_0 OCb_MXN_n3_2 OCb_bbn4 OCb_MXN_n4_1 vss sg13_hv_nmos w=0.5u l=0.45u m=1
MOCb_MXN_S4_1_1 OCb_MXN_n3_3 OCb_bn4 OCb_MXN_n4_1 vss sg13_hv_nmos w=0.5u l=0.45u m=1
MOCb_MXN_S4_2_0 OCb_MXN_n3_4 OCb_bbn4 OCb_MXN_n4_2 vss sg13_hv_nmos w=0.5u l=0.45u m=1
MOCb_MXN_S4_2_1 OCb_MXN_n3_5 OCb_bn4 OCb_MXN_n4_2 vss sg13_hv_nmos w=0.5u l=0.45u m=1
MOCb_MXN_S4_3_0 OCb_MXN_n3_6 OCb_bbn4 OCb_MXN_n4_3 vss sg13_hv_nmos w=0.5u l=0.45u m=1
MOCb_MXN_S4_3_1 OCb_MXN_n3_7 OCb_bn4 OCb_MXN_n4_3 vss sg13_hv_nmos w=0.5u l=0.45u m=1
MOCb_MXN_S4_4_0 OCb_MXN_n3_8 OCb_bbn4 OCb_MXN_n4_4 vss sg13_hv_nmos w=0.5u l=0.45u m=1
MOCb_MXN_S4_4_1 OCb_MXN_n3_9 OCb_bn4 OCb_MXN_n4_4 vss sg13_hv_nmos w=0.5u l=0.45u m=1
MOCb_MXN_S4_5_0 OCb_MXN_n3_10 OCb_bbn4 OCb_MXN_n4_5 vss sg13_hv_nmos w=0.5u l=0.45u m=1
MOCb_MXN_S4_5_1 OCb_MXN_n3_11 OCb_bn4 OCb_MXN_n4_5 vss sg13_hv_nmos w=0.5u l=0.45u m=1
MOCb_MXN_S4_6_0 OCb_MXN_n3_12 OCb_bbn4 OCb_MXN_n4_6 vss sg13_hv_nmos w=0.5u l=0.45u m=1
MOCb_MXN_S4_6_1 OCb_MXN_n3_13 OCb_bn4 OCb_MXN_n4_6 vss sg13_hv_nmos w=0.5u l=0.45u m=1
MOCb_MXN_S4_7_0 OCb_MXN_n3_14 OCb_bbn4 OCb_MXN_n4_7 vss sg13_hv_nmos w=0.5u l=0.45u m=1
MOCb_MXN_S4_7_1 OCb_MXN_n3_15 OCb_bn4 OCb_MXN_n4_7 vss sg13_hv_nmos w=0.5u l=0.45u m=1
MOCb_MXN_S5_0_0 OCb_MXN_n4_0 OCb_bbn5 OCb_MXN_n5_0 vss sg13_hv_nmos w=0.5u l=0.45u m=1
MOCb_MXN_S5_0_1 OCb_MXN_n4_1 OCb_bn5 OCb_MXN_n5_0 vss sg13_hv_nmos w=0.5u l=0.45u m=1
MOCb_MXN_S5_1_0 OCb_MXN_n4_2 OCb_bbn5 OCb_MXN_n5_1 vss sg13_hv_nmos w=0.5u l=0.45u m=1
MOCb_MXN_S5_1_1 OCb_MXN_n4_3 OCb_bn5 OCb_MXN_n5_1 vss sg13_hv_nmos w=0.5u l=0.45u m=1
MOCb_MXN_S5_2_0 OCb_MXN_n4_4 OCb_bbn5 OCb_MXN_n5_2 vss sg13_hv_nmos w=0.5u l=0.45u m=1
MOCb_MXN_S5_2_1 OCb_MXN_n4_5 OCb_bn5 OCb_MXN_n5_2 vss sg13_hv_nmos w=0.5u l=0.45u m=1
MOCb_MXN_S5_3_0 OCb_MXN_n4_6 OCb_bbn5 OCb_MXN_n5_3 vss sg13_hv_nmos w=0.5u l=0.45u m=1
MOCb_MXN_S5_3_1 OCb_MXN_n4_7 OCb_bn5 OCb_MXN_n5_3 vss sg13_hv_nmos w=0.5u l=0.45u m=1
MOCb_MXN_S6_0_0 OCb_MXN_n5_0 OCb_bbn6 OCb_MXN_n6_0 vss sg13_hv_nmos w=0.5u l=0.45u m=1
MOCb_MXN_S6_0_1 OCb_MXN_n5_1 OCb_bn6 OCb_MXN_n6_0 vss sg13_hv_nmos w=0.5u l=0.45u m=1
MOCb_MXN_S6_1_0 OCb_MXN_n5_2 OCb_bbn6 OCb_MXN_n6_1 vss sg13_hv_nmos w=0.5u l=0.45u m=1
MOCb_MXN_S6_1_1 OCb_MXN_n5_3 OCb_bn6 OCb_MXN_n6_1 vss sg13_hv_nmos w=0.5u l=0.45u m=1
MOCb_MXN_S7_0_0 OCb_MXN_n6_0 OCb_bbn7 OCb_refn vss sg13_hv_nmos w=0.5u l=0.45u m=1
MOCb_MXN_S7_0_1 OCb_MXN_n6_1 OCb_bn7 OCb_refn vss sg13_hv_nmos w=0.5u l=0.45u m=1
MOCb_CMP_MBN ibias_ob ibias_ob vss vss sg13_hv_nmos w=4u l=1u m=1
MOCb_CMP_MB2 OCb_CMP_vbp ibias_ob vss vss sg13_hv_nmos w=4u l=1u m=1
MOCb_CMP_MBP OCb_CMP_vbp OCb_CMP_vbp vdda vdda sg13_hv_pmos w=4u l=2u m=1
MOCb_CMP_MTA_m0 OCb_CMP_ta OCb_CMP_vbp vdda vdda sg13_hv_pmos w=4u l=2u m=1
MOCb_CMP_MTA_m1 OCb_CMP_ta OCb_CMP_vbp vdda vdda sg13_hv_pmos w=4u l=2u m=1
MOCb_CMP_MTA_m2 OCb_CMP_ta OCb_CMP_vbp vdda vdda sg13_hv_pmos w=4u l=2u m=1
MOCb_CMP_MTA_m3 OCb_CMP_ta OCb_CMP_vbp vdda vdda sg13_hv_pmos w=4u l=2u m=1
MOCb_CMP_MTA_m4 OCb_CMP_ta OCb_CMP_vbp vdda vdda sg13_hv_pmos w=4u l=2u m=1
MOCb_CMP_MTA_m5 OCb_CMP_ta OCb_CMP_vbp vdda vdda sg13_hv_pmos w=4u l=2u m=1
MOCb_CMP_MTA_m6 OCb_CMP_ta OCb_CMP_vbp vdda vdda sg13_hv_pmos w=4u l=2u m=1
MOCb_CMP_MTA_m7 OCb_CMP_ta OCb_CMP_vbp vdda vdda sg13_hv_pmos w=4u l=2u m=1
MOCb_CMP_MTB_m0 OCb_CMP_tb OCb_CMP_vbp vdda vdda sg13_hv_pmos w=4u l=2u m=1
MOCb_CMP_MTB_m1 OCb_CMP_tb OCb_CMP_vbp vdda vdda sg13_hv_pmos w=4u l=2u m=1
MOCb_CMP_MTB_m2 OCb_CMP_tb OCb_CMP_vbp vdda vdda sg13_hv_pmos w=4u l=2u m=1
MOCb_CMP_MTB_m3 OCb_CMP_tb OCb_CMP_vbp vdda vdda sg13_hv_pmos w=4u l=2u m=1
MOCb_CMP_MTB_m4 OCb_CMP_tb OCb_CMP_vbp vdda vdda sg13_hv_pmos w=4u l=2u m=1
MOCb_CMP_MTB_m5 OCb_CMP_tb OCb_CMP_vbp vdda vdda sg13_hv_pmos w=4u l=2u m=1
MOCb_CMP_MTB_m6 OCb_CMP_tb OCb_CMP_vbp vdda vdda sg13_hv_pmos w=4u l=2u m=1
MOCb_CMP_MTB_m7 OCb_CMP_tb OCb_CMP_vbp vdda vdda sg13_hv_pmos w=4u l=2u m=1
MOCb_CMP_MA1 OCb_CMP_d1 outb_p OCb_CMP_sa1 OCb_CMP_ta sg13_hv_pmos w=20u l=2u m=1
MOCb_CMP_MA2 OCb_CMP_d2 outb_n OCb_CMP_sa2 OCb_CMP_ta sg13_hv_pmos w=20u l=2u m=1
ROCb_CMP_RA1 OCb_CMP_ta OCb_CMP_sa1 vss rppd w=2u l=308u b=0 m=1
ROCb_CMP_RA2 OCb_CMP_ta OCb_CMP_sa2 vss rppd w=2u l=308u b=0 m=1
MOCb_CMP_MB1 OCb_CMP_d1 OCb_refn OCb_CMP_sb1 OCb_CMP_tb sg13_hv_pmos w=20u l=2u m=1
MOCb_CMP_MB2I OCb_CMP_d2 OCb_refp OCb_CMP_sb2 OCb_CMP_tb sg13_hv_pmos w=20u l=2u m=1
ROCb_CMP_RB1 OCb_CMP_tb OCb_CMP_sb1 vss rppd w=2u l=308u b=0 m=1
ROCb_CMP_RB2 OCb_CMP_tb OCb_CMP_sb2 vss rppd w=2u l=308u b=0 m=1
MOCb_CMP_ML1 OCb_CMP_d1 OCb_CMP_d1 vss vss sg13_hv_nmos w=40u l=10u m=1
MOCb_CMP_ML2 OCb_CMP_d2 OCb_CMP_d1 vss vss sg13_hv_nmos w=40u l=10u m=1
MOCb_CMP_MG OCb_CMP_o1 OCb_CMP_d2 vss vss sg13_hv_nmos w=2u l=2u m=1
MOCb_CMP_MGL_m0 OCb_CMP_o1 OCb_CMP_vbp vdda vdda sg13_hv_pmos w=4u l=2u m=1
MOCb_CMP_MGL_m1 OCb_CMP_o1 OCb_CMP_vbp vdda vdda sg13_hv_pmos w=4u l=2u m=1
MOCb_CMP_MI1P OCb_CMP_o2 OCb_CMP_o1 vdda vdda sg13_hv_pmos w=2u l=0.5u m=1
MOCb_CMP_MI1N OCb_CMP_o2 OCb_CMP_o1 vss vss sg13_hv_nmos w=1u l=0.45u m=1
MOCb_CMP_MH1a OCb_CMP_hn1 OCb_CMP_vbp vdda vdda sg13_hv_pmos w=0.5u l=8u m=1
MOCb_CMP_MH1b OCb_CMP_hn2 OCb_CMP_vbp OCb_CMP_hn1 vdda sg13_hv_pmos w=0.5u l=8u m=1
MOCb_CMP_MH1c OCb_CMP_hs OCb_CMP_vbp OCb_CMP_hn2 vdda sg13_hv_pmos w=0.5u l=8u m=1
MOCb_CMP_MH2 OCb_CMP_d2 OCb_CMP_o1 OCb_CMP_hs vdda sg13_hv_pmos w=1u l=0.5u m=1
MOCb_CMP_MH3 OCb_CMP_d1 OCb_CMP_o2 OCb_CMP_hs vdda sg13_hv_pmos w=1u l=0.5u m=1
MOCb_CMP_MD1P OCb_CMP_o3 OCb_CMP_o2 vdd vdd sg13_hv_pmos w=2u l=0.5u m=1
MOCb_CMP_MD1N OCb_CMP_o3 OCb_CMP_o2 vss vss sg13_hv_nmos w=1u l=0.45u m=1
MOCb_CMP_MD2P oc_b OCb_CMP_o3 vdd vdd sg13_lv_pmos w=1u l=0.13u m=1
MOCb_CMP_MD2N oc_b OCb_CMP_o3 vss vss sg13_lv_nmos w=0.5u l=0.13u m=1
MNGb_LSP0_MIP NGb_LSP0_inb nb_p0 vdd vdd sg13_lv_pmos w=1u l=0.13u m=1
MNGb_LSP0_MIN NGb_LSP0_inb nb_p0 vss vss sg13_lv_nmos w=0.5u l=0.13u m=1
MNGb_LSP0_MN1 NGb_LSP0_a nb_p0 vss vss sg13_hv_nmos w=4u l=0.45u m=1
MNGb_LSP0_MN2 NGb_LSP0_b NGb_LSP0_inb vss vss sg13_hv_nmos w=4u l=0.45u m=1
MNGb_LSP0_MP1 NGb_LSP0_a NGb_LSP0_b vdda vdda sg13_hv_pmos w=0.6u l=0.5u m=1
MNGb_LSP0_MP2 NGb_LSP0_b NGb_LSP0_a vdda vdda sg13_hv_pmos w=0.6u l=0.5u m=1
MNGb_LSP0_MB1P NGb_bbp0 NGb_LSP0_b vdda vdda sg13_hv_pmos w=2u l=0.5u m=1
MNGb_LSP0_MB1N NGb_bbp0 NGb_LSP0_b vss vss sg13_hv_nmos w=1u l=0.45u m=1
MNGb_LSP0_MB2P NGb_bp0 NGb_bbp0 vdda vdda sg13_hv_pmos w=2u l=0.5u m=1
MNGb_LSP0_MB2N NGb_bp0 NGb_bbp0 vss vss sg13_hv_nmos w=1u l=0.45u m=1
MNGb_LSN0_MIP NGb_LSN0_inb nb_n0 vdd vdd sg13_lv_pmos w=1u l=0.13u m=1
MNGb_LSN0_MIN NGb_LSN0_inb nb_n0 vss vss sg13_lv_nmos w=0.5u l=0.13u m=1
MNGb_LSN0_MN1 NGb_LSN0_a nb_n0 vss vss sg13_hv_nmos w=4u l=0.45u m=1
MNGb_LSN0_MN2 NGb_LSN0_b NGb_LSN0_inb vss vss sg13_hv_nmos w=4u l=0.45u m=1
MNGb_LSN0_MP1 NGb_LSN0_a NGb_LSN0_b vdda vdda sg13_hv_pmos w=0.6u l=0.5u m=1
MNGb_LSN0_MP2 NGb_LSN0_b NGb_LSN0_a vdda vdda sg13_hv_pmos w=0.6u l=0.5u m=1
MNGb_LSN0_MB1P NGb_bbn0 NGb_LSN0_b vdda vdda sg13_hv_pmos w=2u l=0.5u m=1
MNGb_LSN0_MB1N NGb_bbn0 NGb_LSN0_b vss vss sg13_hv_nmos w=1u l=0.45u m=1
MNGb_LSN0_MB2P NGb_bn0 NGb_bbn0 vdda vdda sg13_hv_pmos w=2u l=0.5u m=1
MNGb_LSN0_MB2N NGb_bn0 NGb_bbn0 vss vss sg13_hv_nmos w=1u l=0.45u m=1
MNGb_LSP1_MIP NGb_LSP1_inb nb_p1 vdd vdd sg13_lv_pmos w=1u l=0.13u m=1
MNGb_LSP1_MIN NGb_LSP1_inb nb_p1 vss vss sg13_lv_nmos w=0.5u l=0.13u m=1
MNGb_LSP1_MN1 NGb_LSP1_a nb_p1 vss vss sg13_hv_nmos w=4u l=0.45u m=1
MNGb_LSP1_MN2 NGb_LSP1_b NGb_LSP1_inb vss vss sg13_hv_nmos w=4u l=0.45u m=1
MNGb_LSP1_MP1 NGb_LSP1_a NGb_LSP1_b vdda vdda sg13_hv_pmos w=0.6u l=0.5u m=1
MNGb_LSP1_MP2 NGb_LSP1_b NGb_LSP1_a vdda vdda sg13_hv_pmos w=0.6u l=0.5u m=1
MNGb_LSP1_MB1P NGb_bbp1 NGb_LSP1_b vdda vdda sg13_hv_pmos w=2u l=0.5u m=1
MNGb_LSP1_MB1N NGb_bbp1 NGb_LSP1_b vss vss sg13_hv_nmos w=1u l=0.45u m=1
MNGb_LSP1_MB2P NGb_bp1 NGb_bbp1 vdda vdda sg13_hv_pmos w=2u l=0.5u m=1
MNGb_LSP1_MB2N NGb_bp1 NGb_bbp1 vss vss sg13_hv_nmos w=1u l=0.45u m=1
MNGb_LSN1_MIP NGb_LSN1_inb nb_n1 vdd vdd sg13_lv_pmos w=1u l=0.13u m=1
MNGb_LSN1_MIN NGb_LSN1_inb nb_n1 vss vss sg13_lv_nmos w=0.5u l=0.13u m=1
MNGb_LSN1_MN1 NGb_LSN1_a nb_n1 vss vss sg13_hv_nmos w=4u l=0.45u m=1
MNGb_LSN1_MN2 NGb_LSN1_b NGb_LSN1_inb vss vss sg13_hv_nmos w=4u l=0.45u m=1
MNGb_LSN1_MP1 NGb_LSN1_a NGb_LSN1_b vdda vdda sg13_hv_pmos w=0.6u l=0.5u m=1
MNGb_LSN1_MP2 NGb_LSN1_b NGb_LSN1_a vdda vdda sg13_hv_pmos w=0.6u l=0.5u m=1
MNGb_LSN1_MB1P NGb_bbn1 NGb_LSN1_b vdda vdda sg13_hv_pmos w=2u l=0.5u m=1
MNGb_LSN1_MB1N NGb_bbn1 NGb_LSN1_b vss vss sg13_hv_nmos w=1u l=0.45u m=1
MNGb_LSN1_MB2P NGb_bn1 NGb_bbn1 vdda vdda sg13_hv_pmos w=2u l=0.5u m=1
MNGb_LSN1_MB2N NGb_bn1 NGb_bbn1 vss vss sg13_hv_nmos w=1u l=0.45u m=1
MNGb_LSP2_MIP NGb_LSP2_inb nb_p2 vdd vdd sg13_lv_pmos w=1u l=0.13u m=1
MNGb_LSP2_MIN NGb_LSP2_inb nb_p2 vss vss sg13_lv_nmos w=0.5u l=0.13u m=1
MNGb_LSP2_MN1 NGb_LSP2_a nb_p2 vss vss sg13_hv_nmos w=4u l=0.45u m=1
MNGb_LSP2_MN2 NGb_LSP2_b NGb_LSP2_inb vss vss sg13_hv_nmos w=4u l=0.45u m=1
MNGb_LSP2_MP1 NGb_LSP2_a NGb_LSP2_b vdda vdda sg13_hv_pmos w=0.6u l=0.5u m=1
MNGb_LSP2_MP2 NGb_LSP2_b NGb_LSP2_a vdda vdda sg13_hv_pmos w=0.6u l=0.5u m=1
MNGb_LSP2_MB1P NGb_bbp2 NGb_LSP2_b vdda vdda sg13_hv_pmos w=2u l=0.5u m=1
MNGb_LSP2_MB1N NGb_bbp2 NGb_LSP2_b vss vss sg13_hv_nmos w=1u l=0.45u m=1
MNGb_LSP2_MB2P NGb_bp2 NGb_bbp2 vdda vdda sg13_hv_pmos w=2u l=0.5u m=1
MNGb_LSP2_MB2N NGb_bp2 NGb_bbp2 vss vss sg13_hv_nmos w=1u l=0.45u m=1
MNGb_LSN2_MIP NGb_LSN2_inb nb_n2 vdd vdd sg13_lv_pmos w=1u l=0.13u m=1
MNGb_LSN2_MIN NGb_LSN2_inb nb_n2 vss vss sg13_lv_nmos w=0.5u l=0.13u m=1
MNGb_LSN2_MN1 NGb_LSN2_a nb_n2 vss vss sg13_hv_nmos w=4u l=0.45u m=1
MNGb_LSN2_MN2 NGb_LSN2_b NGb_LSN2_inb vss vss sg13_hv_nmos w=4u l=0.45u m=1
MNGb_LSN2_MP1 NGb_LSN2_a NGb_LSN2_b vdda vdda sg13_hv_pmos w=0.6u l=0.5u m=1
MNGb_LSN2_MP2 NGb_LSN2_b NGb_LSN2_a vdda vdda sg13_hv_pmos w=0.6u l=0.5u m=1
MNGb_LSN2_MB1P NGb_bbn2 NGb_LSN2_b vdda vdda sg13_hv_pmos w=2u l=0.5u m=1
MNGb_LSN2_MB1N NGb_bbn2 NGb_LSN2_b vss vss sg13_hv_nmos w=1u l=0.45u m=1
MNGb_LSN2_MB2P NGb_bn2 NGb_bbn2 vdda vdda sg13_hv_pmos w=2u l=0.5u m=1
MNGb_LSN2_MB2N NGb_bn2 NGb_bbn2 vss vss sg13_hv_nmos w=1u l=0.45u m=1
MNGb_LSP3_MIP NGb_LSP3_inb nb_p3 vdd vdd sg13_lv_pmos w=1u l=0.13u m=1
MNGb_LSP3_MIN NGb_LSP3_inb nb_p3 vss vss sg13_lv_nmos w=0.5u l=0.13u m=1
MNGb_LSP3_MN1 NGb_LSP3_a nb_p3 vss vss sg13_hv_nmos w=4u l=0.45u m=1
MNGb_LSP3_MN2 NGb_LSP3_b NGb_LSP3_inb vss vss sg13_hv_nmos w=4u l=0.45u m=1
MNGb_LSP3_MP1 NGb_LSP3_a NGb_LSP3_b vdda vdda sg13_hv_pmos w=0.6u l=0.5u m=1
MNGb_LSP3_MP2 NGb_LSP3_b NGb_LSP3_a vdda vdda sg13_hv_pmos w=0.6u l=0.5u m=1
MNGb_LSP3_MB1P NGb_bbp3 NGb_LSP3_b vdda vdda sg13_hv_pmos w=2u l=0.5u m=1
MNGb_LSP3_MB1N NGb_bbp3 NGb_LSP3_b vss vss sg13_hv_nmos w=1u l=0.45u m=1
MNGb_LSP3_MB2P NGb_bp3 NGb_bbp3 vdda vdda sg13_hv_pmos w=2u l=0.5u m=1
MNGb_LSP3_MB2N NGb_bp3 NGb_bbp3 vss vss sg13_hv_nmos w=1u l=0.45u m=1
MNGb_LSN3_MIP NGb_LSN3_inb nb_n3 vdd vdd sg13_lv_pmos w=1u l=0.13u m=1
MNGb_LSN3_MIN NGb_LSN3_inb nb_n3 vss vss sg13_lv_nmos w=0.5u l=0.13u m=1
MNGb_LSN3_MN1 NGb_LSN3_a nb_n3 vss vss sg13_hv_nmos w=4u l=0.45u m=1
MNGb_LSN3_MN2 NGb_LSN3_b NGb_LSN3_inb vss vss sg13_hv_nmos w=4u l=0.45u m=1
MNGb_LSN3_MP1 NGb_LSN3_a NGb_LSN3_b vdda vdda sg13_hv_pmos w=0.6u l=0.5u m=1
MNGb_LSN3_MP2 NGb_LSN3_b NGb_LSN3_a vdda vdda sg13_hv_pmos w=0.6u l=0.5u m=1
MNGb_LSN3_MB1P NGb_bbn3 NGb_LSN3_b vdda vdda sg13_hv_pmos w=2u l=0.5u m=1
MNGb_LSN3_MB1N NGb_bbn3 NGb_LSN3_b vss vss sg13_hv_nmos w=1u l=0.45u m=1
MNGb_LSN3_MB2P NGb_bn3 NGb_bbn3 vdda vdda sg13_hv_pmos w=2u l=0.5u m=1
MNGb_LSN3_MB2N NGb_bn3 NGb_bbn3 vss vss sg13_hv_nmos w=1u l=0.45u m=1
MNGb_LSP4_MIP NGb_LSP4_inb nb_p4 vdd vdd sg13_lv_pmos w=1u l=0.13u m=1
MNGb_LSP4_MIN NGb_LSP4_inb nb_p4 vss vss sg13_lv_nmos w=0.5u l=0.13u m=1
MNGb_LSP4_MN1 NGb_LSP4_a nb_p4 vss vss sg13_hv_nmos w=4u l=0.45u m=1
MNGb_LSP4_MN2 NGb_LSP4_b NGb_LSP4_inb vss vss sg13_hv_nmos w=4u l=0.45u m=1
MNGb_LSP4_MP1 NGb_LSP4_a NGb_LSP4_b vdda vdda sg13_hv_pmos w=0.6u l=0.5u m=1
MNGb_LSP4_MP2 NGb_LSP4_b NGb_LSP4_a vdda vdda sg13_hv_pmos w=0.6u l=0.5u m=1
MNGb_LSP4_MB1P NGb_bbp4 NGb_LSP4_b vdda vdda sg13_hv_pmos w=2u l=0.5u m=1
MNGb_LSP4_MB1N NGb_bbp4 NGb_LSP4_b vss vss sg13_hv_nmos w=1u l=0.45u m=1
MNGb_LSP4_MB2P NGb_bp4 NGb_bbp4 vdda vdda sg13_hv_pmos w=2u l=0.5u m=1
MNGb_LSP4_MB2N NGb_bp4 NGb_bbp4 vss vss sg13_hv_nmos w=1u l=0.45u m=1
MNGb_LSN4_MIP NGb_LSN4_inb nb_n4 vdd vdd sg13_lv_pmos w=1u l=0.13u m=1
MNGb_LSN4_MIN NGb_LSN4_inb nb_n4 vss vss sg13_lv_nmos w=0.5u l=0.13u m=1
MNGb_LSN4_MN1 NGb_LSN4_a nb_n4 vss vss sg13_hv_nmos w=4u l=0.45u m=1
MNGb_LSN4_MN2 NGb_LSN4_b NGb_LSN4_inb vss vss sg13_hv_nmos w=4u l=0.45u m=1
MNGb_LSN4_MP1 NGb_LSN4_a NGb_LSN4_b vdda vdda sg13_hv_pmos w=0.6u l=0.5u m=1
MNGb_LSN4_MP2 NGb_LSN4_b NGb_LSN4_a vdda vdda sg13_hv_pmos w=0.6u l=0.5u m=1
MNGb_LSN4_MB1P NGb_bbn4 NGb_LSN4_b vdda vdda sg13_hv_pmos w=2u l=0.5u m=1
MNGb_LSN4_MB1N NGb_bbn4 NGb_LSN4_b vss vss sg13_hv_nmos w=1u l=0.45u m=1
MNGb_LSN4_MB2P NGb_bn4 NGb_bbn4 vdda vdda sg13_hv_pmos w=2u l=0.5u m=1
MNGb_LSN4_MB2N NGb_bn4 NGb_bbn4 vss vss sg13_hv_nmos w=1u l=0.45u m=1
MNGb_LSP5_MIP NGb_LSP5_inb nb_p5 vdd vdd sg13_lv_pmos w=1u l=0.13u m=1
MNGb_LSP5_MIN NGb_LSP5_inb nb_p5 vss vss sg13_lv_nmos w=0.5u l=0.13u m=1
MNGb_LSP5_MN1 NGb_LSP5_a nb_p5 vss vss sg13_hv_nmos w=4u l=0.45u m=1
MNGb_LSP5_MN2 NGb_LSP5_b NGb_LSP5_inb vss vss sg13_hv_nmos w=4u l=0.45u m=1
MNGb_LSP5_MP1 NGb_LSP5_a NGb_LSP5_b vdda vdda sg13_hv_pmos w=0.6u l=0.5u m=1
MNGb_LSP5_MP2 NGb_LSP5_b NGb_LSP5_a vdda vdda sg13_hv_pmos w=0.6u l=0.5u m=1
MNGb_LSP5_MB1P NGb_bbp5 NGb_LSP5_b vdda vdda sg13_hv_pmos w=2u l=0.5u m=1
MNGb_LSP5_MB1N NGb_bbp5 NGb_LSP5_b vss vss sg13_hv_nmos w=1u l=0.45u m=1
MNGb_LSP5_MB2P NGb_bp5 NGb_bbp5 vdda vdda sg13_hv_pmos w=2u l=0.5u m=1
MNGb_LSP5_MB2N NGb_bp5 NGb_bbp5 vss vss sg13_hv_nmos w=1u l=0.45u m=1
MNGb_LSN5_MIP NGb_LSN5_inb nb_n5 vdd vdd sg13_lv_pmos w=1u l=0.13u m=1
MNGb_LSN5_MIN NGb_LSN5_inb nb_n5 vss vss sg13_lv_nmos w=0.5u l=0.13u m=1
MNGb_LSN5_MN1 NGb_LSN5_a nb_n5 vss vss sg13_hv_nmos w=4u l=0.45u m=1
MNGb_LSN5_MN2 NGb_LSN5_b NGb_LSN5_inb vss vss sg13_hv_nmos w=4u l=0.45u m=1
MNGb_LSN5_MP1 NGb_LSN5_a NGb_LSN5_b vdda vdda sg13_hv_pmos w=0.6u l=0.5u m=1
MNGb_LSN5_MP2 NGb_LSN5_b NGb_LSN5_a vdda vdda sg13_hv_pmos w=0.6u l=0.5u m=1
MNGb_LSN5_MB1P NGb_bbn5 NGb_LSN5_b vdda vdda sg13_hv_pmos w=2u l=0.5u m=1
MNGb_LSN5_MB1N NGb_bbn5 NGb_LSN5_b vss vss sg13_hv_nmos w=1u l=0.45u m=1
MNGb_LSN5_MB2P NGb_bn5 NGb_bbn5 vdda vdda sg13_hv_pmos w=2u l=0.5u m=1
MNGb_LSN5_MB2N NGb_bn5 NGb_bbn5 vss vss sg13_hv_nmos w=1u l=0.45u m=1
MNGb_LSP6_MIP NGb_LSP6_inb nb_p6 vdd vdd sg13_lv_pmos w=1u l=0.13u m=1
MNGb_LSP6_MIN NGb_LSP6_inb nb_p6 vss vss sg13_lv_nmos w=0.5u l=0.13u m=1
MNGb_LSP6_MN1 NGb_LSP6_a nb_p6 vss vss sg13_hv_nmos w=4u l=0.45u m=1
MNGb_LSP6_MN2 NGb_LSP6_b NGb_LSP6_inb vss vss sg13_hv_nmos w=4u l=0.45u m=1
MNGb_LSP6_MP1 NGb_LSP6_a NGb_LSP6_b vdda vdda sg13_hv_pmos w=0.6u l=0.5u m=1
MNGb_LSP6_MP2 NGb_LSP6_b NGb_LSP6_a vdda vdda sg13_hv_pmos w=0.6u l=0.5u m=1
MNGb_LSP6_MB1P NGb_bbp6 NGb_LSP6_b vdda vdda sg13_hv_pmos w=2u l=0.5u m=1
MNGb_LSP6_MB1N NGb_bbp6 NGb_LSP6_b vss vss sg13_hv_nmos w=1u l=0.45u m=1
MNGb_LSP6_MB2P NGb_bp6 NGb_bbp6 vdda vdda sg13_hv_pmos w=2u l=0.5u m=1
MNGb_LSP6_MB2N NGb_bp6 NGb_bbp6 vss vss sg13_hv_nmos w=1u l=0.45u m=1
MNGb_LSN6_MIP NGb_LSN6_inb nb_n6 vdd vdd sg13_lv_pmos w=1u l=0.13u m=1
MNGb_LSN6_MIN NGb_LSN6_inb nb_n6 vss vss sg13_lv_nmos w=0.5u l=0.13u m=1
MNGb_LSN6_MN1 NGb_LSN6_a nb_n6 vss vss sg13_hv_nmos w=4u l=0.45u m=1
MNGb_LSN6_MN2 NGb_LSN6_b NGb_LSN6_inb vss vss sg13_hv_nmos w=4u l=0.45u m=1
MNGb_LSN6_MP1 NGb_LSN6_a NGb_LSN6_b vdda vdda sg13_hv_pmos w=0.6u l=0.5u m=1
MNGb_LSN6_MP2 NGb_LSN6_b NGb_LSN6_a vdda vdda sg13_hv_pmos w=0.6u l=0.5u m=1
MNGb_LSN6_MB1P NGb_bbn6 NGb_LSN6_b vdda vdda sg13_hv_pmos w=2u l=0.5u m=1
MNGb_LSN6_MB1N NGb_bbn6 NGb_LSN6_b vss vss sg13_hv_nmos w=1u l=0.45u m=1
MNGb_LSN6_MB2P NGb_bn6 NGb_bbn6 vdda vdda sg13_hv_pmos w=2u l=0.5u m=1
MNGb_LSN6_MB2N NGb_bn6 NGb_bbn6 vss vss sg13_hv_nmos w=1u l=0.45u m=1
MNGb_LSP7_MIP NGb_LSP7_inb nb_p7 vdd vdd sg13_lv_pmos w=1u l=0.13u m=1
MNGb_LSP7_MIN NGb_LSP7_inb nb_p7 vss vss sg13_lv_nmos w=0.5u l=0.13u m=1
MNGb_LSP7_MN1 NGb_LSP7_a nb_p7 vss vss sg13_hv_nmos w=4u l=0.45u m=1
MNGb_LSP7_MN2 NGb_LSP7_b NGb_LSP7_inb vss vss sg13_hv_nmos w=4u l=0.45u m=1
MNGb_LSP7_MP1 NGb_LSP7_a NGb_LSP7_b vdda vdda sg13_hv_pmos w=0.6u l=0.5u m=1
MNGb_LSP7_MP2 NGb_LSP7_b NGb_LSP7_a vdda vdda sg13_hv_pmos w=0.6u l=0.5u m=1
MNGb_LSP7_MB1P NGb_bbp7 NGb_LSP7_b vdda vdda sg13_hv_pmos w=2u l=0.5u m=1
MNGb_LSP7_MB1N NGb_bbp7 NGb_LSP7_b vss vss sg13_hv_nmos w=1u l=0.45u m=1
MNGb_LSP7_MB2P NGb_bp7 NGb_bbp7 vdda vdda sg13_hv_pmos w=2u l=0.5u m=1
MNGb_LSP7_MB2N NGb_bp7 NGb_bbp7 vss vss sg13_hv_nmos w=1u l=0.45u m=1
MNGb_LSN7_MIP NGb_LSN7_inb nb_n7 vdd vdd sg13_lv_pmos w=1u l=0.13u m=1
MNGb_LSN7_MIN NGb_LSN7_inb nb_n7 vss vss sg13_lv_nmos w=0.5u l=0.13u m=1
MNGb_LSN7_MN1 NGb_LSN7_a nb_n7 vss vss sg13_hv_nmos w=4u l=0.45u m=1
MNGb_LSN7_MN2 NGb_LSN7_b NGb_LSN7_inb vss vss sg13_hv_nmos w=4u l=0.45u m=1
MNGb_LSN7_MP1 NGb_LSN7_a NGb_LSN7_b vdda vdda sg13_hv_pmos w=0.6u l=0.5u m=1
MNGb_LSN7_MP2 NGb_LSN7_b NGb_LSN7_a vdda vdda sg13_hv_pmos w=0.6u l=0.5u m=1
MNGb_LSN7_MB1P NGb_bbn7 NGb_LSN7_b vdda vdda sg13_hv_pmos w=2u l=0.5u m=1
MNGb_LSN7_MB1N NGb_bbn7 NGb_LSN7_b vss vss sg13_hv_nmos w=1u l=0.45u m=1
MNGb_LSN7_MB2P NGb_bn7 NGb_bbn7 vdda vdda sg13_hv_pmos w=2u l=0.5u m=1
MNGb_LSN7_MB2N NGb_bn7 NGb_bbn7 vss vss sg13_hv_nmos w=1u l=0.45u m=1
MNGb_MXP_S0_0_0 vss NGb_bbp0 NGb_MXP_n0_0 vss sg13_hv_nmos w=0.5u l=0.45u m=1
MNGb_MXP_S0_0_1 t1 NGb_bp0 NGb_MXP_n0_0 vss sg13_hv_nmos w=0.5u l=0.45u m=1
MNGb_MXP_S0_1_0 t2 NGb_bbp0 NGb_MXP_n0_1 vss sg13_hv_nmos w=0.5u l=0.45u m=1
MNGb_MXP_S0_1_1 t3 NGb_bp0 NGb_MXP_n0_1 vss sg13_hv_nmos w=0.5u l=0.45u m=1
MNGb_MXP_S0_2_0 t4 NGb_bbp0 NGb_MXP_n0_2 vss sg13_hv_nmos w=0.5u l=0.45u m=1
MNGb_MXP_S0_2_1 t5 NGb_bp0 NGb_MXP_n0_2 vss sg13_hv_nmos w=0.5u l=0.45u m=1
MNGb_MXP_S0_3_0 t6 NGb_bbp0 NGb_MXP_n0_3 vss sg13_hv_nmos w=0.5u l=0.45u m=1
MNGb_MXP_S0_3_1 t7 NGb_bp0 NGb_MXP_n0_3 vss sg13_hv_nmos w=0.5u l=0.45u m=1
MNGb_MXP_S0_4_0 t8 NGb_bbp0 NGb_MXP_n0_4 vss sg13_hv_nmos w=0.5u l=0.45u m=1
MNGb_MXP_S0_4_1 t9 NGb_bp0 NGb_MXP_n0_4 vss sg13_hv_nmos w=0.5u l=0.45u m=1
MNGb_MXP_S0_5_0 t10 NGb_bbp0 NGb_MXP_n0_5 vss sg13_hv_nmos w=0.5u l=0.45u m=1
MNGb_MXP_S0_5_1 t11 NGb_bp0 NGb_MXP_n0_5 vss sg13_hv_nmos w=0.5u l=0.45u m=1
MNGb_MXP_S0_6_0 t12 NGb_bbp0 NGb_MXP_n0_6 vss sg13_hv_nmos w=0.5u l=0.45u m=1
MNGb_MXP_S0_6_1 t13 NGb_bp0 NGb_MXP_n0_6 vss sg13_hv_nmos w=0.5u l=0.45u m=1
MNGb_MXP_S0_7_0 t14 NGb_bbp0 NGb_MXP_n0_7 vss sg13_hv_nmos w=0.5u l=0.45u m=1
MNGb_MXP_S0_7_1 t15 NGb_bp0 NGb_MXP_n0_7 vss sg13_hv_nmos w=0.5u l=0.45u m=1
MNGb_MXP_S0_8_0 t16 NGb_bbp0 NGb_MXP_n0_8 vss sg13_hv_nmos w=0.5u l=0.45u m=1
MNGb_MXP_S0_8_1 t17 NGb_bp0 NGb_MXP_n0_8 vss sg13_hv_nmos w=0.5u l=0.45u m=1
MNGb_MXP_S0_9_0 t18 NGb_bbp0 NGb_MXP_n0_9 vss sg13_hv_nmos w=0.5u l=0.45u m=1
MNGb_MXP_S0_9_1 t19 NGb_bp0 NGb_MXP_n0_9 vss sg13_hv_nmos w=0.5u l=0.45u m=1
MNGb_MXP_S0_10_0 t20 NGb_bbp0 NGb_MXP_n0_10 vss sg13_hv_nmos w=0.5u l=0.45u m=1
MNGb_MXP_S0_10_1 t21 NGb_bp0 NGb_MXP_n0_10 vss sg13_hv_nmos w=0.5u l=0.45u m=1
MNGb_MXP_S0_11_0 t22 NGb_bbp0 NGb_MXP_n0_11 vss sg13_hv_nmos w=0.5u l=0.45u m=1
MNGb_MXP_S0_11_1 t23 NGb_bp0 NGb_MXP_n0_11 vss sg13_hv_nmos w=0.5u l=0.45u m=1
MNGb_MXP_S0_12_0 t24 NGb_bbp0 NGb_MXP_n0_12 vss sg13_hv_nmos w=0.5u l=0.45u m=1
MNGb_MXP_S0_12_1 t25 NGb_bp0 NGb_MXP_n0_12 vss sg13_hv_nmos w=0.5u l=0.45u m=1
MNGb_MXP_S0_13_0 t26 NGb_bbp0 NGb_MXP_n0_13 vss sg13_hv_nmos w=0.5u l=0.45u m=1
MNGb_MXP_S0_13_1 t27 NGb_bp0 NGb_MXP_n0_13 vss sg13_hv_nmos w=0.5u l=0.45u m=1
MNGb_MXP_S0_14_0 t28 NGb_bbp0 NGb_MXP_n0_14 vss sg13_hv_nmos w=0.5u l=0.45u m=1
MNGb_MXP_S0_14_1 t29 NGb_bp0 NGb_MXP_n0_14 vss sg13_hv_nmos w=0.5u l=0.45u m=1
MNGb_MXP_S0_15_0 t30 NGb_bbp0 NGb_MXP_n0_15 vss sg13_hv_nmos w=0.5u l=0.45u m=1
MNGb_MXP_S0_15_1 t31 NGb_bp0 NGb_MXP_n0_15 vss sg13_hv_nmos w=0.5u l=0.45u m=1
MNGb_MXP_S0_16_0 t32 NGb_bbp0 NGb_MXP_n0_16 vss sg13_hv_nmos w=0.5u l=0.45u m=1
MNGb_MXP_S0_16_1 t33 NGb_bp0 NGb_MXP_n0_16 vss sg13_hv_nmos w=0.5u l=0.45u m=1
MNGb_MXP_S0_17_0 t34 NGb_bbp0 NGb_MXP_n0_17 vss sg13_hv_nmos w=0.5u l=0.45u m=1
MNGb_MXP_S0_17_1 t35 NGb_bp0 NGb_MXP_n0_17 vss sg13_hv_nmos w=0.5u l=0.45u m=1
MNGb_MXP_S0_18_0 t36 NGb_bbp0 NGb_MXP_n0_18 vss sg13_hv_nmos w=0.5u l=0.45u m=1
MNGb_MXP_S0_18_1 t37 NGb_bp0 NGb_MXP_n0_18 vss sg13_hv_nmos w=0.5u l=0.45u m=1
MNGb_MXP_S0_19_0 t38 NGb_bbp0 NGb_MXP_n0_19 vss sg13_hv_nmos w=0.5u l=0.45u m=1
MNGb_MXP_S0_19_1 t39 NGb_bp0 NGb_MXP_n0_19 vss sg13_hv_nmos w=0.5u l=0.45u m=1
MNGb_MXP_S0_20_0 t40 NGb_bbp0 NGb_MXP_n0_20 vss sg13_hv_nmos w=0.5u l=0.45u m=1
MNGb_MXP_S0_20_1 t41 NGb_bp0 NGb_MXP_n0_20 vss sg13_hv_nmos w=0.5u l=0.45u m=1
MNGb_MXP_S0_21_0 t42 NGb_bbp0 NGb_MXP_n0_21 vss sg13_hv_nmos w=0.5u l=0.45u m=1
MNGb_MXP_S0_21_1 t43 NGb_bp0 NGb_MXP_n0_21 vss sg13_hv_nmos w=0.5u l=0.45u m=1
MNGb_MXP_S0_22_0 t44 NGb_bbp0 NGb_MXP_n0_22 vss sg13_hv_nmos w=0.5u l=0.45u m=1
MNGb_MXP_S0_22_1 t45 NGb_bp0 NGb_MXP_n0_22 vss sg13_hv_nmos w=0.5u l=0.45u m=1
MNGb_MXP_S0_23_0 t46 NGb_bbp0 NGb_MXP_n0_23 vss sg13_hv_nmos w=0.5u l=0.45u m=1
MNGb_MXP_S0_23_1 t47 NGb_bp0 NGb_MXP_n0_23 vss sg13_hv_nmos w=0.5u l=0.45u m=1
MNGb_MXP_S0_24_0 t48 NGb_bbp0 NGb_MXP_n0_24 vss sg13_hv_nmos w=0.5u l=0.45u m=1
MNGb_MXP_S0_24_1 t49 NGb_bp0 NGb_MXP_n0_24 vss sg13_hv_nmos w=0.5u l=0.45u m=1
MNGb_MXP_S0_25_0 t50 NGb_bbp0 NGb_MXP_n0_25 vss sg13_hv_nmos w=0.5u l=0.45u m=1
MNGb_MXP_S0_25_1 t51 NGb_bp0 NGb_MXP_n0_25 vss sg13_hv_nmos w=0.5u l=0.45u m=1
MNGb_MXP_S0_26_0 t52 NGb_bbp0 NGb_MXP_n0_26 vss sg13_hv_nmos w=0.5u l=0.45u m=1
MNGb_MXP_S0_26_1 t53 NGb_bp0 NGb_MXP_n0_26 vss sg13_hv_nmos w=0.5u l=0.45u m=1
MNGb_MXP_S0_27_0 t54 NGb_bbp0 NGb_MXP_n0_27 vss sg13_hv_nmos w=0.5u l=0.45u m=1
MNGb_MXP_S0_27_1 t55 NGb_bp0 NGb_MXP_n0_27 vss sg13_hv_nmos w=0.5u l=0.45u m=1
MNGb_MXP_S0_28_0 t56 NGb_bbp0 NGb_MXP_n0_28 vss sg13_hv_nmos w=0.5u l=0.45u m=1
MNGb_MXP_S0_28_1 t57 NGb_bp0 NGb_MXP_n0_28 vss sg13_hv_nmos w=0.5u l=0.45u m=1
MNGb_MXP_S0_29_0 t58 NGb_bbp0 NGb_MXP_n0_29 vss sg13_hv_nmos w=0.5u l=0.45u m=1
MNGb_MXP_S0_29_1 t59 NGb_bp0 NGb_MXP_n0_29 vss sg13_hv_nmos w=0.5u l=0.45u m=1
MNGb_MXP_S0_30_0 t60 NGb_bbp0 NGb_MXP_n0_30 vss sg13_hv_nmos w=0.5u l=0.45u m=1
MNGb_MXP_S0_30_1 t61 NGb_bp0 NGb_MXP_n0_30 vss sg13_hv_nmos w=0.5u l=0.45u m=1
MNGb_MXP_S0_31_0 t62 NGb_bbp0 NGb_MXP_n0_31 vss sg13_hv_nmos w=0.5u l=0.45u m=1
MNGb_MXP_S0_31_1 t63 NGb_bp0 NGb_MXP_n0_31 vss sg13_hv_nmos w=0.5u l=0.45u m=1
MNGb_MXP_S0_32_0 t64 NGb_bbp0 NGb_MXP_n0_32 vss sg13_hv_nmos w=0.5u l=0.45u m=1
MNGb_MXP_S0_32_1 t65 NGb_bp0 NGb_MXP_n0_32 vss sg13_hv_nmos w=0.5u l=0.45u m=1
MNGb_MXP_S0_33_0 t66 NGb_bbp0 NGb_MXP_n0_33 vss sg13_hv_nmos w=0.5u l=0.45u m=1
MNGb_MXP_S0_33_1 t67 NGb_bp0 NGb_MXP_n0_33 vss sg13_hv_nmos w=0.5u l=0.45u m=1
MNGb_MXP_S0_34_0 t68 NGb_bbp0 NGb_MXP_n0_34 vss sg13_hv_nmos w=0.5u l=0.45u m=1
MNGb_MXP_S0_34_1 t69 NGb_bp0 NGb_MXP_n0_34 vss sg13_hv_nmos w=0.5u l=0.45u m=1
MNGb_MXP_S0_35_0 t70 NGb_bbp0 NGb_MXP_n0_35 vss sg13_hv_nmos w=0.5u l=0.45u m=1
MNGb_MXP_S0_35_1 t71 NGb_bp0 NGb_MXP_n0_35 vss sg13_hv_nmos w=0.5u l=0.45u m=1
MNGb_MXP_S0_36_0 t72 NGb_bbp0 NGb_MXP_n0_36 vss sg13_hv_nmos w=0.5u l=0.45u m=1
MNGb_MXP_S0_36_1 t73 NGb_bp0 NGb_MXP_n0_36 vss sg13_hv_nmos w=0.5u l=0.45u m=1
MNGb_MXP_S0_37_0 t74 NGb_bbp0 NGb_MXP_n0_37 vss sg13_hv_nmos w=0.5u l=0.45u m=1
MNGb_MXP_S0_37_1 t75 NGb_bp0 NGb_MXP_n0_37 vss sg13_hv_nmos w=0.5u l=0.45u m=1
MNGb_MXP_S0_38_0 t76 NGb_bbp0 NGb_MXP_n0_38 vss sg13_hv_nmos w=0.5u l=0.45u m=1
MNGb_MXP_S0_38_1 t77 NGb_bp0 NGb_MXP_n0_38 vss sg13_hv_nmos w=0.5u l=0.45u m=1
MNGb_MXP_S0_39_0 t78 NGb_bbp0 NGb_MXP_n0_39 vss sg13_hv_nmos w=0.5u l=0.45u m=1
MNGb_MXP_S0_39_1 t79 NGb_bp0 NGb_MXP_n0_39 vss sg13_hv_nmos w=0.5u l=0.45u m=1
MNGb_MXP_S0_40_0 t80 NGb_bbp0 NGb_MXP_n0_40 vss sg13_hv_nmos w=0.5u l=0.45u m=1
MNGb_MXP_S0_40_1 t81 NGb_bp0 NGb_MXP_n0_40 vss sg13_hv_nmos w=0.5u l=0.45u m=1
MNGb_MXP_S0_41_0 t82 NGb_bbp0 NGb_MXP_n0_41 vss sg13_hv_nmos w=0.5u l=0.45u m=1
MNGb_MXP_S0_41_1 t83 NGb_bp0 NGb_MXP_n0_41 vss sg13_hv_nmos w=0.5u l=0.45u m=1
MNGb_MXP_S0_42_0 t84 NGb_bbp0 NGb_MXP_n0_42 vss sg13_hv_nmos w=0.5u l=0.45u m=1
MNGb_MXP_S0_42_1 t85 NGb_bp0 NGb_MXP_n0_42 vss sg13_hv_nmos w=0.5u l=0.45u m=1
MNGb_MXP_S0_43_0 t86 NGb_bbp0 NGb_MXP_n0_43 vss sg13_hv_nmos w=0.5u l=0.45u m=1
MNGb_MXP_S0_43_1 t87 NGb_bp0 NGb_MXP_n0_43 vss sg13_hv_nmos w=0.5u l=0.45u m=1
MNGb_MXP_S0_44_0 t88 NGb_bbp0 NGb_MXP_n0_44 vss sg13_hv_nmos w=0.5u l=0.45u m=1
MNGb_MXP_S0_44_1 t89 NGb_bp0 NGb_MXP_n0_44 vss sg13_hv_nmos w=0.5u l=0.45u m=1
MNGb_MXP_S0_45_0 t90 NGb_bbp0 NGb_MXP_n0_45 vss sg13_hv_nmos w=0.5u l=0.45u m=1
MNGb_MXP_S0_45_1 t91 NGb_bp0 NGb_MXP_n0_45 vss sg13_hv_nmos w=0.5u l=0.45u m=1
MNGb_MXP_S0_46_0 t92 NGb_bbp0 NGb_MXP_n0_46 vss sg13_hv_nmos w=0.5u l=0.45u m=1
MNGb_MXP_S0_46_1 t93 NGb_bp0 NGb_MXP_n0_46 vss sg13_hv_nmos w=0.5u l=0.45u m=1
MNGb_MXP_S0_47_0 t94 NGb_bbp0 NGb_MXP_n0_47 vss sg13_hv_nmos w=0.5u l=0.45u m=1
MNGb_MXP_S0_47_1 t95 NGb_bp0 NGb_MXP_n0_47 vss sg13_hv_nmos w=0.5u l=0.45u m=1
MNGb_MXP_S0_48_0 t96 NGb_bbp0 NGb_MXP_n0_48 vss sg13_hv_nmos w=0.5u l=0.45u m=1
MNGb_MXP_S0_48_1 t97 NGb_bp0 NGb_MXP_n0_48 vss sg13_hv_nmos w=0.5u l=0.45u m=1
MNGb_MXP_S0_49_0 t98 NGb_bbp0 NGb_MXP_n0_49 vss sg13_hv_nmos w=0.5u l=0.45u m=1
MNGb_MXP_S0_49_1 t99 NGb_bp0 NGb_MXP_n0_49 vss sg13_hv_nmos w=0.5u l=0.45u m=1
MNGb_MXP_S0_50_0 t100 NGb_bbp0 NGb_MXP_n0_50 vss sg13_hv_nmos w=0.5u l=0.45u m=1
MNGb_MXP_S0_50_1 t101 NGb_bp0 NGb_MXP_n0_50 vss sg13_hv_nmos w=0.5u l=0.45u m=1
MNGb_MXP_S0_51_0 t102 NGb_bbp0 NGb_MXP_n0_51 vss sg13_hv_nmos w=0.5u l=0.45u m=1
MNGb_MXP_S0_51_1 t103 NGb_bp0 NGb_MXP_n0_51 vss sg13_hv_nmos w=0.5u l=0.45u m=1
MNGb_MXP_S0_52_0 t104 NGb_bbp0 NGb_MXP_n0_52 vss sg13_hv_nmos w=0.5u l=0.45u m=1
MNGb_MXP_S0_52_1 t105 NGb_bp0 NGb_MXP_n0_52 vss sg13_hv_nmos w=0.5u l=0.45u m=1
MNGb_MXP_S0_53_0 t106 NGb_bbp0 NGb_MXP_n0_53 vss sg13_hv_nmos w=0.5u l=0.45u m=1
MNGb_MXP_S0_53_1 t107 NGb_bp0 NGb_MXP_n0_53 vss sg13_hv_nmos w=0.5u l=0.45u m=1
MNGb_MXP_S0_54_0 t108 NGb_bbp0 NGb_MXP_n0_54 vss sg13_hv_nmos w=0.5u l=0.45u m=1
MNGb_MXP_S0_54_1 t109 NGb_bp0 NGb_MXP_n0_54 vss sg13_hv_nmos w=0.5u l=0.45u m=1
MNGb_MXP_S0_55_0 t110 NGb_bbp0 NGb_MXP_n0_55 vss sg13_hv_nmos w=0.5u l=0.45u m=1
MNGb_MXP_S0_55_1 t111 NGb_bp0 NGb_MXP_n0_55 vss sg13_hv_nmos w=0.5u l=0.45u m=1
MNGb_MXP_S0_56_0 t112 NGb_bbp0 NGb_MXP_n0_56 vss sg13_hv_nmos w=0.5u l=0.45u m=1
MNGb_MXP_S0_56_1 t113 NGb_bp0 NGb_MXP_n0_56 vss sg13_hv_nmos w=0.5u l=0.45u m=1
MNGb_MXP_S0_57_0 t114 NGb_bbp0 NGb_MXP_n0_57 vss sg13_hv_nmos w=0.5u l=0.45u m=1
MNGb_MXP_S0_57_1 t115 NGb_bp0 NGb_MXP_n0_57 vss sg13_hv_nmos w=0.5u l=0.45u m=1
MNGb_MXP_S0_58_0 t116 NGb_bbp0 NGb_MXP_n0_58 vss sg13_hv_nmos w=0.5u l=0.45u m=1
MNGb_MXP_S0_58_1 t117 NGb_bp0 NGb_MXP_n0_58 vss sg13_hv_nmos w=0.5u l=0.45u m=1
MNGb_MXP_S0_59_0 t118 NGb_bbp0 NGb_MXP_n0_59 vss sg13_hv_nmos w=0.5u l=0.45u m=1
MNGb_MXP_S0_59_1 t119 NGb_bp0 NGb_MXP_n0_59 vss sg13_hv_nmos w=0.5u l=0.45u m=1
MNGb_MXP_S0_60_0 t120 NGb_bbp0 NGb_MXP_n0_60 vss sg13_hv_nmos w=0.5u l=0.45u m=1
MNGb_MXP_S0_60_1 t121 NGb_bp0 NGb_MXP_n0_60 vss sg13_hv_nmos w=0.5u l=0.45u m=1
MNGb_MXP_S0_61_0 t122 NGb_bbp0 NGb_MXP_n0_61 vss sg13_hv_nmos w=0.5u l=0.45u m=1
MNGb_MXP_S0_61_1 t123 NGb_bp0 NGb_MXP_n0_61 vss sg13_hv_nmos w=0.5u l=0.45u m=1
MNGb_MXP_S0_62_0 t124 NGb_bbp0 NGb_MXP_n0_62 vss sg13_hv_nmos w=0.5u l=0.45u m=1
MNGb_MXP_S0_62_1 t125 NGb_bp0 NGb_MXP_n0_62 vss sg13_hv_nmos w=0.5u l=0.45u m=1
MNGb_MXP_S0_63_0 t126 NGb_bbp0 NGb_MXP_n0_63 vss sg13_hv_nmos w=0.5u l=0.45u m=1
MNGb_MXP_S0_63_1 t127 NGb_bp0 NGb_MXP_n0_63 vss sg13_hv_nmos w=0.5u l=0.45u m=1
MNGb_MXP_S0_64_0 t128 NGb_bbp0 NGb_MXP_n0_64 vss sg13_hv_nmos w=0.5u l=0.45u m=1
MNGb_MXP_S0_64_1 t129 NGb_bp0 NGb_MXP_n0_64 vss sg13_hv_nmos w=0.5u l=0.45u m=1
MNGb_MXP_S0_65_0 t130 NGb_bbp0 NGb_MXP_n0_65 vss sg13_hv_nmos w=0.5u l=0.45u m=1
MNGb_MXP_S0_65_1 t131 NGb_bp0 NGb_MXP_n0_65 vss sg13_hv_nmos w=0.5u l=0.45u m=1
MNGb_MXP_S0_66_0 t132 NGb_bbp0 NGb_MXP_n0_66 vss sg13_hv_nmos w=0.5u l=0.45u m=1
MNGb_MXP_S0_66_1 t133 NGb_bp0 NGb_MXP_n0_66 vss sg13_hv_nmos w=0.5u l=0.45u m=1
MNGb_MXP_S0_67_0 t134 NGb_bbp0 NGb_MXP_n0_67 vss sg13_hv_nmos w=0.5u l=0.45u m=1
MNGb_MXP_S0_67_1 t135 NGb_bp0 NGb_MXP_n0_67 vss sg13_hv_nmos w=0.5u l=0.45u m=1
MNGb_MXP_S0_68_0 t136 NGb_bbp0 NGb_MXP_n0_68 vss sg13_hv_nmos w=0.5u l=0.45u m=1
MNGb_MXP_S0_68_1 t137 NGb_bp0 NGb_MXP_n0_68 vss sg13_hv_nmos w=0.5u l=0.45u m=1
MNGb_MXP_S0_69_0 t138 NGb_bbp0 NGb_MXP_n0_69 vss sg13_hv_nmos w=0.5u l=0.45u m=1
MNGb_MXP_S0_69_1 t139 NGb_bp0 NGb_MXP_n0_69 vss sg13_hv_nmos w=0.5u l=0.45u m=1
MNGb_MXP_S0_70_0 t140 NGb_bbp0 NGb_MXP_n0_70 vss sg13_hv_nmos w=0.5u l=0.45u m=1
MNGb_MXP_S0_70_1 t141 NGb_bp0 NGb_MXP_n0_70 vss sg13_hv_nmos w=0.5u l=0.45u m=1
MNGb_MXP_S0_71_0 t142 NGb_bbp0 NGb_MXP_n0_71 vss sg13_hv_nmos w=0.5u l=0.45u m=1
MNGb_MXP_S0_71_1 t143 NGb_bp0 NGb_MXP_n0_71 vss sg13_hv_nmos w=0.5u l=0.45u m=1
MNGb_MXP_S0_72_0 t144 NGb_bbp0 NGb_MXP_n0_72 vss sg13_hv_nmos w=0.5u l=0.45u m=1
MNGb_MXP_S0_72_1 t145 NGb_bp0 NGb_MXP_n0_72 vss sg13_hv_nmos w=0.5u l=0.45u m=1
MNGb_MXP_S0_73_0 t146 NGb_bbp0 NGb_MXP_n0_73 vss sg13_hv_nmos w=0.5u l=0.45u m=1
MNGb_MXP_S0_73_1 t147 NGb_bp0 NGb_MXP_n0_73 vss sg13_hv_nmos w=0.5u l=0.45u m=1
MNGb_MXP_S0_74_0 t148 NGb_bbp0 NGb_MXP_n0_74 vss sg13_hv_nmos w=0.5u l=0.45u m=1
MNGb_MXP_S0_74_1 t149 NGb_bp0 NGb_MXP_n0_74 vss sg13_hv_nmos w=0.5u l=0.45u m=1
MNGb_MXP_S0_75_0 t150 NGb_bbp0 NGb_MXP_n0_75 vss sg13_hv_nmos w=0.5u l=0.45u m=1
MNGb_MXP_S0_75_1 t151 NGb_bp0 NGb_MXP_n0_75 vss sg13_hv_nmos w=0.5u l=0.45u m=1
MNGb_MXP_S0_76_0 t152 NGb_bbp0 NGb_MXP_n0_76 vss sg13_hv_nmos w=0.5u l=0.45u m=1
MNGb_MXP_S0_76_1 t153 NGb_bp0 NGb_MXP_n0_76 vss sg13_hv_nmos w=0.5u l=0.45u m=1
MNGb_MXP_S0_77_0 t154 NGb_bbp0 NGb_MXP_n0_77 vss sg13_hv_nmos w=0.5u l=0.45u m=1
MNGb_MXP_S0_77_1 t155 NGb_bp0 NGb_MXP_n0_77 vss sg13_hv_nmos w=0.5u l=0.45u m=1
MNGb_MXP_S0_78_0 t156 NGb_bbp0 NGb_MXP_n0_78 vss sg13_hv_nmos w=0.5u l=0.45u m=1
MNGb_MXP_S0_78_1 t157 NGb_bp0 NGb_MXP_n0_78 vss sg13_hv_nmos w=0.5u l=0.45u m=1
MNGb_MXP_S0_79_0 t158 NGb_bbp0 NGb_MXP_n0_79 vss sg13_hv_nmos w=0.5u l=0.45u m=1
MNGb_MXP_S0_79_1 t159 NGb_bp0 NGb_MXP_n0_79 vss sg13_hv_nmos w=0.5u l=0.45u m=1
MNGb_MXP_S0_80_0 t160 NGb_bbp0 NGb_MXP_n0_80 vss sg13_hv_nmos w=0.5u l=0.45u m=1
MNGb_MXP_S0_80_1 t161 NGb_bp0 NGb_MXP_n0_80 vss sg13_hv_nmos w=0.5u l=0.45u m=1
MNGb_MXP_S0_81_0 t162 NGb_bbp0 NGb_MXP_n0_81 vss sg13_hv_nmos w=0.5u l=0.45u m=1
MNGb_MXP_S0_81_1 t163 NGb_bp0 NGb_MXP_n0_81 vss sg13_hv_nmos w=0.5u l=0.45u m=1
MNGb_MXP_S0_82_0 t164 NGb_bbp0 NGb_MXP_n0_82 vss sg13_hv_nmos w=0.5u l=0.45u m=1
MNGb_MXP_S0_82_1 t165 NGb_bp0 NGb_MXP_n0_82 vss sg13_hv_nmos w=0.5u l=0.45u m=1
MNGb_MXP_S0_83_0 t166 NGb_bbp0 NGb_MXP_n0_83 vss sg13_hv_nmos w=0.5u l=0.45u m=1
MNGb_MXP_S0_83_1 t167 NGb_bp0 NGb_MXP_n0_83 vss sg13_hv_nmos w=0.5u l=0.45u m=1
MNGb_MXP_S0_84_0 t168 NGb_bbp0 NGb_MXP_n0_84 vss sg13_hv_nmos w=0.5u l=0.45u m=1
MNGb_MXP_S0_84_1 t169 NGb_bp0 NGb_MXP_n0_84 vss sg13_hv_nmos w=0.5u l=0.45u m=1
MNGb_MXP_S0_85_0 t170 NGb_bbp0 NGb_MXP_n0_85 vss sg13_hv_nmos w=0.5u l=0.45u m=1
MNGb_MXP_S0_85_1 t171 NGb_bp0 NGb_MXP_n0_85 vss sg13_hv_nmos w=0.5u l=0.45u m=1
MNGb_MXP_S0_86_0 t172 NGb_bbp0 NGb_MXP_n0_86 vss sg13_hv_nmos w=0.5u l=0.45u m=1
MNGb_MXP_S0_86_1 t173 NGb_bp0 NGb_MXP_n0_86 vss sg13_hv_nmos w=0.5u l=0.45u m=1
MNGb_MXP_S0_87_0 t174 NGb_bbp0 NGb_MXP_n0_87 vss sg13_hv_nmos w=0.5u l=0.45u m=1
MNGb_MXP_S0_87_1 t175 NGb_bp0 NGb_MXP_n0_87 vss sg13_hv_nmos w=0.5u l=0.45u m=1
MNGb_MXP_S0_88_0 t176 NGb_bbp0 NGb_MXP_n0_88 vss sg13_hv_nmos w=0.5u l=0.45u m=1
MNGb_MXP_S0_88_1 t177 NGb_bp0 NGb_MXP_n0_88 vss sg13_hv_nmos w=0.5u l=0.45u m=1
MNGb_MXP_S0_89_0 t178 NGb_bbp0 NGb_MXP_n0_89 vss sg13_hv_nmos w=0.5u l=0.45u m=1
MNGb_MXP_S0_89_1 t179 NGb_bp0 NGb_MXP_n0_89 vss sg13_hv_nmos w=0.5u l=0.45u m=1
MNGb_MXP_S0_90_0 t180 NGb_bbp0 NGb_MXP_n0_90 vss sg13_hv_nmos w=0.5u l=0.45u m=1
MNGb_MXP_S0_90_1 t181 NGb_bp0 NGb_MXP_n0_90 vss sg13_hv_nmos w=0.5u l=0.45u m=1
MNGb_MXP_S0_91_0 t182 NGb_bbp0 NGb_MXP_n0_91 vss sg13_hv_nmos w=0.5u l=0.45u m=1
MNGb_MXP_S0_91_1 t183 NGb_bp0 NGb_MXP_n0_91 vss sg13_hv_nmos w=0.5u l=0.45u m=1
MNGb_MXP_S0_92_0 t184 NGb_bbp0 NGb_MXP_n0_92 vss sg13_hv_nmos w=0.5u l=0.45u m=1
MNGb_MXP_S0_92_1 t185 NGb_bp0 NGb_MXP_n0_92 vss sg13_hv_nmos w=0.5u l=0.45u m=1
MNGb_MXP_S0_93_0 t186 NGb_bbp0 NGb_MXP_n0_93 vss sg13_hv_nmos w=0.5u l=0.45u m=1
MNGb_MXP_S0_93_1 t187 NGb_bp0 NGb_MXP_n0_93 vss sg13_hv_nmos w=0.5u l=0.45u m=1
MNGb_MXP_S0_94_0 t188 NGb_bbp0 NGb_MXP_n0_94 vss sg13_hv_nmos w=0.5u l=0.45u m=1
MNGb_MXP_S0_94_1 t189 NGb_bp0 NGb_MXP_n0_94 vss sg13_hv_nmos w=0.5u l=0.45u m=1
MNGb_MXP_S0_95_0 t190 NGb_bbp0 NGb_MXP_n0_95 vss sg13_hv_nmos w=0.5u l=0.45u m=1
MNGb_MXP_S0_95_1 t191 NGb_bp0 NGb_MXP_n0_95 vss sg13_hv_nmos w=0.5u l=0.45u m=1
MNGb_MXP_S0_96_0 t192 NGb_bbp0 NGb_MXP_n0_96 vss sg13_hv_nmos w=0.5u l=0.45u m=1
MNGb_MXP_S0_96_1 t193 NGb_bp0 NGb_MXP_n0_96 vss sg13_hv_nmos w=0.5u l=0.45u m=1
MNGb_MXP_S0_97_0 t194 NGb_bbp0 NGb_MXP_n0_97 vss sg13_hv_nmos w=0.5u l=0.45u m=1
MNGb_MXP_S0_97_1 t195 NGb_bp0 NGb_MXP_n0_97 vss sg13_hv_nmos w=0.5u l=0.45u m=1
MNGb_MXP_S0_98_0 t196 NGb_bbp0 NGb_MXP_n0_98 vss sg13_hv_nmos w=0.5u l=0.45u m=1
MNGb_MXP_S0_98_1 t197 NGb_bp0 NGb_MXP_n0_98 vss sg13_hv_nmos w=0.5u l=0.45u m=1
MNGb_MXP_S0_99_0 t198 NGb_bbp0 NGb_MXP_n0_99 vss sg13_hv_nmos w=0.5u l=0.45u m=1
MNGb_MXP_S0_99_1 t199 NGb_bp0 NGb_MXP_n0_99 vss sg13_hv_nmos w=0.5u l=0.45u m=1
MNGb_MXP_S0_100_0 t200 NGb_bbp0 NGb_MXP_n0_100 vss sg13_hv_nmos w=0.5u l=0.45u m=1
MNGb_MXP_S0_100_1 t201 NGb_bp0 NGb_MXP_n0_100 vss sg13_hv_nmos w=0.5u l=0.45u m=1
MNGb_MXP_S0_101_0 t202 NGb_bbp0 NGb_MXP_n0_101 vss sg13_hv_nmos w=0.5u l=0.45u m=1
MNGb_MXP_S0_101_1 t203 NGb_bp0 NGb_MXP_n0_101 vss sg13_hv_nmos w=0.5u l=0.45u m=1
MNGb_MXP_S0_102_0 t204 NGb_bbp0 NGb_MXP_n0_102 vss sg13_hv_nmos w=0.5u l=0.45u m=1
MNGb_MXP_S0_102_1 t205 NGb_bp0 NGb_MXP_n0_102 vss sg13_hv_nmos w=0.5u l=0.45u m=1
MNGb_MXP_S0_103_0 t206 NGb_bbp0 NGb_MXP_n0_103 vss sg13_hv_nmos w=0.5u l=0.45u m=1
MNGb_MXP_S0_103_1 t207 NGb_bp0 NGb_MXP_n0_103 vss sg13_hv_nmos w=0.5u l=0.45u m=1
MNGb_MXP_S0_104_0 t208 NGb_bbp0 NGb_MXP_n0_104 vss sg13_hv_nmos w=0.5u l=0.45u m=1
MNGb_MXP_S0_104_1 t209 NGb_bp0 NGb_MXP_n0_104 vss sg13_hv_nmos w=0.5u l=0.45u m=1
MNGb_MXP_S0_105_0 t210 NGb_bbp0 NGb_MXP_n0_105 vss sg13_hv_nmos w=0.5u l=0.45u m=1
MNGb_MXP_S0_105_1 t211 NGb_bp0 NGb_MXP_n0_105 vss sg13_hv_nmos w=0.5u l=0.45u m=1
MNGb_MXP_S0_106_0 t212 NGb_bbp0 NGb_MXP_n0_106 vss sg13_hv_nmos w=0.5u l=0.45u m=1
MNGb_MXP_S0_106_1 t213 NGb_bp0 NGb_MXP_n0_106 vss sg13_hv_nmos w=0.5u l=0.45u m=1
MNGb_MXP_S0_107_0 t214 NGb_bbp0 NGb_MXP_n0_107 vss sg13_hv_nmos w=0.5u l=0.45u m=1
MNGb_MXP_S0_107_1 t215 NGb_bp0 NGb_MXP_n0_107 vss sg13_hv_nmos w=0.5u l=0.45u m=1
MNGb_MXP_S0_108_0 t216 NGb_bbp0 NGb_MXP_n0_108 vss sg13_hv_nmos w=0.5u l=0.45u m=1
MNGb_MXP_S0_108_1 t217 NGb_bp0 NGb_MXP_n0_108 vss sg13_hv_nmos w=0.5u l=0.45u m=1
MNGb_MXP_S0_109_0 t218 NGb_bbp0 NGb_MXP_n0_109 vss sg13_hv_nmos w=0.5u l=0.45u m=1
MNGb_MXP_S0_109_1 t219 NGb_bp0 NGb_MXP_n0_109 vss sg13_hv_nmos w=0.5u l=0.45u m=1
MNGb_MXP_S0_110_0 t220 NGb_bbp0 NGb_MXP_n0_110 vss sg13_hv_nmos w=0.5u l=0.45u m=1
MNGb_MXP_S0_110_1 t221 NGb_bp0 NGb_MXP_n0_110 vss sg13_hv_nmos w=0.5u l=0.45u m=1
MNGb_MXP_S0_111_0 t222 NGb_bbp0 NGb_MXP_n0_111 vss sg13_hv_nmos w=0.5u l=0.45u m=1
MNGb_MXP_S0_111_1 t223 NGb_bp0 NGb_MXP_n0_111 vss sg13_hv_nmos w=0.5u l=0.45u m=1
MNGb_MXP_S0_112_0 t224 NGb_bbp0 NGb_MXP_n0_112 vss sg13_hv_nmos w=0.5u l=0.45u m=1
MNGb_MXP_S0_112_1 t225 NGb_bp0 NGb_MXP_n0_112 vss sg13_hv_nmos w=0.5u l=0.45u m=1
MNGb_MXP_S0_113_0 t226 NGb_bbp0 NGb_MXP_n0_113 vss sg13_hv_nmos w=0.5u l=0.45u m=1
MNGb_MXP_S0_113_1 t227 NGb_bp0 NGb_MXP_n0_113 vss sg13_hv_nmos w=0.5u l=0.45u m=1
MNGb_MXP_S0_114_0 t228 NGb_bbp0 NGb_MXP_n0_114 vss sg13_hv_nmos w=0.5u l=0.45u m=1
MNGb_MXP_S0_114_1 t229 NGb_bp0 NGb_MXP_n0_114 vss sg13_hv_nmos w=0.5u l=0.45u m=1
MNGb_MXP_S0_115_0 t230 NGb_bbp0 NGb_MXP_n0_115 vss sg13_hv_nmos w=0.5u l=0.45u m=1
MNGb_MXP_S0_115_1 t231 NGb_bp0 NGb_MXP_n0_115 vss sg13_hv_nmos w=0.5u l=0.45u m=1
MNGb_MXP_S0_116_0 t232 NGb_bbp0 NGb_MXP_n0_116 vss sg13_hv_nmos w=0.5u l=0.45u m=1
MNGb_MXP_S0_116_1 t233 NGb_bp0 NGb_MXP_n0_116 vss sg13_hv_nmos w=0.5u l=0.45u m=1
MNGb_MXP_S0_117_0 t234 NGb_bbp0 NGb_MXP_n0_117 vss sg13_hv_nmos w=0.5u l=0.45u m=1
MNGb_MXP_S0_117_1 t235 NGb_bp0 NGb_MXP_n0_117 vss sg13_hv_nmos w=0.5u l=0.45u m=1
MNGb_MXP_S0_118_0 t236 NGb_bbp0 NGb_MXP_n0_118 vss sg13_hv_nmos w=0.5u l=0.45u m=1
MNGb_MXP_S0_118_1 t237 NGb_bp0 NGb_MXP_n0_118 vss sg13_hv_nmos w=0.5u l=0.45u m=1
MNGb_MXP_S0_119_0 t238 NGb_bbp0 NGb_MXP_n0_119 vss sg13_hv_nmos w=0.5u l=0.45u m=1
MNGb_MXP_S0_119_1 t239 NGb_bp0 NGb_MXP_n0_119 vss sg13_hv_nmos w=0.5u l=0.45u m=1
MNGb_MXP_S0_120_0 t240 NGb_bbp0 NGb_MXP_n0_120 vss sg13_hv_nmos w=0.5u l=0.45u m=1
MNGb_MXP_S0_120_1 t241 NGb_bp0 NGb_MXP_n0_120 vss sg13_hv_nmos w=0.5u l=0.45u m=1
MNGb_MXP_S0_121_0 t242 NGb_bbp0 NGb_MXP_n0_121 vss sg13_hv_nmos w=0.5u l=0.45u m=1
MNGb_MXP_S0_121_1 t243 NGb_bp0 NGb_MXP_n0_121 vss sg13_hv_nmos w=0.5u l=0.45u m=1
MNGb_MXP_S0_122_0 t244 NGb_bbp0 NGb_MXP_n0_122 vss sg13_hv_nmos w=0.5u l=0.45u m=1
MNGb_MXP_S0_122_1 t245 NGb_bp0 NGb_MXP_n0_122 vss sg13_hv_nmos w=0.5u l=0.45u m=1
MNGb_MXP_S0_123_0 t246 NGb_bbp0 NGb_MXP_n0_123 vss sg13_hv_nmos w=0.5u l=0.45u m=1
MNGb_MXP_S0_123_1 t247 NGb_bp0 NGb_MXP_n0_123 vss sg13_hv_nmos w=0.5u l=0.45u m=1
MNGb_MXP_S0_124_0 t248 NGb_bbp0 NGb_MXP_n0_124 vss sg13_hv_nmos w=0.5u l=0.45u m=1
MNGb_MXP_S0_124_1 t249 NGb_bp0 NGb_MXP_n0_124 vss sg13_hv_nmos w=0.5u l=0.45u m=1
MNGb_MXP_S0_125_0 t250 NGb_bbp0 NGb_MXP_n0_125 vss sg13_hv_nmos w=0.5u l=0.45u m=1
MNGb_MXP_S0_125_1 t251 NGb_bp0 NGb_MXP_n0_125 vss sg13_hv_nmos w=0.5u l=0.45u m=1
MNGb_MXP_S0_126_0 vref NGb_bbp0 NGb_MXP_n0_126 vss sg13_hv_nmos w=0.5u l=0.45u m=1
MNGb_MXP_S0_126_1 vref NGb_bp0 NGb_MXP_n0_126 vss sg13_hv_nmos w=0.5u l=0.45u m=1
MNGb_MXP_S0_127_0 vref NGb_bbp0 NGb_MXP_n0_127 vss sg13_hv_nmos w=0.5u l=0.45u m=1
MNGb_MXP_S0_127_1 vref NGb_bp0 NGb_MXP_n0_127 vss sg13_hv_nmos w=0.5u l=0.45u m=1
MNGb_MXP_S1_0_0 NGb_MXP_n0_0 NGb_bbp1 NGb_MXP_n1_0 vss sg13_hv_nmos w=0.5u l=0.45u m=1
MNGb_MXP_S1_0_1 NGb_MXP_n0_1 NGb_bp1 NGb_MXP_n1_0 vss sg13_hv_nmos w=0.5u l=0.45u m=1
MNGb_MXP_S1_1_0 NGb_MXP_n0_2 NGb_bbp1 NGb_MXP_n1_1 vss sg13_hv_nmos w=0.5u l=0.45u m=1
MNGb_MXP_S1_1_1 NGb_MXP_n0_3 NGb_bp1 NGb_MXP_n1_1 vss sg13_hv_nmos w=0.5u l=0.45u m=1
MNGb_MXP_S1_2_0 NGb_MXP_n0_4 NGb_bbp1 NGb_MXP_n1_2 vss sg13_hv_nmos w=0.5u l=0.45u m=1
MNGb_MXP_S1_2_1 NGb_MXP_n0_5 NGb_bp1 NGb_MXP_n1_2 vss sg13_hv_nmos w=0.5u l=0.45u m=1
MNGb_MXP_S1_3_0 NGb_MXP_n0_6 NGb_bbp1 NGb_MXP_n1_3 vss sg13_hv_nmos w=0.5u l=0.45u m=1
MNGb_MXP_S1_3_1 NGb_MXP_n0_7 NGb_bp1 NGb_MXP_n1_3 vss sg13_hv_nmos w=0.5u l=0.45u m=1
MNGb_MXP_S1_4_0 NGb_MXP_n0_8 NGb_bbp1 NGb_MXP_n1_4 vss sg13_hv_nmos w=0.5u l=0.45u m=1
MNGb_MXP_S1_4_1 NGb_MXP_n0_9 NGb_bp1 NGb_MXP_n1_4 vss sg13_hv_nmos w=0.5u l=0.45u m=1
MNGb_MXP_S1_5_0 NGb_MXP_n0_10 NGb_bbp1 NGb_MXP_n1_5 vss sg13_hv_nmos w=0.5u l=0.45u m=1
MNGb_MXP_S1_5_1 NGb_MXP_n0_11 NGb_bp1 NGb_MXP_n1_5 vss sg13_hv_nmos w=0.5u l=0.45u m=1
MNGb_MXP_S1_6_0 NGb_MXP_n0_12 NGb_bbp1 NGb_MXP_n1_6 vss sg13_hv_nmos w=0.5u l=0.45u m=1
MNGb_MXP_S1_6_1 NGb_MXP_n0_13 NGb_bp1 NGb_MXP_n1_6 vss sg13_hv_nmos w=0.5u l=0.45u m=1
MNGb_MXP_S1_7_0 NGb_MXP_n0_14 NGb_bbp1 NGb_MXP_n1_7 vss sg13_hv_nmos w=0.5u l=0.45u m=1
MNGb_MXP_S1_7_1 NGb_MXP_n0_15 NGb_bp1 NGb_MXP_n1_7 vss sg13_hv_nmos w=0.5u l=0.45u m=1
MNGb_MXP_S1_8_0 NGb_MXP_n0_16 NGb_bbp1 NGb_MXP_n1_8 vss sg13_hv_nmos w=0.5u l=0.45u m=1
MNGb_MXP_S1_8_1 NGb_MXP_n0_17 NGb_bp1 NGb_MXP_n1_8 vss sg13_hv_nmos w=0.5u l=0.45u m=1
MNGb_MXP_S1_9_0 NGb_MXP_n0_18 NGb_bbp1 NGb_MXP_n1_9 vss sg13_hv_nmos w=0.5u l=0.45u m=1
MNGb_MXP_S1_9_1 NGb_MXP_n0_19 NGb_bp1 NGb_MXP_n1_9 vss sg13_hv_nmos w=0.5u l=0.45u m=1
MNGb_MXP_S1_10_0 NGb_MXP_n0_20 NGb_bbp1 NGb_MXP_n1_10 vss sg13_hv_nmos w=0.5u l=0.45u m=1
MNGb_MXP_S1_10_1 NGb_MXP_n0_21 NGb_bp1 NGb_MXP_n1_10 vss sg13_hv_nmos w=0.5u l=0.45u m=1
MNGb_MXP_S1_11_0 NGb_MXP_n0_22 NGb_bbp1 NGb_MXP_n1_11 vss sg13_hv_nmos w=0.5u l=0.45u m=1
MNGb_MXP_S1_11_1 NGb_MXP_n0_23 NGb_bp1 NGb_MXP_n1_11 vss sg13_hv_nmos w=0.5u l=0.45u m=1
MNGb_MXP_S1_12_0 NGb_MXP_n0_24 NGb_bbp1 NGb_MXP_n1_12 vss sg13_hv_nmos w=0.5u l=0.45u m=1
MNGb_MXP_S1_12_1 NGb_MXP_n0_25 NGb_bp1 NGb_MXP_n1_12 vss sg13_hv_nmos w=0.5u l=0.45u m=1
MNGb_MXP_S1_13_0 NGb_MXP_n0_26 NGb_bbp1 NGb_MXP_n1_13 vss sg13_hv_nmos w=0.5u l=0.45u m=1
MNGb_MXP_S1_13_1 NGb_MXP_n0_27 NGb_bp1 NGb_MXP_n1_13 vss sg13_hv_nmos w=0.5u l=0.45u m=1
MNGb_MXP_S1_14_0 NGb_MXP_n0_28 NGb_bbp1 NGb_MXP_n1_14 vss sg13_hv_nmos w=0.5u l=0.45u m=1
MNGb_MXP_S1_14_1 NGb_MXP_n0_29 NGb_bp1 NGb_MXP_n1_14 vss sg13_hv_nmos w=0.5u l=0.45u m=1
MNGb_MXP_S1_15_0 NGb_MXP_n0_30 NGb_bbp1 NGb_MXP_n1_15 vss sg13_hv_nmos w=0.5u l=0.45u m=1
MNGb_MXP_S1_15_1 NGb_MXP_n0_31 NGb_bp1 NGb_MXP_n1_15 vss sg13_hv_nmos w=0.5u l=0.45u m=1
MNGb_MXP_S1_16_0 NGb_MXP_n0_32 NGb_bbp1 NGb_MXP_n1_16 vss sg13_hv_nmos w=0.5u l=0.45u m=1
MNGb_MXP_S1_16_1 NGb_MXP_n0_33 NGb_bp1 NGb_MXP_n1_16 vss sg13_hv_nmos w=0.5u l=0.45u m=1
MNGb_MXP_S1_17_0 NGb_MXP_n0_34 NGb_bbp1 NGb_MXP_n1_17 vss sg13_hv_nmos w=0.5u l=0.45u m=1
MNGb_MXP_S1_17_1 NGb_MXP_n0_35 NGb_bp1 NGb_MXP_n1_17 vss sg13_hv_nmos w=0.5u l=0.45u m=1
MNGb_MXP_S1_18_0 NGb_MXP_n0_36 NGb_bbp1 NGb_MXP_n1_18 vss sg13_hv_nmos w=0.5u l=0.45u m=1
MNGb_MXP_S1_18_1 NGb_MXP_n0_37 NGb_bp1 NGb_MXP_n1_18 vss sg13_hv_nmos w=0.5u l=0.45u m=1
MNGb_MXP_S1_19_0 NGb_MXP_n0_38 NGb_bbp1 NGb_MXP_n1_19 vss sg13_hv_nmos w=0.5u l=0.45u m=1
MNGb_MXP_S1_19_1 NGb_MXP_n0_39 NGb_bp1 NGb_MXP_n1_19 vss sg13_hv_nmos w=0.5u l=0.45u m=1
MNGb_MXP_S1_20_0 NGb_MXP_n0_40 NGb_bbp1 NGb_MXP_n1_20 vss sg13_hv_nmos w=0.5u l=0.45u m=1
MNGb_MXP_S1_20_1 NGb_MXP_n0_41 NGb_bp1 NGb_MXP_n1_20 vss sg13_hv_nmos w=0.5u l=0.45u m=1
MNGb_MXP_S1_21_0 NGb_MXP_n0_42 NGb_bbp1 NGb_MXP_n1_21 vss sg13_hv_nmos w=0.5u l=0.45u m=1
MNGb_MXP_S1_21_1 NGb_MXP_n0_43 NGb_bp1 NGb_MXP_n1_21 vss sg13_hv_nmos w=0.5u l=0.45u m=1
MNGb_MXP_S1_22_0 NGb_MXP_n0_44 NGb_bbp1 NGb_MXP_n1_22 vss sg13_hv_nmos w=0.5u l=0.45u m=1
MNGb_MXP_S1_22_1 NGb_MXP_n0_45 NGb_bp1 NGb_MXP_n1_22 vss sg13_hv_nmos w=0.5u l=0.45u m=1
MNGb_MXP_S1_23_0 NGb_MXP_n0_46 NGb_bbp1 NGb_MXP_n1_23 vss sg13_hv_nmos w=0.5u l=0.45u m=1
MNGb_MXP_S1_23_1 NGb_MXP_n0_47 NGb_bp1 NGb_MXP_n1_23 vss sg13_hv_nmos w=0.5u l=0.45u m=1
MNGb_MXP_S1_24_0 NGb_MXP_n0_48 NGb_bbp1 NGb_MXP_n1_24 vss sg13_hv_nmos w=0.5u l=0.45u m=1
MNGb_MXP_S1_24_1 NGb_MXP_n0_49 NGb_bp1 NGb_MXP_n1_24 vss sg13_hv_nmos w=0.5u l=0.45u m=1
MNGb_MXP_S1_25_0 NGb_MXP_n0_50 NGb_bbp1 NGb_MXP_n1_25 vss sg13_hv_nmos w=0.5u l=0.45u m=1
MNGb_MXP_S1_25_1 NGb_MXP_n0_51 NGb_bp1 NGb_MXP_n1_25 vss sg13_hv_nmos w=0.5u l=0.45u m=1
MNGb_MXP_S1_26_0 NGb_MXP_n0_52 NGb_bbp1 NGb_MXP_n1_26 vss sg13_hv_nmos w=0.5u l=0.45u m=1
MNGb_MXP_S1_26_1 NGb_MXP_n0_53 NGb_bp1 NGb_MXP_n1_26 vss sg13_hv_nmos w=0.5u l=0.45u m=1
MNGb_MXP_S1_27_0 NGb_MXP_n0_54 NGb_bbp1 NGb_MXP_n1_27 vss sg13_hv_nmos w=0.5u l=0.45u m=1
MNGb_MXP_S1_27_1 NGb_MXP_n0_55 NGb_bp1 NGb_MXP_n1_27 vss sg13_hv_nmos w=0.5u l=0.45u m=1
MNGb_MXP_S1_28_0 NGb_MXP_n0_56 NGb_bbp1 NGb_MXP_n1_28 vss sg13_hv_nmos w=0.5u l=0.45u m=1
MNGb_MXP_S1_28_1 NGb_MXP_n0_57 NGb_bp1 NGb_MXP_n1_28 vss sg13_hv_nmos w=0.5u l=0.45u m=1
MNGb_MXP_S1_29_0 NGb_MXP_n0_58 NGb_bbp1 NGb_MXP_n1_29 vss sg13_hv_nmos w=0.5u l=0.45u m=1
MNGb_MXP_S1_29_1 NGb_MXP_n0_59 NGb_bp1 NGb_MXP_n1_29 vss sg13_hv_nmos w=0.5u l=0.45u m=1
MNGb_MXP_S1_30_0 NGb_MXP_n0_60 NGb_bbp1 NGb_MXP_n1_30 vss sg13_hv_nmos w=0.5u l=0.45u m=1
MNGb_MXP_S1_30_1 NGb_MXP_n0_61 NGb_bp1 NGb_MXP_n1_30 vss sg13_hv_nmos w=0.5u l=0.45u m=1
MNGb_MXP_S1_31_0 NGb_MXP_n0_62 NGb_bbp1 NGb_MXP_n1_31 vss sg13_hv_nmos w=0.5u l=0.45u m=1
MNGb_MXP_S1_31_1 NGb_MXP_n0_63 NGb_bp1 NGb_MXP_n1_31 vss sg13_hv_nmos w=0.5u l=0.45u m=1
MNGb_MXP_S1_32_0 NGb_MXP_n0_64 NGb_bbp1 NGb_MXP_n1_32 vss sg13_hv_nmos w=0.5u l=0.45u m=1
MNGb_MXP_S1_32_1 NGb_MXP_n0_65 NGb_bp1 NGb_MXP_n1_32 vss sg13_hv_nmos w=0.5u l=0.45u m=1
MNGb_MXP_S1_33_0 NGb_MXP_n0_66 NGb_bbp1 NGb_MXP_n1_33 vss sg13_hv_nmos w=0.5u l=0.45u m=1
MNGb_MXP_S1_33_1 NGb_MXP_n0_67 NGb_bp1 NGb_MXP_n1_33 vss sg13_hv_nmos w=0.5u l=0.45u m=1
MNGb_MXP_S1_34_0 NGb_MXP_n0_68 NGb_bbp1 NGb_MXP_n1_34 vss sg13_hv_nmos w=0.5u l=0.45u m=1
MNGb_MXP_S1_34_1 NGb_MXP_n0_69 NGb_bp1 NGb_MXP_n1_34 vss sg13_hv_nmos w=0.5u l=0.45u m=1
MNGb_MXP_S1_35_0 NGb_MXP_n0_70 NGb_bbp1 NGb_MXP_n1_35 vss sg13_hv_nmos w=0.5u l=0.45u m=1
MNGb_MXP_S1_35_1 NGb_MXP_n0_71 NGb_bp1 NGb_MXP_n1_35 vss sg13_hv_nmos w=0.5u l=0.45u m=1
MNGb_MXP_S1_36_0 NGb_MXP_n0_72 NGb_bbp1 NGb_MXP_n1_36 vss sg13_hv_nmos w=0.5u l=0.45u m=1
MNGb_MXP_S1_36_1 NGb_MXP_n0_73 NGb_bp1 NGb_MXP_n1_36 vss sg13_hv_nmos w=0.5u l=0.45u m=1
MNGb_MXP_S1_37_0 NGb_MXP_n0_74 NGb_bbp1 NGb_MXP_n1_37 vss sg13_hv_nmos w=0.5u l=0.45u m=1
MNGb_MXP_S1_37_1 NGb_MXP_n0_75 NGb_bp1 NGb_MXP_n1_37 vss sg13_hv_nmos w=0.5u l=0.45u m=1
MNGb_MXP_S1_38_0 NGb_MXP_n0_76 NGb_bbp1 NGb_MXP_n1_38 vss sg13_hv_nmos w=0.5u l=0.45u m=1
MNGb_MXP_S1_38_1 NGb_MXP_n0_77 NGb_bp1 NGb_MXP_n1_38 vss sg13_hv_nmos w=0.5u l=0.45u m=1
MNGb_MXP_S1_39_0 NGb_MXP_n0_78 NGb_bbp1 NGb_MXP_n1_39 vss sg13_hv_nmos w=0.5u l=0.45u m=1
MNGb_MXP_S1_39_1 NGb_MXP_n0_79 NGb_bp1 NGb_MXP_n1_39 vss sg13_hv_nmos w=0.5u l=0.45u m=1
MNGb_MXP_S1_40_0 NGb_MXP_n0_80 NGb_bbp1 NGb_MXP_n1_40 vss sg13_hv_nmos w=0.5u l=0.45u m=1
MNGb_MXP_S1_40_1 NGb_MXP_n0_81 NGb_bp1 NGb_MXP_n1_40 vss sg13_hv_nmos w=0.5u l=0.45u m=1
MNGb_MXP_S1_41_0 NGb_MXP_n0_82 NGb_bbp1 NGb_MXP_n1_41 vss sg13_hv_nmos w=0.5u l=0.45u m=1
MNGb_MXP_S1_41_1 NGb_MXP_n0_83 NGb_bp1 NGb_MXP_n1_41 vss sg13_hv_nmos w=0.5u l=0.45u m=1
MNGb_MXP_S1_42_0 NGb_MXP_n0_84 NGb_bbp1 NGb_MXP_n1_42 vss sg13_hv_nmos w=0.5u l=0.45u m=1
MNGb_MXP_S1_42_1 NGb_MXP_n0_85 NGb_bp1 NGb_MXP_n1_42 vss sg13_hv_nmos w=0.5u l=0.45u m=1
MNGb_MXP_S1_43_0 NGb_MXP_n0_86 NGb_bbp1 NGb_MXP_n1_43 vss sg13_hv_nmos w=0.5u l=0.45u m=1
MNGb_MXP_S1_43_1 NGb_MXP_n0_87 NGb_bp1 NGb_MXP_n1_43 vss sg13_hv_nmos w=0.5u l=0.45u m=1
MNGb_MXP_S1_44_0 NGb_MXP_n0_88 NGb_bbp1 NGb_MXP_n1_44 vss sg13_hv_nmos w=0.5u l=0.45u m=1
MNGb_MXP_S1_44_1 NGb_MXP_n0_89 NGb_bp1 NGb_MXP_n1_44 vss sg13_hv_nmos w=0.5u l=0.45u m=1
MNGb_MXP_S1_45_0 NGb_MXP_n0_90 NGb_bbp1 NGb_MXP_n1_45 vss sg13_hv_nmos w=0.5u l=0.45u m=1
MNGb_MXP_S1_45_1 NGb_MXP_n0_91 NGb_bp1 NGb_MXP_n1_45 vss sg13_hv_nmos w=0.5u l=0.45u m=1
MNGb_MXP_S1_46_0 NGb_MXP_n0_92 NGb_bbp1 NGb_MXP_n1_46 vss sg13_hv_nmos w=0.5u l=0.45u m=1
MNGb_MXP_S1_46_1 NGb_MXP_n0_93 NGb_bp1 NGb_MXP_n1_46 vss sg13_hv_nmos w=0.5u l=0.45u m=1
MNGb_MXP_S1_47_0 NGb_MXP_n0_94 NGb_bbp1 NGb_MXP_n1_47 vss sg13_hv_nmos w=0.5u l=0.45u m=1
MNGb_MXP_S1_47_1 NGb_MXP_n0_95 NGb_bp1 NGb_MXP_n1_47 vss sg13_hv_nmos w=0.5u l=0.45u m=1
MNGb_MXP_S1_48_0 NGb_MXP_n0_96 NGb_bbp1 NGb_MXP_n1_48 vss sg13_hv_nmos w=0.5u l=0.45u m=1
MNGb_MXP_S1_48_1 NGb_MXP_n0_97 NGb_bp1 NGb_MXP_n1_48 vss sg13_hv_nmos w=0.5u l=0.45u m=1
MNGb_MXP_S1_49_0 NGb_MXP_n0_98 NGb_bbp1 NGb_MXP_n1_49 vss sg13_hv_nmos w=0.5u l=0.45u m=1
MNGb_MXP_S1_49_1 NGb_MXP_n0_99 NGb_bp1 NGb_MXP_n1_49 vss sg13_hv_nmos w=0.5u l=0.45u m=1
MNGb_MXP_S1_50_0 NGb_MXP_n0_100 NGb_bbp1 NGb_MXP_n1_50 vss sg13_hv_nmos w=0.5u l=0.45u m=1
MNGb_MXP_S1_50_1 NGb_MXP_n0_101 NGb_bp1 NGb_MXP_n1_50 vss sg13_hv_nmos w=0.5u l=0.45u m=1
MNGb_MXP_S1_51_0 NGb_MXP_n0_102 NGb_bbp1 NGb_MXP_n1_51 vss sg13_hv_nmos w=0.5u l=0.45u m=1
MNGb_MXP_S1_51_1 NGb_MXP_n0_103 NGb_bp1 NGb_MXP_n1_51 vss sg13_hv_nmos w=0.5u l=0.45u m=1
MNGb_MXP_S1_52_0 NGb_MXP_n0_104 NGb_bbp1 NGb_MXP_n1_52 vss sg13_hv_nmos w=0.5u l=0.45u m=1
MNGb_MXP_S1_52_1 NGb_MXP_n0_105 NGb_bp1 NGb_MXP_n1_52 vss sg13_hv_nmos w=0.5u l=0.45u m=1
MNGb_MXP_S1_53_0 NGb_MXP_n0_106 NGb_bbp1 NGb_MXP_n1_53 vss sg13_hv_nmos w=0.5u l=0.45u m=1
MNGb_MXP_S1_53_1 NGb_MXP_n0_107 NGb_bp1 NGb_MXP_n1_53 vss sg13_hv_nmos w=0.5u l=0.45u m=1
MNGb_MXP_S1_54_0 NGb_MXP_n0_108 NGb_bbp1 NGb_MXP_n1_54 vss sg13_hv_nmos w=0.5u l=0.45u m=1
MNGb_MXP_S1_54_1 NGb_MXP_n0_109 NGb_bp1 NGb_MXP_n1_54 vss sg13_hv_nmos w=0.5u l=0.45u m=1
MNGb_MXP_S1_55_0 NGb_MXP_n0_110 NGb_bbp1 NGb_MXP_n1_55 vss sg13_hv_nmos w=0.5u l=0.45u m=1
MNGb_MXP_S1_55_1 NGb_MXP_n0_111 NGb_bp1 NGb_MXP_n1_55 vss sg13_hv_nmos w=0.5u l=0.45u m=1
MNGb_MXP_S1_56_0 NGb_MXP_n0_112 NGb_bbp1 NGb_MXP_n1_56 vss sg13_hv_nmos w=0.5u l=0.45u m=1
MNGb_MXP_S1_56_1 NGb_MXP_n0_113 NGb_bp1 NGb_MXP_n1_56 vss sg13_hv_nmos w=0.5u l=0.45u m=1
MNGb_MXP_S1_57_0 NGb_MXP_n0_114 NGb_bbp1 NGb_MXP_n1_57 vss sg13_hv_nmos w=0.5u l=0.45u m=1
MNGb_MXP_S1_57_1 NGb_MXP_n0_115 NGb_bp1 NGb_MXP_n1_57 vss sg13_hv_nmos w=0.5u l=0.45u m=1
MNGb_MXP_S1_58_0 NGb_MXP_n0_116 NGb_bbp1 NGb_MXP_n1_58 vss sg13_hv_nmos w=0.5u l=0.45u m=1
MNGb_MXP_S1_58_1 NGb_MXP_n0_117 NGb_bp1 NGb_MXP_n1_58 vss sg13_hv_nmos w=0.5u l=0.45u m=1
MNGb_MXP_S1_59_0 NGb_MXP_n0_118 NGb_bbp1 NGb_MXP_n1_59 vss sg13_hv_nmos w=0.5u l=0.45u m=1
MNGb_MXP_S1_59_1 NGb_MXP_n0_119 NGb_bp1 NGb_MXP_n1_59 vss sg13_hv_nmos w=0.5u l=0.45u m=1
MNGb_MXP_S1_60_0 NGb_MXP_n0_120 NGb_bbp1 NGb_MXP_n1_60 vss sg13_hv_nmos w=0.5u l=0.45u m=1
MNGb_MXP_S1_60_1 NGb_MXP_n0_121 NGb_bp1 NGb_MXP_n1_60 vss sg13_hv_nmos w=0.5u l=0.45u m=1
MNGb_MXP_S1_61_0 NGb_MXP_n0_122 NGb_bbp1 NGb_MXP_n1_61 vss sg13_hv_nmos w=0.5u l=0.45u m=1
MNGb_MXP_S1_61_1 NGb_MXP_n0_123 NGb_bp1 NGb_MXP_n1_61 vss sg13_hv_nmos w=0.5u l=0.45u m=1
MNGb_MXP_S1_62_0 NGb_MXP_n0_124 NGb_bbp1 NGb_MXP_n1_62 vss sg13_hv_nmos w=0.5u l=0.45u m=1
MNGb_MXP_S1_62_1 NGb_MXP_n0_125 NGb_bp1 NGb_MXP_n1_62 vss sg13_hv_nmos w=0.5u l=0.45u m=1
MNGb_MXP_S1_63_0 NGb_MXP_n0_126 NGb_bbp1 NGb_MXP_n1_63 vss sg13_hv_nmos w=0.5u l=0.45u m=1
MNGb_MXP_S1_63_1 NGb_MXP_n0_127 NGb_bp1 NGb_MXP_n1_63 vss sg13_hv_nmos w=0.5u l=0.45u m=1
MNGb_MXP_S2_0_0 NGb_MXP_n1_0 NGb_bbp2 NGb_MXP_n2_0 vss sg13_hv_nmos w=0.5u l=0.45u m=1
MNGb_MXP_S2_0_1 NGb_MXP_n1_1 NGb_bp2 NGb_MXP_n2_0 vss sg13_hv_nmos w=0.5u l=0.45u m=1
MNGb_MXP_S2_1_0 NGb_MXP_n1_2 NGb_bbp2 NGb_MXP_n2_1 vss sg13_hv_nmos w=0.5u l=0.45u m=1
MNGb_MXP_S2_1_1 NGb_MXP_n1_3 NGb_bp2 NGb_MXP_n2_1 vss sg13_hv_nmos w=0.5u l=0.45u m=1
MNGb_MXP_S2_2_0 NGb_MXP_n1_4 NGb_bbp2 NGb_MXP_n2_2 vss sg13_hv_nmos w=0.5u l=0.45u m=1
MNGb_MXP_S2_2_1 NGb_MXP_n1_5 NGb_bp2 NGb_MXP_n2_2 vss sg13_hv_nmos w=0.5u l=0.45u m=1
MNGb_MXP_S2_3_0 NGb_MXP_n1_6 NGb_bbp2 NGb_MXP_n2_3 vss sg13_hv_nmos w=0.5u l=0.45u m=1
MNGb_MXP_S2_3_1 NGb_MXP_n1_7 NGb_bp2 NGb_MXP_n2_3 vss sg13_hv_nmos w=0.5u l=0.45u m=1
MNGb_MXP_S2_4_0 NGb_MXP_n1_8 NGb_bbp2 NGb_MXP_n2_4 vss sg13_hv_nmos w=0.5u l=0.45u m=1
MNGb_MXP_S2_4_1 NGb_MXP_n1_9 NGb_bp2 NGb_MXP_n2_4 vss sg13_hv_nmos w=0.5u l=0.45u m=1
MNGb_MXP_S2_5_0 NGb_MXP_n1_10 NGb_bbp2 NGb_MXP_n2_5 vss sg13_hv_nmos w=0.5u l=0.45u m=1
MNGb_MXP_S2_5_1 NGb_MXP_n1_11 NGb_bp2 NGb_MXP_n2_5 vss sg13_hv_nmos w=0.5u l=0.45u m=1
MNGb_MXP_S2_6_0 NGb_MXP_n1_12 NGb_bbp2 NGb_MXP_n2_6 vss sg13_hv_nmos w=0.5u l=0.45u m=1
MNGb_MXP_S2_6_1 NGb_MXP_n1_13 NGb_bp2 NGb_MXP_n2_6 vss sg13_hv_nmos w=0.5u l=0.45u m=1
MNGb_MXP_S2_7_0 NGb_MXP_n1_14 NGb_bbp2 NGb_MXP_n2_7 vss sg13_hv_nmos w=0.5u l=0.45u m=1
MNGb_MXP_S2_7_1 NGb_MXP_n1_15 NGb_bp2 NGb_MXP_n2_7 vss sg13_hv_nmos w=0.5u l=0.45u m=1
MNGb_MXP_S2_8_0 NGb_MXP_n1_16 NGb_bbp2 NGb_MXP_n2_8 vss sg13_hv_nmos w=0.5u l=0.45u m=1
MNGb_MXP_S2_8_1 NGb_MXP_n1_17 NGb_bp2 NGb_MXP_n2_8 vss sg13_hv_nmos w=0.5u l=0.45u m=1
MNGb_MXP_S2_9_0 NGb_MXP_n1_18 NGb_bbp2 NGb_MXP_n2_9 vss sg13_hv_nmos w=0.5u l=0.45u m=1
MNGb_MXP_S2_9_1 NGb_MXP_n1_19 NGb_bp2 NGb_MXP_n2_9 vss sg13_hv_nmos w=0.5u l=0.45u m=1
MNGb_MXP_S2_10_0 NGb_MXP_n1_20 NGb_bbp2 NGb_MXP_n2_10 vss sg13_hv_nmos w=0.5u l=0.45u m=1
MNGb_MXP_S2_10_1 NGb_MXP_n1_21 NGb_bp2 NGb_MXP_n2_10 vss sg13_hv_nmos w=0.5u l=0.45u m=1
MNGb_MXP_S2_11_0 NGb_MXP_n1_22 NGb_bbp2 NGb_MXP_n2_11 vss sg13_hv_nmos w=0.5u l=0.45u m=1
MNGb_MXP_S2_11_1 NGb_MXP_n1_23 NGb_bp2 NGb_MXP_n2_11 vss sg13_hv_nmos w=0.5u l=0.45u m=1
MNGb_MXP_S2_12_0 NGb_MXP_n1_24 NGb_bbp2 NGb_MXP_n2_12 vss sg13_hv_nmos w=0.5u l=0.45u m=1
MNGb_MXP_S2_12_1 NGb_MXP_n1_25 NGb_bp2 NGb_MXP_n2_12 vss sg13_hv_nmos w=0.5u l=0.45u m=1
MNGb_MXP_S2_13_0 NGb_MXP_n1_26 NGb_bbp2 NGb_MXP_n2_13 vss sg13_hv_nmos w=0.5u l=0.45u m=1
MNGb_MXP_S2_13_1 NGb_MXP_n1_27 NGb_bp2 NGb_MXP_n2_13 vss sg13_hv_nmos w=0.5u l=0.45u m=1
MNGb_MXP_S2_14_0 NGb_MXP_n1_28 NGb_bbp2 NGb_MXP_n2_14 vss sg13_hv_nmos w=0.5u l=0.45u m=1
MNGb_MXP_S2_14_1 NGb_MXP_n1_29 NGb_bp2 NGb_MXP_n2_14 vss sg13_hv_nmos w=0.5u l=0.45u m=1
MNGb_MXP_S2_15_0 NGb_MXP_n1_30 NGb_bbp2 NGb_MXP_n2_15 vss sg13_hv_nmos w=0.5u l=0.45u m=1
MNGb_MXP_S2_15_1 NGb_MXP_n1_31 NGb_bp2 NGb_MXP_n2_15 vss sg13_hv_nmos w=0.5u l=0.45u m=1
MNGb_MXP_S2_16_0 NGb_MXP_n1_32 NGb_bbp2 NGb_MXP_n2_16 vss sg13_hv_nmos w=0.5u l=0.45u m=1
MNGb_MXP_S2_16_1 NGb_MXP_n1_33 NGb_bp2 NGb_MXP_n2_16 vss sg13_hv_nmos w=0.5u l=0.45u m=1
MNGb_MXP_S2_17_0 NGb_MXP_n1_34 NGb_bbp2 NGb_MXP_n2_17 vss sg13_hv_nmos w=0.5u l=0.45u m=1
MNGb_MXP_S2_17_1 NGb_MXP_n1_35 NGb_bp2 NGb_MXP_n2_17 vss sg13_hv_nmos w=0.5u l=0.45u m=1
MNGb_MXP_S2_18_0 NGb_MXP_n1_36 NGb_bbp2 NGb_MXP_n2_18 vss sg13_hv_nmos w=0.5u l=0.45u m=1
MNGb_MXP_S2_18_1 NGb_MXP_n1_37 NGb_bp2 NGb_MXP_n2_18 vss sg13_hv_nmos w=0.5u l=0.45u m=1
MNGb_MXP_S2_19_0 NGb_MXP_n1_38 NGb_bbp2 NGb_MXP_n2_19 vss sg13_hv_nmos w=0.5u l=0.45u m=1
MNGb_MXP_S2_19_1 NGb_MXP_n1_39 NGb_bp2 NGb_MXP_n2_19 vss sg13_hv_nmos w=0.5u l=0.45u m=1
MNGb_MXP_S2_20_0 NGb_MXP_n1_40 NGb_bbp2 NGb_MXP_n2_20 vss sg13_hv_nmos w=0.5u l=0.45u m=1
MNGb_MXP_S2_20_1 NGb_MXP_n1_41 NGb_bp2 NGb_MXP_n2_20 vss sg13_hv_nmos w=0.5u l=0.45u m=1
MNGb_MXP_S2_21_0 NGb_MXP_n1_42 NGb_bbp2 NGb_MXP_n2_21 vss sg13_hv_nmos w=0.5u l=0.45u m=1
MNGb_MXP_S2_21_1 NGb_MXP_n1_43 NGb_bp2 NGb_MXP_n2_21 vss sg13_hv_nmos w=0.5u l=0.45u m=1
MNGb_MXP_S2_22_0 NGb_MXP_n1_44 NGb_bbp2 NGb_MXP_n2_22 vss sg13_hv_nmos w=0.5u l=0.45u m=1
MNGb_MXP_S2_22_1 NGb_MXP_n1_45 NGb_bp2 NGb_MXP_n2_22 vss sg13_hv_nmos w=0.5u l=0.45u m=1
MNGb_MXP_S2_23_0 NGb_MXP_n1_46 NGb_bbp2 NGb_MXP_n2_23 vss sg13_hv_nmos w=0.5u l=0.45u m=1
MNGb_MXP_S2_23_1 NGb_MXP_n1_47 NGb_bp2 NGb_MXP_n2_23 vss sg13_hv_nmos w=0.5u l=0.45u m=1
MNGb_MXP_S2_24_0 NGb_MXP_n1_48 NGb_bbp2 NGb_MXP_n2_24 vss sg13_hv_nmos w=0.5u l=0.45u m=1
MNGb_MXP_S2_24_1 NGb_MXP_n1_49 NGb_bp2 NGb_MXP_n2_24 vss sg13_hv_nmos w=0.5u l=0.45u m=1
MNGb_MXP_S2_25_0 NGb_MXP_n1_50 NGb_bbp2 NGb_MXP_n2_25 vss sg13_hv_nmos w=0.5u l=0.45u m=1
MNGb_MXP_S2_25_1 NGb_MXP_n1_51 NGb_bp2 NGb_MXP_n2_25 vss sg13_hv_nmos w=0.5u l=0.45u m=1
MNGb_MXP_S2_26_0 NGb_MXP_n1_52 NGb_bbp2 NGb_MXP_n2_26 vss sg13_hv_nmos w=0.5u l=0.45u m=1
MNGb_MXP_S2_26_1 NGb_MXP_n1_53 NGb_bp2 NGb_MXP_n2_26 vss sg13_hv_nmos w=0.5u l=0.45u m=1
MNGb_MXP_S2_27_0 NGb_MXP_n1_54 NGb_bbp2 NGb_MXP_n2_27 vss sg13_hv_nmos w=0.5u l=0.45u m=1
MNGb_MXP_S2_27_1 NGb_MXP_n1_55 NGb_bp2 NGb_MXP_n2_27 vss sg13_hv_nmos w=0.5u l=0.45u m=1
MNGb_MXP_S2_28_0 NGb_MXP_n1_56 NGb_bbp2 NGb_MXP_n2_28 vss sg13_hv_nmos w=0.5u l=0.45u m=1
MNGb_MXP_S2_28_1 NGb_MXP_n1_57 NGb_bp2 NGb_MXP_n2_28 vss sg13_hv_nmos w=0.5u l=0.45u m=1
MNGb_MXP_S2_29_0 NGb_MXP_n1_58 NGb_bbp2 NGb_MXP_n2_29 vss sg13_hv_nmos w=0.5u l=0.45u m=1
MNGb_MXP_S2_29_1 NGb_MXP_n1_59 NGb_bp2 NGb_MXP_n2_29 vss sg13_hv_nmos w=0.5u l=0.45u m=1
MNGb_MXP_S2_30_0 NGb_MXP_n1_60 NGb_bbp2 NGb_MXP_n2_30 vss sg13_hv_nmos w=0.5u l=0.45u m=1
MNGb_MXP_S2_30_1 NGb_MXP_n1_61 NGb_bp2 NGb_MXP_n2_30 vss sg13_hv_nmos w=0.5u l=0.45u m=1
MNGb_MXP_S2_31_0 NGb_MXP_n1_62 NGb_bbp2 NGb_MXP_n2_31 vss sg13_hv_nmos w=0.5u l=0.45u m=1
MNGb_MXP_S2_31_1 NGb_MXP_n1_63 NGb_bp2 NGb_MXP_n2_31 vss sg13_hv_nmos w=0.5u l=0.45u m=1
MNGb_MXP_S3_0_0 NGb_MXP_n2_0 NGb_bbp3 NGb_MXP_n3_0 vss sg13_hv_nmos w=0.5u l=0.45u m=1
MNGb_MXP_S3_0_1 NGb_MXP_n2_1 NGb_bp3 NGb_MXP_n3_0 vss sg13_hv_nmos w=0.5u l=0.45u m=1
MNGb_MXP_S3_1_0 NGb_MXP_n2_2 NGb_bbp3 NGb_MXP_n3_1 vss sg13_hv_nmos w=0.5u l=0.45u m=1
MNGb_MXP_S3_1_1 NGb_MXP_n2_3 NGb_bp3 NGb_MXP_n3_1 vss sg13_hv_nmos w=0.5u l=0.45u m=1
MNGb_MXP_S3_2_0 NGb_MXP_n2_4 NGb_bbp3 NGb_MXP_n3_2 vss sg13_hv_nmos w=0.5u l=0.45u m=1
MNGb_MXP_S3_2_1 NGb_MXP_n2_5 NGb_bp3 NGb_MXP_n3_2 vss sg13_hv_nmos w=0.5u l=0.45u m=1
MNGb_MXP_S3_3_0 NGb_MXP_n2_6 NGb_bbp3 NGb_MXP_n3_3 vss sg13_hv_nmos w=0.5u l=0.45u m=1
MNGb_MXP_S3_3_1 NGb_MXP_n2_7 NGb_bp3 NGb_MXP_n3_3 vss sg13_hv_nmos w=0.5u l=0.45u m=1
MNGb_MXP_S3_4_0 NGb_MXP_n2_8 NGb_bbp3 NGb_MXP_n3_4 vss sg13_hv_nmos w=0.5u l=0.45u m=1
MNGb_MXP_S3_4_1 NGb_MXP_n2_9 NGb_bp3 NGb_MXP_n3_4 vss sg13_hv_nmos w=0.5u l=0.45u m=1
MNGb_MXP_S3_5_0 NGb_MXP_n2_10 NGb_bbp3 NGb_MXP_n3_5 vss sg13_hv_nmos w=0.5u l=0.45u m=1
MNGb_MXP_S3_5_1 NGb_MXP_n2_11 NGb_bp3 NGb_MXP_n3_5 vss sg13_hv_nmos w=0.5u l=0.45u m=1
MNGb_MXP_S3_6_0 NGb_MXP_n2_12 NGb_bbp3 NGb_MXP_n3_6 vss sg13_hv_nmos w=0.5u l=0.45u m=1
MNGb_MXP_S3_6_1 NGb_MXP_n2_13 NGb_bp3 NGb_MXP_n3_6 vss sg13_hv_nmos w=0.5u l=0.45u m=1
MNGb_MXP_S3_7_0 NGb_MXP_n2_14 NGb_bbp3 NGb_MXP_n3_7 vss sg13_hv_nmos w=0.5u l=0.45u m=1
MNGb_MXP_S3_7_1 NGb_MXP_n2_15 NGb_bp3 NGb_MXP_n3_7 vss sg13_hv_nmos w=0.5u l=0.45u m=1
MNGb_MXP_S3_8_0 NGb_MXP_n2_16 NGb_bbp3 NGb_MXP_n3_8 vss sg13_hv_nmos w=0.5u l=0.45u m=1
MNGb_MXP_S3_8_1 NGb_MXP_n2_17 NGb_bp3 NGb_MXP_n3_8 vss sg13_hv_nmos w=0.5u l=0.45u m=1
MNGb_MXP_S3_9_0 NGb_MXP_n2_18 NGb_bbp3 NGb_MXP_n3_9 vss sg13_hv_nmos w=0.5u l=0.45u m=1
MNGb_MXP_S3_9_1 NGb_MXP_n2_19 NGb_bp3 NGb_MXP_n3_9 vss sg13_hv_nmos w=0.5u l=0.45u m=1
MNGb_MXP_S3_10_0 NGb_MXP_n2_20 NGb_bbp3 NGb_MXP_n3_10 vss sg13_hv_nmos w=0.5u l=0.45u m=1
MNGb_MXP_S3_10_1 NGb_MXP_n2_21 NGb_bp3 NGb_MXP_n3_10 vss sg13_hv_nmos w=0.5u l=0.45u m=1
MNGb_MXP_S3_11_0 NGb_MXP_n2_22 NGb_bbp3 NGb_MXP_n3_11 vss sg13_hv_nmos w=0.5u l=0.45u m=1
MNGb_MXP_S3_11_1 NGb_MXP_n2_23 NGb_bp3 NGb_MXP_n3_11 vss sg13_hv_nmos w=0.5u l=0.45u m=1
MNGb_MXP_S3_12_0 NGb_MXP_n2_24 NGb_bbp3 NGb_MXP_n3_12 vss sg13_hv_nmos w=0.5u l=0.45u m=1
MNGb_MXP_S3_12_1 NGb_MXP_n2_25 NGb_bp3 NGb_MXP_n3_12 vss sg13_hv_nmos w=0.5u l=0.45u m=1
MNGb_MXP_S3_13_0 NGb_MXP_n2_26 NGb_bbp3 NGb_MXP_n3_13 vss sg13_hv_nmos w=0.5u l=0.45u m=1
MNGb_MXP_S3_13_1 NGb_MXP_n2_27 NGb_bp3 NGb_MXP_n3_13 vss sg13_hv_nmos w=0.5u l=0.45u m=1
MNGb_MXP_S3_14_0 NGb_MXP_n2_28 NGb_bbp3 NGb_MXP_n3_14 vss sg13_hv_nmos w=0.5u l=0.45u m=1
MNGb_MXP_S3_14_1 NGb_MXP_n2_29 NGb_bp3 NGb_MXP_n3_14 vss sg13_hv_nmos w=0.5u l=0.45u m=1
MNGb_MXP_S3_15_0 NGb_MXP_n2_30 NGb_bbp3 NGb_MXP_n3_15 vss sg13_hv_nmos w=0.5u l=0.45u m=1
MNGb_MXP_S3_15_1 NGb_MXP_n2_31 NGb_bp3 NGb_MXP_n3_15 vss sg13_hv_nmos w=0.5u l=0.45u m=1
MNGb_MXP_S4_0_0 NGb_MXP_n3_0 NGb_bbp4 NGb_MXP_n4_0 vss sg13_hv_nmos w=0.5u l=0.45u m=1
MNGb_MXP_S4_0_1 NGb_MXP_n3_1 NGb_bp4 NGb_MXP_n4_0 vss sg13_hv_nmos w=0.5u l=0.45u m=1
MNGb_MXP_S4_1_0 NGb_MXP_n3_2 NGb_bbp4 NGb_MXP_n4_1 vss sg13_hv_nmos w=0.5u l=0.45u m=1
MNGb_MXP_S4_1_1 NGb_MXP_n3_3 NGb_bp4 NGb_MXP_n4_1 vss sg13_hv_nmos w=0.5u l=0.45u m=1
MNGb_MXP_S4_2_0 NGb_MXP_n3_4 NGb_bbp4 NGb_MXP_n4_2 vss sg13_hv_nmos w=0.5u l=0.45u m=1
MNGb_MXP_S4_2_1 NGb_MXP_n3_5 NGb_bp4 NGb_MXP_n4_2 vss sg13_hv_nmos w=0.5u l=0.45u m=1
MNGb_MXP_S4_3_0 NGb_MXP_n3_6 NGb_bbp4 NGb_MXP_n4_3 vss sg13_hv_nmos w=0.5u l=0.45u m=1
MNGb_MXP_S4_3_1 NGb_MXP_n3_7 NGb_bp4 NGb_MXP_n4_3 vss sg13_hv_nmos w=0.5u l=0.45u m=1
MNGb_MXP_S4_4_0 NGb_MXP_n3_8 NGb_bbp4 NGb_MXP_n4_4 vss sg13_hv_nmos w=0.5u l=0.45u m=1
MNGb_MXP_S4_4_1 NGb_MXP_n3_9 NGb_bp4 NGb_MXP_n4_4 vss sg13_hv_nmos w=0.5u l=0.45u m=1
MNGb_MXP_S4_5_0 NGb_MXP_n3_10 NGb_bbp4 NGb_MXP_n4_5 vss sg13_hv_nmos w=0.5u l=0.45u m=1
MNGb_MXP_S4_5_1 NGb_MXP_n3_11 NGb_bp4 NGb_MXP_n4_5 vss sg13_hv_nmos w=0.5u l=0.45u m=1
MNGb_MXP_S4_6_0 NGb_MXP_n3_12 NGb_bbp4 NGb_MXP_n4_6 vss sg13_hv_nmos w=0.5u l=0.45u m=1
MNGb_MXP_S4_6_1 NGb_MXP_n3_13 NGb_bp4 NGb_MXP_n4_6 vss sg13_hv_nmos w=0.5u l=0.45u m=1
MNGb_MXP_S4_7_0 NGb_MXP_n3_14 NGb_bbp4 NGb_MXP_n4_7 vss sg13_hv_nmos w=0.5u l=0.45u m=1
MNGb_MXP_S4_7_1 NGb_MXP_n3_15 NGb_bp4 NGb_MXP_n4_7 vss sg13_hv_nmos w=0.5u l=0.45u m=1
MNGb_MXP_S5_0_0 NGb_MXP_n4_0 NGb_bbp5 NGb_MXP_n5_0 vss sg13_hv_nmos w=0.5u l=0.45u m=1
MNGb_MXP_S5_0_1 NGb_MXP_n4_1 NGb_bp5 NGb_MXP_n5_0 vss sg13_hv_nmos w=0.5u l=0.45u m=1
MNGb_MXP_S5_1_0 NGb_MXP_n4_2 NGb_bbp5 NGb_MXP_n5_1 vss sg13_hv_nmos w=0.5u l=0.45u m=1
MNGb_MXP_S5_1_1 NGb_MXP_n4_3 NGb_bp5 NGb_MXP_n5_1 vss sg13_hv_nmos w=0.5u l=0.45u m=1
MNGb_MXP_S5_2_0 NGb_MXP_n4_4 NGb_bbp5 NGb_MXP_n5_2 vss sg13_hv_nmos w=0.5u l=0.45u m=1
MNGb_MXP_S5_2_1 NGb_MXP_n4_5 NGb_bp5 NGb_MXP_n5_2 vss sg13_hv_nmos w=0.5u l=0.45u m=1
MNGb_MXP_S5_3_0 NGb_MXP_n4_6 NGb_bbp5 NGb_MXP_n5_3 vss sg13_hv_nmos w=0.5u l=0.45u m=1
MNGb_MXP_S5_3_1 NGb_MXP_n4_7 NGb_bp5 NGb_MXP_n5_3 vss sg13_hv_nmos w=0.5u l=0.45u m=1
MNGb_MXP_S6_0_0 NGb_MXP_n5_0 NGb_bbp6 NGb_MXP_n6_0 vss sg13_hv_nmos w=0.5u l=0.45u m=1
MNGb_MXP_S6_0_1 NGb_MXP_n5_1 NGb_bp6 NGb_MXP_n6_0 vss sg13_hv_nmos w=0.5u l=0.45u m=1
MNGb_MXP_S6_1_0 NGb_MXP_n5_2 NGb_bbp6 NGb_MXP_n6_1 vss sg13_hv_nmos w=0.5u l=0.45u m=1
MNGb_MXP_S6_1_1 NGb_MXP_n5_3 NGb_bp6 NGb_MXP_n6_1 vss sg13_hv_nmos w=0.5u l=0.45u m=1
MNGb_MXP_S7_0_0 NGb_MXP_n6_0 NGb_bbp7 NGb_refp vss sg13_hv_nmos w=0.5u l=0.45u m=1
MNGb_MXP_S7_0_1 NGb_MXP_n6_1 NGb_bp7 NGb_refp vss sg13_hv_nmos w=0.5u l=0.45u m=1
MNGb_MXN_S0_0_0 vss NGb_bbn0 NGb_MXN_n0_0 vss sg13_hv_nmos w=0.5u l=0.45u m=1
MNGb_MXN_S0_0_1 t1 NGb_bn0 NGb_MXN_n0_0 vss sg13_hv_nmos w=0.5u l=0.45u m=1
MNGb_MXN_S0_1_0 t2 NGb_bbn0 NGb_MXN_n0_1 vss sg13_hv_nmos w=0.5u l=0.45u m=1
MNGb_MXN_S0_1_1 t3 NGb_bn0 NGb_MXN_n0_1 vss sg13_hv_nmos w=0.5u l=0.45u m=1
MNGb_MXN_S0_2_0 t4 NGb_bbn0 NGb_MXN_n0_2 vss sg13_hv_nmos w=0.5u l=0.45u m=1
MNGb_MXN_S0_2_1 t5 NGb_bn0 NGb_MXN_n0_2 vss sg13_hv_nmos w=0.5u l=0.45u m=1
MNGb_MXN_S0_3_0 t6 NGb_bbn0 NGb_MXN_n0_3 vss sg13_hv_nmos w=0.5u l=0.45u m=1
MNGb_MXN_S0_3_1 t7 NGb_bn0 NGb_MXN_n0_3 vss sg13_hv_nmos w=0.5u l=0.45u m=1
MNGb_MXN_S0_4_0 t8 NGb_bbn0 NGb_MXN_n0_4 vss sg13_hv_nmos w=0.5u l=0.45u m=1
MNGb_MXN_S0_4_1 t9 NGb_bn0 NGb_MXN_n0_4 vss sg13_hv_nmos w=0.5u l=0.45u m=1
MNGb_MXN_S0_5_0 t10 NGb_bbn0 NGb_MXN_n0_5 vss sg13_hv_nmos w=0.5u l=0.45u m=1
MNGb_MXN_S0_5_1 t11 NGb_bn0 NGb_MXN_n0_5 vss sg13_hv_nmos w=0.5u l=0.45u m=1
MNGb_MXN_S0_6_0 t12 NGb_bbn0 NGb_MXN_n0_6 vss sg13_hv_nmos w=0.5u l=0.45u m=1
MNGb_MXN_S0_6_1 t13 NGb_bn0 NGb_MXN_n0_6 vss sg13_hv_nmos w=0.5u l=0.45u m=1
MNGb_MXN_S0_7_0 t14 NGb_bbn0 NGb_MXN_n0_7 vss sg13_hv_nmos w=0.5u l=0.45u m=1
MNGb_MXN_S0_7_1 t15 NGb_bn0 NGb_MXN_n0_7 vss sg13_hv_nmos w=0.5u l=0.45u m=1
MNGb_MXN_S0_8_0 t16 NGb_bbn0 NGb_MXN_n0_8 vss sg13_hv_nmos w=0.5u l=0.45u m=1
MNGb_MXN_S0_8_1 t17 NGb_bn0 NGb_MXN_n0_8 vss sg13_hv_nmos w=0.5u l=0.45u m=1
MNGb_MXN_S0_9_0 t18 NGb_bbn0 NGb_MXN_n0_9 vss sg13_hv_nmos w=0.5u l=0.45u m=1
MNGb_MXN_S0_9_1 t19 NGb_bn0 NGb_MXN_n0_9 vss sg13_hv_nmos w=0.5u l=0.45u m=1
MNGb_MXN_S0_10_0 t20 NGb_bbn0 NGb_MXN_n0_10 vss sg13_hv_nmos w=0.5u l=0.45u m=1
MNGb_MXN_S0_10_1 t21 NGb_bn0 NGb_MXN_n0_10 vss sg13_hv_nmos w=0.5u l=0.45u m=1
MNGb_MXN_S0_11_0 t22 NGb_bbn0 NGb_MXN_n0_11 vss sg13_hv_nmos w=0.5u l=0.45u m=1
MNGb_MXN_S0_11_1 t23 NGb_bn0 NGb_MXN_n0_11 vss sg13_hv_nmos w=0.5u l=0.45u m=1
MNGb_MXN_S0_12_0 t24 NGb_bbn0 NGb_MXN_n0_12 vss sg13_hv_nmos w=0.5u l=0.45u m=1
MNGb_MXN_S0_12_1 t25 NGb_bn0 NGb_MXN_n0_12 vss sg13_hv_nmos w=0.5u l=0.45u m=1
MNGb_MXN_S0_13_0 t26 NGb_bbn0 NGb_MXN_n0_13 vss sg13_hv_nmos w=0.5u l=0.45u m=1
MNGb_MXN_S0_13_1 t27 NGb_bn0 NGb_MXN_n0_13 vss sg13_hv_nmos w=0.5u l=0.45u m=1
MNGb_MXN_S0_14_0 t28 NGb_bbn0 NGb_MXN_n0_14 vss sg13_hv_nmos w=0.5u l=0.45u m=1
MNGb_MXN_S0_14_1 t29 NGb_bn0 NGb_MXN_n0_14 vss sg13_hv_nmos w=0.5u l=0.45u m=1
MNGb_MXN_S0_15_0 t30 NGb_bbn0 NGb_MXN_n0_15 vss sg13_hv_nmos w=0.5u l=0.45u m=1
MNGb_MXN_S0_15_1 t31 NGb_bn0 NGb_MXN_n0_15 vss sg13_hv_nmos w=0.5u l=0.45u m=1
MNGb_MXN_S0_16_0 t32 NGb_bbn0 NGb_MXN_n0_16 vss sg13_hv_nmos w=0.5u l=0.45u m=1
MNGb_MXN_S0_16_1 t33 NGb_bn0 NGb_MXN_n0_16 vss sg13_hv_nmos w=0.5u l=0.45u m=1
MNGb_MXN_S0_17_0 t34 NGb_bbn0 NGb_MXN_n0_17 vss sg13_hv_nmos w=0.5u l=0.45u m=1
MNGb_MXN_S0_17_1 t35 NGb_bn0 NGb_MXN_n0_17 vss sg13_hv_nmos w=0.5u l=0.45u m=1
MNGb_MXN_S0_18_0 t36 NGb_bbn0 NGb_MXN_n0_18 vss sg13_hv_nmos w=0.5u l=0.45u m=1
MNGb_MXN_S0_18_1 t37 NGb_bn0 NGb_MXN_n0_18 vss sg13_hv_nmos w=0.5u l=0.45u m=1
MNGb_MXN_S0_19_0 t38 NGb_bbn0 NGb_MXN_n0_19 vss sg13_hv_nmos w=0.5u l=0.45u m=1
MNGb_MXN_S0_19_1 t39 NGb_bn0 NGb_MXN_n0_19 vss sg13_hv_nmos w=0.5u l=0.45u m=1
MNGb_MXN_S0_20_0 t40 NGb_bbn0 NGb_MXN_n0_20 vss sg13_hv_nmos w=0.5u l=0.45u m=1
MNGb_MXN_S0_20_1 t41 NGb_bn0 NGb_MXN_n0_20 vss sg13_hv_nmos w=0.5u l=0.45u m=1
MNGb_MXN_S0_21_0 t42 NGb_bbn0 NGb_MXN_n0_21 vss sg13_hv_nmos w=0.5u l=0.45u m=1
MNGb_MXN_S0_21_1 t43 NGb_bn0 NGb_MXN_n0_21 vss sg13_hv_nmos w=0.5u l=0.45u m=1
MNGb_MXN_S0_22_0 t44 NGb_bbn0 NGb_MXN_n0_22 vss sg13_hv_nmos w=0.5u l=0.45u m=1
MNGb_MXN_S0_22_1 t45 NGb_bn0 NGb_MXN_n0_22 vss sg13_hv_nmos w=0.5u l=0.45u m=1
MNGb_MXN_S0_23_0 t46 NGb_bbn0 NGb_MXN_n0_23 vss sg13_hv_nmos w=0.5u l=0.45u m=1
MNGb_MXN_S0_23_1 t47 NGb_bn0 NGb_MXN_n0_23 vss sg13_hv_nmos w=0.5u l=0.45u m=1
MNGb_MXN_S0_24_0 t48 NGb_bbn0 NGb_MXN_n0_24 vss sg13_hv_nmos w=0.5u l=0.45u m=1
MNGb_MXN_S0_24_1 t49 NGb_bn0 NGb_MXN_n0_24 vss sg13_hv_nmos w=0.5u l=0.45u m=1
MNGb_MXN_S0_25_0 t50 NGb_bbn0 NGb_MXN_n0_25 vss sg13_hv_nmos w=0.5u l=0.45u m=1
MNGb_MXN_S0_25_1 t51 NGb_bn0 NGb_MXN_n0_25 vss sg13_hv_nmos w=0.5u l=0.45u m=1
MNGb_MXN_S0_26_0 t52 NGb_bbn0 NGb_MXN_n0_26 vss sg13_hv_nmos w=0.5u l=0.45u m=1
MNGb_MXN_S0_26_1 t53 NGb_bn0 NGb_MXN_n0_26 vss sg13_hv_nmos w=0.5u l=0.45u m=1
MNGb_MXN_S0_27_0 t54 NGb_bbn0 NGb_MXN_n0_27 vss sg13_hv_nmos w=0.5u l=0.45u m=1
MNGb_MXN_S0_27_1 t55 NGb_bn0 NGb_MXN_n0_27 vss sg13_hv_nmos w=0.5u l=0.45u m=1
MNGb_MXN_S0_28_0 t56 NGb_bbn0 NGb_MXN_n0_28 vss sg13_hv_nmos w=0.5u l=0.45u m=1
MNGb_MXN_S0_28_1 t57 NGb_bn0 NGb_MXN_n0_28 vss sg13_hv_nmos w=0.5u l=0.45u m=1
MNGb_MXN_S0_29_0 t58 NGb_bbn0 NGb_MXN_n0_29 vss sg13_hv_nmos w=0.5u l=0.45u m=1
MNGb_MXN_S0_29_1 t59 NGb_bn0 NGb_MXN_n0_29 vss sg13_hv_nmos w=0.5u l=0.45u m=1
MNGb_MXN_S0_30_0 t60 NGb_bbn0 NGb_MXN_n0_30 vss sg13_hv_nmos w=0.5u l=0.45u m=1
MNGb_MXN_S0_30_1 t61 NGb_bn0 NGb_MXN_n0_30 vss sg13_hv_nmos w=0.5u l=0.45u m=1
MNGb_MXN_S0_31_0 t62 NGb_bbn0 NGb_MXN_n0_31 vss sg13_hv_nmos w=0.5u l=0.45u m=1
MNGb_MXN_S0_31_1 t63 NGb_bn0 NGb_MXN_n0_31 vss sg13_hv_nmos w=0.5u l=0.45u m=1
MNGb_MXN_S0_32_0 t64 NGb_bbn0 NGb_MXN_n0_32 vss sg13_hv_nmos w=0.5u l=0.45u m=1
MNGb_MXN_S0_32_1 t65 NGb_bn0 NGb_MXN_n0_32 vss sg13_hv_nmos w=0.5u l=0.45u m=1
MNGb_MXN_S0_33_0 t66 NGb_bbn0 NGb_MXN_n0_33 vss sg13_hv_nmos w=0.5u l=0.45u m=1
MNGb_MXN_S0_33_1 t67 NGb_bn0 NGb_MXN_n0_33 vss sg13_hv_nmos w=0.5u l=0.45u m=1
MNGb_MXN_S0_34_0 t68 NGb_bbn0 NGb_MXN_n0_34 vss sg13_hv_nmos w=0.5u l=0.45u m=1
MNGb_MXN_S0_34_1 t69 NGb_bn0 NGb_MXN_n0_34 vss sg13_hv_nmos w=0.5u l=0.45u m=1
MNGb_MXN_S0_35_0 t70 NGb_bbn0 NGb_MXN_n0_35 vss sg13_hv_nmos w=0.5u l=0.45u m=1
MNGb_MXN_S0_35_1 t71 NGb_bn0 NGb_MXN_n0_35 vss sg13_hv_nmos w=0.5u l=0.45u m=1
MNGb_MXN_S0_36_0 t72 NGb_bbn0 NGb_MXN_n0_36 vss sg13_hv_nmos w=0.5u l=0.45u m=1
MNGb_MXN_S0_36_1 t73 NGb_bn0 NGb_MXN_n0_36 vss sg13_hv_nmos w=0.5u l=0.45u m=1
MNGb_MXN_S0_37_0 t74 NGb_bbn0 NGb_MXN_n0_37 vss sg13_hv_nmos w=0.5u l=0.45u m=1
MNGb_MXN_S0_37_1 t75 NGb_bn0 NGb_MXN_n0_37 vss sg13_hv_nmos w=0.5u l=0.45u m=1
MNGb_MXN_S0_38_0 t76 NGb_bbn0 NGb_MXN_n0_38 vss sg13_hv_nmos w=0.5u l=0.45u m=1
MNGb_MXN_S0_38_1 t77 NGb_bn0 NGb_MXN_n0_38 vss sg13_hv_nmos w=0.5u l=0.45u m=1
MNGb_MXN_S0_39_0 t78 NGb_bbn0 NGb_MXN_n0_39 vss sg13_hv_nmos w=0.5u l=0.45u m=1
MNGb_MXN_S0_39_1 t79 NGb_bn0 NGb_MXN_n0_39 vss sg13_hv_nmos w=0.5u l=0.45u m=1
MNGb_MXN_S0_40_0 t80 NGb_bbn0 NGb_MXN_n0_40 vss sg13_hv_nmos w=0.5u l=0.45u m=1
MNGb_MXN_S0_40_1 t81 NGb_bn0 NGb_MXN_n0_40 vss sg13_hv_nmos w=0.5u l=0.45u m=1
MNGb_MXN_S0_41_0 t82 NGb_bbn0 NGb_MXN_n0_41 vss sg13_hv_nmos w=0.5u l=0.45u m=1
MNGb_MXN_S0_41_1 t83 NGb_bn0 NGb_MXN_n0_41 vss sg13_hv_nmos w=0.5u l=0.45u m=1
MNGb_MXN_S0_42_0 t84 NGb_bbn0 NGb_MXN_n0_42 vss sg13_hv_nmos w=0.5u l=0.45u m=1
MNGb_MXN_S0_42_1 t85 NGb_bn0 NGb_MXN_n0_42 vss sg13_hv_nmos w=0.5u l=0.45u m=1
MNGb_MXN_S0_43_0 t86 NGb_bbn0 NGb_MXN_n0_43 vss sg13_hv_nmos w=0.5u l=0.45u m=1
MNGb_MXN_S0_43_1 t87 NGb_bn0 NGb_MXN_n0_43 vss sg13_hv_nmos w=0.5u l=0.45u m=1
MNGb_MXN_S0_44_0 t88 NGb_bbn0 NGb_MXN_n0_44 vss sg13_hv_nmos w=0.5u l=0.45u m=1
MNGb_MXN_S0_44_1 t89 NGb_bn0 NGb_MXN_n0_44 vss sg13_hv_nmos w=0.5u l=0.45u m=1
MNGb_MXN_S0_45_0 t90 NGb_bbn0 NGb_MXN_n0_45 vss sg13_hv_nmos w=0.5u l=0.45u m=1
MNGb_MXN_S0_45_1 t91 NGb_bn0 NGb_MXN_n0_45 vss sg13_hv_nmos w=0.5u l=0.45u m=1
MNGb_MXN_S0_46_0 t92 NGb_bbn0 NGb_MXN_n0_46 vss sg13_hv_nmos w=0.5u l=0.45u m=1
MNGb_MXN_S0_46_1 t93 NGb_bn0 NGb_MXN_n0_46 vss sg13_hv_nmos w=0.5u l=0.45u m=1
MNGb_MXN_S0_47_0 t94 NGb_bbn0 NGb_MXN_n0_47 vss sg13_hv_nmos w=0.5u l=0.45u m=1
MNGb_MXN_S0_47_1 t95 NGb_bn0 NGb_MXN_n0_47 vss sg13_hv_nmos w=0.5u l=0.45u m=1
MNGb_MXN_S0_48_0 t96 NGb_bbn0 NGb_MXN_n0_48 vss sg13_hv_nmos w=0.5u l=0.45u m=1
MNGb_MXN_S0_48_1 t97 NGb_bn0 NGb_MXN_n0_48 vss sg13_hv_nmos w=0.5u l=0.45u m=1
MNGb_MXN_S0_49_0 t98 NGb_bbn0 NGb_MXN_n0_49 vss sg13_hv_nmos w=0.5u l=0.45u m=1
MNGb_MXN_S0_49_1 t99 NGb_bn0 NGb_MXN_n0_49 vss sg13_hv_nmos w=0.5u l=0.45u m=1
MNGb_MXN_S0_50_0 t100 NGb_bbn0 NGb_MXN_n0_50 vss sg13_hv_nmos w=0.5u l=0.45u m=1
MNGb_MXN_S0_50_1 t101 NGb_bn0 NGb_MXN_n0_50 vss sg13_hv_nmos w=0.5u l=0.45u m=1
MNGb_MXN_S0_51_0 t102 NGb_bbn0 NGb_MXN_n0_51 vss sg13_hv_nmos w=0.5u l=0.45u m=1
MNGb_MXN_S0_51_1 t103 NGb_bn0 NGb_MXN_n0_51 vss sg13_hv_nmos w=0.5u l=0.45u m=1
MNGb_MXN_S0_52_0 t104 NGb_bbn0 NGb_MXN_n0_52 vss sg13_hv_nmos w=0.5u l=0.45u m=1
MNGb_MXN_S0_52_1 t105 NGb_bn0 NGb_MXN_n0_52 vss sg13_hv_nmos w=0.5u l=0.45u m=1
MNGb_MXN_S0_53_0 t106 NGb_bbn0 NGb_MXN_n0_53 vss sg13_hv_nmos w=0.5u l=0.45u m=1
MNGb_MXN_S0_53_1 t107 NGb_bn0 NGb_MXN_n0_53 vss sg13_hv_nmos w=0.5u l=0.45u m=1
MNGb_MXN_S0_54_0 t108 NGb_bbn0 NGb_MXN_n0_54 vss sg13_hv_nmos w=0.5u l=0.45u m=1
MNGb_MXN_S0_54_1 t109 NGb_bn0 NGb_MXN_n0_54 vss sg13_hv_nmos w=0.5u l=0.45u m=1
MNGb_MXN_S0_55_0 t110 NGb_bbn0 NGb_MXN_n0_55 vss sg13_hv_nmos w=0.5u l=0.45u m=1
MNGb_MXN_S0_55_1 t111 NGb_bn0 NGb_MXN_n0_55 vss sg13_hv_nmos w=0.5u l=0.45u m=1
MNGb_MXN_S0_56_0 t112 NGb_bbn0 NGb_MXN_n0_56 vss sg13_hv_nmos w=0.5u l=0.45u m=1
MNGb_MXN_S0_56_1 t113 NGb_bn0 NGb_MXN_n0_56 vss sg13_hv_nmos w=0.5u l=0.45u m=1
MNGb_MXN_S0_57_0 t114 NGb_bbn0 NGb_MXN_n0_57 vss sg13_hv_nmos w=0.5u l=0.45u m=1
MNGb_MXN_S0_57_1 t115 NGb_bn0 NGb_MXN_n0_57 vss sg13_hv_nmos w=0.5u l=0.45u m=1
MNGb_MXN_S0_58_0 t116 NGb_bbn0 NGb_MXN_n0_58 vss sg13_hv_nmos w=0.5u l=0.45u m=1
MNGb_MXN_S0_58_1 t117 NGb_bn0 NGb_MXN_n0_58 vss sg13_hv_nmos w=0.5u l=0.45u m=1
MNGb_MXN_S0_59_0 t118 NGb_bbn0 NGb_MXN_n0_59 vss sg13_hv_nmos w=0.5u l=0.45u m=1
MNGb_MXN_S0_59_1 t119 NGb_bn0 NGb_MXN_n0_59 vss sg13_hv_nmos w=0.5u l=0.45u m=1
MNGb_MXN_S0_60_0 t120 NGb_bbn0 NGb_MXN_n0_60 vss sg13_hv_nmos w=0.5u l=0.45u m=1
MNGb_MXN_S0_60_1 t121 NGb_bn0 NGb_MXN_n0_60 vss sg13_hv_nmos w=0.5u l=0.45u m=1
MNGb_MXN_S0_61_0 t122 NGb_bbn0 NGb_MXN_n0_61 vss sg13_hv_nmos w=0.5u l=0.45u m=1
MNGb_MXN_S0_61_1 t123 NGb_bn0 NGb_MXN_n0_61 vss sg13_hv_nmos w=0.5u l=0.45u m=1
MNGb_MXN_S0_62_0 t124 NGb_bbn0 NGb_MXN_n0_62 vss sg13_hv_nmos w=0.5u l=0.45u m=1
MNGb_MXN_S0_62_1 t125 NGb_bn0 NGb_MXN_n0_62 vss sg13_hv_nmos w=0.5u l=0.45u m=1
MNGb_MXN_S0_63_0 t126 NGb_bbn0 NGb_MXN_n0_63 vss sg13_hv_nmos w=0.5u l=0.45u m=1
MNGb_MXN_S0_63_1 t127 NGb_bn0 NGb_MXN_n0_63 vss sg13_hv_nmos w=0.5u l=0.45u m=1
MNGb_MXN_S0_64_0 t128 NGb_bbn0 NGb_MXN_n0_64 vss sg13_hv_nmos w=0.5u l=0.45u m=1
MNGb_MXN_S0_64_1 t129 NGb_bn0 NGb_MXN_n0_64 vss sg13_hv_nmos w=0.5u l=0.45u m=1
MNGb_MXN_S0_65_0 t130 NGb_bbn0 NGb_MXN_n0_65 vss sg13_hv_nmos w=0.5u l=0.45u m=1
MNGb_MXN_S0_65_1 t131 NGb_bn0 NGb_MXN_n0_65 vss sg13_hv_nmos w=0.5u l=0.45u m=1
MNGb_MXN_S0_66_0 t132 NGb_bbn0 NGb_MXN_n0_66 vss sg13_hv_nmos w=0.5u l=0.45u m=1
MNGb_MXN_S0_66_1 t133 NGb_bn0 NGb_MXN_n0_66 vss sg13_hv_nmos w=0.5u l=0.45u m=1
MNGb_MXN_S0_67_0 t134 NGb_bbn0 NGb_MXN_n0_67 vss sg13_hv_nmos w=0.5u l=0.45u m=1
MNGb_MXN_S0_67_1 t135 NGb_bn0 NGb_MXN_n0_67 vss sg13_hv_nmos w=0.5u l=0.45u m=1
MNGb_MXN_S0_68_0 t136 NGb_bbn0 NGb_MXN_n0_68 vss sg13_hv_nmos w=0.5u l=0.45u m=1
MNGb_MXN_S0_68_1 t137 NGb_bn0 NGb_MXN_n0_68 vss sg13_hv_nmos w=0.5u l=0.45u m=1
MNGb_MXN_S0_69_0 t138 NGb_bbn0 NGb_MXN_n0_69 vss sg13_hv_nmos w=0.5u l=0.45u m=1
MNGb_MXN_S0_69_1 t139 NGb_bn0 NGb_MXN_n0_69 vss sg13_hv_nmos w=0.5u l=0.45u m=1
MNGb_MXN_S0_70_0 t140 NGb_bbn0 NGb_MXN_n0_70 vss sg13_hv_nmos w=0.5u l=0.45u m=1
MNGb_MXN_S0_70_1 t141 NGb_bn0 NGb_MXN_n0_70 vss sg13_hv_nmos w=0.5u l=0.45u m=1
MNGb_MXN_S0_71_0 t142 NGb_bbn0 NGb_MXN_n0_71 vss sg13_hv_nmos w=0.5u l=0.45u m=1
MNGb_MXN_S0_71_1 t143 NGb_bn0 NGb_MXN_n0_71 vss sg13_hv_nmos w=0.5u l=0.45u m=1
MNGb_MXN_S0_72_0 t144 NGb_bbn0 NGb_MXN_n0_72 vss sg13_hv_nmos w=0.5u l=0.45u m=1
MNGb_MXN_S0_72_1 t145 NGb_bn0 NGb_MXN_n0_72 vss sg13_hv_nmos w=0.5u l=0.45u m=1
MNGb_MXN_S0_73_0 t146 NGb_bbn0 NGb_MXN_n0_73 vss sg13_hv_nmos w=0.5u l=0.45u m=1
MNGb_MXN_S0_73_1 t147 NGb_bn0 NGb_MXN_n0_73 vss sg13_hv_nmos w=0.5u l=0.45u m=1
MNGb_MXN_S0_74_0 t148 NGb_bbn0 NGb_MXN_n0_74 vss sg13_hv_nmos w=0.5u l=0.45u m=1
MNGb_MXN_S0_74_1 t149 NGb_bn0 NGb_MXN_n0_74 vss sg13_hv_nmos w=0.5u l=0.45u m=1
MNGb_MXN_S0_75_0 t150 NGb_bbn0 NGb_MXN_n0_75 vss sg13_hv_nmos w=0.5u l=0.45u m=1
MNGb_MXN_S0_75_1 t151 NGb_bn0 NGb_MXN_n0_75 vss sg13_hv_nmos w=0.5u l=0.45u m=1
MNGb_MXN_S0_76_0 t152 NGb_bbn0 NGb_MXN_n0_76 vss sg13_hv_nmos w=0.5u l=0.45u m=1
MNGb_MXN_S0_76_1 t153 NGb_bn0 NGb_MXN_n0_76 vss sg13_hv_nmos w=0.5u l=0.45u m=1
MNGb_MXN_S0_77_0 t154 NGb_bbn0 NGb_MXN_n0_77 vss sg13_hv_nmos w=0.5u l=0.45u m=1
MNGb_MXN_S0_77_1 t155 NGb_bn0 NGb_MXN_n0_77 vss sg13_hv_nmos w=0.5u l=0.45u m=1
MNGb_MXN_S0_78_0 t156 NGb_bbn0 NGb_MXN_n0_78 vss sg13_hv_nmos w=0.5u l=0.45u m=1
MNGb_MXN_S0_78_1 t157 NGb_bn0 NGb_MXN_n0_78 vss sg13_hv_nmos w=0.5u l=0.45u m=1
MNGb_MXN_S0_79_0 t158 NGb_bbn0 NGb_MXN_n0_79 vss sg13_hv_nmos w=0.5u l=0.45u m=1
MNGb_MXN_S0_79_1 t159 NGb_bn0 NGb_MXN_n0_79 vss sg13_hv_nmos w=0.5u l=0.45u m=1
MNGb_MXN_S0_80_0 t160 NGb_bbn0 NGb_MXN_n0_80 vss sg13_hv_nmos w=0.5u l=0.45u m=1
MNGb_MXN_S0_80_1 t161 NGb_bn0 NGb_MXN_n0_80 vss sg13_hv_nmos w=0.5u l=0.45u m=1
MNGb_MXN_S0_81_0 t162 NGb_bbn0 NGb_MXN_n0_81 vss sg13_hv_nmos w=0.5u l=0.45u m=1
MNGb_MXN_S0_81_1 t163 NGb_bn0 NGb_MXN_n0_81 vss sg13_hv_nmos w=0.5u l=0.45u m=1
MNGb_MXN_S0_82_0 t164 NGb_bbn0 NGb_MXN_n0_82 vss sg13_hv_nmos w=0.5u l=0.45u m=1
MNGb_MXN_S0_82_1 t165 NGb_bn0 NGb_MXN_n0_82 vss sg13_hv_nmos w=0.5u l=0.45u m=1
MNGb_MXN_S0_83_0 t166 NGb_bbn0 NGb_MXN_n0_83 vss sg13_hv_nmos w=0.5u l=0.45u m=1
MNGb_MXN_S0_83_1 t167 NGb_bn0 NGb_MXN_n0_83 vss sg13_hv_nmos w=0.5u l=0.45u m=1
MNGb_MXN_S0_84_0 t168 NGb_bbn0 NGb_MXN_n0_84 vss sg13_hv_nmos w=0.5u l=0.45u m=1
MNGb_MXN_S0_84_1 t169 NGb_bn0 NGb_MXN_n0_84 vss sg13_hv_nmos w=0.5u l=0.45u m=1
MNGb_MXN_S0_85_0 t170 NGb_bbn0 NGb_MXN_n0_85 vss sg13_hv_nmos w=0.5u l=0.45u m=1
MNGb_MXN_S0_85_1 t171 NGb_bn0 NGb_MXN_n0_85 vss sg13_hv_nmos w=0.5u l=0.45u m=1
MNGb_MXN_S0_86_0 t172 NGb_bbn0 NGb_MXN_n0_86 vss sg13_hv_nmos w=0.5u l=0.45u m=1
MNGb_MXN_S0_86_1 t173 NGb_bn0 NGb_MXN_n0_86 vss sg13_hv_nmos w=0.5u l=0.45u m=1
MNGb_MXN_S0_87_0 t174 NGb_bbn0 NGb_MXN_n0_87 vss sg13_hv_nmos w=0.5u l=0.45u m=1
MNGb_MXN_S0_87_1 t175 NGb_bn0 NGb_MXN_n0_87 vss sg13_hv_nmos w=0.5u l=0.45u m=1
MNGb_MXN_S0_88_0 t176 NGb_bbn0 NGb_MXN_n0_88 vss sg13_hv_nmos w=0.5u l=0.45u m=1
MNGb_MXN_S0_88_1 t177 NGb_bn0 NGb_MXN_n0_88 vss sg13_hv_nmos w=0.5u l=0.45u m=1
MNGb_MXN_S0_89_0 t178 NGb_bbn0 NGb_MXN_n0_89 vss sg13_hv_nmos w=0.5u l=0.45u m=1
MNGb_MXN_S0_89_1 t179 NGb_bn0 NGb_MXN_n0_89 vss sg13_hv_nmos w=0.5u l=0.45u m=1
MNGb_MXN_S0_90_0 t180 NGb_bbn0 NGb_MXN_n0_90 vss sg13_hv_nmos w=0.5u l=0.45u m=1
MNGb_MXN_S0_90_1 t181 NGb_bn0 NGb_MXN_n0_90 vss sg13_hv_nmos w=0.5u l=0.45u m=1
MNGb_MXN_S0_91_0 t182 NGb_bbn0 NGb_MXN_n0_91 vss sg13_hv_nmos w=0.5u l=0.45u m=1
MNGb_MXN_S0_91_1 t183 NGb_bn0 NGb_MXN_n0_91 vss sg13_hv_nmos w=0.5u l=0.45u m=1
MNGb_MXN_S0_92_0 t184 NGb_bbn0 NGb_MXN_n0_92 vss sg13_hv_nmos w=0.5u l=0.45u m=1
MNGb_MXN_S0_92_1 t185 NGb_bn0 NGb_MXN_n0_92 vss sg13_hv_nmos w=0.5u l=0.45u m=1
MNGb_MXN_S0_93_0 t186 NGb_bbn0 NGb_MXN_n0_93 vss sg13_hv_nmos w=0.5u l=0.45u m=1
MNGb_MXN_S0_93_1 t187 NGb_bn0 NGb_MXN_n0_93 vss sg13_hv_nmos w=0.5u l=0.45u m=1
MNGb_MXN_S0_94_0 t188 NGb_bbn0 NGb_MXN_n0_94 vss sg13_hv_nmos w=0.5u l=0.45u m=1
MNGb_MXN_S0_94_1 t189 NGb_bn0 NGb_MXN_n0_94 vss sg13_hv_nmos w=0.5u l=0.45u m=1
MNGb_MXN_S0_95_0 t190 NGb_bbn0 NGb_MXN_n0_95 vss sg13_hv_nmos w=0.5u l=0.45u m=1
MNGb_MXN_S0_95_1 t191 NGb_bn0 NGb_MXN_n0_95 vss sg13_hv_nmos w=0.5u l=0.45u m=1
MNGb_MXN_S0_96_0 t192 NGb_bbn0 NGb_MXN_n0_96 vss sg13_hv_nmos w=0.5u l=0.45u m=1
MNGb_MXN_S0_96_1 t193 NGb_bn0 NGb_MXN_n0_96 vss sg13_hv_nmos w=0.5u l=0.45u m=1
MNGb_MXN_S0_97_0 t194 NGb_bbn0 NGb_MXN_n0_97 vss sg13_hv_nmos w=0.5u l=0.45u m=1
MNGb_MXN_S0_97_1 t195 NGb_bn0 NGb_MXN_n0_97 vss sg13_hv_nmos w=0.5u l=0.45u m=1
MNGb_MXN_S0_98_0 t196 NGb_bbn0 NGb_MXN_n0_98 vss sg13_hv_nmos w=0.5u l=0.45u m=1
MNGb_MXN_S0_98_1 t197 NGb_bn0 NGb_MXN_n0_98 vss sg13_hv_nmos w=0.5u l=0.45u m=1
MNGb_MXN_S0_99_0 t198 NGb_bbn0 NGb_MXN_n0_99 vss sg13_hv_nmos w=0.5u l=0.45u m=1
MNGb_MXN_S0_99_1 t199 NGb_bn0 NGb_MXN_n0_99 vss sg13_hv_nmos w=0.5u l=0.45u m=1
MNGb_MXN_S0_100_0 t200 NGb_bbn0 NGb_MXN_n0_100 vss sg13_hv_nmos w=0.5u l=0.45u m=1
MNGb_MXN_S0_100_1 t201 NGb_bn0 NGb_MXN_n0_100 vss sg13_hv_nmos w=0.5u l=0.45u m=1
MNGb_MXN_S0_101_0 t202 NGb_bbn0 NGb_MXN_n0_101 vss sg13_hv_nmos w=0.5u l=0.45u m=1
MNGb_MXN_S0_101_1 t203 NGb_bn0 NGb_MXN_n0_101 vss sg13_hv_nmos w=0.5u l=0.45u m=1
MNGb_MXN_S0_102_0 t204 NGb_bbn0 NGb_MXN_n0_102 vss sg13_hv_nmos w=0.5u l=0.45u m=1
MNGb_MXN_S0_102_1 t205 NGb_bn0 NGb_MXN_n0_102 vss sg13_hv_nmos w=0.5u l=0.45u m=1
MNGb_MXN_S0_103_0 t206 NGb_bbn0 NGb_MXN_n0_103 vss sg13_hv_nmos w=0.5u l=0.45u m=1
MNGb_MXN_S0_103_1 t207 NGb_bn0 NGb_MXN_n0_103 vss sg13_hv_nmos w=0.5u l=0.45u m=1
MNGb_MXN_S0_104_0 t208 NGb_bbn0 NGb_MXN_n0_104 vss sg13_hv_nmos w=0.5u l=0.45u m=1
MNGb_MXN_S0_104_1 t209 NGb_bn0 NGb_MXN_n0_104 vss sg13_hv_nmos w=0.5u l=0.45u m=1
MNGb_MXN_S0_105_0 t210 NGb_bbn0 NGb_MXN_n0_105 vss sg13_hv_nmos w=0.5u l=0.45u m=1
MNGb_MXN_S0_105_1 t211 NGb_bn0 NGb_MXN_n0_105 vss sg13_hv_nmos w=0.5u l=0.45u m=1
MNGb_MXN_S0_106_0 t212 NGb_bbn0 NGb_MXN_n0_106 vss sg13_hv_nmos w=0.5u l=0.45u m=1
MNGb_MXN_S0_106_1 t213 NGb_bn0 NGb_MXN_n0_106 vss sg13_hv_nmos w=0.5u l=0.45u m=1
MNGb_MXN_S0_107_0 t214 NGb_bbn0 NGb_MXN_n0_107 vss sg13_hv_nmos w=0.5u l=0.45u m=1
MNGb_MXN_S0_107_1 t215 NGb_bn0 NGb_MXN_n0_107 vss sg13_hv_nmos w=0.5u l=0.45u m=1
MNGb_MXN_S0_108_0 t216 NGb_bbn0 NGb_MXN_n0_108 vss sg13_hv_nmos w=0.5u l=0.45u m=1
MNGb_MXN_S0_108_1 t217 NGb_bn0 NGb_MXN_n0_108 vss sg13_hv_nmos w=0.5u l=0.45u m=1
MNGb_MXN_S0_109_0 t218 NGb_bbn0 NGb_MXN_n0_109 vss sg13_hv_nmos w=0.5u l=0.45u m=1
MNGb_MXN_S0_109_1 t219 NGb_bn0 NGb_MXN_n0_109 vss sg13_hv_nmos w=0.5u l=0.45u m=1
MNGb_MXN_S0_110_0 t220 NGb_bbn0 NGb_MXN_n0_110 vss sg13_hv_nmos w=0.5u l=0.45u m=1
MNGb_MXN_S0_110_1 t221 NGb_bn0 NGb_MXN_n0_110 vss sg13_hv_nmos w=0.5u l=0.45u m=1
MNGb_MXN_S0_111_0 t222 NGb_bbn0 NGb_MXN_n0_111 vss sg13_hv_nmos w=0.5u l=0.45u m=1
MNGb_MXN_S0_111_1 t223 NGb_bn0 NGb_MXN_n0_111 vss sg13_hv_nmos w=0.5u l=0.45u m=1
MNGb_MXN_S0_112_0 t224 NGb_bbn0 NGb_MXN_n0_112 vss sg13_hv_nmos w=0.5u l=0.45u m=1
MNGb_MXN_S0_112_1 t225 NGb_bn0 NGb_MXN_n0_112 vss sg13_hv_nmos w=0.5u l=0.45u m=1
MNGb_MXN_S0_113_0 t226 NGb_bbn0 NGb_MXN_n0_113 vss sg13_hv_nmos w=0.5u l=0.45u m=1
MNGb_MXN_S0_113_1 t227 NGb_bn0 NGb_MXN_n0_113 vss sg13_hv_nmos w=0.5u l=0.45u m=1
MNGb_MXN_S0_114_0 t228 NGb_bbn0 NGb_MXN_n0_114 vss sg13_hv_nmos w=0.5u l=0.45u m=1
MNGb_MXN_S0_114_1 t229 NGb_bn0 NGb_MXN_n0_114 vss sg13_hv_nmos w=0.5u l=0.45u m=1
MNGb_MXN_S0_115_0 t230 NGb_bbn0 NGb_MXN_n0_115 vss sg13_hv_nmos w=0.5u l=0.45u m=1
MNGb_MXN_S0_115_1 t231 NGb_bn0 NGb_MXN_n0_115 vss sg13_hv_nmos w=0.5u l=0.45u m=1
MNGb_MXN_S0_116_0 t232 NGb_bbn0 NGb_MXN_n0_116 vss sg13_hv_nmos w=0.5u l=0.45u m=1
MNGb_MXN_S0_116_1 t233 NGb_bn0 NGb_MXN_n0_116 vss sg13_hv_nmos w=0.5u l=0.45u m=1
MNGb_MXN_S0_117_0 t234 NGb_bbn0 NGb_MXN_n0_117 vss sg13_hv_nmos w=0.5u l=0.45u m=1
MNGb_MXN_S0_117_1 t235 NGb_bn0 NGb_MXN_n0_117 vss sg13_hv_nmos w=0.5u l=0.45u m=1
MNGb_MXN_S0_118_0 t236 NGb_bbn0 NGb_MXN_n0_118 vss sg13_hv_nmos w=0.5u l=0.45u m=1
MNGb_MXN_S0_118_1 t237 NGb_bn0 NGb_MXN_n0_118 vss sg13_hv_nmos w=0.5u l=0.45u m=1
MNGb_MXN_S0_119_0 t238 NGb_bbn0 NGb_MXN_n0_119 vss sg13_hv_nmos w=0.5u l=0.45u m=1
MNGb_MXN_S0_119_1 t239 NGb_bn0 NGb_MXN_n0_119 vss sg13_hv_nmos w=0.5u l=0.45u m=1
MNGb_MXN_S0_120_0 t240 NGb_bbn0 NGb_MXN_n0_120 vss sg13_hv_nmos w=0.5u l=0.45u m=1
MNGb_MXN_S0_120_1 t241 NGb_bn0 NGb_MXN_n0_120 vss sg13_hv_nmos w=0.5u l=0.45u m=1
MNGb_MXN_S0_121_0 t242 NGb_bbn0 NGb_MXN_n0_121 vss sg13_hv_nmos w=0.5u l=0.45u m=1
MNGb_MXN_S0_121_1 t243 NGb_bn0 NGb_MXN_n0_121 vss sg13_hv_nmos w=0.5u l=0.45u m=1
MNGb_MXN_S0_122_0 t244 NGb_bbn0 NGb_MXN_n0_122 vss sg13_hv_nmos w=0.5u l=0.45u m=1
MNGb_MXN_S0_122_1 t245 NGb_bn0 NGb_MXN_n0_122 vss sg13_hv_nmos w=0.5u l=0.45u m=1
MNGb_MXN_S0_123_0 t246 NGb_bbn0 NGb_MXN_n0_123 vss sg13_hv_nmos w=0.5u l=0.45u m=1
MNGb_MXN_S0_123_1 t247 NGb_bn0 NGb_MXN_n0_123 vss sg13_hv_nmos w=0.5u l=0.45u m=1
MNGb_MXN_S0_124_0 t248 NGb_bbn0 NGb_MXN_n0_124 vss sg13_hv_nmos w=0.5u l=0.45u m=1
MNGb_MXN_S0_124_1 t249 NGb_bn0 NGb_MXN_n0_124 vss sg13_hv_nmos w=0.5u l=0.45u m=1
MNGb_MXN_S0_125_0 t250 NGb_bbn0 NGb_MXN_n0_125 vss sg13_hv_nmos w=0.5u l=0.45u m=1
MNGb_MXN_S0_125_1 t251 NGb_bn0 NGb_MXN_n0_125 vss sg13_hv_nmos w=0.5u l=0.45u m=1
MNGb_MXN_S0_126_0 vref NGb_bbn0 NGb_MXN_n0_126 vss sg13_hv_nmos w=0.5u l=0.45u m=1
MNGb_MXN_S0_126_1 vref NGb_bn0 NGb_MXN_n0_126 vss sg13_hv_nmos w=0.5u l=0.45u m=1
MNGb_MXN_S0_127_0 vref NGb_bbn0 NGb_MXN_n0_127 vss sg13_hv_nmos w=0.5u l=0.45u m=1
MNGb_MXN_S0_127_1 vref NGb_bn0 NGb_MXN_n0_127 vss sg13_hv_nmos w=0.5u l=0.45u m=1
MNGb_MXN_S1_0_0 NGb_MXN_n0_0 NGb_bbn1 NGb_MXN_n1_0 vss sg13_hv_nmos w=0.5u l=0.45u m=1
MNGb_MXN_S1_0_1 NGb_MXN_n0_1 NGb_bn1 NGb_MXN_n1_0 vss sg13_hv_nmos w=0.5u l=0.45u m=1
MNGb_MXN_S1_1_0 NGb_MXN_n0_2 NGb_bbn1 NGb_MXN_n1_1 vss sg13_hv_nmos w=0.5u l=0.45u m=1
MNGb_MXN_S1_1_1 NGb_MXN_n0_3 NGb_bn1 NGb_MXN_n1_1 vss sg13_hv_nmos w=0.5u l=0.45u m=1
MNGb_MXN_S1_2_0 NGb_MXN_n0_4 NGb_bbn1 NGb_MXN_n1_2 vss sg13_hv_nmos w=0.5u l=0.45u m=1
MNGb_MXN_S1_2_1 NGb_MXN_n0_5 NGb_bn1 NGb_MXN_n1_2 vss sg13_hv_nmos w=0.5u l=0.45u m=1
MNGb_MXN_S1_3_0 NGb_MXN_n0_6 NGb_bbn1 NGb_MXN_n1_3 vss sg13_hv_nmos w=0.5u l=0.45u m=1
MNGb_MXN_S1_3_1 NGb_MXN_n0_7 NGb_bn1 NGb_MXN_n1_3 vss sg13_hv_nmos w=0.5u l=0.45u m=1
MNGb_MXN_S1_4_0 NGb_MXN_n0_8 NGb_bbn1 NGb_MXN_n1_4 vss sg13_hv_nmos w=0.5u l=0.45u m=1
MNGb_MXN_S1_4_1 NGb_MXN_n0_9 NGb_bn1 NGb_MXN_n1_4 vss sg13_hv_nmos w=0.5u l=0.45u m=1
MNGb_MXN_S1_5_0 NGb_MXN_n0_10 NGb_bbn1 NGb_MXN_n1_5 vss sg13_hv_nmos w=0.5u l=0.45u m=1
MNGb_MXN_S1_5_1 NGb_MXN_n0_11 NGb_bn1 NGb_MXN_n1_5 vss sg13_hv_nmos w=0.5u l=0.45u m=1
MNGb_MXN_S1_6_0 NGb_MXN_n0_12 NGb_bbn1 NGb_MXN_n1_6 vss sg13_hv_nmos w=0.5u l=0.45u m=1
MNGb_MXN_S1_6_1 NGb_MXN_n0_13 NGb_bn1 NGb_MXN_n1_6 vss sg13_hv_nmos w=0.5u l=0.45u m=1
MNGb_MXN_S1_7_0 NGb_MXN_n0_14 NGb_bbn1 NGb_MXN_n1_7 vss sg13_hv_nmos w=0.5u l=0.45u m=1
MNGb_MXN_S1_7_1 NGb_MXN_n0_15 NGb_bn1 NGb_MXN_n1_7 vss sg13_hv_nmos w=0.5u l=0.45u m=1
MNGb_MXN_S1_8_0 NGb_MXN_n0_16 NGb_bbn1 NGb_MXN_n1_8 vss sg13_hv_nmos w=0.5u l=0.45u m=1
MNGb_MXN_S1_8_1 NGb_MXN_n0_17 NGb_bn1 NGb_MXN_n1_8 vss sg13_hv_nmos w=0.5u l=0.45u m=1
MNGb_MXN_S1_9_0 NGb_MXN_n0_18 NGb_bbn1 NGb_MXN_n1_9 vss sg13_hv_nmos w=0.5u l=0.45u m=1
MNGb_MXN_S1_9_1 NGb_MXN_n0_19 NGb_bn1 NGb_MXN_n1_9 vss sg13_hv_nmos w=0.5u l=0.45u m=1
MNGb_MXN_S1_10_0 NGb_MXN_n0_20 NGb_bbn1 NGb_MXN_n1_10 vss sg13_hv_nmos w=0.5u l=0.45u m=1
MNGb_MXN_S1_10_1 NGb_MXN_n0_21 NGb_bn1 NGb_MXN_n1_10 vss sg13_hv_nmos w=0.5u l=0.45u m=1
MNGb_MXN_S1_11_0 NGb_MXN_n0_22 NGb_bbn1 NGb_MXN_n1_11 vss sg13_hv_nmos w=0.5u l=0.45u m=1
MNGb_MXN_S1_11_1 NGb_MXN_n0_23 NGb_bn1 NGb_MXN_n1_11 vss sg13_hv_nmos w=0.5u l=0.45u m=1
MNGb_MXN_S1_12_0 NGb_MXN_n0_24 NGb_bbn1 NGb_MXN_n1_12 vss sg13_hv_nmos w=0.5u l=0.45u m=1
MNGb_MXN_S1_12_1 NGb_MXN_n0_25 NGb_bn1 NGb_MXN_n1_12 vss sg13_hv_nmos w=0.5u l=0.45u m=1
MNGb_MXN_S1_13_0 NGb_MXN_n0_26 NGb_bbn1 NGb_MXN_n1_13 vss sg13_hv_nmos w=0.5u l=0.45u m=1
MNGb_MXN_S1_13_1 NGb_MXN_n0_27 NGb_bn1 NGb_MXN_n1_13 vss sg13_hv_nmos w=0.5u l=0.45u m=1
MNGb_MXN_S1_14_0 NGb_MXN_n0_28 NGb_bbn1 NGb_MXN_n1_14 vss sg13_hv_nmos w=0.5u l=0.45u m=1
MNGb_MXN_S1_14_1 NGb_MXN_n0_29 NGb_bn1 NGb_MXN_n1_14 vss sg13_hv_nmos w=0.5u l=0.45u m=1
MNGb_MXN_S1_15_0 NGb_MXN_n0_30 NGb_bbn1 NGb_MXN_n1_15 vss sg13_hv_nmos w=0.5u l=0.45u m=1
MNGb_MXN_S1_15_1 NGb_MXN_n0_31 NGb_bn1 NGb_MXN_n1_15 vss sg13_hv_nmos w=0.5u l=0.45u m=1
MNGb_MXN_S1_16_0 NGb_MXN_n0_32 NGb_bbn1 NGb_MXN_n1_16 vss sg13_hv_nmos w=0.5u l=0.45u m=1
MNGb_MXN_S1_16_1 NGb_MXN_n0_33 NGb_bn1 NGb_MXN_n1_16 vss sg13_hv_nmos w=0.5u l=0.45u m=1
MNGb_MXN_S1_17_0 NGb_MXN_n0_34 NGb_bbn1 NGb_MXN_n1_17 vss sg13_hv_nmos w=0.5u l=0.45u m=1
MNGb_MXN_S1_17_1 NGb_MXN_n0_35 NGb_bn1 NGb_MXN_n1_17 vss sg13_hv_nmos w=0.5u l=0.45u m=1
MNGb_MXN_S1_18_0 NGb_MXN_n0_36 NGb_bbn1 NGb_MXN_n1_18 vss sg13_hv_nmos w=0.5u l=0.45u m=1
MNGb_MXN_S1_18_1 NGb_MXN_n0_37 NGb_bn1 NGb_MXN_n1_18 vss sg13_hv_nmos w=0.5u l=0.45u m=1
MNGb_MXN_S1_19_0 NGb_MXN_n0_38 NGb_bbn1 NGb_MXN_n1_19 vss sg13_hv_nmos w=0.5u l=0.45u m=1
MNGb_MXN_S1_19_1 NGb_MXN_n0_39 NGb_bn1 NGb_MXN_n1_19 vss sg13_hv_nmos w=0.5u l=0.45u m=1
MNGb_MXN_S1_20_0 NGb_MXN_n0_40 NGb_bbn1 NGb_MXN_n1_20 vss sg13_hv_nmos w=0.5u l=0.45u m=1
MNGb_MXN_S1_20_1 NGb_MXN_n0_41 NGb_bn1 NGb_MXN_n1_20 vss sg13_hv_nmos w=0.5u l=0.45u m=1
MNGb_MXN_S1_21_0 NGb_MXN_n0_42 NGb_bbn1 NGb_MXN_n1_21 vss sg13_hv_nmos w=0.5u l=0.45u m=1
MNGb_MXN_S1_21_1 NGb_MXN_n0_43 NGb_bn1 NGb_MXN_n1_21 vss sg13_hv_nmos w=0.5u l=0.45u m=1
MNGb_MXN_S1_22_0 NGb_MXN_n0_44 NGb_bbn1 NGb_MXN_n1_22 vss sg13_hv_nmos w=0.5u l=0.45u m=1
MNGb_MXN_S1_22_1 NGb_MXN_n0_45 NGb_bn1 NGb_MXN_n1_22 vss sg13_hv_nmos w=0.5u l=0.45u m=1
MNGb_MXN_S1_23_0 NGb_MXN_n0_46 NGb_bbn1 NGb_MXN_n1_23 vss sg13_hv_nmos w=0.5u l=0.45u m=1
MNGb_MXN_S1_23_1 NGb_MXN_n0_47 NGb_bn1 NGb_MXN_n1_23 vss sg13_hv_nmos w=0.5u l=0.45u m=1
MNGb_MXN_S1_24_0 NGb_MXN_n0_48 NGb_bbn1 NGb_MXN_n1_24 vss sg13_hv_nmos w=0.5u l=0.45u m=1
MNGb_MXN_S1_24_1 NGb_MXN_n0_49 NGb_bn1 NGb_MXN_n1_24 vss sg13_hv_nmos w=0.5u l=0.45u m=1
MNGb_MXN_S1_25_0 NGb_MXN_n0_50 NGb_bbn1 NGb_MXN_n1_25 vss sg13_hv_nmos w=0.5u l=0.45u m=1
MNGb_MXN_S1_25_1 NGb_MXN_n0_51 NGb_bn1 NGb_MXN_n1_25 vss sg13_hv_nmos w=0.5u l=0.45u m=1
MNGb_MXN_S1_26_0 NGb_MXN_n0_52 NGb_bbn1 NGb_MXN_n1_26 vss sg13_hv_nmos w=0.5u l=0.45u m=1
MNGb_MXN_S1_26_1 NGb_MXN_n0_53 NGb_bn1 NGb_MXN_n1_26 vss sg13_hv_nmos w=0.5u l=0.45u m=1
MNGb_MXN_S1_27_0 NGb_MXN_n0_54 NGb_bbn1 NGb_MXN_n1_27 vss sg13_hv_nmos w=0.5u l=0.45u m=1
MNGb_MXN_S1_27_1 NGb_MXN_n0_55 NGb_bn1 NGb_MXN_n1_27 vss sg13_hv_nmos w=0.5u l=0.45u m=1
MNGb_MXN_S1_28_0 NGb_MXN_n0_56 NGb_bbn1 NGb_MXN_n1_28 vss sg13_hv_nmos w=0.5u l=0.45u m=1
MNGb_MXN_S1_28_1 NGb_MXN_n0_57 NGb_bn1 NGb_MXN_n1_28 vss sg13_hv_nmos w=0.5u l=0.45u m=1
MNGb_MXN_S1_29_0 NGb_MXN_n0_58 NGb_bbn1 NGb_MXN_n1_29 vss sg13_hv_nmos w=0.5u l=0.45u m=1
MNGb_MXN_S1_29_1 NGb_MXN_n0_59 NGb_bn1 NGb_MXN_n1_29 vss sg13_hv_nmos w=0.5u l=0.45u m=1
MNGb_MXN_S1_30_0 NGb_MXN_n0_60 NGb_bbn1 NGb_MXN_n1_30 vss sg13_hv_nmos w=0.5u l=0.45u m=1
MNGb_MXN_S1_30_1 NGb_MXN_n0_61 NGb_bn1 NGb_MXN_n1_30 vss sg13_hv_nmos w=0.5u l=0.45u m=1
MNGb_MXN_S1_31_0 NGb_MXN_n0_62 NGb_bbn1 NGb_MXN_n1_31 vss sg13_hv_nmos w=0.5u l=0.45u m=1
MNGb_MXN_S1_31_1 NGb_MXN_n0_63 NGb_bn1 NGb_MXN_n1_31 vss sg13_hv_nmos w=0.5u l=0.45u m=1
MNGb_MXN_S1_32_0 NGb_MXN_n0_64 NGb_bbn1 NGb_MXN_n1_32 vss sg13_hv_nmos w=0.5u l=0.45u m=1
MNGb_MXN_S1_32_1 NGb_MXN_n0_65 NGb_bn1 NGb_MXN_n1_32 vss sg13_hv_nmos w=0.5u l=0.45u m=1
MNGb_MXN_S1_33_0 NGb_MXN_n0_66 NGb_bbn1 NGb_MXN_n1_33 vss sg13_hv_nmos w=0.5u l=0.45u m=1
MNGb_MXN_S1_33_1 NGb_MXN_n0_67 NGb_bn1 NGb_MXN_n1_33 vss sg13_hv_nmos w=0.5u l=0.45u m=1
MNGb_MXN_S1_34_0 NGb_MXN_n0_68 NGb_bbn1 NGb_MXN_n1_34 vss sg13_hv_nmos w=0.5u l=0.45u m=1
MNGb_MXN_S1_34_1 NGb_MXN_n0_69 NGb_bn1 NGb_MXN_n1_34 vss sg13_hv_nmos w=0.5u l=0.45u m=1
MNGb_MXN_S1_35_0 NGb_MXN_n0_70 NGb_bbn1 NGb_MXN_n1_35 vss sg13_hv_nmos w=0.5u l=0.45u m=1
MNGb_MXN_S1_35_1 NGb_MXN_n0_71 NGb_bn1 NGb_MXN_n1_35 vss sg13_hv_nmos w=0.5u l=0.45u m=1
MNGb_MXN_S1_36_0 NGb_MXN_n0_72 NGb_bbn1 NGb_MXN_n1_36 vss sg13_hv_nmos w=0.5u l=0.45u m=1
MNGb_MXN_S1_36_1 NGb_MXN_n0_73 NGb_bn1 NGb_MXN_n1_36 vss sg13_hv_nmos w=0.5u l=0.45u m=1
MNGb_MXN_S1_37_0 NGb_MXN_n0_74 NGb_bbn1 NGb_MXN_n1_37 vss sg13_hv_nmos w=0.5u l=0.45u m=1
MNGb_MXN_S1_37_1 NGb_MXN_n0_75 NGb_bn1 NGb_MXN_n1_37 vss sg13_hv_nmos w=0.5u l=0.45u m=1
MNGb_MXN_S1_38_0 NGb_MXN_n0_76 NGb_bbn1 NGb_MXN_n1_38 vss sg13_hv_nmos w=0.5u l=0.45u m=1
MNGb_MXN_S1_38_1 NGb_MXN_n0_77 NGb_bn1 NGb_MXN_n1_38 vss sg13_hv_nmos w=0.5u l=0.45u m=1
MNGb_MXN_S1_39_0 NGb_MXN_n0_78 NGb_bbn1 NGb_MXN_n1_39 vss sg13_hv_nmos w=0.5u l=0.45u m=1
MNGb_MXN_S1_39_1 NGb_MXN_n0_79 NGb_bn1 NGb_MXN_n1_39 vss sg13_hv_nmos w=0.5u l=0.45u m=1
MNGb_MXN_S1_40_0 NGb_MXN_n0_80 NGb_bbn1 NGb_MXN_n1_40 vss sg13_hv_nmos w=0.5u l=0.45u m=1
MNGb_MXN_S1_40_1 NGb_MXN_n0_81 NGb_bn1 NGb_MXN_n1_40 vss sg13_hv_nmos w=0.5u l=0.45u m=1
MNGb_MXN_S1_41_0 NGb_MXN_n0_82 NGb_bbn1 NGb_MXN_n1_41 vss sg13_hv_nmos w=0.5u l=0.45u m=1
MNGb_MXN_S1_41_1 NGb_MXN_n0_83 NGb_bn1 NGb_MXN_n1_41 vss sg13_hv_nmos w=0.5u l=0.45u m=1
MNGb_MXN_S1_42_0 NGb_MXN_n0_84 NGb_bbn1 NGb_MXN_n1_42 vss sg13_hv_nmos w=0.5u l=0.45u m=1
MNGb_MXN_S1_42_1 NGb_MXN_n0_85 NGb_bn1 NGb_MXN_n1_42 vss sg13_hv_nmos w=0.5u l=0.45u m=1
MNGb_MXN_S1_43_0 NGb_MXN_n0_86 NGb_bbn1 NGb_MXN_n1_43 vss sg13_hv_nmos w=0.5u l=0.45u m=1
MNGb_MXN_S1_43_1 NGb_MXN_n0_87 NGb_bn1 NGb_MXN_n1_43 vss sg13_hv_nmos w=0.5u l=0.45u m=1
MNGb_MXN_S1_44_0 NGb_MXN_n0_88 NGb_bbn1 NGb_MXN_n1_44 vss sg13_hv_nmos w=0.5u l=0.45u m=1
MNGb_MXN_S1_44_1 NGb_MXN_n0_89 NGb_bn1 NGb_MXN_n1_44 vss sg13_hv_nmos w=0.5u l=0.45u m=1
MNGb_MXN_S1_45_0 NGb_MXN_n0_90 NGb_bbn1 NGb_MXN_n1_45 vss sg13_hv_nmos w=0.5u l=0.45u m=1
MNGb_MXN_S1_45_1 NGb_MXN_n0_91 NGb_bn1 NGb_MXN_n1_45 vss sg13_hv_nmos w=0.5u l=0.45u m=1
MNGb_MXN_S1_46_0 NGb_MXN_n0_92 NGb_bbn1 NGb_MXN_n1_46 vss sg13_hv_nmos w=0.5u l=0.45u m=1
MNGb_MXN_S1_46_1 NGb_MXN_n0_93 NGb_bn1 NGb_MXN_n1_46 vss sg13_hv_nmos w=0.5u l=0.45u m=1
MNGb_MXN_S1_47_0 NGb_MXN_n0_94 NGb_bbn1 NGb_MXN_n1_47 vss sg13_hv_nmos w=0.5u l=0.45u m=1
MNGb_MXN_S1_47_1 NGb_MXN_n0_95 NGb_bn1 NGb_MXN_n1_47 vss sg13_hv_nmos w=0.5u l=0.45u m=1
MNGb_MXN_S1_48_0 NGb_MXN_n0_96 NGb_bbn1 NGb_MXN_n1_48 vss sg13_hv_nmos w=0.5u l=0.45u m=1
MNGb_MXN_S1_48_1 NGb_MXN_n0_97 NGb_bn1 NGb_MXN_n1_48 vss sg13_hv_nmos w=0.5u l=0.45u m=1
MNGb_MXN_S1_49_0 NGb_MXN_n0_98 NGb_bbn1 NGb_MXN_n1_49 vss sg13_hv_nmos w=0.5u l=0.45u m=1
MNGb_MXN_S1_49_1 NGb_MXN_n0_99 NGb_bn1 NGb_MXN_n1_49 vss sg13_hv_nmos w=0.5u l=0.45u m=1
MNGb_MXN_S1_50_0 NGb_MXN_n0_100 NGb_bbn1 NGb_MXN_n1_50 vss sg13_hv_nmos w=0.5u l=0.45u m=1
MNGb_MXN_S1_50_1 NGb_MXN_n0_101 NGb_bn1 NGb_MXN_n1_50 vss sg13_hv_nmos w=0.5u l=0.45u m=1
MNGb_MXN_S1_51_0 NGb_MXN_n0_102 NGb_bbn1 NGb_MXN_n1_51 vss sg13_hv_nmos w=0.5u l=0.45u m=1
MNGb_MXN_S1_51_1 NGb_MXN_n0_103 NGb_bn1 NGb_MXN_n1_51 vss sg13_hv_nmos w=0.5u l=0.45u m=1
MNGb_MXN_S1_52_0 NGb_MXN_n0_104 NGb_bbn1 NGb_MXN_n1_52 vss sg13_hv_nmos w=0.5u l=0.45u m=1
MNGb_MXN_S1_52_1 NGb_MXN_n0_105 NGb_bn1 NGb_MXN_n1_52 vss sg13_hv_nmos w=0.5u l=0.45u m=1
MNGb_MXN_S1_53_0 NGb_MXN_n0_106 NGb_bbn1 NGb_MXN_n1_53 vss sg13_hv_nmos w=0.5u l=0.45u m=1
MNGb_MXN_S1_53_1 NGb_MXN_n0_107 NGb_bn1 NGb_MXN_n1_53 vss sg13_hv_nmos w=0.5u l=0.45u m=1
MNGb_MXN_S1_54_0 NGb_MXN_n0_108 NGb_bbn1 NGb_MXN_n1_54 vss sg13_hv_nmos w=0.5u l=0.45u m=1
MNGb_MXN_S1_54_1 NGb_MXN_n0_109 NGb_bn1 NGb_MXN_n1_54 vss sg13_hv_nmos w=0.5u l=0.45u m=1
MNGb_MXN_S1_55_0 NGb_MXN_n0_110 NGb_bbn1 NGb_MXN_n1_55 vss sg13_hv_nmos w=0.5u l=0.45u m=1
MNGb_MXN_S1_55_1 NGb_MXN_n0_111 NGb_bn1 NGb_MXN_n1_55 vss sg13_hv_nmos w=0.5u l=0.45u m=1
MNGb_MXN_S1_56_0 NGb_MXN_n0_112 NGb_bbn1 NGb_MXN_n1_56 vss sg13_hv_nmos w=0.5u l=0.45u m=1
MNGb_MXN_S1_56_1 NGb_MXN_n0_113 NGb_bn1 NGb_MXN_n1_56 vss sg13_hv_nmos w=0.5u l=0.45u m=1
MNGb_MXN_S1_57_0 NGb_MXN_n0_114 NGb_bbn1 NGb_MXN_n1_57 vss sg13_hv_nmos w=0.5u l=0.45u m=1
MNGb_MXN_S1_57_1 NGb_MXN_n0_115 NGb_bn1 NGb_MXN_n1_57 vss sg13_hv_nmos w=0.5u l=0.45u m=1
MNGb_MXN_S1_58_0 NGb_MXN_n0_116 NGb_bbn1 NGb_MXN_n1_58 vss sg13_hv_nmos w=0.5u l=0.45u m=1
MNGb_MXN_S1_58_1 NGb_MXN_n0_117 NGb_bn1 NGb_MXN_n1_58 vss sg13_hv_nmos w=0.5u l=0.45u m=1
MNGb_MXN_S1_59_0 NGb_MXN_n0_118 NGb_bbn1 NGb_MXN_n1_59 vss sg13_hv_nmos w=0.5u l=0.45u m=1
MNGb_MXN_S1_59_1 NGb_MXN_n0_119 NGb_bn1 NGb_MXN_n1_59 vss sg13_hv_nmos w=0.5u l=0.45u m=1
MNGb_MXN_S1_60_0 NGb_MXN_n0_120 NGb_bbn1 NGb_MXN_n1_60 vss sg13_hv_nmos w=0.5u l=0.45u m=1
MNGb_MXN_S1_60_1 NGb_MXN_n0_121 NGb_bn1 NGb_MXN_n1_60 vss sg13_hv_nmos w=0.5u l=0.45u m=1
MNGb_MXN_S1_61_0 NGb_MXN_n0_122 NGb_bbn1 NGb_MXN_n1_61 vss sg13_hv_nmos w=0.5u l=0.45u m=1
MNGb_MXN_S1_61_1 NGb_MXN_n0_123 NGb_bn1 NGb_MXN_n1_61 vss sg13_hv_nmos w=0.5u l=0.45u m=1
MNGb_MXN_S1_62_0 NGb_MXN_n0_124 NGb_bbn1 NGb_MXN_n1_62 vss sg13_hv_nmos w=0.5u l=0.45u m=1
MNGb_MXN_S1_62_1 NGb_MXN_n0_125 NGb_bn1 NGb_MXN_n1_62 vss sg13_hv_nmos w=0.5u l=0.45u m=1
MNGb_MXN_S1_63_0 NGb_MXN_n0_126 NGb_bbn1 NGb_MXN_n1_63 vss sg13_hv_nmos w=0.5u l=0.45u m=1
MNGb_MXN_S1_63_1 NGb_MXN_n0_127 NGb_bn1 NGb_MXN_n1_63 vss sg13_hv_nmos w=0.5u l=0.45u m=1
MNGb_MXN_S2_0_0 NGb_MXN_n1_0 NGb_bbn2 NGb_MXN_n2_0 vss sg13_hv_nmos w=0.5u l=0.45u m=1
MNGb_MXN_S2_0_1 NGb_MXN_n1_1 NGb_bn2 NGb_MXN_n2_0 vss sg13_hv_nmos w=0.5u l=0.45u m=1
MNGb_MXN_S2_1_0 NGb_MXN_n1_2 NGb_bbn2 NGb_MXN_n2_1 vss sg13_hv_nmos w=0.5u l=0.45u m=1
MNGb_MXN_S2_1_1 NGb_MXN_n1_3 NGb_bn2 NGb_MXN_n2_1 vss sg13_hv_nmos w=0.5u l=0.45u m=1
MNGb_MXN_S2_2_0 NGb_MXN_n1_4 NGb_bbn2 NGb_MXN_n2_2 vss sg13_hv_nmos w=0.5u l=0.45u m=1
MNGb_MXN_S2_2_1 NGb_MXN_n1_5 NGb_bn2 NGb_MXN_n2_2 vss sg13_hv_nmos w=0.5u l=0.45u m=1
MNGb_MXN_S2_3_0 NGb_MXN_n1_6 NGb_bbn2 NGb_MXN_n2_3 vss sg13_hv_nmos w=0.5u l=0.45u m=1
MNGb_MXN_S2_3_1 NGb_MXN_n1_7 NGb_bn2 NGb_MXN_n2_3 vss sg13_hv_nmos w=0.5u l=0.45u m=1
MNGb_MXN_S2_4_0 NGb_MXN_n1_8 NGb_bbn2 NGb_MXN_n2_4 vss sg13_hv_nmos w=0.5u l=0.45u m=1
MNGb_MXN_S2_4_1 NGb_MXN_n1_9 NGb_bn2 NGb_MXN_n2_4 vss sg13_hv_nmos w=0.5u l=0.45u m=1
MNGb_MXN_S2_5_0 NGb_MXN_n1_10 NGb_bbn2 NGb_MXN_n2_5 vss sg13_hv_nmos w=0.5u l=0.45u m=1
MNGb_MXN_S2_5_1 NGb_MXN_n1_11 NGb_bn2 NGb_MXN_n2_5 vss sg13_hv_nmos w=0.5u l=0.45u m=1
MNGb_MXN_S2_6_0 NGb_MXN_n1_12 NGb_bbn2 NGb_MXN_n2_6 vss sg13_hv_nmos w=0.5u l=0.45u m=1
MNGb_MXN_S2_6_1 NGb_MXN_n1_13 NGb_bn2 NGb_MXN_n2_6 vss sg13_hv_nmos w=0.5u l=0.45u m=1
MNGb_MXN_S2_7_0 NGb_MXN_n1_14 NGb_bbn2 NGb_MXN_n2_7 vss sg13_hv_nmos w=0.5u l=0.45u m=1
MNGb_MXN_S2_7_1 NGb_MXN_n1_15 NGb_bn2 NGb_MXN_n2_7 vss sg13_hv_nmos w=0.5u l=0.45u m=1
MNGb_MXN_S2_8_0 NGb_MXN_n1_16 NGb_bbn2 NGb_MXN_n2_8 vss sg13_hv_nmos w=0.5u l=0.45u m=1
MNGb_MXN_S2_8_1 NGb_MXN_n1_17 NGb_bn2 NGb_MXN_n2_8 vss sg13_hv_nmos w=0.5u l=0.45u m=1
MNGb_MXN_S2_9_0 NGb_MXN_n1_18 NGb_bbn2 NGb_MXN_n2_9 vss sg13_hv_nmos w=0.5u l=0.45u m=1
MNGb_MXN_S2_9_1 NGb_MXN_n1_19 NGb_bn2 NGb_MXN_n2_9 vss sg13_hv_nmos w=0.5u l=0.45u m=1
MNGb_MXN_S2_10_0 NGb_MXN_n1_20 NGb_bbn2 NGb_MXN_n2_10 vss sg13_hv_nmos w=0.5u l=0.45u m=1
MNGb_MXN_S2_10_1 NGb_MXN_n1_21 NGb_bn2 NGb_MXN_n2_10 vss sg13_hv_nmos w=0.5u l=0.45u m=1
MNGb_MXN_S2_11_0 NGb_MXN_n1_22 NGb_bbn2 NGb_MXN_n2_11 vss sg13_hv_nmos w=0.5u l=0.45u m=1
MNGb_MXN_S2_11_1 NGb_MXN_n1_23 NGb_bn2 NGb_MXN_n2_11 vss sg13_hv_nmos w=0.5u l=0.45u m=1
MNGb_MXN_S2_12_0 NGb_MXN_n1_24 NGb_bbn2 NGb_MXN_n2_12 vss sg13_hv_nmos w=0.5u l=0.45u m=1
MNGb_MXN_S2_12_1 NGb_MXN_n1_25 NGb_bn2 NGb_MXN_n2_12 vss sg13_hv_nmos w=0.5u l=0.45u m=1
MNGb_MXN_S2_13_0 NGb_MXN_n1_26 NGb_bbn2 NGb_MXN_n2_13 vss sg13_hv_nmos w=0.5u l=0.45u m=1
MNGb_MXN_S2_13_1 NGb_MXN_n1_27 NGb_bn2 NGb_MXN_n2_13 vss sg13_hv_nmos w=0.5u l=0.45u m=1
MNGb_MXN_S2_14_0 NGb_MXN_n1_28 NGb_bbn2 NGb_MXN_n2_14 vss sg13_hv_nmos w=0.5u l=0.45u m=1
MNGb_MXN_S2_14_1 NGb_MXN_n1_29 NGb_bn2 NGb_MXN_n2_14 vss sg13_hv_nmos w=0.5u l=0.45u m=1
MNGb_MXN_S2_15_0 NGb_MXN_n1_30 NGb_bbn2 NGb_MXN_n2_15 vss sg13_hv_nmos w=0.5u l=0.45u m=1
MNGb_MXN_S2_15_1 NGb_MXN_n1_31 NGb_bn2 NGb_MXN_n2_15 vss sg13_hv_nmos w=0.5u l=0.45u m=1
MNGb_MXN_S2_16_0 NGb_MXN_n1_32 NGb_bbn2 NGb_MXN_n2_16 vss sg13_hv_nmos w=0.5u l=0.45u m=1
MNGb_MXN_S2_16_1 NGb_MXN_n1_33 NGb_bn2 NGb_MXN_n2_16 vss sg13_hv_nmos w=0.5u l=0.45u m=1
MNGb_MXN_S2_17_0 NGb_MXN_n1_34 NGb_bbn2 NGb_MXN_n2_17 vss sg13_hv_nmos w=0.5u l=0.45u m=1
MNGb_MXN_S2_17_1 NGb_MXN_n1_35 NGb_bn2 NGb_MXN_n2_17 vss sg13_hv_nmos w=0.5u l=0.45u m=1
MNGb_MXN_S2_18_0 NGb_MXN_n1_36 NGb_bbn2 NGb_MXN_n2_18 vss sg13_hv_nmos w=0.5u l=0.45u m=1
MNGb_MXN_S2_18_1 NGb_MXN_n1_37 NGb_bn2 NGb_MXN_n2_18 vss sg13_hv_nmos w=0.5u l=0.45u m=1
MNGb_MXN_S2_19_0 NGb_MXN_n1_38 NGb_bbn2 NGb_MXN_n2_19 vss sg13_hv_nmos w=0.5u l=0.45u m=1
MNGb_MXN_S2_19_1 NGb_MXN_n1_39 NGb_bn2 NGb_MXN_n2_19 vss sg13_hv_nmos w=0.5u l=0.45u m=1
MNGb_MXN_S2_20_0 NGb_MXN_n1_40 NGb_bbn2 NGb_MXN_n2_20 vss sg13_hv_nmos w=0.5u l=0.45u m=1
MNGb_MXN_S2_20_1 NGb_MXN_n1_41 NGb_bn2 NGb_MXN_n2_20 vss sg13_hv_nmos w=0.5u l=0.45u m=1
MNGb_MXN_S2_21_0 NGb_MXN_n1_42 NGb_bbn2 NGb_MXN_n2_21 vss sg13_hv_nmos w=0.5u l=0.45u m=1
MNGb_MXN_S2_21_1 NGb_MXN_n1_43 NGb_bn2 NGb_MXN_n2_21 vss sg13_hv_nmos w=0.5u l=0.45u m=1
MNGb_MXN_S2_22_0 NGb_MXN_n1_44 NGb_bbn2 NGb_MXN_n2_22 vss sg13_hv_nmos w=0.5u l=0.45u m=1
MNGb_MXN_S2_22_1 NGb_MXN_n1_45 NGb_bn2 NGb_MXN_n2_22 vss sg13_hv_nmos w=0.5u l=0.45u m=1
MNGb_MXN_S2_23_0 NGb_MXN_n1_46 NGb_bbn2 NGb_MXN_n2_23 vss sg13_hv_nmos w=0.5u l=0.45u m=1
MNGb_MXN_S2_23_1 NGb_MXN_n1_47 NGb_bn2 NGb_MXN_n2_23 vss sg13_hv_nmos w=0.5u l=0.45u m=1
MNGb_MXN_S2_24_0 NGb_MXN_n1_48 NGb_bbn2 NGb_MXN_n2_24 vss sg13_hv_nmos w=0.5u l=0.45u m=1
MNGb_MXN_S2_24_1 NGb_MXN_n1_49 NGb_bn2 NGb_MXN_n2_24 vss sg13_hv_nmos w=0.5u l=0.45u m=1
MNGb_MXN_S2_25_0 NGb_MXN_n1_50 NGb_bbn2 NGb_MXN_n2_25 vss sg13_hv_nmos w=0.5u l=0.45u m=1
MNGb_MXN_S2_25_1 NGb_MXN_n1_51 NGb_bn2 NGb_MXN_n2_25 vss sg13_hv_nmos w=0.5u l=0.45u m=1
MNGb_MXN_S2_26_0 NGb_MXN_n1_52 NGb_bbn2 NGb_MXN_n2_26 vss sg13_hv_nmos w=0.5u l=0.45u m=1
MNGb_MXN_S2_26_1 NGb_MXN_n1_53 NGb_bn2 NGb_MXN_n2_26 vss sg13_hv_nmos w=0.5u l=0.45u m=1
MNGb_MXN_S2_27_0 NGb_MXN_n1_54 NGb_bbn2 NGb_MXN_n2_27 vss sg13_hv_nmos w=0.5u l=0.45u m=1
MNGb_MXN_S2_27_1 NGb_MXN_n1_55 NGb_bn2 NGb_MXN_n2_27 vss sg13_hv_nmos w=0.5u l=0.45u m=1
MNGb_MXN_S2_28_0 NGb_MXN_n1_56 NGb_bbn2 NGb_MXN_n2_28 vss sg13_hv_nmos w=0.5u l=0.45u m=1
MNGb_MXN_S2_28_1 NGb_MXN_n1_57 NGb_bn2 NGb_MXN_n2_28 vss sg13_hv_nmos w=0.5u l=0.45u m=1
MNGb_MXN_S2_29_0 NGb_MXN_n1_58 NGb_bbn2 NGb_MXN_n2_29 vss sg13_hv_nmos w=0.5u l=0.45u m=1
MNGb_MXN_S2_29_1 NGb_MXN_n1_59 NGb_bn2 NGb_MXN_n2_29 vss sg13_hv_nmos w=0.5u l=0.45u m=1
MNGb_MXN_S2_30_0 NGb_MXN_n1_60 NGb_bbn2 NGb_MXN_n2_30 vss sg13_hv_nmos w=0.5u l=0.45u m=1
MNGb_MXN_S2_30_1 NGb_MXN_n1_61 NGb_bn2 NGb_MXN_n2_30 vss sg13_hv_nmos w=0.5u l=0.45u m=1
MNGb_MXN_S2_31_0 NGb_MXN_n1_62 NGb_bbn2 NGb_MXN_n2_31 vss sg13_hv_nmos w=0.5u l=0.45u m=1
MNGb_MXN_S2_31_1 NGb_MXN_n1_63 NGb_bn2 NGb_MXN_n2_31 vss sg13_hv_nmos w=0.5u l=0.45u m=1
MNGb_MXN_S3_0_0 NGb_MXN_n2_0 NGb_bbn3 NGb_MXN_n3_0 vss sg13_hv_nmos w=0.5u l=0.45u m=1
MNGb_MXN_S3_0_1 NGb_MXN_n2_1 NGb_bn3 NGb_MXN_n3_0 vss sg13_hv_nmos w=0.5u l=0.45u m=1
MNGb_MXN_S3_1_0 NGb_MXN_n2_2 NGb_bbn3 NGb_MXN_n3_1 vss sg13_hv_nmos w=0.5u l=0.45u m=1
MNGb_MXN_S3_1_1 NGb_MXN_n2_3 NGb_bn3 NGb_MXN_n3_1 vss sg13_hv_nmos w=0.5u l=0.45u m=1
MNGb_MXN_S3_2_0 NGb_MXN_n2_4 NGb_bbn3 NGb_MXN_n3_2 vss sg13_hv_nmos w=0.5u l=0.45u m=1
MNGb_MXN_S3_2_1 NGb_MXN_n2_5 NGb_bn3 NGb_MXN_n3_2 vss sg13_hv_nmos w=0.5u l=0.45u m=1
MNGb_MXN_S3_3_0 NGb_MXN_n2_6 NGb_bbn3 NGb_MXN_n3_3 vss sg13_hv_nmos w=0.5u l=0.45u m=1
MNGb_MXN_S3_3_1 NGb_MXN_n2_7 NGb_bn3 NGb_MXN_n3_3 vss sg13_hv_nmos w=0.5u l=0.45u m=1
MNGb_MXN_S3_4_0 NGb_MXN_n2_8 NGb_bbn3 NGb_MXN_n3_4 vss sg13_hv_nmos w=0.5u l=0.45u m=1
MNGb_MXN_S3_4_1 NGb_MXN_n2_9 NGb_bn3 NGb_MXN_n3_4 vss sg13_hv_nmos w=0.5u l=0.45u m=1
MNGb_MXN_S3_5_0 NGb_MXN_n2_10 NGb_bbn3 NGb_MXN_n3_5 vss sg13_hv_nmos w=0.5u l=0.45u m=1
MNGb_MXN_S3_5_1 NGb_MXN_n2_11 NGb_bn3 NGb_MXN_n3_5 vss sg13_hv_nmos w=0.5u l=0.45u m=1
MNGb_MXN_S3_6_0 NGb_MXN_n2_12 NGb_bbn3 NGb_MXN_n3_6 vss sg13_hv_nmos w=0.5u l=0.45u m=1
MNGb_MXN_S3_6_1 NGb_MXN_n2_13 NGb_bn3 NGb_MXN_n3_6 vss sg13_hv_nmos w=0.5u l=0.45u m=1
MNGb_MXN_S3_7_0 NGb_MXN_n2_14 NGb_bbn3 NGb_MXN_n3_7 vss sg13_hv_nmos w=0.5u l=0.45u m=1
MNGb_MXN_S3_7_1 NGb_MXN_n2_15 NGb_bn3 NGb_MXN_n3_7 vss sg13_hv_nmos w=0.5u l=0.45u m=1
MNGb_MXN_S3_8_0 NGb_MXN_n2_16 NGb_bbn3 NGb_MXN_n3_8 vss sg13_hv_nmos w=0.5u l=0.45u m=1
MNGb_MXN_S3_8_1 NGb_MXN_n2_17 NGb_bn3 NGb_MXN_n3_8 vss sg13_hv_nmos w=0.5u l=0.45u m=1
MNGb_MXN_S3_9_0 NGb_MXN_n2_18 NGb_bbn3 NGb_MXN_n3_9 vss sg13_hv_nmos w=0.5u l=0.45u m=1
MNGb_MXN_S3_9_1 NGb_MXN_n2_19 NGb_bn3 NGb_MXN_n3_9 vss sg13_hv_nmos w=0.5u l=0.45u m=1
MNGb_MXN_S3_10_0 NGb_MXN_n2_20 NGb_bbn3 NGb_MXN_n3_10 vss sg13_hv_nmos w=0.5u l=0.45u m=1
MNGb_MXN_S3_10_1 NGb_MXN_n2_21 NGb_bn3 NGb_MXN_n3_10 vss sg13_hv_nmos w=0.5u l=0.45u m=1
MNGb_MXN_S3_11_0 NGb_MXN_n2_22 NGb_bbn3 NGb_MXN_n3_11 vss sg13_hv_nmos w=0.5u l=0.45u m=1
MNGb_MXN_S3_11_1 NGb_MXN_n2_23 NGb_bn3 NGb_MXN_n3_11 vss sg13_hv_nmos w=0.5u l=0.45u m=1
MNGb_MXN_S3_12_0 NGb_MXN_n2_24 NGb_bbn3 NGb_MXN_n3_12 vss sg13_hv_nmos w=0.5u l=0.45u m=1
MNGb_MXN_S3_12_1 NGb_MXN_n2_25 NGb_bn3 NGb_MXN_n3_12 vss sg13_hv_nmos w=0.5u l=0.45u m=1
MNGb_MXN_S3_13_0 NGb_MXN_n2_26 NGb_bbn3 NGb_MXN_n3_13 vss sg13_hv_nmos w=0.5u l=0.45u m=1
MNGb_MXN_S3_13_1 NGb_MXN_n2_27 NGb_bn3 NGb_MXN_n3_13 vss sg13_hv_nmos w=0.5u l=0.45u m=1
MNGb_MXN_S3_14_0 NGb_MXN_n2_28 NGb_bbn3 NGb_MXN_n3_14 vss sg13_hv_nmos w=0.5u l=0.45u m=1
MNGb_MXN_S3_14_1 NGb_MXN_n2_29 NGb_bn3 NGb_MXN_n3_14 vss sg13_hv_nmos w=0.5u l=0.45u m=1
MNGb_MXN_S3_15_0 NGb_MXN_n2_30 NGb_bbn3 NGb_MXN_n3_15 vss sg13_hv_nmos w=0.5u l=0.45u m=1
MNGb_MXN_S3_15_1 NGb_MXN_n2_31 NGb_bn3 NGb_MXN_n3_15 vss sg13_hv_nmos w=0.5u l=0.45u m=1
MNGb_MXN_S4_0_0 NGb_MXN_n3_0 NGb_bbn4 NGb_MXN_n4_0 vss sg13_hv_nmos w=0.5u l=0.45u m=1
MNGb_MXN_S4_0_1 NGb_MXN_n3_1 NGb_bn4 NGb_MXN_n4_0 vss sg13_hv_nmos w=0.5u l=0.45u m=1
MNGb_MXN_S4_1_0 NGb_MXN_n3_2 NGb_bbn4 NGb_MXN_n4_1 vss sg13_hv_nmos w=0.5u l=0.45u m=1
MNGb_MXN_S4_1_1 NGb_MXN_n3_3 NGb_bn4 NGb_MXN_n4_1 vss sg13_hv_nmos w=0.5u l=0.45u m=1
MNGb_MXN_S4_2_0 NGb_MXN_n3_4 NGb_bbn4 NGb_MXN_n4_2 vss sg13_hv_nmos w=0.5u l=0.45u m=1
MNGb_MXN_S4_2_1 NGb_MXN_n3_5 NGb_bn4 NGb_MXN_n4_2 vss sg13_hv_nmos w=0.5u l=0.45u m=1
MNGb_MXN_S4_3_0 NGb_MXN_n3_6 NGb_bbn4 NGb_MXN_n4_3 vss sg13_hv_nmos w=0.5u l=0.45u m=1
MNGb_MXN_S4_3_1 NGb_MXN_n3_7 NGb_bn4 NGb_MXN_n4_3 vss sg13_hv_nmos w=0.5u l=0.45u m=1
MNGb_MXN_S4_4_0 NGb_MXN_n3_8 NGb_bbn4 NGb_MXN_n4_4 vss sg13_hv_nmos w=0.5u l=0.45u m=1
MNGb_MXN_S4_4_1 NGb_MXN_n3_9 NGb_bn4 NGb_MXN_n4_4 vss sg13_hv_nmos w=0.5u l=0.45u m=1
MNGb_MXN_S4_5_0 NGb_MXN_n3_10 NGb_bbn4 NGb_MXN_n4_5 vss sg13_hv_nmos w=0.5u l=0.45u m=1
MNGb_MXN_S4_5_1 NGb_MXN_n3_11 NGb_bn4 NGb_MXN_n4_5 vss sg13_hv_nmos w=0.5u l=0.45u m=1
MNGb_MXN_S4_6_0 NGb_MXN_n3_12 NGb_bbn4 NGb_MXN_n4_6 vss sg13_hv_nmos w=0.5u l=0.45u m=1
MNGb_MXN_S4_6_1 NGb_MXN_n3_13 NGb_bn4 NGb_MXN_n4_6 vss sg13_hv_nmos w=0.5u l=0.45u m=1
MNGb_MXN_S4_7_0 NGb_MXN_n3_14 NGb_bbn4 NGb_MXN_n4_7 vss sg13_hv_nmos w=0.5u l=0.45u m=1
MNGb_MXN_S4_7_1 NGb_MXN_n3_15 NGb_bn4 NGb_MXN_n4_7 vss sg13_hv_nmos w=0.5u l=0.45u m=1
MNGb_MXN_S5_0_0 NGb_MXN_n4_0 NGb_bbn5 NGb_MXN_n5_0 vss sg13_hv_nmos w=0.5u l=0.45u m=1
MNGb_MXN_S5_0_1 NGb_MXN_n4_1 NGb_bn5 NGb_MXN_n5_0 vss sg13_hv_nmos w=0.5u l=0.45u m=1
MNGb_MXN_S5_1_0 NGb_MXN_n4_2 NGb_bbn5 NGb_MXN_n5_1 vss sg13_hv_nmos w=0.5u l=0.45u m=1
MNGb_MXN_S5_1_1 NGb_MXN_n4_3 NGb_bn5 NGb_MXN_n5_1 vss sg13_hv_nmos w=0.5u l=0.45u m=1
MNGb_MXN_S5_2_0 NGb_MXN_n4_4 NGb_bbn5 NGb_MXN_n5_2 vss sg13_hv_nmos w=0.5u l=0.45u m=1
MNGb_MXN_S5_2_1 NGb_MXN_n4_5 NGb_bn5 NGb_MXN_n5_2 vss sg13_hv_nmos w=0.5u l=0.45u m=1
MNGb_MXN_S5_3_0 NGb_MXN_n4_6 NGb_bbn5 NGb_MXN_n5_3 vss sg13_hv_nmos w=0.5u l=0.45u m=1
MNGb_MXN_S5_3_1 NGb_MXN_n4_7 NGb_bn5 NGb_MXN_n5_3 vss sg13_hv_nmos w=0.5u l=0.45u m=1
MNGb_MXN_S6_0_0 NGb_MXN_n5_0 NGb_bbn6 NGb_MXN_n6_0 vss sg13_hv_nmos w=0.5u l=0.45u m=1
MNGb_MXN_S6_0_1 NGb_MXN_n5_1 NGb_bn6 NGb_MXN_n6_0 vss sg13_hv_nmos w=0.5u l=0.45u m=1
MNGb_MXN_S6_1_0 NGb_MXN_n5_2 NGb_bbn6 NGb_MXN_n6_1 vss sg13_hv_nmos w=0.5u l=0.45u m=1
MNGb_MXN_S6_1_1 NGb_MXN_n5_3 NGb_bn6 NGb_MXN_n6_1 vss sg13_hv_nmos w=0.5u l=0.45u m=1
MNGb_MXN_S7_0_0 NGb_MXN_n6_0 NGb_bbn7 NGb_refn vss sg13_hv_nmos w=0.5u l=0.45u m=1
MNGb_MXN_S7_0_1 NGb_MXN_n6_1 NGb_bn7 NGb_refn vss sg13_hv_nmos w=0.5u l=0.45u m=1
MNGb_CMP_MBN ibias_nb ibias_nb vss vss sg13_hv_nmos w=4u l=1u m=1
MNGb_CMP_MB2 NGb_CMP_vbp ibias_nb vss vss sg13_hv_nmos w=4u l=1u m=1
MNGb_CMP_MBP NGb_CMP_vbp NGb_CMP_vbp vdda vdda sg13_hv_pmos w=4u l=2u m=1
MNGb_CMP_MTA_m0 NGb_CMP_ta NGb_CMP_vbp vdda vdda sg13_hv_pmos w=4u l=2u m=1
MNGb_CMP_MTA_m1 NGb_CMP_ta NGb_CMP_vbp vdda vdda sg13_hv_pmos w=4u l=2u m=1
MNGb_CMP_MTA_m2 NGb_CMP_ta NGb_CMP_vbp vdda vdda sg13_hv_pmos w=4u l=2u m=1
MNGb_CMP_MTA_m3 NGb_CMP_ta NGb_CMP_vbp vdda vdda sg13_hv_pmos w=4u l=2u m=1
MNGb_CMP_MTA_m4 NGb_CMP_ta NGb_CMP_vbp vdda vdda sg13_hv_pmos w=4u l=2u m=1
MNGb_CMP_MTA_m5 NGb_CMP_ta NGb_CMP_vbp vdda vdda sg13_hv_pmos w=4u l=2u m=1
MNGb_CMP_MTA_m6 NGb_CMP_ta NGb_CMP_vbp vdda vdda sg13_hv_pmos w=4u l=2u m=1
MNGb_CMP_MTA_m7 NGb_CMP_ta NGb_CMP_vbp vdda vdda sg13_hv_pmos w=4u l=2u m=1
MNGb_CMP_MTB_m0 NGb_CMP_tb NGb_CMP_vbp vdda vdda sg13_hv_pmos w=4u l=2u m=1
MNGb_CMP_MTB_m1 NGb_CMP_tb NGb_CMP_vbp vdda vdda sg13_hv_pmos w=4u l=2u m=1
MNGb_CMP_MTB_m2 NGb_CMP_tb NGb_CMP_vbp vdda vdda sg13_hv_pmos w=4u l=2u m=1
MNGb_CMP_MTB_m3 NGb_CMP_tb NGb_CMP_vbp vdda vdda sg13_hv_pmos w=4u l=2u m=1
MNGb_CMP_MTB_m4 NGb_CMP_tb NGb_CMP_vbp vdda vdda sg13_hv_pmos w=4u l=2u m=1
MNGb_CMP_MTB_m5 NGb_CMP_tb NGb_CMP_vbp vdda vdda sg13_hv_pmos w=4u l=2u m=1
MNGb_CMP_MTB_m6 NGb_CMP_tb NGb_CMP_vbp vdda vdda sg13_hv_pmos w=4u l=2u m=1
MNGb_CMP_MTB_m7 NGb_CMP_tb NGb_CMP_vbp vdda vdda sg13_hv_pmos w=4u l=2u m=1
MNGb_CMP_MA1 NGb_CMP_d1 outb_n NGb_CMP_sa1 NGb_CMP_ta sg13_hv_pmos w=20u l=2u m=1
MNGb_CMP_MA2 NGb_CMP_d2 outb_p NGb_CMP_sa2 NGb_CMP_ta sg13_hv_pmos w=20u l=2u m=1
RNGb_CMP_RA1 NGb_CMP_ta NGb_CMP_sa1 vss rppd w=2u l=308u b=0 m=1
RNGb_CMP_RA2 NGb_CMP_ta NGb_CMP_sa2 vss rppd w=2u l=308u b=0 m=1
MNGb_CMP_MB1 NGb_CMP_d1 NGb_refn NGb_CMP_sb1 NGb_CMP_tb sg13_hv_pmos w=20u l=2u m=1
MNGb_CMP_MB2I NGb_CMP_d2 NGb_refp NGb_CMP_sb2 NGb_CMP_tb sg13_hv_pmos w=20u l=2u m=1
RNGb_CMP_RB1 NGb_CMP_tb NGb_CMP_sb1 vss rppd w=2u l=308u b=0 m=1
RNGb_CMP_RB2 NGb_CMP_tb NGb_CMP_sb2 vss rppd w=2u l=308u b=0 m=1
MNGb_CMP_ML1 NGb_CMP_d1 NGb_CMP_d1 vss vss sg13_hv_nmos w=40u l=10u m=1
MNGb_CMP_ML2 NGb_CMP_d2 NGb_CMP_d1 vss vss sg13_hv_nmos w=40u l=10u m=1
MNGb_CMP_MG NGb_CMP_o1 NGb_CMP_d2 vss vss sg13_hv_nmos w=2u l=2u m=1
MNGb_CMP_MGL_m0 NGb_CMP_o1 NGb_CMP_vbp vdda vdda sg13_hv_pmos w=4u l=2u m=1
MNGb_CMP_MGL_m1 NGb_CMP_o1 NGb_CMP_vbp vdda vdda sg13_hv_pmos w=4u l=2u m=1
MNGb_CMP_MI1P NGb_CMP_o2 NGb_CMP_o1 vdda vdda sg13_hv_pmos w=2u l=0.5u m=1
MNGb_CMP_MI1N NGb_CMP_o2 NGb_CMP_o1 vss vss sg13_hv_nmos w=1u l=0.45u m=1
MNGb_CMP_MH1a NGb_CMP_hn1 NGb_CMP_vbp vdda vdda sg13_hv_pmos w=0.5u l=8u m=1
MNGb_CMP_MH1b NGb_CMP_hn2 NGb_CMP_vbp NGb_CMP_hn1 vdda sg13_hv_pmos w=0.5u l=8u m=1
MNGb_CMP_MH1c NGb_CMP_hs NGb_CMP_vbp NGb_CMP_hn2 vdda sg13_hv_pmos w=0.5u l=8u m=1
MNGb_CMP_MH2 NGb_CMP_d2 NGb_CMP_o1 NGb_CMP_hs vdda sg13_hv_pmos w=1u l=0.5u m=1
MNGb_CMP_MH3 NGb_CMP_d1 NGb_CMP_o2 NGb_CMP_hs vdda sg13_hv_pmos w=1u l=0.5u m=1
MNGb_CMP_MD1P NGb_CMP_o3 NGb_CMP_o2 vdd vdd sg13_hv_pmos w=2u l=0.5u m=1
MNGb_CMP_MD1N NGb_CMP_o3 NGb_CMP_o2 vss vss sg13_hv_nmos w=1u l=0.45u m=1
MNGb_CMP_MD2P neg_b NGb_CMP_o3 vdd vdd sg13_lv_pmos w=1u l=0.13u m=1
MNGb_CMP_MD2N neg_b NGb_CMP_o3 vss vss sg13_lv_nmos w=0.5u l=0.13u m=1
.ends r1_safe
