* r1_safe mismatch Monte Carlo (reduced fixture, deliberate): the 63-unit string, one overcurrent threshold path
* (r1_safe_thr: level shifters, two 64:1 muxes, comparator; INP=OUTP, INN=OUTN, code 59) and one negative path
* (INP=OUTN, INN=OUTP, lo code 4, i.e. thr code 59 after the r1_safe_an bit inversion), as instantiated in r1_safe_an.
* Each path carries all mismatch sources of one comparator threshold. Codes 59/4 are near the ends of the range,
* where the input pairs carry the largest differential signal (worst case for degeneration mismatch).
* Thresholds: OC +916.7 mV Vod, NEG -916.7 mV Vod. Triangles +-60 mV, 4 us per side, offset by 2 us so that the
* paths never switch together. mm_ok=1 on every device.
* IDEAL REFERENCE SOURCES (this step only): VREF 1.05 V, IBIAS 5 uA PTAT per comparator.
.lib /foss/pdks/ihp-sg13g2/libs.tech/ngspice/models/cornerMOSlv.lib @@MOS@@
.lib /foss/pdks/ihp-sg13g2/libs.tech/ngspice/models/cornerMOShv.lib @@MOS@@
.lib /foss/pdks/ihp-sg13g2/libs.tech/ngspice/models/cornerRES.lib @@RES@@
.lib /foss/pdks/ihp-sg13g2/libs.tech/ngspice/models/cornerCAP.lib @@CAP@@
.temp @@TEMP@@
.include /work/designs/r1-joint/blocks/r1_safe/schematic/r1_safe.spice
.option gmin=1e-12 method=trap
Vdda vdda 0 dc @@VDDA@@
Vdd vdd 0 dc @@VDD@@
Vref vref 0 dc 1.050
Vcms vcms 0 dc 0.570
Io vdda ibias_o dc {5u*(@@TEMP@@+273.15)/300.15}
In vdda ibias_n dc {5u*(@@TEMP@@+273.15)/300.15}
Cbo ibias_o 0 100f
Cbn ibias_n 0 100f
Vvod vod 0 pwl(0 0.85667 4e-06 0.97667 8e-06 0.85667 1e-05 0.85667)
Vvodb vodb 0 pwl(0 -0.85667 2e-06 -0.85667 6e-06 -0.97667 1e-05 -0.85667)
Eap outa_p vcms vod 0 0.5
Ean outa_n vcms vod 0 -0.5
Ebp outb_p vcms vodb 0 0.5
Ebn outb_n vcms vodb 0 -0.5
XSTR vref t0 t1 t2 t3 t4 t5 t6 t7 t8 t9 t10 t11 t12 t13 t14 t15 t16 t17 t18 t19 t20 t21 t22 t23 t24 t25 t26 t27 t28 t29 t30 t31 t32 t33 t34 t35 t36 t37 t38 t39 t40 t41 t42 t43 t44 t45 t46 t47 t48 t49 t50 t51 t52 t53 t54 t55 t56 t57 t58 t59 t60 t61 t62 t63 0 r1_safe_string
Vh0 h0 0 dc @@VDD@@
Vl0 l0 0 dc @@VDD@@
Vh1 h1 0 dc @@VDD@@
Vl1 l1 0 dc @@VDD@@
Vh2 h2 0 dc 0
Vl2 l2 0 dc 0
Vh3 h3 0 dc @@VDD@@
Vl3 l3 0 dc @@VDD@@
Vh4 h4 0 dc @@VDD@@
Vl4 l4 0 dc @@VDD@@
Vh5 h5 0 dc @@VDD@@
Vl5 l5 0 dc @@VDD@@
XOC outa_p outa_n t0 t1 t2 t3 t4 t5 t6 t7 t8 t9 t10 t11 t12 t13 t14 t15 t16 t17 t18 t19 t20 t21 t22 t23 t24 t25 t26 t27 t28 t29 t30 t31 t32 t33 t34 t35 t36 t37 t38 t39 t40 t41 t42 t43 t44 t45 t46 t47 t48 t49 t50 t51 t52 t53 t54 t55 t56 t57 t58 t59 t60 t61 t62 t63 h0 h1 h2 h3 h4 h5 oc_a ibias_o vdda vdd 0 r1_safe_thr
XNG outb_n outb_p t0 t1 t2 t3 t4 t5 t6 t7 t8 t9 t10 t11 t12 t13 t14 t15 t16 t17 t18 t19 t20 t21 t22 t23 t24 t25 t26 t27 t28 t29 t30 t31 t32 t33 t34 t35 t36 t37 t38 t39 t40 t41 t42 t43 t44 t45 t46 t47 t48 t49 t50 t51 t52 t53 t54 t55 t56 t57 t58 t59 t60 t61 t62 t63 l0 l1 l2 l3 l4 l5 neg_b ibias_n vdda vdd 0 r1_safe_thr
CL1 oc_a 0 10f
CL2 neg_b 0 10f
.control
setseed @@SEED@@
let n = @@N@@
let i = 0
let vth = 0.916667
let vthn = -0.916667
let half = @@VDD@@/2
while i < n
  reset
  tran 2n 1e-05 0 2n
  meas tran voa_t find v(vod) when v(oc_a)=half rise=1
  meas tran voa_r find v(vod) when v(oc_a)=half fall=1
  meas tran vnb_t find v(vodb) when v(neg_b)=half rise=1
  meas tran vnb_r find v(vodb) when v(neg_b)=half fall=1
  let e1 = (voa_t - vth)*1e3
  let e4 = (vnb_t - vthn)*1e3
  let h1 = (voa_t - voa_r)*1e3
  let h4 = (vnb_r - vnb_t)*1e3
  let c1 = (voa_t + voa_r)/2*1e3 - vth*1e3
  let c4 = (vnb_t + vnb_r)/2*1e3 - vthn*1e3
  echo "MC" $&i "seed=@@SEED@@ oca_mV=" $&e1 " negb_mV=" $&e4 " hyst_oca_mV=" $&h1 " hyst_negb_mV=" $&h4 " ctr_oca_mV=" $&c1 " ctr_negb_mV=" $&c4
  let i = i + 1
end
.endc
.end
