* r1_safe comparator mismatch Monte Carlo, DC (r1_safe_cmp alone, mm_ok=1 on every device).
* REFP/REFN are ideal sources at the threshold taps (the string and the 64:1 muxes carry no DC current into
* the comparator gates, so they add only the string ratio error, covered by tb_safe_mc). For each sample and each
* threshold Vth = +16.7 mV (code 32), +916.7 mV (code 59) and -916.7 mV (code 4): forward and reverse DC sweeps of
* Vod over Vth +-150 mV, 0.5 mV steps; trip and release points -> threshold (hysteresis centre) error, hysteresis.
* IDEAL SOURCES (this step only): input common mode 0.57 V, tap common mode 0.525 V, IBIAS 5 uA PTAT.
.lib /foss/pdks/ihp-sg13g2/libs.tech/ngspice/models/cornerMOSlv.lib @@MOS@@
.lib /foss/pdks/ihp-sg13g2/libs.tech/ngspice/models/cornerMOShv.lib @@MOS@@
.lib /foss/pdks/ihp-sg13g2/libs.tech/ngspice/models/cornerRES.lib @@RES@@
.lib /foss/pdks/ihp-sg13g2/libs.tech/ngspice/models/cornerCAP.lib @@CAP@@
.temp @@TEMP@@
.include /work/designs/r1-joint/blocks/r1_safe/schematic/r1_safe.spice
.option gmin=1e-12
Vdda vdda 0 dc @@VDDA@@
Vdd vdd 0 dc @@VDD@@
Vcms vcms 0 dc 0.570
Vcmr vcmr 0 dc 0.525
Ib vdda ib dc {5u*(@@TEMP@@+273.15)/300.15}
Vod vod 0 dc 0
Vth vth 0 dc 0
Eap inp vcms vod 0 0.5
Ean inn vcms vod 0 -0.5
Erp refp vcmr vth 0 0.5
Ern refn vcmr vth 0 -0.5
X1 inp inn refp refn out ib vdda vdd 0 r1_safe_cmp
.control
setseed @@SEED@@
let half = @@VDD@@/2
let k = 0
while k < @@N@@
  foreach th 0.016667 0.916667 -0.916667
    reset
    alter vth dc = $th
    let lo = $th - 0.15
    let hi = $th + 0.15
    dc vod $&lo $&hi 0.5m
    meas dc up find v(vod) when v(out)=half rise=1
    dc vod $&hi $&lo -0.5m
    meas dc dn find v(vod) when v(out)=half fall=1
    echo "DCMC seed=@@SEED@@ k=" $&k " th=" $th
  end
  let k = k + 1
end
.endc
.end
