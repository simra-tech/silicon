* Generate tb_safe_joint3.cir: joint path r1_isense (both channels, real outputs) -> r1_safe_an (revision 3), nominal
* devices, corner template for run_deck.py. Questions: threshold centre and delay through the real sense output, and
* simultaneous switching of all four comparators on the shared string.
* Timeline (both channels, shunt-referred input Vsh = ISP - ISN):
*   0-2.05 us     r1_isense auto-zero, Vsh = 0 (comparator outputs invalid, blanked by r1_ctrl)
*   3-13 us       SIMULTANEOUS: both channels ramp Vsh_th -3 mV -> +3 mV -> -3 mV (5 us per side); OC_a, OC_b trip and
*                 NEG_a, NEG_b release at the same crossing (all four at code THR, calibration code k = 32)
*   14-26.5 us    STAGGERED: the same ramp, channel b delayed by 2.5 us (reference without coincident switching)
*   27 us         both channels step 0 -> Vsh_th + 10 % (of Vsh_th) together; 29 us back to 0
*   31-37 us      CROSS-CHANNEL: channel b holds Vsh_th - 1 mV (31-34 us, below its trip point) then Vsh_th + 1 mV
*                 (34-37 us, above), while channel a steps 0 -> Vsh_th + 10 % at 31.5 / 34.5 us and back at 32.5 / 35.5 us;
*                 any transition of oc_b / neg_b in these windows is kickback through the shared string taps
*   Optional reference decoupling (R1_CREF = cmim side in um, 0 = none) on every comparator reference node.
* PATH FIXTURE (deliberate): the codes are static in this deck, so each 256:1 mux is represented by its conducting
* path (8 series thick NMOS switches w 0.5 l 0.45, gates at VDDA) plus one off switch (gate at 0) per level from the
* sibling tap, i.e. the real reference-path impedance and junction loading at 1/30 of the device count. String and
* comparators are the netlist of record; no code level shifters (static codes). The full-netlist version ran at about
* 8 min per simulated us (dev-joint3-fullmux, stopped).
* IDEAL SOURCES (this step only): VREF 1.05 V (shared by r1_isense pedestal arms and the r1_safe string), VCM 0.6 V,
* IBIAS 5 uA PTAT per r1_isense channel and per comparator, AZ phases.  Load: 2 pF per sense output (ADC T/H).
.lib /foss/pdks/ihp-sg13g2/libs.tech/ngspice/models/cornerMOSlv.lib @@MOS@@
.lib /foss/pdks/ihp-sg13g2/libs.tech/ngspice/models/cornerMOShv.lib @@MOS@@
.lib /foss/pdks/ihp-sg13g2/libs.tech/ngspice/models/cornerRES.lib @@RES@@
.lib /foss/pdks/ihp-sg13g2/libs.tech/ngspice/models/cornerCAP.lib @@CAP@@
.temp @@TEMP@@
.include /work/designs/r1-joint/blocks/r1_isense/schematic/r1_isense.spice
.include /work/designs/r1-joint/blocks/r1_safe/schematic/r1_safe.spice
.option gmin=1e-12 method=gear reltol=1e-4 abstol=1e-12 vntol=1e-7
Vdda vdda 0 dc @@VDDA@@
Vdd vdd 0 dc @@VDD@@
Vref vref 0 dc 1.05
Vcm vcm 0 dc 0.6
Iba vdda iba dc {5u*(@@TEMP@@+273.15)/300.15}
Ibb vdda ibb dc {5u*(@@TEMP@@+273.15)/300.15}
Ioa vdda ibias_oa dc {5u*(@@TEMP@@+273.15)/300.15}
Ina vdda ibias_na dc {5u*(@@TEMP@@+273.15)/300.15}
Iob vdda ibias_ob dc {5u*(@@TEMP@@+273.15)/300.15}
Inb vdda ibias_nb dc {5u*(@@TEMP@@+273.15)/300.15}
Cba ibias_oa 0 100f
Cbb ibias_na 0 100f
Cbc ibias_ob 0 100f
Cbd ibias_nb 0 100f
Vaz az 0 pwl(0 @@VDD@@ 2.05u @@VDD@@ 2.051u 0)
Vazh azh 0 pwl(0 @@VDD@@ 2.0u @@VDD@@ 2.001u 0)
Vna isa_n 0 dc 0
Vnb isb_n 0 dc 0
Vpa isa_p isa_n pwl(0 0 2.5e-06 0 3e-06 0.0671465 8e-06 0.0731465 1.3e-05 0.0671465 1.4e-05 0.0671465 1.9e-05 0.0731465 2.4e-05 0.0671465 2.65e-05 0.0671465 2.66e-05 0 2.7e-05 0 2.7001e-05 0.0771612 2.9e-05 0.0771612 2.9001e-05 0 3.1e-05 0 3.15e-05 0 3.1501e-05 0.0771612 3.25e-05 0.0771612 3.2501e-05 0 3.45e-05 0 3.4501e-05 0.0771612 3.55e-05 0.0771612 3.5501e-05 0 3.7e-05 0)
Vpb isb_p isb_n pwl(0 0 2.5e-06 0 3e-06 0.0671465 8e-06 0.0731465 1.3e-05 0.0671465 1.65e-05 0.0671465 2.15e-05 0.0731465 2.65e-05 0.0671465 2.66e-05 0 2.7e-05 0 2.7001e-05 0.0771612 2.9e-05 0.0771612 2.9001e-05 0 3e-05 0 3.1e-05 0.0691465 3.4e-05 0.0691465 3.43e-05 0.0711465 3.7e-05 0.0711465)
XIS isa_p isa_n isb_p isb_n outa_p outa_n outb_p outb_n vref vcm iba ibb az azh az azh vdda vdd 0 r1_isense
CLap outa_p 0 2p
CLan outa_n 0 2p
CLbp outb_p 0 2p
CLbn outb_n 0 2p
XSTR vref t0 t1 t2 t3 t4 t5 t6 t7 t8 t9 t10 t11 t12 t13 t14 t15 t16 t17 t18 t19 t20 t21 t22 t23 t24 t25 t26 t27 t28 t29 t30 t31 t32 t33 t34 t35 t36 t37 t38 t39 t40 t41 t42 t43 t44 t45 t46 t47 t48 t49 t50 t51 t52 t53 t54 t55 t56 t57 t58 t59 t60 t61 t62 t63 t64 t65 t66 t67 t68 t69 t70 t71 t72 t73 t74 t75 t76 t77 t78 t79 t80 t81 t82 t83 t84 t85 t86 t87 t88 t89 t90 t91 t92 t93 t94 t95 t96 t97 t98 t99 t100 t101 t102 t103 t104 t105 t106 t107 t108 t109 t110 t111 t112 t113 t114 t115 t116 t117 t118 t119 t120 t121 t122 t123 t124 t125 t126 t127 t128 t129 t130 t131 t132 t133 t134 t135 t136 t137 t138 t139 t140 t141 t142 t143 t144 t145 t146 t147 t148 t149 t150 t151 t152 t153 t154 t155 t156 t157 t158 t159 t160 t161 t162 t163 t164 t165 t166 t167 t168 t169 t170 t171 t172 t173 t174 t175 t176 t177 t178 t179 t180 t181 t182 t183 t184 t185 t186 t187 t188 t189 t190 t191 t192 t193 t194 t195 t196 t197 t198 t199 t200 t201 t202 t203 t204 t205 t206 t207 t208 t209 t210 t211 t212 t213 t214 t215 t216 t217 t218 t219 t220 t221 t222 t223 t224 t225 t226 t227 t228 t229 t230 t231 t232 t233 t234 t235 t236 t237 t238 t239 t240 t241 t242 t243 t244 t245 t246 t247 t248 t249 t250 t251 t252 0 r1_safe_string
* oa: cell code 44, k = 32: REFP = T176, REFN = T76
Xmpoa_on0 t176 vdda mpoa_l0 0 sg13_hv_nmos w=0.5u l=0.45u ng=1 m=1 mm_ok=1
Xmpoa_off0 t177 0 mpoa_l0 0 sg13_hv_nmos w=0.5u l=0.45u ng=1 m=1 mm_ok=1
Xmpoa_on1 mpoa_l0 vdda mpoa_l1 0 sg13_hv_nmos w=0.5u l=0.45u ng=1 m=1 mm_ok=1
Xmpoa_off1 t178 0 mpoa_l1 0 sg13_hv_nmos w=0.5u l=0.45u ng=1 m=1 mm_ok=1
Xmpoa_on2 mpoa_l1 vdda mpoa_l2 0 sg13_hv_nmos w=0.5u l=0.45u ng=1 m=1 mm_ok=1
Xmpoa_off2 t180 0 mpoa_l2 0 sg13_hv_nmos w=0.5u l=0.45u ng=1 m=1 mm_ok=1
Xmpoa_on3 mpoa_l2 vdda mpoa_l3 0 sg13_hv_nmos w=0.5u l=0.45u ng=1 m=1 mm_ok=1
Xmpoa_off3 t184 0 mpoa_l3 0 sg13_hv_nmos w=0.5u l=0.45u ng=1 m=1 mm_ok=1
Xmpoa_on4 mpoa_l3 vdda mpoa_l4 0 sg13_hv_nmos w=0.5u l=0.45u ng=1 m=1 mm_ok=1
Xmpoa_off4 t160 0 mpoa_l4 0 sg13_hv_nmos w=0.5u l=0.45u ng=1 m=1 mm_ok=1
Xmpoa_on5 mpoa_l4 vdda mpoa_l5 0 sg13_hv_nmos w=0.5u l=0.45u ng=1 m=1 mm_ok=1
Xmpoa_off5 t144 0 mpoa_l5 0 sg13_hv_nmos w=0.5u l=0.45u ng=1 m=1 mm_ok=1
Xmpoa_on6 mpoa_l5 vdda mpoa_l6 0 sg13_hv_nmos w=0.5u l=0.45u ng=1 m=1 mm_ok=1
Xmpoa_off6 t240 0 mpoa_l6 0 sg13_hv_nmos w=0.5u l=0.45u ng=1 m=1 mm_ok=1
Xmpoa_on7 mpoa_l6 vdda refp_oa 0 sg13_hv_nmos w=0.5u l=0.45u ng=1 m=1 mm_ok=1
Xmpoa_off7 t48 0 refp_oa 0 sg13_hv_nmos w=0.5u l=0.45u ng=1 m=1 mm_ok=1
Xmnoa_on0 t76 vdda mnoa_l0 0 sg13_hv_nmos w=0.5u l=0.45u ng=1 m=1 mm_ok=1
Xmnoa_off0 t77 0 mnoa_l0 0 sg13_hv_nmos w=0.5u l=0.45u ng=1 m=1 mm_ok=1
Xmnoa_on1 mnoa_l0 vdda mnoa_l1 0 sg13_hv_nmos w=0.5u l=0.45u ng=1 m=1 mm_ok=1
Xmnoa_off1 t78 0 mnoa_l1 0 sg13_hv_nmos w=0.5u l=0.45u ng=1 m=1 mm_ok=1
Xmnoa_on2 mnoa_l1 vdda mnoa_l2 0 sg13_hv_nmos w=0.5u l=0.45u ng=1 m=1 mm_ok=1
Xmnoa_off2 t72 0 mnoa_l2 0 sg13_hv_nmos w=0.5u l=0.45u ng=1 m=1 mm_ok=1
Xmnoa_on3 mnoa_l2 vdda mnoa_l3 0 sg13_hv_nmos w=0.5u l=0.45u ng=1 m=1 mm_ok=1
Xmnoa_off3 t68 0 mnoa_l3 0 sg13_hv_nmos w=0.5u l=0.45u ng=1 m=1 mm_ok=1
Xmnoa_on4 mnoa_l3 vdda mnoa_l4 0 sg13_hv_nmos w=0.5u l=0.45u ng=1 m=1 mm_ok=1
Xmnoa_off4 t92 0 mnoa_l4 0 sg13_hv_nmos w=0.5u l=0.45u ng=1 m=1 mm_ok=1
Xmnoa_on5 mnoa_l4 vdda mnoa_l5 0 sg13_hv_nmos w=0.5u l=0.45u ng=1 m=1 mm_ok=1
Xmnoa_off5 t108 0 mnoa_l5 0 sg13_hv_nmos w=0.5u l=0.45u ng=1 m=1 mm_ok=1
Xmnoa_on6 mnoa_l5 vdda mnoa_l6 0 sg13_hv_nmos w=0.5u l=0.45u ng=1 m=1 mm_ok=1
Xmnoa_off6 t12 0 mnoa_l6 0 sg13_hv_nmos w=0.5u l=0.45u ng=1 m=1 mm_ok=1
Xmnoa_on7 mnoa_l6 vdda refn_oa 0 sg13_hv_nmos w=0.5u l=0.45u ng=1 m=1 mm_ok=1
Xmnoa_off7 t204 0 refn_oa 0 sg13_hv_nmos w=0.5u l=0.45u ng=1 m=1 mm_ok=1
XOA outa_p outa_n refp_oa refn_oa oc_a ibias_oa vdda vdd 0 r1_safe_cmp
* na: cell code 19, k = 32: REFP = T76, REFN = T176
Xmpna_on0 t76 vdda mpna_l0 0 sg13_hv_nmos w=0.5u l=0.45u ng=1 m=1 mm_ok=1
Xmpna_off0 t77 0 mpna_l0 0 sg13_hv_nmos w=0.5u l=0.45u ng=1 m=1 mm_ok=1
Xmpna_on1 mpna_l0 vdda mpna_l1 0 sg13_hv_nmos w=0.5u l=0.45u ng=1 m=1 mm_ok=1
Xmpna_off1 t78 0 mpna_l1 0 sg13_hv_nmos w=0.5u l=0.45u ng=1 m=1 mm_ok=1
Xmpna_on2 mpna_l1 vdda mpna_l2 0 sg13_hv_nmos w=0.5u l=0.45u ng=1 m=1 mm_ok=1
Xmpna_off2 t72 0 mpna_l2 0 sg13_hv_nmos w=0.5u l=0.45u ng=1 m=1 mm_ok=1
Xmpna_on3 mpna_l2 vdda mpna_l3 0 sg13_hv_nmos w=0.5u l=0.45u ng=1 m=1 mm_ok=1
Xmpna_off3 t68 0 mpna_l3 0 sg13_hv_nmos w=0.5u l=0.45u ng=1 m=1 mm_ok=1
Xmpna_on4 mpna_l3 vdda mpna_l4 0 sg13_hv_nmos w=0.5u l=0.45u ng=1 m=1 mm_ok=1
Xmpna_off4 t92 0 mpna_l4 0 sg13_hv_nmos w=0.5u l=0.45u ng=1 m=1 mm_ok=1
Xmpna_on5 mpna_l4 vdda mpna_l5 0 sg13_hv_nmos w=0.5u l=0.45u ng=1 m=1 mm_ok=1
Xmpna_off5 t108 0 mpna_l5 0 sg13_hv_nmos w=0.5u l=0.45u ng=1 m=1 mm_ok=1
Xmpna_on6 mpna_l5 vdda mpna_l6 0 sg13_hv_nmos w=0.5u l=0.45u ng=1 m=1 mm_ok=1
Xmpna_off6 t12 0 mpna_l6 0 sg13_hv_nmos w=0.5u l=0.45u ng=1 m=1 mm_ok=1
Xmpna_on7 mpna_l6 vdda refp_na 0 sg13_hv_nmos w=0.5u l=0.45u ng=1 m=1 mm_ok=1
Xmpna_off7 t204 0 refp_na 0 sg13_hv_nmos w=0.5u l=0.45u ng=1 m=1 mm_ok=1
Xmnna_on0 t176 vdda mnna_l0 0 sg13_hv_nmos w=0.5u l=0.45u ng=1 m=1 mm_ok=1
Xmnna_off0 t177 0 mnna_l0 0 sg13_hv_nmos w=0.5u l=0.45u ng=1 m=1 mm_ok=1
Xmnna_on1 mnna_l0 vdda mnna_l1 0 sg13_hv_nmos w=0.5u l=0.45u ng=1 m=1 mm_ok=1
Xmnna_off1 t178 0 mnna_l1 0 sg13_hv_nmos w=0.5u l=0.45u ng=1 m=1 mm_ok=1
Xmnna_on2 mnna_l1 vdda mnna_l2 0 sg13_hv_nmos w=0.5u l=0.45u ng=1 m=1 mm_ok=1
Xmnna_off2 t180 0 mnna_l2 0 sg13_hv_nmos w=0.5u l=0.45u ng=1 m=1 mm_ok=1
Xmnna_on3 mnna_l2 vdda mnna_l3 0 sg13_hv_nmos w=0.5u l=0.45u ng=1 m=1 mm_ok=1
Xmnna_off3 t184 0 mnna_l3 0 sg13_hv_nmos w=0.5u l=0.45u ng=1 m=1 mm_ok=1
Xmnna_on4 mnna_l3 vdda mnna_l4 0 sg13_hv_nmos w=0.5u l=0.45u ng=1 m=1 mm_ok=1
Xmnna_off4 t160 0 mnna_l4 0 sg13_hv_nmos w=0.5u l=0.45u ng=1 m=1 mm_ok=1
Xmnna_on5 mnna_l4 vdda mnna_l5 0 sg13_hv_nmos w=0.5u l=0.45u ng=1 m=1 mm_ok=1
Xmnna_off5 t144 0 mnna_l5 0 sg13_hv_nmos w=0.5u l=0.45u ng=1 m=1 mm_ok=1
Xmnna_on6 mnna_l5 vdda mnna_l6 0 sg13_hv_nmos w=0.5u l=0.45u ng=1 m=1 mm_ok=1
Xmnna_off6 t240 0 mnna_l6 0 sg13_hv_nmos w=0.5u l=0.45u ng=1 m=1 mm_ok=1
Xmnna_on7 mnna_l6 vdda refn_na 0 sg13_hv_nmos w=0.5u l=0.45u ng=1 m=1 mm_ok=1
Xmnna_off7 t48 0 refn_na 0 sg13_hv_nmos w=0.5u l=0.45u ng=1 m=1 mm_ok=1
XNA outa_n outa_p refp_na refn_na neg_a ibias_na vdda vdd 0 r1_safe_cmp
* ob: cell code 44, k = 32: REFP = T176, REFN = T76
Xmpob_on0 t176 vdda mpob_l0 0 sg13_hv_nmos w=0.5u l=0.45u ng=1 m=1 mm_ok=1
Xmpob_off0 t177 0 mpob_l0 0 sg13_hv_nmos w=0.5u l=0.45u ng=1 m=1 mm_ok=1
Xmpob_on1 mpob_l0 vdda mpob_l1 0 sg13_hv_nmos w=0.5u l=0.45u ng=1 m=1 mm_ok=1
Xmpob_off1 t178 0 mpob_l1 0 sg13_hv_nmos w=0.5u l=0.45u ng=1 m=1 mm_ok=1
Xmpob_on2 mpob_l1 vdda mpob_l2 0 sg13_hv_nmos w=0.5u l=0.45u ng=1 m=1 mm_ok=1
Xmpob_off2 t180 0 mpob_l2 0 sg13_hv_nmos w=0.5u l=0.45u ng=1 m=1 mm_ok=1
Xmpob_on3 mpob_l2 vdda mpob_l3 0 sg13_hv_nmos w=0.5u l=0.45u ng=1 m=1 mm_ok=1
Xmpob_off3 t184 0 mpob_l3 0 sg13_hv_nmos w=0.5u l=0.45u ng=1 m=1 mm_ok=1
Xmpob_on4 mpob_l3 vdda mpob_l4 0 sg13_hv_nmos w=0.5u l=0.45u ng=1 m=1 mm_ok=1
Xmpob_off4 t160 0 mpob_l4 0 sg13_hv_nmos w=0.5u l=0.45u ng=1 m=1 mm_ok=1
Xmpob_on5 mpob_l4 vdda mpob_l5 0 sg13_hv_nmos w=0.5u l=0.45u ng=1 m=1 mm_ok=1
Xmpob_off5 t144 0 mpob_l5 0 sg13_hv_nmos w=0.5u l=0.45u ng=1 m=1 mm_ok=1
Xmpob_on6 mpob_l5 vdda mpob_l6 0 sg13_hv_nmos w=0.5u l=0.45u ng=1 m=1 mm_ok=1
Xmpob_off6 t240 0 mpob_l6 0 sg13_hv_nmos w=0.5u l=0.45u ng=1 m=1 mm_ok=1
Xmpob_on7 mpob_l6 vdda refp_ob 0 sg13_hv_nmos w=0.5u l=0.45u ng=1 m=1 mm_ok=1
Xmpob_off7 t48 0 refp_ob 0 sg13_hv_nmos w=0.5u l=0.45u ng=1 m=1 mm_ok=1
Xmnob_on0 t76 vdda mnob_l0 0 sg13_hv_nmos w=0.5u l=0.45u ng=1 m=1 mm_ok=1
Xmnob_off0 t77 0 mnob_l0 0 sg13_hv_nmos w=0.5u l=0.45u ng=1 m=1 mm_ok=1
Xmnob_on1 mnob_l0 vdda mnob_l1 0 sg13_hv_nmos w=0.5u l=0.45u ng=1 m=1 mm_ok=1
Xmnob_off1 t78 0 mnob_l1 0 sg13_hv_nmos w=0.5u l=0.45u ng=1 m=1 mm_ok=1
Xmnob_on2 mnob_l1 vdda mnob_l2 0 sg13_hv_nmos w=0.5u l=0.45u ng=1 m=1 mm_ok=1
Xmnob_off2 t72 0 mnob_l2 0 sg13_hv_nmos w=0.5u l=0.45u ng=1 m=1 mm_ok=1
Xmnob_on3 mnob_l2 vdda mnob_l3 0 sg13_hv_nmos w=0.5u l=0.45u ng=1 m=1 mm_ok=1
Xmnob_off3 t68 0 mnob_l3 0 sg13_hv_nmos w=0.5u l=0.45u ng=1 m=1 mm_ok=1
Xmnob_on4 mnob_l3 vdda mnob_l4 0 sg13_hv_nmos w=0.5u l=0.45u ng=1 m=1 mm_ok=1
Xmnob_off4 t92 0 mnob_l4 0 sg13_hv_nmos w=0.5u l=0.45u ng=1 m=1 mm_ok=1
Xmnob_on5 mnob_l4 vdda mnob_l5 0 sg13_hv_nmos w=0.5u l=0.45u ng=1 m=1 mm_ok=1
Xmnob_off5 t108 0 mnob_l5 0 sg13_hv_nmos w=0.5u l=0.45u ng=1 m=1 mm_ok=1
Xmnob_on6 mnob_l5 vdda mnob_l6 0 sg13_hv_nmos w=0.5u l=0.45u ng=1 m=1 mm_ok=1
Xmnob_off6 t12 0 mnob_l6 0 sg13_hv_nmos w=0.5u l=0.45u ng=1 m=1 mm_ok=1
Xmnob_on7 mnob_l6 vdda refn_ob 0 sg13_hv_nmos w=0.5u l=0.45u ng=1 m=1 mm_ok=1
Xmnob_off7 t204 0 refn_ob 0 sg13_hv_nmos w=0.5u l=0.45u ng=1 m=1 mm_ok=1
XOB outb_p outb_n refp_ob refn_ob oc_b ibias_ob vdda vdd 0 r1_safe_cmp
* nb: cell code 19, k = 32: REFP = T76, REFN = T176
Xmpnb_on0 t76 vdda mpnb_l0 0 sg13_hv_nmos w=0.5u l=0.45u ng=1 m=1 mm_ok=1
Xmpnb_off0 t77 0 mpnb_l0 0 sg13_hv_nmos w=0.5u l=0.45u ng=1 m=1 mm_ok=1
Xmpnb_on1 mpnb_l0 vdda mpnb_l1 0 sg13_hv_nmos w=0.5u l=0.45u ng=1 m=1 mm_ok=1
Xmpnb_off1 t78 0 mpnb_l1 0 sg13_hv_nmos w=0.5u l=0.45u ng=1 m=1 mm_ok=1
Xmpnb_on2 mpnb_l1 vdda mpnb_l2 0 sg13_hv_nmos w=0.5u l=0.45u ng=1 m=1 mm_ok=1
Xmpnb_off2 t72 0 mpnb_l2 0 sg13_hv_nmos w=0.5u l=0.45u ng=1 m=1 mm_ok=1
Xmpnb_on3 mpnb_l2 vdda mpnb_l3 0 sg13_hv_nmos w=0.5u l=0.45u ng=1 m=1 mm_ok=1
Xmpnb_off3 t68 0 mpnb_l3 0 sg13_hv_nmos w=0.5u l=0.45u ng=1 m=1 mm_ok=1
Xmpnb_on4 mpnb_l3 vdda mpnb_l4 0 sg13_hv_nmos w=0.5u l=0.45u ng=1 m=1 mm_ok=1
Xmpnb_off4 t92 0 mpnb_l4 0 sg13_hv_nmos w=0.5u l=0.45u ng=1 m=1 mm_ok=1
Xmpnb_on5 mpnb_l4 vdda mpnb_l5 0 sg13_hv_nmos w=0.5u l=0.45u ng=1 m=1 mm_ok=1
Xmpnb_off5 t108 0 mpnb_l5 0 sg13_hv_nmos w=0.5u l=0.45u ng=1 m=1 mm_ok=1
Xmpnb_on6 mpnb_l5 vdda mpnb_l6 0 sg13_hv_nmos w=0.5u l=0.45u ng=1 m=1 mm_ok=1
Xmpnb_off6 t12 0 mpnb_l6 0 sg13_hv_nmos w=0.5u l=0.45u ng=1 m=1 mm_ok=1
Xmpnb_on7 mpnb_l6 vdda refp_nb 0 sg13_hv_nmos w=0.5u l=0.45u ng=1 m=1 mm_ok=1
Xmpnb_off7 t204 0 refp_nb 0 sg13_hv_nmos w=0.5u l=0.45u ng=1 m=1 mm_ok=1
Xmnnb_on0 t176 vdda mnnb_l0 0 sg13_hv_nmos w=0.5u l=0.45u ng=1 m=1 mm_ok=1
Xmnnb_off0 t177 0 mnnb_l0 0 sg13_hv_nmos w=0.5u l=0.45u ng=1 m=1 mm_ok=1
Xmnnb_on1 mnnb_l0 vdda mnnb_l1 0 sg13_hv_nmos w=0.5u l=0.45u ng=1 m=1 mm_ok=1
Xmnnb_off1 t178 0 mnnb_l1 0 sg13_hv_nmos w=0.5u l=0.45u ng=1 m=1 mm_ok=1
Xmnnb_on2 mnnb_l1 vdda mnnb_l2 0 sg13_hv_nmos w=0.5u l=0.45u ng=1 m=1 mm_ok=1
Xmnnb_off2 t180 0 mnnb_l2 0 sg13_hv_nmos w=0.5u l=0.45u ng=1 m=1 mm_ok=1
Xmnnb_on3 mnnb_l2 vdda mnnb_l3 0 sg13_hv_nmos w=0.5u l=0.45u ng=1 m=1 mm_ok=1
Xmnnb_off3 t184 0 mnnb_l3 0 sg13_hv_nmos w=0.5u l=0.45u ng=1 m=1 mm_ok=1
Xmnnb_on4 mnnb_l3 vdda mnnb_l4 0 sg13_hv_nmos w=0.5u l=0.45u ng=1 m=1 mm_ok=1
Xmnnb_off4 t160 0 mnnb_l4 0 sg13_hv_nmos w=0.5u l=0.45u ng=1 m=1 mm_ok=1
Xmnnb_on5 mnnb_l4 vdda mnnb_l5 0 sg13_hv_nmos w=0.5u l=0.45u ng=1 m=1 mm_ok=1
Xmnnb_off5 t144 0 mnnb_l5 0 sg13_hv_nmos w=0.5u l=0.45u ng=1 m=1 mm_ok=1
Xmnnb_on6 mnnb_l5 vdda mnnb_l6 0 sg13_hv_nmos w=0.5u l=0.45u ng=1 m=1 mm_ok=1
Xmnnb_off6 t240 0 mnnb_l6 0 sg13_hv_nmos w=0.5u l=0.45u ng=1 m=1 mm_ok=1
Xmnnb_on7 mnnb_l6 vdda refn_nb 0 sg13_hv_nmos w=0.5u l=0.45u ng=1 m=1 mm_ok=1
Xmnnb_off7 t48 0 refn_nb 0 sg13_hv_nmos w=0.5u l=0.45u ng=1 m=1 mm_ok=1
XNB outb_n outb_p refp_nb refn_nb neg_b ibias_nb vdda vdd 0 r1_safe_cmp
CL1 oc_a 0 10f
CL2 neg_a 0 10f
CL3 oc_b 0 10f
CL4 neg_b 0 10f
.control
set wr_singlescale
set wr_vecnames
tran 1n 37u 0 1n
wrdata @@OUT@@_joint.txt v(isa_p) v(isb_p) v(outa_p) v(outa_n) v(outb_p) v(outb_n) v(oc_a) v(neg_a) v(oc_b) v(neg_b) v(t176) v(t76) i(vdda) i(vdd)
.endc
.end
