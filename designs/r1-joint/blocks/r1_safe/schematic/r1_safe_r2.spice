* SUPERSEDED: revision-2 netlist of record (sha256 prefix 63ac3d0b7961 before this header line), kept as a record. Revision 3 is r1_safe.spice.
* GENERATED by gen_safe.py -- do not edit; sizes: CREF=0 IH_M=1 ITAIL_M=8 LG=2 LH=8 LIN=2 LM=4 NH=3 RSL=30 RSW=1 WG=2 WH=0.5 WIN=20 WM=16
* r1_safe analog: two window comparators per channel (overcurrent high, negative/phase-short low) with 6-bit
* threshold DACs from VREF. IHP SG13G2, schematic-level SPICE source.
*
* Threshold DAC: one 63-unit rppd string (unit 4 kOhm, w=2 l=30.8) from VREF to VSS, taps T0..T63, Tk = k/63*VREF.
*   Each comparator has two 64:1 thick-NMOS tree multiplexers driven by the same 6 code bits:
*   REFP = T(code), REFN = T(63-code) (bits swapped), so  Vth_od = REFP - REFN = (2*code - 63)/63 * VREF.
*   With r1_isense (Vod = 14*(Vsh - VREF/26)) the shunt-referred threshold is
*   Vsh_th = VREF*(1/26 + (2*code-63)/882): -34.6 mV (code 0) .. +115.4 mV (code 63), 2.381 mV per code,
*   set by VREF and resistor ratios only.
* Comparator r1_safe_cmp: trips (OUT high) when (INP - INN) > (REFP - REFN).
*   Overcurrent: INP=OUTP, INN=OUTN, REFP/REFN from the high code.  Negative/phase short: INP=OUTN, INN=OUTP,
*   REFP=T(63-code_lo), REFN=T(code_lo), i.e. trips when Vod < (2*code_lo - 63)/63*VREF.
*   Inputs are thick-oxide PMOS gates (rated 3.3 V); no divider. The sense outputs are <= VDD by construction.
*   Continuous time, no clock (no clock-edge race as in G1 TRIP F1). Hysteresis by an output-switched current.
*   Output: 1.2 V logic (thick-input inverter on VDD, then a thin-oxide inverter), high = threshold crossed.
* Code bits: 1.2 V logic from r1_ctrl registers, level-shifted here (r1_safe_ls).
* Device conventions: PMOS bulks to VDDA except input pairs (bulk = own tail); NMOS bulks to VSS; mm_ok=1.

.subckt r1_safe_ls in vdd vdda vss out outb
XMIP inb in vdd vdd sg13_lv_pmos w=1u l=0.13u ng=1 m=1 mm_ok=1
XMIN inb in vss vss sg13_lv_nmos w=0.5u l=0.13u ng=1 m=1 mm_ok=1
XMN1 a in vss vss sg13_hv_nmos w=4u l=0.45u ng=1 m=1 mm_ok=1
XMN2 b inb vss vss sg13_hv_nmos w=4u l=0.45u ng=1 m=1 mm_ok=1
XMP1 a b vdda vdda sg13_hv_pmos w=0.6u l=0.5u ng=1 m=1 mm_ok=1
XMP2 b a vdda vdda sg13_hv_pmos w=0.6u l=0.5u ng=1 m=1 mm_ok=1
XMB1P outb b vdda vdda sg13_hv_pmos w=2u l=0.5u ng=1 m=1 mm_ok=1
XMB1N outb b vss vss sg13_hv_nmos w=1u l=0.45u ng=1 m=1 mm_ok=1
XMB2P out outb vdda vdda sg13_hv_pmos w=2u l=0.5u ng=1 m=1 mm_ok=1
XMB2N out outb vss vss sg13_hv_nmos w=1u l=0.45u ng=1 m=1 mm_ok=1
.ends r1_safe_ls

.subckt r1_safe_mux64 t0 t1 t2 t3 t4 t5 t6 t7 t8 t9 t10 t11 t12 t13 t14 t15 t16 t17 t18 t19 t20 t21 t22 t23 t24 t25 t26 t27 t28 t29 t30 t31 t32 t33 t34 t35 t36 t37 t38 t39 t40 t41 t42 t43 t44 t45 t46 t47 t48 t49 t50 t51 t52 t53 t54 t55 t56 t57 t58 t59 t60 t61 t62 t63 b0 b1 b2 b3 b4 b5 bb0 bb1 bb2 bb3 bb4 bb5 out vss
* out = t(code), code = sum b_i 2^i; thick NMOS pass switches (gates 0 / 3.3 V), w=0.5 l=0.45
XS0_0_0 t0 bb0 n0_0 vss sg13_hv_nmos w=0.5u l=0.45u ng=1 m=1 mm_ok=1
XS0_0_1 t1 b0 n0_0 vss sg13_hv_nmos w=0.5u l=0.45u ng=1 m=1 mm_ok=1
XS0_1_0 t2 bb0 n0_1 vss sg13_hv_nmos w=0.5u l=0.45u ng=1 m=1 mm_ok=1
XS0_1_1 t3 b0 n0_1 vss sg13_hv_nmos w=0.5u l=0.45u ng=1 m=1 mm_ok=1
XS0_2_0 t4 bb0 n0_2 vss sg13_hv_nmos w=0.5u l=0.45u ng=1 m=1 mm_ok=1
XS0_2_1 t5 b0 n0_2 vss sg13_hv_nmos w=0.5u l=0.45u ng=1 m=1 mm_ok=1
XS0_3_0 t6 bb0 n0_3 vss sg13_hv_nmos w=0.5u l=0.45u ng=1 m=1 mm_ok=1
XS0_3_1 t7 b0 n0_3 vss sg13_hv_nmos w=0.5u l=0.45u ng=1 m=1 mm_ok=1
XS0_4_0 t8 bb0 n0_4 vss sg13_hv_nmos w=0.5u l=0.45u ng=1 m=1 mm_ok=1
XS0_4_1 t9 b0 n0_4 vss sg13_hv_nmos w=0.5u l=0.45u ng=1 m=1 mm_ok=1
XS0_5_0 t10 bb0 n0_5 vss sg13_hv_nmos w=0.5u l=0.45u ng=1 m=1 mm_ok=1
XS0_5_1 t11 b0 n0_5 vss sg13_hv_nmos w=0.5u l=0.45u ng=1 m=1 mm_ok=1
XS0_6_0 t12 bb0 n0_6 vss sg13_hv_nmos w=0.5u l=0.45u ng=1 m=1 mm_ok=1
XS0_6_1 t13 b0 n0_6 vss sg13_hv_nmos w=0.5u l=0.45u ng=1 m=1 mm_ok=1
XS0_7_0 t14 bb0 n0_7 vss sg13_hv_nmos w=0.5u l=0.45u ng=1 m=1 mm_ok=1
XS0_7_1 t15 b0 n0_7 vss sg13_hv_nmos w=0.5u l=0.45u ng=1 m=1 mm_ok=1
XS0_8_0 t16 bb0 n0_8 vss sg13_hv_nmos w=0.5u l=0.45u ng=1 m=1 mm_ok=1
XS0_8_1 t17 b0 n0_8 vss sg13_hv_nmos w=0.5u l=0.45u ng=1 m=1 mm_ok=1
XS0_9_0 t18 bb0 n0_9 vss sg13_hv_nmos w=0.5u l=0.45u ng=1 m=1 mm_ok=1
XS0_9_1 t19 b0 n0_9 vss sg13_hv_nmos w=0.5u l=0.45u ng=1 m=1 mm_ok=1
XS0_10_0 t20 bb0 n0_10 vss sg13_hv_nmos w=0.5u l=0.45u ng=1 m=1 mm_ok=1
XS0_10_1 t21 b0 n0_10 vss sg13_hv_nmos w=0.5u l=0.45u ng=1 m=1 mm_ok=1
XS0_11_0 t22 bb0 n0_11 vss sg13_hv_nmos w=0.5u l=0.45u ng=1 m=1 mm_ok=1
XS0_11_1 t23 b0 n0_11 vss sg13_hv_nmos w=0.5u l=0.45u ng=1 m=1 mm_ok=1
XS0_12_0 t24 bb0 n0_12 vss sg13_hv_nmos w=0.5u l=0.45u ng=1 m=1 mm_ok=1
XS0_12_1 t25 b0 n0_12 vss sg13_hv_nmos w=0.5u l=0.45u ng=1 m=1 mm_ok=1
XS0_13_0 t26 bb0 n0_13 vss sg13_hv_nmos w=0.5u l=0.45u ng=1 m=1 mm_ok=1
XS0_13_1 t27 b0 n0_13 vss sg13_hv_nmos w=0.5u l=0.45u ng=1 m=1 mm_ok=1
XS0_14_0 t28 bb0 n0_14 vss sg13_hv_nmos w=0.5u l=0.45u ng=1 m=1 mm_ok=1
XS0_14_1 t29 b0 n0_14 vss sg13_hv_nmos w=0.5u l=0.45u ng=1 m=1 mm_ok=1
XS0_15_0 t30 bb0 n0_15 vss sg13_hv_nmos w=0.5u l=0.45u ng=1 m=1 mm_ok=1
XS0_15_1 t31 b0 n0_15 vss sg13_hv_nmos w=0.5u l=0.45u ng=1 m=1 mm_ok=1
XS0_16_0 t32 bb0 n0_16 vss sg13_hv_nmos w=0.5u l=0.45u ng=1 m=1 mm_ok=1
XS0_16_1 t33 b0 n0_16 vss sg13_hv_nmos w=0.5u l=0.45u ng=1 m=1 mm_ok=1
XS0_17_0 t34 bb0 n0_17 vss sg13_hv_nmos w=0.5u l=0.45u ng=1 m=1 mm_ok=1
XS0_17_1 t35 b0 n0_17 vss sg13_hv_nmos w=0.5u l=0.45u ng=1 m=1 mm_ok=1
XS0_18_0 t36 bb0 n0_18 vss sg13_hv_nmos w=0.5u l=0.45u ng=1 m=1 mm_ok=1
XS0_18_1 t37 b0 n0_18 vss sg13_hv_nmos w=0.5u l=0.45u ng=1 m=1 mm_ok=1
XS0_19_0 t38 bb0 n0_19 vss sg13_hv_nmos w=0.5u l=0.45u ng=1 m=1 mm_ok=1
XS0_19_1 t39 b0 n0_19 vss sg13_hv_nmos w=0.5u l=0.45u ng=1 m=1 mm_ok=1
XS0_20_0 t40 bb0 n0_20 vss sg13_hv_nmos w=0.5u l=0.45u ng=1 m=1 mm_ok=1
XS0_20_1 t41 b0 n0_20 vss sg13_hv_nmos w=0.5u l=0.45u ng=1 m=1 mm_ok=1
XS0_21_0 t42 bb0 n0_21 vss sg13_hv_nmos w=0.5u l=0.45u ng=1 m=1 mm_ok=1
XS0_21_1 t43 b0 n0_21 vss sg13_hv_nmos w=0.5u l=0.45u ng=1 m=1 mm_ok=1
XS0_22_0 t44 bb0 n0_22 vss sg13_hv_nmos w=0.5u l=0.45u ng=1 m=1 mm_ok=1
XS0_22_1 t45 b0 n0_22 vss sg13_hv_nmos w=0.5u l=0.45u ng=1 m=1 mm_ok=1
XS0_23_0 t46 bb0 n0_23 vss sg13_hv_nmos w=0.5u l=0.45u ng=1 m=1 mm_ok=1
XS0_23_1 t47 b0 n0_23 vss sg13_hv_nmos w=0.5u l=0.45u ng=1 m=1 mm_ok=1
XS0_24_0 t48 bb0 n0_24 vss sg13_hv_nmos w=0.5u l=0.45u ng=1 m=1 mm_ok=1
XS0_24_1 t49 b0 n0_24 vss sg13_hv_nmos w=0.5u l=0.45u ng=1 m=1 mm_ok=1
XS0_25_0 t50 bb0 n0_25 vss sg13_hv_nmos w=0.5u l=0.45u ng=1 m=1 mm_ok=1
XS0_25_1 t51 b0 n0_25 vss sg13_hv_nmos w=0.5u l=0.45u ng=1 m=1 mm_ok=1
XS0_26_0 t52 bb0 n0_26 vss sg13_hv_nmos w=0.5u l=0.45u ng=1 m=1 mm_ok=1
XS0_26_1 t53 b0 n0_26 vss sg13_hv_nmos w=0.5u l=0.45u ng=1 m=1 mm_ok=1
XS0_27_0 t54 bb0 n0_27 vss sg13_hv_nmos w=0.5u l=0.45u ng=1 m=1 mm_ok=1
XS0_27_1 t55 b0 n0_27 vss sg13_hv_nmos w=0.5u l=0.45u ng=1 m=1 mm_ok=1
XS0_28_0 t56 bb0 n0_28 vss sg13_hv_nmos w=0.5u l=0.45u ng=1 m=1 mm_ok=1
XS0_28_1 t57 b0 n0_28 vss sg13_hv_nmos w=0.5u l=0.45u ng=1 m=1 mm_ok=1
XS0_29_0 t58 bb0 n0_29 vss sg13_hv_nmos w=0.5u l=0.45u ng=1 m=1 mm_ok=1
XS0_29_1 t59 b0 n0_29 vss sg13_hv_nmos w=0.5u l=0.45u ng=1 m=1 mm_ok=1
XS0_30_0 t60 bb0 n0_30 vss sg13_hv_nmos w=0.5u l=0.45u ng=1 m=1 mm_ok=1
XS0_30_1 t61 b0 n0_30 vss sg13_hv_nmos w=0.5u l=0.45u ng=1 m=1 mm_ok=1
XS0_31_0 t62 bb0 n0_31 vss sg13_hv_nmos w=0.5u l=0.45u ng=1 m=1 mm_ok=1
XS0_31_1 t63 b0 n0_31 vss sg13_hv_nmos w=0.5u l=0.45u ng=1 m=1 mm_ok=1
XS1_0_0 n0_0 bb1 n1_0 vss sg13_hv_nmos w=0.5u l=0.45u ng=1 m=1 mm_ok=1
XS1_0_1 n0_1 b1 n1_0 vss sg13_hv_nmos w=0.5u l=0.45u ng=1 m=1 mm_ok=1
XS1_1_0 n0_2 bb1 n1_1 vss sg13_hv_nmos w=0.5u l=0.45u ng=1 m=1 mm_ok=1
XS1_1_1 n0_3 b1 n1_1 vss sg13_hv_nmos w=0.5u l=0.45u ng=1 m=1 mm_ok=1
XS1_2_0 n0_4 bb1 n1_2 vss sg13_hv_nmos w=0.5u l=0.45u ng=1 m=1 mm_ok=1
XS1_2_1 n0_5 b1 n1_2 vss sg13_hv_nmos w=0.5u l=0.45u ng=1 m=1 mm_ok=1
XS1_3_0 n0_6 bb1 n1_3 vss sg13_hv_nmos w=0.5u l=0.45u ng=1 m=1 mm_ok=1
XS1_3_1 n0_7 b1 n1_3 vss sg13_hv_nmos w=0.5u l=0.45u ng=1 m=1 mm_ok=1
XS1_4_0 n0_8 bb1 n1_4 vss sg13_hv_nmos w=0.5u l=0.45u ng=1 m=1 mm_ok=1
XS1_4_1 n0_9 b1 n1_4 vss sg13_hv_nmos w=0.5u l=0.45u ng=1 m=1 mm_ok=1
XS1_5_0 n0_10 bb1 n1_5 vss sg13_hv_nmos w=0.5u l=0.45u ng=1 m=1 mm_ok=1
XS1_5_1 n0_11 b1 n1_5 vss sg13_hv_nmos w=0.5u l=0.45u ng=1 m=1 mm_ok=1
XS1_6_0 n0_12 bb1 n1_6 vss sg13_hv_nmos w=0.5u l=0.45u ng=1 m=1 mm_ok=1
XS1_6_1 n0_13 b1 n1_6 vss sg13_hv_nmos w=0.5u l=0.45u ng=1 m=1 mm_ok=1
XS1_7_0 n0_14 bb1 n1_7 vss sg13_hv_nmos w=0.5u l=0.45u ng=1 m=1 mm_ok=1
XS1_7_1 n0_15 b1 n1_7 vss sg13_hv_nmos w=0.5u l=0.45u ng=1 m=1 mm_ok=1
XS1_8_0 n0_16 bb1 n1_8 vss sg13_hv_nmos w=0.5u l=0.45u ng=1 m=1 mm_ok=1
XS1_8_1 n0_17 b1 n1_8 vss sg13_hv_nmos w=0.5u l=0.45u ng=1 m=1 mm_ok=1
XS1_9_0 n0_18 bb1 n1_9 vss sg13_hv_nmos w=0.5u l=0.45u ng=1 m=1 mm_ok=1
XS1_9_1 n0_19 b1 n1_9 vss sg13_hv_nmos w=0.5u l=0.45u ng=1 m=1 mm_ok=1
XS1_10_0 n0_20 bb1 n1_10 vss sg13_hv_nmos w=0.5u l=0.45u ng=1 m=1 mm_ok=1
XS1_10_1 n0_21 b1 n1_10 vss sg13_hv_nmos w=0.5u l=0.45u ng=1 m=1 mm_ok=1
XS1_11_0 n0_22 bb1 n1_11 vss sg13_hv_nmos w=0.5u l=0.45u ng=1 m=1 mm_ok=1
XS1_11_1 n0_23 b1 n1_11 vss sg13_hv_nmos w=0.5u l=0.45u ng=1 m=1 mm_ok=1
XS1_12_0 n0_24 bb1 n1_12 vss sg13_hv_nmos w=0.5u l=0.45u ng=1 m=1 mm_ok=1
XS1_12_1 n0_25 b1 n1_12 vss sg13_hv_nmos w=0.5u l=0.45u ng=1 m=1 mm_ok=1
XS1_13_0 n0_26 bb1 n1_13 vss sg13_hv_nmos w=0.5u l=0.45u ng=1 m=1 mm_ok=1
XS1_13_1 n0_27 b1 n1_13 vss sg13_hv_nmos w=0.5u l=0.45u ng=1 m=1 mm_ok=1
XS1_14_0 n0_28 bb1 n1_14 vss sg13_hv_nmos w=0.5u l=0.45u ng=1 m=1 mm_ok=1
XS1_14_1 n0_29 b1 n1_14 vss sg13_hv_nmos w=0.5u l=0.45u ng=1 m=1 mm_ok=1
XS1_15_0 n0_30 bb1 n1_15 vss sg13_hv_nmos w=0.5u l=0.45u ng=1 m=1 mm_ok=1
XS1_15_1 n0_31 b1 n1_15 vss sg13_hv_nmos w=0.5u l=0.45u ng=1 m=1 mm_ok=1
XS2_0_0 n1_0 bb2 n2_0 vss sg13_hv_nmos w=0.5u l=0.45u ng=1 m=1 mm_ok=1
XS2_0_1 n1_1 b2 n2_0 vss sg13_hv_nmos w=0.5u l=0.45u ng=1 m=1 mm_ok=1
XS2_1_0 n1_2 bb2 n2_1 vss sg13_hv_nmos w=0.5u l=0.45u ng=1 m=1 mm_ok=1
XS2_1_1 n1_3 b2 n2_1 vss sg13_hv_nmos w=0.5u l=0.45u ng=1 m=1 mm_ok=1
XS2_2_0 n1_4 bb2 n2_2 vss sg13_hv_nmos w=0.5u l=0.45u ng=1 m=1 mm_ok=1
XS2_2_1 n1_5 b2 n2_2 vss sg13_hv_nmos w=0.5u l=0.45u ng=1 m=1 mm_ok=1
XS2_3_0 n1_6 bb2 n2_3 vss sg13_hv_nmos w=0.5u l=0.45u ng=1 m=1 mm_ok=1
XS2_3_1 n1_7 b2 n2_3 vss sg13_hv_nmos w=0.5u l=0.45u ng=1 m=1 mm_ok=1
XS2_4_0 n1_8 bb2 n2_4 vss sg13_hv_nmos w=0.5u l=0.45u ng=1 m=1 mm_ok=1
XS2_4_1 n1_9 b2 n2_4 vss sg13_hv_nmos w=0.5u l=0.45u ng=1 m=1 mm_ok=1
XS2_5_0 n1_10 bb2 n2_5 vss sg13_hv_nmos w=0.5u l=0.45u ng=1 m=1 mm_ok=1
XS2_5_1 n1_11 b2 n2_5 vss sg13_hv_nmos w=0.5u l=0.45u ng=1 m=1 mm_ok=1
XS2_6_0 n1_12 bb2 n2_6 vss sg13_hv_nmos w=0.5u l=0.45u ng=1 m=1 mm_ok=1
XS2_6_1 n1_13 b2 n2_6 vss sg13_hv_nmos w=0.5u l=0.45u ng=1 m=1 mm_ok=1
XS2_7_0 n1_14 bb2 n2_7 vss sg13_hv_nmos w=0.5u l=0.45u ng=1 m=1 mm_ok=1
XS2_7_1 n1_15 b2 n2_7 vss sg13_hv_nmos w=0.5u l=0.45u ng=1 m=1 mm_ok=1
XS3_0_0 n2_0 bb3 n3_0 vss sg13_hv_nmos w=0.5u l=0.45u ng=1 m=1 mm_ok=1
XS3_0_1 n2_1 b3 n3_0 vss sg13_hv_nmos w=0.5u l=0.45u ng=1 m=1 mm_ok=1
XS3_1_0 n2_2 bb3 n3_1 vss sg13_hv_nmos w=0.5u l=0.45u ng=1 m=1 mm_ok=1
XS3_1_1 n2_3 b3 n3_1 vss sg13_hv_nmos w=0.5u l=0.45u ng=1 m=1 mm_ok=1
XS3_2_0 n2_4 bb3 n3_2 vss sg13_hv_nmos w=0.5u l=0.45u ng=1 m=1 mm_ok=1
XS3_2_1 n2_5 b3 n3_2 vss sg13_hv_nmos w=0.5u l=0.45u ng=1 m=1 mm_ok=1
XS3_3_0 n2_6 bb3 n3_3 vss sg13_hv_nmos w=0.5u l=0.45u ng=1 m=1 mm_ok=1
XS3_3_1 n2_7 b3 n3_3 vss sg13_hv_nmos w=0.5u l=0.45u ng=1 m=1 mm_ok=1
XS4_0_0 n3_0 bb4 n4_0 vss sg13_hv_nmos w=0.5u l=0.45u ng=1 m=1 mm_ok=1
XS4_0_1 n3_1 b4 n4_0 vss sg13_hv_nmos w=0.5u l=0.45u ng=1 m=1 mm_ok=1
XS4_1_0 n3_2 bb4 n4_1 vss sg13_hv_nmos w=0.5u l=0.45u ng=1 m=1 mm_ok=1
XS4_1_1 n3_3 b4 n4_1 vss sg13_hv_nmos w=0.5u l=0.45u ng=1 m=1 mm_ok=1
XS5_0_0 n4_0 bb5 out vss sg13_hv_nmos w=0.5u l=0.45u ng=1 m=1 mm_ok=1
XS5_0_1 n4_1 b5 out vss sg13_hv_nmos w=0.5u l=0.45u ng=1 m=1 mm_ok=1
.ends r1_safe_mux64

.subckt r1_safe_string vref t0 t1 t2 t3 t4 t5 t6 t7 t8 t9 t10 t11 t12 t13 t14 t15 t16 t17 t18 t19 t20 t21 t22 t23 t24 t25 t26 t27 t28 t29 t30 t31 t32 t33 t34 t35 t36 t37 t38 t39 t40 t41 t42 t43 t44 t45 t46 t47 t48 t49 t50 t51 t52 t53 t54 t55 t56 t57 t58 t59 t60 t61 t62 t63 vss
* 63 rppd units of 4 kOhm between VREF (T63) and VSS (T0); 4.2 uA at 1.05 V
XRS0 t1 t0 vss rppd w=2u l=30.8u m=1 b=0 mm_ok=1
XRS1 t2 t1 vss rppd w=2u l=30.8u m=1 b=0 mm_ok=1
XRS2 t3 t2 vss rppd w=2u l=30.8u m=1 b=0 mm_ok=1
XRS3 t4 t3 vss rppd w=2u l=30.8u m=1 b=0 mm_ok=1
XRS4 t5 t4 vss rppd w=2u l=30.8u m=1 b=0 mm_ok=1
XRS5 t6 t5 vss rppd w=2u l=30.8u m=1 b=0 mm_ok=1
XRS6 t7 t6 vss rppd w=2u l=30.8u m=1 b=0 mm_ok=1
XRS7 t8 t7 vss rppd w=2u l=30.8u m=1 b=0 mm_ok=1
XRS8 t9 t8 vss rppd w=2u l=30.8u m=1 b=0 mm_ok=1
XRS9 t10 t9 vss rppd w=2u l=30.8u m=1 b=0 mm_ok=1
XRS10 t11 t10 vss rppd w=2u l=30.8u m=1 b=0 mm_ok=1
XRS11 t12 t11 vss rppd w=2u l=30.8u m=1 b=0 mm_ok=1
XRS12 t13 t12 vss rppd w=2u l=30.8u m=1 b=0 mm_ok=1
XRS13 t14 t13 vss rppd w=2u l=30.8u m=1 b=0 mm_ok=1
XRS14 t15 t14 vss rppd w=2u l=30.8u m=1 b=0 mm_ok=1
XRS15 t16 t15 vss rppd w=2u l=30.8u m=1 b=0 mm_ok=1
XRS16 t17 t16 vss rppd w=2u l=30.8u m=1 b=0 mm_ok=1
XRS17 t18 t17 vss rppd w=2u l=30.8u m=1 b=0 mm_ok=1
XRS18 t19 t18 vss rppd w=2u l=30.8u m=1 b=0 mm_ok=1
XRS19 t20 t19 vss rppd w=2u l=30.8u m=1 b=0 mm_ok=1
XRS20 t21 t20 vss rppd w=2u l=30.8u m=1 b=0 mm_ok=1
XRS21 t22 t21 vss rppd w=2u l=30.8u m=1 b=0 mm_ok=1
XRS22 t23 t22 vss rppd w=2u l=30.8u m=1 b=0 mm_ok=1
XRS23 t24 t23 vss rppd w=2u l=30.8u m=1 b=0 mm_ok=1
XRS24 t25 t24 vss rppd w=2u l=30.8u m=1 b=0 mm_ok=1
XRS25 t26 t25 vss rppd w=2u l=30.8u m=1 b=0 mm_ok=1
XRS26 t27 t26 vss rppd w=2u l=30.8u m=1 b=0 mm_ok=1
XRS27 t28 t27 vss rppd w=2u l=30.8u m=1 b=0 mm_ok=1
XRS28 t29 t28 vss rppd w=2u l=30.8u m=1 b=0 mm_ok=1
XRS29 t30 t29 vss rppd w=2u l=30.8u m=1 b=0 mm_ok=1
XRS30 t31 t30 vss rppd w=2u l=30.8u m=1 b=0 mm_ok=1
XRS31 t32 t31 vss rppd w=2u l=30.8u m=1 b=0 mm_ok=1
XRS32 t33 t32 vss rppd w=2u l=30.8u m=1 b=0 mm_ok=1
XRS33 t34 t33 vss rppd w=2u l=30.8u m=1 b=0 mm_ok=1
XRS34 t35 t34 vss rppd w=2u l=30.8u m=1 b=0 mm_ok=1
XRS35 t36 t35 vss rppd w=2u l=30.8u m=1 b=0 mm_ok=1
XRS36 t37 t36 vss rppd w=2u l=30.8u m=1 b=0 mm_ok=1
XRS37 t38 t37 vss rppd w=2u l=30.8u m=1 b=0 mm_ok=1
XRS38 t39 t38 vss rppd w=2u l=30.8u m=1 b=0 mm_ok=1
XRS39 t40 t39 vss rppd w=2u l=30.8u m=1 b=0 mm_ok=1
XRS40 t41 t40 vss rppd w=2u l=30.8u m=1 b=0 mm_ok=1
XRS41 t42 t41 vss rppd w=2u l=30.8u m=1 b=0 mm_ok=1
XRS42 t43 t42 vss rppd w=2u l=30.8u m=1 b=0 mm_ok=1
XRS43 t44 t43 vss rppd w=2u l=30.8u m=1 b=0 mm_ok=1
XRS44 t45 t44 vss rppd w=2u l=30.8u m=1 b=0 mm_ok=1
XRS45 t46 t45 vss rppd w=2u l=30.8u m=1 b=0 mm_ok=1
XRS46 t47 t46 vss rppd w=2u l=30.8u m=1 b=0 mm_ok=1
XRS47 t48 t47 vss rppd w=2u l=30.8u m=1 b=0 mm_ok=1
XRS48 t49 t48 vss rppd w=2u l=30.8u m=1 b=0 mm_ok=1
XRS49 t50 t49 vss rppd w=2u l=30.8u m=1 b=0 mm_ok=1
XRS50 t51 t50 vss rppd w=2u l=30.8u m=1 b=0 mm_ok=1
XRS51 t52 t51 vss rppd w=2u l=30.8u m=1 b=0 mm_ok=1
XRS52 t53 t52 vss rppd w=2u l=30.8u m=1 b=0 mm_ok=1
XRS53 t54 t53 vss rppd w=2u l=30.8u m=1 b=0 mm_ok=1
XRS54 t55 t54 vss rppd w=2u l=30.8u m=1 b=0 mm_ok=1
XRS55 t56 t55 vss rppd w=2u l=30.8u m=1 b=0 mm_ok=1
XRS56 t57 t56 vss rppd w=2u l=30.8u m=1 b=0 mm_ok=1
XRS57 t58 t57 vss rppd w=2u l=30.8u m=1 b=0 mm_ok=1
XRS58 t59 t58 vss rppd w=2u l=30.8u m=1 b=0 mm_ok=1
XRS59 t60 t59 vss rppd w=2u l=30.8u m=1 b=0 mm_ok=1
XRS60 t61 t60 vss rppd w=2u l=30.8u m=1 b=0 mm_ok=1
XRS61 t62 t61 vss rppd w=2u l=30.8u m=1 b=0 mm_ok=1
XRS62 t63 t62 vss rppd w=2u l=30.8u m=1 b=0 mm_ok=1
Rt63 t63 vref 1e-3
Rt0 t0 vss 1e-3
.ends r1_safe_string

.subckt r1_safe_cmp inp inn refp refn out ibias vdda vdd vss
* ibias: 5 uA sunk into the pin (from r1_bgr PTAT branch; ideal source in this step)
XMBN ibias ibias vss vss sg13_hv_nmos w=4u l=1u ng=1 m=1 mm_ok=1
XMB2 vbp ibias vss vss sg13_hv_nmos w=4u l=1u ng=1 m=1 mm_ok=1
XMBP vbp vbp vdda vdda sg13_hv_pmos w=4u l=2u ng=1 m=1 mm_ok=1
* input pairs, 40 uA tails each
XMTA ta vbp vdda vdda sg13_hv_pmos w=4u l=2u ng=1 m=8 mm_ok=1
XMTB tb vbp vdda vdda sg13_hv_pmos w=4u l=2u ng=1 m=8 mm_ok=1
* each pair is source-degenerated (rhigh per side) so that it stays linear over the full +-1.05 V input range:
* without degeneration both pairs saturate for |Vth| > about 0.1 V and the comparison fails (run safe-cmp-20261020-r1).
XMA1 d1 inp sa1 ta sg13_hv_pmos w=20u l=2u ng=4 m=1 mm_ok=1
XMA2 d2 inn sa2 ta sg13_hv_pmos w=20u l=2u ng=4 m=1 mm_ok=1
XRA1 ta sa1 vss rhigh w=1u l=30u m=1 b=0 mm_ok=1
XRA2 ta sa2 vss rhigh w=1u l=30u m=1 b=0 mm_ok=1
XMB1 d1 refn sb1 tb sg13_hv_pmos w=20u l=2u ng=4 m=1 mm_ok=1
XMB2I d2 refp sb2 tb sg13_hv_pmos w=20u l=2u ng=4 m=1 mm_ok=1
XRB1 tb sb1 vss rhigh w=1u l=30u m=1 b=0 mm_ok=1
XRB2 tb sb2 vss rhigh w=1u l=30u m=1 b=0 mm_ok=1
* NMOS mirror load: d1 diode, d2 output (d2 rises when (inp-inn) > (refp-refn))
XML1 d1 d1 vss vss sg13_hv_nmos w=16u l=4u ng=1 m=1 mm_ok=1
XML2 d2 d1 vss vss sg13_hv_nmos w=16u l=4u ng=1 m=1 mm_ok=1
* gain stage: NMOS common source, PMOS source 10 uA
XMG o1 d2 vss vss sg13_hv_nmos w=2u l=2u ng=1 m=1 mm_ok=1
XMGL o1 vbp vdda vdda sg13_hv_pmos w=4u l=2u ng=1 m=2 mm_ok=1
* inverter (3.3 V): o2 high when tripped
XMI1P o2 o1 vdda vdda sg13_hv_pmos w=2u l=0.5u ng=1 m=1 mm_ok=1
XMI1N o2 o1 vss vss sg13_hv_nmos w=1u l=0.45u ng=1 m=1 mm_ok=1
* hysteresis: a small current steered into d2 while tripped (o1 low) and into d1 otherwise (o2 low);
* steering (not switching off) keeps node hs driven at all times
XMH1a hn1 vbp vdda vdda sg13_hv_pmos w=0.5u l=8u ng=1 m=1 mm_ok=1
XMH1b hn2 vbp hn1 vdda sg13_hv_pmos w=0.5u l=8u ng=1 m=1 mm_ok=1
XMH1c hs vbp hn2 vdda sg13_hv_pmos w=0.5u l=8u ng=1 m=1 mm_ok=1
XMH2 d2 o1 hs vdda sg13_hv_pmos w=1u l=0.5u ng=1 m=1 mm_ok=1
XMH3 d1 o2 hs vdda sg13_hv_pmos w=1u l=0.5u ng=1 m=1 mm_ok=1
* down-shift to 1.2 V: thick-input inverter on VDD, then thin inverter
XMD1P o3 o2 vdd vdd sg13_hv_pmos w=2u l=0.5u ng=1 m=1 mm_ok=1
XMD1N o3 o2 vss vss sg13_hv_nmos w=1u l=0.45u ng=1 m=1 mm_ok=1
XMD2P out o3 vdd vdd sg13_lv_pmos w=1u l=0.13u ng=1 m=1 mm_ok=1
XMD2N out o3 vss vss sg13_lv_nmos w=0.5u l=0.13u ng=1 m=1 mm_ok=1
.ends r1_safe_cmp

.subckt r1_safe_thr inp inn t0 t1 t2 t3 t4 t5 t6 t7 t8 t9 t10 t11 t12 t13 t14 t15 t16 t17 t18 t19 t20 t21 t22 t23 t24 t25 t26 t27 t28 t29 t30 t31 t32 t33 t34 t35 t36 t37 t38 t39 t40 t41 t42 t43 t44 t45 t46 t47 t48 t49 t50 t51 t52 t53 t54 t55 t56 t57 t58 t59 t60 t61 t62 t63 c0 c1 c2 c3 c4 c5 out ibias vdda vdd vss
* one comparator + its threshold DAC: REFP = T(code), REFN = T(63-code); c0..c5 = 1.2 V code bits
XLS0 c0 vdd vdda vss b0 bb0 r1_safe_ls
XLS1 c1 vdd vdda vss b1 bb1 r1_safe_ls
XLS2 c2 vdd vdda vss b2 bb2 r1_safe_ls
XLS3 c3 vdd vdda vss b3 bb3 r1_safe_ls
XLS4 c4 vdd vdda vss b4 bb4 r1_safe_ls
XLS5 c5 vdd vdda vss b5 bb5 r1_safe_ls
XMXP t0 t1 t2 t3 t4 t5 t6 t7 t8 t9 t10 t11 t12 t13 t14 t15 t16 t17 t18 t19 t20 t21 t22 t23 t24 t25 t26 t27 t28 t29 t30 t31 t32 t33 t34 t35 t36 t37 t38 t39 t40 t41 t42 t43 t44 t45 t46 t47 t48 t49 t50 t51 t52 t53 t54 t55 t56 t57 t58 t59 t60 t61 t62 t63 b0 b1 b2 b3 b4 b5 bb0 bb1 bb2 bb3 bb4 bb5 refp vss r1_safe_mux64
XMXN t0 t1 t2 t3 t4 t5 t6 t7 t8 t9 t10 t11 t12 t13 t14 t15 t16 t17 t18 t19 t20 t21 t22 t23 t24 t25 t26 t27 t28 t29 t30 t31 t32 t33 t34 t35 t36 t37 t38 t39 t40 t41 t42 t43 t44 t45 t46 t47 t48 t49 t50 t51 t52 t53 t54 t55 t56 t57 t58 t59 t60 t61 t62 t63 bb0 bb1 bb2 bb3 bb4 bb5 b0 b1 b2 b3 b4 b5 refn vss r1_safe_mux64
XCMP inp inn refp refn out ibias vdda vdd vss r1_safe_cmp
.ends r1_safe_thr

.subckt r1_safe_an outa_p outa_n outb_p outb_n vref hia0 hia1 hia2 hia3 hia4 hia5 loa0 loa1 loa2 loa3 loa4 loa5 hib0 hib1 hib2 hib3 hib4 hib5 lob0 lob1 lob2 lob3 lob4 lob5 oc_a neg_a oc_b neg_b ibias_oa ibias_na ibias_ob ibias_nb vdda vdd vss
* oc_x high: Vod_x > Vth(hi code);  neg_x high: Vod_x < Vth(lo code).  Codes: 6-bit, 1.2 V logic, bit 0 = LSB.
XSTR vref t0 t1 t2 t3 t4 t5 t6 t7 t8 t9 t10 t11 t12 t13 t14 t15 t16 t17 t18 t19 t20 t21 t22 t23 t24 t25 t26 t27 t28 t29 t30 t31 t32 t33 t34 t35 t36 t37 t38 t39 t40 t41 t42 t43 t44 t45 t46 t47 t48 t49 t50 t51 t52 t53 t54 t55 t56 t57 t58 t59 t60 t61 t62 t63 vss r1_safe_string
XOCa outa_p outa_n t0 t1 t2 t3 t4 t5 t6 t7 t8 t9 t10 t11 t12 t13 t14 t15 t16 t17 t18 t19 t20 t21 t22 t23 t24 t25 t26 t27 t28 t29 t30 t31 t32 t33 t34 t35 t36 t37 t38 t39 t40 t41 t42 t43 t44 t45 t46 t47 t48 t49 t50 t51 t52 t53 t54 t55 t56 t57 t58 t59 t60 t61 t62 t63 hia0 hia1 hia2 hia3 hia4 hia5 oc_a ibias_oa vdda vdd vss r1_safe_thr
XIVPa0 loab0 loa0 vdd vdd sg13_lv_pmos w=1u l=0.13u ng=1 m=1 mm_ok=1
XIVNa0 loab0 loa0 vss vss sg13_lv_nmos w=0.5u l=0.13u ng=1 m=1 mm_ok=1
XIVPa1 loab1 loa1 vdd vdd sg13_lv_pmos w=1u l=0.13u ng=1 m=1 mm_ok=1
XIVNa1 loab1 loa1 vss vss sg13_lv_nmos w=0.5u l=0.13u ng=1 m=1 mm_ok=1
XIVPa2 loab2 loa2 vdd vdd sg13_lv_pmos w=1u l=0.13u ng=1 m=1 mm_ok=1
XIVNa2 loab2 loa2 vss vss sg13_lv_nmos w=0.5u l=0.13u ng=1 m=1 mm_ok=1
XIVPa3 loab3 loa3 vdd vdd sg13_lv_pmos w=1u l=0.13u ng=1 m=1 mm_ok=1
XIVNa3 loab3 loa3 vss vss sg13_lv_nmos w=0.5u l=0.13u ng=1 m=1 mm_ok=1
XIVPa4 loab4 loa4 vdd vdd sg13_lv_pmos w=1u l=0.13u ng=1 m=1 mm_ok=1
XIVNa4 loab4 loa4 vss vss sg13_lv_nmos w=0.5u l=0.13u ng=1 m=1 mm_ok=1
XIVPa5 loab5 loa5 vdd vdd sg13_lv_pmos w=1u l=0.13u ng=1 m=1 mm_ok=1
XIVNa5 loab5 loa5 vss vss sg13_lv_nmos w=0.5u l=0.13u ng=1 m=1 mm_ok=1
XNGa outa_n outa_p t0 t1 t2 t3 t4 t5 t6 t7 t8 t9 t10 t11 t12 t13 t14 t15 t16 t17 t18 t19 t20 t21 t22 t23 t24 t25 t26 t27 t28 t29 t30 t31 t32 t33 t34 t35 t36 t37 t38 t39 t40 t41 t42 t43 t44 t45 t46 t47 t48 t49 t50 t51 t52 t53 t54 t55 t56 t57 t58 t59 t60 t61 t62 t63 loab0 loab1 loab2 loab3 loab4 loab5 neg_a ibias_na vdda vdd vss r1_safe_thr
XOCb outb_p outb_n t0 t1 t2 t3 t4 t5 t6 t7 t8 t9 t10 t11 t12 t13 t14 t15 t16 t17 t18 t19 t20 t21 t22 t23 t24 t25 t26 t27 t28 t29 t30 t31 t32 t33 t34 t35 t36 t37 t38 t39 t40 t41 t42 t43 t44 t45 t46 t47 t48 t49 t50 t51 t52 t53 t54 t55 t56 t57 t58 t59 t60 t61 t62 t63 hib0 hib1 hib2 hib3 hib4 hib5 oc_b ibias_ob vdda vdd vss r1_safe_thr
XIVPb0 lobb0 lob0 vdd vdd sg13_lv_pmos w=1u l=0.13u ng=1 m=1 mm_ok=1
XIVNb0 lobb0 lob0 vss vss sg13_lv_nmos w=0.5u l=0.13u ng=1 m=1 mm_ok=1
XIVPb1 lobb1 lob1 vdd vdd sg13_lv_pmos w=1u l=0.13u ng=1 m=1 mm_ok=1
XIVNb1 lobb1 lob1 vss vss sg13_lv_nmos w=0.5u l=0.13u ng=1 m=1 mm_ok=1
XIVPb2 lobb2 lob2 vdd vdd sg13_lv_pmos w=1u l=0.13u ng=1 m=1 mm_ok=1
XIVNb2 lobb2 lob2 vss vss sg13_lv_nmos w=0.5u l=0.13u ng=1 m=1 mm_ok=1
XIVPb3 lobb3 lob3 vdd vdd sg13_lv_pmos w=1u l=0.13u ng=1 m=1 mm_ok=1
XIVNb3 lobb3 lob3 vss vss sg13_lv_nmos w=0.5u l=0.13u ng=1 m=1 mm_ok=1
XIVPb4 lobb4 lob4 vdd vdd sg13_lv_pmos w=1u l=0.13u ng=1 m=1 mm_ok=1
XIVNb4 lobb4 lob4 vss vss sg13_lv_nmos w=0.5u l=0.13u ng=1 m=1 mm_ok=1
XIVPb5 lobb5 lob5 vdd vdd sg13_lv_pmos w=1u l=0.13u ng=1 m=1 mm_ok=1
XIVNb5 lobb5 lob5 vss vss sg13_lv_nmos w=0.5u l=0.13u ng=1 m=1 mm_ok=1
XNGb outb_n outb_p t0 t1 t2 t3 t4 t5 t6 t7 t8 t9 t10 t11 t12 t13 t14 t15 t16 t17 t18 t19 t20 t21 t22 t23 t24 t25 t26 t27 t28 t29 t30 t31 t32 t33 t34 t35 t36 t37 t38 t39 t40 t41 t42 t43 t44 t45 t46 t47 t48 t49 t50 t51 t52 t53 t54 t55 t56 t57 t58 t59 t60 t61 t62 t63 lobb0 lobb1 lobb2 lobb3 lobb4 lobb5 neg_b ibias_nb vdda vdd vss r1_safe_thr
.ends r1_safe_an
