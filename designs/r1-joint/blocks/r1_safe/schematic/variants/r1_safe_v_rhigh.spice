* GENERATED by gen_safe.py -- do not edit; sizes: CREF=0 DEG=rhigh FINE=4 IH_M=1 ITAIL_M=8 LG=2 LH=8 LIN=2 LM=10 NH=3 RSL=30 RSW=1 WG=2 WH=0.5 WIN=20 WM=40
* r1_safe analog, revision 3: two window comparators per channel (overcurrent high, negative/phase-short low),
* each with a threshold DAC that sums a 6-bit threshold code and a 6-bit offset-calibration code. IHP SG13G2,
* schematic-level SPICE source.
*
* String: one shared rppd string of 63*F units (F = 4, unit 1000 Ohm, w=2 l=7.7) from VREF (T252) to VSS (T0),
*   fine taps Tn = n/252*VREF; coarse threshold taps are every F-th fine tap (same 252 kOhm, 4.2 uA as revision 2).
* Each comparator has two 256:1 thick-NMOS tree multiplexers: REFP = T(nP), REFN = T(nN), nP/nN are 8-bit codes
*   (1.2 V logic) from the summing logic in r1_safe (digital, see README): with cell threshold code c (0..63) and
*   calibration code k (0..63, d = k - 32):
*     nP = F*c + ceil(d/2),  nN = F*(63 - c) - floor(d/2),   both clipped to 0..252
*     Vth_cell = REFP - REFN = VREF*(2*F*c - 252 + d)/252 = (2c-63)/63*VREF + d*VREF/252
*   i.e. the threshold LSB is 2*VREF/63 = 33.3 mV Vod and the calibration step is VREF/252 = LSB/8 (4.17 mV Vod),
*   range -32..+31 steps (-4.0..+3.9 LSB). Overcurrent cell: c = thr_oc, INP=OUTP, INN=OUTN.
*   Negative cell: c = 63 - thr_neg, INP=OUTN, INN=OUTP (trips when Vod < (2*thr_neg-63)/63*VREF - d*VREF/252).
* With r1_isense (Vod = 14*(Vsh - VREF/26)) the shunt-referred threshold is Vsh_th = VREF*(1/26 + (2*code-63)/882).
* Comparator r1_safe_cmp: trips (OUT high) when (INP - INN) > (REFP - REFN).
*   Inputs are thick-oxide PMOS gates (rated 3.3 V); no divider. The sense outputs are <= VDD by construction.
*   Continuous time, no clock (no clock-edge race as in G1 TRIP F1). Hysteresis by an output-switched current.
*   Output: 1.2 V logic (thick-input inverter on VDD, then a thin-oxide inverter), high = threshold crossed.
* Device conventions: PMOS bulks to VDDA except input pairs (bulk = own tail); NMOS bulks to VSS; mm_ok=1.

.subckt r1_safe_ls in vdd vdda vss out outb
XMIP inb in vdd vdd sg13_lv_pmos w=1u l=0.13u ng=1 m=1 mm_ok=1
XMIN inb in vss vss sg13_lv_nmos w=0.5u l=0.13u ng=1 m=1 mm_ok=1
XMN1 a in vss vss sg13_hv_nmos w=4u l=0.45u ng=1 m=1 mm_ok=1
XMN2 b inb vss vss sg13_hv_nmos w=4u l=0.45u ng=1 m=1 mm_ok=1
XMP1 a b vdda vdda sg13_hv_pmos w=0.6u l=0.5u ng=1 m=1 mm_ok=1
XMP2 b a vdda vdda sg13_hv_pmos w=0.6u l=0.5u ng=1 m=1 mm_ok=1
XMB1P outb b vdda vdda sg13_hv_pmos w=2u l=0.5u ng=1 m=1 mm_ok=1
XMB1N outb b vss vss sg13_hv_nmos w=1u l=0.45u ng=1 m=1 mm_ok=1
XMB2P out outb vdda vdda sg13_hv_pmos w=2u l=0.5u ng=1 m=1 mm_ok=1
XMB2N out outb vss vss sg13_hv_nmos w=1u l=0.45u ng=1 m=1 mm_ok=1
.ends r1_safe_ls

.subckt r1_safe_mux t0 t1 t2 t3 t4 t5 t6 t7 t8 t9 t10 t11 t12 t13 t14 t15 t16 t17 t18 t19 t20 t21 t22 t23 t24 t25 t26 t27 t28 t29 t30 t31 t32 t33 t34 t35 t36 t37 t38 t39 t40 t41 t42 t43 t44 t45 t46 t47 t48 t49 t50 t51 t52 t53 t54 t55 t56 t57 t58 t59 t60 t61 t62 t63 t64 t65 t66 t67 t68 t69 t70 t71 t72 t73 t74 t75 t76 t77 t78 t79 t80 t81 t82 t83 t84 t85 t86 t87 t88 t89 t90 t91 t92 t93 t94 t95 t96 t97 t98 t99 t100 t101 t102 t103 t104 t105 t106 t107 t108 t109 t110 t111 t112 t113 t114 t115 t116 t117 t118 t119 t120 t121 t122 t123 t124 t125 t126 t127 t128 t129 t130 t131 t132 t133 t134 t135 t136 t137 t138 t139 t140 t141 t142 t143 t144 t145 t146 t147 t148 t149 t150 t151 t152 t153 t154 t155 t156 t157 t158 t159 t160 t161 t162 t163 t164 t165 t166 t167 t168 t169 t170 t171 t172 t173 t174 t175 t176 t177 t178 t179 t180 t181 t182 t183 t184 t185 t186 t187 t188 t189 t190 t191 t192 t193 t194 t195 t196 t197 t198 t199 t200 t201 t202 t203 t204 t205 t206 t207 t208 t209 t210 t211 t212 t213 t214 t215 t216 t217 t218 t219 t220 t221 t222 t223 t224 t225 t226 t227 t228 t229 t230 t231 t232 t233 t234 t235 t236 t237 t238 t239 t240 t241 t242 t243 t244 t245 t246 t247 t248 t249 t250 t251 t252 t253 t254 t255 b0 b1 b2 b3 b4 b5 b6 b7 bb0 bb1 bb2 bb3 bb4 bb5 bb6 bb7 out vss
* out = t(code), code = sum b_i 2^i; thick NMOS pass switches (gates 0 / 3.3 V), w=0.5 l=0.45
XS0_0_0 t0 bb0 n0_0 vss sg13_hv_nmos w=0.5u l=0.45u ng=1 m=1 mm_ok=1
XS0_0_1 t1 b0 n0_0 vss sg13_hv_nmos w=0.5u l=0.45u ng=1 m=1 mm_ok=1
XS0_1_0 t2 bb0 n0_1 vss sg13_hv_nmos w=0.5u l=0.45u ng=1 m=1 mm_ok=1
XS0_1_1 t3 b0 n0_1 vss sg13_hv_nmos w=0.5u l=0.45u ng=1 m=1 mm_ok=1
XS0_2_0 t4 bb0 n0_2 vss sg13_hv_nmos w=0.5u l=0.45u ng=1 m=1 mm_ok=1
XS0_2_1 t5 b0 n0_2 vss sg13_hv_nmos w=0.5u l=0.45u ng=1 m=1 mm_ok=1
XS0_3_0 t6 bb0 n0_3 vss sg13_hv_nmos w=0.5u l=0.45u ng=1 m=1 mm_ok=1
XS0_3_1 t7 b0 n0_3 vss sg13_hv_nmos w=0.5u l=0.45u ng=1 m=1 mm_ok=1
XS0_4_0 t8 bb0 n0_4 vss sg13_hv_nmos w=0.5u l=0.45u ng=1 m=1 mm_ok=1
XS0_4_1 t9 b0 n0_4 vss sg13_hv_nmos w=0.5u l=0.45u ng=1 m=1 mm_ok=1
XS0_5_0 t10 bb0 n0_5 vss sg13_hv_nmos w=0.5u l=0.45u ng=1 m=1 mm_ok=1
XS0_5_1 t11 b0 n0_5 vss sg13_hv_nmos w=0.5u l=0.45u ng=1 m=1 mm_ok=1
XS0_6_0 t12 bb0 n0_6 vss sg13_hv_nmos w=0.5u l=0.45u ng=1 m=1 mm_ok=1
XS0_6_1 t13 b0 n0_6 vss sg13_hv_nmos w=0.5u l=0.45u ng=1 m=1 mm_ok=1
XS0_7_0 t14 bb0 n0_7 vss sg13_hv_nmos w=0.5u l=0.45u ng=1 m=1 mm_ok=1
XS0_7_1 t15 b0 n0_7 vss sg13_hv_nmos w=0.5u l=0.45u ng=1 m=1 mm_ok=1
XS0_8_0 t16 bb0 n0_8 vss sg13_hv_nmos w=0.5u l=0.45u ng=1 m=1 mm_ok=1
XS0_8_1 t17 b0 n0_8 vss sg13_hv_nmos w=0.5u l=0.45u ng=1 m=1 mm_ok=1
XS0_9_0 t18 bb0 n0_9 vss sg13_hv_nmos w=0.5u l=0.45u ng=1 m=1 mm_ok=1
XS0_9_1 t19 b0 n0_9 vss sg13_hv_nmos w=0.5u l=0.45u ng=1 m=1 mm_ok=1
XS0_10_0 t20 bb0 n0_10 vss sg13_hv_nmos w=0.5u l=0.45u ng=1 m=1 mm_ok=1
XS0_10_1 t21 b0 n0_10 vss sg13_hv_nmos w=0.5u l=0.45u ng=1 m=1 mm_ok=1
XS0_11_0 t22 bb0 n0_11 vss sg13_hv_nmos w=0.5u l=0.45u ng=1 m=1 mm_ok=1
XS0_11_1 t23 b0 n0_11 vss sg13_hv_nmos w=0.5u l=0.45u ng=1 m=1 mm_ok=1
XS0_12_0 t24 bb0 n0_12 vss sg13_hv_nmos w=0.5u l=0.45u ng=1 m=1 mm_ok=1
XS0_12_1 t25 b0 n0_12 vss sg13_hv_nmos w=0.5u l=0.45u ng=1 m=1 mm_ok=1
XS0_13_0 t26 bb0 n0_13 vss sg13_hv_nmos w=0.5u l=0.45u ng=1 m=1 mm_ok=1
XS0_13_1 t27 b0 n0_13 vss sg13_hv_nmos w=0.5u l=0.45u ng=1 m=1 mm_ok=1
XS0_14_0 t28 bb0 n0_14 vss sg13_hv_nmos w=0.5u l=0.45u ng=1 m=1 mm_ok=1
XS0_14_1 t29 b0 n0_14 vss sg13_hv_nmos w=0.5u l=0.45u ng=1 m=1 mm_ok=1
XS0_15_0 t30 bb0 n0_15 vss sg13_hv_nmos w=0.5u l=0.45u ng=1 m=1 mm_ok=1
XS0_15_1 t31 b0 n0_15 vss sg13_hv_nmos w=0.5u l=0.45u ng=1 m=1 mm_ok=1
XS0_16_0 t32 bb0 n0_16 vss sg13_hv_nmos w=0.5u l=0.45u ng=1 m=1 mm_ok=1
XS0_16_1 t33 b0 n0_16 vss sg13_hv_nmos w=0.5u l=0.45u ng=1 m=1 mm_ok=1
XS0_17_0 t34 bb0 n0_17 vss sg13_hv_nmos w=0.5u l=0.45u ng=1 m=1 mm_ok=1
XS0_17_1 t35 b0 n0_17 vss sg13_hv_nmos w=0.5u l=0.45u ng=1 m=1 mm_ok=1
XS0_18_0 t36 bb0 n0_18 vss sg13_hv_nmos w=0.5u l=0.45u ng=1 m=1 mm_ok=1
XS0_18_1 t37 b0 n0_18 vss sg13_hv_nmos w=0.5u l=0.45u ng=1 m=1 mm_ok=1
XS0_19_0 t38 bb0 n0_19 vss sg13_hv_nmos w=0.5u l=0.45u ng=1 m=1 mm_ok=1
XS0_19_1 t39 b0 n0_19 vss sg13_hv_nmos w=0.5u l=0.45u ng=1 m=1 mm_ok=1
XS0_20_0 t40 bb0 n0_20 vss sg13_hv_nmos w=0.5u l=0.45u ng=1 m=1 mm_ok=1
XS0_20_1 t41 b0 n0_20 vss sg13_hv_nmos w=0.5u l=0.45u ng=1 m=1 mm_ok=1
XS0_21_0 t42 bb0 n0_21 vss sg13_hv_nmos w=0.5u l=0.45u ng=1 m=1 mm_ok=1
XS0_21_1 t43 b0 n0_21 vss sg13_hv_nmos w=0.5u l=0.45u ng=1 m=1 mm_ok=1
XS0_22_0 t44 bb0 n0_22 vss sg13_hv_nmos w=0.5u l=0.45u ng=1 m=1 mm_ok=1
XS0_22_1 t45 b0 n0_22 vss sg13_hv_nmos w=0.5u l=0.45u ng=1 m=1 mm_ok=1
XS0_23_0 t46 bb0 n0_23 vss sg13_hv_nmos w=0.5u l=0.45u ng=1 m=1 mm_ok=1
XS0_23_1 t47 b0 n0_23 vss sg13_hv_nmos w=0.5u l=0.45u ng=1 m=1 mm_ok=1
XS0_24_0 t48 bb0 n0_24 vss sg13_hv_nmos w=0.5u l=0.45u ng=1 m=1 mm_ok=1
XS0_24_1 t49 b0 n0_24 vss sg13_hv_nmos w=0.5u l=0.45u ng=1 m=1 mm_ok=1
XS0_25_0 t50 bb0 n0_25 vss sg13_hv_nmos w=0.5u l=0.45u ng=1 m=1 mm_ok=1
XS0_25_1 t51 b0 n0_25 vss sg13_hv_nmos w=0.5u l=0.45u ng=1 m=1 mm_ok=1
XS0_26_0 t52 bb0 n0_26 vss sg13_hv_nmos w=0.5u l=0.45u ng=1 m=1 mm_ok=1
XS0_26_1 t53 b0 n0_26 vss sg13_hv_nmos w=0.5u l=0.45u ng=1 m=1 mm_ok=1
XS0_27_0 t54 bb0 n0_27 vss sg13_hv_nmos w=0.5u l=0.45u ng=1 m=1 mm_ok=1
XS0_27_1 t55 b0 n0_27 vss sg13_hv_nmos w=0.5u l=0.45u ng=1 m=1 mm_ok=1
XS0_28_0 t56 bb0 n0_28 vss sg13_hv_nmos w=0.5u l=0.45u ng=1 m=1 mm_ok=1
XS0_28_1 t57 b0 n0_28 vss sg13_hv_nmos w=0.5u l=0.45u ng=1 m=1 mm_ok=1
XS0_29_0 t58 bb0 n0_29 vss sg13_hv_nmos w=0.5u l=0.45u ng=1 m=1 mm_ok=1
XS0_29_1 t59 b0 n0_29 vss sg13_hv_nmos w=0.5u l=0.45u ng=1 m=1 mm_ok=1
XS0_30_0 t60 bb0 n0_30 vss sg13_hv_nmos w=0.5u l=0.45u ng=1 m=1 mm_ok=1
XS0_30_1 t61 b0 n0_30 vss sg13_hv_nmos w=0.5u l=0.45u ng=1 m=1 mm_ok=1
XS0_31_0 t62 bb0 n0_31 vss sg13_hv_nmos w=0.5u l=0.45u ng=1 m=1 mm_ok=1
XS0_31_1 t63 b0 n0_31 vss sg13_hv_nmos w=0.5u l=0.45u ng=1 m=1 mm_ok=1
XS0_32_0 t64 bb0 n0_32 vss sg13_hv_nmos w=0.5u l=0.45u ng=1 m=1 mm_ok=1
XS0_32_1 t65 b0 n0_32 vss sg13_hv_nmos w=0.5u l=0.45u ng=1 m=1 mm_ok=1
XS0_33_0 t66 bb0 n0_33 vss sg13_hv_nmos w=0.5u l=0.45u ng=1 m=1 mm_ok=1
XS0_33_1 t67 b0 n0_33 vss sg13_hv_nmos w=0.5u l=0.45u ng=1 m=1 mm_ok=1
XS0_34_0 t68 bb0 n0_34 vss sg13_hv_nmos w=0.5u l=0.45u ng=1 m=1 mm_ok=1
XS0_34_1 t69 b0 n0_34 vss sg13_hv_nmos w=0.5u l=0.45u ng=1 m=1 mm_ok=1
XS0_35_0 t70 bb0 n0_35 vss sg13_hv_nmos w=0.5u l=0.45u ng=1 m=1 mm_ok=1
XS0_35_1 t71 b0 n0_35 vss sg13_hv_nmos w=0.5u l=0.45u ng=1 m=1 mm_ok=1
XS0_36_0 t72 bb0 n0_36 vss sg13_hv_nmos w=0.5u l=0.45u ng=1 m=1 mm_ok=1
XS0_36_1 t73 b0 n0_36 vss sg13_hv_nmos w=0.5u l=0.45u ng=1 m=1 mm_ok=1
XS0_37_0 t74 bb0 n0_37 vss sg13_hv_nmos w=0.5u l=0.45u ng=1 m=1 mm_ok=1
XS0_37_1 t75 b0 n0_37 vss sg13_hv_nmos w=0.5u l=0.45u ng=1 m=1 mm_ok=1
XS0_38_0 t76 bb0 n0_38 vss sg13_hv_nmos w=0.5u l=0.45u ng=1 m=1 mm_ok=1
XS0_38_1 t77 b0 n0_38 vss sg13_hv_nmos w=0.5u l=0.45u ng=1 m=1 mm_ok=1
XS0_39_0 t78 bb0 n0_39 vss sg13_hv_nmos w=0.5u l=0.45u ng=1 m=1 mm_ok=1
XS0_39_1 t79 b0 n0_39 vss sg13_hv_nmos w=0.5u l=0.45u ng=1 m=1 mm_ok=1
XS0_40_0 t80 bb0 n0_40 vss sg13_hv_nmos w=0.5u l=0.45u ng=1 m=1 mm_ok=1
XS0_40_1 t81 b0 n0_40 vss sg13_hv_nmos w=0.5u l=0.45u ng=1 m=1 mm_ok=1
XS0_41_0 t82 bb0 n0_41 vss sg13_hv_nmos w=0.5u l=0.45u ng=1 m=1 mm_ok=1
XS0_41_1 t83 b0 n0_41 vss sg13_hv_nmos w=0.5u l=0.45u ng=1 m=1 mm_ok=1
XS0_42_0 t84 bb0 n0_42 vss sg13_hv_nmos w=0.5u l=0.45u ng=1 m=1 mm_ok=1
XS0_42_1 t85 b0 n0_42 vss sg13_hv_nmos w=0.5u l=0.45u ng=1 m=1 mm_ok=1
XS0_43_0 t86 bb0 n0_43 vss sg13_hv_nmos w=0.5u l=0.45u ng=1 m=1 mm_ok=1
XS0_43_1 t87 b0 n0_43 vss sg13_hv_nmos w=0.5u l=0.45u ng=1 m=1 mm_ok=1
XS0_44_0 t88 bb0 n0_44 vss sg13_hv_nmos w=0.5u l=0.45u ng=1 m=1 mm_ok=1
XS0_44_1 t89 b0 n0_44 vss sg13_hv_nmos w=0.5u l=0.45u ng=1 m=1 mm_ok=1
XS0_45_0 t90 bb0 n0_45 vss sg13_hv_nmos w=0.5u l=0.45u ng=1 m=1 mm_ok=1
XS0_45_1 t91 b0 n0_45 vss sg13_hv_nmos w=0.5u l=0.45u ng=1 m=1 mm_ok=1
XS0_46_0 t92 bb0 n0_46 vss sg13_hv_nmos w=0.5u l=0.45u ng=1 m=1 mm_ok=1
XS0_46_1 t93 b0 n0_46 vss sg13_hv_nmos w=0.5u l=0.45u ng=1 m=1 mm_ok=1
XS0_47_0 t94 bb0 n0_47 vss sg13_hv_nmos w=0.5u l=0.45u ng=1 m=1 mm_ok=1
XS0_47_1 t95 b0 n0_47 vss sg13_hv_nmos w=0.5u l=0.45u ng=1 m=1 mm_ok=1
XS0_48_0 t96 bb0 n0_48 vss sg13_hv_nmos w=0.5u l=0.45u ng=1 m=1 mm_ok=1
XS0_48_1 t97 b0 n0_48 vss sg13_hv_nmos w=0.5u l=0.45u ng=1 m=1 mm_ok=1
XS0_49_0 t98 bb0 n0_49 vss sg13_hv_nmos w=0.5u l=0.45u ng=1 m=1 mm_ok=1
XS0_49_1 t99 b0 n0_49 vss sg13_hv_nmos w=0.5u l=0.45u ng=1 m=1 mm_ok=1
XS0_50_0 t100 bb0 n0_50 vss sg13_hv_nmos w=0.5u l=0.45u ng=1 m=1 mm_ok=1
XS0_50_1 t101 b0 n0_50 vss sg13_hv_nmos w=0.5u l=0.45u ng=1 m=1 mm_ok=1
XS0_51_0 t102 bb0 n0_51 vss sg13_hv_nmos w=0.5u l=0.45u ng=1 m=1 mm_ok=1
XS0_51_1 t103 b0 n0_51 vss sg13_hv_nmos w=0.5u l=0.45u ng=1 m=1 mm_ok=1
XS0_52_0 t104 bb0 n0_52 vss sg13_hv_nmos w=0.5u l=0.45u ng=1 m=1 mm_ok=1
XS0_52_1 t105 b0 n0_52 vss sg13_hv_nmos w=0.5u l=0.45u ng=1 m=1 mm_ok=1
XS0_53_0 t106 bb0 n0_53 vss sg13_hv_nmos w=0.5u l=0.45u ng=1 m=1 mm_ok=1
XS0_53_1 t107 b0 n0_53 vss sg13_hv_nmos w=0.5u l=0.45u ng=1 m=1 mm_ok=1
XS0_54_0 t108 bb0 n0_54 vss sg13_hv_nmos w=0.5u l=0.45u ng=1 m=1 mm_ok=1
XS0_54_1 t109 b0 n0_54 vss sg13_hv_nmos w=0.5u l=0.45u ng=1 m=1 mm_ok=1
XS0_55_0 t110 bb0 n0_55 vss sg13_hv_nmos w=0.5u l=0.45u ng=1 m=1 mm_ok=1
XS0_55_1 t111 b0 n0_55 vss sg13_hv_nmos w=0.5u l=0.45u ng=1 m=1 mm_ok=1
XS0_56_0 t112 bb0 n0_56 vss sg13_hv_nmos w=0.5u l=0.45u ng=1 m=1 mm_ok=1
XS0_56_1 t113 b0 n0_56 vss sg13_hv_nmos w=0.5u l=0.45u ng=1 m=1 mm_ok=1
XS0_57_0 t114 bb0 n0_57 vss sg13_hv_nmos w=0.5u l=0.45u ng=1 m=1 mm_ok=1
XS0_57_1 t115 b0 n0_57 vss sg13_hv_nmos w=0.5u l=0.45u ng=1 m=1 mm_ok=1
XS0_58_0 t116 bb0 n0_58 vss sg13_hv_nmos w=0.5u l=0.45u ng=1 m=1 mm_ok=1
XS0_58_1 t117 b0 n0_58 vss sg13_hv_nmos w=0.5u l=0.45u ng=1 m=1 mm_ok=1
XS0_59_0 t118 bb0 n0_59 vss sg13_hv_nmos w=0.5u l=0.45u ng=1 m=1 mm_ok=1
XS0_59_1 t119 b0 n0_59 vss sg13_hv_nmos w=0.5u l=0.45u ng=1 m=1 mm_ok=1
XS0_60_0 t120 bb0 n0_60 vss sg13_hv_nmos w=0.5u l=0.45u ng=1 m=1 mm_ok=1
XS0_60_1 t121 b0 n0_60 vss sg13_hv_nmos w=0.5u l=0.45u ng=1 m=1 mm_ok=1
XS0_61_0 t122 bb0 n0_61 vss sg13_hv_nmos w=0.5u l=0.45u ng=1 m=1 mm_ok=1
XS0_61_1 t123 b0 n0_61 vss sg13_hv_nmos w=0.5u l=0.45u ng=1 m=1 mm_ok=1
XS0_62_0 t124 bb0 n0_62 vss sg13_hv_nmos w=0.5u l=0.45u ng=1 m=1 mm_ok=1
XS0_62_1 t125 b0 n0_62 vss sg13_hv_nmos w=0.5u l=0.45u ng=1 m=1 mm_ok=1
XS0_63_0 t126 bb0 n0_63 vss sg13_hv_nmos w=0.5u l=0.45u ng=1 m=1 mm_ok=1
XS0_63_1 t127 b0 n0_63 vss sg13_hv_nmos w=0.5u l=0.45u ng=1 m=1 mm_ok=1
XS0_64_0 t128 bb0 n0_64 vss sg13_hv_nmos w=0.5u l=0.45u ng=1 m=1 mm_ok=1
XS0_64_1 t129 b0 n0_64 vss sg13_hv_nmos w=0.5u l=0.45u ng=1 m=1 mm_ok=1
XS0_65_0 t130 bb0 n0_65 vss sg13_hv_nmos w=0.5u l=0.45u ng=1 m=1 mm_ok=1
XS0_65_1 t131 b0 n0_65 vss sg13_hv_nmos w=0.5u l=0.45u ng=1 m=1 mm_ok=1
XS0_66_0 t132 bb0 n0_66 vss sg13_hv_nmos w=0.5u l=0.45u ng=1 m=1 mm_ok=1
XS0_66_1 t133 b0 n0_66 vss sg13_hv_nmos w=0.5u l=0.45u ng=1 m=1 mm_ok=1
XS0_67_0 t134 bb0 n0_67 vss sg13_hv_nmos w=0.5u l=0.45u ng=1 m=1 mm_ok=1
XS0_67_1 t135 b0 n0_67 vss sg13_hv_nmos w=0.5u l=0.45u ng=1 m=1 mm_ok=1
XS0_68_0 t136 bb0 n0_68 vss sg13_hv_nmos w=0.5u l=0.45u ng=1 m=1 mm_ok=1
XS0_68_1 t137 b0 n0_68 vss sg13_hv_nmos w=0.5u l=0.45u ng=1 m=1 mm_ok=1
XS0_69_0 t138 bb0 n0_69 vss sg13_hv_nmos w=0.5u l=0.45u ng=1 m=1 mm_ok=1
XS0_69_1 t139 b0 n0_69 vss sg13_hv_nmos w=0.5u l=0.45u ng=1 m=1 mm_ok=1
XS0_70_0 t140 bb0 n0_70 vss sg13_hv_nmos w=0.5u l=0.45u ng=1 m=1 mm_ok=1
XS0_70_1 t141 b0 n0_70 vss sg13_hv_nmos w=0.5u l=0.45u ng=1 m=1 mm_ok=1
XS0_71_0 t142 bb0 n0_71 vss sg13_hv_nmos w=0.5u l=0.45u ng=1 m=1 mm_ok=1
XS0_71_1 t143 b0 n0_71 vss sg13_hv_nmos w=0.5u l=0.45u ng=1 m=1 mm_ok=1
XS0_72_0 t144 bb0 n0_72 vss sg13_hv_nmos w=0.5u l=0.45u ng=1 m=1 mm_ok=1
XS0_72_1 t145 b0 n0_72 vss sg13_hv_nmos w=0.5u l=0.45u ng=1 m=1 mm_ok=1
XS0_73_0 t146 bb0 n0_73 vss sg13_hv_nmos w=0.5u l=0.45u ng=1 m=1 mm_ok=1
XS0_73_1 t147 b0 n0_73 vss sg13_hv_nmos w=0.5u l=0.45u ng=1 m=1 mm_ok=1
XS0_74_0 t148 bb0 n0_74 vss sg13_hv_nmos w=0.5u l=0.45u ng=1 m=1 mm_ok=1
XS0_74_1 t149 b0 n0_74 vss sg13_hv_nmos w=0.5u l=0.45u ng=1 m=1 mm_ok=1
XS0_75_0 t150 bb0 n0_75 vss sg13_hv_nmos w=0.5u l=0.45u ng=1 m=1 mm_ok=1
XS0_75_1 t151 b0 n0_75 vss sg13_hv_nmos w=0.5u l=0.45u ng=1 m=1 mm_ok=1
XS0_76_0 t152 bb0 n0_76 vss sg13_hv_nmos w=0.5u l=0.45u ng=1 m=1 mm_ok=1
XS0_76_1 t153 b0 n0_76 vss sg13_hv_nmos w=0.5u l=0.45u ng=1 m=1 mm_ok=1
XS0_77_0 t154 bb0 n0_77 vss sg13_hv_nmos w=0.5u l=0.45u ng=1 m=1 mm_ok=1
XS0_77_1 t155 b0 n0_77 vss sg13_hv_nmos w=0.5u l=0.45u ng=1 m=1 mm_ok=1
XS0_78_0 t156 bb0 n0_78 vss sg13_hv_nmos w=0.5u l=0.45u ng=1 m=1 mm_ok=1
XS0_78_1 t157 b0 n0_78 vss sg13_hv_nmos w=0.5u l=0.45u ng=1 m=1 mm_ok=1
XS0_79_0 t158 bb0 n0_79 vss sg13_hv_nmos w=0.5u l=0.45u ng=1 m=1 mm_ok=1
XS0_79_1 t159 b0 n0_79 vss sg13_hv_nmos w=0.5u l=0.45u ng=1 m=1 mm_ok=1
XS0_80_0 t160 bb0 n0_80 vss sg13_hv_nmos w=0.5u l=0.45u ng=1 m=1 mm_ok=1
XS0_80_1 t161 b0 n0_80 vss sg13_hv_nmos w=0.5u l=0.45u ng=1 m=1 mm_ok=1
XS0_81_0 t162 bb0 n0_81 vss sg13_hv_nmos w=0.5u l=0.45u ng=1 m=1 mm_ok=1
XS0_81_1 t163 b0 n0_81 vss sg13_hv_nmos w=0.5u l=0.45u ng=1 m=1 mm_ok=1
XS0_82_0 t164 bb0 n0_82 vss sg13_hv_nmos w=0.5u l=0.45u ng=1 m=1 mm_ok=1
XS0_82_1 t165 b0 n0_82 vss sg13_hv_nmos w=0.5u l=0.45u ng=1 m=1 mm_ok=1
XS0_83_0 t166 bb0 n0_83 vss sg13_hv_nmos w=0.5u l=0.45u ng=1 m=1 mm_ok=1
XS0_83_1 t167 b0 n0_83 vss sg13_hv_nmos w=0.5u l=0.45u ng=1 m=1 mm_ok=1
XS0_84_0 t168 bb0 n0_84 vss sg13_hv_nmos w=0.5u l=0.45u ng=1 m=1 mm_ok=1
XS0_84_1 t169 b0 n0_84 vss sg13_hv_nmos w=0.5u l=0.45u ng=1 m=1 mm_ok=1
XS0_85_0 t170 bb0 n0_85 vss sg13_hv_nmos w=0.5u l=0.45u ng=1 m=1 mm_ok=1
XS0_85_1 t171 b0 n0_85 vss sg13_hv_nmos w=0.5u l=0.45u ng=1 m=1 mm_ok=1
XS0_86_0 t172 bb0 n0_86 vss sg13_hv_nmos w=0.5u l=0.45u ng=1 m=1 mm_ok=1
XS0_86_1 t173 b0 n0_86 vss sg13_hv_nmos w=0.5u l=0.45u ng=1 m=1 mm_ok=1
XS0_87_0 t174 bb0 n0_87 vss sg13_hv_nmos w=0.5u l=0.45u ng=1 m=1 mm_ok=1
XS0_87_1 t175 b0 n0_87 vss sg13_hv_nmos w=0.5u l=0.45u ng=1 m=1 mm_ok=1
XS0_88_0 t176 bb0 n0_88 vss sg13_hv_nmos w=0.5u l=0.45u ng=1 m=1 mm_ok=1
XS0_88_1 t177 b0 n0_88 vss sg13_hv_nmos w=0.5u l=0.45u ng=1 m=1 mm_ok=1
XS0_89_0 t178 bb0 n0_89 vss sg13_hv_nmos w=0.5u l=0.45u ng=1 m=1 mm_ok=1
XS0_89_1 t179 b0 n0_89 vss sg13_hv_nmos w=0.5u l=0.45u ng=1 m=1 mm_ok=1
XS0_90_0 t180 bb0 n0_90 vss sg13_hv_nmos w=0.5u l=0.45u ng=1 m=1 mm_ok=1
XS0_90_1 t181 b0 n0_90 vss sg13_hv_nmos w=0.5u l=0.45u ng=1 m=1 mm_ok=1
XS0_91_0 t182 bb0 n0_91 vss sg13_hv_nmos w=0.5u l=0.45u ng=1 m=1 mm_ok=1
XS0_91_1 t183 b0 n0_91 vss sg13_hv_nmos w=0.5u l=0.45u ng=1 m=1 mm_ok=1
XS0_92_0 t184 bb0 n0_92 vss sg13_hv_nmos w=0.5u l=0.45u ng=1 m=1 mm_ok=1
XS0_92_1 t185 b0 n0_92 vss sg13_hv_nmos w=0.5u l=0.45u ng=1 m=1 mm_ok=1
XS0_93_0 t186 bb0 n0_93 vss sg13_hv_nmos w=0.5u l=0.45u ng=1 m=1 mm_ok=1
XS0_93_1 t187 b0 n0_93 vss sg13_hv_nmos w=0.5u l=0.45u ng=1 m=1 mm_ok=1
XS0_94_0 t188 bb0 n0_94 vss sg13_hv_nmos w=0.5u l=0.45u ng=1 m=1 mm_ok=1
XS0_94_1 t189 b0 n0_94 vss sg13_hv_nmos w=0.5u l=0.45u ng=1 m=1 mm_ok=1
XS0_95_0 t190 bb0 n0_95 vss sg13_hv_nmos w=0.5u l=0.45u ng=1 m=1 mm_ok=1
XS0_95_1 t191 b0 n0_95 vss sg13_hv_nmos w=0.5u l=0.45u ng=1 m=1 mm_ok=1
XS0_96_0 t192 bb0 n0_96 vss sg13_hv_nmos w=0.5u l=0.45u ng=1 m=1 mm_ok=1
XS0_96_1 t193 b0 n0_96 vss sg13_hv_nmos w=0.5u l=0.45u ng=1 m=1 mm_ok=1
XS0_97_0 t194 bb0 n0_97 vss sg13_hv_nmos w=0.5u l=0.45u ng=1 m=1 mm_ok=1
XS0_97_1 t195 b0 n0_97 vss sg13_hv_nmos w=0.5u l=0.45u ng=1 m=1 mm_ok=1
XS0_98_0 t196 bb0 n0_98 vss sg13_hv_nmos w=0.5u l=0.45u ng=1 m=1 mm_ok=1
XS0_98_1 t197 b0 n0_98 vss sg13_hv_nmos w=0.5u l=0.45u ng=1 m=1 mm_ok=1
XS0_99_0 t198 bb0 n0_99 vss sg13_hv_nmos w=0.5u l=0.45u ng=1 m=1 mm_ok=1
XS0_99_1 t199 b0 n0_99 vss sg13_hv_nmos w=0.5u l=0.45u ng=1 m=1 mm_ok=1
XS0_100_0 t200 bb0 n0_100 vss sg13_hv_nmos w=0.5u l=0.45u ng=1 m=1 mm_ok=1
XS0_100_1 t201 b0 n0_100 vss sg13_hv_nmos w=0.5u l=0.45u ng=1 m=1 mm_ok=1
XS0_101_0 t202 bb0 n0_101 vss sg13_hv_nmos w=0.5u l=0.45u ng=1 m=1 mm_ok=1
XS0_101_1 t203 b0 n0_101 vss sg13_hv_nmos w=0.5u l=0.45u ng=1 m=1 mm_ok=1
XS0_102_0 t204 bb0 n0_102 vss sg13_hv_nmos w=0.5u l=0.45u ng=1 m=1 mm_ok=1
XS0_102_1 t205 b0 n0_102 vss sg13_hv_nmos w=0.5u l=0.45u ng=1 m=1 mm_ok=1
XS0_103_0 t206 bb0 n0_103 vss sg13_hv_nmos w=0.5u l=0.45u ng=1 m=1 mm_ok=1
XS0_103_1 t207 b0 n0_103 vss sg13_hv_nmos w=0.5u l=0.45u ng=1 m=1 mm_ok=1
XS0_104_0 t208 bb0 n0_104 vss sg13_hv_nmos w=0.5u l=0.45u ng=1 m=1 mm_ok=1
XS0_104_1 t209 b0 n0_104 vss sg13_hv_nmos w=0.5u l=0.45u ng=1 m=1 mm_ok=1
XS0_105_0 t210 bb0 n0_105 vss sg13_hv_nmos w=0.5u l=0.45u ng=1 m=1 mm_ok=1
XS0_105_1 t211 b0 n0_105 vss sg13_hv_nmos w=0.5u l=0.45u ng=1 m=1 mm_ok=1
XS0_106_0 t212 bb0 n0_106 vss sg13_hv_nmos w=0.5u l=0.45u ng=1 m=1 mm_ok=1
XS0_106_1 t213 b0 n0_106 vss sg13_hv_nmos w=0.5u l=0.45u ng=1 m=1 mm_ok=1
XS0_107_0 t214 bb0 n0_107 vss sg13_hv_nmos w=0.5u l=0.45u ng=1 m=1 mm_ok=1
XS0_107_1 t215 b0 n0_107 vss sg13_hv_nmos w=0.5u l=0.45u ng=1 m=1 mm_ok=1
XS0_108_0 t216 bb0 n0_108 vss sg13_hv_nmos w=0.5u l=0.45u ng=1 m=1 mm_ok=1
XS0_108_1 t217 b0 n0_108 vss sg13_hv_nmos w=0.5u l=0.45u ng=1 m=1 mm_ok=1
XS0_109_0 t218 bb0 n0_109 vss sg13_hv_nmos w=0.5u l=0.45u ng=1 m=1 mm_ok=1
XS0_109_1 t219 b0 n0_109 vss sg13_hv_nmos w=0.5u l=0.45u ng=1 m=1 mm_ok=1
XS0_110_0 t220 bb0 n0_110 vss sg13_hv_nmos w=0.5u l=0.45u ng=1 m=1 mm_ok=1
XS0_110_1 t221 b0 n0_110 vss sg13_hv_nmos w=0.5u l=0.45u ng=1 m=1 mm_ok=1
XS0_111_0 t222 bb0 n0_111 vss sg13_hv_nmos w=0.5u l=0.45u ng=1 m=1 mm_ok=1
XS0_111_1 t223 b0 n0_111 vss sg13_hv_nmos w=0.5u l=0.45u ng=1 m=1 mm_ok=1
XS0_112_0 t224 bb0 n0_112 vss sg13_hv_nmos w=0.5u l=0.45u ng=1 m=1 mm_ok=1
XS0_112_1 t225 b0 n0_112 vss sg13_hv_nmos w=0.5u l=0.45u ng=1 m=1 mm_ok=1
XS0_113_0 t226 bb0 n0_113 vss sg13_hv_nmos w=0.5u l=0.45u ng=1 m=1 mm_ok=1
XS0_113_1 t227 b0 n0_113 vss sg13_hv_nmos w=0.5u l=0.45u ng=1 m=1 mm_ok=1
XS0_114_0 t228 bb0 n0_114 vss sg13_hv_nmos w=0.5u l=0.45u ng=1 m=1 mm_ok=1
XS0_114_1 t229 b0 n0_114 vss sg13_hv_nmos w=0.5u l=0.45u ng=1 m=1 mm_ok=1
XS0_115_0 t230 bb0 n0_115 vss sg13_hv_nmos w=0.5u l=0.45u ng=1 m=1 mm_ok=1
XS0_115_1 t231 b0 n0_115 vss sg13_hv_nmos w=0.5u l=0.45u ng=1 m=1 mm_ok=1
XS0_116_0 t232 bb0 n0_116 vss sg13_hv_nmos w=0.5u l=0.45u ng=1 m=1 mm_ok=1
XS0_116_1 t233 b0 n0_116 vss sg13_hv_nmos w=0.5u l=0.45u ng=1 m=1 mm_ok=1
XS0_117_0 t234 bb0 n0_117 vss sg13_hv_nmos w=0.5u l=0.45u ng=1 m=1 mm_ok=1
XS0_117_1 t235 b0 n0_117 vss sg13_hv_nmos w=0.5u l=0.45u ng=1 m=1 mm_ok=1
XS0_118_0 t236 bb0 n0_118 vss sg13_hv_nmos w=0.5u l=0.45u ng=1 m=1 mm_ok=1
XS0_118_1 t237 b0 n0_118 vss sg13_hv_nmos w=0.5u l=0.45u ng=1 m=1 mm_ok=1
XS0_119_0 t238 bb0 n0_119 vss sg13_hv_nmos w=0.5u l=0.45u ng=1 m=1 mm_ok=1
XS0_119_1 t239 b0 n0_119 vss sg13_hv_nmos w=0.5u l=0.45u ng=1 m=1 mm_ok=1
XS0_120_0 t240 bb0 n0_120 vss sg13_hv_nmos w=0.5u l=0.45u ng=1 m=1 mm_ok=1
XS0_120_1 t241 b0 n0_120 vss sg13_hv_nmos w=0.5u l=0.45u ng=1 m=1 mm_ok=1
XS0_121_0 t242 bb0 n0_121 vss sg13_hv_nmos w=0.5u l=0.45u ng=1 m=1 mm_ok=1
XS0_121_1 t243 b0 n0_121 vss sg13_hv_nmos w=0.5u l=0.45u ng=1 m=1 mm_ok=1
XS0_122_0 t244 bb0 n0_122 vss sg13_hv_nmos w=0.5u l=0.45u ng=1 m=1 mm_ok=1
XS0_122_1 t245 b0 n0_122 vss sg13_hv_nmos w=0.5u l=0.45u ng=1 m=1 mm_ok=1
XS0_123_0 t246 bb0 n0_123 vss sg13_hv_nmos w=0.5u l=0.45u ng=1 m=1 mm_ok=1
XS0_123_1 t247 b0 n0_123 vss sg13_hv_nmos w=0.5u l=0.45u ng=1 m=1 mm_ok=1
XS0_124_0 t248 bb0 n0_124 vss sg13_hv_nmos w=0.5u l=0.45u ng=1 m=1 mm_ok=1
XS0_124_1 t249 b0 n0_124 vss sg13_hv_nmos w=0.5u l=0.45u ng=1 m=1 mm_ok=1
XS0_125_0 t250 bb0 n0_125 vss sg13_hv_nmos w=0.5u l=0.45u ng=1 m=1 mm_ok=1
XS0_125_1 t251 b0 n0_125 vss sg13_hv_nmos w=0.5u l=0.45u ng=1 m=1 mm_ok=1
XS0_126_0 t252 bb0 n0_126 vss sg13_hv_nmos w=0.5u l=0.45u ng=1 m=1 mm_ok=1
XS0_126_1 t253 b0 n0_126 vss sg13_hv_nmos w=0.5u l=0.45u ng=1 m=1 mm_ok=1
XS0_127_0 t254 bb0 n0_127 vss sg13_hv_nmos w=0.5u l=0.45u ng=1 m=1 mm_ok=1
XS0_127_1 t255 b0 n0_127 vss sg13_hv_nmos w=0.5u l=0.45u ng=1 m=1 mm_ok=1
XS1_0_0 n0_0 bb1 n1_0 vss sg13_hv_nmos w=0.5u l=0.45u ng=1 m=1 mm_ok=1
XS1_0_1 n0_1 b1 n1_0 vss sg13_hv_nmos w=0.5u l=0.45u ng=1 m=1 mm_ok=1
XS1_1_0 n0_2 bb1 n1_1 vss sg13_hv_nmos w=0.5u l=0.45u ng=1 m=1 mm_ok=1
XS1_1_1 n0_3 b1 n1_1 vss sg13_hv_nmos w=0.5u l=0.45u ng=1 m=1 mm_ok=1
XS1_2_0 n0_4 bb1 n1_2 vss sg13_hv_nmos w=0.5u l=0.45u ng=1 m=1 mm_ok=1
XS1_2_1 n0_5 b1 n1_2 vss sg13_hv_nmos w=0.5u l=0.45u ng=1 m=1 mm_ok=1
XS1_3_0 n0_6 bb1 n1_3 vss sg13_hv_nmos w=0.5u l=0.45u ng=1 m=1 mm_ok=1
XS1_3_1 n0_7 b1 n1_3 vss sg13_hv_nmos w=0.5u l=0.45u ng=1 m=1 mm_ok=1
XS1_4_0 n0_8 bb1 n1_4 vss sg13_hv_nmos w=0.5u l=0.45u ng=1 m=1 mm_ok=1
XS1_4_1 n0_9 b1 n1_4 vss sg13_hv_nmos w=0.5u l=0.45u ng=1 m=1 mm_ok=1
XS1_5_0 n0_10 bb1 n1_5 vss sg13_hv_nmos w=0.5u l=0.45u ng=1 m=1 mm_ok=1
XS1_5_1 n0_11 b1 n1_5 vss sg13_hv_nmos w=0.5u l=0.45u ng=1 m=1 mm_ok=1
XS1_6_0 n0_12 bb1 n1_6 vss sg13_hv_nmos w=0.5u l=0.45u ng=1 m=1 mm_ok=1
XS1_6_1 n0_13 b1 n1_6 vss sg13_hv_nmos w=0.5u l=0.45u ng=1 m=1 mm_ok=1
XS1_7_0 n0_14 bb1 n1_7 vss sg13_hv_nmos w=0.5u l=0.45u ng=1 m=1 mm_ok=1
XS1_7_1 n0_15 b1 n1_7 vss sg13_hv_nmos w=0.5u l=0.45u ng=1 m=1 mm_ok=1
XS1_8_0 n0_16 bb1 n1_8 vss sg13_hv_nmos w=0.5u l=0.45u ng=1 m=1 mm_ok=1
XS1_8_1 n0_17 b1 n1_8 vss sg13_hv_nmos w=0.5u l=0.45u ng=1 m=1 mm_ok=1
XS1_9_0 n0_18 bb1 n1_9 vss sg13_hv_nmos w=0.5u l=0.45u ng=1 m=1 mm_ok=1
XS1_9_1 n0_19 b1 n1_9 vss sg13_hv_nmos w=0.5u l=0.45u ng=1 m=1 mm_ok=1
XS1_10_0 n0_20 bb1 n1_10 vss sg13_hv_nmos w=0.5u l=0.45u ng=1 m=1 mm_ok=1
XS1_10_1 n0_21 b1 n1_10 vss sg13_hv_nmos w=0.5u l=0.45u ng=1 m=1 mm_ok=1
XS1_11_0 n0_22 bb1 n1_11 vss sg13_hv_nmos w=0.5u l=0.45u ng=1 m=1 mm_ok=1
XS1_11_1 n0_23 b1 n1_11 vss sg13_hv_nmos w=0.5u l=0.45u ng=1 m=1 mm_ok=1
XS1_12_0 n0_24 bb1 n1_12 vss sg13_hv_nmos w=0.5u l=0.45u ng=1 m=1 mm_ok=1
XS1_12_1 n0_25 b1 n1_12 vss sg13_hv_nmos w=0.5u l=0.45u ng=1 m=1 mm_ok=1
XS1_13_0 n0_26 bb1 n1_13 vss sg13_hv_nmos w=0.5u l=0.45u ng=1 m=1 mm_ok=1
XS1_13_1 n0_27 b1 n1_13 vss sg13_hv_nmos w=0.5u l=0.45u ng=1 m=1 mm_ok=1
XS1_14_0 n0_28 bb1 n1_14 vss sg13_hv_nmos w=0.5u l=0.45u ng=1 m=1 mm_ok=1
XS1_14_1 n0_29 b1 n1_14 vss sg13_hv_nmos w=0.5u l=0.45u ng=1 m=1 mm_ok=1
XS1_15_0 n0_30 bb1 n1_15 vss sg13_hv_nmos w=0.5u l=0.45u ng=1 m=1 mm_ok=1
XS1_15_1 n0_31 b1 n1_15 vss sg13_hv_nmos w=0.5u l=0.45u ng=1 m=1 mm_ok=1
XS1_16_0 n0_32 bb1 n1_16 vss sg13_hv_nmos w=0.5u l=0.45u ng=1 m=1 mm_ok=1
XS1_16_1 n0_33 b1 n1_16 vss sg13_hv_nmos w=0.5u l=0.45u ng=1 m=1 mm_ok=1
XS1_17_0 n0_34 bb1 n1_17 vss sg13_hv_nmos w=0.5u l=0.45u ng=1 m=1 mm_ok=1
XS1_17_1 n0_35 b1 n1_17 vss sg13_hv_nmos w=0.5u l=0.45u ng=1 m=1 mm_ok=1
XS1_18_0 n0_36 bb1 n1_18 vss sg13_hv_nmos w=0.5u l=0.45u ng=1 m=1 mm_ok=1
XS1_18_1 n0_37 b1 n1_18 vss sg13_hv_nmos w=0.5u l=0.45u ng=1 m=1 mm_ok=1
XS1_19_0 n0_38 bb1 n1_19 vss sg13_hv_nmos w=0.5u l=0.45u ng=1 m=1 mm_ok=1
XS1_19_1 n0_39 b1 n1_19 vss sg13_hv_nmos w=0.5u l=0.45u ng=1 m=1 mm_ok=1
XS1_20_0 n0_40 bb1 n1_20 vss sg13_hv_nmos w=0.5u l=0.45u ng=1 m=1 mm_ok=1
XS1_20_1 n0_41 b1 n1_20 vss sg13_hv_nmos w=0.5u l=0.45u ng=1 m=1 mm_ok=1
XS1_21_0 n0_42 bb1 n1_21 vss sg13_hv_nmos w=0.5u l=0.45u ng=1 m=1 mm_ok=1
XS1_21_1 n0_43 b1 n1_21 vss sg13_hv_nmos w=0.5u l=0.45u ng=1 m=1 mm_ok=1
XS1_22_0 n0_44 bb1 n1_22 vss sg13_hv_nmos w=0.5u l=0.45u ng=1 m=1 mm_ok=1
XS1_22_1 n0_45 b1 n1_22 vss sg13_hv_nmos w=0.5u l=0.45u ng=1 m=1 mm_ok=1
XS1_23_0 n0_46 bb1 n1_23 vss sg13_hv_nmos w=0.5u l=0.45u ng=1 m=1 mm_ok=1
XS1_23_1 n0_47 b1 n1_23 vss sg13_hv_nmos w=0.5u l=0.45u ng=1 m=1 mm_ok=1
XS1_24_0 n0_48 bb1 n1_24 vss sg13_hv_nmos w=0.5u l=0.45u ng=1 m=1 mm_ok=1
XS1_24_1 n0_49 b1 n1_24 vss sg13_hv_nmos w=0.5u l=0.45u ng=1 m=1 mm_ok=1
XS1_25_0 n0_50 bb1 n1_25 vss sg13_hv_nmos w=0.5u l=0.45u ng=1 m=1 mm_ok=1
XS1_25_1 n0_51 b1 n1_25 vss sg13_hv_nmos w=0.5u l=0.45u ng=1 m=1 mm_ok=1
XS1_26_0 n0_52 bb1 n1_26 vss sg13_hv_nmos w=0.5u l=0.45u ng=1 m=1 mm_ok=1
XS1_26_1 n0_53 b1 n1_26 vss sg13_hv_nmos w=0.5u l=0.45u ng=1 m=1 mm_ok=1
XS1_27_0 n0_54 bb1 n1_27 vss sg13_hv_nmos w=0.5u l=0.45u ng=1 m=1 mm_ok=1
XS1_27_1 n0_55 b1 n1_27 vss sg13_hv_nmos w=0.5u l=0.45u ng=1 m=1 mm_ok=1
XS1_28_0 n0_56 bb1 n1_28 vss sg13_hv_nmos w=0.5u l=0.45u ng=1 m=1 mm_ok=1
XS1_28_1 n0_57 b1 n1_28 vss sg13_hv_nmos w=0.5u l=0.45u ng=1 m=1 mm_ok=1
XS1_29_0 n0_58 bb1 n1_29 vss sg13_hv_nmos w=0.5u l=0.45u ng=1 m=1 mm_ok=1
XS1_29_1 n0_59 b1 n1_29 vss sg13_hv_nmos w=0.5u l=0.45u ng=1 m=1 mm_ok=1
XS1_30_0 n0_60 bb1 n1_30 vss sg13_hv_nmos w=0.5u l=0.45u ng=1 m=1 mm_ok=1
XS1_30_1 n0_61 b1 n1_30 vss sg13_hv_nmos w=0.5u l=0.45u ng=1 m=1 mm_ok=1
XS1_31_0 n0_62 bb1 n1_31 vss sg13_hv_nmos w=0.5u l=0.45u ng=1 m=1 mm_ok=1
XS1_31_1 n0_63 b1 n1_31 vss sg13_hv_nmos w=0.5u l=0.45u ng=1 m=1 mm_ok=1
XS1_32_0 n0_64 bb1 n1_32 vss sg13_hv_nmos w=0.5u l=0.45u ng=1 m=1 mm_ok=1
XS1_32_1 n0_65 b1 n1_32 vss sg13_hv_nmos w=0.5u l=0.45u ng=1 m=1 mm_ok=1
XS1_33_0 n0_66 bb1 n1_33 vss sg13_hv_nmos w=0.5u l=0.45u ng=1 m=1 mm_ok=1
XS1_33_1 n0_67 b1 n1_33 vss sg13_hv_nmos w=0.5u l=0.45u ng=1 m=1 mm_ok=1
XS1_34_0 n0_68 bb1 n1_34 vss sg13_hv_nmos w=0.5u l=0.45u ng=1 m=1 mm_ok=1
XS1_34_1 n0_69 b1 n1_34 vss sg13_hv_nmos w=0.5u l=0.45u ng=1 m=1 mm_ok=1
XS1_35_0 n0_70 bb1 n1_35 vss sg13_hv_nmos w=0.5u l=0.45u ng=1 m=1 mm_ok=1
XS1_35_1 n0_71 b1 n1_35 vss sg13_hv_nmos w=0.5u l=0.45u ng=1 m=1 mm_ok=1
XS1_36_0 n0_72 bb1 n1_36 vss sg13_hv_nmos w=0.5u l=0.45u ng=1 m=1 mm_ok=1
XS1_36_1 n0_73 b1 n1_36 vss sg13_hv_nmos w=0.5u l=0.45u ng=1 m=1 mm_ok=1
XS1_37_0 n0_74 bb1 n1_37 vss sg13_hv_nmos w=0.5u l=0.45u ng=1 m=1 mm_ok=1
XS1_37_1 n0_75 b1 n1_37 vss sg13_hv_nmos w=0.5u l=0.45u ng=1 m=1 mm_ok=1
XS1_38_0 n0_76 bb1 n1_38 vss sg13_hv_nmos w=0.5u l=0.45u ng=1 m=1 mm_ok=1
XS1_38_1 n0_77 b1 n1_38 vss sg13_hv_nmos w=0.5u l=0.45u ng=1 m=1 mm_ok=1
XS1_39_0 n0_78 bb1 n1_39 vss sg13_hv_nmos w=0.5u l=0.45u ng=1 m=1 mm_ok=1
XS1_39_1 n0_79 b1 n1_39 vss sg13_hv_nmos w=0.5u l=0.45u ng=1 m=1 mm_ok=1
XS1_40_0 n0_80 bb1 n1_40 vss sg13_hv_nmos w=0.5u l=0.45u ng=1 m=1 mm_ok=1
XS1_40_1 n0_81 b1 n1_40 vss sg13_hv_nmos w=0.5u l=0.45u ng=1 m=1 mm_ok=1
XS1_41_0 n0_82 bb1 n1_41 vss sg13_hv_nmos w=0.5u l=0.45u ng=1 m=1 mm_ok=1
XS1_41_1 n0_83 b1 n1_41 vss sg13_hv_nmos w=0.5u l=0.45u ng=1 m=1 mm_ok=1
XS1_42_0 n0_84 bb1 n1_42 vss sg13_hv_nmos w=0.5u l=0.45u ng=1 m=1 mm_ok=1
XS1_42_1 n0_85 b1 n1_42 vss sg13_hv_nmos w=0.5u l=0.45u ng=1 m=1 mm_ok=1
XS1_43_0 n0_86 bb1 n1_43 vss sg13_hv_nmos w=0.5u l=0.45u ng=1 m=1 mm_ok=1
XS1_43_1 n0_87 b1 n1_43 vss sg13_hv_nmos w=0.5u l=0.45u ng=1 m=1 mm_ok=1
XS1_44_0 n0_88 bb1 n1_44 vss sg13_hv_nmos w=0.5u l=0.45u ng=1 m=1 mm_ok=1
XS1_44_1 n0_89 b1 n1_44 vss sg13_hv_nmos w=0.5u l=0.45u ng=1 m=1 mm_ok=1
XS1_45_0 n0_90 bb1 n1_45 vss sg13_hv_nmos w=0.5u l=0.45u ng=1 m=1 mm_ok=1
XS1_45_1 n0_91 b1 n1_45 vss sg13_hv_nmos w=0.5u l=0.45u ng=1 m=1 mm_ok=1
XS1_46_0 n0_92 bb1 n1_46 vss sg13_hv_nmos w=0.5u l=0.45u ng=1 m=1 mm_ok=1
XS1_46_1 n0_93 b1 n1_46 vss sg13_hv_nmos w=0.5u l=0.45u ng=1 m=1 mm_ok=1
XS1_47_0 n0_94 bb1 n1_47 vss sg13_hv_nmos w=0.5u l=0.45u ng=1 m=1 mm_ok=1
XS1_47_1 n0_95 b1 n1_47 vss sg13_hv_nmos w=0.5u l=0.45u ng=1 m=1 mm_ok=1
XS1_48_0 n0_96 bb1 n1_48 vss sg13_hv_nmos w=0.5u l=0.45u ng=1 m=1 mm_ok=1
XS1_48_1 n0_97 b1 n1_48 vss sg13_hv_nmos w=0.5u l=0.45u ng=1 m=1 mm_ok=1
XS1_49_0 n0_98 bb1 n1_49 vss sg13_hv_nmos w=0.5u l=0.45u ng=1 m=1 mm_ok=1
XS1_49_1 n0_99 b1 n1_49 vss sg13_hv_nmos w=0.5u l=0.45u ng=1 m=1 mm_ok=1
XS1_50_0 n0_100 bb1 n1_50 vss sg13_hv_nmos w=0.5u l=0.45u ng=1 m=1 mm_ok=1
XS1_50_1 n0_101 b1 n1_50 vss sg13_hv_nmos w=0.5u l=0.45u ng=1 m=1 mm_ok=1
XS1_51_0 n0_102 bb1 n1_51 vss sg13_hv_nmos w=0.5u l=0.45u ng=1 m=1 mm_ok=1
XS1_51_1 n0_103 b1 n1_51 vss sg13_hv_nmos w=0.5u l=0.45u ng=1 m=1 mm_ok=1
XS1_52_0 n0_104 bb1 n1_52 vss sg13_hv_nmos w=0.5u l=0.45u ng=1 m=1 mm_ok=1
XS1_52_1 n0_105 b1 n1_52 vss sg13_hv_nmos w=0.5u l=0.45u ng=1 m=1 mm_ok=1
XS1_53_0 n0_106 bb1 n1_53 vss sg13_hv_nmos w=0.5u l=0.45u ng=1 m=1 mm_ok=1
XS1_53_1 n0_107 b1 n1_53 vss sg13_hv_nmos w=0.5u l=0.45u ng=1 m=1 mm_ok=1
XS1_54_0 n0_108 bb1 n1_54 vss sg13_hv_nmos w=0.5u l=0.45u ng=1 m=1 mm_ok=1
XS1_54_1 n0_109 b1 n1_54 vss sg13_hv_nmos w=0.5u l=0.45u ng=1 m=1 mm_ok=1
XS1_55_0 n0_110 bb1 n1_55 vss sg13_hv_nmos w=0.5u l=0.45u ng=1 m=1 mm_ok=1
XS1_55_1 n0_111 b1 n1_55 vss sg13_hv_nmos w=0.5u l=0.45u ng=1 m=1 mm_ok=1
XS1_56_0 n0_112 bb1 n1_56 vss sg13_hv_nmos w=0.5u l=0.45u ng=1 m=1 mm_ok=1
XS1_56_1 n0_113 b1 n1_56 vss sg13_hv_nmos w=0.5u l=0.45u ng=1 m=1 mm_ok=1
XS1_57_0 n0_114 bb1 n1_57 vss sg13_hv_nmos w=0.5u l=0.45u ng=1 m=1 mm_ok=1
XS1_57_1 n0_115 b1 n1_57 vss sg13_hv_nmos w=0.5u l=0.45u ng=1 m=1 mm_ok=1
XS1_58_0 n0_116 bb1 n1_58 vss sg13_hv_nmos w=0.5u l=0.45u ng=1 m=1 mm_ok=1
XS1_58_1 n0_117 b1 n1_58 vss sg13_hv_nmos w=0.5u l=0.45u ng=1 m=1 mm_ok=1
XS1_59_0 n0_118 bb1 n1_59 vss sg13_hv_nmos w=0.5u l=0.45u ng=1 m=1 mm_ok=1
XS1_59_1 n0_119 b1 n1_59 vss sg13_hv_nmos w=0.5u l=0.45u ng=1 m=1 mm_ok=1
XS1_60_0 n0_120 bb1 n1_60 vss sg13_hv_nmos w=0.5u l=0.45u ng=1 m=1 mm_ok=1
XS1_60_1 n0_121 b1 n1_60 vss sg13_hv_nmos w=0.5u l=0.45u ng=1 m=1 mm_ok=1
XS1_61_0 n0_122 bb1 n1_61 vss sg13_hv_nmos w=0.5u l=0.45u ng=1 m=1 mm_ok=1
XS1_61_1 n0_123 b1 n1_61 vss sg13_hv_nmos w=0.5u l=0.45u ng=1 m=1 mm_ok=1
XS1_62_0 n0_124 bb1 n1_62 vss sg13_hv_nmos w=0.5u l=0.45u ng=1 m=1 mm_ok=1
XS1_62_1 n0_125 b1 n1_62 vss sg13_hv_nmos w=0.5u l=0.45u ng=1 m=1 mm_ok=1
XS1_63_0 n0_126 bb1 n1_63 vss sg13_hv_nmos w=0.5u l=0.45u ng=1 m=1 mm_ok=1
XS1_63_1 n0_127 b1 n1_63 vss sg13_hv_nmos w=0.5u l=0.45u ng=1 m=1 mm_ok=1
XS2_0_0 n1_0 bb2 n2_0 vss sg13_hv_nmos w=0.5u l=0.45u ng=1 m=1 mm_ok=1
XS2_0_1 n1_1 b2 n2_0 vss sg13_hv_nmos w=0.5u l=0.45u ng=1 m=1 mm_ok=1
XS2_1_0 n1_2 bb2 n2_1 vss sg13_hv_nmos w=0.5u l=0.45u ng=1 m=1 mm_ok=1
XS2_1_1 n1_3 b2 n2_1 vss sg13_hv_nmos w=0.5u l=0.45u ng=1 m=1 mm_ok=1
XS2_2_0 n1_4 bb2 n2_2 vss sg13_hv_nmos w=0.5u l=0.45u ng=1 m=1 mm_ok=1
XS2_2_1 n1_5 b2 n2_2 vss sg13_hv_nmos w=0.5u l=0.45u ng=1 m=1 mm_ok=1
XS2_3_0 n1_6 bb2 n2_3 vss sg13_hv_nmos w=0.5u l=0.45u ng=1 m=1 mm_ok=1
XS2_3_1 n1_7 b2 n2_3 vss sg13_hv_nmos w=0.5u l=0.45u ng=1 m=1 mm_ok=1
XS2_4_0 n1_8 bb2 n2_4 vss sg13_hv_nmos w=0.5u l=0.45u ng=1 m=1 mm_ok=1
XS2_4_1 n1_9 b2 n2_4 vss sg13_hv_nmos w=0.5u l=0.45u ng=1 m=1 mm_ok=1
XS2_5_0 n1_10 bb2 n2_5 vss sg13_hv_nmos w=0.5u l=0.45u ng=1 m=1 mm_ok=1
XS2_5_1 n1_11 b2 n2_5 vss sg13_hv_nmos w=0.5u l=0.45u ng=1 m=1 mm_ok=1
XS2_6_0 n1_12 bb2 n2_6 vss sg13_hv_nmos w=0.5u l=0.45u ng=1 m=1 mm_ok=1
XS2_6_1 n1_13 b2 n2_6 vss sg13_hv_nmos w=0.5u l=0.45u ng=1 m=1 mm_ok=1
XS2_7_0 n1_14 bb2 n2_7 vss sg13_hv_nmos w=0.5u l=0.45u ng=1 m=1 mm_ok=1
XS2_7_1 n1_15 b2 n2_7 vss sg13_hv_nmos w=0.5u l=0.45u ng=1 m=1 mm_ok=1
XS2_8_0 n1_16 bb2 n2_8 vss sg13_hv_nmos w=0.5u l=0.45u ng=1 m=1 mm_ok=1
XS2_8_1 n1_17 b2 n2_8 vss sg13_hv_nmos w=0.5u l=0.45u ng=1 m=1 mm_ok=1
XS2_9_0 n1_18 bb2 n2_9 vss sg13_hv_nmos w=0.5u l=0.45u ng=1 m=1 mm_ok=1
XS2_9_1 n1_19 b2 n2_9 vss sg13_hv_nmos w=0.5u l=0.45u ng=1 m=1 mm_ok=1
XS2_10_0 n1_20 bb2 n2_10 vss sg13_hv_nmos w=0.5u l=0.45u ng=1 m=1 mm_ok=1
XS2_10_1 n1_21 b2 n2_10 vss sg13_hv_nmos w=0.5u l=0.45u ng=1 m=1 mm_ok=1
XS2_11_0 n1_22 bb2 n2_11 vss sg13_hv_nmos w=0.5u l=0.45u ng=1 m=1 mm_ok=1
XS2_11_1 n1_23 b2 n2_11 vss sg13_hv_nmos w=0.5u l=0.45u ng=1 m=1 mm_ok=1
XS2_12_0 n1_24 bb2 n2_12 vss sg13_hv_nmos w=0.5u l=0.45u ng=1 m=1 mm_ok=1
XS2_12_1 n1_25 b2 n2_12 vss sg13_hv_nmos w=0.5u l=0.45u ng=1 m=1 mm_ok=1
XS2_13_0 n1_26 bb2 n2_13 vss sg13_hv_nmos w=0.5u l=0.45u ng=1 m=1 mm_ok=1
XS2_13_1 n1_27 b2 n2_13 vss sg13_hv_nmos w=0.5u l=0.45u ng=1 m=1 mm_ok=1
XS2_14_0 n1_28 bb2 n2_14 vss sg13_hv_nmos w=0.5u l=0.45u ng=1 m=1 mm_ok=1
XS2_14_1 n1_29 b2 n2_14 vss sg13_hv_nmos w=0.5u l=0.45u ng=1 m=1 mm_ok=1
XS2_15_0 n1_30 bb2 n2_15 vss sg13_hv_nmos w=0.5u l=0.45u ng=1 m=1 mm_ok=1
XS2_15_1 n1_31 b2 n2_15 vss sg13_hv_nmos w=0.5u l=0.45u ng=1 m=1 mm_ok=1
XS2_16_0 n1_32 bb2 n2_16 vss sg13_hv_nmos w=0.5u l=0.45u ng=1 m=1 mm_ok=1
XS2_16_1 n1_33 b2 n2_16 vss sg13_hv_nmos w=0.5u l=0.45u ng=1 m=1 mm_ok=1
XS2_17_0 n1_34 bb2 n2_17 vss sg13_hv_nmos w=0.5u l=0.45u ng=1 m=1 mm_ok=1
XS2_17_1 n1_35 b2 n2_17 vss sg13_hv_nmos w=0.5u l=0.45u ng=1 m=1 mm_ok=1
XS2_18_0 n1_36 bb2 n2_18 vss sg13_hv_nmos w=0.5u l=0.45u ng=1 m=1 mm_ok=1
XS2_18_1 n1_37 b2 n2_18 vss sg13_hv_nmos w=0.5u l=0.45u ng=1 m=1 mm_ok=1
XS2_19_0 n1_38 bb2 n2_19 vss sg13_hv_nmos w=0.5u l=0.45u ng=1 m=1 mm_ok=1
XS2_19_1 n1_39 b2 n2_19 vss sg13_hv_nmos w=0.5u l=0.45u ng=1 m=1 mm_ok=1
XS2_20_0 n1_40 bb2 n2_20 vss sg13_hv_nmos w=0.5u l=0.45u ng=1 m=1 mm_ok=1
XS2_20_1 n1_41 b2 n2_20 vss sg13_hv_nmos w=0.5u l=0.45u ng=1 m=1 mm_ok=1
XS2_21_0 n1_42 bb2 n2_21 vss sg13_hv_nmos w=0.5u l=0.45u ng=1 m=1 mm_ok=1
XS2_21_1 n1_43 b2 n2_21 vss sg13_hv_nmos w=0.5u l=0.45u ng=1 m=1 mm_ok=1
XS2_22_0 n1_44 bb2 n2_22 vss sg13_hv_nmos w=0.5u l=0.45u ng=1 m=1 mm_ok=1
XS2_22_1 n1_45 b2 n2_22 vss sg13_hv_nmos w=0.5u l=0.45u ng=1 m=1 mm_ok=1
XS2_23_0 n1_46 bb2 n2_23 vss sg13_hv_nmos w=0.5u l=0.45u ng=1 m=1 mm_ok=1
XS2_23_1 n1_47 b2 n2_23 vss sg13_hv_nmos w=0.5u l=0.45u ng=1 m=1 mm_ok=1
XS2_24_0 n1_48 bb2 n2_24 vss sg13_hv_nmos w=0.5u l=0.45u ng=1 m=1 mm_ok=1
XS2_24_1 n1_49 b2 n2_24 vss sg13_hv_nmos w=0.5u l=0.45u ng=1 m=1 mm_ok=1
XS2_25_0 n1_50 bb2 n2_25 vss sg13_hv_nmos w=0.5u l=0.45u ng=1 m=1 mm_ok=1
XS2_25_1 n1_51 b2 n2_25 vss sg13_hv_nmos w=0.5u l=0.45u ng=1 m=1 mm_ok=1
XS2_26_0 n1_52 bb2 n2_26 vss sg13_hv_nmos w=0.5u l=0.45u ng=1 m=1 mm_ok=1
XS2_26_1 n1_53 b2 n2_26 vss sg13_hv_nmos w=0.5u l=0.45u ng=1 m=1 mm_ok=1
XS2_27_0 n1_54 bb2 n2_27 vss sg13_hv_nmos w=0.5u l=0.45u ng=1 m=1 mm_ok=1
XS2_27_1 n1_55 b2 n2_27 vss sg13_hv_nmos w=0.5u l=0.45u ng=1 m=1 mm_ok=1
XS2_28_0 n1_56 bb2 n2_28 vss sg13_hv_nmos w=0.5u l=0.45u ng=1 m=1 mm_ok=1
XS2_28_1 n1_57 b2 n2_28 vss sg13_hv_nmos w=0.5u l=0.45u ng=1 m=1 mm_ok=1
XS2_29_0 n1_58 bb2 n2_29 vss sg13_hv_nmos w=0.5u l=0.45u ng=1 m=1 mm_ok=1
XS2_29_1 n1_59 b2 n2_29 vss sg13_hv_nmos w=0.5u l=0.45u ng=1 m=1 mm_ok=1
XS2_30_0 n1_60 bb2 n2_30 vss sg13_hv_nmos w=0.5u l=0.45u ng=1 m=1 mm_ok=1
XS2_30_1 n1_61 b2 n2_30 vss sg13_hv_nmos w=0.5u l=0.45u ng=1 m=1 mm_ok=1
XS2_31_0 n1_62 bb2 n2_31 vss sg13_hv_nmos w=0.5u l=0.45u ng=1 m=1 mm_ok=1
XS2_31_1 n1_63 b2 n2_31 vss sg13_hv_nmos w=0.5u l=0.45u ng=1 m=1 mm_ok=1
XS3_0_0 n2_0 bb3 n3_0 vss sg13_hv_nmos w=0.5u l=0.45u ng=1 m=1 mm_ok=1
XS3_0_1 n2_1 b3 n3_0 vss sg13_hv_nmos w=0.5u l=0.45u ng=1 m=1 mm_ok=1
XS3_1_0 n2_2 bb3 n3_1 vss sg13_hv_nmos w=0.5u l=0.45u ng=1 m=1 mm_ok=1
XS3_1_1 n2_3 b3 n3_1 vss sg13_hv_nmos w=0.5u l=0.45u ng=1 m=1 mm_ok=1
XS3_2_0 n2_4 bb3 n3_2 vss sg13_hv_nmos w=0.5u l=0.45u ng=1 m=1 mm_ok=1
XS3_2_1 n2_5 b3 n3_2 vss sg13_hv_nmos w=0.5u l=0.45u ng=1 m=1 mm_ok=1
XS3_3_0 n2_6 bb3 n3_3 vss sg13_hv_nmos w=0.5u l=0.45u ng=1 m=1 mm_ok=1
XS3_3_1 n2_7 b3 n3_3 vss sg13_hv_nmos w=0.5u l=0.45u ng=1 m=1 mm_ok=1
XS3_4_0 n2_8 bb3 n3_4 vss sg13_hv_nmos w=0.5u l=0.45u ng=1 m=1 mm_ok=1
XS3_4_1 n2_9 b3 n3_4 vss sg13_hv_nmos w=0.5u l=0.45u ng=1 m=1 mm_ok=1
XS3_5_0 n2_10 bb3 n3_5 vss sg13_hv_nmos w=0.5u l=0.45u ng=1 m=1 mm_ok=1
XS3_5_1 n2_11 b3 n3_5 vss sg13_hv_nmos w=0.5u l=0.45u ng=1 m=1 mm_ok=1
XS3_6_0 n2_12 bb3 n3_6 vss sg13_hv_nmos w=0.5u l=0.45u ng=1 m=1 mm_ok=1
XS3_6_1 n2_13 b3 n3_6 vss sg13_hv_nmos w=0.5u l=0.45u ng=1 m=1 mm_ok=1
XS3_7_0 n2_14 bb3 n3_7 vss sg13_hv_nmos w=0.5u l=0.45u ng=1 m=1 mm_ok=1
XS3_7_1 n2_15 b3 n3_7 vss sg13_hv_nmos w=0.5u l=0.45u ng=1 m=1 mm_ok=1
XS3_8_0 n2_16 bb3 n3_8 vss sg13_hv_nmos w=0.5u l=0.45u ng=1 m=1 mm_ok=1
XS3_8_1 n2_17 b3 n3_8 vss sg13_hv_nmos w=0.5u l=0.45u ng=1 m=1 mm_ok=1
XS3_9_0 n2_18 bb3 n3_9 vss sg13_hv_nmos w=0.5u l=0.45u ng=1 m=1 mm_ok=1
XS3_9_1 n2_19 b3 n3_9 vss sg13_hv_nmos w=0.5u l=0.45u ng=1 m=1 mm_ok=1
XS3_10_0 n2_20 bb3 n3_10 vss sg13_hv_nmos w=0.5u l=0.45u ng=1 m=1 mm_ok=1
XS3_10_1 n2_21 b3 n3_10 vss sg13_hv_nmos w=0.5u l=0.45u ng=1 m=1 mm_ok=1
XS3_11_0 n2_22 bb3 n3_11 vss sg13_hv_nmos w=0.5u l=0.45u ng=1 m=1 mm_ok=1
XS3_11_1 n2_23 b3 n3_11 vss sg13_hv_nmos w=0.5u l=0.45u ng=1 m=1 mm_ok=1
XS3_12_0 n2_24 bb3 n3_12 vss sg13_hv_nmos w=0.5u l=0.45u ng=1 m=1 mm_ok=1
XS3_12_1 n2_25 b3 n3_12 vss sg13_hv_nmos w=0.5u l=0.45u ng=1 m=1 mm_ok=1
XS3_13_0 n2_26 bb3 n3_13 vss sg13_hv_nmos w=0.5u l=0.45u ng=1 m=1 mm_ok=1
XS3_13_1 n2_27 b3 n3_13 vss sg13_hv_nmos w=0.5u l=0.45u ng=1 m=1 mm_ok=1
XS3_14_0 n2_28 bb3 n3_14 vss sg13_hv_nmos w=0.5u l=0.45u ng=1 m=1 mm_ok=1
XS3_14_1 n2_29 b3 n3_14 vss sg13_hv_nmos w=0.5u l=0.45u ng=1 m=1 mm_ok=1
XS3_15_0 n2_30 bb3 n3_15 vss sg13_hv_nmos w=0.5u l=0.45u ng=1 m=1 mm_ok=1
XS3_15_1 n2_31 b3 n3_15 vss sg13_hv_nmos w=0.5u l=0.45u ng=1 m=1 mm_ok=1
XS4_0_0 n3_0 bb4 n4_0 vss sg13_hv_nmos w=0.5u l=0.45u ng=1 m=1 mm_ok=1
XS4_0_1 n3_1 b4 n4_0 vss sg13_hv_nmos w=0.5u l=0.45u ng=1 m=1 mm_ok=1
XS4_1_0 n3_2 bb4 n4_1 vss sg13_hv_nmos w=0.5u l=0.45u ng=1 m=1 mm_ok=1
XS4_1_1 n3_3 b4 n4_1 vss sg13_hv_nmos w=0.5u l=0.45u ng=1 m=1 mm_ok=1
XS4_2_0 n3_4 bb4 n4_2 vss sg13_hv_nmos w=0.5u l=0.45u ng=1 m=1 mm_ok=1
XS4_2_1 n3_5 b4 n4_2 vss sg13_hv_nmos w=0.5u l=0.45u ng=1 m=1 mm_ok=1
XS4_3_0 n3_6 bb4 n4_3 vss sg13_hv_nmos w=0.5u l=0.45u ng=1 m=1 mm_ok=1
XS4_3_1 n3_7 b4 n4_3 vss sg13_hv_nmos w=0.5u l=0.45u ng=1 m=1 mm_ok=1
XS4_4_0 n3_8 bb4 n4_4 vss sg13_hv_nmos w=0.5u l=0.45u ng=1 m=1 mm_ok=1
XS4_4_1 n3_9 b4 n4_4 vss sg13_hv_nmos w=0.5u l=0.45u ng=1 m=1 mm_ok=1
XS4_5_0 n3_10 bb4 n4_5 vss sg13_hv_nmos w=0.5u l=0.45u ng=1 m=1 mm_ok=1
XS4_5_1 n3_11 b4 n4_5 vss sg13_hv_nmos w=0.5u l=0.45u ng=1 m=1 mm_ok=1
XS4_6_0 n3_12 bb4 n4_6 vss sg13_hv_nmos w=0.5u l=0.45u ng=1 m=1 mm_ok=1
XS4_6_1 n3_13 b4 n4_6 vss sg13_hv_nmos w=0.5u l=0.45u ng=1 m=1 mm_ok=1
XS4_7_0 n3_14 bb4 n4_7 vss sg13_hv_nmos w=0.5u l=0.45u ng=1 m=1 mm_ok=1
XS4_7_1 n3_15 b4 n4_7 vss sg13_hv_nmos w=0.5u l=0.45u ng=1 m=1 mm_ok=1
XS5_0_0 n4_0 bb5 n5_0 vss sg13_hv_nmos w=0.5u l=0.45u ng=1 m=1 mm_ok=1
XS5_0_1 n4_1 b5 n5_0 vss sg13_hv_nmos w=0.5u l=0.45u ng=1 m=1 mm_ok=1
XS5_1_0 n4_2 bb5 n5_1 vss sg13_hv_nmos w=0.5u l=0.45u ng=1 m=1 mm_ok=1
XS5_1_1 n4_3 b5 n5_1 vss sg13_hv_nmos w=0.5u l=0.45u ng=1 m=1 mm_ok=1
XS5_2_0 n4_4 bb5 n5_2 vss sg13_hv_nmos w=0.5u l=0.45u ng=1 m=1 mm_ok=1
XS5_2_1 n4_5 b5 n5_2 vss sg13_hv_nmos w=0.5u l=0.45u ng=1 m=1 mm_ok=1
XS5_3_0 n4_6 bb5 n5_3 vss sg13_hv_nmos w=0.5u l=0.45u ng=1 m=1 mm_ok=1
XS5_3_1 n4_7 b5 n5_3 vss sg13_hv_nmos w=0.5u l=0.45u ng=1 m=1 mm_ok=1
XS6_0_0 n5_0 bb6 n6_0 vss sg13_hv_nmos w=0.5u l=0.45u ng=1 m=1 mm_ok=1
XS6_0_1 n5_1 b6 n6_0 vss sg13_hv_nmos w=0.5u l=0.45u ng=1 m=1 mm_ok=1
XS6_1_0 n5_2 bb6 n6_1 vss sg13_hv_nmos w=0.5u l=0.45u ng=1 m=1 mm_ok=1
XS6_1_1 n5_3 b6 n6_1 vss sg13_hv_nmos w=0.5u l=0.45u ng=1 m=1 mm_ok=1
XS7_0_0 n6_0 bb7 out vss sg13_hv_nmos w=0.5u l=0.45u ng=1 m=1 mm_ok=1
XS7_0_1 n6_1 b7 out vss sg13_hv_nmos w=0.5u l=0.45u ng=1 m=1 mm_ok=1
.ends r1_safe_mux

.subckt r1_safe_string vref t0 t1 t2 t3 t4 t5 t6 t7 t8 t9 t10 t11 t12 t13 t14 t15 t16 t17 t18 t19 t20 t21 t22 t23 t24 t25 t26 t27 t28 t29 t30 t31 t32 t33 t34 t35 t36 t37 t38 t39 t40 t41 t42 t43 t44 t45 t46 t47 t48 t49 t50 t51 t52 t53 t54 t55 t56 t57 t58 t59 t60 t61 t62 t63 t64 t65 t66 t67 t68 t69 t70 t71 t72 t73 t74 t75 t76 t77 t78 t79 t80 t81 t82 t83 t84 t85 t86 t87 t88 t89 t90 t91 t92 t93 t94 t95 t96 t97 t98 t99 t100 t101 t102 t103 t104 t105 t106 t107 t108 t109 t110 t111 t112 t113 t114 t115 t116 t117 t118 t119 t120 t121 t122 t123 t124 t125 t126 t127 t128 t129 t130 t131 t132 t133 t134 t135 t136 t137 t138 t139 t140 t141 t142 t143 t144 t145 t146 t147 t148 t149 t150 t151 t152 t153 t154 t155 t156 t157 t158 t159 t160 t161 t162 t163 t164 t165 t166 t167 t168 t169 t170 t171 t172 t173 t174 t175 t176 t177 t178 t179 t180 t181 t182 t183 t184 t185 t186 t187 t188 t189 t190 t191 t192 t193 t194 t195 t196 t197 t198 t199 t200 t201 t202 t203 t204 t205 t206 t207 t208 t209 t210 t211 t212 t213 t214 t215 t216 t217 t218 t219 t220 t221 t222 t223 t224 t225 t226 t227 t228 t229 t230 t231 t232 t233 t234 t235 t236 t237 t238 t239 t240 t241 t242 t243 t244 t245 t246 t247 t248 t249 t250 t251 t252 vss
* 252 rppd units of 1000 Ohm between VREF (T252) and VSS (T0); 4.2 uA at 1.05 V
XRS0 t1 t0 vss rppd w=2u l=7.7u m=1 b=0 mm_ok=1
XRS1 t2 t1 vss rppd w=2u l=7.7u m=1 b=0 mm_ok=1
XRS2 t3 t2 vss rppd w=2u l=7.7u m=1 b=0 mm_ok=1
XRS3 t4 t3 vss rppd w=2u l=7.7u m=1 b=0 mm_ok=1
XRS4 t5 t4 vss rppd w=2u l=7.7u m=1 b=0 mm_ok=1
XRS5 t6 t5 vss rppd w=2u l=7.7u m=1 b=0 mm_ok=1
XRS6 t7 t6 vss rppd w=2u l=7.7u m=1 b=0 mm_ok=1
XRS7 t8 t7 vss rppd w=2u l=7.7u m=1 b=0 mm_ok=1
XRS8 t9 t8 vss rppd w=2u l=7.7u m=1 b=0 mm_ok=1
XRS9 t10 t9 vss rppd w=2u l=7.7u m=1 b=0 mm_ok=1
XRS10 t11 t10 vss rppd w=2u l=7.7u m=1 b=0 mm_ok=1
XRS11 t12 t11 vss rppd w=2u l=7.7u m=1 b=0 mm_ok=1
XRS12 t13 t12 vss rppd w=2u l=7.7u m=1 b=0 mm_ok=1
XRS13 t14 t13 vss rppd w=2u l=7.7u m=1 b=0 mm_ok=1
XRS14 t15 t14 vss rppd w=2u l=7.7u m=1 b=0 mm_ok=1
XRS15 t16 t15 vss rppd w=2u l=7.7u m=1 b=0 mm_ok=1
XRS16 t17 t16 vss rppd w=2u l=7.7u m=1 b=0 mm_ok=1
XRS17 t18 t17 vss rppd w=2u l=7.7u m=1 b=0 mm_ok=1
XRS18 t19 t18 vss rppd w=2u l=7.7u m=1 b=0 mm_ok=1
XRS19 t20 t19 vss rppd w=2u l=7.7u m=1 b=0 mm_ok=1
XRS20 t21 t20 vss rppd w=2u l=7.7u m=1 b=0 mm_ok=1
XRS21 t22 t21 vss rppd w=2u l=7.7u m=1 b=0 mm_ok=1
XRS22 t23 t22 vss rppd w=2u l=7.7u m=1 b=0 mm_ok=1
XRS23 t24 t23 vss rppd w=2u l=7.7u m=1 b=0 mm_ok=1
XRS24 t25 t24 vss rppd w=2u l=7.7u m=1 b=0 mm_ok=1
XRS25 t26 t25 vss rppd w=2u l=7.7u m=1 b=0 mm_ok=1
XRS26 t27 t26 vss rppd w=2u l=7.7u m=1 b=0 mm_ok=1
XRS27 t28 t27 vss rppd w=2u l=7.7u m=1 b=0 mm_ok=1
XRS28 t29 t28 vss rppd w=2u l=7.7u m=1 b=0 mm_ok=1
XRS29 t30 t29 vss rppd w=2u l=7.7u m=1 b=0 mm_ok=1
XRS30 t31 t30 vss rppd w=2u l=7.7u m=1 b=0 mm_ok=1
XRS31 t32 t31 vss rppd w=2u l=7.7u m=1 b=0 mm_ok=1
XRS32 t33 t32 vss rppd w=2u l=7.7u m=1 b=0 mm_ok=1
XRS33 t34 t33 vss rppd w=2u l=7.7u m=1 b=0 mm_ok=1
XRS34 t35 t34 vss rppd w=2u l=7.7u m=1 b=0 mm_ok=1
XRS35 t36 t35 vss rppd w=2u l=7.7u m=1 b=0 mm_ok=1
XRS36 t37 t36 vss rppd w=2u l=7.7u m=1 b=0 mm_ok=1
XRS37 t38 t37 vss rppd w=2u l=7.7u m=1 b=0 mm_ok=1
XRS38 t39 t38 vss rppd w=2u l=7.7u m=1 b=0 mm_ok=1
XRS39 t40 t39 vss rppd w=2u l=7.7u m=1 b=0 mm_ok=1
XRS40 t41 t40 vss rppd w=2u l=7.7u m=1 b=0 mm_ok=1
XRS41 t42 t41 vss rppd w=2u l=7.7u m=1 b=0 mm_ok=1
XRS42 t43 t42 vss rppd w=2u l=7.7u m=1 b=0 mm_ok=1
XRS43 t44 t43 vss rppd w=2u l=7.7u m=1 b=0 mm_ok=1
XRS44 t45 t44 vss rppd w=2u l=7.7u m=1 b=0 mm_ok=1
XRS45 t46 t45 vss rppd w=2u l=7.7u m=1 b=0 mm_ok=1
XRS46 t47 t46 vss rppd w=2u l=7.7u m=1 b=0 mm_ok=1
XRS47 t48 t47 vss rppd w=2u l=7.7u m=1 b=0 mm_ok=1
XRS48 t49 t48 vss rppd w=2u l=7.7u m=1 b=0 mm_ok=1
XRS49 t50 t49 vss rppd w=2u l=7.7u m=1 b=0 mm_ok=1
XRS50 t51 t50 vss rppd w=2u l=7.7u m=1 b=0 mm_ok=1
XRS51 t52 t51 vss rppd w=2u l=7.7u m=1 b=0 mm_ok=1
XRS52 t53 t52 vss rppd w=2u l=7.7u m=1 b=0 mm_ok=1
XRS53 t54 t53 vss rppd w=2u l=7.7u m=1 b=0 mm_ok=1
XRS54 t55 t54 vss rppd w=2u l=7.7u m=1 b=0 mm_ok=1
XRS55 t56 t55 vss rppd w=2u l=7.7u m=1 b=0 mm_ok=1
XRS56 t57 t56 vss rppd w=2u l=7.7u m=1 b=0 mm_ok=1
XRS57 t58 t57 vss rppd w=2u l=7.7u m=1 b=0 mm_ok=1
XRS58 t59 t58 vss rppd w=2u l=7.7u m=1 b=0 mm_ok=1
XRS59 t60 t59 vss rppd w=2u l=7.7u m=1 b=0 mm_ok=1
XRS60 t61 t60 vss rppd w=2u l=7.7u m=1 b=0 mm_ok=1
XRS61 t62 t61 vss rppd w=2u l=7.7u m=1 b=0 mm_ok=1
XRS62 t63 t62 vss rppd w=2u l=7.7u m=1 b=0 mm_ok=1
XRS63 t64 t63 vss rppd w=2u l=7.7u m=1 b=0 mm_ok=1
XRS64 t65 t64 vss rppd w=2u l=7.7u m=1 b=0 mm_ok=1
XRS65 t66 t65 vss rppd w=2u l=7.7u m=1 b=0 mm_ok=1
XRS66 t67 t66 vss rppd w=2u l=7.7u m=1 b=0 mm_ok=1
XRS67 t68 t67 vss rppd w=2u l=7.7u m=1 b=0 mm_ok=1
XRS68 t69 t68 vss rppd w=2u l=7.7u m=1 b=0 mm_ok=1
XRS69 t70 t69 vss rppd w=2u l=7.7u m=1 b=0 mm_ok=1
XRS70 t71 t70 vss rppd w=2u l=7.7u m=1 b=0 mm_ok=1
XRS71 t72 t71 vss rppd w=2u l=7.7u m=1 b=0 mm_ok=1
XRS72 t73 t72 vss rppd w=2u l=7.7u m=1 b=0 mm_ok=1
XRS73 t74 t73 vss rppd w=2u l=7.7u m=1 b=0 mm_ok=1
XRS74 t75 t74 vss rppd w=2u l=7.7u m=1 b=0 mm_ok=1
XRS75 t76 t75 vss rppd w=2u l=7.7u m=1 b=0 mm_ok=1
XRS76 t77 t76 vss rppd w=2u l=7.7u m=1 b=0 mm_ok=1
XRS77 t78 t77 vss rppd w=2u l=7.7u m=1 b=0 mm_ok=1
XRS78 t79 t78 vss rppd w=2u l=7.7u m=1 b=0 mm_ok=1
XRS79 t80 t79 vss rppd w=2u l=7.7u m=1 b=0 mm_ok=1
XRS80 t81 t80 vss rppd w=2u l=7.7u m=1 b=0 mm_ok=1
XRS81 t82 t81 vss rppd w=2u l=7.7u m=1 b=0 mm_ok=1
XRS82 t83 t82 vss rppd w=2u l=7.7u m=1 b=0 mm_ok=1
XRS83 t84 t83 vss rppd w=2u l=7.7u m=1 b=0 mm_ok=1
XRS84 t85 t84 vss rppd w=2u l=7.7u m=1 b=0 mm_ok=1
XRS85 t86 t85 vss rppd w=2u l=7.7u m=1 b=0 mm_ok=1
XRS86 t87 t86 vss rppd w=2u l=7.7u m=1 b=0 mm_ok=1
XRS87 t88 t87 vss rppd w=2u l=7.7u m=1 b=0 mm_ok=1
XRS88 t89 t88 vss rppd w=2u l=7.7u m=1 b=0 mm_ok=1
XRS89 t90 t89 vss rppd w=2u l=7.7u m=1 b=0 mm_ok=1
XRS90 t91 t90 vss rppd w=2u l=7.7u m=1 b=0 mm_ok=1
XRS91 t92 t91 vss rppd w=2u l=7.7u m=1 b=0 mm_ok=1
XRS92 t93 t92 vss rppd w=2u l=7.7u m=1 b=0 mm_ok=1
XRS93 t94 t93 vss rppd w=2u l=7.7u m=1 b=0 mm_ok=1
XRS94 t95 t94 vss rppd w=2u l=7.7u m=1 b=0 mm_ok=1
XRS95 t96 t95 vss rppd w=2u l=7.7u m=1 b=0 mm_ok=1
XRS96 t97 t96 vss rppd w=2u l=7.7u m=1 b=0 mm_ok=1
XRS97 t98 t97 vss rppd w=2u l=7.7u m=1 b=0 mm_ok=1
XRS98 t99 t98 vss rppd w=2u l=7.7u m=1 b=0 mm_ok=1
XRS99 t100 t99 vss rppd w=2u l=7.7u m=1 b=0 mm_ok=1
XRS100 t101 t100 vss rppd w=2u l=7.7u m=1 b=0 mm_ok=1
XRS101 t102 t101 vss rppd w=2u l=7.7u m=1 b=0 mm_ok=1
XRS102 t103 t102 vss rppd w=2u l=7.7u m=1 b=0 mm_ok=1
XRS103 t104 t103 vss rppd w=2u l=7.7u m=1 b=0 mm_ok=1
XRS104 t105 t104 vss rppd w=2u l=7.7u m=1 b=0 mm_ok=1
XRS105 t106 t105 vss rppd w=2u l=7.7u m=1 b=0 mm_ok=1
XRS106 t107 t106 vss rppd w=2u l=7.7u m=1 b=0 mm_ok=1
XRS107 t108 t107 vss rppd w=2u l=7.7u m=1 b=0 mm_ok=1
XRS108 t109 t108 vss rppd w=2u l=7.7u m=1 b=0 mm_ok=1
XRS109 t110 t109 vss rppd w=2u l=7.7u m=1 b=0 mm_ok=1
XRS110 t111 t110 vss rppd w=2u l=7.7u m=1 b=0 mm_ok=1
XRS111 t112 t111 vss rppd w=2u l=7.7u m=1 b=0 mm_ok=1
XRS112 t113 t112 vss rppd w=2u l=7.7u m=1 b=0 mm_ok=1
XRS113 t114 t113 vss rppd w=2u l=7.7u m=1 b=0 mm_ok=1
XRS114 t115 t114 vss rppd w=2u l=7.7u m=1 b=0 mm_ok=1
XRS115 t116 t115 vss rppd w=2u l=7.7u m=1 b=0 mm_ok=1
XRS116 t117 t116 vss rppd w=2u l=7.7u m=1 b=0 mm_ok=1
XRS117 t118 t117 vss rppd w=2u l=7.7u m=1 b=0 mm_ok=1
XRS118 t119 t118 vss rppd w=2u l=7.7u m=1 b=0 mm_ok=1
XRS119 t120 t119 vss rppd w=2u l=7.7u m=1 b=0 mm_ok=1
XRS120 t121 t120 vss rppd w=2u l=7.7u m=1 b=0 mm_ok=1
XRS121 t122 t121 vss rppd w=2u l=7.7u m=1 b=0 mm_ok=1
XRS122 t123 t122 vss rppd w=2u l=7.7u m=1 b=0 mm_ok=1
XRS123 t124 t123 vss rppd w=2u l=7.7u m=1 b=0 mm_ok=1
XRS124 t125 t124 vss rppd w=2u l=7.7u m=1 b=0 mm_ok=1
XRS125 t126 t125 vss rppd w=2u l=7.7u m=1 b=0 mm_ok=1
XRS126 t127 t126 vss rppd w=2u l=7.7u m=1 b=0 mm_ok=1
XRS127 t128 t127 vss rppd w=2u l=7.7u m=1 b=0 mm_ok=1
XRS128 t129 t128 vss rppd w=2u l=7.7u m=1 b=0 mm_ok=1
XRS129 t130 t129 vss rppd w=2u l=7.7u m=1 b=0 mm_ok=1
XRS130 t131 t130 vss rppd w=2u l=7.7u m=1 b=0 mm_ok=1
XRS131 t132 t131 vss rppd w=2u l=7.7u m=1 b=0 mm_ok=1
XRS132 t133 t132 vss rppd w=2u l=7.7u m=1 b=0 mm_ok=1
XRS133 t134 t133 vss rppd w=2u l=7.7u m=1 b=0 mm_ok=1
XRS134 t135 t134 vss rppd w=2u l=7.7u m=1 b=0 mm_ok=1
XRS135 t136 t135 vss rppd w=2u l=7.7u m=1 b=0 mm_ok=1
XRS136 t137 t136 vss rppd w=2u l=7.7u m=1 b=0 mm_ok=1
XRS137 t138 t137 vss rppd w=2u l=7.7u m=1 b=0 mm_ok=1
XRS138 t139 t138 vss rppd w=2u l=7.7u m=1 b=0 mm_ok=1
XRS139 t140 t139 vss rppd w=2u l=7.7u m=1 b=0 mm_ok=1
XRS140 t141 t140 vss rppd w=2u l=7.7u m=1 b=0 mm_ok=1
XRS141 t142 t141 vss rppd w=2u l=7.7u m=1 b=0 mm_ok=1
XRS142 t143 t142 vss rppd w=2u l=7.7u m=1 b=0 mm_ok=1
XRS143 t144 t143 vss rppd w=2u l=7.7u m=1 b=0 mm_ok=1
XRS144 t145 t144 vss rppd w=2u l=7.7u m=1 b=0 mm_ok=1
XRS145 t146 t145 vss rppd w=2u l=7.7u m=1 b=0 mm_ok=1
XRS146 t147 t146 vss rppd w=2u l=7.7u m=1 b=0 mm_ok=1
XRS147 t148 t147 vss rppd w=2u l=7.7u m=1 b=0 mm_ok=1
XRS148 t149 t148 vss rppd w=2u l=7.7u m=1 b=0 mm_ok=1
XRS149 t150 t149 vss rppd w=2u l=7.7u m=1 b=0 mm_ok=1
XRS150 t151 t150 vss rppd w=2u l=7.7u m=1 b=0 mm_ok=1
XRS151 t152 t151 vss rppd w=2u l=7.7u m=1 b=0 mm_ok=1
XRS152 t153 t152 vss rppd w=2u l=7.7u m=1 b=0 mm_ok=1
XRS153 t154 t153 vss rppd w=2u l=7.7u m=1 b=0 mm_ok=1
XRS154 t155 t154 vss rppd w=2u l=7.7u m=1 b=0 mm_ok=1
XRS155 t156 t155 vss rppd w=2u l=7.7u m=1 b=0 mm_ok=1
XRS156 t157 t156 vss rppd w=2u l=7.7u m=1 b=0 mm_ok=1
XRS157 t158 t157 vss rppd w=2u l=7.7u m=1 b=0 mm_ok=1
XRS158 t159 t158 vss rppd w=2u l=7.7u m=1 b=0 mm_ok=1
XRS159 t160 t159 vss rppd w=2u l=7.7u m=1 b=0 mm_ok=1
XRS160 t161 t160 vss rppd w=2u l=7.7u m=1 b=0 mm_ok=1
XRS161 t162 t161 vss rppd w=2u l=7.7u m=1 b=0 mm_ok=1
XRS162 t163 t162 vss rppd w=2u l=7.7u m=1 b=0 mm_ok=1
XRS163 t164 t163 vss rppd w=2u l=7.7u m=1 b=0 mm_ok=1
XRS164 t165 t164 vss rppd w=2u l=7.7u m=1 b=0 mm_ok=1
XRS165 t166 t165 vss rppd w=2u l=7.7u m=1 b=0 mm_ok=1
XRS166 t167 t166 vss rppd w=2u l=7.7u m=1 b=0 mm_ok=1
XRS167 t168 t167 vss rppd w=2u l=7.7u m=1 b=0 mm_ok=1
XRS168 t169 t168 vss rppd w=2u l=7.7u m=1 b=0 mm_ok=1
XRS169 t170 t169 vss rppd w=2u l=7.7u m=1 b=0 mm_ok=1
XRS170 t171 t170 vss rppd w=2u l=7.7u m=1 b=0 mm_ok=1
XRS171 t172 t171 vss rppd w=2u l=7.7u m=1 b=0 mm_ok=1
XRS172 t173 t172 vss rppd w=2u l=7.7u m=1 b=0 mm_ok=1
XRS173 t174 t173 vss rppd w=2u l=7.7u m=1 b=0 mm_ok=1
XRS174 t175 t174 vss rppd w=2u l=7.7u m=1 b=0 mm_ok=1
XRS175 t176 t175 vss rppd w=2u l=7.7u m=1 b=0 mm_ok=1
XRS176 t177 t176 vss rppd w=2u l=7.7u m=1 b=0 mm_ok=1
XRS177 t178 t177 vss rppd w=2u l=7.7u m=1 b=0 mm_ok=1
XRS178 t179 t178 vss rppd w=2u l=7.7u m=1 b=0 mm_ok=1
XRS179 t180 t179 vss rppd w=2u l=7.7u m=1 b=0 mm_ok=1
XRS180 t181 t180 vss rppd w=2u l=7.7u m=1 b=0 mm_ok=1
XRS181 t182 t181 vss rppd w=2u l=7.7u m=1 b=0 mm_ok=1
XRS182 t183 t182 vss rppd w=2u l=7.7u m=1 b=0 mm_ok=1
XRS183 t184 t183 vss rppd w=2u l=7.7u m=1 b=0 mm_ok=1
XRS184 t185 t184 vss rppd w=2u l=7.7u m=1 b=0 mm_ok=1
XRS185 t186 t185 vss rppd w=2u l=7.7u m=1 b=0 mm_ok=1
XRS186 t187 t186 vss rppd w=2u l=7.7u m=1 b=0 mm_ok=1
XRS187 t188 t187 vss rppd w=2u l=7.7u m=1 b=0 mm_ok=1
XRS188 t189 t188 vss rppd w=2u l=7.7u m=1 b=0 mm_ok=1
XRS189 t190 t189 vss rppd w=2u l=7.7u m=1 b=0 mm_ok=1
XRS190 t191 t190 vss rppd w=2u l=7.7u m=1 b=0 mm_ok=1
XRS191 t192 t191 vss rppd w=2u l=7.7u m=1 b=0 mm_ok=1
XRS192 t193 t192 vss rppd w=2u l=7.7u m=1 b=0 mm_ok=1
XRS193 t194 t193 vss rppd w=2u l=7.7u m=1 b=0 mm_ok=1
XRS194 t195 t194 vss rppd w=2u l=7.7u m=1 b=0 mm_ok=1
XRS195 t196 t195 vss rppd w=2u l=7.7u m=1 b=0 mm_ok=1
XRS196 t197 t196 vss rppd w=2u l=7.7u m=1 b=0 mm_ok=1
XRS197 t198 t197 vss rppd w=2u l=7.7u m=1 b=0 mm_ok=1
XRS198 t199 t198 vss rppd w=2u l=7.7u m=1 b=0 mm_ok=1
XRS199 t200 t199 vss rppd w=2u l=7.7u m=1 b=0 mm_ok=1
XRS200 t201 t200 vss rppd w=2u l=7.7u m=1 b=0 mm_ok=1
XRS201 t202 t201 vss rppd w=2u l=7.7u m=1 b=0 mm_ok=1
XRS202 t203 t202 vss rppd w=2u l=7.7u m=1 b=0 mm_ok=1
XRS203 t204 t203 vss rppd w=2u l=7.7u m=1 b=0 mm_ok=1
XRS204 t205 t204 vss rppd w=2u l=7.7u m=1 b=0 mm_ok=1
XRS205 t206 t205 vss rppd w=2u l=7.7u m=1 b=0 mm_ok=1
XRS206 t207 t206 vss rppd w=2u l=7.7u m=1 b=0 mm_ok=1
XRS207 t208 t207 vss rppd w=2u l=7.7u m=1 b=0 mm_ok=1
XRS208 t209 t208 vss rppd w=2u l=7.7u m=1 b=0 mm_ok=1
XRS209 t210 t209 vss rppd w=2u l=7.7u m=1 b=0 mm_ok=1
XRS210 t211 t210 vss rppd w=2u l=7.7u m=1 b=0 mm_ok=1
XRS211 t212 t211 vss rppd w=2u l=7.7u m=1 b=0 mm_ok=1
XRS212 t213 t212 vss rppd w=2u l=7.7u m=1 b=0 mm_ok=1
XRS213 t214 t213 vss rppd w=2u l=7.7u m=1 b=0 mm_ok=1
XRS214 t215 t214 vss rppd w=2u l=7.7u m=1 b=0 mm_ok=1
XRS215 t216 t215 vss rppd w=2u l=7.7u m=1 b=0 mm_ok=1
XRS216 t217 t216 vss rppd w=2u l=7.7u m=1 b=0 mm_ok=1
XRS217 t218 t217 vss rppd w=2u l=7.7u m=1 b=0 mm_ok=1
XRS218 t219 t218 vss rppd w=2u l=7.7u m=1 b=0 mm_ok=1
XRS219 t220 t219 vss rppd w=2u l=7.7u m=1 b=0 mm_ok=1
XRS220 t221 t220 vss rppd w=2u l=7.7u m=1 b=0 mm_ok=1
XRS221 t222 t221 vss rppd w=2u l=7.7u m=1 b=0 mm_ok=1
XRS222 t223 t222 vss rppd w=2u l=7.7u m=1 b=0 mm_ok=1
XRS223 t224 t223 vss rppd w=2u l=7.7u m=1 b=0 mm_ok=1
XRS224 t225 t224 vss rppd w=2u l=7.7u m=1 b=0 mm_ok=1
XRS225 t226 t225 vss rppd w=2u l=7.7u m=1 b=0 mm_ok=1
XRS226 t227 t226 vss rppd w=2u l=7.7u m=1 b=0 mm_ok=1
XRS227 t228 t227 vss rppd w=2u l=7.7u m=1 b=0 mm_ok=1
XRS228 t229 t228 vss rppd w=2u l=7.7u m=1 b=0 mm_ok=1
XRS229 t230 t229 vss rppd w=2u l=7.7u m=1 b=0 mm_ok=1
XRS230 t231 t230 vss rppd w=2u l=7.7u m=1 b=0 mm_ok=1
XRS231 t232 t231 vss rppd w=2u l=7.7u m=1 b=0 mm_ok=1
XRS232 t233 t232 vss rppd w=2u l=7.7u m=1 b=0 mm_ok=1
XRS233 t234 t233 vss rppd w=2u l=7.7u m=1 b=0 mm_ok=1
XRS234 t235 t234 vss rppd w=2u l=7.7u m=1 b=0 mm_ok=1
XRS235 t236 t235 vss rppd w=2u l=7.7u m=1 b=0 mm_ok=1
XRS236 t237 t236 vss rppd w=2u l=7.7u m=1 b=0 mm_ok=1
XRS237 t238 t237 vss rppd w=2u l=7.7u m=1 b=0 mm_ok=1
XRS238 t239 t238 vss rppd w=2u l=7.7u m=1 b=0 mm_ok=1
XRS239 t240 t239 vss rppd w=2u l=7.7u m=1 b=0 mm_ok=1
XRS240 t241 t240 vss rppd w=2u l=7.7u m=1 b=0 mm_ok=1
XRS241 t242 t241 vss rppd w=2u l=7.7u m=1 b=0 mm_ok=1
XRS242 t243 t242 vss rppd w=2u l=7.7u m=1 b=0 mm_ok=1
XRS243 t244 t243 vss rppd w=2u l=7.7u m=1 b=0 mm_ok=1
XRS244 t245 t244 vss rppd w=2u l=7.7u m=1 b=0 mm_ok=1
XRS245 t246 t245 vss rppd w=2u l=7.7u m=1 b=0 mm_ok=1
XRS246 t247 t246 vss rppd w=2u l=7.7u m=1 b=0 mm_ok=1
XRS247 t248 t247 vss rppd w=2u l=7.7u m=1 b=0 mm_ok=1
XRS248 t249 t248 vss rppd w=2u l=7.7u m=1 b=0 mm_ok=1
XRS249 t250 t249 vss rppd w=2u l=7.7u m=1 b=0 mm_ok=1
XRS250 t251 t250 vss rppd w=2u l=7.7u m=1 b=0 mm_ok=1
XRS251 t252 t251 vss rppd w=2u l=7.7u m=1 b=0 mm_ok=1
Rt252 t252 vref 1e-3
Rt0 t0 vss 1e-3
.ends r1_safe_string

.subckt r1_safe_cmp inp inn refp refn out ibias vdda vdd vss
* ibias: 5 uA sunk into the pin (from r1_bgr PTAT branch; ideal source in this step)
XMBN ibias ibias vss vss sg13_hv_nmos w=4u l=1u ng=1 m=1 mm_ok=1
XMB2 vbp ibias vss vss sg13_hv_nmos w=4u l=1u ng=1 m=1 mm_ok=1
XMBP vbp vbp vdda vdda sg13_hv_pmos w=4u l=2u ng=1 m=1 mm_ok=1
* input pairs, 40 uA tails each
XMTA ta vbp vdda vdda sg13_hv_pmos w=4u l=2u ng=1 m=8 mm_ok=1
XMTB tb vbp vdda vdda sg13_hv_pmos w=4u l=2u ng=1 m=8 mm_ok=1
* each pair is source-degenerated (rhigh per side) so that it stays linear over the full +-1.05 V input range:
* without degeneration both pairs saturate for |Vth| > about 0.1 V and the comparison fails (run safe-cmp-20261020-r1).
XMA1 d1 inp sa1 ta sg13_hv_pmos w=20u l=2u ng=4 m=1 mm_ok=1
XMA2 d2 inn sa2 ta sg13_hv_pmos w=20u l=2u ng=4 m=1 mm_ok=1
XRA1 ta sa1 vss rhigh w=1u l=30u m=1 b=0 mm_ok=1
XRA2 ta sa2 vss rhigh w=1u l=30u m=1 b=0 mm_ok=1
XMB1 d1 refn sb1 tb sg13_hv_pmos w=20u l=2u ng=4 m=1 mm_ok=1
XMB2I d2 refp sb2 tb sg13_hv_pmos w=20u l=2u ng=4 m=1 mm_ok=1
XRB1 tb sb1 vss rhigh w=1u l=30u m=1 b=0 mm_ok=1
XRB2 tb sb2 vss rhigh w=1u l=30u m=1 b=0 mm_ok=1
* NMOS mirror load: d1 diode, d2 output (d2 rises when (inp-inn) > (refp-refn))
XML1 d1 d1 vss vss sg13_hv_nmos w=40u l=10u ng=1 m=1 mm_ok=1
XML2 d2 d1 vss vss sg13_hv_nmos w=40u l=10u ng=1 m=1 mm_ok=1
* gain stage: NMOS common source, PMOS source 10 uA
XMG o1 d2 vss vss sg13_hv_nmos w=2u l=2u ng=1 m=1 mm_ok=1
XMGL o1 vbp vdda vdda sg13_hv_pmos w=4u l=2u ng=1 m=2 mm_ok=1
* inverter (3.3 V): o2 high when tripped
XMI1P o2 o1 vdda vdda sg13_hv_pmos w=2u l=0.5u ng=1 m=1 mm_ok=1
XMI1N o2 o1 vss vss sg13_hv_nmos w=1u l=0.45u ng=1 m=1 mm_ok=1
* hysteresis: a small current steered into d2 while tripped (o1 low) and into d1 otherwise (o2 low);
* steering (not switching off) keeps node hs driven at all times
XMH1a hn1 vbp vdda vdda sg13_hv_pmos w=0.5u l=8u ng=1 m=1 mm_ok=1
XMH1b hn2 vbp hn1 vdda sg13_hv_pmos w=0.5u l=8u ng=1 m=1 mm_ok=1
XMH1c hs vbp hn2 vdda sg13_hv_pmos w=0.5u l=8u ng=1 m=1 mm_ok=1
XMH2 d2 o1 hs vdda sg13_hv_pmos w=1u l=0.5u ng=1 m=1 mm_ok=1
XMH3 d1 o2 hs vdda sg13_hv_pmos w=1u l=0.5u ng=1 m=1 mm_ok=1
* down-shift to 1.2 V: thick-input inverter on VDD, then thin inverter
XMD1P o3 o2 vdd vdd sg13_hv_pmos w=2u l=0.5u ng=1 m=1 mm_ok=1
XMD1N o3 o2 vss vss sg13_hv_nmos w=1u l=0.45u ng=1 m=1 mm_ok=1
XMD2P out o3 vdd vdd sg13_lv_pmos w=1u l=0.13u ng=1 m=1 mm_ok=1
XMD2N out o3 vss vss sg13_lv_nmos w=0.5u l=0.13u ng=1 m=1 mm_ok=1
.ends r1_safe_cmp

.subckt r1_safe_thr inp inn t0 t1 t2 t3 t4 t5 t6 t7 t8 t9 t10 t11 t12 t13 t14 t15 t16 t17 t18 t19 t20 t21 t22 t23 t24 t25 t26 t27 t28 t29 t30 t31 t32 t33 t34 t35 t36 t37 t38 t39 t40 t41 t42 t43 t44 t45 t46 t47 t48 t49 t50 t51 t52 t53 t54 t55 t56 t57 t58 t59 t60 t61 t62 t63 t64 t65 t66 t67 t68 t69 t70 t71 t72 t73 t74 t75 t76 t77 t78 t79 t80 t81 t82 t83 t84 t85 t86 t87 t88 t89 t90 t91 t92 t93 t94 t95 t96 t97 t98 t99 t100 t101 t102 t103 t104 t105 t106 t107 t108 t109 t110 t111 t112 t113 t114 t115 t116 t117 t118 t119 t120 t121 t122 t123 t124 t125 t126 t127 t128 t129 t130 t131 t132 t133 t134 t135 t136 t137 t138 t139 t140 t141 t142 t143 t144 t145 t146 t147 t148 t149 t150 t151 t152 t153 t154 t155 t156 t157 t158 t159 t160 t161 t162 t163 t164 t165 t166 t167 t168 t169 t170 t171 t172 t173 t174 t175 t176 t177 t178 t179 t180 t181 t182 t183 t184 t185 t186 t187 t188 t189 t190 t191 t192 t193 t194 t195 t196 t197 t198 t199 t200 t201 t202 t203 t204 t205 t206 t207 t208 t209 t210 t211 t212 t213 t214 t215 t216 t217 t218 t219 t220 t221 t222 t223 t224 t225 t226 t227 t228 t229 t230 t231 t232 t233 t234 t235 t236 t237 t238 t239 t240 t241 t242 t243 t244 t245 t246 t247 t248 t249 t250 t251 t252 p0 p1 p2 p3 p4 p5 p6 p7 n0 n1 n2 n3 n4 n5 n6 n7 out ibias vdda vdd vss
* one comparator + its threshold DAC: REFP = T(nP), REFN = T(nN); p*/n* = 1.2 V code bits (summed codes)
XLSP0 p0 vdd vdda vss bp0 bbp0 r1_safe_ls
XLSN0 n0 vdd vdda vss bn0 bbn0 r1_safe_ls
XLSP1 p1 vdd vdda vss bp1 bbp1 r1_safe_ls
XLSN1 n1 vdd vdda vss bn1 bbn1 r1_safe_ls
XLSP2 p2 vdd vdda vss bp2 bbp2 r1_safe_ls
XLSN2 n2 vdd vdda vss bn2 bbn2 r1_safe_ls
XLSP3 p3 vdd vdda vss bp3 bbp3 r1_safe_ls
XLSN3 n3 vdd vdda vss bn3 bbn3 r1_safe_ls
XLSP4 p4 vdd vdda vss bp4 bbp4 r1_safe_ls
XLSN4 n4 vdd vdda vss bn4 bbn4 r1_safe_ls
XLSP5 p5 vdd vdda vss bp5 bbp5 r1_safe_ls
XLSN5 n5 vdd vdda vss bn5 bbn5 r1_safe_ls
XLSP6 p6 vdd vdda vss bp6 bbp6 r1_safe_ls
XLSN6 n6 vdd vdda vss bn6 bbn6 r1_safe_ls
XLSP7 p7 vdd vdda vss bp7 bbp7 r1_safe_ls
XLSN7 n7 vdd vdda vss bn7 bbn7 r1_safe_ls
XMXP t0 t1 t2 t3 t4 t5 t6 t7 t8 t9 t10 t11 t12 t13 t14 t15 t16 t17 t18 t19 t20 t21 t22 t23 t24 t25 t26 t27 t28 t29 t30 t31 t32 t33 t34 t35 t36 t37 t38 t39 t40 t41 t42 t43 t44 t45 t46 t47 t48 t49 t50 t51 t52 t53 t54 t55 t56 t57 t58 t59 t60 t61 t62 t63 t64 t65 t66 t67 t68 t69 t70 t71 t72 t73 t74 t75 t76 t77 t78 t79 t80 t81 t82 t83 t84 t85 t86 t87 t88 t89 t90 t91 t92 t93 t94 t95 t96 t97 t98 t99 t100 t101 t102 t103 t104 t105 t106 t107 t108 t109 t110 t111 t112 t113 t114 t115 t116 t117 t118 t119 t120 t121 t122 t123 t124 t125 t126 t127 t128 t129 t130 t131 t132 t133 t134 t135 t136 t137 t138 t139 t140 t141 t142 t143 t144 t145 t146 t147 t148 t149 t150 t151 t152 t153 t154 t155 t156 t157 t158 t159 t160 t161 t162 t163 t164 t165 t166 t167 t168 t169 t170 t171 t172 t173 t174 t175 t176 t177 t178 t179 t180 t181 t182 t183 t184 t185 t186 t187 t188 t189 t190 t191 t192 t193 t194 t195 t196 t197 t198 t199 t200 t201 t202 t203 t204 t205 t206 t207 t208 t209 t210 t211 t212 t213 t214 t215 t216 t217 t218 t219 t220 t221 t222 t223 t224 t225 t226 t227 t228 t229 t230 t231 t232 t233 t234 t235 t236 t237 t238 t239 t240 t241 t242 t243 t244 t245 t246 t247 t248 t249 t250 t251 t252 t252 t252 t252 bp0 bp1 bp2 bp3 bp4 bp5 bp6 bp7 bbp0 bbp1 bbp2 bbp3 bbp4 bbp5 bbp6 bbp7 refp vss r1_safe_mux
XMXN t0 t1 t2 t3 t4 t5 t6 t7 t8 t9 t10 t11 t12 t13 t14 t15 t16 t17 t18 t19 t20 t21 t22 t23 t24 t25 t26 t27 t28 t29 t30 t31 t32 t33 t34 t35 t36 t37 t38 t39 t40 t41 t42 t43 t44 t45 t46 t47 t48 t49 t50 t51 t52 t53 t54 t55 t56 t57 t58 t59 t60 t61 t62 t63 t64 t65 t66 t67 t68 t69 t70 t71 t72 t73 t74 t75 t76 t77 t78 t79 t80 t81 t82 t83 t84 t85 t86 t87 t88 t89 t90 t91 t92 t93 t94 t95 t96 t97 t98 t99 t100 t101 t102 t103 t104 t105 t106 t107 t108 t109 t110 t111 t112 t113 t114 t115 t116 t117 t118 t119 t120 t121 t122 t123 t124 t125 t126 t127 t128 t129 t130 t131 t132 t133 t134 t135 t136 t137 t138 t139 t140 t141 t142 t143 t144 t145 t146 t147 t148 t149 t150 t151 t152 t153 t154 t155 t156 t157 t158 t159 t160 t161 t162 t163 t164 t165 t166 t167 t168 t169 t170 t171 t172 t173 t174 t175 t176 t177 t178 t179 t180 t181 t182 t183 t184 t185 t186 t187 t188 t189 t190 t191 t192 t193 t194 t195 t196 t197 t198 t199 t200 t201 t202 t203 t204 t205 t206 t207 t208 t209 t210 t211 t212 t213 t214 t215 t216 t217 t218 t219 t220 t221 t222 t223 t224 t225 t226 t227 t228 t229 t230 t231 t232 t233 t234 t235 t236 t237 t238 t239 t240 t241 t242 t243 t244 t245 t246 t247 t248 t249 t250 t251 t252 t252 t252 t252 bn0 bn1 bn2 bn3 bn4 bn5 bn6 bn7 bbn0 bbn1 bbn2 bbn3 bbn4 bbn5 bbn6 bbn7 refn vss r1_safe_mux
XCMP inp inn refp refn out ibias vdda vdd vss r1_safe_cmp
.ends r1_safe_thr

.subckt r1_safe_an outa_p outa_n outb_p outb_n vref oa_p0 oa_p1 oa_p2 oa_p3 oa_p4 oa_p5 oa_p6 oa_p7 oa_n0 oa_n1 oa_n2 oa_n3 oa_n4 oa_n5 oa_n6 oa_n7 na_p0 na_p1 na_p2 na_p3 na_p4 na_p5 na_p6 na_p7 na_n0 na_n1 na_n2 na_n3 na_n4 na_n5 na_n6 na_n7 ob_p0 ob_p1 ob_p2 ob_p3 ob_p4 ob_p5 ob_p6 ob_p7 ob_n0 ob_n1 ob_n2 ob_n3 ob_n4 ob_n5 ob_n6 ob_n7 nb_p0 nb_p1 nb_p2 nb_p3 nb_p4 nb_p5 nb_p6 nb_p7 nb_n0 nb_n1 nb_n2 nb_n3 nb_n4 nb_n5 nb_n6 nb_n7 oc_a neg_a oc_b neg_b ibias_oa ibias_na ibias_ob ibias_nb vdda vdd vss
* oc_x high: Vod_x > Vth(thr_oc_x) (+ cal);  neg_x high: Vod_x < Vth(thr_neg_x) (- cal).  <c>_p*/<c>_n*: nP/nN, bit 0 = LSB.
XSTR vref t0 t1 t2 t3 t4 t5 t6 t7 t8 t9 t10 t11 t12 t13 t14 t15 t16 t17 t18 t19 t20 t21 t22 t23 t24 t25 t26 t27 t28 t29 t30 t31 t32 t33 t34 t35 t36 t37 t38 t39 t40 t41 t42 t43 t44 t45 t46 t47 t48 t49 t50 t51 t52 t53 t54 t55 t56 t57 t58 t59 t60 t61 t62 t63 t64 t65 t66 t67 t68 t69 t70 t71 t72 t73 t74 t75 t76 t77 t78 t79 t80 t81 t82 t83 t84 t85 t86 t87 t88 t89 t90 t91 t92 t93 t94 t95 t96 t97 t98 t99 t100 t101 t102 t103 t104 t105 t106 t107 t108 t109 t110 t111 t112 t113 t114 t115 t116 t117 t118 t119 t120 t121 t122 t123 t124 t125 t126 t127 t128 t129 t130 t131 t132 t133 t134 t135 t136 t137 t138 t139 t140 t141 t142 t143 t144 t145 t146 t147 t148 t149 t150 t151 t152 t153 t154 t155 t156 t157 t158 t159 t160 t161 t162 t163 t164 t165 t166 t167 t168 t169 t170 t171 t172 t173 t174 t175 t176 t177 t178 t179 t180 t181 t182 t183 t184 t185 t186 t187 t188 t189 t190 t191 t192 t193 t194 t195 t196 t197 t198 t199 t200 t201 t202 t203 t204 t205 t206 t207 t208 t209 t210 t211 t212 t213 t214 t215 t216 t217 t218 t219 t220 t221 t222 t223 t224 t225 t226 t227 t228 t229 t230 t231 t232 t233 t234 t235 t236 t237 t238 t239 t240 t241 t242 t243 t244 t245 t246 t247 t248 t249 t250 t251 t252 vss r1_safe_string
XOCa outa_p outa_n t0 t1 t2 t3 t4 t5 t6 t7 t8 t9 t10 t11 t12 t13 t14 t15 t16 t17 t18 t19 t20 t21 t22 t23 t24 t25 t26 t27 t28 t29 t30 t31 t32 t33 t34 t35 t36 t37 t38 t39 t40 t41 t42 t43 t44 t45 t46 t47 t48 t49 t50 t51 t52 t53 t54 t55 t56 t57 t58 t59 t60 t61 t62 t63 t64 t65 t66 t67 t68 t69 t70 t71 t72 t73 t74 t75 t76 t77 t78 t79 t80 t81 t82 t83 t84 t85 t86 t87 t88 t89 t90 t91 t92 t93 t94 t95 t96 t97 t98 t99 t100 t101 t102 t103 t104 t105 t106 t107 t108 t109 t110 t111 t112 t113 t114 t115 t116 t117 t118 t119 t120 t121 t122 t123 t124 t125 t126 t127 t128 t129 t130 t131 t132 t133 t134 t135 t136 t137 t138 t139 t140 t141 t142 t143 t144 t145 t146 t147 t148 t149 t150 t151 t152 t153 t154 t155 t156 t157 t158 t159 t160 t161 t162 t163 t164 t165 t166 t167 t168 t169 t170 t171 t172 t173 t174 t175 t176 t177 t178 t179 t180 t181 t182 t183 t184 t185 t186 t187 t188 t189 t190 t191 t192 t193 t194 t195 t196 t197 t198 t199 t200 t201 t202 t203 t204 t205 t206 t207 t208 t209 t210 t211 t212 t213 t214 t215 t216 t217 t218 t219 t220 t221 t222 t223 t224 t225 t226 t227 t228 t229 t230 t231 t232 t233 t234 t235 t236 t237 t238 t239 t240 t241 t242 t243 t244 t245 t246 t247 t248 t249 t250 t251 t252 oa_p0 oa_p1 oa_p2 oa_p3 oa_p4 oa_p5 oa_p6 oa_p7 oa_n0 oa_n1 oa_n2 oa_n3 oa_n4 oa_n5 oa_n6 oa_n7 oc_a ibias_oa vdda vdd vss r1_safe_thr
XNGa outa_n outa_p t0 t1 t2 t3 t4 t5 t6 t7 t8 t9 t10 t11 t12 t13 t14 t15 t16 t17 t18 t19 t20 t21 t22 t23 t24 t25 t26 t27 t28 t29 t30 t31 t32 t33 t34 t35 t36 t37 t38 t39 t40 t41 t42 t43 t44 t45 t46 t47 t48 t49 t50 t51 t52 t53 t54 t55 t56 t57 t58 t59 t60 t61 t62 t63 t64 t65 t66 t67 t68 t69 t70 t71 t72 t73 t74 t75 t76 t77 t78 t79 t80 t81 t82 t83 t84 t85 t86 t87 t88 t89 t90 t91 t92 t93 t94 t95 t96 t97 t98 t99 t100 t101 t102 t103 t104 t105 t106 t107 t108 t109 t110 t111 t112 t113 t114 t115 t116 t117 t118 t119 t120 t121 t122 t123 t124 t125 t126 t127 t128 t129 t130 t131 t132 t133 t134 t135 t136 t137 t138 t139 t140 t141 t142 t143 t144 t145 t146 t147 t148 t149 t150 t151 t152 t153 t154 t155 t156 t157 t158 t159 t160 t161 t162 t163 t164 t165 t166 t167 t168 t169 t170 t171 t172 t173 t174 t175 t176 t177 t178 t179 t180 t181 t182 t183 t184 t185 t186 t187 t188 t189 t190 t191 t192 t193 t194 t195 t196 t197 t198 t199 t200 t201 t202 t203 t204 t205 t206 t207 t208 t209 t210 t211 t212 t213 t214 t215 t216 t217 t218 t219 t220 t221 t222 t223 t224 t225 t226 t227 t228 t229 t230 t231 t232 t233 t234 t235 t236 t237 t238 t239 t240 t241 t242 t243 t244 t245 t246 t247 t248 t249 t250 t251 t252 na_p0 na_p1 na_p2 na_p3 na_p4 na_p5 na_p6 na_p7 na_n0 na_n1 na_n2 na_n3 na_n4 na_n5 na_n6 na_n7 neg_a ibias_na vdda vdd vss r1_safe_thr
XOCb outb_p outb_n t0 t1 t2 t3 t4 t5 t6 t7 t8 t9 t10 t11 t12 t13 t14 t15 t16 t17 t18 t19 t20 t21 t22 t23 t24 t25 t26 t27 t28 t29 t30 t31 t32 t33 t34 t35 t36 t37 t38 t39 t40 t41 t42 t43 t44 t45 t46 t47 t48 t49 t50 t51 t52 t53 t54 t55 t56 t57 t58 t59 t60 t61 t62 t63 t64 t65 t66 t67 t68 t69 t70 t71 t72 t73 t74 t75 t76 t77 t78 t79 t80 t81 t82 t83 t84 t85 t86 t87 t88 t89 t90 t91 t92 t93 t94 t95 t96 t97 t98 t99 t100 t101 t102 t103 t104 t105 t106 t107 t108 t109 t110 t111 t112 t113 t114 t115 t116 t117 t118 t119 t120 t121 t122 t123 t124 t125 t126 t127 t128 t129 t130 t131 t132 t133 t134 t135 t136 t137 t138 t139 t140 t141 t142 t143 t144 t145 t146 t147 t148 t149 t150 t151 t152 t153 t154 t155 t156 t157 t158 t159 t160 t161 t162 t163 t164 t165 t166 t167 t168 t169 t170 t171 t172 t173 t174 t175 t176 t177 t178 t179 t180 t181 t182 t183 t184 t185 t186 t187 t188 t189 t190 t191 t192 t193 t194 t195 t196 t197 t198 t199 t200 t201 t202 t203 t204 t205 t206 t207 t208 t209 t210 t211 t212 t213 t214 t215 t216 t217 t218 t219 t220 t221 t222 t223 t224 t225 t226 t227 t228 t229 t230 t231 t232 t233 t234 t235 t236 t237 t238 t239 t240 t241 t242 t243 t244 t245 t246 t247 t248 t249 t250 t251 t252 ob_p0 ob_p1 ob_p2 ob_p3 ob_p4 ob_p5 ob_p6 ob_p7 ob_n0 ob_n1 ob_n2 ob_n3 ob_n4 ob_n5 ob_n6 ob_n7 oc_b ibias_ob vdda vdd vss r1_safe_thr
XNGb outb_n outb_p t0 t1 t2 t3 t4 t5 t6 t7 t8 t9 t10 t11 t12 t13 t14 t15 t16 t17 t18 t19 t20 t21 t22 t23 t24 t25 t26 t27 t28 t29 t30 t31 t32 t33 t34 t35 t36 t37 t38 t39 t40 t41 t42 t43 t44 t45 t46 t47 t48 t49 t50 t51 t52 t53 t54 t55 t56 t57 t58 t59 t60 t61 t62 t63 t64 t65 t66 t67 t68 t69 t70 t71 t72 t73 t74 t75 t76 t77 t78 t79 t80 t81 t82 t83 t84 t85 t86 t87 t88 t89 t90 t91 t92 t93 t94 t95 t96 t97 t98 t99 t100 t101 t102 t103 t104 t105 t106 t107 t108 t109 t110 t111 t112 t113 t114 t115 t116 t117 t118 t119 t120 t121 t122 t123 t124 t125 t126 t127 t128 t129 t130 t131 t132 t133 t134 t135 t136 t137 t138 t139 t140 t141 t142 t143 t144 t145 t146 t147 t148 t149 t150 t151 t152 t153 t154 t155 t156 t157 t158 t159 t160 t161 t162 t163 t164 t165 t166 t167 t168 t169 t170 t171 t172 t173 t174 t175 t176 t177 t178 t179 t180 t181 t182 t183 t184 t185 t186 t187 t188 t189 t190 t191 t192 t193 t194 t195 t196 t197 t198 t199 t200 t201 t202 t203 t204 t205 t206 t207 t208 t209 t210 t211 t212 t213 t214 t215 t216 t217 t218 t219 t220 t221 t222 t223 t224 t225 t226 t227 t228 t229 t230 t231 t232 t233 t234 t235 t236 t237 t238 t239 t240 t241 t242 t243 t244 t245 t246 t247 t248 t249 t250 t251 t252 nb_p0 nb_p1 nb_p2 nb_p3 nb_p4 nb_p5 nb_p6 nb_p7 nb_n0 nb_n1 nb_n2 nb_n3 nb_n4 nb_n5 nb_n6 nb_n7 neg_b ibias_nb vdda vdd vss r1_safe_thr
.ends r1_safe_an
