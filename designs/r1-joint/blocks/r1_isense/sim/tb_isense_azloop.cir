* r1_isense auto-zero loop gain (return ratio), loop broken at the auxiliary-pair gates during AZ hold (az = azh = 1).
* Loop: x1a -> hold switch -> h1 (1 pF) -> aux pair XA1 -> fold node f1 -> cascode -> x1a (each side; the stage-2 Miller
* loop and CMFB are inside). The break uses a 1 GH / 1 F pair (DC operating point unchanged); the gate load of the
* aux devices (about 0.07 fF/um2 x 32 um2) is small against the 1 pF hold cap at the open end, so no replica is added.
* Differential: AC +0.5/-0.5 at the two gates, T_dm = -(v(h1)-v(h2))/(v(hg1)-v(hg2)); common mode: +0.5/+0.5.
* Uses a deck-local copy of r1_isense_ch (r1_isense_ch_lg, generated by gen_tb_isense_azloop.py from the netlist of record).
.lib /foss/pdks/ihp-sg13g2/libs.tech/ngspice/models/cornerMOSlv.lib @@MOS@@
.lib /foss/pdks/ihp-sg13g2/libs.tech/ngspice/models/cornerMOShv.lib @@MOS@@
.lib /foss/pdks/ihp-sg13g2/libs.tech/ngspice/models/cornerRES.lib @@RES@@
.lib /foss/pdks/ihp-sg13g2/libs.tech/ngspice/models/cornerCAP.lib @@CAP@@
.temp @@TEMP@@
.include /work/designs/r1-joint/blocks/r1_isense/schematic/r1_isense.spice
.subckt r1_isense_ch_lg isp isn outp outn vref vcm ibias az_lv azh_lv vdda vdd vss tpa tpb
*.ipin isp isn       shunt Kelvin pins (through the analog pads)
*.ipin vref         1.05 V reference for the pedestal (buffered; ideal source in this step)
*.ipin vcm          0.6 V output common mode (from the r1_adc reference; ideal source in this step)
*.ipin ibias        5 uA bias current sunk into this pin's diode (from r1_bgr; ideal source in this step)
*.ipin az_lv azh_lv auto-zero phases, 1.2 V logic from r1_ctrl
*.opin outp outn    differential output to the ADC multiplexer and r1_safe
* ---- level shifters for the AZ phases
XLS1 az_lv vdd vdda vss az azb r1_ls
XLS2 azh_lv vdd vdda vss azh azhb r1_ls
* ---- resistor network, unit RIN = 4 kOhm (rppd w=2 l=30.8)
XRIA isp sa vss rppd w=2u l=30.8u m=1 b=0 mm_ok=1
XRIB isn sb vss rppd w=2u l=30.8u m=1 b=0 mm_ok=1
* feedback arms: 14 units each (two-terminal multiple: m units in series written out)
XRFA1 rfoa rfa1 vss rppd w=2u l=30.8u m=1 b=0 mm_ok=1
XRFA2 rfa1 rfa2 vss rppd w=2u l=30.8u m=1 b=0 mm_ok=1
XRFA3 rfa2 rfa3 vss rppd w=2u l=30.8u m=1 b=0 mm_ok=1
XRFA4 rfa3 rfa4 vss rppd w=2u l=30.8u m=1 b=0 mm_ok=1
XRFA5 rfa4 rfa5 vss rppd w=2u l=30.8u m=1 b=0 mm_ok=1
XRFA6 rfa5 rfa6 vss rppd w=2u l=30.8u m=1 b=0 mm_ok=1
XRFA7 rfa6 rfa7 vss rppd w=2u l=30.8u m=1 b=0 mm_ok=1
XRFA8 rfa7 rfa8 vss rppd w=2u l=30.8u m=1 b=0 mm_ok=1
XRFA9 rfa8 rfa9 vss rppd w=2u l=30.8u m=1 b=0 mm_ok=1
XRFA10 rfa9 rfa10 vss rppd w=2u l=30.8u m=1 b=0 mm_ok=1
XRFA11 rfa10 rfa11 vss rppd w=2u l=30.8u m=1 b=0 mm_ok=1
XRFA12 rfa11 rfa12 vss rppd w=2u l=30.8u m=1 b=0 mm_ok=1
XRFA13 rfa12 rfa13 vss rppd w=2u l=30.8u m=1 b=0 mm_ok=1
XRFA14 rfa13 sa vss rppd w=2u l=30.8u m=1 b=0 mm_ok=1
XRFB1 rfob rfb1 vss rppd w=2u l=30.8u m=1 b=0 mm_ok=1
XRFB2 rfb1 rfb2 vss rppd w=2u l=30.8u m=1 b=0 mm_ok=1
XRFB3 rfb2 rfb3 vss rppd w=2u l=30.8u m=1 b=0 mm_ok=1
XRFB4 rfb3 rfb4 vss rppd w=2u l=30.8u m=1 b=0 mm_ok=1
XRFB5 rfb4 rfb5 vss rppd w=2u l=30.8u m=1 b=0 mm_ok=1
XRFB6 rfb5 rfb6 vss rppd w=2u l=30.8u m=1 b=0 mm_ok=1
XRFB7 rfb6 rfb7 vss rppd w=2u l=30.8u m=1 b=0 mm_ok=1
XRFB8 rfb7 rfb8 vss rppd w=2u l=30.8u m=1 b=0 mm_ok=1
XRFB9 rfb8 rfb9 vss rppd w=2u l=30.8u m=1 b=0 mm_ok=1
XRFB10 rfb9 rfb10 vss rppd w=2u l=30.8u m=1 b=0 mm_ok=1
XRFB11 rfb10 rfb11 vss rppd w=2u l=30.8u m=1 b=0 mm_ok=1
XRFB12 rfb11 rfb12 vss rppd w=2u l=30.8u m=1 b=0 mm_ok=1
XRFB13 rfb12 rfb13 vss rppd w=2u l=30.8u m=1 b=0 mm_ok=1
XRFB14 rfb13 sb vss rppd w=2u l=30.8u m=1 b=0 mm_ok=1
* pedestal: RP = 26 RIN units (104 kOhm) from vref into sb (ISN side), matching RP from sa to vss;
* VPED = 1.05 V / 26 = 40.38 mV, set by a unit ratio only
XRPB1 vref rpb1 vss rppd w=2u l=30.8u m=1 b=0 mm_ok=1
XRPB2 rpb1 rpb2 vss rppd w=2u l=30.8u m=1 b=0 mm_ok=1
XRPB3 rpb2 rpb3 vss rppd w=2u l=30.8u m=1 b=0 mm_ok=1
XRPB4 rpb3 rpb4 vss rppd w=2u l=30.8u m=1 b=0 mm_ok=1
XRPB5 rpb4 rpb5 vss rppd w=2u l=30.8u m=1 b=0 mm_ok=1
XRPB6 rpb5 rpb6 vss rppd w=2u l=30.8u m=1 b=0 mm_ok=1
XRPB7 rpb6 rpb7 vss rppd w=2u l=30.8u m=1 b=0 mm_ok=1
XRPB8 rpb7 rpb8 vss rppd w=2u l=30.8u m=1 b=0 mm_ok=1
XRPB9 rpb8 rpb9 vss rppd w=2u l=30.8u m=1 b=0 mm_ok=1
XRPB10 rpb9 rpb10 vss rppd w=2u l=30.8u m=1 b=0 mm_ok=1
XRPB11 rpb10 rpb11 vss rppd w=2u l=30.8u m=1 b=0 mm_ok=1
XRPB12 rpb11 rpb12 vss rppd w=2u l=30.8u m=1 b=0 mm_ok=1
XRPB13 rpb12 rpb13 vss rppd w=2u l=30.8u m=1 b=0 mm_ok=1
XRPB14 rpb13 rpb14 vss rppd w=2u l=30.8u m=1 b=0 mm_ok=1
XRPB15 rpb14 rpb15 vss rppd w=2u l=30.8u m=1 b=0 mm_ok=1
XRPB16 rpb15 rpb16 vss rppd w=2u l=30.8u m=1 b=0 mm_ok=1
XRPB17 rpb16 rpb17 vss rppd w=2u l=30.8u m=1 b=0 mm_ok=1
XRPB18 rpb17 rpb18 vss rppd w=2u l=30.8u m=1 b=0 mm_ok=1
XRPB19 rpb18 rpb19 vss rppd w=2u l=30.8u m=1 b=0 mm_ok=1
XRPB20 rpb19 rpb20 vss rppd w=2u l=30.8u m=1 b=0 mm_ok=1
XRPB21 rpb20 rpb21 vss rppd w=2u l=30.8u m=1 b=0 mm_ok=1
XRPB22 rpb21 rpb22 vss rppd w=2u l=30.8u m=1 b=0 mm_ok=1
XRPB23 rpb22 rpb23 vss rppd w=2u l=30.8u m=1 b=0 mm_ok=1
XRPB24 rpb23 rpb24 vss rppd w=2u l=30.8u m=1 b=0 mm_ok=1
XRPB25 rpb24 rpb25 vss rppd w=2u l=30.8u m=1 b=0 mm_ok=1
XRPB26 rpb25 rpbs vss rppd w=2u l=30.8u m=1 b=0 mm_ok=1
XRPA1 vss rpa1 vss rppd w=2u l=30.8u m=1 b=0 mm_ok=1
XRPA2 rpa1 rpa2 vss rppd w=2u l=30.8u m=1 b=0 mm_ok=1
XRPA3 rpa2 rpa3 vss rppd w=2u l=30.8u m=1 b=0 mm_ok=1
XRPA4 rpa3 rpa4 vss rppd w=2u l=30.8u m=1 b=0 mm_ok=1
XRPA5 rpa4 rpa5 vss rppd w=2u l=30.8u m=1 b=0 mm_ok=1
XRPA6 rpa5 rpa6 vss rppd w=2u l=30.8u m=1 b=0 mm_ok=1
XRPA7 rpa6 rpa7 vss rppd w=2u l=30.8u m=1 b=0 mm_ok=1
XRPA8 rpa7 rpa8 vss rppd w=2u l=30.8u m=1 b=0 mm_ok=1
XRPA9 rpa8 rpa9 vss rppd w=2u l=30.8u m=1 b=0 mm_ok=1
XRPA10 rpa9 rpa10 vss rppd w=2u l=30.8u m=1 b=0 mm_ok=1
XRPA11 rpa10 rpa11 vss rppd w=2u l=30.8u m=1 b=0 mm_ok=1
XRPA12 rpa11 rpa12 vss rppd w=2u l=30.8u m=1 b=0 mm_ok=1
XRPA13 rpa12 rpa13 vss rppd w=2u l=30.8u m=1 b=0 mm_ok=1
XRPA14 rpa13 rpa14 vss rppd w=2u l=30.8u m=1 b=0 mm_ok=1
XRPA15 rpa14 rpa15 vss rppd w=2u l=30.8u m=1 b=0 mm_ok=1
XRPA16 rpa15 rpa16 vss rppd w=2u l=30.8u m=1 b=0 mm_ok=1
XRPA17 rpa16 rpa17 vss rppd w=2u l=30.8u m=1 b=0 mm_ok=1
XRPA18 rpa17 rpa18 vss rppd w=2u l=30.8u m=1 b=0 mm_ok=1
XRPA19 rpa18 rpa19 vss rppd w=2u l=30.8u m=1 b=0 mm_ok=1
XRPA20 rpa19 rpa20 vss rppd w=2u l=30.8u m=1 b=0 mm_ok=1
XRPA21 rpa20 rpa21 vss rppd w=2u l=30.8u m=1 b=0 mm_ok=1
XRPA22 rpa21 rpa22 vss rppd w=2u l=30.8u m=1 b=0 mm_ok=1
XRPA23 rpa22 rpa23 vss rppd w=2u l=30.8u m=1 b=0 mm_ok=1
XRPA24 rpa23 rpa24 vss rppd w=2u l=30.8u m=1 b=0 mm_ok=1
XRPA25 rpa24 rpa25 vss rppd w=2u l=30.8u m=1 b=0 mm_ok=1
XRPA26 rpa25 rpas vss rppd w=2u l=30.8u m=1 b=0 mm_ok=1
* pedestal switches (on in normal mode, open during AZ), at the summing-node end (source near 0 V, matched Vgs)
XSPB rpbs azb sb vss sg13_hv_nmos w=10u l=0.45u ng=1 m=1 mm_ok=1
XSPA rpas azb sa vss sg13_hv_nmos w=10u l=0.45u ng=1 m=1 mm_ok=1
* ---- bias (unit NMOS nu = w4/l1 at 5 uA, unit PMOS pu = w4/l2 at 5 uA)
XMBN ibias ibias vss vss sg13_hv_nmos w=4u l=1u ng=1 m=1 mm_ok=1
XMB2 vbp ibias vss vss sg13_hv_nmos w=4u l=1u ng=1 m=2 mm_ok=1
XMBP vbp vbp vdda vdda sg13_hv_pmos w=4u l=2u ng=1 m=2 mm_ok=1
XMB3 vbpc ibias vss vss sg13_hv_nmos w=4u l=1u ng=1 m=1 mm_ok=1
XMBPC vbpc vbpc vdda vdda sg13_hv_pmos w=0.5u l=3u ng=1 m=1 mm_ok=1
XMB4 vbnc vbp vdda vdda sg13_hv_pmos w=4u l=2u ng=1 m=1 mm_ok=1
XMBNC vbnc vbnc vss vss sg13_hv_nmos w=1u l=3u ng=1 m=1 mm_ok=1
XMB5 vbl ibias vss vss sg13_hv_nmos w=4u l=1u ng=1 m=4 mm_ok=1
XMB6 vbf vbp vdda vdda sg13_hv_pmos w=4u l=2u ng=1 m=1 mm_ok=1
XMBF vbf vbf vss vss sg13_hv_nmos w=8u l=2u ng=1 m=1 mm_ok=1
XMBL vbl vbl vdd vdd sg13_lv_pmos w=4u l=0.25u ng=1 m=1 mm_ok=1
* ---- stage 1: input pair, tail 40 uA
XMT tail vbp vdda vdda sg13_hv_pmos w=4u l=2u ng=1 m=8 mm_ok=1
XM1 f1 sa tail tail sg13_hv_pmos w=40u l=1u ng=8 m=1 mm_ok=1
XM2 f2 sb tail tail sg13_hv_pmos w=40u l=1u ng=8 m=1 mm_ok=1
* auxiliary (AZ) pair, tail 10 uA
XMTA atail vbp vdda vdda sg13_hv_pmos w=4u l=2u ng=1 m=2 mm_ok=1
XA1 f1 hg1 atail atail sg13_hv_pmos w=8u l=4u ng=1 m=1 mm_ok=1
XA2 f2 hg2 atail atail sg13_hv_pmos w=8u l=4u ng=1 m=1 mm_ok=1
* folding sinks per side: 35 uA fixed (7 units), mirrored from a PMOS-fed diode (vbf), so they track the PMOS currents,
* + 2/3 x the CMFB diode current (nominal 10 uA at balance, range 0..20 uA). Required 45 uA = 20 (pair) + 5 (aux) + 20 (load).
* The small CMFB share keeps the CM loop crossover below the second-stage pole (a 8/3 share oscillated at 46 MHz).
* Sink mirrors use L = 2 um to limit channel-length modulation at the low fold-node voltage.
XMS1 f1 vbf vss vss sg13_hv_nmos w=8u l=2u ng=1 m=7 mm_ok=1
XMC1S f1 vcmfb vss vss sg13_hv_nmos w=8u l=2u ng=1 m=2 mm_ok=1
XMS2 f2 vbf vss vss sg13_hv_nmos w=8u l=2u ng=1 m=7 mm_ok=1
XMC2S f2 vcmfb vss vss sg13_hv_nmos w=8u l=2u ng=1 m=2 mm_ok=1
* NMOS cascodes
XMN1 x1a vbnc f1 vss sg13_hv_nmos w=40u l=2u ng=4 m=1 mm_ok=1
XMN2 x1b vbnc f2 vss sg13_hv_nmos w=40u l=2u ng=4 m=1 mm_ok=1
* PMOS cascoded loads, 20 uA
XMP1 p1 vbp vdda vdda sg13_hv_pmos w=4u l=2u ng=1 m=4 mm_ok=1
XMP2 p2 vbp vdda vdda sg13_hv_pmos w=4u l=2u ng=1 m=4 mm_ok=1
XMPC1 x1a vbpc p1 vdda sg13_hv_pmos w=16u l=2u ng=2 m=1 mm_ok=1
XMPC2 x1b vbpc p2 vdda sg13_hv_pmos w=16u l=2u ng=2 m=1 mm_ok=1
* ---- stage 2 on VDD: thick NMOS driver, thin PMOS load
XMOA outp x1a vss vss sg13_hv_nmos w=16u l=0.5u ng=4 m=1 mm_ok=1
XMOB outn x1b vss vss sg13_hv_nmos w=16u l=0.5u ng=4 m=1 mm_ok=1
XMLA outp vbl vdd vdd sg13_lv_pmos w=40u l=0.25u ng=4 m=1 mm_ok=1
XMLB outn vbl vdd vdd sg13_lv_pmos w=40u l=0.25u ng=4 m=1 mm_ok=1
* Miller compensation with nulling resistor
XRZA x1a cza vss rppd w=1u l=3.6u m=1 b=0 mm_ok=1
XCCA cza outp cap_cmim w=12u l=12u m=1 mm_ok=1
XRZB x1b czb vss rppd w=1u l=3.6u m=1 b=0 mm_ok=1
XCCB czb outn cap_cmim w=12u l=12u m=1 mm_ok=1
* ---- CMFB: rhigh sense 2 x 200 k with 0.1 pF bypass, thick PMOS pair, tail 30 uA
XRCA outp vcms vss rhigh w=1u l=150u m=1 b=0 mm_ok=1
XRCB outn vcms vss rhigh w=1u l=150u m=1 b=0 mm_ok=1
XCMA outp vcms cap_cmim w=8u l=8u m=1 mm_ok=1
XCMB outn vcms cap_cmim w=8u l=8u m=1 mm_ok=1
XMTC ctail vbp vdda vdda sg13_hv_pmos w=4u l=2u ng=1 m=6 mm_ok=1
XMF1 vcmfb vcms ctail ctail sg13_hv_pmos w=24u l=1u ng=4 m=1 mm_ok=1
XMF2 vcmd vcm ctail ctail sg13_hv_pmos w=24u l=1u ng=4 m=1 mm_ok=1
XMFD vcmfb vcmfb vss vss sg13_hv_nmos w=8u l=2u ng=1 m=3 mm_ok=1
XMFE vcmd vcmd vss vss sg13_hv_nmos w=8u l=2u ng=1 m=3 mm_ok=1
* ---- auto-zero: hold switches and caps
XSH1 h1 azh x1a vss sg13_hv_nmos w=1u l=0.45u ng=1 m=1 mm_ok=1
XSH2 h2 azh x1b vss sg13_hv_nmos w=1u l=0.45u ng=1 m=1 mm_ok=1
XCH1 h1 vss cap_cmim w=26u l=26u m=1 mm_ok=1
XCH2 h2 vss cap_cmim w=26u l=26u m=1 mm_ok=1
* RF arm output ends: connected to the outputs in normal mode, to VCM during AZ (network sees Vod = 0 exactly)
XSFA outn azb rfoa vss sg13_hv_nmos w=40u l=0.45u ng=4 m=1 mm_ok=1
XSFB outp azb rfob vss sg13_hv_nmos w=40u l=0.45u ng=4 m=1 mm_ok=1
XSVA rfoa az vcm vss sg13_hv_nmos w=4u l=0.45u ng=1 m=1 mm_ok=1
XSVB rfob az vcm vss sg13_hv_nmos w=4u l=0.45u ng=1 m=1 mm_ok=1
* LOOP BREAK (test only): DC through 1 GH, AC injected through 1 F at the aux-pair gates
Lb1 h1 hg1 1e9
Lb2 h2 hg2 1e9
Ci1 hg1 tpa 1
Ci2 hg2 tpb 1
* replica of the aux gate load at the open end (h1/h2 already carry 1 pF hold caps)
.ends r1_isense_ch_lg
.option gmin=1e-12
Vdda vdda 0 dc @@VDDA@@
Vdd vdd 0 dc @@VDD@@
* IDEAL REFERENCE SOURCES (this step only)
Vref vref 0 dc 1.05
Vcm vcm 0 dc 0.6
Ibias vdda ibias dc {5u*(@@TEMP@@+273.15)/300.15}
Vaz az 0 dc @@VDD@@
Vazh azh 0 dc @@VDD@@
Vcmi isn 0 dc 0
Vin isp isn dc 0
Vta tpa 0 dc 0 ac 0.5
Vtb tpb 0 dc 0 ac -0.5
XDUT isp isn outp outn vref vcm ibias az azh vdda vdd 0 tpa tpb r1_isense_ch_lg
CLP outp 0 2p
CLN outn 0 2p
.control
set wr_singlescale
set wr_vecnames
ac dec 40 10 10g
let t = -(v(xdut.h1)-v(xdut.h2))/(v(xdut.hg1)-v(xdut.hg2))
let tdb = db(t)
let tph = cph(t)*180/pi
wrdata @@OUT@@_dm.txt tdb tph
alter vtb ac = 0.5
ac dec 40 10 10g
let t = -(v(xdut.h1)+v(xdut.h2))/(v(xdut.hg1)+v(xdut.hg2))
let tdb = db(t)
let tph = cph(t)*180/pi
wrdata @@OUT@@_cm.txt tdb tph
.endc
.end
