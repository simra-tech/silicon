* LVS reference CDL for r1_isense (revision 2), written by layout/r1_isense_netlist.py from schematic/r1_isense.spice
* unit split only (see the module docstring): long rhigh/rppd -> straight series segments, MOS finger re-cut;
* r1_ls instances flattened into r1_isense_ch (prefix xls1_/xls2_). Layout dummies are poly only (no devices).
* layout revision c: the channel vss is split into the returns vss (quiet), vss_o (output stage sources) and
* vss_sw (level-shifter NMOS sources), and the Kelvin end vss_k of the pedestal arm (xrpa1); r1_isense ties the
* four to its vss pin (flattened circuit unchanged).
.subckt r1_isense_ch isp isn outp outn vref vcm ibias az_lv azh_lv vdda vdd vss vss_o vss_sw vss_k
Mxls1_xmip xls1_inb az_lv vdd vdd sg13_lv_pmos w=1u l=0.13u m=1
Mxls1_xmin xls1_inb az_lv vss_sw vss sg13_lv_nmos w=0.5u l=0.13u m=1
Mxls1_xmn1 xls1_a az_lv vss_sw vss sg13_hv_nmos w=4u l=0.45u m=1
Mxls1_xmn2 xls1_b xls1_inb vss_sw vss sg13_hv_nmos w=4u l=0.45u m=1
Mxls1_xmp1 xls1_a xls1_b vdda vdda sg13_hv_pmos w=0.6u l=0.5u m=1
Mxls1_xmp2 xls1_b xls1_a vdda vdda sg13_hv_pmos w=0.6u l=0.5u m=1
Mxls1_xmb1p azb xls1_b vdda vdda sg13_hv_pmos w=2u l=0.5u m=1
Mxls1_xmb1n azb xls1_b vss_sw vss sg13_hv_nmos w=1u l=0.45u m=1
Mxls1_xmb2p az azb vdda vdda sg13_hv_pmos w=2u l=0.5u m=1
Mxls1_xmb2n az azb vss_sw vss sg13_hv_nmos w=1u l=0.45u m=1
Mxls2_xmip xls2_inb azh_lv vdd vdd sg13_lv_pmos w=1u l=0.13u m=1
Mxls2_xmin xls2_inb azh_lv vss_sw vss sg13_lv_nmos w=0.5u l=0.13u m=1
Mxls2_xmn1 xls2_a azh_lv vss_sw vss sg13_hv_nmos w=4u l=0.45u m=1
Mxls2_xmn2 xls2_b xls2_inb vss_sw vss sg13_hv_nmos w=4u l=0.45u m=1
Mxls2_xmp1 xls2_a xls2_b vdda vdda sg13_hv_pmos w=0.6u l=0.5u m=1
Mxls2_xmp2 xls2_b xls2_a vdda vdda sg13_hv_pmos w=0.6u l=0.5u m=1
Mxls2_xmb1p azhb xls2_b vdda vdda sg13_hv_pmos w=2u l=0.5u m=1
Mxls2_xmb1n azhb xls2_b vss_sw vss sg13_hv_nmos w=1u l=0.45u m=1
Mxls2_xmb2p azh azhb vdda vdda sg13_hv_pmos w=2u l=0.5u m=1
Mxls2_xmb2n azh azhb vss_sw vss sg13_hv_nmos w=1u l=0.45u m=1
Rxria isp sa vss rppd w=2u l=30.8u m=1 b=0
Rxrib isn sb vss rppd w=2u l=30.8u m=1 b=0
Rxrfa1 rfoa rfa1 vss rppd w=2u l=30.8u m=1 b=0
Rxrfa2 rfa1 rfa2 vss rppd w=2u l=30.8u m=1 b=0
Rxrfa3 rfa2 rfa3 vss rppd w=2u l=30.8u m=1 b=0
Rxrfa4 rfa3 rfa4 vss rppd w=2u l=30.8u m=1 b=0
Rxrfa5 rfa4 rfa5 vss rppd w=2u l=30.8u m=1 b=0
Rxrfa6 rfa5 rfa6 vss rppd w=2u l=30.8u m=1 b=0
Rxrfa7 rfa6 rfa7 vss rppd w=2u l=30.8u m=1 b=0
Rxrfa8 rfa7 rfa8 vss rppd w=2u l=30.8u m=1 b=0
Rxrfa9 rfa8 rfa9 vss rppd w=2u l=30.8u m=1 b=0
Rxrfa10 rfa9 rfa10 vss rppd w=2u l=30.8u m=1 b=0
Rxrfa11 rfa10 rfa11 vss rppd w=2u l=30.8u m=1 b=0
Rxrfa12 rfa11 rfa12 vss rppd w=2u l=30.8u m=1 b=0
Rxrfa13 rfa12 rfa13 vss rppd w=2u l=30.8u m=1 b=0
Rxrfa14 rfa13 sa vss rppd w=2u l=30.8u m=1 b=0
Rxrfb1 rfob rfb1 vss rppd w=2u l=30.8u m=1 b=0
Rxrfb2 rfb1 rfb2 vss rppd w=2u l=30.8u m=1 b=0
Rxrfb3 rfb2 rfb3 vss rppd w=2u l=30.8u m=1 b=0
Rxrfb4 rfb3 rfb4 vss rppd w=2u l=30.8u m=1 b=0
Rxrfb5 rfb4 rfb5 vss rppd w=2u l=30.8u m=1 b=0
Rxrfb6 rfb5 rfb6 vss rppd w=2u l=30.8u m=1 b=0
Rxrfb7 rfb6 rfb7 vss rppd w=2u l=30.8u m=1 b=0
Rxrfb8 rfb7 rfb8 vss rppd w=2u l=30.8u m=1 b=0
Rxrfb9 rfb8 rfb9 vss rppd w=2u l=30.8u m=1 b=0
Rxrfb10 rfb9 rfb10 vss rppd w=2u l=30.8u m=1 b=0
Rxrfb11 rfb10 rfb11 vss rppd w=2u l=30.8u m=1 b=0
Rxrfb12 rfb11 rfb12 vss rppd w=2u l=30.8u m=1 b=0
Rxrfb13 rfb12 rfb13 vss rppd w=2u l=30.8u m=1 b=0
Rxrfb14 rfb13 sb vss rppd w=2u l=30.8u m=1 b=0
Rxrpb1 vref rpb1 vss rppd w=2u l=30.8u m=1 b=0
Rxrpb2 rpb1 rpb2 vss rppd w=2u l=30.8u m=1 b=0
Rxrpb3 rpb2 rpb3 vss rppd w=2u l=30.8u m=1 b=0
Rxrpb4 rpb3 rpb4 vss rppd w=2u l=30.8u m=1 b=0
Rxrpb5 rpb4 rpb5 vss rppd w=2u l=30.8u m=1 b=0
Rxrpb6 rpb5 rpb6 vss rppd w=2u l=30.8u m=1 b=0
Rxrpb7 rpb6 rpb7 vss rppd w=2u l=30.8u m=1 b=0
Rxrpb8 rpb7 rpb8 vss rppd w=2u l=30.8u m=1 b=0
Rxrpb9 rpb8 rpb9 vss rppd w=2u l=30.8u m=1 b=0
Rxrpb10 rpb9 rpb10 vss rppd w=2u l=30.8u m=1 b=0
Rxrpb11 rpb10 rpb11 vss rppd w=2u l=30.8u m=1 b=0
Rxrpb12 rpb11 rpb12 vss rppd w=2u l=30.8u m=1 b=0
Rxrpb13 rpb12 rpb13 vss rppd w=2u l=30.8u m=1 b=0
Rxrpb14 rpb13 rpb14 vss rppd w=2u l=30.8u m=1 b=0
Rxrpb15 rpb14 rpb15 vss rppd w=2u l=30.8u m=1 b=0
Rxrpb16 rpb15 rpb16 vss rppd w=2u l=30.8u m=1 b=0
Rxrpb17 rpb16 rpb17 vss rppd w=2u l=30.8u m=1 b=0
Rxrpb18 rpb17 rpb18 vss rppd w=2u l=30.8u m=1 b=0
Rxrpb19 rpb18 rpb19 vss rppd w=2u l=30.8u m=1 b=0
Rxrpb20 rpb19 rpb20 vss rppd w=2u l=30.8u m=1 b=0
Rxrpb21 rpb20 rpb21 vss rppd w=2u l=30.8u m=1 b=0
Rxrpb22 rpb21 rpb22 vss rppd w=2u l=30.8u m=1 b=0
Rxrpb23 rpb22 rpb23 vss rppd w=2u l=30.8u m=1 b=0
Rxrpb24 rpb23 rpb24 vss rppd w=2u l=30.8u m=1 b=0
Rxrpb25 rpb24 rpb25 vss rppd w=2u l=30.8u m=1 b=0
Rxrpb26 rpb25 rpbs vss rppd w=2u l=30.8u m=1 b=0
Rxrpa1 vss_k rpa1 vss rppd w=2u l=30.8u m=1 b=0
Rxrpa2 rpa1 rpa2 vss rppd w=2u l=30.8u m=1 b=0
Rxrpa3 rpa2 rpa3 vss rppd w=2u l=30.8u m=1 b=0
Rxrpa4 rpa3 rpa4 vss rppd w=2u l=30.8u m=1 b=0
Rxrpa5 rpa4 rpa5 vss rppd w=2u l=30.8u m=1 b=0
Rxrpa6 rpa5 rpa6 vss rppd w=2u l=30.8u m=1 b=0
Rxrpa7 rpa6 rpa7 vss rppd w=2u l=30.8u m=1 b=0
Rxrpa8 rpa7 rpa8 vss rppd w=2u l=30.8u m=1 b=0
Rxrpa9 rpa8 rpa9 vss rppd w=2u l=30.8u m=1 b=0
Rxrpa10 rpa9 rpa10 vss rppd w=2u l=30.8u m=1 b=0
Rxrpa11 rpa10 rpa11 vss rppd w=2u l=30.8u m=1 b=0
Rxrpa12 rpa11 rpa12 vss rppd w=2u l=30.8u m=1 b=0
Rxrpa13 rpa12 rpa13 vss rppd w=2u l=30.8u m=1 b=0
Rxrpa14 rpa13 rpa14 vss rppd w=2u l=30.8u m=1 b=0
Rxrpa15 rpa14 rpa15 vss rppd w=2u l=30.8u m=1 b=0
Rxrpa16 rpa15 rpa16 vss rppd w=2u l=30.8u m=1 b=0
Rxrpa17 rpa16 rpa17 vss rppd w=2u l=30.8u m=1 b=0
Rxrpa18 rpa17 rpa18 vss rppd w=2u l=30.8u m=1 b=0
Rxrpa19 rpa18 rpa19 vss rppd w=2u l=30.8u m=1 b=0
Rxrpa20 rpa19 rpa20 vss rppd w=2u l=30.8u m=1 b=0
Rxrpa21 rpa20 rpa21 vss rppd w=2u l=30.8u m=1 b=0
Rxrpa22 rpa21 rpa22 vss rppd w=2u l=30.8u m=1 b=0
Rxrpa23 rpa22 rpa23 vss rppd w=2u l=30.8u m=1 b=0
Rxrpa24 rpa23 rpa24 vss rppd w=2u l=30.8u m=1 b=0
Rxrpa25 rpa24 rpa25 vss rppd w=2u l=30.8u m=1 b=0
Rxrpa26 rpa25 rpas vss rppd w=2u l=30.8u m=1 b=0
Mxspb rpbs azb sb vss sg13_hv_nmos w=10u l=0.45u m=1
Mxspa rpas azb sa vss sg13_hv_nmos w=10u l=0.45u m=1
Mxmbn ibias ibias vss vss sg13_hv_nmos w=4u l=1u m=1
Mxmb2 vbp ibias vss vss sg13_hv_nmos w=8u l=1u m=1
Mxmbp vbp vbp vdda vdda sg13_hv_pmos w=8u l=2u m=1
Mxmb3 vbpc ibias vss vss sg13_hv_nmos w=4u l=1u m=1
Mxmbpc vbpc vbpc vdda vdda sg13_hv_pmos w=0.5u l=3u m=1
Mxmb4 vbnc vbp vdda vdda sg13_hv_pmos w=4u l=2u m=1
Mxmbnc vbnc vbnc vss vss sg13_hv_nmos w=1u l=3u m=1
Mxmb5 vbl ibias vss vss sg13_hv_nmos w=16u l=1u m=1
Mxmb6 vbf vbp vdda vdda sg13_hv_pmos w=4u l=2u m=1
Mxmbf vbfs vbf vss vss sg13_hv_nmos w=8u l=2u m=1
Mxmbfc vbf vbnc vbfs vss sg13_hv_nmos w=10u l=2u m=1
Mxmbl vbl vbl vdd vdd sg13_lv_pmos w=4u l=0.25u m=1
Mxmt tail vbp vdda vdda sg13_hv_pmos w=32u l=2u m=1
Mxm1_h0 f1 sa tail tail sg13_hv_pmos w=20u l=1u m=1
Mxm1_h1 f1 sa tail tail sg13_hv_pmos w=20u l=1u m=1
Mxm2_h0 f2 sb tail tail sg13_hv_pmos w=20u l=1u m=1
Mxm2_h1 f2 sb tail tail sg13_hv_pmos w=20u l=1u m=1
Mxmta atail vbp vdda vdda sg13_hv_pmos w=8u l=2u m=1
Mxa1_h0 f1 h1 atail atail sg13_hv_pmos w=4u l=4u m=1
Mxa1_h1 f1 h1 atail atail sg13_hv_pmos w=4u l=4u m=1
Mxa2_h0 f2 h2 atail atail sg13_hv_pmos w=4u l=4u m=1
Mxa2_h1 f2 h2 atail atail sg13_hv_pmos w=4u l=4u m=1
Mxms1 f1 vbf vss vss sg13_hv_nmos w=64u l=2u m=1
Mxmc1s f1 vcmfb vss vss sg13_hv_nmos w=8u l=2u m=1
Mxms2 f2 vbf vss vss sg13_hv_nmos w=64u l=2u m=1
Mxmc2s f2 vcmfb vss vss sg13_hv_nmos w=8u l=2u m=1
Mxmn1 x1a vbnc f1 vss sg13_hv_nmos w=40u l=2u m=1
Mxmn2 x1b vbnc f2 vss sg13_hv_nmos w=40u l=2u m=1
Mxmp1 p1 vbp vdda vdda sg13_hv_pmos w=16u l=2u m=1
Mxmp2 p2 vbp vdda vdda sg13_hv_pmos w=16u l=2u m=1
Mxmpc1 x1a vbpc p1 vdda sg13_hv_pmos w=16u l=2u m=1
Mxmpc2 x1b vbpc p2 vdda sg13_hv_pmos w=16u l=2u m=1
Mxmoa outp x1a vss_o vss sg13_hv_nmos w=16u l=0.5u m=1
Mxmob outn x1b vss_o vss sg13_hv_nmos w=16u l=0.5u m=1
Mxmla outp vbl vdd vdd sg13_lv_pmos w=40u l=0.25u m=1
Mxmlb outn vbl vdd vdd sg13_lv_pmos w=40u l=0.25u m=1
Rxrza x1a cza vss rppd w=1u l=3.6u m=1 b=0
Cxcca cza outp cap_cmim w=12u l=12u m=1
Rxrzb x1b czb vss rppd w=1u l=3.6u m=1 b=0
Cxccb czb outn cap_cmim w=12u l=12u m=1
Rxrca_s0 outp xrca_n1 vss rhigh w=1u l=37.5u m=1 b=0
Rxrca_s1 xrca_n1 xrca_n2 vss rhigh w=1u l=37.5u m=1 b=0
Rxrca_s2 xrca_n2 xrca_n3 vss rhigh w=1u l=37.5u m=1 b=0
Rxrca_s3 xrca_n3 vcms vss rhigh w=1u l=37.5u m=1 b=0
Rxrcb_s0 outn xrcb_n1 vss rhigh w=1u l=37.5u m=1 b=0
Rxrcb_s1 xrcb_n1 xrcb_n2 vss rhigh w=1u l=37.5u m=1 b=0
Rxrcb_s2 xrcb_n2 xrcb_n3 vss rhigh w=1u l=37.5u m=1 b=0
Rxrcb_s3 xrcb_n3 vcms vss rhigh w=1u l=37.5u m=1 b=0
Cxcma outp vcms cap_cmim w=8u l=8u m=1
Cxcmb outn vcms cap_cmim w=8u l=8u m=1
Mxmtc ctail vbp vdda vdda sg13_hv_pmos w=24u l=2u m=1
Mxmf1 vcmfb vcms sf1 ctail sg13_hv_pmos w=24u l=1u m=1
Mxmf2 vcmd vint sf2 ctail sg13_hv_pmos w=24u l=1u m=1
Rxrdg1_s0 ctail xrdg1_n1 vss rppd w=1u l=25u m=1 b=0
Rxrdg1_s1 xrdg1_n1 sf1 vss rppd w=1u l=25u m=1 b=0
Rxrdg2_s0 ctail xrdg2_n1 vss rppd w=1u l=25u m=1 b=0
Rxrdg2_s1 xrdg2_n1 sf2 vss rppd w=1u l=25u m=1 b=0
Mxmtg gtail vbp vdda vdda sg13_hv_pmos w=0.5u l=2u m=1
Mxmg1 vint vcms gtail gtail sg13_hv_pmos w=1u l=24u m=1
Mxmg2 vgd vcm gtail gtail sg13_hv_pmos w=1u l=24u m=1
Mxmgd vgd vgd vss vss sg13_hv_nmos w=8u l=32u m=1
Mxmgm vint vgd vss vss sg13_hv_nmos w=8u l=32u m=1
Cxci vint vcm cap_cmim w=36u l=36u m=1
Mxmfd vcmfs vcmfb vss vss sg13_hv_nmos w=24u l=2u m=1
Mxmfdc vcmfb vbnc vcmfs vss sg13_hv_nmos w=30u l=2u m=1
Mxmfe vcmds vcmd vss vss sg13_hv_nmos w=24u l=2u m=1
Mxmfec vcmd vbnc vcmds vss sg13_hv_nmos w=30u l=2u m=1
Mxsh1 h1 azh xh1 vss sg13_hv_nmos w=1u l=0.45u m=1
Mxsh2 h2 azh xh2 vss sg13_hv_nmos w=1u l=0.45u m=1
Cxch1 h1 vss cap_cmim w=26u l=26u m=1
Cxch2 h2 vss cap_cmim w=26u l=26u m=1
Rxrh1 x1a xh1 vss rhigh w=1u l=37.5u m=1 b=0
Rxrh2 x1b xh2 vss rhigh w=1u l=37.5u m=1 b=0
Mxsfa outn azb rfoa vss sg13_hv_nmos w=40u l=0.45u m=1
Mxsfb outp azb rfob vss sg13_hv_nmos w=40u l=0.45u m=1
Mxsva rfoa az vcm vss sg13_hv_nmos w=4u l=0.45u m=1
Mxsvb rfob az vcm vss sg13_hv_nmos w=4u l=0.45u m=1
.ends
.subckt r1_isense isa_p isa_n isb_p isb_n outa_p outa_n outb_p outb_n vref vcm ibias_a ibias_b az_a azh_a az_b azh_b vdda vdd vss
Xxcha isa_p isa_n outa_p outa_n vref vcm ibias_a az_a azh_a vdda vdd vss vss vss vss r1_isense_ch
Xxchb isb_p isb_n outb_p outb_n vref vcm ibias_b az_b azh_b vdda vdd vss vss vss vss r1_isense_ch
.ends
