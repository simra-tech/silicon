* T10 diagnostic: g1_t2f rev2 alone, ideal rails from the fast view (27 C), production options; does xqa1 abort?
.lib /foss/pdks/ihp-sg13g2/libs.tech/ngspice/models/cornerMOSlv.lib mos_tt
.lib /foss/pdks/ihp-sg13g2/libs.tech/ngspice/models/cornerMOShv.lib mos_tt
.lib /foss/pdks/ihp-sg13g2/libs.tech/ngspice/models/cornerRES.lib res_typ
.lib /foss/pdks/ihp-sg13g2/libs.tech/ngspice/models/cornerCAP.lib cap_typ
.lib /foss/pdks/ihp-sg13g2/libs.tech/ngspice/models/cornerHBT.lib hbt_typ
.lib /foss/pdks/ihp-sg13g2/libs.tech/ngspice/models/cornerDIO.lib dio_tt
.include /work/designs/r1-joint/blocks/r1_t2f/schematic/g1_t2f_rev2.spice
.temp 27
.option method=gear maxord=2 reltol=1e-4 abstol=1e-12 vntol=1e-5 chgtol=1e-14 gmin=1e-15 itl4=100 klu rshunt=1e12
.global sub!
Vsub sub! 0 0
Vdda vdda 0 3.3
Vdd vdd 0 1.2
Vref vref 0 1.0449
Bpb pbias 0 V=v(vdda)-1.00273
Bpc pcasc 0 V=v(vdda)-1.54743
Ven en 0 pwl(0 0 1u 0 1.01u 3.3)
Vmode mode 0 0
X1 vdda vdd 0 pbias pcasc vref en mode fout g1_t2f
Cf fout 0 5f
.save v(fout)
.control
tran 1n 12u 0 5n
rusage all
write tran.raw
.endc
.end
