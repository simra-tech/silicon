* R1 full-chip testbench (T10) test 6: oscillator: OSC_COUNT against the frequency of the transistor-level r1_osc in the deck
* view pex, corner tt, 27 degC, run t10-t6-pex-d; generated by tb/run_tb.py; chip netlist tb/r1_chip.sp
.lib /foss/pdks/ihp-sg13g2/libs.tech/ngspice/models/cornerMOSlv.lib mos_tt
.lib /foss/pdks/ihp-sg13g2/libs.tech/ngspice/models/cornerMOShv.lib mos_tt
.lib /foss/pdks/ihp-sg13g2/libs.tech/ngspice/models/cornerRES.lib res_typ
.lib /foss/pdks/ihp-sg13g2/libs.tech/ngspice/models/cornerCAP.lib cap_typ
.lib /foss/pdks/ihp-sg13g2/libs.tech/ngspice/models/cornerHBT.lib hbt_typ
.lib /foss/pdks/ihp-sg13g2/libs.tech/ngspice/models/cornerDIO.lib dio_tt
.include <G1_RESULTS_ROOT>/r1_top/tb/t10-t6-pex-d/sg13g2_io_nodcn.spi
.include /foss/pdks/ihp-sg13g2/libs.ref/sg13g2_stdcell/spice/sg13g2_stdcell.spice
.include <G1_RESULTS_ROOT>/r1_top/tb/t10-t6-pex-d/view_pex.inc
.include <G1_RESULTS_ROOT>/r1_top/tb/t10-t6-pex-d/ctrl_rtl.inc
.include <G1_RESULTS_ROOT>/r1_top/tb/t10-t6-pex-d/r1_chip_nodcn.sp
.temp 27
.option method=gear maxord=2 reltol=1e-4 abstol=1e-12 vntol=1e-5 chgtol=1e-14 gmin=1e-15 itl4=100 klu rshunt=1e12
* ---------------- board ----------------
* supplies: one 3.3 V rail for VDDA (pad 7) and IOVDD (PLAN D14), 1.2 V VDD; 0.5 Ohm + 1 nF per rail (G1 board)
* decks 2-5 (deviation D2, --start op): supplies on from the operating point; tb_rst_n resets the macro
V33 rail33 0 3.3
V12 rail12 0 1.2
Vm_vdda rail33 vdda_s 0
Rs_vdda vdda_s VDDA 0.5
Cd_vdda VDDA 0 1n
Vm_iovdd rail33 iovdd_s 0
Rs_iovdd iovdd_s IOVDD 0.5
Cd_iovdd IOVDD 0 1n
Vm_vdd rail12 vdd_s 0
Rs_vdd vdd_s VDD 0.5
Cd_vdd VDD 0 1n
Vm_vss VSS 0 0
Vm_iovss IOVSS 0 0
* encoder head: 1 Vpp differential (0.25 V amplitude per side), 0.5 V CM, 0 Hz electrical, theta0 30 deg,
* 100 Ohm source resistance per line (assumed head output)
Bsp hsp 0 V=0.5+0.25*sin((6.283185307179586*0*time+0.523598775598))
Bsn hsn 0 V=0.5-0.25*sin((6.283185307179586*0*time+0.523598775598))
Bcp hcp 0 V=0.5+0.25*cos((6.283185307179586*0*time+0.523598775598))
Bcn hcn 0 V=0.5-0.25*cos((6.283185307179586*0*time+0.523598775598))
Rh_sin_p hsp SIN_P 100
Rh_sin_n hsn SIN_N 100
Rh_cos_p hcp COS_P 100
Rh_cos_n hcn COS_N 100
* shunts: V = level(selector) x low-side FET on (GATE pad, smooth), 10 ns RC; Kelvin traces 1 Ohm; ISx_N at ground
Bsha sha_i 0 V=(((4*(v(tbs_a2)>0.6)+2*(v(tbs_a1)>0.6)+(v(tbs_a0)>0.6))==1 ? 0.03 : ((4*(v(tbs_a2)>0.6)+2*(v(tbs_a1)>0.6)+(v(tbs_a0)>0.6))==2 ? 0.09 : ((4*(v(tbs_a2)>0.6)+2*(v(tbs_a1)>0.6)+(v(tbs_a0)>0.6))==3 ? 0.1 : 0))))*(0.5+0.5*tanh((v(GATE_A)-1.65)/0.15))
Bshb shb_i 0 V=(((4*(v(tbs_b2)>0.6)+2*(v(tbs_b1)>0.6)+(v(tbs_b0)>0.6))==1 ? 0.08 : ((4*(v(tbs_b2)>0.6)+2*(v(tbs_b1)>0.6)+(v(tbs_b0)>0.6))==2 ? 0.01 : 0)))*(0.5+0.5*tanh((v(GATE_B)-1.65)/0.15))
Rsha sha_i shunt_a 10
Csha shunt_a 0 1n
Rshb shb_i shunt_b 10
Cshb shunt_b 0 1n
Rk_isa_p shunt_a ISA_P 1
Rk_isa_n 0 ISA_N 1
Rk_isb_p shunt_b ISB_P 1
Rk_isb_n 0 ISB_N 1
* gate loads 1 nF (spec gate-drive row, D19); FAULT_N and SLO/SDO 10 pF
Cl_gate_a GATE_A 0 1n
Cl_gate_b GATE_B 0 1n
Cl_gate_c GATE_C 0 1n
Cl_fault FAULT_N 0 10p
Cl_slo SLO_SDO 0 10p
* master pad drives (dac_bridge 0 / 3.3 V inside XU_CTRL) through 50 Ohm board lines
Rb_cs_n tbm_cs_n CS_N 50
Rb_ma_sclk tbm_sclk MA_SCLK 50
Rb_sdi tbm_sdi SDI 50
Rb_en_sto_in tbm_en EN_STO_IN 50
.save v(SIN_P) v(SIN_N) v(COS_P) v(COS_N) v(ISA_P) v(ISA_N) v(ISB_P) v(ISB_N) v(CS_N) v(MA_SCLK) v(SDI) v(EN_STO_IN) v(FAULT_N) v(SLO_SDO) v(GATE_A) v(GATE_B) v(GATE_C) v(VDD) v(VDDA) v(vref_bg) v(vref_l) v(por_n) v(osc_clk) v(t2f_fout) v(souts_p) v(souts_n) v(soutc_p) v(soutc_n) v(vcm2) v(vcm) v(outa_p) v(outa_n) v(outb_p) v(outb_n) v(cmp_oc_a) v(cmp_neg_a) v(cmp_oc_b) v(cmp_neg_b) v(adc_hold) v(is_smp) v(adc_start) v(az_a) v(pbias) v(pcasc) v(ib_afe_s1) v(ib_is_a) v(ib_sf_oa) v(ib_adc_ref) v(pwm_a) v(fault_n_c2p) v(xu_adc.vrefo) v(xu_adc.vreflo) v(shunt_a) v(shunt_b) v(seq_stb0) v(seq_stb13)
.save i(Vm_vdda) i(Vm_iovdd) i(Vm_vdd)
.control
set num_threads=1
tran 1n 12.5u 0 5n
rusage all
write <G1_RESULTS_ROOT>/r1_top/tb/t10-t6-pex-d/tran.raw
.endc
.end
