* r1_bias generated by gen_r1_bias.py c_filt=18 l_dv=27 l_in=24 l_ld=20 l_nb=2 l_o=1 l_ra=45.9 l_rb=260.3 l_rpd=735 l_u=4 m_b=5 m_in=4 m_o=4 m_s=4 m_t=2 n_b=10 n_cc=2 n_st=20 n_t1=16 n_t2=1 rep_local=0 s_cc=48.3 vb_units=1 w_c=32 w_cpl=10 w_gl=2.5 w_in=8 w_ld=5 w_nb=5 w_o=10 w_s=10 w_tail=5 w_u=12
* Revision 2 (T9, 2026-10-26, D20: VREF buffer r1_vbuf, pins vref and vref_b, internal leg ibvb) on revision 1d (2026-10-21; 1b: local POR rail, 1c: 0.5 pF filters on vrh, vrl, tapa, 1d: pass-gate down-shifter). Supply VDDA 3.0-3.6 V (thick-oxide sg13_hv_*), VDD 1.2 V for the por_n output only.

* r1_bias_leg: one cascoded PMOS output leg from the r1_bgr rails, m units of w_u/l_u (mirror and cascode).
* The output sources current into the consumer's NMOS diode. Cascode body = its source (as in r1_bgr).
.subckt r1_bias_leg out pbias pcasc vdda m=1
XMP d pbias vdda vdda sg13_hv_pmos w=12u l=4u ng=1 m={m} mm_ok=1
XMC out pcasc d d sg13_hv_pmos w=12u l=4u ng=1 m={m} mm_ok=1
.ends r1_bias_leg

.subckt r1_por_inv a y vdda vss
XP y a vdda vdda sg13_hv_pmos w=1u l=0.5u ng=1 m=1 mm_ok=1
XN y a vss vss sg13_hv_nmos w=0.5u l=0.5u ng=1 m=1 mm_ok=1
.ends r1_por_inv
.subckt r1_por_nand2 a b y vdda vss
XP1 y a vdda vdda sg13_hv_pmos w=1u l=0.5u ng=1 m=1 mm_ok=1
XP2 y b vdda vdda sg13_hv_pmos w=1u l=0.5u ng=1 m=1 mm_ok=1
XN1 y a x vss sg13_hv_nmos w=1u l=0.5u ng=1 m=1 mm_ok=1
XN2 x b vss vss sg13_hv_nmos w=1u l=0.5u ng=1 m=1 mm_ok=1
.ends r1_por_nand2

* r1_por_cmp: open-loop two-stage comparator, PMOS input pair, tail from pbias (no cascode: headroom).
* o low <=> inp > inn. No feedback loop inside; the hysteresis loop is closed outside by switching the threshold.
.subckt r1_por_cmp inp inn o pbias vdda vss
* (pin pbias is connected to the local POR rail pl in r1_por)
XMT tail pbias vdda vdda sg13_hv_pmos w=5u l=4u ng=1 m=1 mm_ok=1
XM1 d1 inp tail vdda sg13_hv_pmos w=8u l=2u ng=1 m=1 mm_ok=1
XM2 d2 inn tail vdda sg13_hv_pmos w=8u l=2u ng=1 m=1 mm_ok=1
XML1 d1 d1 vss vss sg13_hv_nmos w=2u l=4u ng=1 m=1 mm_ok=1
XML2 d2 d1 vss vss sg13_hv_nmos w=2u l=4u ng=1 m=1 mm_ok=1
XMG o d2 vss vss sg13_hv_nmos w=1u l=2u ng=1 m=1 mm_ok=1
XMGL o pbias vdda vdda sg13_hv_pmos w=2.5u l=4u ng=1 m=1 mm_ok=1
.ends r1_por_cmp

* r1_por_schmitt: 6-transistor Schmitt inverter on the delay capacitor (VDDA domain).
.subckt r1_por_schmitt a y vdda vss
XP1 sp a vdda vdda sg13_hv_pmos w=1u l=0.5u ng=1 m=1 mm_ok=1
XP2 y a sp vdda sg13_hv_pmos w=1u l=0.5u ng=1 m=1 mm_ok=1
XP3 sp y vss vdda sg13_hv_pmos w=1u l=0.5u ng=1 m=1 mm_ok=1
XN1 sn a vss vss sg13_hv_nmos w=0.5u l=0.5u ng=1 m=1 mm_ok=1
XN2 y a sn vss sg13_hv_nmos w=0.5u l=0.5u ng=1 m=1 mm_ok=1
XN3 sn y vdda vss sg13_hv_nmos w=0.5u l=0.5u ng=1 m=1 mm_ok=1
.ends r1_por_schmitt

* r1_por: power-on reset. por_n (VDD domain) = 1 only when VDDA > 2.70 V (falling 2.60 V) AND VDD > 1.00 V
* (falling 0.95 V) have held for the delay (MIM charged by a PMOS stack from pbias; reset at once when either
* supply is low). Reference: replica of the r1_bgr output leg with a shorter R (vrh 1.00 V, tap vrl 0.95 V);
* it does not load the r1_bgr vref node.
.subckt r1_por vdda vdd vss pbias pcasc por_n
* replica reference
XMPR dr pbias vdda vdda sg13_hv_pmos w=10u l=4u ng=1 m=1 mm_ok=1
XMCR vrh pcasc dr dr sg13_hv_pmos w=10u l=4u ng=1 m=1 mm_ok=1
XRRA vrh vrl sub! rppd w=1u l=45.9u m=1 b=0 mm_ok=1
XRRB vrl vq sub! rppd w=1u l=260.3u m=1 b=0 mm_ok=1
XQR_0 vq vq vss vss npn13G2 Nx=1 mm_ok=1
XQR_1 vq vq vss vss npn13G2 Nx=1 mm_ok=1
XQR_2 vq vq vss vss npn13G2 Nx=1 mm_ok=1
XQR_3 vq vq vss vss npn13G2 Nx=1 mm_ok=1
* local bias rail pl (revision 1b): one cascoded bgr leg -> NMOS diode -> NMOS mirror -> PMOS diode pl,
* decoupled to vdda. Comparator tails, second-stage loads and the delay stack hang on pl, so their switching
* edges do not reach the r1_bgr pbias node (chain a/b: solver stalls in r1_bgr at every comparator edge).
XMPL dl pbias vdda vdda sg13_hv_pmos w=10u l=4u ng=1 m=1 mm_ok=1
XMCL nl pcasc dl dl sg13_hv_pmos w=10u l=4u ng=1 m=1 mm_ok=1
XNL nl nl vss vss sg13_hv_nmos w=4u l=4u ng=1 m=1 mm_ok=1
XNM pl nl vss vss sg13_hv_nmos w=4u l=4u ng=1 m=1 mm_ok=1
XPL pl pl vdda vdda sg13_hv_pmos w=10u l=4u ng=1 m=1 mm_ok=1
XCPL vdda pl vdda vdda sg13_hv_pmos w=10u l=10u ng=1 m=1 mm_ok=1
* VDDA divider (rhigh units): vdda - Rt1 - na - Rt2 - tapa - Rb - vss; Rt2 shorted while VDDA is good
XRT1_0 vdda dt1_1 sub! rhigh w=0.5u l=27u m=1 b=0 mm_ok=1
XRT1_1 dt1_1 dt1_2 sub! rhigh w=0.5u l=27u m=1 b=0 mm_ok=1
XRT1_2 dt1_2 dt1_3 sub! rhigh w=0.5u l=27u m=1 b=0 mm_ok=1
XRT1_3 dt1_3 dt1_4 sub! rhigh w=0.5u l=27u m=1 b=0 mm_ok=1
XRT1_4 dt1_4 dt1_5 sub! rhigh w=0.5u l=27u m=1 b=0 mm_ok=1
XRT1_5 dt1_5 dt1_6 sub! rhigh w=0.5u l=27u m=1 b=0 mm_ok=1
XRT1_6 dt1_6 dt1_7 sub! rhigh w=0.5u l=27u m=1 b=0 mm_ok=1
XRT1_7 dt1_7 dt1_8 sub! rhigh w=0.5u l=27u m=1 b=0 mm_ok=1
XRT1_8 dt1_8 dt1_9 sub! rhigh w=0.5u l=27u m=1 b=0 mm_ok=1
XRT1_9 dt1_9 dt1_10 sub! rhigh w=0.5u l=27u m=1 b=0 mm_ok=1
XRT1_10 dt1_10 dt1_11 sub! rhigh w=0.5u l=27u m=1 b=0 mm_ok=1
XRT1_11 dt1_11 dt1_12 sub! rhigh w=0.5u l=27u m=1 b=0 mm_ok=1
XRT1_12 dt1_12 dt1_13 sub! rhigh w=0.5u l=27u m=1 b=0 mm_ok=1
XRT1_13 dt1_13 dt1_14 sub! rhigh w=0.5u l=27u m=1 b=0 mm_ok=1
XRT1_14 dt1_14 dt1_15 sub! rhigh w=0.5u l=27u m=1 b=0 mm_ok=1
XRT1_15 dt1_15 na sub! rhigh w=0.5u l=27u m=1 b=0 mm_ok=1
XRT2_0 na tapa sub! rhigh w=0.5u l=27u m=1 b=0 mm_ok=1
XRB_0 tapa db_1 sub! rhigh w=0.5u l=27u m=1 b=0 mm_ok=1
XRB_1 db_1 db_2 sub! rhigh w=0.5u l=27u m=1 b=0 mm_ok=1
XRB_2 db_2 db_3 sub! rhigh w=0.5u l=27u m=1 b=0 mm_ok=1
XRB_3 db_3 db_4 sub! rhigh w=0.5u l=27u m=1 b=0 mm_ok=1
XRB_4 db_4 db_5 sub! rhigh w=0.5u l=27u m=1 b=0 mm_ok=1
XRB_5 db_5 db_6 sub! rhigh w=0.5u l=27u m=1 b=0 mm_ok=1
XRB_6 db_6 db_7 sub! rhigh w=0.5u l=27u m=1 b=0 mm_ok=1
XRB_7 db_7 db_8 sub! rhigh w=0.5u l=27u m=1 b=0 mm_ok=1
XRB_8 db_8 db_9 sub! rhigh w=0.5u l=27u m=1 b=0 mm_ok=1
XRB_9 db_9 vss sub! rhigh w=0.5u l=27u m=1 b=0 mm_ok=1
XHA na gooda tapa vss sg13_hv_nmos w=1u l=0.5u ng=1 m=1 mm_ok=1
* comparators: A = VDDA tap vs vrh; D = VDD vs refd (vrh while VDD is bad, vrl while it is good)
XCF_vrh vrh vss cap_cmim w=18u l=18u m=1 mm_ok=1
XCF_vrl vrl vss cap_cmim w=18u l=18u m=1 mm_ok=1
XCF_tapa tapa vss cap_cmim w=18u l=18u m=1 mm_ok=1
XCA tapa vrh oa pl vdda vss r1_por_cmp
XCD vdd refd od pl vdda vss r1_por_cmp
XIA oa gooda vdda vss r1_por_inv
XID od goodd vdda vss r1_por_inv
XIDB goodd badd vdda vss r1_por_inv
XHD1 refd goodd vrl vss sg13_hv_nmos w=1u l=0.5u ng=1 m=1 mm_ok=1
XHD2 refd badd vrh vss sg13_hv_nmos w=1u l=0.5u ng=1 m=1 mm_ok=1
* rst = NOT (gooda AND goodd): discharges the delay capacitor
XNR gooda goodd rst vdda vss r1_por_nand2
* delay: PMOS stack from pbias charges the MIM; Schmitt; ready = NOT sy
XST_0 st_1 pl vdda vdda sg13_hv_pmos w=0.5u l=4u ng=1 m=1 mm_ok=1
XST_1 st_2 pl st_1 vdda sg13_hv_pmos w=0.5u l=4u ng=1 m=1 mm_ok=1
XST_2 st_3 pl st_2 vdda sg13_hv_pmos w=0.5u l=4u ng=1 m=1 mm_ok=1
XST_3 st_4 pl st_3 vdda sg13_hv_pmos w=0.5u l=4u ng=1 m=1 mm_ok=1
XST_4 st_5 pl st_4 vdda sg13_hv_pmos w=0.5u l=4u ng=1 m=1 mm_ok=1
XST_5 st_6 pl st_5 vdda sg13_hv_pmos w=0.5u l=4u ng=1 m=1 mm_ok=1
XST_6 st_7 pl st_6 vdda sg13_hv_pmos w=0.5u l=4u ng=1 m=1 mm_ok=1
XST_7 st_8 pl st_7 vdda sg13_hv_pmos w=0.5u l=4u ng=1 m=1 mm_ok=1
XST_8 st_9 pl st_8 vdda sg13_hv_pmos w=0.5u l=4u ng=1 m=1 mm_ok=1
XST_9 st_10 pl st_9 vdda sg13_hv_pmos w=0.5u l=4u ng=1 m=1 mm_ok=1
XST_10 st_11 pl st_10 vdda sg13_hv_pmos w=0.5u l=4u ng=1 m=1 mm_ok=1
XST_11 st_12 pl st_11 vdda sg13_hv_pmos w=0.5u l=4u ng=1 m=1 mm_ok=1
XST_12 st_13 pl st_12 vdda sg13_hv_pmos w=0.5u l=4u ng=1 m=1 mm_ok=1
XST_13 st_14 pl st_13 vdda sg13_hv_pmos w=0.5u l=4u ng=1 m=1 mm_ok=1
XST_14 st_15 pl st_14 vdda sg13_hv_pmos w=0.5u l=4u ng=1 m=1 mm_ok=1
XST_15 st_16 pl st_15 vdda sg13_hv_pmos w=0.5u l=4u ng=1 m=1 mm_ok=1
XST_16 st_17 pl st_16 vdda sg13_hv_pmos w=0.5u l=4u ng=1 m=1 mm_ok=1
XST_17 st_18 pl st_17 vdda sg13_hv_pmos w=0.5u l=4u ng=1 m=1 mm_ok=1
XST_18 st_19 pl st_18 vdda sg13_hv_pmos w=0.5u l=4u ng=1 m=1 mm_ok=1
XST_19 cdel pl st_19 vdda sg13_hv_pmos w=0.5u l=4u ng=1 m=1 mm_ok=1
XCDEL cdel vss cap_cmim w=32u l=32u m=1 mm_ok=1
XRST cdel rst vss vss sg13_hv_nmos w=1u l=0.5u ng=1 m=1 mm_ok=1
XSCH cdel sy vdda vss r1_por_schmitt
XIR sy ready vdda vss r1_por_inv
* down-shift to the 1.2 V domain (revision 1d): thick NMOS pass from VDD gated by ready (VDDA level), rhigh
* pull-down (about 2 MOhm) on por_raw, then two thin inverters. por_raw is defined low whenever ready is low or
* VDDA is absent, so por_n cannot follow a fast VDD ramp (revision 1c inverter pair did: chain c, ff 10 us ramp).
XDPS vdd ready por_raw vss sg13_hv_nmos w=1u l=0.5u ng=1 m=1 mm_ok=1
XRPD por_raw vss sub! rhigh w=0.5u l=735u m=1 b=0 mm_ok=1
XDP1 o3 por_raw vdd vdd sg13_lv_pmos w=1u l=0.13u ng=1 m=1 mm_ok=1
XDN1 o3 por_raw vss vss sg13_lv_nmos w=0.5u l=0.13u ng=1 m=1 mm_ok=1
XDP2 por_n o3 vdd vdd sg13_lv_pmos w=1u l=0.13u ng=1 m=1 mm_ok=1
XDN2 por_n o3 vss vss sg13_lv_nmos w=0.5u l=0.13u ng=1 m=1 mm_ok=1
.ends r1_por

* r1_vbuf (revision 2, decision D20): unity-gain buffer of the raw bandgap vref (gate input only) for the
* r1_safe string, the r1_isense pedestal arms and the r1_t2f vref pin. Two stages: NMOS input pair
* (XM1 gate = vin = raw vref on the mirror-diode side, XM2 gate = vout), PMOS mirror load, high-impedance node x1
* compensated by XCC to vss (dominant pole), NMOS source follower XM7 (drain at vdda: sources the load current),
* NMOS sink XM8. The output device has its drain on the supply, so a vdda step does not move vout through
* a gate-source path (the PMOS common-source version of 2026-10-26 failed the supply step). Bias: the r1_bias
* leg ibvb sources into the NMOS diode XMB (5 units, 1 uA each at tt); tail XMT 2 units (2 uA), sink XM8 4 units of
* twice the width (8 uA). No enable, no trim.
.subckt r1_vbuf vin vout ibn vdda vss
XM1 d1 vin ns vss sg13_hv_nmos w=8u l=24u ng=1 m=4 mm_ok=1
XM2 x1 vout ns vss sg13_hv_nmos w=8u l=24u ng=1 m=4 mm_ok=1
XM3 d1 d1 vdda vdda sg13_hv_pmos w=5u l=20u ng=1 m=1 mm_ok=1
XM4 x1 d1 vdda vdda sg13_hv_pmos w=5u l=20u ng=1 m=1 mm_ok=1
XMB ibn ibn vss vss sg13_hv_nmos w=5u l=2u ng=1 m=5 mm_ok=1
XMT ns ibn vss vss sg13_hv_nmos w=5u l=2u ng=1 m=2 mm_ok=1
XM8 vout ibn vss vss sg13_hv_nmos w=10u l=2u ng=1 m=4 mm_ok=1
XM7 vdda x1 vout vss sg13_hv_nmos w=10u l=1u ng=1 m=4 mm_ok=1
XCC1 x1 vss cap_cmim w=48.3u l=48.3u m=1 mm_ok=1
XCC2 x1 vss cap_cmim w=48.3u l=48.3u m=1 mm_ok=1
.ends r1_vbuf

* r1_bias top: 11 output legs (15 units) + 1 internal leg unit(s) + r1_por + r1_vbuf. pbias/pcasc are inputs from r1_bgr (the T2F takes them directly).
* Revision 2: input vref (raw r1_bgr output, gate load only), output vref_b (buffered, D20).
.subckt r1_bias vdda vdd vss pbias pcasc ib_afe_s1 ib_afe_s2 ib_afe_c1 ib_afe_c2 ib_is_a ib_is_b ib_sf_oa ib_sf_na ib_sf_ob ib_sf_nb ib_adc_ref por_n vref vref_b
XL_ib_afe_s1 ib_afe_s1 pbias pcasc vdda r1_bias_leg m=2
XL_ib_afe_s2 ib_afe_s2 pbias pcasc vdda r1_bias_leg m=2
XL_ib_afe_c1 ib_afe_c1 pbias pcasc vdda r1_bias_leg m=2
XL_ib_afe_c2 ib_afe_c2 pbias pcasc vdda r1_bias_leg m=2
XL_ib_is_a ib_is_a pbias pcasc vdda r1_bias_leg m=1
XL_ib_is_b ib_is_b pbias pcasc vdda r1_bias_leg m=1
XL_ib_sf_oa ib_sf_oa pbias pcasc vdda r1_bias_leg m=1
XL_ib_sf_na ib_sf_na pbias pcasc vdda r1_bias_leg m=1
XL_ib_sf_ob ib_sf_ob pbias pcasc vdda r1_bias_leg m=1
XL_ib_sf_nb ib_sf_nb pbias pcasc vdda r1_bias_leg m=1
XL_ib_adc_ref ib_adc_ref pbias pcasc vdda r1_bias_leg m=1
XL_ibvb ibvb pbias pcasc vdda r1_bias_leg m=1
XPOR vdda vdd vss pbias pcasc por_n r1_por
XVB vref vref_b ibvb vdda vss r1_vbuf
.ends r1_bias
