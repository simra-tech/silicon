* T10 test 1a: power-up subset (r1_bgr + r1_bias/r1_por + r1_osc), run t10-t1a-osc-a
.lib /foss/pdks/ihp-sg13g2/libs.tech/ngspice/models/cornerHBT.lib hbt_typ
.lib /foss/pdks/ihp-sg13g2/libs.tech/ngspice/models/cornerMOShv.lib mos_tt
.lib /foss/pdks/ihp-sg13g2/libs.tech/ngspice/models/cornerMOSlv.lib mos_tt
.lib /foss/pdks/ihp-sg13g2/libs.tech/ngspice/models/cornerRES.lib res_typ
.lib /foss/pdks/ihp-sg13g2/libs.tech/ngspice/models/cornerCAP.lib cap_typ
.lib /foss/pdks/ihp-sg13g2/libs.tech/ngspice/models/cornerDIO.lib dio_tt
.include /work/designs/r1-joint/blocks/r1_osc/schematic/r1_osc.spice
.option method=gear reltol=1e-4 abstol=1e-12 vntol=1e-6 chgtol=1e-15 gmin=1e-15 itl4=100 klu
.temp 27
.global sub!
Vsub sub! 0 0
* rails: VDDA 0 -> 3.3 V in 10 us from 1 us, VDD 0 -> 1.2 V in 10 us from 2 us
Vdda vdda 0 pwl(0 0 1u 0 11u 3.3)
Vdd vdd 0 pwl(0 0 2u 0 12u 1.2)
Vdl vdl 0 dc 1.0
* r1_osc: enable tie-high (chip XU_TIE_OSC), trim code 22 = 10110 (ctrl OSC_CFG reset value) at VDD level
Btr4 tr4 0 V=v(vdd)
Btr3 tr3 0 V=0
Btr2 tr2 0 V=v(vdd)
Btr1 tr1 0 V=v(vdd)
Btr0 tr0 0 V=0
Ben osc_en 0 V=v(vdd)
Xosc osc_en tr0 tr1 tr2 tr3 tr4 osc_clk vdd 0 r1_osc
Cosc osc_clk 0 20f
.save v(vdda) v(vdd) v(osc_clk)
.control
tran 1n 20u 0 0.2n uic
rusage all
write <G1_RESULTS_ROOT>/r1_top/tb/t10-t1a-osc-a/tran.raw
.endc
.end
