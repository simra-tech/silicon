* r1_chip.sp -- R1 full-chip testbench netlist (track T10), generated by tb/gen_chip.py; do not edit
* Top-level nodes: pads in upper case (spec section 3), internal nets as the chip LVS reference (lower case).
* Needs: PDK models, sg13g2_io.spice, sg13g2_stdcell.spice, one block view (views/sch.inc), views/ctrl_rtl.inc.

* ---------------- pads (PDK sg13g2_io cells; core side = pad terminal for the analog pads, as the chip CDL) ----
XP_sin_p SIN_P padres_sin_p VDD VSS IOVDD IOVSS sg13g2_IOPadAnalog
XP_sin_n SIN_N padres_sin_n VDD VSS IOVDD IOVSS sg13g2_IOPadAnalog
XP_cos_p COS_P padres_cos_p VDD VSS IOVDD IOVSS sg13g2_IOPadAnalog
XP_cos_n COS_N padres_cos_n VDD VSS IOVDD IOVSS sg13g2_IOPadAnalog
XP_isa_p ISA_P padres_isa_p VDD VSS IOVDD IOVSS sg13g2_IOPadAnalog
XP_isa_n ISA_N padres_isa_n VDD VSS IOVDD IOVSS sg13g2_IOPadAnalog
XP_isb_p ISB_P padres_isb_p VDD VSS IOVDD IOVSS sg13g2_IOPadAnalog
XP_isb_n ISB_N padres_isb_n VDD VSS IOVDD IOVSS sg13g2_IOPadAnalog
XP_vdda VDDA padres_vdda VDD VSS IOVDD IOVSS sg13g2_IOPadAnalog
XP_cs_n CS_N cs_n_p2c VDD VSS IOVDD IOVSS sg13g2_IOPadIn
XP_ma_sclk MA_SCLK ma_sclk_p2c VDD VSS IOVDD IOVSS sg13g2_IOPadIn
XP_sdi SDI sdi_p2c VDD VSS IOVDD IOVSS sg13g2_IOPadIn
XP_en_sto_in EN_STO_IN en_sto_in_p2c VDD VSS IOVDD IOVSS sg13g2_IOPadIn
XP_fault_n FAULT_N fault_n_c2p VDD VSS IOVDD IOVSS sg13g2_IOPadOut4mA
XP_slo_sdo SLO_SDO slo_sdo_c2p VDD VSS IOVDD IOVSS sg13g2_IOPadOut4mA
XP_gate_a GATE_A gate_a_c2p VDD VSS IOVDD IOVSS sg13g2_IOPadOut30mA
XP_gate_b GATE_B gate_b_c2p VDD VSS IOVDD IOVSS sg13g2_IOPadOut30mA
XP_gate_c GATE_C gate_c_c2p VDD VSS IOVDD IOVSS sg13g2_IOPadOut30mA

* ---------------- analog blocks ----------------
XU_BGR VDDA VSS vref_bg bgr_iptat pbias pcasc bgr_vbe bgr_dvbe r1_bgr
* MODEL M6 (T10 finding R1): no block of record buffers vref_bg. r1_bgr has a source of about 180 kOhm; the
* r1_safe string (252 kOhm) and the r1_isense pedestals load it to 0.22 V (run t10-diag-nodeset-b). Ideal unity
* buffer with 10 Ohm output for the resistive loads (isense, safe). T2F and the ADC filter keep vref_bg (gate inputs).
Evref_m6 vref_m6i VSS vref_bg VSS 1
Rvref_m6 vref_m6i vref_l 10
XU_BIAS VDDA VDD VSS pbias pcasc ib_afe_s1 ib_afe_s2 ib_afe_c1 ib_afe_c2 ib_is_a ib_is_b ib_sf_oa ib_sf_na ib_sf_ob ib_sf_nb ib_adc_ref por_n r1_bias
XU_T2F VDDA VDD VSS pbias pcasc vref_bg t2f_en33 t2f_mode33 t2f_fout r1_t2f
* PENDING-IN-LAYOUT: t2f en/mode level shifters u_ls_t2f0/1 are placed but not connected in try e
XU_LS_T2F0 t2f_en t2f_en33 VDD VDDA VSS t10_ls
XU_LS_T2F1 t2f_mode t2f_mode33 VDD VDDA VSS t10_ls
* PENDING-IN-LAYOUT: PGA lines pga_c[3:0] -> u_ls_afe0..3 -> r1_afe c1..c4
XU_LS_AFE0 pga_c0 afe_c1 VDD VDDA VSS t10_ls
XU_LS_AFE1 pga_c1 afe_c2 VDD VDDA VSS t10_ls
XU_LS_AFE2 pga_c2 afe_c3 VDD VDDA VSS t10_ls
XU_LS_AFE3 pga_c3 afe_c4 VDD VDDA VSS t10_ls
* PENDING-IN-LAYOUT: AFE outputs and vcm2 to the ADC
XU_AFE SIN_P SIN_N COS_P COS_N souts_p souts_n soutc_p soutc_n vcm2 ib_afe_s1 ib_afe_s2 ib_afe_c1 ib_afe_c2 afe_c1 afe_c2 afe_c3 afe_c4 VDDA VSS r1_afe
* PENDING-IN-LAYOUT: isense outputs (to the ADC and to r1_safe), vcm, az/azh
XU_ISENSE ISA_P ISA_N ISB_P ISB_N outa_p outa_n outb_p outb_n vref_l vcm ib_is_a ib_is_b az_a azh_a az_b azh_b VDDA VDD VSS r1_isense
* PENDING-IN-LAYOUT: safe comparator inputs outa_p/n, outb_p/n (try e lists them as diagnostics) and the 64 tap
* inputs (ctrl 0.5 tap_p/tap_n; comparator i = 0 OC_A, 1 NEG_A, 2 OC_B, 3 NEG_B at [8i +: 8], bit 0 = LSB)
XU_SAFE outa_p outa_n outb_p outb_n vref_l
+ tap_p0 tap_p1 tap_p2 tap_p3 tap_p4 tap_p5 tap_p6 tap_p7 tap_n0 tap_n1 tap_n2 tap_n3 tap_n4 tap_n5 tap_n6 tap_n7
+ tap_p8 tap_p9 tap_p10 tap_p11 tap_p12 tap_p13 tap_p14 tap_p15 tap_n8 tap_n9 tap_n10 tap_n11 tap_n12 tap_n13 tap_n14 tap_n15
+ tap_p16 tap_p17 tap_p18 tap_p19 tap_p20 tap_p21 tap_p22 tap_p23 tap_n16 tap_n17 tap_n18 tap_n19 tap_n20 tap_n21 tap_n22 tap_n23
+ tap_p24 tap_p25 tap_p26 tap_p27 tap_p28 tap_p29 tap_p30 tap_p31 tap_n24 tap_n25 tap_n26 tap_n27 tap_n28 tap_n29 tap_n30 tap_n31
+ cmp_oc_a cmp_neg_a cmp_oc_b cmp_neg_b ib_sf_oa ib_sf_na ib_sf_ob ib_sf_nb VDDA VDD VSS r1_safe
* oscillator enable held high by a tie cell (as try e)
XU_TIE_OSC osc_en VDD VSS sg13g2_tiehi
XU_OSC osc_en osc_trim0 osc_trim1 osc_trim2 osc_trim3 osc_trim4 osc_clk VDD VSS r1_osc
* PENDING-IN-LAYOUT: the whole r1_adc (placeholder r1_adc_ph); pin list of the placeholder + cur_trk (testbench)
XU_ADC adc_hold is_smp osc_clk adc_start adc_sel adc_valid_a
+ adc_raw_a0 adc_raw_a1 adc_raw_a2 adc_raw_a3 adc_raw_a4 adc_raw_a5 adc_raw_a6 adc_raw_a7 adc_raw_a8 adc_raw_a9 adc_raw_a10 adc_raw_a11 adc_raw_a12 adc_raw_a13
+ adc_valid_b
+ adc_raw_b0 adc_raw_b1 adc_raw_b2 adc_raw_b3 adc_raw_b4 adc_raw_b5 adc_raw_b6 adc_raw_b7 adc_raw_b8 adc_raw_b9 adc_raw_b10 adc_raw_b11 adc_raw_b12 adc_raw_b13
+ por_n souts_p souts_n soutc_p soutc_n vcm2 ib_adc_ref outa_p outa_n outb_p outb_n vcm VDDA VDD VSS vref_bg cur_trk r1_adc
* gate path: ctrl gate_a/b/c (PWM AND gate_ok AND EN) -> r1_gate_lv -> 30 mA pads; gate_en tied to VDD (try e)
XU_GATE pwm_a pwm_b pwm_c VDD gate_a_c2p gate_b_c2p gate_c_c2p VDD gate_vdda_nc VSS r1_gate_lv
Rgate_vdda_nc gate_vdda_nc VSS 1e12

* ---------------- digital macro + testbench master (view views/ctrl_rtl.inc) ----------------
* XU_CTRL holds the r1_ctrl 0.5 RTL, the MODEL glue (rtl/r1_chip_dig.v) and the TESTBENCH master (rtl/t10_master.v)
* in one d_cosim instance. The last 13 pins are testbench pins (master pad drives, stimulus selector, pad probes).
XU_CTRL
+ osc_clk por_n cs_n_p2c ma_sclk_p2c sdi_p2c en_sto_in_p2c cmp_neg_b cmp_oc_b cmp_neg_a cmp_oc_a t2f_fout adc_valid_a adc_raw_a13 adc_raw_a12 adc_raw_a11 adc_raw_a10
+ adc_raw_a9 adc_raw_a8 adc_raw_a7 adc_raw_a6 adc_raw_a5 adc_raw_a4 adc_raw_a3 adc_raw_a2 adc_raw_a1 adc_raw_a0 adc_valid_b adc_raw_b13 adc_raw_b12 adc_raw_b11 adc_raw_b10 adc_raw_b9
+ adc_raw_b8 adc_raw_b7 adc_raw_b6 adc_raw_b5 adc_raw_b4 adc_raw_b3 adc_raw_b2 adc_raw_b1 adc_raw_b0 SLO_SDO FAULT_N GATE_A slo_sdo_c2p fault_n_c2p pwm_a pwm_b
+ pwm_c adc_hold is_smp adc_start adc_sel tap_p31 tap_p30 tap_p29 tap_p28 tap_p27 tap_p26 tap_p25 tap_p24 tap_p23 tap_p22 tap_p21
+ tap_p20 tap_p19 tap_p18 tap_p17 tap_p16 tap_p15 tap_p14 tap_p13 tap_p12 tap_p11 tap_p10 tap_p9 tap_p8 tap_p7 tap_p6 tap_p5
+ tap_p4 tap_p3 tap_p2 tap_p1 tap_p0 tap_n31 tap_n30 tap_n29 tap_n28 tap_n27 tap_n26 tap_n25 tap_n24 tap_n23 tap_n22 tap_n21
+ tap_n20 tap_n19 tap_n18 tap_n17 tap_n16 tap_n15 tap_n14 tap_n13 tap_n12 tap_n11 tap_n10 tap_n9 tap_n8 tap_n7 tap_n6 tap_n5
+ tap_n4 tap_n3 tap_n2 tap_n1 tap_n0 az_a azh_a az_b azh_b osc_trim4 osc_trim3 osc_trim2 osc_trim1 osc_trim0 pga_c3 pga_c2
+ pga_c1 pga_c0 t2f_en t2f_mode bias_en seq_trka0 seq_trka1 seq_trkb0 seq_trkb1 seq_win seq_lat seq_stb13 seq_stb12 seq_stb11 seq_stb10 seq_stb9
+ seq_stb8 seq_stb7 seq_stb6 seq_stb5 seq_stb4 seq_stb3 seq_stb2 seq_stb1 seq_stb0 seq_valid cur_trk tbm_cs_n tbm_sclk tbm_sdi tbm_en tbs_a2
+ tbs_a1 tbs_a0 tbs_b2 tbs_b1 tbs_b0 VDD VSS
+ r1_ctrl_top_tb
Rbias_en_nc bias_en VSS 1e9
