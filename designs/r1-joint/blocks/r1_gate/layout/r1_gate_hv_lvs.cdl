* CDL for KLayout LVS, generated by layout/make_lvs_cdl.py from schematic/r1_gate.spice and schematic/g1_cells_copy.spice (substrate net = vss)
.subckt g1_lv_inv a y vdd vss
MMP y a vdd vdd sg13_lv_pmos w=2u l=0.13u m=1
MMN y a vss vss sg13_lv_nmos w=1u l=0.13u m=1
.ends
.subckt g1_lvlup a y vdd vdda vss
XI a ab vdd vss g1_lv_inv
MMN1 nb a vss vss sg13_hv_nmos w=1.9u l=0.45u m=1
MMN2 n ab vss vss sg13_hv_nmos w=1.9u l=0.45u m=1
MMP1 nb n vdda vdda sg13_hv_pmos w=0.3u l=0.45u m=1
MMP2 n nb vdda vdda sg13_hv_pmos w=0.3u l=0.45u m=1
XO nb y vdda vss g1_hv_inv
.ends
.subckt g1_hv_nor2 a b y vdda vss
MMP1 m a vdda vdda sg13_hv_pmos w=7.8u l=0.45u m=1
MMP2 y b m vdda sg13_hv_pmos w=7.8u l=0.45u m=1
MMN1 y a vss vss sg13_hv_nmos w=1.9u l=0.45u m=1
MMN2 y b vss vss sg13_hv_nmos w=1.9u l=0.45u m=1
.ends
.subckt g1_hv_inv a y vdda vss
MMP y a vdda vdda sg13_hv_pmos w=3.9u l=0.45u m=1
MMN y a vss vss sg13_hv_nmos w=1.9u l=0.45u m=1
.ends
.subckt g1_lvldn a ab y vdd vss
MMN1 yb a vss vss sg13_hv_nmos w=2u l=0.45u m=1
MMN2 y ab vss vss sg13_hv_nmos w=2u l=0.45u m=1
MMP1 y yb vdd vdd sg13_lv_pmos w=1u l=0.13u m=1
MMP2 yb y vdd vdd sg13_lv_pmos w=1u l=0.13u m=1
.ends
.subckt r1_gate_hv pwm_a pwm_b pwm_c gate_en gc_a gc_b gc_c vdd vdda vss
XUE gate_en en_h vdd vdda vss g1_lvlup
XIE en_h en_hn vdda vss g1_hv_inv
XUA pwm_a pa_h vdd vdda vss g1_lvlup
XIA pa_h pa_hn vdda vss g1_hv_inv
XNA en_hn pa_hn ga_h vdda vss g1_hv_nor2
XGA ga_h ga_hn vdda vss g1_hv_inv
XDA ga_h ga_hn gc_a vdd vss g1_lvldn
XUB pwm_b pb_h vdd vdda vss g1_lvlup
XIB pb_h pb_hn vdda vss g1_hv_inv
XNB en_hn pb_hn gb_h vdda vss g1_hv_nor2
XGB gb_h gb_hn vdda vss g1_hv_inv
XDB gb_h gb_hn gc_b vdd vss g1_lvldn
XUC pwm_c pc_h vdd vdda vss g1_lvlup
XIC pc_h pc_hn vdda vss g1_hv_inv
XNC en_hn pc_hn gc_h vdda vss g1_hv_nor2
XGC gc_h gc_hn vdda vss g1_hv_inv
XDC gc_h gc_hn gc_c vdd vss g1_lvldn
.ends
