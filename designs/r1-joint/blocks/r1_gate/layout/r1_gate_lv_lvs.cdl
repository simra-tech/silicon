* CDL for KLayout LVS, generated by layout/make_lvs_cdl.py from schematic/r1_gate.spice and schematic/g1_cells_copy.spice (substrate net = vss)
.subckt g1_lv_nand2 a b y vdd vss
MMP1 y a vdd vdd sg13_lv_pmos w=2u l=0.13u m=1
MMP2 y b vdd vdd sg13_lv_pmos w=2u l=0.13u m=1
MMN1 y a m vss sg13_lv_nmos w=2u l=0.13u m=1
MMN2 m b vss vss sg13_lv_nmos w=2u l=0.13u m=1
.ends
.subckt g1_lv_inv a y vdd vss
MMP y a vdd vdd sg13_lv_pmos w=2u l=0.13u m=1
MMN y a vss vss sg13_lv_nmos w=1u l=0.13u m=1
.ends
.subckt r1_gate_lv pwm_a pwm_b pwm_c gate_en gc_a gc_b gc_c vdd vdda vss
XNA pwm_a gate_en na vdd vss g1_lv_nand2
XIA na gc_a vdd vss g1_lv_inv
XNB pwm_b gate_en nb vdd vss g1_lv_nand2
XIB nb gc_b vdd vss g1_lv_inv
XNC pwm_c gate_en nc vdd vss g1_lv_nand2
XIC nc gc_c vdd vss g1_lv_inv
.ends
