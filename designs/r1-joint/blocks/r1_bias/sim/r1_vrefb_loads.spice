* r1_bias revision 2 vref_b consumer loads (T9, 2026-10-26), written by make_vrefb_loads.py. Do not edit.
* Sources (sha256 at the time of copy):
*   r1_safe   schematic/r1_safe.spice   812f886dce2b759af121230bd2e9100aeac59041effdf9a3341647c29299cbde (rev 3): subckt r1_safe_string unchanged
*   r1_isense schematic/r1_isense.spice af013b95f5fd57e2f1cd0d1345a4c75471c2f216b063ede3a39bdea6412ba4ee (rev 2): XRPB1..26 and XSPB of r1_isense_ch unchanged

.subckt r1_safe_string vref t0 t1 t2 t3 t4 t5 t6 t7 t8 t9 t10 t11 t12 t13 t14 t15 t16 t17 t18 t19 t20 t21 t22 t23 t24 t25 t26 t27 t28 t29 t30 t31 t32 t33 t34 t35 t36 t37 t38 t39 t40 t41 t42 t43 t44 t45 t46 t47 t48 t49 t50 t51 t52 t53 t54 t55 t56 t57 t58 t59 t60 t61 t62 t63 t64 t65 t66 t67 t68 t69 t70 t71 t72 t73 t74 t75 t76 t77 t78 t79 t80 t81 t82 t83 t84 t85 t86 t87 t88 t89 t90 t91 t92 t93 t94 t95 t96 t97 t98 t99 t100 t101 t102 t103 t104 t105 t106 t107 t108 t109 t110 t111 t112 t113 t114 t115 t116 t117 t118 t119 t120 t121 t122 t123 t124 t125 t126 t127 t128 t129 t130 t131 t132 t133 t134 t135 t136 t137 t138 t139 t140 t141 t142 t143 t144 t145 t146 t147 t148 t149 t150 t151 t152 t153 t154 t155 t156 t157 t158 t159 t160 t161 t162 t163 t164 t165 t166 t167 t168 t169 t170 t171 t172 t173 t174 t175 t176 t177 t178 t179 t180 t181 t182 t183 t184 t185 t186 t187 t188 t189 t190 t191 t192 t193 t194 t195 t196 t197 t198 t199 t200 t201 t202 t203 t204 t205 t206 t207 t208 t209 t210 t211 t212 t213 t214 t215 t216 t217 t218 t219 t220 t221 t222 t223 t224 t225 t226 t227 t228 t229 t230 t231 t232 t233 t234 t235 t236 t237 t238 t239 t240 t241 t242 t243 t244 t245 t246 t247 t248 t249 t250 t251 t252 vss
* 252 rppd units of 1000 Ohm between VREF (T252) and VSS (T0); 4.2 uA at 1.05 V
XRS0 t1 t0 vss rppd w=2u l=7.7u m=1 b=0 mm_ok=1
XRS1 t2 t1 vss rppd w=2u l=7.7u m=1 b=0 mm_ok=1
XRS2 t3 t2 vss rppd w=2u l=7.7u m=1 b=0 mm_ok=1
XRS3 t4 t3 vss rppd w=2u l=7.7u m=1 b=0 mm_ok=1
XRS4 t5 t4 vss rppd w=2u l=7.7u m=1 b=0 mm_ok=1
XRS5 t6 t5 vss rppd w=2u l=7.7u m=1 b=0 mm_ok=1
XRS6 t7 t6 vss rppd w=2u l=7.7u m=1 b=0 mm_ok=1
XRS7 t8 t7 vss rppd w=2u l=7.7u m=1 b=0 mm_ok=1
XRS8 t9 t8 vss rppd w=2u l=7.7u m=1 b=0 mm_ok=1
XRS9 t10 t9 vss rppd w=2u l=7.7u m=1 b=0 mm_ok=1
XRS10 t11 t10 vss rppd w=2u l=7.7u m=1 b=0 mm_ok=1
XRS11 t12 t11 vss rppd w=2u l=7.7u m=1 b=0 mm_ok=1
XRS12 t13 t12 vss rppd w=2u l=7.7u m=1 b=0 mm_ok=1
XRS13 t14 t13 vss rppd w=2u l=7.7u m=1 b=0 mm_ok=1
XRS14 t15 t14 vss rppd w=2u l=7.7u m=1 b=0 mm_ok=1
XRS15 t16 t15 vss rppd w=2u l=7.7u m=1 b=0 mm_ok=1
XRS16 t17 t16 vss rppd w=2u l=7.7u m=1 b=0 mm_ok=1
XRS17 t18 t17 vss rppd w=2u l=7.7u m=1 b=0 mm_ok=1
XRS18 t19 t18 vss rppd w=2u l=7.7u m=1 b=0 mm_ok=1
XRS19 t20 t19 vss rppd w=2u l=7.7u m=1 b=0 mm_ok=1
XRS20 t21 t20 vss rppd w=2u l=7.7u m=1 b=0 mm_ok=1
XRS21 t22 t21 vss rppd w=2u l=7.7u m=1 b=0 mm_ok=1
XRS22 t23 t22 vss rppd w=2u l=7.7u m=1 b=0 mm_ok=1
XRS23 t24 t23 vss rppd w=2u l=7.7u m=1 b=0 mm_ok=1
XRS24 t25 t24 vss rppd w=2u l=7.7u m=1 b=0 mm_ok=1
XRS25 t26 t25 vss rppd w=2u l=7.7u m=1 b=0 mm_ok=1
XRS26 t27 t26 vss rppd w=2u l=7.7u m=1 b=0 mm_ok=1
XRS27 t28 t27 vss rppd w=2u l=7.7u m=1 b=0 mm_ok=1
XRS28 t29 t28 vss rppd w=2u l=7.7u m=1 b=0 mm_ok=1
XRS29 t30 t29 vss rppd w=2u l=7.7u m=1 b=0 mm_ok=1
XRS30 t31 t30 vss rppd w=2u l=7.7u m=1 b=0 mm_ok=1
XRS31 t32 t31 vss rppd w=2u l=7.7u m=1 b=0 mm_ok=1
XRS32 t33 t32 vss rppd w=2u l=7.7u m=1 b=0 mm_ok=1
XRS33 t34 t33 vss rppd w=2u l=7.7u m=1 b=0 mm_ok=1
XRS34 t35 t34 vss rppd w=2u l=7.7u m=1 b=0 mm_ok=1
XRS35 t36 t35 vss rppd w=2u l=7.7u m=1 b=0 mm_ok=1
XRS36 t37 t36 vss rppd w=2u l=7.7u m=1 b=0 mm_ok=1
XRS37 t38 t37 vss rppd w=2u l=7.7u m=1 b=0 mm_ok=1
XRS38 t39 t38 vss rppd w=2u l=7.7u m=1 b=0 mm_ok=1
XRS39 t40 t39 vss rppd w=2u l=7.7u m=1 b=0 mm_ok=1
XRS40 t41 t40 vss rppd w=2u l=7.7u m=1 b=0 mm_ok=1
XRS41 t42 t41 vss rppd w=2u l=7.7u m=1 b=0 mm_ok=1
XRS42 t43 t42 vss rppd w=2u l=7.7u m=1 b=0 mm_ok=1
XRS43 t44 t43 vss rppd w=2u l=7.7u m=1 b=0 mm_ok=1
XRS44 t45 t44 vss rppd w=2u l=7.7u m=1 b=0 mm_ok=1
XRS45 t46 t45 vss rppd w=2u l=7.7u m=1 b=0 mm_ok=1
XRS46 t47 t46 vss rppd w=2u l=7.7u m=1 b=0 mm_ok=1
XRS47 t48 t47 vss rppd w=2u l=7.7u m=1 b=0 mm_ok=1
XRS48 t49 t48 vss rppd w=2u l=7.7u m=1 b=0 mm_ok=1
XRS49 t50 t49 vss rppd w=2u l=7.7u m=1 b=0 mm_ok=1
XRS50 t51 t50 vss rppd w=2u l=7.7u m=1 b=0 mm_ok=1
XRS51 t52 t51 vss rppd w=2u l=7.7u m=1 b=0 mm_ok=1
XRS52 t53 t52 vss rppd w=2u l=7.7u m=1 b=0 mm_ok=1
XRS53 t54 t53 vss rppd w=2u l=7.7u m=1 b=0 mm_ok=1
XRS54 t55 t54 vss rppd w=2u l=7.7u m=1 b=0 mm_ok=1
XRS55 t56 t55 vss rppd w=2u l=7.7u m=1 b=0 mm_ok=1
XRS56 t57 t56 vss rppd w=2u l=7.7u m=1 b=0 mm_ok=1
XRS57 t58 t57 vss rppd w=2u l=7.7u m=1 b=0 mm_ok=1
XRS58 t59 t58 vss rppd w=2u l=7.7u m=1 b=0 mm_ok=1
XRS59 t60 t59 vss rppd w=2u l=7.7u m=1 b=0 mm_ok=1
XRS60 t61 t60 vss rppd w=2u l=7.7u m=1 b=0 mm_ok=1
XRS61 t62 t61 vss rppd w=2u l=7.7u m=1 b=0 mm_ok=1
XRS62 t63 t62 vss rppd w=2u l=7.7u m=1 b=0 mm_ok=1
XRS63 t64 t63 vss rppd w=2u l=7.7u m=1 b=0 mm_ok=1
XRS64 t65 t64 vss rppd w=2u l=7.7u m=1 b=0 mm_ok=1
XRS65 t66 t65 vss rppd w=2u l=7.7u m=1 b=0 mm_ok=1
XRS66 t67 t66 vss rppd w=2u l=7.7u m=1 b=0 mm_ok=1
XRS67 t68 t67 vss rppd w=2u l=7.7u m=1 b=0 mm_ok=1
XRS68 t69 t68 vss rppd w=2u l=7.7u m=1 b=0 mm_ok=1
XRS69 t70 t69 vss rppd w=2u l=7.7u m=1 b=0 mm_ok=1
XRS70 t71 t70 vss rppd w=2u l=7.7u m=1 b=0 mm_ok=1
XRS71 t72 t71 vss rppd w=2u l=7.7u m=1 b=0 mm_ok=1
XRS72 t73 t72 vss rppd w=2u l=7.7u m=1 b=0 mm_ok=1
XRS73 t74 t73 vss rppd w=2u l=7.7u m=1 b=0 mm_ok=1
XRS74 t75 t74 vss rppd w=2u l=7.7u m=1 b=0 mm_ok=1
XRS75 t76 t75 vss rppd w=2u l=7.7u m=1 b=0 mm_ok=1
XRS76 t77 t76 vss rppd w=2u l=7.7u m=1 b=0 mm_ok=1
XRS77 t78 t77 vss rppd w=2u l=7.7u m=1 b=0 mm_ok=1
XRS78 t79 t78 vss rppd w=2u l=7.7u m=1 b=0 mm_ok=1
XRS79 t80 t79 vss rppd w=2u l=7.7u m=1 b=0 mm_ok=1
XRS80 t81 t80 vss rppd w=2u l=7.7u m=1 b=0 mm_ok=1
XRS81 t82 t81 vss rppd w=2u l=7.7u m=1 b=0 mm_ok=1
XRS82 t83 t82 vss rppd w=2u l=7.7u m=1 b=0 mm_ok=1
XRS83 t84 t83 vss rppd w=2u l=7.7u m=1 b=0 mm_ok=1
XRS84 t85 t84 vss rppd w=2u l=7.7u m=1 b=0 mm_ok=1
XRS85 t86 t85 vss rppd w=2u l=7.7u m=1 b=0 mm_ok=1
XRS86 t87 t86 vss rppd w=2u l=7.7u m=1 b=0 mm_ok=1
XRS87 t88 t87 vss rppd w=2u l=7.7u m=1 b=0 mm_ok=1
XRS88 t89 t88 vss rppd w=2u l=7.7u m=1 b=0 mm_ok=1
XRS89 t90 t89 vss rppd w=2u l=7.7u m=1 b=0 mm_ok=1
XRS90 t91 t90 vss rppd w=2u l=7.7u m=1 b=0 mm_ok=1
XRS91 t92 t91 vss rppd w=2u l=7.7u m=1 b=0 mm_ok=1
XRS92 t93 t92 vss rppd w=2u l=7.7u m=1 b=0 mm_ok=1
XRS93 t94 t93 vss rppd w=2u l=7.7u m=1 b=0 mm_ok=1
XRS94 t95 t94 vss rppd w=2u l=7.7u m=1 b=0 mm_ok=1
XRS95 t96 t95 vss rppd w=2u l=7.7u m=1 b=0 mm_ok=1
XRS96 t97 t96 vss rppd w=2u l=7.7u m=1 b=0 mm_ok=1
XRS97 t98 t97 vss rppd w=2u l=7.7u m=1 b=0 mm_ok=1
XRS98 t99 t98 vss rppd w=2u l=7.7u m=1 b=0 mm_ok=1
XRS99 t100 t99 vss rppd w=2u l=7.7u m=1 b=0 mm_ok=1
XRS100 t101 t100 vss rppd w=2u l=7.7u m=1 b=0 mm_ok=1
XRS101 t102 t101 vss rppd w=2u l=7.7u m=1 b=0 mm_ok=1
XRS102 t103 t102 vss rppd w=2u l=7.7u m=1 b=0 mm_ok=1
XRS103 t104 t103 vss rppd w=2u l=7.7u m=1 b=0 mm_ok=1
XRS104 t105 t104 vss rppd w=2u l=7.7u m=1 b=0 mm_ok=1
XRS105 t106 t105 vss rppd w=2u l=7.7u m=1 b=0 mm_ok=1
XRS106 t107 t106 vss rppd w=2u l=7.7u m=1 b=0 mm_ok=1
XRS107 t108 t107 vss rppd w=2u l=7.7u m=1 b=0 mm_ok=1
XRS108 t109 t108 vss rppd w=2u l=7.7u m=1 b=0 mm_ok=1
XRS109 t110 t109 vss rppd w=2u l=7.7u m=1 b=0 mm_ok=1
XRS110 t111 t110 vss rppd w=2u l=7.7u m=1 b=0 mm_ok=1
XRS111 t112 t111 vss rppd w=2u l=7.7u m=1 b=0 mm_ok=1
XRS112 t113 t112 vss rppd w=2u l=7.7u m=1 b=0 mm_ok=1
XRS113 t114 t113 vss rppd w=2u l=7.7u m=1 b=0 mm_ok=1
XRS114 t115 t114 vss rppd w=2u l=7.7u m=1 b=0 mm_ok=1
XRS115 t116 t115 vss rppd w=2u l=7.7u m=1 b=0 mm_ok=1
XRS116 t117 t116 vss rppd w=2u l=7.7u m=1 b=0 mm_ok=1
XRS117 t118 t117 vss rppd w=2u l=7.7u m=1 b=0 mm_ok=1
XRS118 t119 t118 vss rppd w=2u l=7.7u m=1 b=0 mm_ok=1
XRS119 t120 t119 vss rppd w=2u l=7.7u m=1 b=0 mm_ok=1
XRS120 t121 t120 vss rppd w=2u l=7.7u m=1 b=0 mm_ok=1
XRS121 t122 t121 vss rppd w=2u l=7.7u m=1 b=0 mm_ok=1
XRS122 t123 t122 vss rppd w=2u l=7.7u m=1 b=0 mm_ok=1
XRS123 t124 t123 vss rppd w=2u l=7.7u m=1 b=0 mm_ok=1
XRS124 t125 t124 vss rppd w=2u l=7.7u m=1 b=0 mm_ok=1
XRS125 t126 t125 vss rppd w=2u l=7.7u m=1 b=0 mm_ok=1
XRS126 t127 t126 vss rppd w=2u l=7.7u m=1 b=0 mm_ok=1
XRS127 t128 t127 vss rppd w=2u l=7.7u m=1 b=0 mm_ok=1
XRS128 t129 t128 vss rppd w=2u l=7.7u m=1 b=0 mm_ok=1
XRS129 t130 t129 vss rppd w=2u l=7.7u m=1 b=0 mm_ok=1
XRS130 t131 t130 vss rppd w=2u l=7.7u m=1 b=0 mm_ok=1
XRS131 t132 t131 vss rppd w=2u l=7.7u m=1 b=0 mm_ok=1
XRS132 t133 t132 vss rppd w=2u l=7.7u m=1 b=0 mm_ok=1
XRS133 t134 t133 vss rppd w=2u l=7.7u m=1 b=0 mm_ok=1
XRS134 t135 t134 vss rppd w=2u l=7.7u m=1 b=0 mm_ok=1
XRS135 t136 t135 vss rppd w=2u l=7.7u m=1 b=0 mm_ok=1
XRS136 t137 t136 vss rppd w=2u l=7.7u m=1 b=0 mm_ok=1
XRS137 t138 t137 vss rppd w=2u l=7.7u m=1 b=0 mm_ok=1
XRS138 t139 t138 vss rppd w=2u l=7.7u m=1 b=0 mm_ok=1
XRS139 t140 t139 vss rppd w=2u l=7.7u m=1 b=0 mm_ok=1
XRS140 t141 t140 vss rppd w=2u l=7.7u m=1 b=0 mm_ok=1
XRS141 t142 t141 vss rppd w=2u l=7.7u m=1 b=0 mm_ok=1
XRS142 t143 t142 vss rppd w=2u l=7.7u m=1 b=0 mm_ok=1
XRS143 t144 t143 vss rppd w=2u l=7.7u m=1 b=0 mm_ok=1
XRS144 t145 t144 vss rppd w=2u l=7.7u m=1 b=0 mm_ok=1
XRS145 t146 t145 vss rppd w=2u l=7.7u m=1 b=0 mm_ok=1
XRS146 t147 t146 vss rppd w=2u l=7.7u m=1 b=0 mm_ok=1
XRS147 t148 t147 vss rppd w=2u l=7.7u m=1 b=0 mm_ok=1
XRS148 t149 t148 vss rppd w=2u l=7.7u m=1 b=0 mm_ok=1
XRS149 t150 t149 vss rppd w=2u l=7.7u m=1 b=0 mm_ok=1
XRS150 t151 t150 vss rppd w=2u l=7.7u m=1 b=0 mm_ok=1
XRS151 t152 t151 vss rppd w=2u l=7.7u m=1 b=0 mm_ok=1
XRS152 t153 t152 vss rppd w=2u l=7.7u m=1 b=0 mm_ok=1
XRS153 t154 t153 vss rppd w=2u l=7.7u m=1 b=0 mm_ok=1
XRS154 t155 t154 vss rppd w=2u l=7.7u m=1 b=0 mm_ok=1
XRS155 t156 t155 vss rppd w=2u l=7.7u m=1 b=0 mm_ok=1
XRS156 t157 t156 vss rppd w=2u l=7.7u m=1 b=0 mm_ok=1
XRS157 t158 t157 vss rppd w=2u l=7.7u m=1 b=0 mm_ok=1
XRS158 t159 t158 vss rppd w=2u l=7.7u m=1 b=0 mm_ok=1
XRS159 t160 t159 vss rppd w=2u l=7.7u m=1 b=0 mm_ok=1
XRS160 t161 t160 vss rppd w=2u l=7.7u m=1 b=0 mm_ok=1
XRS161 t162 t161 vss rppd w=2u l=7.7u m=1 b=0 mm_ok=1
XRS162 t163 t162 vss rppd w=2u l=7.7u m=1 b=0 mm_ok=1
XRS163 t164 t163 vss rppd w=2u l=7.7u m=1 b=0 mm_ok=1
XRS164 t165 t164 vss rppd w=2u l=7.7u m=1 b=0 mm_ok=1
XRS165 t166 t165 vss rppd w=2u l=7.7u m=1 b=0 mm_ok=1
XRS166 t167 t166 vss rppd w=2u l=7.7u m=1 b=0 mm_ok=1
XRS167 t168 t167 vss rppd w=2u l=7.7u m=1 b=0 mm_ok=1
XRS168 t169 t168 vss rppd w=2u l=7.7u m=1 b=0 mm_ok=1
XRS169 t170 t169 vss rppd w=2u l=7.7u m=1 b=0 mm_ok=1
XRS170 t171 t170 vss rppd w=2u l=7.7u m=1 b=0 mm_ok=1
XRS171 t172 t171 vss rppd w=2u l=7.7u m=1 b=0 mm_ok=1
XRS172 t173 t172 vss rppd w=2u l=7.7u m=1 b=0 mm_ok=1
XRS173 t174 t173 vss rppd w=2u l=7.7u m=1 b=0 mm_ok=1
XRS174 t175 t174 vss rppd w=2u l=7.7u m=1 b=0 mm_ok=1
XRS175 t176 t175 vss rppd w=2u l=7.7u m=1 b=0 mm_ok=1
XRS176 t177 t176 vss rppd w=2u l=7.7u m=1 b=0 mm_ok=1
XRS177 t178 t177 vss rppd w=2u l=7.7u m=1 b=0 mm_ok=1
XRS178 t179 t178 vss rppd w=2u l=7.7u m=1 b=0 mm_ok=1
XRS179 t180 t179 vss rppd w=2u l=7.7u m=1 b=0 mm_ok=1
XRS180 t181 t180 vss rppd w=2u l=7.7u m=1 b=0 mm_ok=1
XRS181 t182 t181 vss rppd w=2u l=7.7u m=1 b=0 mm_ok=1
XRS182 t183 t182 vss rppd w=2u l=7.7u m=1 b=0 mm_ok=1
XRS183 t184 t183 vss rppd w=2u l=7.7u m=1 b=0 mm_ok=1
XRS184 t185 t184 vss rppd w=2u l=7.7u m=1 b=0 mm_ok=1
XRS185 t186 t185 vss rppd w=2u l=7.7u m=1 b=0 mm_ok=1
XRS186 t187 t186 vss rppd w=2u l=7.7u m=1 b=0 mm_ok=1
XRS187 t188 t187 vss rppd w=2u l=7.7u m=1 b=0 mm_ok=1
XRS188 t189 t188 vss rppd w=2u l=7.7u m=1 b=0 mm_ok=1
XRS189 t190 t189 vss rppd w=2u l=7.7u m=1 b=0 mm_ok=1
XRS190 t191 t190 vss rppd w=2u l=7.7u m=1 b=0 mm_ok=1
XRS191 t192 t191 vss rppd w=2u l=7.7u m=1 b=0 mm_ok=1
XRS192 t193 t192 vss rppd w=2u l=7.7u m=1 b=0 mm_ok=1
XRS193 t194 t193 vss rppd w=2u l=7.7u m=1 b=0 mm_ok=1
XRS194 t195 t194 vss rppd w=2u l=7.7u m=1 b=0 mm_ok=1
XRS195 t196 t195 vss rppd w=2u l=7.7u m=1 b=0 mm_ok=1
XRS196 t197 t196 vss rppd w=2u l=7.7u m=1 b=0 mm_ok=1
XRS197 t198 t197 vss rppd w=2u l=7.7u m=1 b=0 mm_ok=1
XRS198 t199 t198 vss rppd w=2u l=7.7u m=1 b=0 mm_ok=1
XRS199 t200 t199 vss rppd w=2u l=7.7u m=1 b=0 mm_ok=1
XRS200 t201 t200 vss rppd w=2u l=7.7u m=1 b=0 mm_ok=1
XRS201 t202 t201 vss rppd w=2u l=7.7u m=1 b=0 mm_ok=1
XRS202 t203 t202 vss rppd w=2u l=7.7u m=1 b=0 mm_ok=1
XRS203 t204 t203 vss rppd w=2u l=7.7u m=1 b=0 mm_ok=1
XRS204 t205 t204 vss rppd w=2u l=7.7u m=1 b=0 mm_ok=1
XRS205 t206 t205 vss rppd w=2u l=7.7u m=1 b=0 mm_ok=1
XRS206 t207 t206 vss rppd w=2u l=7.7u m=1 b=0 mm_ok=1
XRS207 t208 t207 vss rppd w=2u l=7.7u m=1 b=0 mm_ok=1
XRS208 t209 t208 vss rppd w=2u l=7.7u m=1 b=0 mm_ok=1
XRS209 t210 t209 vss rppd w=2u l=7.7u m=1 b=0 mm_ok=1
XRS210 t211 t210 vss rppd w=2u l=7.7u m=1 b=0 mm_ok=1
XRS211 t212 t211 vss rppd w=2u l=7.7u m=1 b=0 mm_ok=1
XRS212 t213 t212 vss rppd w=2u l=7.7u m=1 b=0 mm_ok=1
XRS213 t214 t213 vss rppd w=2u l=7.7u m=1 b=0 mm_ok=1
XRS214 t215 t214 vss rppd w=2u l=7.7u m=1 b=0 mm_ok=1
XRS215 t216 t215 vss rppd w=2u l=7.7u m=1 b=0 mm_ok=1
XRS216 t217 t216 vss rppd w=2u l=7.7u m=1 b=0 mm_ok=1
XRS217 t218 t217 vss rppd w=2u l=7.7u m=1 b=0 mm_ok=1
XRS218 t219 t218 vss rppd w=2u l=7.7u m=1 b=0 mm_ok=1
XRS219 t220 t219 vss rppd w=2u l=7.7u m=1 b=0 mm_ok=1
XRS220 t221 t220 vss rppd w=2u l=7.7u m=1 b=0 mm_ok=1
XRS221 t222 t221 vss rppd w=2u l=7.7u m=1 b=0 mm_ok=1
XRS222 t223 t222 vss rppd w=2u l=7.7u m=1 b=0 mm_ok=1
XRS223 t224 t223 vss rppd w=2u l=7.7u m=1 b=0 mm_ok=1
XRS224 t225 t224 vss rppd w=2u l=7.7u m=1 b=0 mm_ok=1
XRS225 t226 t225 vss rppd w=2u l=7.7u m=1 b=0 mm_ok=1
XRS226 t227 t226 vss rppd w=2u l=7.7u m=1 b=0 mm_ok=1
XRS227 t228 t227 vss rppd w=2u l=7.7u m=1 b=0 mm_ok=1
XRS228 t229 t228 vss rppd w=2u l=7.7u m=1 b=0 mm_ok=1
XRS229 t230 t229 vss rppd w=2u l=7.7u m=1 b=0 mm_ok=1
XRS230 t231 t230 vss rppd w=2u l=7.7u m=1 b=0 mm_ok=1
XRS231 t232 t231 vss rppd w=2u l=7.7u m=1 b=0 mm_ok=1
XRS232 t233 t232 vss rppd w=2u l=7.7u m=1 b=0 mm_ok=1
XRS233 t234 t233 vss rppd w=2u l=7.7u m=1 b=0 mm_ok=1
XRS234 t235 t234 vss rppd w=2u l=7.7u m=1 b=0 mm_ok=1
XRS235 t236 t235 vss rppd w=2u l=7.7u m=1 b=0 mm_ok=1
XRS236 t237 t236 vss rppd w=2u l=7.7u m=1 b=0 mm_ok=1
XRS237 t238 t237 vss rppd w=2u l=7.7u m=1 b=0 mm_ok=1
XRS238 t239 t238 vss rppd w=2u l=7.7u m=1 b=0 mm_ok=1
XRS239 t240 t239 vss rppd w=2u l=7.7u m=1 b=0 mm_ok=1
XRS240 t241 t240 vss rppd w=2u l=7.7u m=1 b=0 mm_ok=1
XRS241 t242 t241 vss rppd w=2u l=7.7u m=1 b=0 mm_ok=1
XRS242 t243 t242 vss rppd w=2u l=7.7u m=1 b=0 mm_ok=1
XRS243 t244 t243 vss rppd w=2u l=7.7u m=1 b=0 mm_ok=1
XRS244 t245 t244 vss rppd w=2u l=7.7u m=1 b=0 mm_ok=1
XRS245 t246 t245 vss rppd w=2u l=7.7u m=1 b=0 mm_ok=1
XRS246 t247 t246 vss rppd w=2u l=7.7u m=1 b=0 mm_ok=1
XRS247 t248 t247 vss rppd w=2u l=7.7u m=1 b=0 mm_ok=1
XRS248 t249 t248 vss rppd w=2u l=7.7u m=1 b=0 mm_ok=1
XRS249 t250 t249 vss rppd w=2u l=7.7u m=1 b=0 mm_ok=1
XRS250 t251 t250 vss rppd w=2u l=7.7u m=1 b=0 mm_ok=1
XRS251 t252 t251 vss rppd w=2u l=7.7u m=1 b=0 mm_ok=1
Rt252 t252 vref 1e-3
Rt0 t0 vss 1e-3
.ends r1_safe_string

* one r1_isense pedestal arm: 26 rppd units (104 kOhm) from vref to the switch XSPB into the summing node sb
.subckt ld_isped vref azb sb vss
XRPB1 vref rpb1 vss rppd w=2u l=30.8u m=1 b=0 mm_ok=1
XRPB2 rpb1 rpb2 vss rppd w=2u l=30.8u m=1 b=0 mm_ok=1
XRPB3 rpb2 rpb3 vss rppd w=2u l=30.8u m=1 b=0 mm_ok=1
XRPB4 rpb3 rpb4 vss rppd w=2u l=30.8u m=1 b=0 mm_ok=1
XRPB5 rpb4 rpb5 vss rppd w=2u l=30.8u m=1 b=0 mm_ok=1
XRPB6 rpb5 rpb6 vss rppd w=2u l=30.8u m=1 b=0 mm_ok=1
XRPB7 rpb6 rpb7 vss rppd w=2u l=30.8u m=1 b=0 mm_ok=1
XRPB8 rpb7 rpb8 vss rppd w=2u l=30.8u m=1 b=0 mm_ok=1
XRPB9 rpb8 rpb9 vss rppd w=2u l=30.8u m=1 b=0 mm_ok=1
XRPB10 rpb9 rpb10 vss rppd w=2u l=30.8u m=1 b=0 mm_ok=1
XRPB11 rpb10 rpb11 vss rppd w=2u l=30.8u m=1 b=0 mm_ok=1
XRPB12 rpb11 rpb12 vss rppd w=2u l=30.8u m=1 b=0 mm_ok=1
XRPB13 rpb12 rpb13 vss rppd w=2u l=30.8u m=1 b=0 mm_ok=1
XRPB14 rpb13 rpb14 vss rppd w=2u l=30.8u m=1 b=0 mm_ok=1
XRPB15 rpb14 rpb15 vss rppd w=2u l=30.8u m=1 b=0 mm_ok=1
XRPB16 rpb15 rpb16 vss rppd w=2u l=30.8u m=1 b=0 mm_ok=1
XRPB17 rpb16 rpb17 vss rppd w=2u l=30.8u m=1 b=0 mm_ok=1
XRPB18 rpb17 rpb18 vss rppd w=2u l=30.8u m=1 b=0 mm_ok=1
XRPB19 rpb18 rpb19 vss rppd w=2u l=30.8u m=1 b=0 mm_ok=1
XRPB20 rpb19 rpb20 vss rppd w=2u l=30.8u m=1 b=0 mm_ok=1
XRPB21 rpb20 rpb21 vss rppd w=2u l=30.8u m=1 b=0 mm_ok=1
XRPB22 rpb21 rpb22 vss rppd w=2u l=30.8u m=1 b=0 mm_ok=1
XRPB23 rpb22 rpb23 vss rppd w=2u l=30.8u m=1 b=0 mm_ok=1
XRPB24 rpb23 rpb24 vss rppd w=2u l=30.8u m=1 b=0 mm_ok=1
XRPB25 rpb24 rpb25 vss rppd w=2u l=30.8u m=1 b=0 mm_ok=1
XRPB26 rpb25 rpbs vss rppd w=2u l=30.8u m=1 b=0 mm_ok=1
XSPB rpbs azb sb vss sg13_hv_nmos w=10u l=0.45u ng=1 m=1 mm_ok=1
.ends ld_isped
