* Extracted by KLayout with SG13G2 LVS runset on : 26/10/2026 19:13

.SUBCKT r1_afe_ch c1 c1b c2 c2b c3 c3b c4 c4b ib1 ib2 inn inp m1n m1p on2 op2
+ outn outp vcm1 vcm2 vdd vss x1n x1p x2n x2p xa1_cb1 xa1_cb2 xa1_cmd xa1_cz1
+ xa1_cz2 xa1_fn xa1_fp xa1_gn xa1_gp xa1_o1n xa1_o1p xa1_tc xa1_tn xa1_tp
+ xa1_vbnc xa1_vbp xa1_vbpc xa1_vcmfb xa1_vcms xa1_xrs1_n1 xa1_xrs1_n2
+ xa1_xrs1_n3 xa1_xrs1_n4 xa1_xrs1_n5 xa1_xrs1_n6 xa1_xrs1_n7 xa1_xrs1_n8
+ xa1_xrs1_n9 xa1_xrs2_n1 xa1_xrs2_n2 xa1_xrs2_n3 xa1_xrs2_n4 xa1_xrs2_n5
+ xa1_xrs2_n6 xa1_xrs2_n7 xa1_xrs2_n8 xa1_xrs2_n9 xa2_cmd xa2_cz1 xa2_cz2
+ xa2_fn xa2_fp xa2_gn xa2_gp xa2_o1n xa2_o1p xa2_tc xa2_tp xa2_vbnc xa2_vbp
+ xa2_vbpc xa2_vcmfb xa2_vcms xa2_xrs1_n1 xa2_xrs1_n2 xa2_xrs1_n3 xa2_xrs1_n4
+ xa2_xrs1_n5 xa2_xrs1_n6 xa2_xrs1_n7 xa2_xrs1_n8 xa2_xrs1_n9 xa2_xrs2_n1
+ xa2_xrs2_n2 xa2_xrs2_n3 xa2_xrs2_n4 xa2_xrs2_n5 xa2_xrs2_n6 xa2_xrs2_n7
+ xa2_xrs2_n8 xa2_xrs2_n9 xs1n_a1 xs1n_a2 xs1n_a3 xs1n_a4 xs1n_a5 xs1n_a6
+ xs1n_a7 xs1n_a8 xs1n_af xs1n_xu1_xr_n1 xs1n_xu2_xr_n1 xs1n_xu3_xr_n1
+ xs1n_xu4_xr_n1 xs1n_xu5_xr_n1 xs1n_xu6_xr_n1 xs1n_xu7_xr_n1 xs1n_xu8_xr_n1
+ xs1n_xuf_xr_n1 xs1p_a1 xs1p_a2 xs1p_a3 xs1p_a4 xs1p_a5 xs1p_a6 xs1p_a7
+ xs1p_a8 xs1p_af xs1p_xu1_xr_n1 xs1p_xu2_xr_n1 xs1p_xu3_xr_n1 xs1p_xu4_xr_n1
+ xs1p_xu5_xr_n1 xs1p_xu6_xr_n1 xs1p_xu7_xr_n1 xs1p_xu8_xr_n1 xs1p_xuf_xr_n1
+ xs2n_b1 xs2n_b2 xs2n_b3 xs2n_b4 xs2n_bf xs2p_b1 xs2p_b2 xs2p_b3 xs2p_b4
+ xs2p_bf
M$1 x1p vdd xs1p_a1 vss sg13_hv_nmos L=0.45u W=5u AS=1.7p AD=0.95p PS=10.68u
+ PD=5.38u rfmode=0
M$2 xs1p_a1 vdd x1p vss sg13_hv_nmos L=0.45u W=5u AS=0.95p AD=1.7p PS=5.38u
+ PD=10.68u rfmode=0
M$3 x1p c1 xs1p_a2 vss sg13_hv_nmos L=0.45u W=5u AS=1.7p AD=0.95p PS=10.68u
+ PD=5.38u rfmode=0
M$4 xs1p_a2 c1 x1p vss sg13_hv_nmos L=0.45u W=5u AS=0.95p AD=1.7p PS=5.38u
+ PD=10.68u rfmode=0
M$5 x1p c2 xs1p_a3 vss sg13_hv_nmos L=0.45u W=5u AS=1.7p AD=0.95p PS=10.68u
+ PD=5.38u rfmode=0
M$6 xs1p_a3 c2 x1p vss sg13_hv_nmos L=0.45u W=5u AS=0.95p AD=1.7p PS=5.38u
+ PD=10.68u rfmode=0
M$7 x1p c2 xs1p_a4 vss sg13_hv_nmos L=0.45u W=5u AS=1.7p AD=0.95p PS=10.68u
+ PD=5.38u rfmode=0
M$8 xs1p_a4 c2 x1p vss sg13_hv_nmos L=0.45u W=5u AS=0.95p AD=1.7p PS=5.38u
+ PD=10.68u rfmode=0
M$9 x1p c3 xs1p_a5 vss sg13_hv_nmos L=0.45u W=5u AS=1.7p AD=0.95p PS=10.68u
+ PD=5.38u rfmode=0
M$10 xs1p_a5 c3 x1p vss sg13_hv_nmos L=0.45u W=5u AS=0.95p AD=1.7p PS=5.38u
+ PD=10.68u rfmode=0
M$11 x1p c3 xs1p_a6 vss sg13_hv_nmos L=0.45u W=5u AS=1.7p AD=0.95p PS=10.68u
+ PD=5.38u rfmode=0
M$12 xs1p_a6 c3 x1p vss sg13_hv_nmos L=0.45u W=5u AS=0.95p AD=1.7p PS=5.38u
+ PD=10.68u rfmode=0
M$13 x1p c3 xs1p_a7 vss sg13_hv_nmos L=0.45u W=5u AS=1.7p AD=0.95p PS=10.68u
+ PD=5.38u rfmode=0
M$14 xs1p_a7 c3 x1p vss sg13_hv_nmos L=0.45u W=5u AS=0.95p AD=1.7p PS=5.38u
+ PD=10.68u rfmode=0
M$15 x1p c3 xs1p_a8 vss sg13_hv_nmos L=0.45u W=5u AS=1.7p AD=0.95p PS=10.68u
+ PD=5.38u rfmode=0
M$16 xs1p_a8 c3 x1p vss sg13_hv_nmos L=0.45u W=5u AS=0.95p AD=1.7p PS=5.38u
+ PD=10.68u rfmode=0
M$17 m1n vdd xs1p_af vss sg13_hv_nmos L=0.45u W=5u AS=1.7p AD=0.95p PS=10.68u
+ PD=5.38u rfmode=0
M$18 xs1p_af vdd m1n vss sg13_hv_nmos L=0.45u W=5u AS=0.95p AD=1.7p PS=5.38u
+ PD=10.68u rfmode=0
M$19 x2p vdd xs2p_b1 vss sg13_hv_nmos L=0.45u W=5u AS=1.7p AD=0.95p PS=10.68u
+ PD=5.38u rfmode=0
M$20 xs2p_b1 vdd x2p vss sg13_hv_nmos L=0.45u W=5u AS=0.95p AD=1.7p PS=5.38u
+ PD=10.68u rfmode=0
M$21 x2p c4 xs2p_b2 vss sg13_hv_nmos L=0.45u W=5u AS=1.7p AD=0.95p PS=10.68u
+ PD=5.38u rfmode=0
M$22 xs2p_b2 c4 x2p vss sg13_hv_nmos L=0.45u W=5u AS=0.95p AD=1.7p PS=5.38u
+ PD=10.68u rfmode=0
M$23 x2p c4 xs2p_b3 vss sg13_hv_nmos L=0.45u W=5u AS=1.7p AD=0.95p PS=10.68u
+ PD=5.38u rfmode=0
M$24 xs2p_b3 c4 x2p vss sg13_hv_nmos L=0.45u W=5u AS=0.95p AD=1.7p PS=5.38u
+ PD=10.68u rfmode=0
M$25 x2p c4 xs2p_b4 vss sg13_hv_nmos L=0.45u W=5u AS=1.7p AD=0.95p PS=10.68u
+ PD=5.38u rfmode=0
M$26 xs2p_b4 c4 x2p vss sg13_hv_nmos L=0.45u W=5u AS=0.95p AD=1.7p PS=5.38u
+ PD=10.68u rfmode=0
M$27 op2 vdd xs2p_bf vss sg13_hv_nmos L=0.45u W=5u AS=1.7p AD=0.95p PS=10.68u
+ PD=5.38u rfmode=0
M$28 xs2p_bf vdd op2 vss sg13_hv_nmos L=0.45u W=5u AS=0.95p AD=1.7p PS=5.38u
+ PD=10.68u rfmode=0
M$29 xa1_cb1 c3b xa1_cz1 vss sg13_hv_nmos L=0.45u W=5u AS=1.7p AD=0.95p
+ PS=10.68u PD=5.38u rfmode=0
M$30 xa1_cz1 c3b xa1_cb1 vss sg13_hv_nmos L=0.45u W=5u AS=0.95p AD=1.7p
+ PS=5.38u PD=10.68u rfmode=0
M$31 vss c1 c1b vss sg13_hv_nmos L=0.45u W=1u AS=0.34p AD=0.34p PS=2.68u
+ PD=2.68u rfmode=0
M$32 vss c2 c2b vss sg13_hv_nmos L=0.45u W=1u AS=0.34p AD=0.34p PS=2.68u
+ PD=2.68u rfmode=0
M$33 vss c3 c3b vss sg13_hv_nmos L=0.45u W=1u AS=0.34p AD=0.34p PS=2.68u
+ PD=2.68u rfmode=0
M$34 vss c4 c4b vss sg13_hv_nmos L=0.45u W=1u AS=0.34p AD=0.34p PS=2.68u
+ PD=2.68u rfmode=0
M$35 xa1_cb2 c3b xa1_cz2 vss sg13_hv_nmos L=0.45u W=5u AS=1.7p AD=0.95p
+ PS=10.68u PD=5.38u rfmode=0
M$36 xa1_cz2 c3b xa1_cb2 vss sg13_hv_nmos L=0.45u W=5u AS=0.95p AD=1.7p
+ PS=5.38u PD=10.68u rfmode=0
M$37 x2n vdd xs2n_b1 vss sg13_hv_nmos L=0.45u W=5u AS=1.7p AD=0.95p PS=10.68u
+ PD=5.38u rfmode=0
M$38 xs2n_b1 vdd x2n vss sg13_hv_nmos L=0.45u W=5u AS=0.95p AD=1.7p PS=5.38u
+ PD=10.68u rfmode=0
M$39 x2n c4 xs2n_b2 vss sg13_hv_nmos L=0.45u W=5u AS=1.7p AD=0.95p PS=10.68u
+ PD=5.38u rfmode=0
M$40 xs2n_b2 c4 x2n vss sg13_hv_nmos L=0.45u W=5u AS=0.95p AD=1.7p PS=5.38u
+ PD=10.68u rfmode=0
M$41 x2n c4 xs2n_b3 vss sg13_hv_nmos L=0.45u W=5u AS=1.7p AD=0.95p PS=10.68u
+ PD=5.38u rfmode=0
M$42 xs2n_b3 c4 x2n vss sg13_hv_nmos L=0.45u W=5u AS=0.95p AD=1.7p PS=5.38u
+ PD=10.68u rfmode=0
M$43 x2n c4 xs2n_b4 vss sg13_hv_nmos L=0.45u W=5u AS=1.7p AD=0.95p PS=10.68u
+ PD=5.38u rfmode=0
M$44 xs2n_b4 c4 x2n vss sg13_hv_nmos L=0.45u W=5u AS=0.95p AD=1.7p PS=5.38u
+ PD=10.68u rfmode=0
M$45 on2 vdd xs2n_bf vss sg13_hv_nmos L=0.45u W=5u AS=1.7p AD=0.95p PS=10.68u
+ PD=5.38u rfmode=0
M$46 xs2n_bf vdd on2 vss sg13_hv_nmos L=0.45u W=5u AS=0.95p AD=1.7p PS=5.38u
+ PD=10.68u rfmode=0
M$47 x1n vdd xs1n_a1 vss sg13_hv_nmos L=0.45u W=5u AS=1.7p AD=0.95p PS=10.68u
+ PD=5.38u rfmode=0
M$48 xs1n_a1 vdd x1n vss sg13_hv_nmos L=0.45u W=5u AS=0.95p AD=1.7p PS=5.38u
+ PD=10.68u rfmode=0
M$49 x1n c1 xs1n_a2 vss sg13_hv_nmos L=0.45u W=5u AS=1.7p AD=0.95p PS=10.68u
+ PD=5.38u rfmode=0
M$50 xs1n_a2 c1 x1n vss sg13_hv_nmos L=0.45u W=5u AS=0.95p AD=1.7p PS=5.38u
+ PD=10.68u rfmode=0
M$51 x1n c2 xs1n_a3 vss sg13_hv_nmos L=0.45u W=5u AS=1.7p AD=0.95p PS=10.68u
+ PD=5.38u rfmode=0
M$52 xs1n_a3 c2 x1n vss sg13_hv_nmos L=0.45u W=5u AS=0.95p AD=1.7p PS=5.38u
+ PD=10.68u rfmode=0
M$53 x1n c2 xs1n_a4 vss sg13_hv_nmos L=0.45u W=5u AS=1.7p AD=0.95p PS=10.68u
+ PD=5.38u rfmode=0
M$54 xs1n_a4 c2 x1n vss sg13_hv_nmos L=0.45u W=5u AS=0.95p AD=1.7p PS=5.38u
+ PD=10.68u rfmode=0
M$55 x1n c3 xs1n_a5 vss sg13_hv_nmos L=0.45u W=5u AS=1.7p AD=0.95p PS=10.68u
+ PD=5.38u rfmode=0
M$56 xs1n_a5 c3 x1n vss sg13_hv_nmos L=0.45u W=5u AS=0.95p AD=1.7p PS=5.38u
+ PD=10.68u rfmode=0
M$57 x1n c3 xs1n_a6 vss sg13_hv_nmos L=0.45u W=5u AS=1.7p AD=0.95p PS=10.68u
+ PD=5.38u rfmode=0
M$58 xs1n_a6 c3 x1n vss sg13_hv_nmos L=0.45u W=5u AS=0.95p AD=1.7p PS=5.38u
+ PD=10.68u rfmode=0
M$59 x1n c3 xs1n_a7 vss sg13_hv_nmos L=0.45u W=5u AS=1.7p AD=0.95p PS=10.68u
+ PD=5.38u rfmode=0
M$60 xs1n_a7 c3 x1n vss sg13_hv_nmos L=0.45u W=5u AS=0.95p AD=1.7p PS=5.38u
+ PD=10.68u rfmode=0
M$61 x1n c3 xs1n_a8 vss sg13_hv_nmos L=0.45u W=5u AS=1.7p AD=0.95p PS=10.68u
+ PD=5.38u rfmode=0
M$62 xs1n_a8 c3 x1n vss sg13_hv_nmos L=0.45u W=5u AS=0.95p AD=1.7p PS=5.38u
+ PD=10.68u rfmode=0
M$63 m1p vdd xs1n_af vss sg13_hv_nmos L=0.45u W=5u AS=1.7p AD=0.95p PS=10.68u
+ PD=5.38u rfmode=0
M$64 xs1n_af vdd m1p vss sg13_hv_nmos L=0.45u W=5u AS=0.95p AD=1.7p PS=5.38u
+ PD=10.68u rfmode=0
M$65 vss ib1 ib1 vss sg13_hv_nmos L=1u W=4u AS=1.36p AD=1.36p PS=8.68u PD=8.68u
+ rfmode=0
M$66 xa1_tn x1p xa1_gn vss sg13_hv_nmos L=2u W=5u AS=1.7p AD=0.95p PS=10.68u
+ PD=5.38u rfmode=0
M$67 xa1_gn x1p xa1_tn vss sg13_hv_nmos L=2u W=5u AS=0.95p AD=0.95p PS=5.38u
+ PD=5.38u rfmode=0
M$68 xa1_tn x1p xa1_gn vss sg13_hv_nmos L=2u W=5u AS=0.95p AD=0.95p PS=5.38u
+ PD=5.38u rfmode=0
M$69 xa1_gn x1p xa1_tn vss sg13_hv_nmos L=2u W=5u AS=0.95p AD=0.95p PS=5.38u
+ PD=5.38u rfmode=0
M$70 xa1_tn x1p xa1_gn vss sg13_hv_nmos L=2u W=5u AS=0.95p AD=0.95p PS=5.38u
+ PD=5.38u rfmode=0
M$71 xa1_gn x1p xa1_tn vss sg13_hv_nmos L=2u W=5u AS=0.95p AD=0.95p PS=5.38u
+ PD=5.38u rfmode=0
M$72 xa1_tn x1p xa1_gn vss sg13_hv_nmos L=2u W=5u AS=0.95p AD=0.95p PS=5.38u
+ PD=5.38u rfmode=0
M$73 xa1_gn x1p xa1_tn vss sg13_hv_nmos L=2u W=5u AS=0.95p AD=0.95p PS=5.38u
+ PD=5.38u rfmode=0
M$74 xa1_tn x1p xa1_gn vss sg13_hv_nmos L=2u W=5u AS=0.95p AD=0.95p PS=5.38u
+ PD=5.38u rfmode=0
M$75 xa1_gn x1p xa1_tn vss sg13_hv_nmos L=2u W=5u AS=0.95p AD=0.95p PS=5.38u
+ PD=5.38u rfmode=0
M$76 xa1_tn x1p xa1_gn vss sg13_hv_nmos L=2u W=5u AS=0.95p AD=0.95p PS=5.38u
+ PD=5.38u rfmode=0
M$77 xa1_gn x1p xa1_tn vss sg13_hv_nmos L=2u W=5u AS=0.95p AD=0.95p PS=5.38u
+ PD=5.38u rfmode=0
M$78 xa1_tn x1p xa1_gn vss sg13_hv_nmos L=2u W=5u AS=0.95p AD=0.95p PS=5.38u
+ PD=5.38u rfmode=0
M$79 xa1_gn x1p xa1_tn vss sg13_hv_nmos L=2u W=5u AS=0.95p AD=0.95p PS=5.38u
+ PD=5.38u rfmode=0
M$80 xa1_tn x1p xa1_gn vss sg13_hv_nmos L=2u W=5u AS=0.95p AD=0.95p PS=5.38u
+ PD=5.38u rfmode=0
M$81 xa1_gn x1p xa1_tn vss sg13_hv_nmos L=2u W=5u AS=0.95p AD=0.95p PS=5.38u
+ PD=5.38u rfmode=0
M$82 xa1_tn x1p xa1_gn vss sg13_hv_nmos L=2u W=5u AS=0.95p AD=0.95p PS=5.38u
+ PD=5.38u rfmode=0
M$83 xa1_gn x1p xa1_tn vss sg13_hv_nmos L=2u W=5u AS=0.95p AD=0.95p PS=5.38u
+ PD=5.38u rfmode=0
M$84 xa1_tn x1p xa1_gn vss sg13_hv_nmos L=2u W=5u AS=0.95p AD=0.95p PS=5.38u
+ PD=5.38u rfmode=0
M$85 xa1_gn x1p xa1_tn vss sg13_hv_nmos L=2u W=5u AS=0.95p AD=0.95p PS=5.38u
+ PD=5.38u rfmode=0
M$86 xa1_tn x1p xa1_gn vss sg13_hv_nmos L=2u W=5u AS=0.95p AD=0.95p PS=5.38u
+ PD=5.38u rfmode=0
M$87 xa1_gn x1p xa1_tn vss sg13_hv_nmos L=2u W=5u AS=0.95p AD=0.95p PS=5.38u
+ PD=5.38u rfmode=0
M$88 xa1_tn x1p xa1_gn vss sg13_hv_nmos L=2u W=5u AS=0.95p AD=0.95p PS=5.38u
+ PD=5.38u rfmode=0
M$89 xa1_gn x1p xa1_tn vss sg13_hv_nmos L=2u W=5u AS=0.95p AD=0.95p PS=5.38u
+ PD=5.38u rfmode=0
M$90 xa1_tn x1p xa1_gn vss sg13_hv_nmos L=2u W=5u AS=0.95p AD=0.95p PS=5.38u
+ PD=5.38u rfmode=0
M$91 xa1_gn x1p xa1_tn vss sg13_hv_nmos L=2u W=5u AS=0.95p AD=0.95p PS=5.38u
+ PD=5.38u rfmode=0
M$92 xa1_tn x1p xa1_gn vss sg13_hv_nmos L=2u W=5u AS=0.95p AD=0.95p PS=5.38u
+ PD=5.38u rfmode=0
M$93 xa1_gn x1p xa1_tn vss sg13_hv_nmos L=2u W=5u AS=0.95p AD=0.95p PS=5.38u
+ PD=5.38u rfmode=0
M$94 xa1_tn x1p xa1_gn vss sg13_hv_nmos L=2u W=5u AS=0.95p AD=0.95p PS=5.38u
+ PD=5.38u rfmode=0
M$95 xa1_gn x1p xa1_tn vss sg13_hv_nmos L=2u W=5u AS=0.95p AD=0.95p PS=5.38u
+ PD=5.38u rfmode=0
M$96 xa1_tn x1p xa1_gn vss sg13_hv_nmos L=2u W=5u AS=0.95p AD=0.95p PS=5.38u
+ PD=5.38u rfmode=0
M$97 xa1_gn x1p xa1_tn vss sg13_hv_nmos L=2u W=5u AS=0.95p AD=1.7p PS=5.38u
+ PD=10.68u rfmode=0
M$98 vss ib1 xa1_vbp vss sg13_hv_nmos L=1u W=4u AS=1.36p AD=1.36p PS=8.68u
+ PD=8.68u rfmode=0
M$99 vss ib1 xa1_vbpc vss sg13_hv_nmos L=1u W=4u AS=1.36p AD=1.36p PS=8.68u
+ PD=8.68u rfmode=0
M$100 vss xa1_vbnc xa1_vbnc vss sg13_hv_nmos L=2u W=1u AS=0.34p AD=0.34p
+ PS=2.68u PD=2.68u rfmode=0
M$101 vss ib1 xa1_fn vss sg13_hv_nmos L=2u W=0.5u AS=0.17p AD=0.17p PS=1.68u
+ PD=1.68u rfmode=0
M$102 vss xa1_vcmfb xa1_fn vss sg13_hv_nmos L=2u W=4u AS=1.36p AD=0.76p
+ PS=8.68u PD=4.38u rfmode=0
M$103 xa1_fn xa1_vcmfb vss vss sg13_hv_nmos L=2u W=4u AS=0.76p AD=0.76p
+ PS=4.38u PD=4.38u rfmode=0
M$104 vss xa1_vcmfb xa1_fn vss sg13_hv_nmos L=2u W=4u AS=0.76p AD=0.76p
+ PS=4.38u PD=4.38u rfmode=0
M$105 xa1_fn xa1_vcmfb vss vss sg13_hv_nmos L=2u W=4u AS=0.76p AD=1.36p
+ PS=4.38u PD=8.68u rfmode=0
M$106 xa1_fn xa1_vbnc xa1_o1n vss sg13_hv_nmos L=1u W=6u AS=2.04p AD=1.14p
+ PS=12.68u PD=6.38u rfmode=0
M$107 xa1_o1n xa1_vbnc xa1_fn vss sg13_hv_nmos L=1u W=6u AS=1.14p AD=1.14p
+ PS=6.38u PD=6.38u rfmode=0
M$108 xa1_fn xa1_vbnc xa1_o1n vss sg13_hv_nmos L=1u W=6u AS=1.14p AD=1.14p
+ PS=6.38u PD=6.38u rfmode=0
M$109 xa1_o1n xa1_vbnc xa1_fn vss sg13_hv_nmos L=1u W=6u AS=1.14p AD=2.04p
+ PS=6.38u PD=12.68u rfmode=0
M$110 vss xa1_o1n m1p vss sg13_hv_nmos L=0.5u W=1u AS=0.34p AD=0.19p PS=2.68u
+ PD=1.38u rfmode=0
M$111 m1p xa1_o1n vss vss sg13_hv_nmos L=0.5u W=1u AS=0.19p AD=0.19p PS=1.38u
+ PD=1.38u rfmode=0
M$112 vss xa1_o1n m1p vss sg13_hv_nmos L=0.5u W=1u AS=0.19p AD=0.19p PS=1.38u
+ PD=1.38u rfmode=0
M$113 m1p xa1_o1n vss vss sg13_hv_nmos L=0.5u W=1u AS=0.19p AD=0.19p PS=1.38u
+ PD=1.38u rfmode=0
M$114 vss xa1_o1n m1p vss sg13_hv_nmos L=0.5u W=1u AS=0.19p AD=0.19p PS=1.38u
+ PD=1.38u rfmode=0
M$115 m1p xa1_o1n vss vss sg13_hv_nmos L=0.5u W=1u AS=0.19p AD=0.19p PS=1.38u
+ PD=1.38u rfmode=0
M$116 vss xa1_o1n m1p vss sg13_hv_nmos L=0.5u W=1u AS=0.19p AD=0.19p PS=1.38u
+ PD=1.38u rfmode=0
M$117 m1p xa1_o1n vss vss sg13_hv_nmos L=0.5u W=1u AS=0.19p AD=0.34p PS=1.38u
+ PD=2.68u rfmode=0
M$118 vss xa1_vcmfb xa1_vcmfb vss sg13_hv_nmos L=1u W=4u AS=1.36p AD=1.36p
+ PS=8.68u PD=8.68u rfmode=0
M$119 vss ib1 xa1_tn vss sg13_hv_nmos L=1u W=6u AS=2.04p AD=1.14p PS=12.68u
+ PD=6.38u rfmode=0
M$120 xa1_tn ib1 vss vss sg13_hv_nmos L=1u W=6u AS=1.14p AD=1.14p PS=6.38u
+ PD=6.38u rfmode=0
M$121 vss ib1 xa1_tn vss sg13_hv_nmos L=1u W=6u AS=1.14p AD=1.14p PS=6.38u
+ PD=6.38u rfmode=0
M$122 xa1_tn ib1 vss vss sg13_hv_nmos L=1u W=6u AS=1.14p AD=2.04p PS=6.38u
+ PD=12.68u rfmode=0
M$123 vss xa1_cmd xa1_cmd vss sg13_hv_nmos L=1u W=4u AS=1.36p AD=1.36p PS=8.68u
+ PD=8.68u rfmode=0
M$124 xa1_tn x1n xa1_gp vss sg13_hv_nmos L=2u W=5u AS=1.7p AD=0.95p PS=10.68u
+ PD=5.38u rfmode=0
M$125 xa1_gp x1n xa1_tn vss sg13_hv_nmos L=2u W=5u AS=0.95p AD=0.95p PS=5.38u
+ PD=5.38u rfmode=0
M$126 xa1_tn x1n xa1_gp vss sg13_hv_nmos L=2u W=5u AS=0.95p AD=0.95p PS=5.38u
+ PD=5.38u rfmode=0
M$127 xa1_gp x1n xa1_tn vss sg13_hv_nmos L=2u W=5u AS=0.95p AD=0.95p PS=5.38u
+ PD=5.38u rfmode=0
M$128 xa1_tn x1n xa1_gp vss sg13_hv_nmos L=2u W=5u AS=0.95p AD=0.95p PS=5.38u
+ PD=5.38u rfmode=0
M$129 xa1_gp x1n xa1_tn vss sg13_hv_nmos L=2u W=5u AS=0.95p AD=0.95p PS=5.38u
+ PD=5.38u rfmode=0
M$130 xa1_tn x1n xa1_gp vss sg13_hv_nmos L=2u W=5u AS=0.95p AD=0.95p PS=5.38u
+ PD=5.38u rfmode=0
M$131 xa1_gp x1n xa1_tn vss sg13_hv_nmos L=2u W=5u AS=0.95p AD=0.95p PS=5.38u
+ PD=5.38u rfmode=0
M$132 xa1_tn x1n xa1_gp vss sg13_hv_nmos L=2u W=5u AS=0.95p AD=0.95p PS=5.38u
+ PD=5.38u rfmode=0
M$133 xa1_gp x1n xa1_tn vss sg13_hv_nmos L=2u W=5u AS=0.95p AD=0.95p PS=5.38u
+ PD=5.38u rfmode=0
M$134 xa1_tn x1n xa1_gp vss sg13_hv_nmos L=2u W=5u AS=0.95p AD=0.95p PS=5.38u
+ PD=5.38u rfmode=0
M$135 xa1_gp x1n xa1_tn vss sg13_hv_nmos L=2u W=5u AS=0.95p AD=0.95p PS=5.38u
+ PD=5.38u rfmode=0
M$136 xa1_tn x1n xa1_gp vss sg13_hv_nmos L=2u W=5u AS=0.95p AD=0.95p PS=5.38u
+ PD=5.38u rfmode=0
M$137 xa1_gp x1n xa1_tn vss sg13_hv_nmos L=2u W=5u AS=0.95p AD=0.95p PS=5.38u
+ PD=5.38u rfmode=0
M$138 xa1_tn x1n xa1_gp vss sg13_hv_nmos L=2u W=5u AS=0.95p AD=0.95p PS=5.38u
+ PD=5.38u rfmode=0
M$139 xa1_gp x1n xa1_tn vss sg13_hv_nmos L=2u W=5u AS=0.95p AD=0.95p PS=5.38u
+ PD=5.38u rfmode=0
M$140 xa1_tn x1n xa1_gp vss sg13_hv_nmos L=2u W=5u AS=0.95p AD=0.95p PS=5.38u
+ PD=5.38u rfmode=0
M$141 xa1_gp x1n xa1_tn vss sg13_hv_nmos L=2u W=5u AS=0.95p AD=0.95p PS=5.38u
+ PD=5.38u rfmode=0
M$142 xa1_tn x1n xa1_gp vss sg13_hv_nmos L=2u W=5u AS=0.95p AD=0.95p PS=5.38u
+ PD=5.38u rfmode=0
M$143 xa1_gp x1n xa1_tn vss sg13_hv_nmos L=2u W=5u AS=0.95p AD=0.95p PS=5.38u
+ PD=5.38u rfmode=0
M$144 xa1_tn x1n xa1_gp vss sg13_hv_nmos L=2u W=5u AS=0.95p AD=0.95p PS=5.38u
+ PD=5.38u rfmode=0
M$145 xa1_gp x1n xa1_tn vss sg13_hv_nmos L=2u W=5u AS=0.95p AD=0.95p PS=5.38u
+ PD=5.38u rfmode=0
M$146 xa1_tn x1n xa1_gp vss sg13_hv_nmos L=2u W=5u AS=0.95p AD=0.95p PS=5.38u
+ PD=5.38u rfmode=0
M$147 xa1_gp x1n xa1_tn vss sg13_hv_nmos L=2u W=5u AS=0.95p AD=0.95p PS=5.38u
+ PD=5.38u rfmode=0
M$148 xa1_tn x1n xa1_gp vss sg13_hv_nmos L=2u W=5u AS=0.95p AD=0.95p PS=5.38u
+ PD=5.38u rfmode=0
M$149 xa1_gp x1n xa1_tn vss sg13_hv_nmos L=2u W=5u AS=0.95p AD=0.95p PS=5.38u
+ PD=5.38u rfmode=0
M$150 xa1_tn x1n xa1_gp vss sg13_hv_nmos L=2u W=5u AS=0.95p AD=0.95p PS=5.38u
+ PD=5.38u rfmode=0
M$151 xa1_gp x1n xa1_tn vss sg13_hv_nmos L=2u W=5u AS=0.95p AD=0.95p PS=5.38u
+ PD=5.38u rfmode=0
M$152 xa1_tn x1n xa1_gp vss sg13_hv_nmos L=2u W=5u AS=0.95p AD=0.95p PS=5.38u
+ PD=5.38u rfmode=0
M$153 xa1_gp x1n xa1_tn vss sg13_hv_nmos L=2u W=5u AS=0.95p AD=0.95p PS=5.38u
+ PD=5.38u rfmode=0
M$154 xa1_tn x1n xa1_gp vss sg13_hv_nmos L=2u W=5u AS=0.95p AD=0.95p PS=5.38u
+ PD=5.38u rfmode=0
M$155 xa1_gp x1n xa1_tn vss sg13_hv_nmos L=2u W=5u AS=0.95p AD=1.7p PS=5.38u
+ PD=10.68u rfmode=0
M$156 vss xa1_o1p m1n vss sg13_hv_nmos L=0.5u W=1u AS=0.34p AD=0.19p PS=2.68u
+ PD=1.38u rfmode=0
M$157 m1n xa1_o1p vss vss sg13_hv_nmos L=0.5u W=1u AS=0.19p AD=0.19p PS=1.38u
+ PD=1.38u rfmode=0
M$158 vss xa1_o1p m1n vss sg13_hv_nmos L=0.5u W=1u AS=0.19p AD=0.19p PS=1.38u
+ PD=1.38u rfmode=0
M$159 m1n xa1_o1p vss vss sg13_hv_nmos L=0.5u W=1u AS=0.19p AD=0.19p PS=1.38u
+ PD=1.38u rfmode=0
M$160 vss xa1_o1p m1n vss sg13_hv_nmos L=0.5u W=1u AS=0.19p AD=0.19p PS=1.38u
+ PD=1.38u rfmode=0
M$161 m1n xa1_o1p vss vss sg13_hv_nmos L=0.5u W=1u AS=0.19p AD=0.19p PS=1.38u
+ PD=1.38u rfmode=0
M$162 vss xa1_o1p m1n vss sg13_hv_nmos L=0.5u W=1u AS=0.19p AD=0.19p PS=1.38u
+ PD=1.38u rfmode=0
M$163 m1n xa1_o1p vss vss sg13_hv_nmos L=0.5u W=1u AS=0.19p AD=0.34p PS=1.38u
+ PD=2.68u rfmode=0
M$164 xa1_fp xa1_vbnc xa1_o1p vss sg13_hv_nmos L=1u W=6u AS=2.04p AD=1.14p
+ PS=12.68u PD=6.38u rfmode=0
M$165 xa1_o1p xa1_vbnc xa1_fp vss sg13_hv_nmos L=1u W=6u AS=1.14p AD=1.14p
+ PS=6.38u PD=6.38u rfmode=0
M$166 xa1_fp xa1_vbnc xa1_o1p vss sg13_hv_nmos L=1u W=6u AS=1.14p AD=1.14p
+ PS=6.38u PD=6.38u rfmode=0
M$167 xa1_o1p xa1_vbnc xa1_fp vss sg13_hv_nmos L=1u W=6u AS=1.14p AD=2.04p
+ PS=6.38u PD=12.68u rfmode=0
M$168 vss xa1_vcmfb xa1_fp vss sg13_hv_nmos L=2u W=4u AS=1.36p AD=0.76p
+ PS=8.68u PD=4.38u rfmode=0
M$169 xa1_fp xa1_vcmfb vss vss sg13_hv_nmos L=2u W=4u AS=0.76p AD=0.76p
+ PS=4.38u PD=4.38u rfmode=0
M$170 vss xa1_vcmfb xa1_fp vss sg13_hv_nmos L=2u W=4u AS=0.76p AD=0.76p
+ PS=4.38u PD=4.38u rfmode=0
M$171 xa1_fp xa1_vcmfb vss vss sg13_hv_nmos L=2u W=4u AS=0.76p AD=1.36p
+ PS=4.38u PD=8.68u rfmode=0
M$172 vss ib1 xa1_fp vss sg13_hv_nmos L=2u W=0.5u AS=0.17p AD=0.17p PS=1.68u
+ PD=1.68u rfmode=0
M$173 vss ib2 ib2 vss sg13_hv_nmos L=2u W=8u AS=2.72p AD=2.72p PS=16.68u
+ PD=16.68u rfmode=0
M$174 vss ib2 xa2_vbp vss sg13_hv_nmos L=2u W=8u AS=2.72p AD=2.72p PS=16.68u
+ PD=16.68u rfmode=0
M$175 vss ib2 xa2_vbpc vss sg13_hv_nmos L=2u W=8u AS=2.72p AD=2.72p PS=16.68u
+ PD=16.68u rfmode=0
M$176 vss xa2_vbnc xa2_vbnc vss sg13_hv_nmos L=2u W=1u AS=0.34p AD=0.34p
+ PS=2.68u PD=2.68u rfmode=0
M$177 vss ib2 xa2_fn vss sg13_hv_nmos L=2u W=5u AS=1.7p AD=0.95p PS=10.68u
+ PD=5.38u rfmode=0
M$178 xa2_fn ib2 vss vss sg13_hv_nmos L=2u W=5u AS=0.95p AD=0.95p PS=5.38u
+ PD=5.38u rfmode=0
M$179 vss ib2 xa2_fn vss sg13_hv_nmos L=2u W=5u AS=0.95p AD=0.95p PS=5.38u
+ PD=5.38u rfmode=0
M$180 xa2_fn ib2 vss vss sg13_hv_nmos L=2u W=5u AS=0.95p AD=1.7p PS=5.38u
+ PD=10.68u rfmode=0
M$181 vss xa2_vcmfb xa2_fn vss sg13_hv_nmos L=2u W=2.5u AS=0.85p AD=0.475p
+ PS=5.68u PD=2.88u rfmode=0
M$182 xa2_fn xa2_vcmfb vss vss sg13_hv_nmos L=2u W=2.5u AS=0.475p AD=0.475p
+ PS=2.88u PD=2.88u rfmode=0
M$183 vss xa2_vcmfb xa2_fn vss sg13_hv_nmos L=2u W=2.5u AS=0.475p AD=0.475p
+ PS=2.88u PD=2.88u rfmode=0
M$184 xa2_fn xa2_vcmfb vss vss sg13_hv_nmos L=2u W=2.5u AS=0.475p AD=0.85p
+ PS=2.88u PD=5.68u rfmode=0
M$185 xa2_fn xa2_vbnc xa2_o1n vss sg13_hv_nmos L=1u W=6u AS=2.04p AD=1.14p
+ PS=12.68u PD=6.38u rfmode=0
M$186 xa2_o1n xa2_vbnc xa2_fn vss sg13_hv_nmos L=1u W=6u AS=1.14p AD=1.14p
+ PS=6.38u PD=6.38u rfmode=0
M$187 xa2_fn xa2_vbnc xa2_o1n vss sg13_hv_nmos L=1u W=6u AS=1.14p AD=1.14p
+ PS=6.38u PD=6.38u rfmode=0
M$188 xa2_o1n xa2_vbnc xa2_fn vss sg13_hv_nmos L=1u W=6u AS=1.14p AD=2.04p
+ PS=6.38u PD=12.68u rfmode=0
M$189 vss xa2_o1n on2 vss sg13_hv_nmos L=0.5u W=7.5u AS=2.55p AD=1.425p
+ PS=15.68u PD=7.88u rfmode=0
M$190 on2 xa2_o1n vss vss sg13_hv_nmos L=0.5u W=7.5u AS=1.425p AD=1.425p
+ PS=7.88u PD=7.88u rfmode=0
M$191 vss xa2_o1n on2 vss sg13_hv_nmos L=0.5u W=7.5u AS=1.425p AD=1.425p
+ PS=7.88u PD=7.88u rfmode=0
M$192 on2 xa2_o1n vss vss sg13_hv_nmos L=0.5u W=7.5u AS=1.425p AD=1.425p
+ PS=7.88u PD=7.88u rfmode=0
M$193 vss xa2_o1n on2 vss sg13_hv_nmos L=0.5u W=7.5u AS=1.425p AD=1.425p
+ PS=7.88u PD=7.88u rfmode=0
M$194 on2 xa2_o1n vss vss sg13_hv_nmos L=0.5u W=7.5u AS=1.425p AD=1.425p
+ PS=7.88u PD=7.88u rfmode=0
M$195 vss xa2_o1n on2 vss sg13_hv_nmos L=0.5u W=7.5u AS=1.425p AD=1.425p
+ PS=7.88u PD=7.88u rfmode=0
M$196 on2 xa2_o1n vss vss sg13_hv_nmos L=0.5u W=7.5u AS=1.425p AD=2.55p
+ PS=7.88u PD=15.68u rfmode=0
M$197 vss xa2_vcmfb xa2_vcmfb vss sg13_hv_nmos L=2u W=8u AS=2.72p AD=2.72p
+ PS=16.68u PD=16.68u rfmode=0
M$198 vss xa2_cmd xa2_cmd vss sg13_hv_nmos L=2u W=8u AS=2.72p AD=2.72p
+ PS=16.68u PD=16.68u rfmode=0
M$199 vss xa2_o1p op2 vss sg13_hv_nmos L=0.5u W=7.5u AS=2.55p AD=1.425p
+ PS=15.68u PD=7.88u rfmode=0
M$200 op2 xa2_o1p vss vss sg13_hv_nmos L=0.5u W=7.5u AS=1.425p AD=1.425p
+ PS=7.88u PD=7.88u rfmode=0
M$201 vss xa2_o1p op2 vss sg13_hv_nmos L=0.5u W=7.5u AS=1.425p AD=1.425p
+ PS=7.88u PD=7.88u rfmode=0
M$202 op2 xa2_o1p vss vss sg13_hv_nmos L=0.5u W=7.5u AS=1.425p AD=1.425p
+ PS=7.88u PD=7.88u rfmode=0
M$203 vss xa2_o1p op2 vss sg13_hv_nmos L=0.5u W=7.5u AS=1.425p AD=1.425p
+ PS=7.88u PD=7.88u rfmode=0
M$204 op2 xa2_o1p vss vss sg13_hv_nmos L=0.5u W=7.5u AS=1.425p AD=1.425p
+ PS=7.88u PD=7.88u rfmode=0
M$205 vss xa2_o1p op2 vss sg13_hv_nmos L=0.5u W=7.5u AS=1.425p AD=1.425p
+ PS=7.88u PD=7.88u rfmode=0
M$206 op2 xa2_o1p vss vss sg13_hv_nmos L=0.5u W=7.5u AS=1.425p AD=2.55p
+ PS=7.88u PD=15.68u rfmode=0
M$207 xa2_fp xa2_vbnc xa2_o1p vss sg13_hv_nmos L=1u W=6u AS=2.04p AD=1.14p
+ PS=12.68u PD=6.38u rfmode=0
M$208 xa2_o1p xa2_vbnc xa2_fp vss sg13_hv_nmos L=1u W=6u AS=1.14p AD=1.14p
+ PS=6.38u PD=6.38u rfmode=0
M$209 xa2_fp xa2_vbnc xa2_o1p vss sg13_hv_nmos L=1u W=6u AS=1.14p AD=1.14p
+ PS=6.38u PD=6.38u rfmode=0
M$210 xa2_o1p xa2_vbnc xa2_fp vss sg13_hv_nmos L=1u W=6u AS=1.14p AD=2.04p
+ PS=6.38u PD=12.68u rfmode=0
M$211 vss xa2_vcmfb xa2_fp vss sg13_hv_nmos L=2u W=2.5u AS=0.85p AD=0.475p
+ PS=5.68u PD=2.88u rfmode=0
M$212 xa2_fp xa2_vcmfb vss vss sg13_hv_nmos L=2u W=2.5u AS=0.475p AD=0.475p
+ PS=2.88u PD=2.88u rfmode=0
M$213 vss xa2_vcmfb xa2_fp vss sg13_hv_nmos L=2u W=2.5u AS=0.475p AD=0.475p
+ PS=2.88u PD=2.88u rfmode=0
M$214 xa2_fp xa2_vcmfb vss vss sg13_hv_nmos L=2u W=2.5u AS=0.475p AD=0.85p
+ PS=2.88u PD=5.68u rfmode=0
M$215 vss ib2 xa2_fp vss sg13_hv_nmos L=2u W=5u AS=1.7p AD=0.95p PS=10.68u
+ PD=5.38u rfmode=0
M$216 xa2_fp ib2 vss vss sg13_hv_nmos L=2u W=5u AS=0.95p AD=0.95p PS=5.38u
+ PD=5.38u rfmode=0
M$217 vss ib2 xa2_fp vss sg13_hv_nmos L=2u W=5u AS=0.95p AD=0.95p PS=5.38u
+ PD=5.38u rfmode=0
M$218 xa2_fp ib2 vss vss sg13_hv_nmos L=2u W=5u AS=0.95p AD=1.7p PS=5.38u
+ PD=10.68u rfmode=0
M$219 x1p vss xs1p_a1 vdd sg13_hv_pmos L=0.45u W=5u AS=1.7p AD=0.95p PS=10.68u
+ PD=5.38u rfmode=0
M$220 xs1p_a1 vss x1p vdd sg13_hv_pmos L=0.45u W=5u AS=0.95p AD=0.95p PS=5.38u
+ PD=5.38u rfmode=0
M$221 x1p vss xs1p_a1 vdd sg13_hv_pmos L=0.45u W=5u AS=0.95p AD=0.95p PS=5.38u
+ PD=5.38u rfmode=0
M$222 xs1p_a1 vss x1p vdd sg13_hv_pmos L=0.45u W=5u AS=0.95p AD=1.7p PS=5.38u
+ PD=10.68u rfmode=0
M$223 x1p c1b xs1p_a2 vdd sg13_hv_pmos L=0.45u W=5u AS=1.7p AD=0.95p PS=10.68u
+ PD=5.38u rfmode=0
M$224 xs1p_a2 c1b x1p vdd sg13_hv_pmos L=0.45u W=5u AS=0.95p AD=0.95p PS=5.38u
+ PD=5.38u rfmode=0
M$225 x1p c1b xs1p_a2 vdd sg13_hv_pmos L=0.45u W=5u AS=0.95p AD=0.95p PS=5.38u
+ PD=5.38u rfmode=0
M$226 xs1p_a2 c1b x1p vdd sg13_hv_pmos L=0.45u W=5u AS=0.95p AD=1.7p PS=5.38u
+ PD=10.68u rfmode=0
M$227 x1p c2b xs1p_a3 vdd sg13_hv_pmos L=0.45u W=5u AS=1.7p AD=0.95p PS=10.68u
+ PD=5.38u rfmode=0
M$228 xs1p_a3 c2b x1p vdd sg13_hv_pmos L=0.45u W=5u AS=0.95p AD=0.95p PS=5.38u
+ PD=5.38u rfmode=0
M$229 x1p c2b xs1p_a3 vdd sg13_hv_pmos L=0.45u W=5u AS=0.95p AD=0.95p PS=5.38u
+ PD=5.38u rfmode=0
M$230 xs1p_a3 c2b x1p vdd sg13_hv_pmos L=0.45u W=5u AS=0.95p AD=1.7p PS=5.38u
+ PD=10.68u rfmode=0
M$231 x1p c2b xs1p_a4 vdd sg13_hv_pmos L=0.45u W=5u AS=1.7p AD=0.95p PS=10.68u
+ PD=5.38u rfmode=0
M$232 xs1p_a4 c2b x1p vdd sg13_hv_pmos L=0.45u W=5u AS=0.95p AD=0.95p PS=5.38u
+ PD=5.38u rfmode=0
M$233 x1p c2b xs1p_a4 vdd sg13_hv_pmos L=0.45u W=5u AS=0.95p AD=0.95p PS=5.38u
+ PD=5.38u rfmode=0
M$234 xs1p_a4 c2b x1p vdd sg13_hv_pmos L=0.45u W=5u AS=0.95p AD=1.7p PS=5.38u
+ PD=10.68u rfmode=0
M$235 x1p c3b xs1p_a5 vdd sg13_hv_pmos L=0.45u W=5u AS=1.7p AD=0.95p PS=10.68u
+ PD=5.38u rfmode=0
M$236 xs1p_a5 c3b x1p vdd sg13_hv_pmos L=0.45u W=5u AS=0.95p AD=0.95p PS=5.38u
+ PD=5.38u rfmode=0
M$237 x1p c3b xs1p_a5 vdd sg13_hv_pmos L=0.45u W=5u AS=0.95p AD=0.95p PS=5.38u
+ PD=5.38u rfmode=0
M$238 xs1p_a5 c3b x1p vdd sg13_hv_pmos L=0.45u W=5u AS=0.95p AD=1.7p PS=5.38u
+ PD=10.68u rfmode=0
M$239 x1p c3b xs1p_a6 vdd sg13_hv_pmos L=0.45u W=5u AS=1.7p AD=0.95p PS=10.68u
+ PD=5.38u rfmode=0
M$240 xs1p_a6 c3b x1p vdd sg13_hv_pmos L=0.45u W=5u AS=0.95p AD=0.95p PS=5.38u
+ PD=5.38u rfmode=0
M$241 x1p c3b xs1p_a6 vdd sg13_hv_pmos L=0.45u W=5u AS=0.95p AD=0.95p PS=5.38u
+ PD=5.38u rfmode=0
M$242 xs1p_a6 c3b x1p vdd sg13_hv_pmos L=0.45u W=5u AS=0.95p AD=1.7p PS=5.38u
+ PD=10.68u rfmode=0
M$243 x1p c3b xs1p_a7 vdd sg13_hv_pmos L=0.45u W=5u AS=1.7p AD=0.95p PS=10.68u
+ PD=5.38u rfmode=0
M$244 xs1p_a7 c3b x1p vdd sg13_hv_pmos L=0.45u W=5u AS=0.95p AD=0.95p PS=5.38u
+ PD=5.38u rfmode=0
M$245 x1p c3b xs1p_a7 vdd sg13_hv_pmos L=0.45u W=5u AS=0.95p AD=0.95p PS=5.38u
+ PD=5.38u rfmode=0
M$246 xs1p_a7 c3b x1p vdd sg13_hv_pmos L=0.45u W=5u AS=0.95p AD=1.7p PS=5.38u
+ PD=10.68u rfmode=0
M$247 x1p c3b xs1p_a8 vdd sg13_hv_pmos L=0.45u W=5u AS=1.7p AD=0.95p PS=10.68u
+ PD=5.38u rfmode=0
M$248 xs1p_a8 c3b x1p vdd sg13_hv_pmos L=0.45u W=5u AS=0.95p AD=0.95p PS=5.38u
+ PD=5.38u rfmode=0
M$249 x1p c3b xs1p_a8 vdd sg13_hv_pmos L=0.45u W=5u AS=0.95p AD=0.95p PS=5.38u
+ PD=5.38u rfmode=0
M$250 xs1p_a8 c3b x1p vdd sg13_hv_pmos L=0.45u W=5u AS=0.95p AD=1.7p PS=5.38u
+ PD=10.68u rfmode=0
M$251 m1n vss xs1p_af vdd sg13_hv_pmos L=0.45u W=5u AS=1.7p AD=0.95p PS=10.68u
+ PD=5.38u rfmode=0
M$252 xs1p_af vss m1n vdd sg13_hv_pmos L=0.45u W=5u AS=0.95p AD=0.95p PS=5.38u
+ PD=5.38u rfmode=0
M$253 m1n vss xs1p_af vdd sg13_hv_pmos L=0.45u W=5u AS=0.95p AD=0.95p PS=5.38u
+ PD=5.38u rfmode=0
M$254 xs1p_af vss m1n vdd sg13_hv_pmos L=0.45u W=5u AS=0.95p AD=1.7p PS=5.38u
+ PD=10.68u rfmode=0
M$255 x2p vss xs2p_b1 vdd sg13_hv_pmos L=0.45u W=5u AS=1.7p AD=0.95p PS=10.68u
+ PD=5.38u rfmode=0
M$256 xs2p_b1 vss x2p vdd sg13_hv_pmos L=0.45u W=5u AS=0.95p AD=0.95p PS=5.38u
+ PD=5.38u rfmode=0
M$257 x2p vss xs2p_b1 vdd sg13_hv_pmos L=0.45u W=5u AS=0.95p AD=0.95p PS=5.38u
+ PD=5.38u rfmode=0
M$258 xs2p_b1 vss x2p vdd sg13_hv_pmos L=0.45u W=5u AS=0.95p AD=1.7p PS=5.38u
+ PD=10.68u rfmode=0
M$259 x2p c4b xs2p_b2 vdd sg13_hv_pmos L=0.45u W=5u AS=1.7p AD=0.95p PS=10.68u
+ PD=5.38u rfmode=0
M$260 xs2p_b2 c4b x2p vdd sg13_hv_pmos L=0.45u W=5u AS=0.95p AD=0.95p PS=5.38u
+ PD=5.38u rfmode=0
M$261 x2p c4b xs2p_b2 vdd sg13_hv_pmos L=0.45u W=5u AS=0.95p AD=0.95p PS=5.38u
+ PD=5.38u rfmode=0
M$262 xs2p_b2 c4b x2p vdd sg13_hv_pmos L=0.45u W=5u AS=0.95p AD=1.7p PS=5.38u
+ PD=10.68u rfmode=0
M$263 x2p c4b xs2p_b3 vdd sg13_hv_pmos L=0.45u W=5u AS=1.7p AD=0.95p PS=10.68u
+ PD=5.38u rfmode=0
M$264 xs2p_b3 c4b x2p vdd sg13_hv_pmos L=0.45u W=5u AS=0.95p AD=0.95p PS=5.38u
+ PD=5.38u rfmode=0
M$265 x2p c4b xs2p_b3 vdd sg13_hv_pmos L=0.45u W=5u AS=0.95p AD=0.95p PS=5.38u
+ PD=5.38u rfmode=0
M$266 xs2p_b3 c4b x2p vdd sg13_hv_pmos L=0.45u W=5u AS=0.95p AD=1.7p PS=5.38u
+ PD=10.68u rfmode=0
M$267 x2p c4b xs2p_b4 vdd sg13_hv_pmos L=0.45u W=5u AS=1.7p AD=0.95p PS=10.68u
+ PD=5.38u rfmode=0
M$268 xs2p_b4 c4b x2p vdd sg13_hv_pmos L=0.45u W=5u AS=0.95p AD=0.95p PS=5.38u
+ PD=5.38u rfmode=0
M$269 x2p c4b xs2p_b4 vdd sg13_hv_pmos L=0.45u W=5u AS=0.95p AD=0.95p PS=5.38u
+ PD=5.38u rfmode=0
M$270 xs2p_b4 c4b x2p vdd sg13_hv_pmos L=0.45u W=5u AS=0.95p AD=1.7p PS=5.38u
+ PD=10.68u rfmode=0
M$271 op2 vss xs2p_bf vdd sg13_hv_pmos L=0.45u W=5u AS=1.7p AD=0.95p PS=10.68u
+ PD=5.38u rfmode=0
M$272 xs2p_bf vss op2 vdd sg13_hv_pmos L=0.45u W=5u AS=0.95p AD=0.95p PS=5.38u
+ PD=5.38u rfmode=0
M$273 op2 vss xs2p_bf vdd sg13_hv_pmos L=0.45u W=5u AS=0.95p AD=0.95p PS=5.38u
+ PD=5.38u rfmode=0
M$274 xs2p_bf vss op2 vdd sg13_hv_pmos L=0.45u W=5u AS=0.95p AD=1.7p PS=5.38u
+ PD=10.68u rfmode=0
M$275 xa1_cb1 c3 xa1_cz1 vdd sg13_hv_pmos L=0.45u W=5u AS=1.7p AD=0.95p
+ PS=10.68u PD=5.38u rfmode=0
M$276 xa1_cz1 c3 xa1_cb1 vdd sg13_hv_pmos L=0.45u W=5u AS=0.95p AD=0.95p
+ PS=5.38u PD=5.38u rfmode=0
M$277 xa1_cb1 c3 xa1_cz1 vdd sg13_hv_pmos L=0.45u W=5u AS=0.95p AD=0.95p
+ PS=5.38u PD=5.38u rfmode=0
M$278 xa1_cz1 c3 xa1_cb1 vdd sg13_hv_pmos L=0.45u W=5u AS=0.95p AD=1.7p
+ PS=5.38u PD=10.68u rfmode=0
M$279 vdd c1 c1b vdd sg13_hv_pmos L=0.45u W=2u AS=0.68p AD=0.68p PS=4.68u
+ PD=4.68u rfmode=0
M$280 vdd c2 c2b vdd sg13_hv_pmos L=0.45u W=2u AS=0.68p AD=0.68p PS=4.68u
+ PD=4.68u rfmode=0
M$281 vdd c3 c3b vdd sg13_hv_pmos L=0.45u W=2u AS=0.68p AD=0.68p PS=4.68u
+ PD=4.68u rfmode=0
M$282 vdd c4 c4b vdd sg13_hv_pmos L=0.45u W=2u AS=0.68p AD=0.68p PS=4.68u
+ PD=4.68u rfmode=0
M$283 xa1_cb2 c3 xa1_cz2 vdd sg13_hv_pmos L=0.45u W=5u AS=1.7p AD=0.95p
+ PS=10.68u PD=5.38u rfmode=0
M$284 xa1_cz2 c3 xa1_cb2 vdd sg13_hv_pmos L=0.45u W=5u AS=0.95p AD=0.95p
+ PS=5.38u PD=5.38u rfmode=0
M$285 xa1_cb2 c3 xa1_cz2 vdd sg13_hv_pmos L=0.45u W=5u AS=0.95p AD=0.95p
+ PS=5.38u PD=5.38u rfmode=0
M$286 xa1_cz2 c3 xa1_cb2 vdd sg13_hv_pmos L=0.45u W=5u AS=0.95p AD=1.7p
+ PS=5.38u PD=10.68u rfmode=0
M$287 x2n vss xs2n_b1 vdd sg13_hv_pmos L=0.45u W=5u AS=1.7p AD=0.95p PS=10.68u
+ PD=5.38u rfmode=0
M$288 xs2n_b1 vss x2n vdd sg13_hv_pmos L=0.45u W=5u AS=0.95p AD=0.95p PS=5.38u
+ PD=5.38u rfmode=0
M$289 x2n vss xs2n_b1 vdd sg13_hv_pmos L=0.45u W=5u AS=0.95p AD=0.95p PS=5.38u
+ PD=5.38u rfmode=0
M$290 xs2n_b1 vss x2n vdd sg13_hv_pmos L=0.45u W=5u AS=0.95p AD=1.7p PS=5.38u
+ PD=10.68u rfmode=0
M$291 x2n c4b xs2n_b2 vdd sg13_hv_pmos L=0.45u W=5u AS=1.7p AD=0.95p PS=10.68u
+ PD=5.38u rfmode=0
M$292 xs2n_b2 c4b x2n vdd sg13_hv_pmos L=0.45u W=5u AS=0.95p AD=0.95p PS=5.38u
+ PD=5.38u rfmode=0
M$293 x2n c4b xs2n_b2 vdd sg13_hv_pmos L=0.45u W=5u AS=0.95p AD=0.95p PS=5.38u
+ PD=5.38u rfmode=0
M$294 xs2n_b2 c4b x2n vdd sg13_hv_pmos L=0.45u W=5u AS=0.95p AD=1.7p PS=5.38u
+ PD=10.68u rfmode=0
M$295 x2n c4b xs2n_b3 vdd sg13_hv_pmos L=0.45u W=5u AS=1.7p AD=0.95p PS=10.68u
+ PD=5.38u rfmode=0
M$296 xs2n_b3 c4b x2n vdd sg13_hv_pmos L=0.45u W=5u AS=0.95p AD=0.95p PS=5.38u
+ PD=5.38u rfmode=0
M$297 x2n c4b xs2n_b3 vdd sg13_hv_pmos L=0.45u W=5u AS=0.95p AD=0.95p PS=5.38u
+ PD=5.38u rfmode=0
M$298 xs2n_b3 c4b x2n vdd sg13_hv_pmos L=0.45u W=5u AS=0.95p AD=1.7p PS=5.38u
+ PD=10.68u rfmode=0
M$299 x2n c4b xs2n_b4 vdd sg13_hv_pmos L=0.45u W=5u AS=1.7p AD=0.95p PS=10.68u
+ PD=5.38u rfmode=0
M$300 xs2n_b4 c4b x2n vdd sg13_hv_pmos L=0.45u W=5u AS=0.95p AD=0.95p PS=5.38u
+ PD=5.38u rfmode=0
M$301 x2n c4b xs2n_b4 vdd sg13_hv_pmos L=0.45u W=5u AS=0.95p AD=0.95p PS=5.38u
+ PD=5.38u rfmode=0
M$302 xs2n_b4 c4b x2n vdd sg13_hv_pmos L=0.45u W=5u AS=0.95p AD=1.7p PS=5.38u
+ PD=10.68u rfmode=0
M$303 on2 vss xs2n_bf vdd sg13_hv_pmos L=0.45u W=5u AS=1.7p AD=0.95p PS=10.68u
+ PD=5.38u rfmode=0
M$304 xs2n_bf vss on2 vdd sg13_hv_pmos L=0.45u W=5u AS=0.95p AD=0.95p PS=5.38u
+ PD=5.38u rfmode=0
M$305 on2 vss xs2n_bf vdd sg13_hv_pmos L=0.45u W=5u AS=0.95p AD=0.95p PS=5.38u
+ PD=5.38u rfmode=0
M$306 xs2n_bf vss on2 vdd sg13_hv_pmos L=0.45u W=5u AS=0.95p AD=1.7p PS=5.38u
+ PD=10.68u rfmode=0
M$307 x1n vss xs1n_a1 vdd sg13_hv_pmos L=0.45u W=5u AS=1.7p AD=0.95p PS=10.68u
+ PD=5.38u rfmode=0
M$308 xs1n_a1 vss x1n vdd sg13_hv_pmos L=0.45u W=5u AS=0.95p AD=0.95p PS=5.38u
+ PD=5.38u rfmode=0
M$309 x1n vss xs1n_a1 vdd sg13_hv_pmos L=0.45u W=5u AS=0.95p AD=0.95p PS=5.38u
+ PD=5.38u rfmode=0
M$310 xs1n_a1 vss x1n vdd sg13_hv_pmos L=0.45u W=5u AS=0.95p AD=1.7p PS=5.38u
+ PD=10.68u rfmode=0
M$311 x1n c1b xs1n_a2 vdd sg13_hv_pmos L=0.45u W=5u AS=1.7p AD=0.95p PS=10.68u
+ PD=5.38u rfmode=0
M$312 xs1n_a2 c1b x1n vdd sg13_hv_pmos L=0.45u W=5u AS=0.95p AD=0.95p PS=5.38u
+ PD=5.38u rfmode=0
M$313 x1n c1b xs1n_a2 vdd sg13_hv_pmos L=0.45u W=5u AS=0.95p AD=0.95p PS=5.38u
+ PD=5.38u rfmode=0
M$314 xs1n_a2 c1b x1n vdd sg13_hv_pmos L=0.45u W=5u AS=0.95p AD=1.7p PS=5.38u
+ PD=10.68u rfmode=0
M$315 x1n c2b xs1n_a3 vdd sg13_hv_pmos L=0.45u W=5u AS=1.7p AD=0.95p PS=10.68u
+ PD=5.38u rfmode=0
M$316 xs1n_a3 c2b x1n vdd sg13_hv_pmos L=0.45u W=5u AS=0.95p AD=0.95p PS=5.38u
+ PD=5.38u rfmode=0
M$317 x1n c2b xs1n_a3 vdd sg13_hv_pmos L=0.45u W=5u AS=0.95p AD=0.95p PS=5.38u
+ PD=5.38u rfmode=0
M$318 xs1n_a3 c2b x1n vdd sg13_hv_pmos L=0.45u W=5u AS=0.95p AD=1.7p PS=5.38u
+ PD=10.68u rfmode=0
M$319 x1n c2b xs1n_a4 vdd sg13_hv_pmos L=0.45u W=5u AS=1.7p AD=0.95p PS=10.68u
+ PD=5.38u rfmode=0
M$320 xs1n_a4 c2b x1n vdd sg13_hv_pmos L=0.45u W=5u AS=0.95p AD=0.95p PS=5.38u
+ PD=5.38u rfmode=0
M$321 x1n c2b xs1n_a4 vdd sg13_hv_pmos L=0.45u W=5u AS=0.95p AD=0.95p PS=5.38u
+ PD=5.38u rfmode=0
M$322 xs1n_a4 c2b x1n vdd sg13_hv_pmos L=0.45u W=5u AS=0.95p AD=1.7p PS=5.38u
+ PD=10.68u rfmode=0
M$323 x1n c3b xs1n_a5 vdd sg13_hv_pmos L=0.45u W=5u AS=1.7p AD=0.95p PS=10.68u
+ PD=5.38u rfmode=0
M$324 xs1n_a5 c3b x1n vdd sg13_hv_pmos L=0.45u W=5u AS=0.95p AD=0.95p PS=5.38u
+ PD=5.38u rfmode=0
M$325 x1n c3b xs1n_a5 vdd sg13_hv_pmos L=0.45u W=5u AS=0.95p AD=0.95p PS=5.38u
+ PD=5.38u rfmode=0
M$326 xs1n_a5 c3b x1n vdd sg13_hv_pmos L=0.45u W=5u AS=0.95p AD=1.7p PS=5.38u
+ PD=10.68u rfmode=0
M$327 x1n c3b xs1n_a6 vdd sg13_hv_pmos L=0.45u W=5u AS=1.7p AD=0.95p PS=10.68u
+ PD=5.38u rfmode=0
M$328 xs1n_a6 c3b x1n vdd sg13_hv_pmos L=0.45u W=5u AS=0.95p AD=0.95p PS=5.38u
+ PD=5.38u rfmode=0
M$329 x1n c3b xs1n_a6 vdd sg13_hv_pmos L=0.45u W=5u AS=0.95p AD=0.95p PS=5.38u
+ PD=5.38u rfmode=0
M$330 xs1n_a6 c3b x1n vdd sg13_hv_pmos L=0.45u W=5u AS=0.95p AD=1.7p PS=5.38u
+ PD=10.68u rfmode=0
M$331 x1n c3b xs1n_a7 vdd sg13_hv_pmos L=0.45u W=5u AS=1.7p AD=0.95p PS=10.68u
+ PD=5.38u rfmode=0
M$332 xs1n_a7 c3b x1n vdd sg13_hv_pmos L=0.45u W=5u AS=0.95p AD=0.95p PS=5.38u
+ PD=5.38u rfmode=0
M$333 x1n c3b xs1n_a7 vdd sg13_hv_pmos L=0.45u W=5u AS=0.95p AD=0.95p PS=5.38u
+ PD=5.38u rfmode=0
M$334 xs1n_a7 c3b x1n vdd sg13_hv_pmos L=0.45u W=5u AS=0.95p AD=1.7p PS=5.38u
+ PD=10.68u rfmode=0
M$335 x1n c3b xs1n_a8 vdd sg13_hv_pmos L=0.45u W=5u AS=1.7p AD=0.95p PS=10.68u
+ PD=5.38u rfmode=0
M$336 xs1n_a8 c3b x1n vdd sg13_hv_pmos L=0.45u W=5u AS=0.95p AD=0.95p PS=5.38u
+ PD=5.38u rfmode=0
M$337 x1n c3b xs1n_a8 vdd sg13_hv_pmos L=0.45u W=5u AS=0.95p AD=0.95p PS=5.38u
+ PD=5.38u rfmode=0
M$338 xs1n_a8 c3b x1n vdd sg13_hv_pmos L=0.45u W=5u AS=0.95p AD=1.7p PS=5.38u
+ PD=10.68u rfmode=0
M$339 m1p vss xs1n_af vdd sg13_hv_pmos L=0.45u W=5u AS=1.7p AD=0.95p PS=10.68u
+ PD=5.38u rfmode=0
M$340 xs1n_af vss m1p vdd sg13_hv_pmos L=0.45u W=5u AS=0.95p AD=0.95p PS=5.38u
+ PD=5.38u rfmode=0
M$341 m1p vss xs1n_af vdd sg13_hv_pmos L=0.45u W=5u AS=0.95p AD=0.95p PS=5.38u
+ PD=5.38u rfmode=0
M$342 xs1n_af vss m1p vdd sg13_hv_pmos L=0.45u W=5u AS=0.95p AD=1.7p PS=5.38u
+ PD=10.68u rfmode=0
M$343 vdd xa1_vbp xa1_vbp vdd sg13_hv_pmos L=1u W=8u AS=2.72p AD=2.72p
+ PS=16.68u PD=16.68u rfmode=0
M$344 vdd xa1_vbp xa1_gn vdd sg13_hv_pmos L=2u W=8u AS=2.72p AD=1.52p PS=16.68u
+ PD=8.38u rfmode=0
M$345 xa1_gn xa1_vbp vdd vdd sg13_hv_pmos L=2u W=8u AS=1.52p AD=1.52p PS=8.38u
+ PD=8.38u rfmode=0
M$346 vdd xa1_vbp xa1_gn vdd sg13_hv_pmos L=2u W=8u AS=1.52p AD=1.52p PS=8.38u
+ PD=8.38u rfmode=0
M$347 xa1_gn xa1_vbp vdd vdd sg13_hv_pmos L=2u W=8u AS=1.52p AD=1.52p PS=8.38u
+ PD=8.38u rfmode=0
M$348 vdd xa1_vbp xa1_gn vdd sg13_hv_pmos L=2u W=8u AS=1.52p AD=1.52p PS=8.38u
+ PD=8.38u rfmode=0
M$349 xa1_gn xa1_vbp vdd vdd sg13_hv_pmos L=2u W=8u AS=1.52p AD=1.52p PS=8.38u
+ PD=8.38u rfmode=0
M$350 vdd xa1_vbp xa1_gn vdd sg13_hv_pmos L=2u W=8u AS=1.52p AD=1.52p PS=8.38u
+ PD=8.38u rfmode=0
M$351 xa1_gn xa1_vbp vdd vdd sg13_hv_pmos L=2u W=8u AS=1.52p AD=1.52p PS=8.38u
+ PD=8.38u rfmode=0
M$352 vdd xa1_vbp xa1_gn vdd sg13_hv_pmos L=2u W=8u AS=1.52p AD=1.52p PS=8.38u
+ PD=8.38u rfmode=0
M$353 xa1_gn xa1_vbp vdd vdd sg13_hv_pmos L=2u W=8u AS=1.52p AD=1.52p PS=8.38u
+ PD=8.38u rfmode=0
M$354 vdd xa1_vbp xa1_gn vdd sg13_hv_pmos L=2u W=8u AS=1.52p AD=1.52p PS=8.38u
+ PD=8.38u rfmode=0
M$355 xa1_gn xa1_vbp vdd vdd sg13_hv_pmos L=2u W=8u AS=1.52p AD=2.72p PS=8.38u
+ PD=16.68u rfmode=0
M$356 vdd xa1_vbpc xa1_vbpc vdd sg13_hv_pmos L=3u W=2u AS=0.68p AD=0.68p
+ PS=4.68u PD=4.68u rfmode=0
M$357 vdd xa1_vbp xa1_vbnc vdd sg13_hv_pmos L=1u W=8u AS=2.72p AD=2.72p
+ PS=16.68u PD=16.68u rfmode=0
M$358 vdd xa1_vbp xa1_tp vdd sg13_hv_pmos L=1u W=9u AS=3.06p AD=1.71p PS=18.68u
+ PD=9.38u rfmode=0
M$359 xa1_tp xa1_vbp vdd vdd sg13_hv_pmos L=1u W=9u AS=1.71p AD=1.71p PS=9.38u
+ PD=9.38u rfmode=0
M$360 vdd xa1_vbp xa1_tp vdd sg13_hv_pmos L=1u W=9u AS=1.71p AD=1.71p PS=9.38u
+ PD=9.38u rfmode=0
M$361 xa1_tp xa1_vbp vdd vdd sg13_hv_pmos L=1u W=9u AS=1.71p AD=1.71p PS=9.38u
+ PD=9.38u rfmode=0
M$362 vdd xa1_vbp xa1_tp vdd sg13_hv_pmos L=1u W=9u AS=1.71p AD=1.71p PS=9.38u
+ PD=9.38u rfmode=0
M$363 xa1_tp xa1_vbp vdd vdd sg13_hv_pmos L=1u W=9u AS=1.71p AD=1.71p PS=9.38u
+ PD=9.38u rfmode=0
M$364 vdd xa1_vbp xa1_tp vdd sg13_hv_pmos L=1u W=9u AS=1.71p AD=1.71p PS=9.38u
+ PD=9.38u rfmode=0
M$365 xa1_tp xa1_vbp vdd vdd sg13_hv_pmos L=1u W=9u AS=1.71p AD=3.06p PS=9.38u
+ PD=18.68u rfmode=0
M$366 xa1_tp x1p xa1_fn vdd sg13_hv_pmos L=2u W=5u AS=1.7p AD=0.95p PS=10.68u
+ PD=5.38u rfmode=0
M$367 xa1_fn x1p xa1_tp vdd sg13_hv_pmos L=2u W=5u AS=0.95p AD=0.95p PS=5.38u
+ PD=5.38u rfmode=0
M$368 xa1_tp x1p xa1_fn vdd sg13_hv_pmos L=2u W=5u AS=0.95p AD=0.95p PS=5.38u
+ PD=5.38u rfmode=0
M$369 xa1_fn x1p xa1_tp vdd sg13_hv_pmos L=2u W=5u AS=0.95p AD=0.95p PS=5.38u
+ PD=5.38u rfmode=0
M$370 xa1_tp x1p xa1_fn vdd sg13_hv_pmos L=2u W=5u AS=0.95p AD=0.95p PS=5.38u
+ PD=5.38u rfmode=0
M$371 xa1_fn x1p xa1_tp vdd sg13_hv_pmos L=2u W=5u AS=0.95p AD=0.95p PS=5.38u
+ PD=5.38u rfmode=0
M$372 xa1_tp x1p xa1_fn vdd sg13_hv_pmos L=2u W=5u AS=0.95p AD=0.95p PS=5.38u
+ PD=5.38u rfmode=0
M$373 xa1_fn x1p xa1_tp vdd sg13_hv_pmos L=2u W=5u AS=0.95p AD=0.95p PS=5.38u
+ PD=5.38u rfmode=0
M$374 xa1_tp x1p xa1_fn vdd sg13_hv_pmos L=2u W=5u AS=0.95p AD=0.95p PS=5.38u
+ PD=5.38u rfmode=0
M$375 xa1_fn x1p xa1_tp vdd sg13_hv_pmos L=2u W=5u AS=0.95p AD=0.95p PS=5.38u
+ PD=5.38u rfmode=0
M$376 xa1_tp x1p xa1_fn vdd sg13_hv_pmos L=2u W=5u AS=0.95p AD=0.95p PS=5.38u
+ PD=5.38u rfmode=0
M$377 xa1_fn x1p xa1_tp vdd sg13_hv_pmos L=2u W=5u AS=0.95p AD=0.95p PS=5.38u
+ PD=5.38u rfmode=0
M$378 xa1_tp x1p xa1_fn vdd sg13_hv_pmos L=2u W=5u AS=0.95p AD=0.95p PS=5.38u
+ PD=5.38u rfmode=0
M$379 xa1_fn x1p xa1_tp vdd sg13_hv_pmos L=2u W=5u AS=0.95p AD=0.95p PS=5.38u
+ PD=5.38u rfmode=0
M$380 xa1_tp x1p xa1_fn vdd sg13_hv_pmos L=2u W=5u AS=0.95p AD=0.95p PS=5.38u
+ PD=5.38u rfmode=0
M$381 xa1_fn x1p xa1_tp vdd sg13_hv_pmos L=2u W=5u AS=0.95p AD=1.7p PS=5.38u
+ PD=10.68u rfmode=0
M$382 xa1_gn xa1_vbpc xa1_o1n vdd sg13_hv_pmos L=1u W=8u AS=2.72p AD=1.52p
+ PS=16.68u PD=8.38u rfmode=0
M$383 xa1_o1n xa1_vbpc xa1_gn vdd sg13_hv_pmos L=1u W=8u AS=1.52p AD=1.52p
+ PS=8.38u PD=8.38u rfmode=0
M$384 xa1_gn xa1_vbpc xa1_o1n vdd sg13_hv_pmos L=1u W=8u AS=1.52p AD=1.52p
+ PS=8.38u PD=8.38u rfmode=0
M$385 xa1_o1n xa1_vbpc xa1_gn vdd sg13_hv_pmos L=1u W=8u AS=1.52p AD=1.52p
+ PS=8.38u PD=8.38u rfmode=0
M$386 xa1_gn xa1_vbpc xa1_o1n vdd sg13_hv_pmos L=1u W=8u AS=1.52p AD=1.52p
+ PS=8.38u PD=8.38u rfmode=0
M$387 xa1_o1n xa1_vbpc xa1_gn vdd sg13_hv_pmos L=1u W=8u AS=1.52p AD=2.72p
+ PS=8.38u PD=16.68u rfmode=0
M$388 vdd xa1_vbp m1p vdd sg13_hv_pmos L=1u W=4u AS=1.36p AD=0.76p PS=8.68u
+ PD=4.38u rfmode=0
M$389 m1p xa1_vbp vdd vdd sg13_hv_pmos L=1u W=4u AS=0.76p AD=0.76p PS=4.38u
+ PD=4.38u rfmode=0
M$390 vdd xa1_vbp m1p vdd sg13_hv_pmos L=1u W=4u AS=0.76p AD=0.76p PS=4.38u
+ PD=4.38u rfmode=0
M$391 m1p xa1_vbp vdd vdd sg13_hv_pmos L=1u W=4u AS=0.76p AD=0.76p PS=4.38u
+ PD=4.38u rfmode=0
M$392 vdd xa1_vbp m1p vdd sg13_hv_pmos L=1u W=4u AS=0.76p AD=0.76p PS=4.38u
+ PD=4.38u rfmode=0
M$393 m1p xa1_vbp vdd vdd sg13_hv_pmos L=1u W=4u AS=0.76p AD=0.76p PS=4.38u
+ PD=4.38u rfmode=0
M$394 vdd xa1_vbp m1p vdd sg13_hv_pmos L=1u W=4u AS=0.76p AD=0.76p PS=4.38u
+ PD=4.38u rfmode=0
M$395 m1p xa1_vbp vdd vdd sg13_hv_pmos L=1u W=4u AS=0.76p AD=0.76p PS=4.38u
+ PD=4.38u rfmode=0
M$396 vdd xa1_vbp m1p vdd sg13_hv_pmos L=1u W=4u AS=0.76p AD=0.76p PS=4.38u
+ PD=4.38u rfmode=0
M$397 m1p xa1_vbp vdd vdd sg13_hv_pmos L=1u W=4u AS=0.76p AD=0.76p PS=4.38u
+ PD=4.38u rfmode=0
M$398 vdd xa1_vbp m1p vdd sg13_hv_pmos L=1u W=4u AS=0.76p AD=0.76p PS=4.38u
+ PD=4.38u rfmode=0
M$399 m1p xa1_vbp vdd vdd sg13_hv_pmos L=1u W=4u AS=0.76p AD=1.36p PS=4.38u
+ PD=8.68u rfmode=0
M$400 vdd xa1_vbp xa1_tc vdd sg13_hv_pmos L=1u W=9.6u AS=3.264p AD=1.824p
+ PS=19.88u PD=9.98u rfmode=0
M$401 xa1_tc xa1_vbp vdd vdd sg13_hv_pmos L=1u W=9.6u AS=1.824p AD=1.824p
+ PS=9.98u PD=9.98u rfmode=0
M$402 vdd xa1_vbp xa1_tc vdd sg13_hv_pmos L=1u W=9.6u AS=1.824p AD=1.824p
+ PS=9.98u PD=9.98u rfmode=0
M$403 xa1_tc xa1_vbp vdd vdd sg13_hv_pmos L=1u W=9.6u AS=1.824p AD=1.824p
+ PS=9.98u PD=9.98u rfmode=0
M$404 vdd xa1_vbp xa1_tc vdd sg13_hv_pmos L=1u W=9.6u AS=1.824p AD=3.264p
+ PS=9.98u PD=19.88u rfmode=0
M$405 xa1_tc xa1_vcms xa1_vcmfb vdd sg13_hv_pmos L=1u W=8u AS=2.72p AD=1.52p
+ PS=16.68u PD=8.38u rfmode=0
M$406 xa1_vcmfb xa1_vcms xa1_tc vdd sg13_hv_pmos L=1u W=8u AS=1.52p AD=2.72p
+ PS=8.38u PD=16.68u rfmode=0
M$407 xa1_tp x1n xa1_fp vdd sg13_hv_pmos L=2u W=5u AS=1.7p AD=0.95p PS=10.68u
+ PD=5.38u rfmode=0
M$408 xa1_fp x1n xa1_tp vdd sg13_hv_pmos L=2u W=5u AS=0.95p AD=0.95p PS=5.38u
+ PD=5.38u rfmode=0
M$409 xa1_tp x1n xa1_fp vdd sg13_hv_pmos L=2u W=5u AS=0.95p AD=0.95p PS=5.38u
+ PD=5.38u rfmode=0
M$410 xa1_fp x1n xa1_tp vdd sg13_hv_pmos L=2u W=5u AS=0.95p AD=0.95p PS=5.38u
+ PD=5.38u rfmode=0
M$411 xa1_tp x1n xa1_fp vdd sg13_hv_pmos L=2u W=5u AS=0.95p AD=0.95p PS=5.38u
+ PD=5.38u rfmode=0
M$412 xa1_fp x1n xa1_tp vdd sg13_hv_pmos L=2u W=5u AS=0.95p AD=0.95p PS=5.38u
+ PD=5.38u rfmode=0
M$413 xa1_tp x1n xa1_fp vdd sg13_hv_pmos L=2u W=5u AS=0.95p AD=0.95p PS=5.38u
+ PD=5.38u rfmode=0
M$414 xa1_fp x1n xa1_tp vdd sg13_hv_pmos L=2u W=5u AS=0.95p AD=0.95p PS=5.38u
+ PD=5.38u rfmode=0
M$415 xa1_tp x1n xa1_fp vdd sg13_hv_pmos L=2u W=5u AS=0.95p AD=0.95p PS=5.38u
+ PD=5.38u rfmode=0
M$416 xa1_fp x1n xa1_tp vdd sg13_hv_pmos L=2u W=5u AS=0.95p AD=0.95p PS=5.38u
+ PD=5.38u rfmode=0
M$417 xa1_tp x1n xa1_fp vdd sg13_hv_pmos L=2u W=5u AS=0.95p AD=0.95p PS=5.38u
+ PD=5.38u rfmode=0
M$418 xa1_fp x1n xa1_tp vdd sg13_hv_pmos L=2u W=5u AS=0.95p AD=0.95p PS=5.38u
+ PD=5.38u rfmode=0
M$419 xa1_tp x1n xa1_fp vdd sg13_hv_pmos L=2u W=5u AS=0.95p AD=0.95p PS=5.38u
+ PD=5.38u rfmode=0
M$420 xa1_fp x1n xa1_tp vdd sg13_hv_pmos L=2u W=5u AS=0.95p AD=0.95p PS=5.38u
+ PD=5.38u rfmode=0
M$421 xa1_tp x1n xa1_fp vdd sg13_hv_pmos L=2u W=5u AS=0.95p AD=0.95p PS=5.38u
+ PD=5.38u rfmode=0
M$422 xa1_fp x1n xa1_tp vdd sg13_hv_pmos L=2u W=5u AS=0.95p AD=1.7p PS=5.38u
+ PD=10.68u rfmode=0
M$423 xa1_tc vcm1 xa1_cmd vdd sg13_hv_pmos L=1u W=8u AS=2.72p AD=1.52p
+ PS=16.68u PD=8.38u rfmode=0
M$424 xa1_cmd vcm1 xa1_tc vdd sg13_hv_pmos L=1u W=8u AS=1.52p AD=2.72p PS=8.38u
+ PD=16.68u rfmode=0
M$425 vdd xa1_vbp m1n vdd sg13_hv_pmos L=1u W=4u AS=1.36p AD=0.76p PS=8.68u
+ PD=4.38u rfmode=0
M$426 m1n xa1_vbp vdd vdd sg13_hv_pmos L=1u W=4u AS=0.76p AD=0.76p PS=4.38u
+ PD=4.38u rfmode=0
M$427 vdd xa1_vbp m1n vdd sg13_hv_pmos L=1u W=4u AS=0.76p AD=0.76p PS=4.38u
+ PD=4.38u rfmode=0
M$428 m1n xa1_vbp vdd vdd sg13_hv_pmos L=1u W=4u AS=0.76p AD=0.76p PS=4.38u
+ PD=4.38u rfmode=0
M$429 vdd xa1_vbp m1n vdd sg13_hv_pmos L=1u W=4u AS=0.76p AD=0.76p PS=4.38u
+ PD=4.38u rfmode=0
M$430 m1n xa1_vbp vdd vdd sg13_hv_pmos L=1u W=4u AS=0.76p AD=0.76p PS=4.38u
+ PD=4.38u rfmode=0
M$431 vdd xa1_vbp m1n vdd sg13_hv_pmos L=1u W=4u AS=0.76p AD=0.76p PS=4.38u
+ PD=4.38u rfmode=0
M$432 m1n xa1_vbp vdd vdd sg13_hv_pmos L=1u W=4u AS=0.76p AD=0.76p PS=4.38u
+ PD=4.38u rfmode=0
M$433 vdd xa1_vbp m1n vdd sg13_hv_pmos L=1u W=4u AS=0.76p AD=0.76p PS=4.38u
+ PD=4.38u rfmode=0
M$434 m1n xa1_vbp vdd vdd sg13_hv_pmos L=1u W=4u AS=0.76p AD=0.76p PS=4.38u
+ PD=4.38u rfmode=0
M$435 vdd xa1_vbp m1n vdd sg13_hv_pmos L=1u W=4u AS=0.76p AD=0.76p PS=4.38u
+ PD=4.38u rfmode=0
M$436 m1n xa1_vbp vdd vdd sg13_hv_pmos L=1u W=4u AS=0.76p AD=1.36p PS=4.38u
+ PD=8.68u rfmode=0
M$437 xa1_gp xa1_vbpc xa1_o1p vdd sg13_hv_pmos L=1u W=8u AS=2.72p AD=1.52p
+ PS=16.68u PD=8.38u rfmode=0
M$438 xa1_o1p xa1_vbpc xa1_gp vdd sg13_hv_pmos L=1u W=8u AS=1.52p AD=1.52p
+ PS=8.38u PD=8.38u rfmode=0
M$439 xa1_gp xa1_vbpc xa1_o1p vdd sg13_hv_pmos L=1u W=8u AS=1.52p AD=1.52p
+ PS=8.38u PD=8.38u rfmode=0
M$440 xa1_o1p xa1_vbpc xa1_gp vdd sg13_hv_pmos L=1u W=8u AS=1.52p AD=1.52p
+ PS=8.38u PD=8.38u rfmode=0
M$441 xa1_gp xa1_vbpc xa1_o1p vdd sg13_hv_pmos L=1u W=8u AS=1.52p AD=1.52p
+ PS=8.38u PD=8.38u rfmode=0
M$442 xa1_o1p xa1_vbpc xa1_gp vdd sg13_hv_pmos L=1u W=8u AS=1.52p AD=2.72p
+ PS=8.38u PD=16.68u rfmode=0
M$443 vdd xa1_vbp xa1_gp vdd sg13_hv_pmos L=2u W=8u AS=2.72p AD=1.52p PS=16.68u
+ PD=8.38u rfmode=0
M$444 xa1_gp xa1_vbp vdd vdd sg13_hv_pmos L=2u W=8u AS=1.52p AD=1.52p PS=8.38u
+ PD=8.38u rfmode=0
M$445 vdd xa1_vbp xa1_gp vdd sg13_hv_pmos L=2u W=8u AS=1.52p AD=1.52p PS=8.38u
+ PD=8.38u rfmode=0
M$446 xa1_gp xa1_vbp vdd vdd sg13_hv_pmos L=2u W=8u AS=1.52p AD=1.52p PS=8.38u
+ PD=8.38u rfmode=0
M$447 vdd xa1_vbp xa1_gp vdd sg13_hv_pmos L=2u W=8u AS=1.52p AD=1.52p PS=8.38u
+ PD=8.38u rfmode=0
M$448 xa1_gp xa1_vbp vdd vdd sg13_hv_pmos L=2u W=8u AS=1.52p AD=1.52p PS=8.38u
+ PD=8.38u rfmode=0
M$449 vdd xa1_vbp xa1_gp vdd sg13_hv_pmos L=2u W=8u AS=1.52p AD=1.52p PS=8.38u
+ PD=8.38u rfmode=0
M$450 xa1_gp xa1_vbp vdd vdd sg13_hv_pmos L=2u W=8u AS=1.52p AD=1.52p PS=8.38u
+ PD=8.38u rfmode=0
M$451 vdd xa1_vbp xa1_gp vdd sg13_hv_pmos L=2u W=8u AS=1.52p AD=1.52p PS=8.38u
+ PD=8.38u rfmode=0
M$452 xa1_gp xa1_vbp vdd vdd sg13_hv_pmos L=2u W=8u AS=1.52p AD=1.52p PS=8.38u
+ PD=8.38u rfmode=0
M$453 vdd xa1_vbp xa1_gp vdd sg13_hv_pmos L=2u W=8u AS=1.52p AD=1.52p PS=8.38u
+ PD=8.38u rfmode=0
M$454 xa1_gp xa1_vbp vdd vdd sg13_hv_pmos L=2u W=8u AS=1.52p AD=2.72p PS=8.38u
+ PD=16.68u rfmode=0
M$455 vdd xa2_vbp xa2_vbp vdd sg13_hv_pmos L=1u W=8u AS=2.72p AD=2.72p
+ PS=16.68u PD=16.68u rfmode=0
M$456 vdd xa2_vbp xa2_gn vdd sg13_hv_pmos L=2u W=8u AS=2.72p AD=1.52p PS=16.68u
+ PD=8.38u rfmode=0
M$457 xa2_gn xa2_vbp vdd vdd sg13_hv_pmos L=2u W=8u AS=1.52p AD=1.52p PS=8.38u
+ PD=8.38u rfmode=0
M$458 vdd xa2_vbp xa2_gn vdd sg13_hv_pmos L=2u W=8u AS=1.52p AD=1.52p PS=8.38u
+ PD=8.38u rfmode=0
M$459 xa2_gn xa2_vbp vdd vdd sg13_hv_pmos L=2u W=8u AS=1.52p AD=2.72p PS=8.38u
+ PD=16.68u rfmode=0
M$460 vdd xa2_vbpc xa2_vbpc vdd sg13_hv_pmos L=3u W=2u AS=0.68p AD=0.68p
+ PS=4.68u PD=4.68u rfmode=0
M$461 vdd xa2_vbp xa2_vbnc vdd sg13_hv_pmos L=1u W=8u AS=2.72p AD=2.72p
+ PS=16.68u PD=16.68u rfmode=0
M$462 xa2_tp x2p xa2_fn vdd sg13_hv_pmos L=2u W=5u AS=1.7p AD=0.95p PS=10.68u
+ PD=5.38u rfmode=0
M$463 xa2_fn x2p xa2_tp vdd sg13_hv_pmos L=2u W=5u AS=0.95p AD=0.95p PS=5.38u
+ PD=5.38u rfmode=0
M$464 xa2_tp x2p xa2_fn vdd sg13_hv_pmos L=2u W=5u AS=0.95p AD=0.95p PS=5.38u
+ PD=5.38u rfmode=0
M$465 xa2_fn x2p xa2_tp vdd sg13_hv_pmos L=2u W=5u AS=0.95p AD=0.95p PS=5.38u
+ PD=5.38u rfmode=0
M$466 xa2_tp x2p xa2_fn vdd sg13_hv_pmos L=2u W=5u AS=0.95p AD=0.95p PS=5.38u
+ PD=5.38u rfmode=0
M$467 xa2_fn x2p xa2_tp vdd sg13_hv_pmos L=2u W=5u AS=0.95p AD=0.95p PS=5.38u
+ PD=5.38u rfmode=0
M$468 xa2_tp x2p xa2_fn vdd sg13_hv_pmos L=2u W=5u AS=0.95p AD=0.95p PS=5.38u
+ PD=5.38u rfmode=0
M$469 xa2_fn x2p xa2_tp vdd sg13_hv_pmos L=2u W=5u AS=0.95p AD=0.95p PS=5.38u
+ PD=5.38u rfmode=0
M$470 xa2_tp x2p xa2_fn vdd sg13_hv_pmos L=2u W=5u AS=0.95p AD=0.95p PS=5.38u
+ PD=5.38u rfmode=0
M$471 xa2_fn x2p xa2_tp vdd sg13_hv_pmos L=2u W=5u AS=0.95p AD=0.95p PS=5.38u
+ PD=5.38u rfmode=0
M$472 xa2_tp x2p xa2_fn vdd sg13_hv_pmos L=2u W=5u AS=0.95p AD=0.95p PS=5.38u
+ PD=5.38u rfmode=0
M$473 xa2_fn x2p xa2_tp vdd sg13_hv_pmos L=2u W=5u AS=0.95p AD=0.95p PS=5.38u
+ PD=5.38u rfmode=0
M$474 xa2_tp x2p xa2_fn vdd sg13_hv_pmos L=2u W=5u AS=0.95p AD=0.95p PS=5.38u
+ PD=5.38u rfmode=0
M$475 xa2_fn x2p xa2_tp vdd sg13_hv_pmos L=2u W=5u AS=0.95p AD=0.95p PS=5.38u
+ PD=5.38u rfmode=0
M$476 xa2_tp x2p xa2_fn vdd sg13_hv_pmos L=2u W=5u AS=0.95p AD=0.95p PS=5.38u
+ PD=5.38u rfmode=0
M$477 xa2_fn x2p xa2_tp vdd sg13_hv_pmos L=2u W=5u AS=0.95p AD=1.7p PS=5.38u
+ PD=10.68u rfmode=0
M$478 xa2_gn xa2_vbpc xa2_o1n vdd sg13_hv_pmos L=1u W=8u AS=2.72p AD=1.52p
+ PS=16.68u PD=8.38u rfmode=0
M$479 xa2_o1n xa2_vbpc xa2_gn vdd sg13_hv_pmos L=1u W=8u AS=1.52p AD=1.52p
+ PS=8.38u PD=8.38u rfmode=0
M$480 xa2_gn xa2_vbpc xa2_o1n vdd sg13_hv_pmos L=1u W=8u AS=1.52p AD=1.52p
+ PS=8.38u PD=8.38u rfmode=0
M$481 xa2_o1n xa2_vbpc xa2_gn vdd sg13_hv_pmos L=1u W=8u AS=1.52p AD=1.52p
+ PS=8.38u PD=8.38u rfmode=0
M$482 xa2_gn xa2_vbpc xa2_o1n vdd sg13_hv_pmos L=1u W=8u AS=1.52p AD=1.52p
+ PS=8.38u PD=8.38u rfmode=0
M$483 xa2_o1n xa2_vbpc xa2_gn vdd sg13_hv_pmos L=1u W=8u AS=1.52p AD=2.72p
+ PS=8.38u PD=16.68u rfmode=0
M$484 vdd xa2_vbp on2 vdd sg13_hv_pmos L=1u W=10u AS=3.4p AD=1.9p PS=20.68u
+ PD=10.38u rfmode=0
M$485 on2 xa2_vbp vdd vdd sg13_hv_pmos L=1u W=10u AS=1.9p AD=1.9p PS=10.38u
+ PD=10.38u rfmode=0
M$486 vdd xa2_vbp on2 vdd sg13_hv_pmos L=1u W=10u AS=1.9p AD=1.9p PS=10.38u
+ PD=10.38u rfmode=0
M$487 on2 xa2_vbp vdd vdd sg13_hv_pmos L=1u W=10u AS=1.9p AD=1.9p PS=10.38u
+ PD=10.38u rfmode=0
M$488 vdd xa2_vbp on2 vdd sg13_hv_pmos L=1u W=10u AS=1.9p AD=1.9p PS=10.38u
+ PD=10.38u rfmode=0
M$489 on2 xa2_vbp vdd vdd sg13_hv_pmos L=1u W=10u AS=1.9p AD=1.9p PS=10.38u
+ PD=10.38u rfmode=0
M$490 vdd xa2_vbp on2 vdd sg13_hv_pmos L=1u W=10u AS=1.9p AD=1.9p PS=10.38u
+ PD=10.38u rfmode=0
M$491 on2 xa2_vbp vdd vdd sg13_hv_pmos L=1u W=10u AS=1.9p AD=1.9p PS=10.38u
+ PD=10.38u rfmode=0
M$492 vdd xa2_vbp on2 vdd sg13_hv_pmos L=1u W=10u AS=1.9p AD=1.9p PS=10.38u
+ PD=10.38u rfmode=0
M$493 on2 xa2_vbp vdd vdd sg13_hv_pmos L=1u W=10u AS=1.9p AD=1.9p PS=10.38u
+ PD=10.38u rfmode=0
M$494 vdd xa2_vbp on2 vdd sg13_hv_pmos L=1u W=10u AS=1.9p AD=1.9p PS=10.38u
+ PD=10.38u rfmode=0
M$495 on2 xa2_vbp vdd vdd sg13_hv_pmos L=1u W=10u AS=1.9p AD=3.4p PS=10.38u
+ PD=20.68u rfmode=0
M$496 vdd xa2_vbp xa2_tc vdd sg13_hv_pmos L=1u W=8u AS=2.72p AD=1.52p PS=16.68u
+ PD=8.38u rfmode=0
M$497 xa2_tc xa2_vbp vdd vdd sg13_hv_pmos L=1u W=8u AS=1.52p AD=1.52p PS=8.38u
+ PD=8.38u rfmode=0
M$498 vdd xa2_vbp xa2_tc vdd sg13_hv_pmos L=1u W=8u AS=1.52p AD=1.52p PS=8.38u
+ PD=8.38u rfmode=0
M$499 xa2_tc xa2_vbp vdd vdd sg13_hv_pmos L=1u W=8u AS=1.52p AD=2.72p PS=8.38u
+ PD=16.68u rfmode=0
M$500 xa2_tp x2n xa2_fp vdd sg13_hv_pmos L=2u W=5u AS=1.7p AD=0.95p PS=10.68u
+ PD=5.38u rfmode=0
M$501 xa2_fp x2n xa2_tp vdd sg13_hv_pmos L=2u W=5u AS=0.95p AD=0.95p PS=5.38u
+ PD=5.38u rfmode=0
M$502 xa2_tp x2n xa2_fp vdd sg13_hv_pmos L=2u W=5u AS=0.95p AD=0.95p PS=5.38u
+ PD=5.38u rfmode=0
M$503 xa2_fp x2n xa2_tp vdd sg13_hv_pmos L=2u W=5u AS=0.95p AD=0.95p PS=5.38u
+ PD=5.38u rfmode=0
M$504 xa2_tp x2n xa2_fp vdd sg13_hv_pmos L=2u W=5u AS=0.95p AD=0.95p PS=5.38u
+ PD=5.38u rfmode=0
M$505 xa2_fp x2n xa2_tp vdd sg13_hv_pmos L=2u W=5u AS=0.95p AD=0.95p PS=5.38u
+ PD=5.38u rfmode=0
M$506 xa2_tp x2n xa2_fp vdd sg13_hv_pmos L=2u W=5u AS=0.95p AD=0.95p PS=5.38u
+ PD=5.38u rfmode=0
M$507 xa2_fp x2n xa2_tp vdd sg13_hv_pmos L=2u W=5u AS=0.95p AD=0.95p PS=5.38u
+ PD=5.38u rfmode=0
M$508 xa2_tp x2n xa2_fp vdd sg13_hv_pmos L=2u W=5u AS=0.95p AD=0.95p PS=5.38u
+ PD=5.38u rfmode=0
M$509 xa2_fp x2n xa2_tp vdd sg13_hv_pmos L=2u W=5u AS=0.95p AD=0.95p PS=5.38u
+ PD=5.38u rfmode=0
M$510 xa2_tp x2n xa2_fp vdd sg13_hv_pmos L=2u W=5u AS=0.95p AD=0.95p PS=5.38u
+ PD=5.38u rfmode=0
M$511 xa2_fp x2n xa2_tp vdd sg13_hv_pmos L=2u W=5u AS=0.95p AD=0.95p PS=5.38u
+ PD=5.38u rfmode=0
M$512 xa2_tp x2n xa2_fp vdd sg13_hv_pmos L=2u W=5u AS=0.95p AD=0.95p PS=5.38u
+ PD=5.38u rfmode=0
M$513 xa2_fp x2n xa2_tp vdd sg13_hv_pmos L=2u W=5u AS=0.95p AD=0.95p PS=5.38u
+ PD=5.38u rfmode=0
M$514 xa2_tp x2n xa2_fp vdd sg13_hv_pmos L=2u W=5u AS=0.95p AD=0.95p PS=5.38u
+ PD=5.38u rfmode=0
M$515 xa2_fp x2n xa2_tp vdd sg13_hv_pmos L=2u W=5u AS=0.95p AD=1.7p PS=5.38u
+ PD=10.68u rfmode=0
M$516 xa2_tc xa2_vcms xa2_vcmfb vdd sg13_hv_pmos L=1u W=8u AS=2.72p AD=1.52p
+ PS=16.68u PD=8.38u rfmode=0
M$517 xa2_vcmfb xa2_vcms xa2_tc vdd sg13_hv_pmos L=1u W=8u AS=1.52p AD=1.52p
+ PS=8.38u PD=8.38u rfmode=0
M$518 xa2_tc xa2_vcms xa2_vcmfb vdd sg13_hv_pmos L=1u W=8u AS=1.52p AD=1.52p
+ PS=8.38u PD=8.38u rfmode=0
M$519 xa2_vcmfb xa2_vcms xa2_tc vdd sg13_hv_pmos L=1u W=8u AS=1.52p AD=2.72p
+ PS=8.38u PD=16.68u rfmode=0
M$520 xa2_tc vcm2 xa2_cmd vdd sg13_hv_pmos L=1u W=8u AS=2.72p AD=1.52p
+ PS=16.68u PD=8.38u rfmode=0
M$521 xa2_cmd vcm2 xa2_tc vdd sg13_hv_pmos L=1u W=8u AS=1.52p AD=1.52p PS=8.38u
+ PD=8.38u rfmode=0
M$522 xa2_tc vcm2 xa2_cmd vdd sg13_hv_pmos L=1u W=8u AS=1.52p AD=1.52p PS=8.38u
+ PD=8.38u rfmode=0
M$523 xa2_cmd vcm2 xa2_tc vdd sg13_hv_pmos L=1u W=8u AS=1.52p AD=2.72p PS=8.38u
+ PD=16.68u rfmode=0
M$524 vdd xa2_vbp op2 vdd sg13_hv_pmos L=1u W=10u AS=3.4p AD=1.9p PS=20.68u
+ PD=10.38u rfmode=0
M$525 op2 xa2_vbp vdd vdd sg13_hv_pmos L=1u W=10u AS=1.9p AD=1.9p PS=10.38u
+ PD=10.38u rfmode=0
M$526 vdd xa2_vbp op2 vdd sg13_hv_pmos L=1u W=10u AS=1.9p AD=1.9p PS=10.38u
+ PD=10.38u rfmode=0
M$527 op2 xa2_vbp vdd vdd sg13_hv_pmos L=1u W=10u AS=1.9p AD=1.9p PS=10.38u
+ PD=10.38u rfmode=0
M$528 vdd xa2_vbp op2 vdd sg13_hv_pmos L=1u W=10u AS=1.9p AD=1.9p PS=10.38u
+ PD=10.38u rfmode=0
M$529 op2 xa2_vbp vdd vdd sg13_hv_pmos L=1u W=10u AS=1.9p AD=1.9p PS=10.38u
+ PD=10.38u rfmode=0
M$530 vdd xa2_vbp op2 vdd sg13_hv_pmos L=1u W=10u AS=1.9p AD=1.9p PS=10.38u
+ PD=10.38u rfmode=0
M$531 op2 xa2_vbp vdd vdd sg13_hv_pmos L=1u W=10u AS=1.9p AD=1.9p PS=10.38u
+ PD=10.38u rfmode=0
M$532 vdd xa2_vbp op2 vdd sg13_hv_pmos L=1u W=10u AS=1.9p AD=1.9p PS=10.38u
+ PD=10.38u rfmode=0
M$533 op2 xa2_vbp vdd vdd sg13_hv_pmos L=1u W=10u AS=1.9p AD=1.9p PS=10.38u
+ PD=10.38u rfmode=0
M$534 vdd xa2_vbp op2 vdd sg13_hv_pmos L=1u W=10u AS=1.9p AD=1.9p PS=10.38u
+ PD=10.38u rfmode=0
M$535 op2 xa2_vbp vdd vdd sg13_hv_pmos L=1u W=10u AS=1.9p AD=3.4p PS=10.38u
+ PD=20.68u rfmode=0
M$536 xa2_gp xa2_vbpc xa2_o1p vdd sg13_hv_pmos L=1u W=8u AS=2.72p AD=1.52p
+ PS=16.68u PD=8.38u rfmode=0
M$537 xa2_o1p xa2_vbpc xa2_gp vdd sg13_hv_pmos L=1u W=8u AS=1.52p AD=1.52p
+ PS=8.38u PD=8.38u rfmode=0
M$538 xa2_gp xa2_vbpc xa2_o1p vdd sg13_hv_pmos L=1u W=8u AS=1.52p AD=1.52p
+ PS=8.38u PD=8.38u rfmode=0
M$539 xa2_o1p xa2_vbpc xa2_gp vdd sg13_hv_pmos L=1u W=8u AS=1.52p AD=1.52p
+ PS=8.38u PD=8.38u rfmode=0
M$540 xa2_gp xa2_vbpc xa2_o1p vdd sg13_hv_pmos L=1u W=8u AS=1.52p AD=1.52p
+ PS=8.38u PD=8.38u rfmode=0
M$541 xa2_o1p xa2_vbpc xa2_gp vdd sg13_hv_pmos L=1u W=8u AS=1.52p AD=2.72p
+ PS=8.38u PD=16.68u rfmode=0
M$542 vdd xa2_vbp xa2_gp vdd sg13_hv_pmos L=2u W=8u AS=2.72p AD=1.52p PS=16.68u
+ PD=8.38u rfmode=0
M$543 xa2_gp xa2_vbp vdd vdd sg13_hv_pmos L=2u W=8u AS=1.52p AD=1.52p PS=8.38u
+ PD=8.38u rfmode=0
M$544 vdd xa2_vbp xa2_gp vdd sg13_hv_pmos L=2u W=8u AS=1.52p AD=1.52p PS=8.38u
+ PD=8.38u rfmode=0
M$545 xa2_gp xa2_vbp vdd vdd sg13_hv_pmos L=2u W=8u AS=1.52p AD=2.72p PS=8.38u
+ PD=16.68u rfmode=0
M$546 vdd xa2_vbp xa2_tp vdd sg13_hv_pmos L=1u W=8u AS=2.72p AD=1.52p PS=16.68u
+ PD=8.38u rfmode=0
M$547 xa2_tp xa2_vbp vdd vdd sg13_hv_pmos L=1u W=8u AS=1.52p AD=1.52p PS=8.38u
+ PD=8.38u rfmode=0
M$548 vdd xa2_vbp xa2_tp vdd sg13_hv_pmos L=1u W=8u AS=1.52p AD=1.52p PS=8.38u
+ PD=8.38u rfmode=0
M$549 xa2_tp xa2_vbp vdd vdd sg13_hv_pmos L=1u W=8u AS=1.52p AD=1.52p PS=8.38u
+ PD=8.38u rfmode=0
M$550 vdd xa2_vbp xa2_tp vdd sg13_hv_pmos L=1u W=8u AS=1.52p AD=1.52p PS=8.38u
+ PD=8.38u rfmode=0
M$551 xa2_tp xa2_vbp vdd vdd sg13_hv_pmos L=1u W=8u AS=1.52p AD=2.72p PS=8.38u
+ PD=16.68u rfmode=0
R$552 inp xs1p_xu1_xr_n1 vss rppd w=1u l=76.925u ps=0u b=0 m=1
R$553 xs1p_a1 xs1p_xu1_xr_n1 vss rppd w=1u l=76.925u ps=0u b=0 m=1
R$554 inn xs1n_xu1_xr_n1 vss rppd w=1u l=76.925u ps=0u b=0 m=1
R$555 xs1n_a1 xs1n_xu1_xr_n1 vss rppd w=1u l=76.925u ps=0u b=0 m=1
R$556 inp xs1p_xu2_xr_n1 vss rppd w=1u l=76.925u ps=0u b=0 m=1
R$557 xs1p_a2 xs1p_xu2_xr_n1 vss rppd w=1u l=76.925u ps=0u b=0 m=1
R$558 inn xs1n_xu2_xr_n1 vss rppd w=1u l=76.925u ps=0u b=0 m=1
R$559 xs1n_a2 xs1n_xu2_xr_n1 vss rppd w=1u l=76.925u ps=0u b=0 m=1
R$560 inp xs1p_xu3_xr_n1 vss rppd w=1u l=76.925u ps=0u b=0 m=1
R$561 xs1p_a3 xs1p_xu3_xr_n1 vss rppd w=1u l=76.925u ps=0u b=0 m=1
R$562 inn xs1n_xu3_xr_n1 vss rppd w=1u l=76.925u ps=0u b=0 m=1
R$563 xs1n_a3 xs1n_xu3_xr_n1 vss rppd w=1u l=76.925u ps=0u b=0 m=1
R$564 inp xs1p_xu4_xr_n1 vss rppd w=1u l=76.925u ps=0u b=0 m=1
R$565 xs1p_a4 xs1p_xu4_xr_n1 vss rppd w=1u l=76.925u ps=0u b=0 m=1
R$566 inn xs1n_xu4_xr_n1 vss rppd w=1u l=76.925u ps=0u b=0 m=1
R$567 xs1n_a4 xs1n_xu4_xr_n1 vss rppd w=1u l=76.925u ps=0u b=0 m=1
R$568 inp xs1p_xu5_xr_n1 vss rppd w=1u l=76.925u ps=0u b=0 m=1
R$569 xs1p_a5 xs1p_xu5_xr_n1 vss rppd w=1u l=76.925u ps=0u b=0 m=1
R$570 inn xs1n_xu5_xr_n1 vss rppd w=1u l=76.925u ps=0u b=0 m=1
R$571 xs1n_a5 xs1n_xu5_xr_n1 vss rppd w=1u l=76.925u ps=0u b=0 m=1
R$572 inp xs1p_xu6_xr_n1 vss rppd w=1u l=76.925u ps=0u b=0 m=1
R$573 xs1p_a6 xs1p_xu6_xr_n1 vss rppd w=1u l=76.925u ps=0u b=0 m=1
R$574 inn xs1n_xu6_xr_n1 vss rppd w=1u l=76.925u ps=0u b=0 m=1
R$575 xs1n_a6 xs1n_xu6_xr_n1 vss rppd w=1u l=76.925u ps=0u b=0 m=1
R$576 inp xs1p_xu7_xr_n1 vss rppd w=1u l=76.925u ps=0u b=0 m=1
R$577 xs1p_a7 xs1p_xu7_xr_n1 vss rppd w=1u l=76.925u ps=0u b=0 m=1
R$578 inn xs1n_xu7_xr_n1 vss rppd w=1u l=76.925u ps=0u b=0 m=1
R$579 xs1n_a7 xs1n_xu7_xr_n1 vss rppd w=1u l=76.925u ps=0u b=0 m=1
R$580 inp xs1p_xu8_xr_n1 vss rppd w=1u l=76.925u ps=0u b=0 m=1
R$581 xs1p_a8 xs1p_xu8_xr_n1 vss rppd w=1u l=76.925u ps=0u b=0 m=1
R$582 inn xs1n_xu8_xr_n1 vss rppd w=1u l=76.925u ps=0u b=0 m=1
R$583 xs1n_a8 xs1n_xu8_xr_n1 vss rppd w=1u l=76.925u ps=0u b=0 m=1
R$584 x1p xs1p_xuf_xr_n1 vss rppd w=1u l=76.925u ps=0u b=0 m=1
R$585 xs1p_af xs1p_xuf_xr_n1 vss rppd w=1u l=76.925u ps=0u b=0 m=1
R$586 x1n xs1n_xuf_xr_n1 vss rppd w=1u l=76.925u ps=0u b=0 m=1
R$587 xs1n_af xs1n_xuf_xr_n1 vss rppd w=1u l=76.925u ps=0u b=0 m=1
R$588 m1p xa1_xrs1_n1 vss rppd w=1u l=77u ps=0u b=0 m=1
R$589 xa1_xrs1_n2 xa1_xrs1_n1 vss rppd w=1u l=77u ps=0u b=0 m=1
R$590 xa1_xrs1_n2 xa1_xrs1_n3 vss rppd w=1u l=77u ps=0u b=0 m=1
R$591 xa1_xrs1_n4 xa1_xrs1_n3 vss rppd w=1u l=77u ps=0u b=0 m=1
R$592 xa1_xrs1_n4 xa1_xrs1_n5 vss rppd w=1u l=77u ps=0u b=0 m=1
R$593 xa1_xrs1_n6 xa1_xrs1_n5 vss rppd w=1u l=77u ps=0u b=0 m=1
R$594 xa1_xrs1_n6 xa1_xrs1_n7 vss rppd w=1u l=77u ps=0u b=0 m=1
R$595 xa1_xrs1_n8 xa1_xrs1_n7 vss rppd w=1u l=77u ps=0u b=0 m=1
R$596 xa1_xrs1_n8 xa1_xrs1_n9 vss rppd w=1u l=77u ps=0u b=0 m=1
R$597 xa1_vcms xa1_xrs1_n9 vss rppd w=1u l=77u ps=0u b=0 m=1
R$598 m1n xa1_xrs2_n1 vss rppd w=1u l=77u ps=0u b=0 m=1
R$599 xa1_xrs2_n2 xa1_xrs2_n1 vss rppd w=1u l=77u ps=0u b=0 m=1
R$600 xa1_xrs2_n2 xa1_xrs2_n3 vss rppd w=1u l=77u ps=0u b=0 m=1
R$601 xa1_xrs2_n4 xa1_xrs2_n3 vss rppd w=1u l=77u ps=0u b=0 m=1
R$602 xa1_xrs2_n4 xa1_xrs2_n5 vss rppd w=1u l=77u ps=0u b=0 m=1
R$603 xa1_xrs2_n6 xa1_xrs2_n5 vss rppd w=1u l=77u ps=0u b=0 m=1
R$604 xa1_xrs2_n6 xa1_xrs2_n7 vss rppd w=1u l=77u ps=0u b=0 m=1
R$605 xa1_xrs2_n8 xa1_xrs2_n7 vss rppd w=1u l=77u ps=0u b=0 m=1
R$606 xa1_xrs2_n8 xa1_xrs2_n9 vss rppd w=1u l=77u ps=0u b=0 m=1
R$607 xa1_vcms xa1_xrs2_n9 vss rppd w=1u l=77u ps=0u b=0 m=1
R$608 on2 xa2_xrs1_n1 vss rppd w=1u l=77u ps=0u b=0 m=1
R$609 xa2_xrs1_n2 xa2_xrs1_n1 vss rppd w=1u l=77u ps=0u b=0 m=1
R$610 xa2_xrs1_n2 xa2_xrs1_n3 vss rppd w=1u l=77u ps=0u b=0 m=1
R$611 xa2_xrs1_n4 xa2_xrs1_n3 vss rppd w=1u l=77u ps=0u b=0 m=1
R$612 xa2_xrs1_n4 xa2_xrs1_n5 vss rppd w=1u l=77u ps=0u b=0 m=1
R$613 xa2_xrs1_n6 xa2_xrs1_n5 vss rppd w=1u l=77u ps=0u b=0 m=1
R$614 xa2_xrs1_n6 xa2_xrs1_n7 vss rppd w=1u l=77u ps=0u b=0 m=1
R$615 xa2_xrs1_n8 xa2_xrs1_n7 vss rppd w=1u l=77u ps=0u b=0 m=1
R$616 xa2_xrs1_n8 xa2_xrs1_n9 vss rppd w=1u l=77u ps=0u b=0 m=1
R$617 xa2_vcms xa2_xrs1_n9 vss rppd w=1u l=77u ps=0u b=0 m=1
R$618 op2 xa2_xrs2_n1 vss rppd w=1u l=77u ps=0u b=0 m=1
R$619 xa2_xrs2_n2 xa2_xrs2_n1 vss rppd w=1u l=77u ps=0u b=0 m=1
R$620 xa2_xrs2_n2 xa2_xrs2_n3 vss rppd w=1u l=77u ps=0u b=0 m=1
R$621 xa2_xrs2_n4 xa2_xrs2_n3 vss rppd w=1u l=77u ps=0u b=0 m=1
R$622 xa2_xrs2_n4 xa2_xrs2_n5 vss rppd w=1u l=77u ps=0u b=0 m=1
R$623 xa2_xrs2_n6 xa2_xrs2_n5 vss rppd w=1u l=77u ps=0u b=0 m=1
R$624 xa2_xrs2_n6 xa2_xrs2_n7 vss rppd w=1u l=77u ps=0u b=0 m=1
R$625 xa2_xrs2_n8 xa2_xrs2_n7 vss rppd w=1u l=77u ps=0u b=0 m=1
R$626 xa2_xrs2_n8 xa2_xrs2_n9 vss rppd w=1u l=77u ps=0u b=0 m=1
R$627 xa2_vcms xa2_xrs2_n9 vss rppd w=1u l=77u ps=0u b=0 m=1
R$628 m1n xs2p_b1 vss rppd w=1u l=74.79u ps=0u b=0 m=1
R$629 m1p xs2n_b1 vss rppd w=1u l=74.79u ps=0u b=0 m=1
R$630 m1p xs2n_b2 vss rppd w=1u l=74.79u ps=0u b=0 m=1
R$631 m1n xs2p_b2 vss rppd w=1u l=74.79u ps=0u b=0 m=1
R$632 m1n xs2p_b3 vss rppd w=1u l=74.79u ps=0u b=0 m=1
R$633 m1p xs2n_b3 vss rppd w=1u l=74.79u ps=0u b=0 m=1
R$634 m1p xs2n_b4 vss rppd w=1u l=74.79u ps=0u b=0 m=1
R$635 m1n xs2p_b4 vss rppd w=1u l=74.79u ps=0u b=0 m=1
R$636 x2p xs2p_bf vss rppd w=1u l=76.9u ps=0u b=0 m=1
R$637 x2n xs2n_bf vss rppd w=1u l=76.9u ps=0u b=0 m=1
R$638 xa1_o1n xa1_cz1 vss rppd w=1u l=21u ps=0u b=0 m=1
R$639 xa1_o1p xa1_cz2 vss rppd w=1u l=21u ps=0u b=0 m=1
R$640 xa2_o1n xa2_cz1 vss rppd w=1u l=7u ps=0u b=0 m=1
R$641 op2 outp vss rppd w=1u l=11.55u ps=0u b=0 m=1
R$642 on2 outn vss rppd w=1u l=11.55u ps=0u b=0 m=1
R$643 xa2_o1p xa2_cz2 vss rppd w=1u l=7u ps=0u b=0 m=1
.ENDS r1_afe_ch
