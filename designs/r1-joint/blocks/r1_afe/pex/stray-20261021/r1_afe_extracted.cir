* Extracted by KLayout with SG13G2 LVS runset on : 26/10/2026 19:05

.SUBCKT r1_afe c1 c2 c3 c4 cosn cosp ib_c1 ib_c2 ib_s1 ib_s2 sinn sinp soutc_n
+ soutc_p souts_n souts_p vcm1 vcm2 vdd vss xrd1_n1 xrd1_n10 xrd1_n11 xrd1_n12
+ xrd1_n13 xrd1_n14 xrd1_n15 xrd1_n16 xrd1_n17 xrd1_n18 xrd1_n19 xrd1_n2
+ xrd1_n20 xrd1_n21 xrd1_n22 xrd1_n23 xrd1_n24 xrd1_n25 xrd1_n26 xrd1_n27
+ xrd1_n3 xrd1_n4 xrd1_n5 xrd1_n6 xrd1_n7 xrd1_n8 xrd1_n9 xrd2_n1 xrd2_n10
+ xrd2_n11 xrd2_n12 xrd2_n13 xrd2_n14 xrd2_n15 xrd2_n16 xrd2_n2 xrd2_n3 xrd2_n4
+ xrd2_n5 xrd2_n6 xrd2_n7 xrd2_n8 xrd2_n9
M$1 \$15 vss \$16 vss sg13_lv_nmos L=0.2u W=0.6u AS=0.3p AD=0.3p PS=2.2u
+ PD=2.2u rfmode=0
M$2 \$18 souts_p \$17 vss sg13_lv_nmos L=0.2u W=0.6u AS=0.3p AD=0.3p PS=2.2u
+ PD=2.2u rfmode=0
M$3 \$20 sinp \$19 vss sg13_lv_nmos L=0.2u W=0.6u AS=0.3p AD=0.3p PS=2.2u
+ PD=2.2u rfmode=0
M$4 \$24 sinn \$23 vss sg13_lv_nmos L=0.2u W=0.6u AS=0.3p AD=0.3p PS=2.2u
+ PD=2.2u rfmode=0
M$5 \$26 souts_n \$25 vss sg13_lv_nmos L=0.2u W=0.6u AS=0.3p AD=0.3p PS=2.2u
+ PD=2.2u rfmode=0
M$6 \$28 vss \$27 vss sg13_lv_nmos L=0.2u W=0.6u AS=0.3p AD=0.3p PS=2.2u
+ PD=2.2u rfmode=0
M$7 \$30 ib_s1 \$29 vss sg13_lv_nmos L=0.2u W=0.6u AS=0.3p AD=0.3p PS=2.2u
+ PD=2.2u rfmode=0
M$8 \$31 ib_s2 \$32 vss sg13_lv_nmos L=0.2u W=0.6u AS=0.3p AD=0.3p PS=2.2u
+ PD=2.2u rfmode=0
M$9 \$34 vcm1 \$33 vss sg13_lv_nmos L=0.2u W=0.6u AS=0.3p AD=0.3p PS=2.2u
+ PD=2.2u rfmode=0
M$10 \$36 vcm2 \$35 vss sg13_lv_nmos L=0.2u W=0.6u AS=0.3p AD=0.3p PS=2.2u
+ PD=2.2u rfmode=0
M$11 \$38 vdd \$37 vss sg13_lv_nmos L=0.2u W=0.6u AS=0.3p AD=0.3p PS=2.2u
+ PD=2.2u rfmode=0
M$12 \$40 c1 \$39 vss sg13_lv_nmos L=0.2u W=0.6u AS=0.3p AD=0.3p PS=2.2u
+ PD=2.2u rfmode=0
M$13 \$42 c2 \$41 vss sg13_lv_nmos L=0.2u W=0.6u AS=0.3p AD=0.3p PS=2.2u
+ PD=2.2u rfmode=0
M$14 \$43 c3 \$44 vss sg13_lv_nmos L=0.2u W=0.6u AS=0.3p AD=0.3p PS=2.2u
+ PD=2.2u rfmode=0
M$15 \$46 c4 \$45 vss sg13_lv_nmos L=0.2u W=0.6u AS=0.3p AD=0.3p PS=2.2u
+ PD=2.2u rfmode=0
M$16 \$47 vdd \$48 vss sg13_lv_nmos L=0.2u W=0.6u AS=0.3p AD=0.3p PS=2.2u
+ PD=2.2u rfmode=0
M$17 \$49 vss \$50 vss sg13_lv_nmos L=0.2u W=0.6u AS=0.3p AD=0.3p PS=2.2u
+ PD=2.2u rfmode=0
M$18 \$51 vdd \$52 vss sg13_lv_nmos L=0.2u W=0.6u AS=0.3p AD=0.3p PS=2.2u
+ PD=2.2u rfmode=0
M$19 \$103 vss \$102 vss sg13_lv_nmos L=0.2u W=0.6u AS=0.3p AD=0.3p PS=2.2u
+ PD=2.2u rfmode=0
M$20 \$105 soutc_p \$104 vss sg13_lv_nmos L=0.2u W=0.6u AS=0.3p AD=0.3p PS=2.2u
+ PD=2.2u rfmode=0
M$21 \$107 cosp \$106 vss sg13_lv_nmos L=0.2u W=0.6u AS=0.3p AD=0.3p PS=2.2u
+ PD=2.2u rfmode=0
M$22 \$111 cosn \$110 vss sg13_lv_nmos L=0.2u W=0.6u AS=0.3p AD=0.3p PS=2.2u
+ PD=2.2u rfmode=0
M$23 \$112 soutc_n \$113 vss sg13_lv_nmos L=0.2u W=0.6u AS=0.3p AD=0.3p PS=2.2u
+ PD=2.2u rfmode=0
M$24 \$114 vss \$115 vss sg13_lv_nmos L=0.2u W=0.6u AS=0.3p AD=0.3p PS=2.2u
+ PD=2.2u rfmode=0
M$25 \$116 ib_c1 \$117 vss sg13_lv_nmos L=0.2u W=0.6u AS=0.3p AD=0.3p PS=2.2u
+ PD=2.2u rfmode=0
M$26 \$118 ib_c2 \$119 vss sg13_lv_nmos L=0.2u W=0.6u AS=0.3p AD=0.3p PS=2.2u
+ PD=2.2u rfmode=0
M$27 \$120 vcm1 \$121 vss sg13_lv_nmos L=0.2u W=0.6u AS=0.3p AD=0.3p PS=2.2u
+ PD=2.2u rfmode=0
M$28 \$123 vcm2 \$122 vss sg13_lv_nmos L=0.2u W=0.6u AS=0.3p AD=0.3p PS=2.2u
+ PD=2.2u rfmode=0
M$29 \$125 vdd \$124 vss sg13_lv_nmos L=0.2u W=0.6u AS=0.3p AD=0.3p PS=2.2u
+ PD=2.2u rfmode=0
M$30 \$127 c1 \$126 vss sg13_lv_nmos L=0.2u W=0.6u AS=0.3p AD=0.3p PS=2.2u
+ PD=2.2u rfmode=0
M$31 \$129 c2 \$128 vss sg13_lv_nmos L=0.2u W=0.6u AS=0.3p AD=0.3p PS=2.2u
+ PD=2.2u rfmode=0
M$32 \$131 c3 \$130 vss sg13_lv_nmos L=0.2u W=0.6u AS=0.3p AD=0.3p PS=2.2u
+ PD=2.2u rfmode=0
M$33 \$133 c4 \$132 vss sg13_lv_nmos L=0.2u W=0.6u AS=0.3p AD=0.3p PS=2.2u
+ PD=2.2u rfmode=0
M$34 \$134 vdd \$135 vss sg13_lv_nmos L=0.2u W=0.6u AS=0.3p AD=0.3p PS=2.2u
+ PD=2.2u rfmode=0
M$35 \$137 vss \$136 vss sg13_lv_nmos L=0.2u W=0.6u AS=0.3p AD=0.3p PS=2.2u
+ PD=2.2u rfmode=0
M$36 \$139 vdd \$138 vss sg13_lv_nmos L=0.2u W=0.6u AS=0.3p AD=0.3p PS=2.2u
+ PD=2.2u rfmode=0
R$37 vdd xrd1_n1 vss rppd w=1u l=76.5u ps=0u b=0 m=1
R$38 xrd1_n2 xrd1_n1 vss rppd w=1u l=76.5u ps=0u b=0 m=1
R$39 xrd1_n2 xrd1_n3 vss rppd w=1u l=76.5u ps=0u b=0 m=1
R$40 xrd1_n4 xrd1_n3 vss rppd w=1u l=76.5u ps=0u b=0 m=1
R$41 xrd1_n4 xrd1_n5 vss rppd w=1u l=76.5u ps=0u b=0 m=1
R$42 xrd1_n6 xrd1_n5 vss rppd w=1u l=76.5u ps=0u b=0 m=1
R$43 xrd1_n6 xrd1_n7 vss rppd w=1u l=76.5u ps=0u b=0 m=1
R$44 xrd1_n8 xrd1_n7 vss rppd w=1u l=76.5u ps=0u b=0 m=1
R$45 xrd1_n8 xrd1_n9 vss rppd w=1u l=76.5u ps=0u b=0 m=1
R$46 xrd1_n10 xrd1_n9 vss rppd w=1u l=76.5u ps=0u b=0 m=1
R$47 xrd1_n10 xrd1_n11 vss rppd w=1u l=76.5u ps=0u b=0 m=1
R$48 xrd1_n12 xrd1_n11 vss rppd w=1u l=76.5u ps=0u b=0 m=1
R$49 xrd1_n12 xrd1_n13 vss rppd w=1u l=76.5u ps=0u b=0 m=1
R$50 xrd1_n14 xrd1_n13 vss rppd w=1u l=76.5u ps=0u b=0 m=1
R$51 xrd1_n14 xrd1_n15 vss rppd w=1u l=76.5u ps=0u b=0 m=1
R$52 xrd1_n16 xrd1_n15 vss rppd w=1u l=76.5u ps=0u b=0 m=1
R$53 xrd1_n16 xrd1_n17 vss rppd w=1u l=76.5u ps=0u b=0 m=1
R$54 xrd1_n18 xrd1_n17 vss rppd w=1u l=76.5u ps=0u b=0 m=1
R$55 xrd1_n18 xrd1_n19 vss rppd w=1u l=76.5u ps=0u b=0 m=1
R$56 xrd1_n20 xrd1_n19 vss rppd w=1u l=76.5u ps=0u b=0 m=1
R$57 xrd1_n20 xrd1_n21 vss rppd w=1u l=76.5u ps=0u b=0 m=1
R$58 xrd1_n22 xrd1_n21 vss rppd w=1u l=76.5u ps=0u b=0 m=1
R$59 xrd1_n22 xrd1_n23 vss rppd w=1u l=76.5u ps=0u b=0 m=1
R$60 xrd1_n24 xrd1_n23 vss rppd w=1u l=76.5u ps=0u b=0 m=1
R$61 xrd1_n24 xrd1_n25 vss rppd w=1u l=76.5u ps=0u b=0 m=1
R$62 xrd1_n26 xrd1_n25 vss rppd w=1u l=76.5u ps=0u b=0 m=1
R$63 xrd1_n26 xrd1_n27 vss rppd w=1u l=76.5u ps=0u b=0 m=1
R$64 vcm1 xrd1_n27 vss rppd w=1u l=76.5u ps=0u b=0 m=1
R$65 vcm1 xrd2_n1 vss rppd w=1u l=55u ps=0u b=0 m=1
R$66 xrd2_n2 xrd2_n1 vss rppd w=1u l=55u ps=0u b=0 m=1
R$67 xrd2_n2 xrd2_n3 vss rppd w=1u l=55u ps=0u b=0 m=1
R$68 xrd2_n4 xrd2_n3 vss rppd w=1u l=55u ps=0u b=0 m=1
R$69 xrd2_n4 xrd2_n5 vss rppd w=1u l=55u ps=0u b=0 m=1
R$70 xrd2_n6 xrd2_n5 vss rppd w=1u l=55u ps=0u b=0 m=1
R$71 xrd2_n6 xrd2_n7 vss rppd w=1u l=55u ps=0u b=0 m=1
R$72 xrd2_n8 xrd2_n7 vss rppd w=1u l=55u ps=0u b=0 m=1
R$73 xrd2_n8 xrd2_n9 vss rppd w=1u l=55u ps=0u b=0 m=1
R$74 xrd2_n10 xrd2_n9 vss rppd w=1u l=55u ps=0u b=0 m=1
R$75 xrd2_n10 xrd2_n11 vss rppd w=1u l=55u ps=0u b=0 m=1
R$76 xrd2_n12 xrd2_n11 vss rppd w=1u l=55u ps=0u b=0 m=1
R$77 xrd2_n12 xrd2_n13 vss rppd w=1u l=55u ps=0u b=0 m=1
R$78 xrd2_n14 xrd2_n13 vss rppd w=1u l=55u ps=0u b=0 m=1
R$79 xrd2_n14 xrd2_n15 vss rppd w=1u l=55u ps=0u b=0 m=1
R$80 xrd2_n16 xrd2_n15 vss rppd w=1u l=55u ps=0u b=0 m=1
R$81 xrd2_n16 vss vss rppd w=1u l=55u ps=0u b=0 m=1
.ENDS r1_afe
