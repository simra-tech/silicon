* tb_afe_settle_adc -- r1_afe driving the r1_adc track-and-hold model (2026-10-20 r1_adc schematic: top-plate CDAC):
* variant with the r1_adc numbers: per output a 100 ohm switch into Cs = @@CS@@ to ground (CDAC side, 128 x 22 fF),
* track 250 ns, hold 250 ns, Cs reset to @@VRST@@ V during hold (top plate after monotonic switching)
* (the full output step is re-acquired every cycle). Both channels sampled on the same edge.
* DC input at +full scale for the gain step (output +1.0 V differential). Error = sampled differential value at
* the end of track minus the unloaded DC output (operating point before switching), in volts and 12-bit LSB
* (LSB = @@LSB@@ V differential; revision B used 2.4 V / 4096 = 0.586 mV, revision C 2.0 V / 4096 = 0.488 mV, D11).
@@HEAD@@
.options reltol=1e-5 abstol=1e-13 vntol=1e-8
Vic ic 0 dc {VCMI}
Vd vd 0 dc @@AMP@@
Esp sinp ic vd 0 0.5
Esn sinn ic vd 0 -0.5
Ecp cosp ic vd 0 0.5
Ecn cosn ic vd 0 -0.5
Vrst vrst 0 dc @@VRST@@
.model swm sw vt=0.6 vh=0.01 ron=100 roff=1e12
Vtr trk 0 dc 0 pulse(0 1.2 0 0.2n 0.2n 249.6n 500n)
Vho hld 0 dc 1.2 pulse(1.2 0 0 0.2n 0.2n 249.6n 500n)
S1 souts_p hsp trk 0 swm
S2 souts_n hsn trk 0 swm
S3 soutc_p hcp trk 0 swm
S4 soutc_n hcn trk 0 swm
S5 hsp vrst hld 0 swm
S6 hsn vrst hld 0 swm
S7 hcp vrst hld 0 swm
S8 hcn vrst hld 0 swm
Ch1 hsp 0 @@CS@@
Ch2 hsn 0 @@CS@@
Ch3 hcp 0 @@CS@@
Ch4 hcn 0 @@CS@@
Cw1 souts_p 0 0.2p
Cw2 souts_n 0 0.2p
Cw3 soutc_p 0 0.2p
Cw4 soutc_n 0 0.2p
XDUT sinp sinn cosp cosn souts_p souts_n soutc_p soutc_n vcm2 ib_s1 ib_s2 ib_c1 ib_c2 c1 c2 c3 c4 vdd 0 r1_afe
.control
@@CODES@@
let k = @@CODE@@
let vh = @@VDDA@@
let a1 = ctab[4*k]*vh
let a2 = ctab[4*k+1]*vh
let a3 = ctab[4*k+2]*vh
let a4 = ctab[4*k+3]*vh
alter vc1 dc = $&a1
alter vc2 dc = $&a2
alter vc3 dc = $&a3
alter vc4 dc = $&a4
alter vtr pulse = [ 0 0 0 0.2n 0.2n 249.6n 500n ]
alter vho pulse = [ 1.2 1.2 0 0.2n 0.2n 249.6n 500n ]
op
let v0s = v(souts_p)-v(souts_n)
let v0c = v(soutc_p)-v(soutc_n)
let r0s = v0s
let r0c = v0c
setplot const
let r0s = op1.r0s
let r0c = op1.r0c
alter vtr pulse = [ 0 1.2 0 0.2n 0.2n 249.6n 500n ]
alter vho pulse = [ 1.2 0 0 0.2n 0.2n 249.6n 500n ]
tran 0.1n 5.5u 0 0.5n
let hs = v(hsp)-v(hsn)
let hc = v(hcp)-v(hcn)
let es = hs - r0s
let ec = hc - r0c
foreach t 2.249u 2.749u 3.249u 3.749u 4.249u 4.749u 5.249u
  meas tran xs find es at=$t
  meas tran xc find ec at=$t
  let ls = xs/@@LSB@@
  let lc = xc/@@LSB@@
  echo "STROW code=$&k t=$t vout0=$&r0s err_s=$&xs err_c=$&xc lsb_s=$&ls lsb_c=$&lc"
end
* error vs track time in the last cycle (start of track at 5.0 us)
foreach t 5.05u 5.1u 5.15u 5.2u
  meas tran xs find es at=$t
  let ls = xs/@@LSB@@
  echo "STTROW code=$&k t=$t err_s=$&xs lsb_s=$&ls"
end
wrdata @@RAW@@_settle.txt hs hc es ec v(souts_p) v(souts_n)
.endc
.end
