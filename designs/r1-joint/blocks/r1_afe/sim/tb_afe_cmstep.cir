* tb_afe_cmstep -- common-mode step test (revision C). Excites the stage-1 and stage-2 CM loops with large
* steps while a full-scale 100 kHz sine runs on both channels (the condition in which revision-B variants
* oscillated, runs dev-quick-03, dev-revb-01, dev-revb-02). Events (edges in brackets):
*   10 us  input pin CM 2.45 V -> 0.60 V (20 ns)      20 us  back to 2.45 V (20 ns)
*   30 us  vcm2 0.60 V -> 0.65 V (5 ns)               35 us  back to 0.60 V (5 ns)
*   40 us  VDDA -0.2 V (10 ns)                        45 us  back (10 ns)
* run_afe.py reads the waveform file and reports per event the peak CM deviation, the settling time of the
* stage-1 CM (m1p + m1n)/2 and of the output CM, and the CM peak-to-peak in the last 2 us before the next event
* (an oscillation shows as a large value there). Load 100 ohm + 2.8 pF per output (r1_adc CDAC in track).
@@HEAD@@
.options reltol=1e-4 abstol=1e-12 vntol=1e-7
Vic ic 0 dc 2.45 pwl(0 2.45 10u 2.45 10.02u 0.6 20u 0.6 20.02u 2.45)
Vds vds 0 dc 0 sin(0 @@AMP@@ 100k 0 0 0)
Vdc vdc 0 dc 0 sin(0 @@AMP@@ 100k 0 0 90)
Esp sinp ic vds 0 0.5
Esn sinn ic vds 0 -0.5
Ecp cosp ic vdc 0 0.5
Ecn cosn ic vdc 0 -0.5
Rl1 souts_p l1 100
Rl2 souts_n l2 100
Rl3 soutc_p l3 100
Rl4 soutc_n l4 100
Cl1 l1 0 2.8p
Cl2 l2 0 2.8p
Cl3 l3 0 2.8p
Cl4 l4 0 2.8p
* steps in series with the head sources: vcm2 +50 mV 30-35 us, VDDA -0.2 V 40-45 us
Vstc vcm2s vcm2 dc 0 pwl(0 0 30u 0 30.005u 0.05 35u 0.05 35.005u 0)
Vstd vdds vdd dc 0 pwl(0 0 40u 0 40.01u -0.2 45u -0.2 45.01u 0)
XDUT sinp sinn cosp cosn souts_p souts_n soutc_p soutc_n vcm2s ib_s1 ib_s2 ib_c1 ib_c2 c1 c2 c3 c4 vdds 0 r1_afe
.control
@@CODES@@
let k = @@CODE@@
let vh = @@VDDA@@
let a1 = ctab[4*k]*vh
let a2 = ctab[4*k+1]*vh
let a3 = ctab[4*k+2]*vh
let a4 = ctab[4*k+3]*vh
alter vc1 dc = $&a1
alter vc2 dc = $&a2
alter vc3 dc = $&a3
alter vc4 dc = $&a4
tran 2n 50u 0 2n
let o1cm = (v(xdut.xsin.m1p)+v(xdut.xsin.m1n))/2
let ocm = (v(souts_p)+v(souts_n))/2
let o1cmc = (v(xdut.xcos.m1p)+v(xdut.xcos.m1n))/2
linearize o1cm ocm o1cmc
wrdata @@RAW@@_cm.txt o1cm ocm o1cmc
echo "CMSTEPFILE code=$&k"
.endc
.end
