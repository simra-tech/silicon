* cell R1_PADRING
* pin VDDA
* pin ISA_P
* pin ISA_N
* pin ISB_P
* pin ISB_N
* pin FAULT_N
* pin GATE_A
* pin GATE_B
* pin GATE_C
* pin CS_N
* pin MA_SCLK
* pin SLO_SDO
* pin SDI
* pin EN_STO_IN
* pin SIN_P
* pin SIN_N
* pin COS_P
* pin COS_N
* pin VDD
* pin VSS
* pin IOVDD
* pin IOVSS
.SUBCKT R1_PADRING VDDA ISA_P ISA_N ISB_P ISB_N FAULT_N GATE_A GATE_B GATE_C
+ CS_N MA_SCLK SLO_SDO SDI EN_STO_IN SIN_P SIN_N COS_P COS_N VDD VSS IOVDD IOVSS
* device instance PAD01_VDD._G1_TAP_SYNTAX_XR1 r0 *1 0,0 PTAP1
R1PAD01_VDD._G1_TAP_SYNTAX_XR1 IOVSS SUBSTRATE_NODE PTAP1 A=1997.6623p P=411.58u
* device instance PAD01_VDD._G1_TAP_SYNTAX_XR0 r0 *1 0,0 PTAP1
R2PAD01_VDD._G1_TAP_SYNTAX_XR0 VSS SUBSTRATE_NODE PTAP1 A=24p P=160.6u
* device instance PAD01_VDD.I1.N0<1> r0 *1 0,0 sg13_hv_nmos
MPAD01_VDD.I1.N0<1> IOVSS PAD01_VDD.NET3 VDD SUBSTRATE_NODE sg13_hv_nmos L=0.6u
+ W=4.4u AS=0p AD=0p PS=0u PD=0u rfmode=0
* device instance PAD01_VDD.I1.N0<2> r0 *1 0,0 sg13_hv_nmos
MPAD01_VDD.I1.N0<2> IOVSS PAD01_VDD.NET3 VDD SUBSTRATE_NODE sg13_hv_nmos L=0.6u
+ W=4.4u AS=0p AD=0p PS=0u PD=0u rfmode=0
* device instance PAD01_VDD.I1.N0<3> r0 *1 0,0 sg13_hv_nmos
MPAD01_VDD.I1.N0<3> IOVSS PAD01_VDD.NET3 VDD SUBSTRATE_NODE sg13_hv_nmos L=0.6u
+ W=4.4u AS=0p AD=0p PS=0u PD=0u rfmode=0
* device instance PAD01_VDD.I1.N0<4> r0 *1 0,0 sg13_hv_nmos
MPAD01_VDD.I1.N0<4> IOVSS PAD01_VDD.NET3 VDD SUBSTRATE_NODE sg13_hv_nmos L=0.6u
+ W=4.4u AS=0p AD=0p PS=0u PD=0u rfmode=0
* device instance PAD01_VDD.I1.N0<5> r0 *1 0,0 sg13_hv_nmos
MPAD01_VDD.I1.N0<5> IOVSS PAD01_VDD.NET3 VDD SUBSTRATE_NODE sg13_hv_nmos L=0.6u
+ W=4.4u AS=0p AD=0p PS=0u PD=0u rfmode=0
* device instance PAD01_VDD.I1.N0<6> r0 *1 0,0 sg13_hv_nmos
MPAD01_VDD.I1.N0<6> IOVSS PAD01_VDD.NET3 VDD SUBSTRATE_NODE sg13_hv_nmos L=0.6u
+ W=4.4u AS=0p AD=0p PS=0u PD=0u rfmode=0
* device instance PAD01_VDD.I1.N0<7> r0 *1 0,0 sg13_hv_nmos
MPAD01_VDD.I1.N0<7> IOVSS PAD01_VDD.NET3 VDD SUBSTRATE_NODE sg13_hv_nmos L=0.6u
+ W=4.4u AS=0p AD=0p PS=0u PD=0u rfmode=0
* device instance PAD01_VDD.I1.N0<8> r0 *1 0,0 sg13_hv_nmos
MPAD01_VDD.I1.N0<8> IOVSS PAD01_VDD.NET3 VDD SUBSTRATE_NODE sg13_hv_nmos L=0.6u
+ W=4.4u AS=0p AD=0p PS=0u PD=0u rfmode=0
* device instance PAD01_VDD.I1.N0<9> r0 *1 0,0 sg13_hv_nmos
MPAD01_VDD.I1.N0<9> IOVSS PAD01_VDD.NET3 VDD SUBSTRATE_NODE sg13_hv_nmos L=0.6u
+ W=4.4u AS=0p AD=0p PS=0u PD=0u rfmode=0
* device instance PAD01_VDD.I1.N0<10> r0 *1 0,0 sg13_hv_nmos
MPAD01_VDD.I1.N0<10> IOVSS PAD01_VDD.NET3 VDD SUBSTRATE_NODE sg13_hv_nmos
+ L=0.6u W=4.4u AS=0p AD=0p PS=0u PD=0u rfmode=0
* device instance PAD01_VDD.I1.N0<11> r0 *1 0,0 sg13_hv_nmos
MPAD01_VDD.I1.N0<11> IOVSS PAD01_VDD.NET3 VDD SUBSTRATE_NODE sg13_hv_nmos
+ L=0.6u W=4.4u AS=0p AD=0p PS=0u PD=0u rfmode=0
* device instance PAD01_VDD.I1.N0<12> r0 *1 0,0 sg13_hv_nmos
MPAD01_VDD.I1.N0<12> IOVSS PAD01_VDD.NET3 VDD SUBSTRATE_NODE sg13_hv_nmos
+ L=0.6u W=4.4u AS=0p AD=0p PS=0u PD=0u rfmode=0
* device instance PAD01_VDD.I1.N0<13> r0 *1 0,0 sg13_hv_nmos
MPAD01_VDD.I1.N0<13> IOVSS PAD01_VDD.NET3 VDD SUBSTRATE_NODE sg13_hv_nmos
+ L=0.6u W=4.4u AS=0p AD=0p PS=0u PD=0u rfmode=0
* device instance PAD01_VDD.I1.N0<14> r0 *1 0,0 sg13_hv_nmos
MPAD01_VDD.I1.N0<14> IOVSS PAD01_VDD.NET3 VDD SUBSTRATE_NODE sg13_hv_nmos
+ L=0.6u W=4.4u AS=0p AD=0p PS=0u PD=0u rfmode=0
* device instance PAD01_VDD.I1.N0<15> r0 *1 0,0 sg13_hv_nmos
MPAD01_VDD.I1.N0<15> IOVSS PAD01_VDD.NET3 VDD SUBSTRATE_NODE sg13_hv_nmos
+ L=0.6u W=4.4u AS=0p AD=0p PS=0u PD=0u rfmode=0
* device instance PAD01_VDD.I1.N0<16> r0 *1 0,0 sg13_hv_nmos
MPAD01_VDD.I1.N0<16> IOVSS PAD01_VDD.NET3 VDD SUBSTRATE_NODE sg13_hv_nmos
+ L=0.6u W=4.4u AS=0p AD=0p PS=0u PD=0u rfmode=0
* device instance PAD01_VDD.I1.N0<17> r0 *1 0,0 sg13_hv_nmos
MPAD01_VDD.I1.N0<17> IOVSS PAD01_VDD.NET3 VDD SUBSTRATE_NODE sg13_hv_nmos
+ L=0.6u W=4.4u AS=0p AD=0p PS=0u PD=0u rfmode=0
* device instance PAD01_VDD.I1.N0<18> r0 *1 0,0 sg13_hv_nmos
MPAD01_VDD.I1.N0<18> IOVSS PAD01_VDD.NET3 VDD SUBSTRATE_NODE sg13_hv_nmos
+ L=0.6u W=4.4u AS=0p AD=0p PS=0u PD=0u rfmode=0
* device instance PAD01_VDD.I1.N0<19> r0 *1 0,0 sg13_hv_nmos
MPAD01_VDD.I1.N0<19> IOVSS PAD01_VDD.NET3 VDD SUBSTRATE_NODE sg13_hv_nmos
+ L=0.6u W=4.4u AS=0p AD=0p PS=0u PD=0u rfmode=0
* device instance PAD01_VDD.I1.N0<20> r0 *1 0,0 sg13_hv_nmos
MPAD01_VDD.I1.N0<20> IOVSS PAD01_VDD.NET3 VDD SUBSTRATE_NODE sg13_hv_nmos
+ L=0.6u W=4.4u AS=0p AD=0p PS=0u PD=0u rfmode=0
* device instance PAD01_VDD.I1.N0<21> r0 *1 0,0 sg13_hv_nmos
MPAD01_VDD.I1.N0<21> IOVSS PAD01_VDD.NET3 VDD SUBSTRATE_NODE sg13_hv_nmos
+ L=0.6u W=4.4u AS=0p AD=0p PS=0u PD=0u rfmode=0
* device instance PAD01_VDD.I1.N0<22> r0 *1 0,0 sg13_hv_nmos
MPAD01_VDD.I1.N0<22> IOVSS PAD01_VDD.NET3 VDD SUBSTRATE_NODE sg13_hv_nmos
+ L=0.6u W=4.4u AS=0p AD=0p PS=0u PD=0u rfmode=0
* device instance PAD01_VDD.I1.N0<23> r0 *1 0,0 sg13_hv_nmos
MPAD01_VDD.I1.N0<23> IOVSS PAD01_VDD.NET3 VDD SUBSTRATE_NODE sg13_hv_nmos
+ L=0.6u W=4.4u AS=0p AD=0p PS=0u PD=0u rfmode=0
* device instance PAD01_VDD.I1.N0<24> r0 *1 0,0 sg13_hv_nmos
MPAD01_VDD.I1.N0<24> IOVSS PAD01_VDD.NET3 VDD SUBSTRATE_NODE sg13_hv_nmos
+ L=0.6u W=4.4u AS=0p AD=0p PS=0u PD=0u rfmode=0
* device instance PAD01_VDD.I1.N0<25> r0 *1 0,0 sg13_hv_nmos
MPAD01_VDD.I1.N0<25> IOVSS PAD01_VDD.NET3 VDD SUBSTRATE_NODE sg13_hv_nmos
+ L=0.6u W=4.4u AS=0p AD=0p PS=0u PD=0u rfmode=0
* device instance PAD01_VDD.I1.N0<26> r0 *1 0,0 sg13_hv_nmos
MPAD01_VDD.I1.N0<26> IOVSS PAD01_VDD.NET3 VDD SUBSTRATE_NODE sg13_hv_nmos
+ L=0.6u W=4.4u AS=0p AD=0p PS=0u PD=0u rfmode=0
* device instance PAD01_VDD.I1.N0<27> r0 *1 0,0 sg13_hv_nmos
MPAD01_VDD.I1.N0<27> IOVSS PAD01_VDD.NET3 VDD SUBSTRATE_NODE sg13_hv_nmos
+ L=0.6u W=4.4u AS=0p AD=0p PS=0u PD=0u rfmode=0
* device instance PAD01_VDD.I1.N0<28> r0 *1 0,0 sg13_hv_nmos
MPAD01_VDD.I1.N0<28> IOVSS PAD01_VDD.NET3 VDD SUBSTRATE_NODE sg13_hv_nmos
+ L=0.6u W=4.4u AS=0p AD=0p PS=0u PD=0u rfmode=0
* device instance PAD01_VDD.I1.N0<29> r0 *1 0,0 sg13_hv_nmos
MPAD01_VDD.I1.N0<29> IOVSS PAD01_VDD.NET3 VDD SUBSTRATE_NODE sg13_hv_nmos
+ L=0.6u W=4.4u AS=0p AD=0p PS=0u PD=0u rfmode=0
* device instance PAD01_VDD.I1.N0<30> r0 *1 0,0 sg13_hv_nmos
MPAD01_VDD.I1.N0<30> IOVSS PAD01_VDD.NET3 VDD SUBSTRATE_NODE sg13_hv_nmos
+ L=0.6u W=4.4u AS=0p AD=0p PS=0u PD=0u rfmode=0
* device instance PAD01_VDD.I1.N0<31> r0 *1 0,0 sg13_hv_nmos
MPAD01_VDD.I1.N0<31> IOVSS PAD01_VDD.NET3 VDD SUBSTRATE_NODE sg13_hv_nmos
+ L=0.6u W=4.4u AS=0p AD=0p PS=0u PD=0u rfmode=0
* device instance PAD01_VDD.I1.N0<32> r0 *1 0,0 sg13_hv_nmos
MPAD01_VDD.I1.N0<32> IOVSS PAD01_VDD.NET3 VDD SUBSTRATE_NODE sg13_hv_nmos
+ L=0.6u W=4.4u AS=0p AD=0p PS=0u PD=0u rfmode=0
* device instance PAD01_VDD.I1.N0<33> r0 *1 0,0 sg13_hv_nmos
MPAD01_VDD.I1.N0<33> IOVSS PAD01_VDD.NET3 VDD SUBSTRATE_NODE sg13_hv_nmos
+ L=0.6u W=4.4u AS=0p AD=0p PS=0u PD=0u rfmode=0
* device instance PAD01_VDD.I1.N0<34> r0 *1 0,0 sg13_hv_nmos
MPAD01_VDD.I1.N0<34> IOVSS PAD01_VDD.NET3 VDD SUBSTRATE_NODE sg13_hv_nmos
+ L=0.6u W=4.4u AS=0p AD=0p PS=0u PD=0u rfmode=0
* device instance PAD01_VDD.I1.N0<35> r0 *1 0,0 sg13_hv_nmos
MPAD01_VDD.I1.N0<35> IOVSS PAD01_VDD.NET3 VDD SUBSTRATE_NODE sg13_hv_nmos
+ L=0.6u W=4.4u AS=0p AD=0p PS=0u PD=0u rfmode=0
* device instance PAD01_VDD.I1.N0<36> r0 *1 0,0 sg13_hv_nmos
MPAD01_VDD.I1.N0<36> IOVSS PAD01_VDD.NET3 VDD SUBSTRATE_NODE sg13_hv_nmos
+ L=0.6u W=4.4u AS=0p AD=0p PS=0u PD=0u rfmode=0
* device instance PAD01_VDD.I1.N0<37> r0 *1 0,0 sg13_hv_nmos
MPAD01_VDD.I1.N0<37> IOVSS PAD01_VDD.NET3 VDD SUBSTRATE_NODE sg13_hv_nmos
+ L=0.6u W=4.4u AS=0p AD=0p PS=0u PD=0u rfmode=0
* device instance PAD01_VDD.I1.N0<38> r0 *1 0,0 sg13_hv_nmos
MPAD01_VDD.I1.N0<38> IOVSS PAD01_VDD.NET3 VDD SUBSTRATE_NODE sg13_hv_nmos
+ L=0.6u W=4.4u AS=0p AD=0p PS=0u PD=0u rfmode=0
* device instance PAD01_VDD.I1.N0<39> r0 *1 0,0 sg13_hv_nmos
MPAD01_VDD.I1.N0<39> IOVSS PAD01_VDD.NET3 VDD SUBSTRATE_NODE sg13_hv_nmos
+ L=0.6u W=4.4u AS=0p AD=0p PS=0u PD=0u rfmode=0
* device instance PAD01_VDD.I1.N0<40> r0 *1 0,0 sg13_hv_nmos
MPAD01_VDD.I1.N0<40> IOVSS PAD01_VDD.NET3 VDD SUBSTRATE_NODE sg13_hv_nmos
+ L=0.6u W=4.4u AS=0p AD=0p PS=0u PD=0u rfmode=0
* device instance PAD01_VDD.I1.N0<41> r0 *1 0,0 sg13_hv_nmos
MPAD01_VDD.I1.N0<41> IOVSS PAD01_VDD.NET3 VDD SUBSTRATE_NODE sg13_hv_nmos
+ L=0.6u W=4.4u AS=0p AD=0p PS=0u PD=0u rfmode=0
* device instance PAD01_VDD.I1.N0<42> r0 *1 0,0 sg13_hv_nmos
MPAD01_VDD.I1.N0<42> IOVSS PAD01_VDD.NET3 VDD SUBSTRATE_NODE sg13_hv_nmos
+ L=0.6u W=4.4u AS=0p AD=0p PS=0u PD=0u rfmode=0
* device instance PAD01_VDD.I1.N0<43> r0 *1 0,0 sg13_hv_nmos
MPAD01_VDD.I1.N0<43> IOVSS PAD01_VDD.NET3 VDD SUBSTRATE_NODE sg13_hv_nmos
+ L=0.6u W=4.4u AS=0p AD=0p PS=0u PD=0u rfmode=0
* device instance PAD01_VDD.I1.N0<44> r0 *1 0,0 sg13_hv_nmos
MPAD01_VDD.I1.N0<44> IOVSS PAD01_VDD.NET3 VDD SUBSTRATE_NODE sg13_hv_nmos
+ L=0.6u W=4.4u AS=0p AD=0p PS=0u PD=0u rfmode=0
* device instance PAD01_VDD.I1.N0<45> r0 *1 0,0 sg13_hv_nmos
MPAD01_VDD.I1.N0<45> IOVSS PAD01_VDD.NET3 VDD SUBSTRATE_NODE sg13_hv_nmos
+ L=0.6u W=4.4u AS=0p AD=0p PS=0u PD=0u rfmode=0
* device instance PAD01_VDD.I1.N0<46> r0 *1 0,0 sg13_hv_nmos
MPAD01_VDD.I1.N0<46> IOVSS PAD01_VDD.NET3 VDD SUBSTRATE_NODE sg13_hv_nmos
+ L=0.6u W=4.4u AS=0p AD=0p PS=0u PD=0u rfmode=0
* device instance PAD01_VDD.I1.N0<47> r0 *1 0,0 sg13_hv_nmos
MPAD01_VDD.I1.N0<47> IOVSS PAD01_VDD.NET3 VDD SUBSTRATE_NODE sg13_hv_nmos
+ L=0.6u W=4.4u AS=0p AD=0p PS=0u PD=0u rfmode=0
* device instance PAD01_VDD.I1.N0<48> r0 *1 0,0 sg13_hv_nmos
MPAD01_VDD.I1.N0<48> IOVSS PAD01_VDD.NET3 VDD SUBSTRATE_NODE sg13_hv_nmos
+ L=0.6u W=4.4u AS=0p AD=0p PS=0u PD=0u rfmode=0
* device instance PAD01_VDD.I1.N0<49> r0 *1 0,0 sg13_hv_nmos
MPAD01_VDD.I1.N0<49> IOVSS PAD01_VDD.NET3 VDD SUBSTRATE_NODE sg13_hv_nmos
+ L=0.6u W=4.4u AS=0p AD=0p PS=0u PD=0u rfmode=0
* device instance PAD01_VDD.I1.N0<50> r0 *1 0,0 sg13_hv_nmos
MPAD01_VDD.I1.N0<50> IOVSS PAD01_VDD.NET3 VDD SUBSTRATE_NODE sg13_hv_nmos
+ L=0.6u W=4.4u AS=0p AD=0p PS=0u PD=0u rfmode=0
* device instance PAD01_VDD.I1.N0<51> r0 *1 0,0 sg13_hv_nmos
MPAD01_VDD.I1.N0<51> IOVSS PAD01_VDD.NET3 VDD SUBSTRATE_NODE sg13_hv_nmos
+ L=0.6u W=4.4u AS=0p AD=0p PS=0u PD=0u rfmode=0
* device instance PAD01_VDD.I1.N0<52> r0 *1 0,0 sg13_hv_nmos
MPAD01_VDD.I1.N0<52> IOVSS PAD01_VDD.NET3 VDD SUBSTRATE_NODE sg13_hv_nmos
+ L=0.6u W=4.4u AS=0p AD=0p PS=0u PD=0u rfmode=0
* device instance PAD01_VDD.I1.N0<53> r0 *1 0,0 sg13_hv_nmos
MPAD01_VDD.I1.N0<53> IOVSS PAD01_VDD.NET3 VDD SUBSTRATE_NODE sg13_hv_nmos
+ L=0.6u W=4.4u AS=0p AD=0p PS=0u PD=0u rfmode=0
* device instance PAD01_VDD.I1.N0<54> r0 *1 0,0 sg13_hv_nmos
MPAD01_VDD.I1.N0<54> IOVSS PAD01_VDD.NET3 VDD SUBSTRATE_NODE sg13_hv_nmos
+ L=0.6u W=4.4u AS=0p AD=0p PS=0u PD=0u rfmode=0
* device instance PAD01_VDD.I1.N0<55> r0 *1 0,0 sg13_hv_nmos
MPAD01_VDD.I1.N0<55> IOVSS PAD01_VDD.NET3 VDD SUBSTRATE_NODE sg13_hv_nmos
+ L=0.6u W=4.4u AS=0p AD=0p PS=0u PD=0u rfmode=0
* device instance PAD01_VDD.I1.N0<56> r0 *1 0,0 sg13_hv_nmos
MPAD01_VDD.I1.N0<56> IOVSS PAD01_VDD.NET3 VDD SUBSTRATE_NODE sg13_hv_nmos
+ L=0.6u W=4.4u AS=0p AD=0p PS=0u PD=0u rfmode=0
* device instance PAD01_VDD.I1.N0<57> r0 *1 0,0 sg13_hv_nmos
MPAD01_VDD.I1.N0<57> IOVSS PAD01_VDD.NET3 VDD SUBSTRATE_NODE sg13_hv_nmos
+ L=0.6u W=4.4u AS=0p AD=0p PS=0u PD=0u rfmode=0
* device instance PAD01_VDD.I1.N0<58> r0 *1 0,0 sg13_hv_nmos
MPAD01_VDD.I1.N0<58> IOVSS PAD01_VDD.NET3 VDD SUBSTRATE_NODE sg13_hv_nmos
+ L=0.6u W=4.4u AS=0p AD=0p PS=0u PD=0u rfmode=0
* device instance PAD01_VDD.I1.N0<59> r0 *1 0,0 sg13_hv_nmos
MPAD01_VDD.I1.N0<59> IOVSS PAD01_VDD.NET3 VDD SUBSTRATE_NODE sg13_hv_nmos
+ L=0.6u W=4.4u AS=0p AD=0p PS=0u PD=0u rfmode=0
* device instance PAD01_VDD.I1.N0<60> r0 *1 0,0 sg13_hv_nmos
MPAD01_VDD.I1.N0<60> IOVSS PAD01_VDD.NET3 VDD SUBSTRATE_NODE sg13_hv_nmos
+ L=0.6u W=4.4u AS=0p AD=0p PS=0u PD=0u rfmode=0
* device instance PAD01_VDD.I1.N0<61> r0 *1 0,0 sg13_hv_nmos
MPAD01_VDD.I1.N0<61> IOVSS PAD01_VDD.NET3 VDD SUBSTRATE_NODE sg13_hv_nmos
+ L=0.6u W=4.4u AS=0p AD=0p PS=0u PD=0u rfmode=0
* device instance PAD01_VDD.I1.N0<62> r0 *1 0,0 sg13_hv_nmos
MPAD01_VDD.I1.N0<62> IOVSS PAD01_VDD.NET3 VDD SUBSTRATE_NODE sg13_hv_nmos
+ L=0.6u W=4.4u AS=0p AD=0p PS=0u PD=0u rfmode=0
* device instance PAD01_VDD.I1.N0<63> r0 *1 0,0 sg13_hv_nmos
MPAD01_VDD.I1.N0<63> IOVSS PAD01_VDD.NET3 VDD SUBSTRATE_NODE sg13_hv_nmos
+ L=0.6u W=4.4u AS=0p AD=0p PS=0u PD=0u rfmode=0
* device instance PAD01_VDD.I1.N0<64> r0 *1 0,0 sg13_hv_nmos
MPAD01_VDD.I1.N0<64> IOVSS PAD01_VDD.NET3 VDD SUBSTRATE_NODE sg13_hv_nmos
+ L=0.6u W=4.4u AS=0p AD=0p PS=0u PD=0u rfmode=0
* device instance PAD01_VDD.I1.N0<65> r0 *1 0,0 sg13_hv_nmos
MPAD01_VDD.I1.N0<65> IOVSS PAD01_VDD.NET3 VDD SUBSTRATE_NODE sg13_hv_nmos
+ L=0.6u W=4.4u AS=0p AD=0p PS=0u PD=0u rfmode=0
* device instance PAD01_VDD.I1.N0<66> r0 *1 0,0 sg13_hv_nmos
MPAD01_VDD.I1.N0<66> IOVSS PAD01_VDD.NET3 VDD SUBSTRATE_NODE sg13_hv_nmos
+ L=0.6u W=4.4u AS=0p AD=0p PS=0u PD=0u rfmode=0
* device instance PAD01_VDD.I1.N0<67> r0 *1 0,0 sg13_hv_nmos
MPAD01_VDD.I1.N0<67> IOVSS PAD01_VDD.NET3 VDD SUBSTRATE_NODE sg13_hv_nmos
+ L=0.6u W=4.4u AS=0p AD=0p PS=0u PD=0u rfmode=0
* device instance PAD01_VDD.I1.N0<68> r0 *1 0,0 sg13_hv_nmos
MPAD01_VDD.I1.N0<68> IOVSS PAD01_VDD.NET3 VDD SUBSTRATE_NODE sg13_hv_nmos
+ L=0.6u W=4.4u AS=0p AD=0p PS=0u PD=0u rfmode=0
* device instance PAD01_VDD.I1.N0<69> r0 *1 0,0 sg13_hv_nmos
MPAD01_VDD.I1.N0<69> IOVSS PAD01_VDD.NET3 VDD SUBSTRATE_NODE sg13_hv_nmos
+ L=0.6u W=4.4u AS=0p AD=0p PS=0u PD=0u rfmode=0
* device instance PAD01_VDD.I1.N0<70> r0 *1 0,0 sg13_hv_nmos
MPAD01_VDD.I1.N0<70> IOVSS PAD01_VDD.NET3 VDD SUBSTRATE_NODE sg13_hv_nmos
+ L=0.6u W=4.4u AS=0p AD=0p PS=0u PD=0u rfmode=0
* device instance PAD01_VDD.I1.N0<71> r0 *1 0,0 sg13_hv_nmos
MPAD01_VDD.I1.N0<71> IOVSS PAD01_VDD.NET3 VDD SUBSTRATE_NODE sg13_hv_nmos
+ L=0.6u W=4.4u AS=0p AD=0p PS=0u PD=0u rfmode=0
* device instance PAD01_VDD.I1.N0<72> r0 *1 0,0 sg13_hv_nmos
MPAD01_VDD.I1.N0<72> IOVSS PAD01_VDD.NET3 VDD SUBSTRATE_NODE sg13_hv_nmos
+ L=0.6u W=4.4u AS=0p AD=0p PS=0u PD=0u rfmode=0
* device instance PAD01_VDD.I1.N0<73> r0 *1 0,0 sg13_hv_nmos
MPAD01_VDD.I1.N0<73> IOVSS PAD01_VDD.NET3 VDD SUBSTRATE_NODE sg13_hv_nmos
+ L=0.6u W=4.4u AS=0p AD=0p PS=0u PD=0u rfmode=0
* device instance PAD01_VDD.I1.N0<74> r0 *1 0,0 sg13_hv_nmos
MPAD01_VDD.I1.N0<74> IOVSS PAD01_VDD.NET3 VDD SUBSTRATE_NODE sg13_hv_nmos
+ L=0.6u W=4.4u AS=0p AD=0p PS=0u PD=0u rfmode=0
* device instance PAD01_VDD.I1.N0<75> r0 *1 0,0 sg13_hv_nmos
MPAD01_VDD.I1.N0<75> IOVSS PAD01_VDD.NET3 VDD SUBSTRATE_NODE sg13_hv_nmos
+ L=0.6u W=4.4u AS=0p AD=0p PS=0u PD=0u rfmode=0
* device instance PAD01_VDD.I1.N0<76> r0 *1 0,0 sg13_hv_nmos
MPAD01_VDD.I1.N0<76> IOVSS PAD01_VDD.NET3 VDD SUBSTRATE_NODE sg13_hv_nmos
+ L=0.6u W=4.4u AS=0p AD=0p PS=0u PD=0u rfmode=0
* device instance PAD01_VDD.I1.N0<77> r0 *1 0,0 sg13_hv_nmos
MPAD01_VDD.I1.N0<77> IOVSS PAD01_VDD.NET3 VDD SUBSTRATE_NODE sg13_hv_nmos
+ L=0.6u W=4.4u AS=0p AD=0p PS=0u PD=0u rfmode=0
* device instance PAD01_VDD.I1.N0<78> r0 *1 0,0 sg13_hv_nmos
MPAD01_VDD.I1.N0<78> IOVSS PAD01_VDD.NET3 VDD SUBSTRATE_NODE sg13_hv_nmos
+ L=0.6u W=4.4u AS=0p AD=0p PS=0u PD=0u rfmode=0
* device instance PAD01_VDD.I1.N0<79> r0 *1 0,0 sg13_hv_nmos
MPAD01_VDD.I1.N0<79> IOVSS PAD01_VDD.NET3 VDD SUBSTRATE_NODE sg13_hv_nmos
+ L=0.6u W=4.4u AS=0p AD=0p PS=0u PD=0u rfmode=0
* device instance PAD01_VDD.I1.N0<80> r0 *1 0,0 sg13_hv_nmos
MPAD01_VDD.I1.N0<80> IOVSS PAD01_VDD.NET3 VDD SUBSTRATE_NODE sg13_hv_nmos
+ L=0.6u W=4.4u AS=0p AD=0p PS=0u PD=0u rfmode=0
* device instance PAD01_VDD.I1.N0<81> r0 *1 0,0 sg13_hv_nmos
MPAD01_VDD.I1.N0<81> IOVSS PAD01_VDD.NET3 VDD SUBSTRATE_NODE sg13_hv_nmos
+ L=0.6u W=4.4u AS=0p AD=0p PS=0u PD=0u rfmode=0
* device instance PAD01_VDD.I1.N0<82> r0 *1 0,0 sg13_hv_nmos
MPAD01_VDD.I1.N0<82> IOVSS PAD01_VDD.NET3 VDD SUBSTRATE_NODE sg13_hv_nmos
+ L=0.6u W=4.4u AS=0p AD=0p PS=0u PD=0u rfmode=0
* device instance PAD01_VDD.I1.N0<83> r0 *1 0,0 sg13_hv_nmos
MPAD01_VDD.I1.N0<83> IOVSS PAD01_VDD.NET3 VDD SUBSTRATE_NODE sg13_hv_nmos
+ L=0.6u W=4.4u AS=0p AD=0p PS=0u PD=0u rfmode=0
* device instance PAD01_VDD.I1.N0<84> r0 *1 0,0 sg13_hv_nmos
MPAD01_VDD.I1.N0<84> IOVSS PAD01_VDD.NET3 VDD SUBSTRATE_NODE sg13_hv_nmos
+ L=0.6u W=4.4u AS=0p AD=0p PS=0u PD=0u rfmode=0
* device instance PAD01_VDD.I1.N0<85> r0 *1 0,0 sg13_hv_nmos
MPAD01_VDD.I1.N0<85> IOVSS PAD01_VDD.NET3 VDD SUBSTRATE_NODE sg13_hv_nmos
+ L=0.6u W=4.4u AS=0p AD=0p PS=0u PD=0u rfmode=0
* device instance PAD01_VDD.I1.N0<86> r0 *1 0,0 sg13_hv_nmos
MPAD01_VDD.I1.N0<86> IOVSS PAD01_VDD.NET3 VDD SUBSTRATE_NODE sg13_hv_nmos
+ L=0.6u W=4.4u AS=0p AD=0p PS=0u PD=0u rfmode=0
* device instance PAD01_VDD.I1.N0<87> r0 *1 0,0 sg13_hv_nmos
MPAD01_VDD.I1.N0<87> IOVSS PAD01_VDD.NET3 VDD SUBSTRATE_NODE sg13_hv_nmos
+ L=0.6u W=4.4u AS=0p AD=0p PS=0u PD=0u rfmode=0
* device instance PAD01_VDD.I1.N0<88> r0 *1 0,0 sg13_hv_nmos
MPAD01_VDD.I1.N0<88> IOVSS PAD01_VDD.NET3 VDD SUBSTRATE_NODE sg13_hv_nmos
+ L=0.6u W=4.4u AS=0p AD=0p PS=0u PD=0u rfmode=0
* device instance PAD01_VDD.I1.N0<89> r0 *1 0,0 sg13_hv_nmos
MPAD01_VDD.I1.N0<89> IOVSS PAD01_VDD.NET3 VDD SUBSTRATE_NODE sg13_hv_nmos
+ L=0.6u W=4.4u AS=0p AD=0p PS=0u PD=0u rfmode=0
* device instance PAD01_VDD.I1.N0<90> r0 *1 0,0 sg13_hv_nmos
MPAD01_VDD.I1.N0<90> IOVSS PAD01_VDD.NET3 VDD SUBSTRATE_NODE sg13_hv_nmos
+ L=0.6u W=4.4u AS=0p AD=0p PS=0u PD=0u rfmode=0
* device instance PAD01_VDD.I1.N0<91> r0 *1 0,0 sg13_hv_nmos
MPAD01_VDD.I1.N0<91> IOVSS PAD01_VDD.NET3 VDD SUBSTRATE_NODE sg13_hv_nmos
+ L=0.6u W=4.4u AS=0p AD=0p PS=0u PD=0u rfmode=0
* device instance PAD01_VDD.I1.N0<92> r0 *1 0,0 sg13_hv_nmos
MPAD01_VDD.I1.N0<92> IOVSS PAD01_VDD.NET3 VDD SUBSTRATE_NODE sg13_hv_nmos
+ L=0.6u W=4.4u AS=0p AD=0p PS=0u PD=0u rfmode=0
* device instance PAD01_VDD.I1.N0<93> r0 *1 0,0 sg13_hv_nmos
MPAD01_VDD.I1.N0<93> IOVSS PAD01_VDD.NET3 VDD SUBSTRATE_NODE sg13_hv_nmos
+ L=0.6u W=4.4u AS=0p AD=0p PS=0u PD=0u rfmode=0
* device instance PAD01_VDD.I1.N0<94> r0 *1 0,0 sg13_hv_nmos
MPAD01_VDD.I1.N0<94> IOVSS PAD01_VDD.NET3 VDD SUBSTRATE_NODE sg13_hv_nmos
+ L=0.6u W=4.4u AS=0p AD=0p PS=0u PD=0u rfmode=0
* device instance PAD01_VDD.I1.N0<95> r0 *1 0,0 sg13_hv_nmos
MPAD01_VDD.I1.N0<95> IOVSS PAD01_VDD.NET3 VDD SUBSTRATE_NODE sg13_hv_nmos
+ L=0.6u W=4.4u AS=0p AD=0p PS=0u PD=0u rfmode=0
* device instance PAD01_VDD.I1.N0<96> r0 *1 0,0 sg13_hv_nmos
MPAD01_VDD.I1.N0<96> IOVSS PAD01_VDD.NET3 VDD SUBSTRATE_NODE sg13_hv_nmos
+ L=0.6u W=4.4u AS=0p AD=0p PS=0u PD=0u rfmode=0
* device instance PAD01_VDD.I1.N0<97> r0 *1 0,0 sg13_hv_nmos
MPAD01_VDD.I1.N0<97> IOVSS PAD01_VDD.NET3 VDD SUBSTRATE_NODE sg13_hv_nmos
+ L=0.6u W=4.4u AS=0p AD=0p PS=0u PD=0u rfmode=0
* device instance PAD01_VDD.I1.N0<98> r0 *1 0,0 sg13_hv_nmos
MPAD01_VDD.I1.N0<98> IOVSS PAD01_VDD.NET3 VDD SUBSTRATE_NODE sg13_hv_nmos
+ L=0.6u W=4.4u AS=0p AD=0p PS=0u PD=0u rfmode=0
* device instance PAD01_VDD.I1.N0<99> r0 *1 0,0 sg13_hv_nmos
MPAD01_VDD.I1.N0<99> IOVSS PAD01_VDD.NET3 VDD SUBSTRATE_NODE sg13_hv_nmos
+ L=0.6u W=4.4u AS=0p AD=0p PS=0u PD=0u rfmode=0
* device instance PAD01_VDD.I1.N0<100> r0 *1 0,0 sg13_hv_nmos
MPAD01_VDD.I1.N0<100> IOVSS PAD01_VDD.NET3 VDD SUBSTRATE_NODE sg13_hv_nmos
+ L=0.6u W=4.4u AS=0p AD=0p PS=0u PD=0u rfmode=0
* device instance PAD01_VDD.I1.N0<101> r0 *1 0,0 sg13_hv_nmos
MPAD01_VDD.I1.N0<101> IOVSS PAD01_VDD.NET3 VDD SUBSTRATE_NODE sg13_hv_nmos
+ L=0.6u W=4.4u AS=0p AD=0p PS=0u PD=0u rfmode=0
* device instance PAD01_VDD.I1.N0<102> r0 *1 0,0 sg13_hv_nmos
MPAD01_VDD.I1.N0<102> IOVSS PAD01_VDD.NET3 VDD SUBSTRATE_NODE sg13_hv_nmos
+ L=0.6u W=4.4u AS=0p AD=0p PS=0u PD=0u rfmode=0
* device instance PAD01_VDD.I1.N0<103> r0 *1 0,0 sg13_hv_nmos
MPAD01_VDD.I1.N0<103> IOVSS PAD01_VDD.NET3 VDD SUBSTRATE_NODE sg13_hv_nmos
+ L=0.6u W=4.4u AS=0p AD=0p PS=0u PD=0u rfmode=0
* device instance PAD01_VDD.I1.N0<104> r0 *1 0,0 sg13_hv_nmos
MPAD01_VDD.I1.N0<104> IOVSS PAD01_VDD.NET3 VDD SUBSTRATE_NODE sg13_hv_nmos
+ L=0.6u W=4.4u AS=0p AD=0p PS=0u PD=0u rfmode=0
* device instance PAD01_VDD.I1.N0<105> r0 *1 0,0 sg13_hv_nmos
MPAD01_VDD.I1.N0<105> IOVSS PAD01_VDD.NET3 VDD SUBSTRATE_NODE sg13_hv_nmos
+ L=0.6u W=4.4u AS=0p AD=0p PS=0u PD=0u rfmode=0
* device instance PAD01_VDD.I1.N0<106> r0 *1 0,0 sg13_hv_nmos
MPAD01_VDD.I1.N0<106> IOVSS PAD01_VDD.NET3 VDD SUBSTRATE_NODE sg13_hv_nmos
+ L=0.6u W=4.4u AS=0p AD=0p PS=0u PD=0u rfmode=0
* device instance PAD01_VDD.I1.N0<107> r0 *1 0,0 sg13_hv_nmos
MPAD01_VDD.I1.N0<107> IOVSS PAD01_VDD.NET3 VDD SUBSTRATE_NODE sg13_hv_nmos
+ L=0.6u W=4.4u AS=0p AD=0p PS=0u PD=0u rfmode=0
* device instance PAD01_VDD.I1.N0<108> r0 *1 0,0 sg13_hv_nmos
MPAD01_VDD.I1.N0<108> IOVSS PAD01_VDD.NET3 VDD SUBSTRATE_NODE sg13_hv_nmos
+ L=0.6u W=4.4u AS=0p AD=0p PS=0u PD=0u rfmode=0
* device instance PAD01_VDD.I1.N0<109> r0 *1 0,0 sg13_hv_nmos
MPAD01_VDD.I1.N0<109> IOVSS PAD01_VDD.NET3 VDD SUBSTRATE_NODE sg13_hv_nmos
+ L=0.6u W=4.4u AS=0p AD=0p PS=0u PD=0u rfmode=0
* device instance PAD01_VDD.I1.N0<110> r0 *1 0,0 sg13_hv_nmos
MPAD01_VDD.I1.N0<110> IOVSS PAD01_VDD.NET3 VDD SUBSTRATE_NODE sg13_hv_nmos
+ L=0.6u W=4.4u AS=0p AD=0p PS=0u PD=0u rfmode=0
* device instance PAD01_VDD.I1.N0<111> r0 *1 0,0 sg13_hv_nmos
MPAD01_VDD.I1.N0<111> IOVSS PAD01_VDD.NET3 VDD SUBSTRATE_NODE sg13_hv_nmos
+ L=0.6u W=4.4u AS=0p AD=0p PS=0u PD=0u rfmode=0
* device instance PAD01_VDD.I1.N0<112> r0 *1 0,0 sg13_hv_nmos
MPAD01_VDD.I1.N0<112> IOVSS PAD01_VDD.NET3 VDD SUBSTRATE_NODE sg13_hv_nmos
+ L=0.6u W=4.4u AS=0p AD=0p PS=0u PD=0u rfmode=0
* device instance PAD01_VDD.I1.N0<113> r0 *1 0,0 sg13_hv_nmos
MPAD01_VDD.I1.N0<113> IOVSS PAD01_VDD.NET3 VDD SUBSTRATE_NODE sg13_hv_nmos
+ L=0.6u W=4.4u AS=0p AD=0p PS=0u PD=0u rfmode=0
* device instance PAD01_VDD.I1.N0<114> r0 *1 0,0 sg13_hv_nmos
MPAD01_VDD.I1.N0<114> IOVSS PAD01_VDD.NET3 VDD SUBSTRATE_NODE sg13_hv_nmos
+ L=0.6u W=4.4u AS=0p AD=0p PS=0u PD=0u rfmode=0
* device instance PAD01_VDD.I1.N0<115> r0 *1 0,0 sg13_hv_nmos
MPAD01_VDD.I1.N0<115> IOVSS PAD01_VDD.NET3 VDD SUBSTRATE_NODE sg13_hv_nmos
+ L=0.6u W=4.4u AS=0p AD=0p PS=0u PD=0u rfmode=0
* device instance PAD01_VDD.I1.N0<116> r0 *1 0,0 sg13_hv_nmos
MPAD01_VDD.I1.N0<116> IOVSS PAD01_VDD.NET3 VDD SUBSTRATE_NODE sg13_hv_nmos
+ L=0.6u W=4.4u AS=0p AD=0p PS=0u PD=0u rfmode=0
* device instance PAD01_VDD.I1.N0<117> r0 *1 0,0 sg13_hv_nmos
MPAD01_VDD.I1.N0<117> IOVSS PAD01_VDD.NET3 VDD SUBSTRATE_NODE sg13_hv_nmos
+ L=0.6u W=4.4u AS=0p AD=0p PS=0u PD=0u rfmode=0
* device instance PAD01_VDD.I1.N0<118> r0 *1 0,0 sg13_hv_nmos
MPAD01_VDD.I1.N0<118> IOVSS PAD01_VDD.NET3 VDD SUBSTRATE_NODE sg13_hv_nmos
+ L=0.6u W=4.4u AS=0p AD=0p PS=0u PD=0u rfmode=0
* device instance PAD01_VDD.I1.N0<119> r0 *1 0,0 sg13_hv_nmos
MPAD01_VDD.I1.N0<119> IOVSS PAD01_VDD.NET3 VDD SUBSTRATE_NODE sg13_hv_nmos
+ L=0.6u W=4.4u AS=0p AD=0p PS=0u PD=0u rfmode=0
* device instance PAD01_VDD.I1.N0<120> r0 *1 0,0 sg13_hv_nmos
MPAD01_VDD.I1.N0<120> IOVSS PAD01_VDD.NET3 VDD SUBSTRATE_NODE sg13_hv_nmos
+ L=0.6u W=4.4u AS=0p AD=0p PS=0u PD=0u rfmode=0
* device instance PAD01_VDD.I1.N0<121> r0 *1 0,0 sg13_hv_nmos
MPAD01_VDD.I1.N0<121> IOVSS PAD01_VDD.NET3 VDD SUBSTRATE_NODE sg13_hv_nmos
+ L=0.6u W=4.4u AS=0p AD=0p PS=0u PD=0u rfmode=0
* device instance PAD01_VDD.I1.N0<122> r0 *1 0,0 sg13_hv_nmos
MPAD01_VDD.I1.N0<122> IOVSS PAD01_VDD.NET3 VDD SUBSTRATE_NODE sg13_hv_nmos
+ L=0.6u W=4.4u AS=0p AD=0p PS=0u PD=0u rfmode=0
* device instance PAD01_VDD.I1.N0<123> r0 *1 0,0 sg13_hv_nmos
MPAD01_VDD.I1.N0<123> IOVSS PAD01_VDD.NET3 VDD SUBSTRATE_NODE sg13_hv_nmos
+ L=0.6u W=4.4u AS=0p AD=0p PS=0u PD=0u rfmode=0
* device instance PAD01_VDD.I1.N0<124> r0 *1 0,0 sg13_hv_nmos
MPAD01_VDD.I1.N0<124> IOVSS PAD01_VDD.NET3 VDD SUBSTRATE_NODE sg13_hv_nmos
+ L=0.6u W=4.4u AS=0p AD=0p PS=0u PD=0u rfmode=0
* device instance PAD01_VDD.I1.N0<125> r0 *1 0,0 sg13_hv_nmos
MPAD01_VDD.I1.N0<125> IOVSS PAD01_VDD.NET3 VDD SUBSTRATE_NODE sg13_hv_nmos
+ L=0.6u W=4.4u AS=0p AD=0p PS=0u PD=0u rfmode=0
* device instance PAD01_VDD.I1.N0<126> r0 *1 0,0 sg13_hv_nmos
MPAD01_VDD.I1.N0<126> IOVSS PAD01_VDD.NET3 VDD SUBSTRATE_NODE sg13_hv_nmos
+ L=0.6u W=4.4u AS=0p AD=0p PS=0u PD=0u rfmode=0
* device instance PAD01_VDD.I1.N0<127> r0 *1 0,0 sg13_hv_nmos
MPAD01_VDD.I1.N0<127> IOVSS PAD01_VDD.NET3 VDD SUBSTRATE_NODE sg13_hv_nmos
+ L=0.6u W=4.4u AS=0p AD=0p PS=0u PD=0u rfmode=0
* device instance PAD01_VDD.I1.N0<128> r0 *1 0,0 sg13_hv_nmos
MPAD01_VDD.I1.N0<128> IOVSS PAD01_VDD.NET3 VDD SUBSTRATE_NODE sg13_hv_nmos
+ L=0.6u W=4.4u AS=0p AD=0p PS=0u PD=0u rfmode=0
* device instance PAD01_VDD.I1.N0<129> r0 *1 0,0 sg13_hv_nmos
MPAD01_VDD.I1.N0<129> IOVSS PAD01_VDD.NET3 VDD SUBSTRATE_NODE sg13_hv_nmos
+ L=0.6u W=4.4u AS=0p AD=0p PS=0u PD=0u rfmode=0
* device instance PAD01_VDD.I1.N0<130> r0 *1 0,0 sg13_hv_nmos
MPAD01_VDD.I1.N0<130> IOVSS PAD01_VDD.NET3 VDD SUBSTRATE_NODE sg13_hv_nmos
+ L=0.6u W=4.4u AS=0p AD=0p PS=0u PD=0u rfmode=0
* device instance PAD01_VDD.I1.N0<131> r0 *1 0,0 sg13_hv_nmos
MPAD01_VDD.I1.N0<131> IOVSS PAD01_VDD.NET3 VDD SUBSTRATE_NODE sg13_hv_nmos
+ L=0.6u W=4.4u AS=0p AD=0p PS=0u PD=0u rfmode=0
* device instance PAD01_VDD.I1.N0<132> r0 *1 0,0 sg13_hv_nmos
MPAD01_VDD.I1.N0<132> IOVSS PAD01_VDD.NET3 VDD SUBSTRATE_NODE sg13_hv_nmos
+ L=0.6u W=4.4u AS=0p AD=0p PS=0u PD=0u rfmode=0
* device instance PAD01_VDD.I1.N0<133> r0 *1 0,0 sg13_hv_nmos
MPAD01_VDD.I1.N0<133> IOVSS PAD01_VDD.NET3 VDD SUBSTRATE_NODE sg13_hv_nmos
+ L=0.6u W=4.4u AS=0p AD=0p PS=0u PD=0u rfmode=0
* device instance PAD01_VDD.I1.N0<134> r0 *1 0,0 sg13_hv_nmos
MPAD01_VDD.I1.N0<134> IOVSS PAD01_VDD.NET3 VDD SUBSTRATE_NODE sg13_hv_nmos
+ L=0.6u W=4.4u AS=0p AD=0p PS=0u PD=0u rfmode=0
* device instance PAD01_VDD.I1.N0<135> r0 *1 0,0 sg13_hv_nmos
MPAD01_VDD.I1.N0<135> IOVSS PAD01_VDD.NET3 VDD SUBSTRATE_NODE sg13_hv_nmos
+ L=0.6u W=4.4u AS=0p AD=0p PS=0u PD=0u rfmode=0
* device instance PAD01_VDD.I1.N0<136> r0 *1 0,0 sg13_hv_nmos
MPAD01_VDD.I1.N0<136> IOVSS PAD01_VDD.NET3 VDD SUBSTRATE_NODE sg13_hv_nmos
+ L=0.6u W=4.4u AS=0p AD=0p PS=0u PD=0u rfmode=0
* device instance PAD01_VDD.I1.N0<137> r0 *1 0,0 sg13_hv_nmos
MPAD01_VDD.I1.N0<137> IOVSS PAD01_VDD.NET3 VDD SUBSTRATE_NODE sg13_hv_nmos
+ L=0.6u W=4.4u AS=0p AD=0p PS=0u PD=0u rfmode=0
* device instance PAD01_VDD.I1.N0<138> r0 *1 0,0 sg13_hv_nmos
MPAD01_VDD.I1.N0<138> IOVSS PAD01_VDD.NET3 VDD SUBSTRATE_NODE sg13_hv_nmos
+ L=0.6u W=4.4u AS=0p AD=0p PS=0u PD=0u rfmode=0
* device instance PAD01_VDD.I1.N0<139> r0 *1 0,0 sg13_hv_nmos
MPAD01_VDD.I1.N0<139> IOVSS PAD01_VDD.NET3 VDD SUBSTRATE_NODE sg13_hv_nmos
+ L=0.6u W=4.4u AS=0p AD=0p PS=0u PD=0u rfmode=0
* device instance PAD01_VDD.I1.N0<140> r0 *1 0,0 sg13_hv_nmos
MPAD01_VDD.I1.N0<140> IOVSS PAD01_VDD.NET3 VDD SUBSTRATE_NODE sg13_hv_nmos
+ L=0.6u W=4.4u AS=0p AD=0p PS=0u PD=0u rfmode=0
* device instance PAD01_VDD.I1.N0<141> r0 *1 0,0 sg13_hv_nmos
MPAD01_VDD.I1.N0<141> IOVSS PAD01_VDD.NET3 VDD SUBSTRATE_NODE sg13_hv_nmos
+ L=0.6u W=4.4u AS=0p AD=0p PS=0u PD=0u rfmode=0
* device instance PAD01_VDD.I1.N0<142> r0 *1 0,0 sg13_hv_nmos
MPAD01_VDD.I1.N0<142> IOVSS PAD01_VDD.NET3 VDD SUBSTRATE_NODE sg13_hv_nmos
+ L=0.6u W=4.4u AS=0p AD=0p PS=0u PD=0u rfmode=0
* device instance PAD01_VDD.I1.N0<143> r0 *1 0,0 sg13_hv_nmos
MPAD01_VDD.I1.N0<143> IOVSS PAD01_VDD.NET3 VDD SUBSTRATE_NODE sg13_hv_nmos
+ L=0.6u W=4.4u AS=0p AD=0p PS=0u PD=0u rfmode=0
* device instance PAD01_VDD.I1.N0<144> r0 *1 0,0 sg13_hv_nmos
MPAD01_VDD.I1.N0<144> IOVSS PAD01_VDD.NET3 VDD SUBSTRATE_NODE sg13_hv_nmos
+ L=0.6u W=4.4u AS=0p AD=0p PS=0u PD=0u rfmode=0
* device instance PAD01_VDD.I1.N0<145> r0 *1 0,0 sg13_hv_nmos
MPAD01_VDD.I1.N0<145> IOVSS PAD01_VDD.NET3 VDD SUBSTRATE_NODE sg13_hv_nmos
+ L=0.6u W=4.4u AS=0p AD=0p PS=0u PD=0u rfmode=0
* device instance PAD01_VDD.I1.N0<146> r0 *1 0,0 sg13_hv_nmos
MPAD01_VDD.I1.N0<146> IOVSS PAD01_VDD.NET3 VDD SUBSTRATE_NODE sg13_hv_nmos
+ L=0.6u W=4.4u AS=0p AD=0p PS=0u PD=0u rfmode=0
* device instance PAD01_VDD.I1.N0<147> r0 *1 0,0 sg13_hv_nmos
MPAD01_VDD.I1.N0<147> IOVSS PAD01_VDD.NET3 VDD SUBSTRATE_NODE sg13_hv_nmos
+ L=0.6u W=4.4u AS=0p AD=0p PS=0u PD=0u rfmode=0
* device instance PAD01_VDD.I1.N0<148> r0 *1 0,0 sg13_hv_nmos
MPAD01_VDD.I1.N0<148> IOVSS PAD01_VDD.NET3 VDD SUBSTRATE_NODE sg13_hv_nmos
+ L=0.6u W=4.4u AS=0p AD=0p PS=0u PD=0u rfmode=0
* device instance PAD01_VDD.I1.N0<149> r0 *1 0,0 sg13_hv_nmos
MPAD01_VDD.I1.N0<149> IOVSS PAD01_VDD.NET3 VDD SUBSTRATE_NODE sg13_hv_nmos
+ L=0.6u W=4.4u AS=0p AD=0p PS=0u PD=0u rfmode=0
* device instance PAD01_VDD.I1.N0<150> r0 *1 0,0 sg13_hv_nmos
MPAD01_VDD.I1.N0<150> IOVSS PAD01_VDD.NET3 VDD SUBSTRATE_NODE sg13_hv_nmos
+ L=0.6u W=4.4u AS=0p AD=0p PS=0u PD=0u rfmode=0
* device instance PAD01_VDD.I1.N0<151> r0 *1 0,0 sg13_hv_nmos
MPAD01_VDD.I1.N0<151> IOVSS PAD01_VDD.NET3 VDD SUBSTRATE_NODE sg13_hv_nmos
+ L=0.6u W=4.4u AS=0p AD=0p PS=0u PD=0u rfmode=0
* device instance PAD01_VDD.I1.N0<152> r0 *1 0,0 sg13_hv_nmos
MPAD01_VDD.I1.N0<152> IOVSS PAD01_VDD.NET3 VDD SUBSTRATE_NODE sg13_hv_nmos
+ L=0.6u W=4.4u AS=0p AD=0p PS=0u PD=0u rfmode=0
* device instance PAD01_VDD.I1.N0<153> r0 *1 0,0 sg13_hv_nmos
MPAD01_VDD.I1.N0<153> IOVSS PAD01_VDD.NET3 VDD SUBSTRATE_NODE sg13_hv_nmos
+ L=0.6u W=4.4u AS=0p AD=0p PS=0u PD=0u rfmode=0
* device instance PAD01_VDD.I1.N0<154> r0 *1 0,0 sg13_hv_nmos
MPAD01_VDD.I1.N0<154> IOVSS PAD01_VDD.NET3 VDD SUBSTRATE_NODE sg13_hv_nmos
+ L=0.6u W=4.4u AS=0p AD=0p PS=0u PD=0u rfmode=0
* device instance PAD01_VDD.I1.N0<155> r0 *1 0,0 sg13_hv_nmos
MPAD01_VDD.I1.N0<155> IOVSS PAD01_VDD.NET3 VDD SUBSTRATE_NODE sg13_hv_nmos
+ L=0.6u W=4.4u AS=0p AD=0p PS=0u PD=0u rfmode=0
* device instance PAD01_VDD.I1.N0<156> r0 *1 0,0 sg13_hv_nmos
MPAD01_VDD.I1.N0<156> IOVSS PAD01_VDD.NET3 VDD SUBSTRATE_NODE sg13_hv_nmos
+ L=0.6u W=4.4u AS=0p AD=0p PS=0u PD=0u rfmode=0
* device instance PAD01_VDD.I1.N0<157> r0 *1 0,0 sg13_hv_nmos
MPAD01_VDD.I1.N0<157> IOVSS PAD01_VDD.NET3 VDD SUBSTRATE_NODE sg13_hv_nmos
+ L=0.6u W=4.4u AS=0p AD=0p PS=0u PD=0u rfmode=0
* device instance PAD01_VDD.I1.N0<158> r0 *1 0,0 sg13_hv_nmos
MPAD01_VDD.I1.N0<158> IOVSS PAD01_VDD.NET3 VDD SUBSTRATE_NODE sg13_hv_nmos
+ L=0.6u W=4.4u AS=0p AD=0p PS=0u PD=0u rfmode=0
* device instance PAD01_VDD.I1.N0<159> r0 *1 0,0 sg13_hv_nmos
MPAD01_VDD.I1.N0<159> IOVSS PAD01_VDD.NET3 VDD SUBSTRATE_NODE sg13_hv_nmos
+ L=0.6u W=4.4u AS=0p AD=0p PS=0u PD=0u rfmode=0
* device instance PAD01_VDD.I1.N0<160> r0 *1 0,0 sg13_hv_nmos
MPAD01_VDD.I1.N0<160> IOVSS PAD01_VDD.NET3 VDD SUBSTRATE_NODE sg13_hv_nmos
+ L=0.6u W=4.4u AS=0p AD=0p PS=0u PD=0u rfmode=0
* device instance PAD01_VDD.I1.N0<161> r0 *1 0,0 sg13_hv_nmos
MPAD01_VDD.I1.N0<161> IOVSS PAD01_VDD.NET3 VDD SUBSTRATE_NODE sg13_hv_nmos
+ L=0.6u W=4.4u AS=0p AD=0p PS=0u PD=0u rfmode=0
* device instance PAD01_VDD.I1.N0<162> r0 *1 0,0 sg13_hv_nmos
MPAD01_VDD.I1.N0<162> IOVSS PAD01_VDD.NET3 VDD SUBSTRATE_NODE sg13_hv_nmos
+ L=0.6u W=4.4u AS=0p AD=0p PS=0u PD=0u rfmode=0
* device instance PAD01_VDD.I1.N0<163> r0 *1 0,0 sg13_hv_nmos
MPAD01_VDD.I1.N0<163> IOVSS PAD01_VDD.NET3 VDD SUBSTRATE_NODE sg13_hv_nmos
+ L=0.6u W=4.4u AS=0p AD=0p PS=0u PD=0u rfmode=0
* device instance PAD01_VDD.I1.N0<164> r0 *1 0,0 sg13_hv_nmos
MPAD01_VDD.I1.N0<164> IOVSS PAD01_VDD.NET3 VDD SUBSTRATE_NODE sg13_hv_nmos
+ L=0.6u W=4.4u AS=0p AD=0p PS=0u PD=0u rfmode=0
* device instance PAD01_VDD.I1.N0<165> r0 *1 0,0 sg13_hv_nmos
MPAD01_VDD.I1.N0<165> IOVSS PAD01_VDD.NET3 VDD SUBSTRATE_NODE sg13_hv_nmos
+ L=0.6u W=4.4u AS=0p AD=0p PS=0u PD=0u rfmode=0
* device instance PAD01_VDD.I1.N0<166> r0 *1 0,0 sg13_hv_nmos
MPAD01_VDD.I1.N0<166> IOVSS PAD01_VDD.NET3 VDD SUBSTRATE_NODE sg13_hv_nmos
+ L=0.6u W=4.4u AS=0p AD=0p PS=0u PD=0u rfmode=0
* device instance PAD01_VDD.I1.N0<167> r0 *1 0,0 sg13_hv_nmos
MPAD01_VDD.I1.N0<167> IOVSS PAD01_VDD.NET3 VDD SUBSTRATE_NODE sg13_hv_nmos
+ L=0.6u W=4.4u AS=0p AD=0p PS=0u PD=0u rfmode=0
* device instance PAD01_VDD.I1.N0<168> r0 *1 0,0 sg13_hv_nmos
MPAD01_VDD.I1.N0<168> IOVSS PAD01_VDD.NET3 VDD SUBSTRATE_NODE sg13_hv_nmos
+ L=0.6u W=4.4u AS=0p AD=0p PS=0u PD=0u rfmode=0
* device instance PAD01_VDD.I1.N0<169> r0 *1 0,0 sg13_hv_nmos
MPAD01_VDD.I1.N0<169> IOVSS PAD01_VDD.NET3 VDD SUBSTRATE_NODE sg13_hv_nmos
+ L=0.6u W=4.4u AS=0p AD=0p PS=0u PD=0u rfmode=0
* device instance PAD01_VDD.I1.N0<170> r0 *1 0,0 sg13_hv_nmos
MPAD01_VDD.I1.N0<170> IOVSS PAD01_VDD.NET3 VDD SUBSTRATE_NODE sg13_hv_nmos
+ L=0.6u W=4.4u AS=0p AD=0p PS=0u PD=0u rfmode=0
* device instance PAD01_VDD.I1.N0<171> r0 *1 0,0 sg13_hv_nmos
MPAD01_VDD.I1.N0<171> IOVSS PAD01_VDD.NET3 VDD SUBSTRATE_NODE sg13_hv_nmos
+ L=0.6u W=4.4u AS=0p AD=0p PS=0u PD=0u rfmode=0
* device instance PAD01_VDD.I1.N0<172> r0 *1 0,0 sg13_hv_nmos
MPAD01_VDD.I1.N0<172> IOVSS PAD01_VDD.NET3 VDD SUBSTRATE_NODE sg13_hv_nmos
+ L=0.6u W=4.4u AS=0p AD=0p PS=0u PD=0u rfmode=0
* device instance PAD01_VDD.I1._G1_TAP_SYNTAX_XR0 r0 *1 0,0 PTAP1
R175PAD01_VDD.I1._G1_TAP_SYNTAX_XR0 IOVSS SUBSTRATE_NODE PTAP1 A=65.6472p
+ P=386.16u
* device instance PAD01_VDD.I1.D0 r0 *1 0,0 DANTENNA
D176PAD01_VDD.I1.D0 SUBSTRATE_NODE PAD01_VDD.NET3 DANTENNA A=0.2304p P=1.92u m=1
* device instance PAD01_VDD.I4.R15 r0 *1 0,0 RPPD
R177PAD01_VDD.I4.R15 PAD01_VDD.I4.NET15 PAD01_VDD.I4.NET16 SUBSTRATE_NODE RPPD
+ w=1u l=20u ps=0u b=0 m=1
* device instance PAD01_VDD.I4.R20 r0 *1 0,0 RPPD
R178PAD01_VDD.I4.R20 PAD01_VDD.I4.NET20 PAD01_VDD.I4.NET21 SUBSTRATE_NODE RPPD
+ w=1u l=20u ps=0u b=0 m=1
* device instance PAD01_VDD.I4.R23 r0 *1 0,0 RPPD
R179PAD01_VDD.I4.R23 PAD01_VDD.I4.NET23 PAD01_VDD.I4.NET24 SUBSTRATE_NODE RPPD
+ w=1u l=20u ps=0u b=0 m=1
* device instance PAD01_VDD.I4.R17 r0 *1 0,0 RPPD
R180PAD01_VDD.I4.R17 PAD01_VDD.I4.NET17 PAD01_VDD.I4.NET18 SUBSTRATE_NODE RPPD
+ w=1u l=20u ps=0u b=0 m=1
* device instance PAD01_VDD.I4.R16 r0 *1 0,0 RPPD
R181PAD01_VDD.I4.R16 PAD01_VDD.I4.NET16 PAD01_VDD.I4.NET17 SUBSTRATE_NODE RPPD
+ w=1u l=20u ps=0u b=0 m=1
* device instance PAD01_VDD.I4.R25 r0 *1 0,0 RPPD
R182PAD01_VDD.I4.R25 PAD01_VDD.I4.NET25 PAD01_VDD.NET1 SUBSTRATE_NODE RPPD w=1u
+ l=20u ps=0u b=0 m=1
* device instance PAD01_VDD.I4.R22 r0 *1 0,0 RPPD
R183PAD01_VDD.I4.R22 PAD01_VDD.I4.NET22 PAD01_VDD.I4.NET23 SUBSTRATE_NODE RPPD
+ w=1u l=20u ps=0u b=0 m=1
* device instance PAD01_VDD.I4.R19 r0 *1 0,0 RPPD
R184PAD01_VDD.I4.R19 PAD01_VDD.I4.NET19 PAD01_VDD.I4.NET20 SUBSTRATE_NODE RPPD
+ w=1u l=20u ps=0u b=0 m=1
* device instance PAD01_VDD.I4.R24 r0 *1 0,0 RPPD
R185PAD01_VDD.I4.R24 PAD01_VDD.I4.NET24 PAD01_VDD.I4.NET25 SUBSTRATE_NODE RPPD
+ w=1u l=20u ps=0u b=0 m=1
* device instance PAD01_VDD.I4.R21 r0 *1 0,0 RPPD
R186PAD01_VDD.I4.R21 PAD01_VDD.I4.NET21 PAD01_VDD.I4.NET22 SUBSTRATE_NODE RPPD
+ w=1u l=20u ps=0u b=0 m=1
* device instance PAD01_VDD.I4.R18 r0 *1 0,0 RPPD
R187PAD01_VDD.I4.R18 PAD01_VDD.I4.NET18 PAD01_VDD.I4.NET19 SUBSTRATE_NODE RPPD
+ w=1u l=20u ps=0u b=0 m=1
* device instance PAD01_VDD.I4.R5 r0 *1 0,0 RPPD
R188PAD01_VDD.I4.R5 PAD01_VDD.I4.NET5 PAD01_VDD.I4.NET6 SUBSTRATE_NODE RPPD w=1u
+ l=20u ps=0u b=0 m=1
* device instance PAD01_VDD.I4.R8 r0 *1 0,0 RPPD
R189PAD01_VDD.I4.R8 PAD01_VDD.I4.NET8 PAD01_VDD.I4.NET9 SUBSTRATE_NODE RPPD w=1u
+ l=20u ps=0u b=0 m=1
* device instance PAD01_VDD.I4.R11 r0 *1 0,0 RPPD
R190PAD01_VDD.I4.R11 PAD01_VDD.I4.NET11 PAD01_VDD.I4.NET12 SUBSTRATE_NODE RPPD
+ w=1u l=20u ps=0u b=0 m=1
* device instance PAD01_VDD.I4.R14 r0 *1 0,0 RPPD
R191PAD01_VDD.I4.R14 PAD01_VDD.I4.NET14 PAD01_VDD.I4.NET15 SUBSTRATE_NODE RPPD
+ w=1u l=20u ps=0u b=0 m=1
* device instance PAD01_VDD.I4.R2 r0 *1 0,0 RPPD
R192PAD01_VDD.I4.R2 PAD01_VDD.I4.NET2 PAD01_VDD.I4.NET3 SUBSTRATE_NODE RPPD w=1u
+ l=20u ps=0u b=0 m=1
* device instance PAD01_VDD.I4.R1 r0 *1 0,0 RPPD
R193PAD01_VDD.I4.R1 PAD01_VDD.I4.NET1 PAD01_VDD.I4.NET2 SUBSTRATE_NODE RPPD w=1u
+ l=20u ps=0u b=0 m=1
* device instance PAD01_VDD.I4.R13 r0 *1 0,0 RPPD
R194PAD01_VDD.I4.R13 PAD01_VDD.I4.NET13 PAD01_VDD.I4.NET14 SUBSTRATE_NODE RPPD
+ w=1u l=20u ps=0u b=0 m=1
* device instance PAD01_VDD.I4.R10 r0 *1 0,0 RPPD
R195PAD01_VDD.I4.R10 PAD01_VDD.I4.NET10 PAD01_VDD.I4.NET11 SUBSTRATE_NODE RPPD
+ w=1u l=20u ps=0u b=0 m=1
* device instance PAD01_VDD.I4.R7 r0 *1 0,0 RPPD
R196PAD01_VDD.I4.R7 PAD01_VDD.I4.NET7 PAD01_VDD.I4.NET8 SUBSTRATE_NODE RPPD w=1u
+ l=20u ps=0u b=0 m=1
* device instance PAD01_VDD.I4.R4 r0 *1 0,0 RPPD
R197PAD01_VDD.I4.R4 PAD01_VDD.I4.NET4 PAD01_VDD.I4.NET5 SUBSTRATE_NODE RPPD w=1u
+ l=20u ps=0u b=0 m=1
* device instance PAD01_VDD.I4.R12 r0 *1 0,0 RPPD
R198PAD01_VDD.I4.R12 PAD01_VDD.I4.NET12 PAD01_VDD.I4.NET13 SUBSTRATE_NODE RPPD
+ w=1u l=20u ps=0u b=0 m=1
* device instance PAD01_VDD.I4.R9 r0 *1 0,0 RPPD
R199PAD01_VDD.I4.R9 PAD01_VDD.I4.NET9 PAD01_VDD.I4.NET10 SUBSTRATE_NODE RPPD
+ w=1u l=20u ps=0u b=0 m=1
* device instance PAD01_VDD.I4.R6 r0 *1 0,0 RPPD
R200PAD01_VDD.I4.R6 PAD01_VDD.I4.NET6 PAD01_VDD.I4.NET7 SUBSTRATE_NODE RPPD w=1u
+ l=20u ps=0u b=0 m=1
* device instance PAD01_VDD.I4.R3 r0 *1 0,0 RPPD
R201PAD01_VDD.I4.R3 PAD01_VDD.I4.NET3 PAD01_VDD.I4.NET4 SUBSTRATE_NODE RPPD w=1u
+ l=20u ps=0u b=0 m=1
* device instance PAD01_VDD.I4.R0 r0 *1 0,0 RPPD
R202PAD01_VDD.I4.R0 VDD PAD01_VDD.I4.NET1 SUBSTRATE_NODE RPPD w=1u l=20u ps=0u
+ b=0 m=1
* device instance PAD01_VDD.I3.N1 r0 *1 0,0 sg13_hv_nmos
MPAD01_VDD.I3.N1 IOVSS PAD01_VDD.NET1 IOVSS SUBSTRATE_NODE sg13_hv_nmos L=9.5u
+ W=63u AS=0p AD=0p PS=0u PD=0u rfmode=0
* device instance PAD01_VDD.I3.N3 r0 *1 0,0 sg13_hv_nmos
MPAD01_VDD.I3.N3 IOVSS PAD01_VDD.NET1 PAD01_VDD.NET3 SUBSTRATE_NODE
+ sg13_hv_nmos L=0.5u W=54u AS=0p AD=0p PS=0u PD=0u rfmode=0
* device instance PAD01_VDD.I3.N0 r0 *1 0,0 sg13_hv_nmos
MPAD01_VDD.I3.N0 IOVSS PAD01_VDD.NET1 IOVSS SUBSTRATE_NODE sg13_hv_nmos L=9.5u
+ W=63u AS=0p AD=0p PS=0u PD=0u rfmode=0
* device instance PAD01_VDD.I3.N2 r0 *1 0,0 sg13_hv_nmos
MPAD01_VDD.I3.N2 IOVSS PAD01_VDD.NET1 PAD01_VDD.NET3 SUBSTRATE_NODE
+ sg13_hv_nmos L=0.5u W=54u AS=0p AD=0p PS=0u PD=0u rfmode=0
* device instance PAD01_VDD.I3._G1_TAP_SYNTAX_XR0 r0 *1 0,0 PTAP1
R207PAD01_VDD.I3._G1_TAP_SYNTAX_XR0 IOVSS SUBSTRATE_NODE PTAP1 A=69.122p P=406.6u
* device instance PAD01_VDD.I3.P0 r0 *1 0,0 sg13_hv_pmos
MPAD01_VDD.I3.P0 VDD PAD01_VDD.NET1 PAD01_VDD.NET3 VDD sg13_hv_pmos L=0.5u
+ W=350u AS=0p AD=0p PS=0u PD=0u rfmode=0
* device instance PAD02_VSS._G1_TAP_SYNTAX_XR1 r0 *1 0,0 PTAP1
R209PAD02_VSS._G1_TAP_SYNTAX_XR1 IOVSS SUBSTRATE_NODE PTAP1 A=5379.0466p
+ P=677.04u
* device instance PAD02_VSS._G1_TAP_SYNTAX_XR0 r0 *1 0,0 PTAP1
R210PAD02_VSS._G1_TAP_SYNTAX_XR0 VSS SUBSTRATE_NODE PTAP1 A=24p P=160.6u
* device instance PAD02_VSS.I1.D1 r0 *1 0,0 DANTENNA
D211PAD02_VSS.I1.D1 SUBSTRATE_NODE VSS DANTENNA A=35.003p P=58.08u m=1
* device instance PAD02_VSS.I1.D0 r0 *1 0,0 DANTENNA
D212PAD02_VSS.I1.D0 SUBSTRATE_NODE VSS DANTENNA A=35.003p P=58.08u m=1
* device instance PAD02_VSS.I1._G1_TAP_SYNTAX_XR0 r0 *1 0,0 PTAP1
R213PAD02_VSS.I1._G1_TAP_SYNTAX_XR0 IOVSS SUBSTRATE_NODE PTAP1 A=141.2964p
+ P=221.76u
* device instance PAD02_VSS.I2.D1 r0 *1 0,0 DPANTENNA
D214PAD02_VSS.I2.D1 VSS IOVDD DPANTENNA A=35.003p P=58.08u m=1
* device instance PAD02_VSS.I2.D0 r0 *1 0,0 DPANTENNA
D215PAD02_VSS.I2.D0 VSS IOVDD DPANTENNA A=35.003p P=58.08u m=1
* device instance PAD02_VSS.I2._G1_TAP_SYNTAX_XR0 r0 *1 0,0 PTAP1
R216PAD02_VSS.I2._G1_TAP_SYNTAX_XR0 IOVSS SUBSTRATE_NODE PTAP1 A=33.5104p
+ P=197.12u
* device instance PAD05_VSS._G1_TAP_SYNTAX_XR1 r0 *1 0,0 PTAP1
R217PAD05_VSS._G1_TAP_SYNTAX_XR1 IOVSS SUBSTRATE_NODE PTAP1 A=5379.0466p
+ P=677.04u
* device instance PAD05_VSS._G1_TAP_SYNTAX_XR0 r0 *1 0,0 PTAP1
R218PAD05_VSS._G1_TAP_SYNTAX_XR0 VSS SUBSTRATE_NODE PTAP1 A=24p P=160.6u
* device instance PAD05_VSS.I1.D1 r0 *1 0,0 DANTENNA
D219PAD05_VSS.I1.D1 SUBSTRATE_NODE VSS DANTENNA A=35.003p P=58.08u m=1
* device instance PAD05_VSS.I1.D0 r0 *1 0,0 DANTENNA
D220PAD05_VSS.I1.D0 SUBSTRATE_NODE VSS DANTENNA A=35.003p P=58.08u m=1
* device instance PAD05_VSS.I1._G1_TAP_SYNTAX_XR0 r0 *1 0,0 PTAP1
R221PAD05_VSS.I1._G1_TAP_SYNTAX_XR0 IOVSS SUBSTRATE_NODE PTAP1 A=141.2964p
+ P=221.76u
* device instance PAD05_VSS.I2.D1 r0 *1 0,0 DPANTENNA
D222PAD05_VSS.I2.D1 VSS IOVDD DPANTENNA A=35.003p P=58.08u m=1
* device instance PAD05_VSS.I2.D0 r0 *1 0,0 DPANTENNA
D223PAD05_VSS.I2.D0 VSS IOVDD DPANTENNA A=35.003p P=58.08u m=1
* device instance PAD05_VSS.I2._G1_TAP_SYNTAX_XR0 r0 *1 0,0 PTAP1
R224PAD05_VSS.I2._G1_TAP_SYNTAX_XR0 IOVSS SUBSTRATE_NODE PTAP1 A=33.5104p
+ P=197.12u
* device instance PAD03_IOVDD._G1_TAP_SYNTAX_XR0 r0 *1 0,0 PTAP1
R225PAD03_IOVDD._G1_TAP_SYNTAX_XR0 VSS SUBSTRATE_NODE PTAP1 A=24p P=160.6u
* device instance PAD03_IOVDD._G1_TAP_SYNTAX_XR1 r0 *1 0,0 PTAP1
R226PAD03_IOVDD._G1_TAP_SYNTAX_XR1 IOVSS SUBSTRATE_NODE PTAP1 A=1997.9154p
+ P=411.58u
* device instance PAD03_IOVDD.I1.N0<1> r0 *1 0,0 sg13_hv_nmos
MPAD03_IOVDD.I1.N0<1> IOVSS PAD03_IOVDD.NET4 IOVDD SUBSTRATE_NODE sg13_hv_nmos
+ L=0.6u W=4.4u AS=0p AD=0p PS=0u PD=0u rfmode=0
* device instance PAD03_IOVDD.I1.N0<2> r0 *1 0,0 sg13_hv_nmos
MPAD03_IOVDD.I1.N0<2> IOVSS PAD03_IOVDD.NET4 IOVDD SUBSTRATE_NODE sg13_hv_nmos
+ L=0.6u W=4.4u AS=0p AD=0p PS=0u PD=0u rfmode=0
* device instance PAD03_IOVDD.I1.N0<3> r0 *1 0,0 sg13_hv_nmos
MPAD03_IOVDD.I1.N0<3> IOVSS PAD03_IOVDD.NET4 IOVDD SUBSTRATE_NODE sg13_hv_nmos
+ L=0.6u W=4.4u AS=0p AD=0p PS=0u PD=0u rfmode=0
* device instance PAD03_IOVDD.I1.N0<4> r0 *1 0,0 sg13_hv_nmos
MPAD03_IOVDD.I1.N0<4> IOVSS PAD03_IOVDD.NET4 IOVDD SUBSTRATE_NODE sg13_hv_nmos
+ L=0.6u W=4.4u AS=0p AD=0p PS=0u PD=0u rfmode=0
* device instance PAD03_IOVDD.I1.N0<5> r0 *1 0,0 sg13_hv_nmos
MPAD03_IOVDD.I1.N0<5> IOVSS PAD03_IOVDD.NET4 IOVDD SUBSTRATE_NODE sg13_hv_nmos
+ L=0.6u W=4.4u AS=0p AD=0p PS=0u PD=0u rfmode=0
* device instance PAD03_IOVDD.I1.N0<6> r0 *1 0,0 sg13_hv_nmos
MPAD03_IOVDD.I1.N0<6> IOVSS PAD03_IOVDD.NET4 IOVDD SUBSTRATE_NODE sg13_hv_nmos
+ L=0.6u W=4.4u AS=0p AD=0p PS=0u PD=0u rfmode=0
* device instance PAD03_IOVDD.I1.N0<7> r0 *1 0,0 sg13_hv_nmos
MPAD03_IOVDD.I1.N0<7> IOVSS PAD03_IOVDD.NET4 IOVDD SUBSTRATE_NODE sg13_hv_nmos
+ L=0.6u W=4.4u AS=0p AD=0p PS=0u PD=0u rfmode=0
* device instance PAD03_IOVDD.I1.N0<8> r0 *1 0,0 sg13_hv_nmos
MPAD03_IOVDD.I1.N0<8> IOVSS PAD03_IOVDD.NET4 IOVDD SUBSTRATE_NODE sg13_hv_nmos
+ L=0.6u W=4.4u AS=0p AD=0p PS=0u PD=0u rfmode=0
* device instance PAD03_IOVDD.I1.N0<9> r0 *1 0,0 sg13_hv_nmos
MPAD03_IOVDD.I1.N0<9> IOVSS PAD03_IOVDD.NET4 IOVDD SUBSTRATE_NODE sg13_hv_nmos
+ L=0.6u W=4.4u AS=0p AD=0p PS=0u PD=0u rfmode=0
* device instance PAD03_IOVDD.I1.N0<10> r0 *1 0,0 sg13_hv_nmos
MPAD03_IOVDD.I1.N0<10> IOVSS PAD03_IOVDD.NET4 IOVDD SUBSTRATE_NODE sg13_hv_nmos
+ L=0.6u W=4.4u AS=0p AD=0p PS=0u PD=0u rfmode=0
* device instance PAD03_IOVDD.I1.N0<11> r0 *1 0,0 sg13_hv_nmos
MPAD03_IOVDD.I1.N0<11> IOVSS PAD03_IOVDD.NET4 IOVDD SUBSTRATE_NODE sg13_hv_nmos
+ L=0.6u W=4.4u AS=0p AD=0p PS=0u PD=0u rfmode=0
* device instance PAD03_IOVDD.I1.N0<12> r0 *1 0,0 sg13_hv_nmos
MPAD03_IOVDD.I1.N0<12> IOVSS PAD03_IOVDD.NET4 IOVDD SUBSTRATE_NODE sg13_hv_nmos
+ L=0.6u W=4.4u AS=0p AD=0p PS=0u PD=0u rfmode=0
* device instance PAD03_IOVDD.I1.N0<13> r0 *1 0,0 sg13_hv_nmos
MPAD03_IOVDD.I1.N0<13> IOVSS PAD03_IOVDD.NET4 IOVDD SUBSTRATE_NODE sg13_hv_nmos
+ L=0.6u W=4.4u AS=0p AD=0p PS=0u PD=0u rfmode=0
* device instance PAD03_IOVDD.I1.N0<14> r0 *1 0,0 sg13_hv_nmos
MPAD03_IOVDD.I1.N0<14> IOVSS PAD03_IOVDD.NET4 IOVDD SUBSTRATE_NODE sg13_hv_nmos
+ L=0.6u W=4.4u AS=0p AD=0p PS=0u PD=0u rfmode=0
* device instance PAD03_IOVDD.I1.N0<15> r0 *1 0,0 sg13_hv_nmos
MPAD03_IOVDD.I1.N0<15> IOVSS PAD03_IOVDD.NET4 IOVDD SUBSTRATE_NODE sg13_hv_nmos
+ L=0.6u W=4.4u AS=0p AD=0p PS=0u PD=0u rfmode=0
* device instance PAD03_IOVDD.I1.N0<16> r0 *1 0,0 sg13_hv_nmos
MPAD03_IOVDD.I1.N0<16> IOVSS PAD03_IOVDD.NET4 IOVDD SUBSTRATE_NODE sg13_hv_nmos
+ L=0.6u W=4.4u AS=0p AD=0p PS=0u PD=0u rfmode=0
* device instance PAD03_IOVDD.I1.N0<17> r0 *1 0,0 sg13_hv_nmos
MPAD03_IOVDD.I1.N0<17> IOVSS PAD03_IOVDD.NET4 IOVDD SUBSTRATE_NODE sg13_hv_nmos
+ L=0.6u W=4.4u AS=0p AD=0p PS=0u PD=0u rfmode=0
* device instance PAD03_IOVDD.I1.N0<18> r0 *1 0,0 sg13_hv_nmos
MPAD03_IOVDD.I1.N0<18> IOVSS PAD03_IOVDD.NET4 IOVDD SUBSTRATE_NODE sg13_hv_nmos
+ L=0.6u W=4.4u AS=0p AD=0p PS=0u PD=0u rfmode=0
* device instance PAD03_IOVDD.I1.N0<19> r0 *1 0,0 sg13_hv_nmos
MPAD03_IOVDD.I1.N0<19> IOVSS PAD03_IOVDD.NET4 IOVDD SUBSTRATE_NODE sg13_hv_nmos
+ L=0.6u W=4.4u AS=0p AD=0p PS=0u PD=0u rfmode=0
* device instance PAD03_IOVDD.I1.N0<20> r0 *1 0,0 sg13_hv_nmos
MPAD03_IOVDD.I1.N0<20> IOVSS PAD03_IOVDD.NET4 IOVDD SUBSTRATE_NODE sg13_hv_nmos
+ L=0.6u W=4.4u AS=0p AD=0p PS=0u PD=0u rfmode=0
* device instance PAD03_IOVDD.I1.N0<21> r0 *1 0,0 sg13_hv_nmos
MPAD03_IOVDD.I1.N0<21> IOVSS PAD03_IOVDD.NET4 IOVDD SUBSTRATE_NODE sg13_hv_nmos
+ L=0.6u W=4.4u AS=0p AD=0p PS=0u PD=0u rfmode=0
* device instance PAD03_IOVDD.I1.N0<22> r0 *1 0,0 sg13_hv_nmos
MPAD03_IOVDD.I1.N0<22> IOVSS PAD03_IOVDD.NET4 IOVDD SUBSTRATE_NODE sg13_hv_nmos
+ L=0.6u W=4.4u AS=0p AD=0p PS=0u PD=0u rfmode=0
* device instance PAD03_IOVDD.I1.N0<23> r0 *1 0,0 sg13_hv_nmos
MPAD03_IOVDD.I1.N0<23> IOVSS PAD03_IOVDD.NET4 IOVDD SUBSTRATE_NODE sg13_hv_nmos
+ L=0.6u W=4.4u AS=0p AD=0p PS=0u PD=0u rfmode=0
* device instance PAD03_IOVDD.I1.N0<24> r0 *1 0,0 sg13_hv_nmos
MPAD03_IOVDD.I1.N0<24> IOVSS PAD03_IOVDD.NET4 IOVDD SUBSTRATE_NODE sg13_hv_nmos
+ L=0.6u W=4.4u AS=0p AD=0p PS=0u PD=0u rfmode=0
* device instance PAD03_IOVDD.I1.N0<25> r0 *1 0,0 sg13_hv_nmos
MPAD03_IOVDD.I1.N0<25> IOVSS PAD03_IOVDD.NET4 IOVDD SUBSTRATE_NODE sg13_hv_nmos
+ L=0.6u W=4.4u AS=0p AD=0p PS=0u PD=0u rfmode=0
* device instance PAD03_IOVDD.I1.N0<26> r0 *1 0,0 sg13_hv_nmos
MPAD03_IOVDD.I1.N0<26> IOVSS PAD03_IOVDD.NET4 IOVDD SUBSTRATE_NODE sg13_hv_nmos
+ L=0.6u W=4.4u AS=0p AD=0p PS=0u PD=0u rfmode=0
* device instance PAD03_IOVDD.I1.N0<27> r0 *1 0,0 sg13_hv_nmos
MPAD03_IOVDD.I1.N0<27> IOVSS PAD03_IOVDD.NET4 IOVDD SUBSTRATE_NODE sg13_hv_nmos
+ L=0.6u W=4.4u AS=0p AD=0p PS=0u PD=0u rfmode=0
* device instance PAD03_IOVDD.I1.N0<28> r0 *1 0,0 sg13_hv_nmos
MPAD03_IOVDD.I1.N0<28> IOVSS PAD03_IOVDD.NET4 IOVDD SUBSTRATE_NODE sg13_hv_nmos
+ L=0.6u W=4.4u AS=0p AD=0p PS=0u PD=0u rfmode=0
* device instance PAD03_IOVDD.I1.N0<29> r0 *1 0,0 sg13_hv_nmos
MPAD03_IOVDD.I1.N0<29> IOVSS PAD03_IOVDD.NET4 IOVDD SUBSTRATE_NODE sg13_hv_nmos
+ L=0.6u W=4.4u AS=0p AD=0p PS=0u PD=0u rfmode=0
* device instance PAD03_IOVDD.I1.N0<30> r0 *1 0,0 sg13_hv_nmos
MPAD03_IOVDD.I1.N0<30> IOVSS PAD03_IOVDD.NET4 IOVDD SUBSTRATE_NODE sg13_hv_nmos
+ L=0.6u W=4.4u AS=0p AD=0p PS=0u PD=0u rfmode=0
* device instance PAD03_IOVDD.I1.N0<31> r0 *1 0,0 sg13_hv_nmos
MPAD03_IOVDD.I1.N0<31> IOVSS PAD03_IOVDD.NET4 IOVDD SUBSTRATE_NODE sg13_hv_nmos
+ L=0.6u W=4.4u AS=0p AD=0p PS=0u PD=0u rfmode=0
* device instance PAD03_IOVDD.I1.N0<32> r0 *1 0,0 sg13_hv_nmos
MPAD03_IOVDD.I1.N0<32> IOVSS PAD03_IOVDD.NET4 IOVDD SUBSTRATE_NODE sg13_hv_nmos
+ L=0.6u W=4.4u AS=0p AD=0p PS=0u PD=0u rfmode=0
* device instance PAD03_IOVDD.I1.N0<33> r0 *1 0,0 sg13_hv_nmos
MPAD03_IOVDD.I1.N0<33> IOVSS PAD03_IOVDD.NET4 IOVDD SUBSTRATE_NODE sg13_hv_nmos
+ L=0.6u W=4.4u AS=0p AD=0p PS=0u PD=0u rfmode=0
* device instance PAD03_IOVDD.I1.N0<34> r0 *1 0,0 sg13_hv_nmos
MPAD03_IOVDD.I1.N0<34> IOVSS PAD03_IOVDD.NET4 IOVDD SUBSTRATE_NODE sg13_hv_nmos
+ L=0.6u W=4.4u AS=0p AD=0p PS=0u PD=0u rfmode=0
* device instance PAD03_IOVDD.I1.N0<35> r0 *1 0,0 sg13_hv_nmos
MPAD03_IOVDD.I1.N0<35> IOVSS PAD03_IOVDD.NET4 IOVDD SUBSTRATE_NODE sg13_hv_nmos
+ L=0.6u W=4.4u AS=0p AD=0p PS=0u PD=0u rfmode=0
* device instance PAD03_IOVDD.I1.N0<36> r0 *1 0,0 sg13_hv_nmos
MPAD03_IOVDD.I1.N0<36> IOVSS PAD03_IOVDD.NET4 IOVDD SUBSTRATE_NODE sg13_hv_nmos
+ L=0.6u W=4.4u AS=0p AD=0p PS=0u PD=0u rfmode=0
* device instance PAD03_IOVDD.I1.N0<37> r0 *1 0,0 sg13_hv_nmos
MPAD03_IOVDD.I1.N0<37> IOVSS PAD03_IOVDD.NET4 IOVDD SUBSTRATE_NODE sg13_hv_nmos
+ L=0.6u W=4.4u AS=0p AD=0p PS=0u PD=0u rfmode=0
* device instance PAD03_IOVDD.I1.N0<38> r0 *1 0,0 sg13_hv_nmos
MPAD03_IOVDD.I1.N0<38> IOVSS PAD03_IOVDD.NET4 IOVDD SUBSTRATE_NODE sg13_hv_nmos
+ L=0.6u W=4.4u AS=0p AD=0p PS=0u PD=0u rfmode=0
* device instance PAD03_IOVDD.I1.N0<39> r0 *1 0,0 sg13_hv_nmos
MPAD03_IOVDD.I1.N0<39> IOVSS PAD03_IOVDD.NET4 IOVDD SUBSTRATE_NODE sg13_hv_nmos
+ L=0.6u W=4.4u AS=0p AD=0p PS=0u PD=0u rfmode=0
* device instance PAD03_IOVDD.I1.N0<40> r0 *1 0,0 sg13_hv_nmos
MPAD03_IOVDD.I1.N0<40> IOVSS PAD03_IOVDD.NET4 IOVDD SUBSTRATE_NODE sg13_hv_nmos
+ L=0.6u W=4.4u AS=0p AD=0p PS=0u PD=0u rfmode=0
* device instance PAD03_IOVDD.I1.N0<41> r0 *1 0,0 sg13_hv_nmos
MPAD03_IOVDD.I1.N0<41> IOVSS PAD03_IOVDD.NET4 IOVDD SUBSTRATE_NODE sg13_hv_nmos
+ L=0.6u W=4.4u AS=0p AD=0p PS=0u PD=0u rfmode=0
* device instance PAD03_IOVDD.I1.N0<42> r0 *1 0,0 sg13_hv_nmos
MPAD03_IOVDD.I1.N0<42> IOVSS PAD03_IOVDD.NET4 IOVDD SUBSTRATE_NODE sg13_hv_nmos
+ L=0.6u W=4.4u AS=0p AD=0p PS=0u PD=0u rfmode=0
* device instance PAD03_IOVDD.I1.N0<43> r0 *1 0,0 sg13_hv_nmos
MPAD03_IOVDD.I1.N0<43> IOVSS PAD03_IOVDD.NET4 IOVDD SUBSTRATE_NODE sg13_hv_nmos
+ L=0.6u W=4.4u AS=0p AD=0p PS=0u PD=0u rfmode=0
* device instance PAD03_IOVDD.I1.N0<44> r0 *1 0,0 sg13_hv_nmos
MPAD03_IOVDD.I1.N0<44> IOVSS PAD03_IOVDD.NET4 IOVDD SUBSTRATE_NODE sg13_hv_nmos
+ L=0.6u W=4.4u AS=0p AD=0p PS=0u PD=0u rfmode=0
* device instance PAD03_IOVDD.I1.N0<45> r0 *1 0,0 sg13_hv_nmos
MPAD03_IOVDD.I1.N0<45> IOVSS PAD03_IOVDD.NET4 IOVDD SUBSTRATE_NODE sg13_hv_nmos
+ L=0.6u W=4.4u AS=0p AD=0p PS=0u PD=0u rfmode=0
* device instance PAD03_IOVDD.I1.N0<46> r0 *1 0,0 sg13_hv_nmos
MPAD03_IOVDD.I1.N0<46> IOVSS PAD03_IOVDD.NET4 IOVDD SUBSTRATE_NODE sg13_hv_nmos
+ L=0.6u W=4.4u AS=0p AD=0p PS=0u PD=0u rfmode=0
* device instance PAD03_IOVDD.I1.N0<47> r0 *1 0,0 sg13_hv_nmos
MPAD03_IOVDD.I1.N0<47> IOVSS PAD03_IOVDD.NET4 IOVDD SUBSTRATE_NODE sg13_hv_nmos
+ L=0.6u W=4.4u AS=0p AD=0p PS=0u PD=0u rfmode=0
* device instance PAD03_IOVDD.I1.N0<48> r0 *1 0,0 sg13_hv_nmos
MPAD03_IOVDD.I1.N0<48> IOVSS PAD03_IOVDD.NET4 IOVDD SUBSTRATE_NODE sg13_hv_nmos
+ L=0.6u W=4.4u AS=0p AD=0p PS=0u PD=0u rfmode=0
* device instance PAD03_IOVDD.I1.N0<49> r0 *1 0,0 sg13_hv_nmos
MPAD03_IOVDD.I1.N0<49> IOVSS PAD03_IOVDD.NET4 IOVDD SUBSTRATE_NODE sg13_hv_nmos
+ L=0.6u W=4.4u AS=0p AD=0p PS=0u PD=0u rfmode=0
* device instance PAD03_IOVDD.I1.N0<50> r0 *1 0,0 sg13_hv_nmos
MPAD03_IOVDD.I1.N0<50> IOVSS PAD03_IOVDD.NET4 IOVDD SUBSTRATE_NODE sg13_hv_nmos
+ L=0.6u W=4.4u AS=0p AD=0p PS=0u PD=0u rfmode=0
* device instance PAD03_IOVDD.I1.N0<51> r0 *1 0,0 sg13_hv_nmos
MPAD03_IOVDD.I1.N0<51> IOVSS PAD03_IOVDD.NET4 IOVDD SUBSTRATE_NODE sg13_hv_nmos
+ L=0.6u W=4.4u AS=0p AD=0p PS=0u PD=0u rfmode=0
* device instance PAD03_IOVDD.I1.N0<52> r0 *1 0,0 sg13_hv_nmos
MPAD03_IOVDD.I1.N0<52> IOVSS PAD03_IOVDD.NET4 IOVDD SUBSTRATE_NODE sg13_hv_nmos
+ L=0.6u W=4.4u AS=0p AD=0p PS=0u PD=0u rfmode=0
* device instance PAD03_IOVDD.I1.N0<53> r0 *1 0,0 sg13_hv_nmos
MPAD03_IOVDD.I1.N0<53> IOVSS PAD03_IOVDD.NET4 IOVDD SUBSTRATE_NODE sg13_hv_nmos
+ L=0.6u W=4.4u AS=0p AD=0p PS=0u PD=0u rfmode=0
* device instance PAD03_IOVDD.I1.N0<54> r0 *1 0,0 sg13_hv_nmos
MPAD03_IOVDD.I1.N0<54> IOVSS PAD03_IOVDD.NET4 IOVDD SUBSTRATE_NODE sg13_hv_nmos
+ L=0.6u W=4.4u AS=0p AD=0p PS=0u PD=0u rfmode=0
* device instance PAD03_IOVDD.I1.N0<55> r0 *1 0,0 sg13_hv_nmos
MPAD03_IOVDD.I1.N0<55> IOVSS PAD03_IOVDD.NET4 IOVDD SUBSTRATE_NODE sg13_hv_nmos
+ L=0.6u W=4.4u AS=0p AD=0p PS=0u PD=0u rfmode=0
* device instance PAD03_IOVDD.I1.N0<56> r0 *1 0,0 sg13_hv_nmos
MPAD03_IOVDD.I1.N0<56> IOVSS PAD03_IOVDD.NET4 IOVDD SUBSTRATE_NODE sg13_hv_nmos
+ L=0.6u W=4.4u AS=0p AD=0p PS=0u PD=0u rfmode=0
* device instance PAD03_IOVDD.I1.N0<57> r0 *1 0,0 sg13_hv_nmos
MPAD03_IOVDD.I1.N0<57> IOVSS PAD03_IOVDD.NET4 IOVDD SUBSTRATE_NODE sg13_hv_nmos
+ L=0.6u W=4.4u AS=0p AD=0p PS=0u PD=0u rfmode=0
* device instance PAD03_IOVDD.I1.N0<58> r0 *1 0,0 sg13_hv_nmos
MPAD03_IOVDD.I1.N0<58> IOVSS PAD03_IOVDD.NET4 IOVDD SUBSTRATE_NODE sg13_hv_nmos
+ L=0.6u W=4.4u AS=0p AD=0p PS=0u PD=0u rfmode=0
* device instance PAD03_IOVDD.I1.N0<59> r0 *1 0,0 sg13_hv_nmos
MPAD03_IOVDD.I1.N0<59> IOVSS PAD03_IOVDD.NET4 IOVDD SUBSTRATE_NODE sg13_hv_nmos
+ L=0.6u W=4.4u AS=0p AD=0p PS=0u PD=0u rfmode=0
* device instance PAD03_IOVDD.I1.N0<60> r0 *1 0,0 sg13_hv_nmos
MPAD03_IOVDD.I1.N0<60> IOVSS PAD03_IOVDD.NET4 IOVDD SUBSTRATE_NODE sg13_hv_nmos
+ L=0.6u W=4.4u AS=0p AD=0p PS=0u PD=0u rfmode=0
* device instance PAD03_IOVDD.I1.N0<61> r0 *1 0,0 sg13_hv_nmos
MPAD03_IOVDD.I1.N0<61> IOVSS PAD03_IOVDD.NET4 IOVDD SUBSTRATE_NODE sg13_hv_nmos
+ L=0.6u W=4.4u AS=0p AD=0p PS=0u PD=0u rfmode=0
* device instance PAD03_IOVDD.I1.N0<62> r0 *1 0,0 sg13_hv_nmos
MPAD03_IOVDD.I1.N0<62> IOVSS PAD03_IOVDD.NET4 IOVDD SUBSTRATE_NODE sg13_hv_nmos
+ L=0.6u W=4.4u AS=0p AD=0p PS=0u PD=0u rfmode=0
* device instance PAD03_IOVDD.I1.N0<63> r0 *1 0,0 sg13_hv_nmos
MPAD03_IOVDD.I1.N0<63> IOVSS PAD03_IOVDD.NET4 IOVDD SUBSTRATE_NODE sg13_hv_nmos
+ L=0.6u W=4.4u AS=0p AD=0p PS=0u PD=0u rfmode=0
* device instance PAD03_IOVDD.I1.N0<64> r0 *1 0,0 sg13_hv_nmos
MPAD03_IOVDD.I1.N0<64> IOVSS PAD03_IOVDD.NET4 IOVDD SUBSTRATE_NODE sg13_hv_nmos
+ L=0.6u W=4.4u AS=0p AD=0p PS=0u PD=0u rfmode=0
* device instance PAD03_IOVDD.I1.N0<65> r0 *1 0,0 sg13_hv_nmos
MPAD03_IOVDD.I1.N0<65> IOVSS PAD03_IOVDD.NET4 IOVDD SUBSTRATE_NODE sg13_hv_nmos
+ L=0.6u W=4.4u AS=0p AD=0p PS=0u PD=0u rfmode=0
* device instance PAD03_IOVDD.I1.N0<66> r0 *1 0,0 sg13_hv_nmos
MPAD03_IOVDD.I1.N0<66> IOVSS PAD03_IOVDD.NET4 IOVDD SUBSTRATE_NODE sg13_hv_nmos
+ L=0.6u W=4.4u AS=0p AD=0p PS=0u PD=0u rfmode=0
* device instance PAD03_IOVDD.I1.N0<67> r0 *1 0,0 sg13_hv_nmos
MPAD03_IOVDD.I1.N0<67> IOVSS PAD03_IOVDD.NET4 IOVDD SUBSTRATE_NODE sg13_hv_nmos
+ L=0.6u W=4.4u AS=0p AD=0p PS=0u PD=0u rfmode=0
* device instance PAD03_IOVDD.I1.N0<68> r0 *1 0,0 sg13_hv_nmos
MPAD03_IOVDD.I1.N0<68> IOVSS PAD03_IOVDD.NET4 IOVDD SUBSTRATE_NODE sg13_hv_nmos
+ L=0.6u W=4.4u AS=0p AD=0p PS=0u PD=0u rfmode=0
* device instance PAD03_IOVDD.I1.N0<69> r0 *1 0,0 sg13_hv_nmos
MPAD03_IOVDD.I1.N0<69> IOVSS PAD03_IOVDD.NET4 IOVDD SUBSTRATE_NODE sg13_hv_nmos
+ L=0.6u W=4.4u AS=0p AD=0p PS=0u PD=0u rfmode=0
* device instance PAD03_IOVDD.I1.N0<70> r0 *1 0,0 sg13_hv_nmos
MPAD03_IOVDD.I1.N0<70> IOVSS PAD03_IOVDD.NET4 IOVDD SUBSTRATE_NODE sg13_hv_nmos
+ L=0.6u W=4.4u AS=0p AD=0p PS=0u PD=0u rfmode=0
* device instance PAD03_IOVDD.I1.N0<71> r0 *1 0,0 sg13_hv_nmos
MPAD03_IOVDD.I1.N0<71> IOVSS PAD03_IOVDD.NET4 IOVDD SUBSTRATE_NODE sg13_hv_nmos
+ L=0.6u W=4.4u AS=0p AD=0p PS=0u PD=0u rfmode=0
* device instance PAD03_IOVDD.I1.N0<72> r0 *1 0,0 sg13_hv_nmos
MPAD03_IOVDD.I1.N0<72> IOVSS PAD03_IOVDD.NET4 IOVDD SUBSTRATE_NODE sg13_hv_nmos
+ L=0.6u W=4.4u AS=0p AD=0p PS=0u PD=0u rfmode=0
* device instance PAD03_IOVDD.I1.N0<73> r0 *1 0,0 sg13_hv_nmos
MPAD03_IOVDD.I1.N0<73> IOVSS PAD03_IOVDD.NET4 IOVDD SUBSTRATE_NODE sg13_hv_nmos
+ L=0.6u W=4.4u AS=0p AD=0p PS=0u PD=0u rfmode=0
* device instance PAD03_IOVDD.I1.N0<74> r0 *1 0,0 sg13_hv_nmos
MPAD03_IOVDD.I1.N0<74> IOVSS PAD03_IOVDD.NET4 IOVDD SUBSTRATE_NODE sg13_hv_nmos
+ L=0.6u W=4.4u AS=0p AD=0p PS=0u PD=0u rfmode=0
* device instance PAD03_IOVDD.I1.N0<75> r0 *1 0,0 sg13_hv_nmos
MPAD03_IOVDD.I1.N0<75> IOVSS PAD03_IOVDD.NET4 IOVDD SUBSTRATE_NODE sg13_hv_nmos
+ L=0.6u W=4.4u AS=0p AD=0p PS=0u PD=0u rfmode=0
* device instance PAD03_IOVDD.I1.N0<76> r0 *1 0,0 sg13_hv_nmos
MPAD03_IOVDD.I1.N0<76> IOVSS PAD03_IOVDD.NET4 IOVDD SUBSTRATE_NODE sg13_hv_nmos
+ L=0.6u W=4.4u AS=0p AD=0p PS=0u PD=0u rfmode=0
* device instance PAD03_IOVDD.I1.N0<77> r0 *1 0,0 sg13_hv_nmos
MPAD03_IOVDD.I1.N0<77> IOVSS PAD03_IOVDD.NET4 IOVDD SUBSTRATE_NODE sg13_hv_nmos
+ L=0.6u W=4.4u AS=0p AD=0p PS=0u PD=0u rfmode=0
* device instance PAD03_IOVDD.I1.N0<78> r0 *1 0,0 sg13_hv_nmos
MPAD03_IOVDD.I1.N0<78> IOVSS PAD03_IOVDD.NET4 IOVDD SUBSTRATE_NODE sg13_hv_nmos
+ L=0.6u W=4.4u AS=0p AD=0p PS=0u PD=0u rfmode=0
* device instance PAD03_IOVDD.I1.N0<79> r0 *1 0,0 sg13_hv_nmos
MPAD03_IOVDD.I1.N0<79> IOVSS PAD03_IOVDD.NET4 IOVDD SUBSTRATE_NODE sg13_hv_nmos
+ L=0.6u W=4.4u AS=0p AD=0p PS=0u PD=0u rfmode=0
* device instance PAD03_IOVDD.I1.N0<80> r0 *1 0,0 sg13_hv_nmos
MPAD03_IOVDD.I1.N0<80> IOVSS PAD03_IOVDD.NET4 IOVDD SUBSTRATE_NODE sg13_hv_nmos
+ L=0.6u W=4.4u AS=0p AD=0p PS=0u PD=0u rfmode=0
* device instance PAD03_IOVDD.I1.N0<81> r0 *1 0,0 sg13_hv_nmos
MPAD03_IOVDD.I1.N0<81> IOVSS PAD03_IOVDD.NET4 IOVDD SUBSTRATE_NODE sg13_hv_nmos
+ L=0.6u W=4.4u AS=0p AD=0p PS=0u PD=0u rfmode=0
* device instance PAD03_IOVDD.I1.N0<82> r0 *1 0,0 sg13_hv_nmos
MPAD03_IOVDD.I1.N0<82> IOVSS PAD03_IOVDD.NET4 IOVDD SUBSTRATE_NODE sg13_hv_nmos
+ L=0.6u W=4.4u AS=0p AD=0p PS=0u PD=0u rfmode=0
* device instance PAD03_IOVDD.I1.N0<83> r0 *1 0,0 sg13_hv_nmos
MPAD03_IOVDD.I1.N0<83> IOVSS PAD03_IOVDD.NET4 IOVDD SUBSTRATE_NODE sg13_hv_nmos
+ L=0.6u W=4.4u AS=0p AD=0p PS=0u PD=0u rfmode=0
* device instance PAD03_IOVDD.I1.N0<84> r0 *1 0,0 sg13_hv_nmos
MPAD03_IOVDD.I1.N0<84> IOVSS PAD03_IOVDD.NET4 IOVDD SUBSTRATE_NODE sg13_hv_nmos
+ L=0.6u W=4.4u AS=0p AD=0p PS=0u PD=0u rfmode=0
* device instance PAD03_IOVDD.I1.N0<85> r0 *1 0,0 sg13_hv_nmos
MPAD03_IOVDD.I1.N0<85> IOVSS PAD03_IOVDD.NET4 IOVDD SUBSTRATE_NODE sg13_hv_nmos
+ L=0.6u W=4.4u AS=0p AD=0p PS=0u PD=0u rfmode=0
* device instance PAD03_IOVDD.I1.N0<86> r0 *1 0,0 sg13_hv_nmos
MPAD03_IOVDD.I1.N0<86> IOVSS PAD03_IOVDD.NET4 IOVDD SUBSTRATE_NODE sg13_hv_nmos
+ L=0.6u W=4.4u AS=0p AD=0p PS=0u PD=0u rfmode=0
* device instance PAD03_IOVDD.I1.N0<87> r0 *1 0,0 sg13_hv_nmos
MPAD03_IOVDD.I1.N0<87> IOVSS PAD03_IOVDD.NET4 IOVDD SUBSTRATE_NODE sg13_hv_nmos
+ L=0.6u W=4.4u AS=0p AD=0p PS=0u PD=0u rfmode=0
* device instance PAD03_IOVDD.I1.N0<88> r0 *1 0,0 sg13_hv_nmos
MPAD03_IOVDD.I1.N0<88> IOVSS PAD03_IOVDD.NET4 IOVDD SUBSTRATE_NODE sg13_hv_nmos
+ L=0.6u W=4.4u AS=0p AD=0p PS=0u PD=0u rfmode=0
* device instance PAD03_IOVDD.I1.N0<89> r0 *1 0,0 sg13_hv_nmos
MPAD03_IOVDD.I1.N0<89> IOVSS PAD03_IOVDD.NET4 IOVDD SUBSTRATE_NODE sg13_hv_nmos
+ L=0.6u W=4.4u AS=0p AD=0p PS=0u PD=0u rfmode=0
* device instance PAD03_IOVDD.I1.N0<90> r0 *1 0,0 sg13_hv_nmos
MPAD03_IOVDD.I1.N0<90> IOVSS PAD03_IOVDD.NET4 IOVDD SUBSTRATE_NODE sg13_hv_nmos
+ L=0.6u W=4.4u AS=0p AD=0p PS=0u PD=0u rfmode=0
* device instance PAD03_IOVDD.I1.N0<91> r0 *1 0,0 sg13_hv_nmos
MPAD03_IOVDD.I1.N0<91> IOVSS PAD03_IOVDD.NET4 IOVDD SUBSTRATE_NODE sg13_hv_nmos
+ L=0.6u W=4.4u AS=0p AD=0p PS=0u PD=0u rfmode=0
* device instance PAD03_IOVDD.I1.N0<92> r0 *1 0,0 sg13_hv_nmos
MPAD03_IOVDD.I1.N0<92> IOVSS PAD03_IOVDD.NET4 IOVDD SUBSTRATE_NODE sg13_hv_nmos
+ L=0.6u W=4.4u AS=0p AD=0p PS=0u PD=0u rfmode=0
* device instance PAD03_IOVDD.I1.N0<93> r0 *1 0,0 sg13_hv_nmos
MPAD03_IOVDD.I1.N0<93> IOVSS PAD03_IOVDD.NET4 IOVDD SUBSTRATE_NODE sg13_hv_nmos
+ L=0.6u W=4.4u AS=0p AD=0p PS=0u PD=0u rfmode=0
* device instance PAD03_IOVDD.I1.N0<94> r0 *1 0,0 sg13_hv_nmos
MPAD03_IOVDD.I1.N0<94> IOVSS PAD03_IOVDD.NET4 IOVDD SUBSTRATE_NODE sg13_hv_nmos
+ L=0.6u W=4.4u AS=0p AD=0p PS=0u PD=0u rfmode=0
* device instance PAD03_IOVDD.I1.N0<95> r0 *1 0,0 sg13_hv_nmos
MPAD03_IOVDD.I1.N0<95> IOVSS PAD03_IOVDD.NET4 IOVDD SUBSTRATE_NODE sg13_hv_nmos
+ L=0.6u W=4.4u AS=0p AD=0p PS=0u PD=0u rfmode=0
* device instance PAD03_IOVDD.I1.N0<96> r0 *1 0,0 sg13_hv_nmos
MPAD03_IOVDD.I1.N0<96> IOVSS PAD03_IOVDD.NET4 IOVDD SUBSTRATE_NODE sg13_hv_nmos
+ L=0.6u W=4.4u AS=0p AD=0p PS=0u PD=0u rfmode=0
* device instance PAD03_IOVDD.I1.N0<97> r0 *1 0,0 sg13_hv_nmos
MPAD03_IOVDD.I1.N0<97> IOVSS PAD03_IOVDD.NET4 IOVDD SUBSTRATE_NODE sg13_hv_nmos
+ L=0.6u W=4.4u AS=0p AD=0p PS=0u PD=0u rfmode=0
* device instance PAD03_IOVDD.I1.N0<98> r0 *1 0,0 sg13_hv_nmos
MPAD03_IOVDD.I1.N0<98> IOVSS PAD03_IOVDD.NET4 IOVDD SUBSTRATE_NODE sg13_hv_nmos
+ L=0.6u W=4.4u AS=0p AD=0p PS=0u PD=0u rfmode=0
* device instance PAD03_IOVDD.I1.N0<99> r0 *1 0,0 sg13_hv_nmos
MPAD03_IOVDD.I1.N0<99> IOVSS PAD03_IOVDD.NET4 IOVDD SUBSTRATE_NODE sg13_hv_nmos
+ L=0.6u W=4.4u AS=0p AD=0p PS=0u PD=0u rfmode=0
* device instance PAD03_IOVDD.I1.N0<100> r0 *1 0,0 sg13_hv_nmos
MPAD03_IOVDD.I1.N0<100> IOVSS PAD03_IOVDD.NET4 IOVDD SUBSTRATE_NODE
+ sg13_hv_nmos L=0.6u W=4.4u AS=0p AD=0p PS=0u PD=0u rfmode=0
* device instance PAD03_IOVDD.I1.N0<101> r0 *1 0,0 sg13_hv_nmos
MPAD03_IOVDD.I1.N0<101> IOVSS PAD03_IOVDD.NET4 IOVDD SUBSTRATE_NODE
+ sg13_hv_nmos L=0.6u W=4.4u AS=0p AD=0p PS=0u PD=0u rfmode=0
* device instance PAD03_IOVDD.I1.N0<102> r0 *1 0,0 sg13_hv_nmos
MPAD03_IOVDD.I1.N0<102> IOVSS PAD03_IOVDD.NET4 IOVDD SUBSTRATE_NODE
+ sg13_hv_nmos L=0.6u W=4.4u AS=0p AD=0p PS=0u PD=0u rfmode=0
* device instance PAD03_IOVDD.I1.N0<103> r0 *1 0,0 sg13_hv_nmos
MPAD03_IOVDD.I1.N0<103> IOVSS PAD03_IOVDD.NET4 IOVDD SUBSTRATE_NODE
+ sg13_hv_nmos L=0.6u W=4.4u AS=0p AD=0p PS=0u PD=0u rfmode=0
* device instance PAD03_IOVDD.I1.N0<104> r0 *1 0,0 sg13_hv_nmos
MPAD03_IOVDD.I1.N0<104> IOVSS PAD03_IOVDD.NET4 IOVDD SUBSTRATE_NODE
+ sg13_hv_nmos L=0.6u W=4.4u AS=0p AD=0p PS=0u PD=0u rfmode=0
* device instance PAD03_IOVDD.I1.N0<105> r0 *1 0,0 sg13_hv_nmos
MPAD03_IOVDD.I1.N0<105> IOVSS PAD03_IOVDD.NET4 IOVDD SUBSTRATE_NODE
+ sg13_hv_nmos L=0.6u W=4.4u AS=0p AD=0p PS=0u PD=0u rfmode=0
* device instance PAD03_IOVDD.I1.N0<106> r0 *1 0,0 sg13_hv_nmos
MPAD03_IOVDD.I1.N0<106> IOVSS PAD03_IOVDD.NET4 IOVDD SUBSTRATE_NODE
+ sg13_hv_nmos L=0.6u W=4.4u AS=0p AD=0p PS=0u PD=0u rfmode=0
* device instance PAD03_IOVDD.I1.N0<107> r0 *1 0,0 sg13_hv_nmos
MPAD03_IOVDD.I1.N0<107> IOVSS PAD03_IOVDD.NET4 IOVDD SUBSTRATE_NODE
+ sg13_hv_nmos L=0.6u W=4.4u AS=0p AD=0p PS=0u PD=0u rfmode=0
* device instance PAD03_IOVDD.I1.N0<108> r0 *1 0,0 sg13_hv_nmos
MPAD03_IOVDD.I1.N0<108> IOVSS PAD03_IOVDD.NET4 IOVDD SUBSTRATE_NODE
+ sg13_hv_nmos L=0.6u W=4.4u AS=0p AD=0p PS=0u PD=0u rfmode=0
* device instance PAD03_IOVDD.I1.N0<109> r0 *1 0,0 sg13_hv_nmos
MPAD03_IOVDD.I1.N0<109> IOVSS PAD03_IOVDD.NET4 IOVDD SUBSTRATE_NODE
+ sg13_hv_nmos L=0.6u W=4.4u AS=0p AD=0p PS=0u PD=0u rfmode=0
* device instance PAD03_IOVDD.I1.N0<110> r0 *1 0,0 sg13_hv_nmos
MPAD03_IOVDD.I1.N0<110> IOVSS PAD03_IOVDD.NET4 IOVDD SUBSTRATE_NODE
+ sg13_hv_nmos L=0.6u W=4.4u AS=0p AD=0p PS=0u PD=0u rfmode=0
* device instance PAD03_IOVDD.I1.N0<111> r0 *1 0,0 sg13_hv_nmos
MPAD03_IOVDD.I1.N0<111> IOVSS PAD03_IOVDD.NET4 IOVDD SUBSTRATE_NODE
+ sg13_hv_nmos L=0.6u W=4.4u AS=0p AD=0p PS=0u PD=0u rfmode=0
* device instance PAD03_IOVDD.I1.N0<112> r0 *1 0,0 sg13_hv_nmos
MPAD03_IOVDD.I1.N0<112> IOVSS PAD03_IOVDD.NET4 IOVDD SUBSTRATE_NODE
+ sg13_hv_nmos L=0.6u W=4.4u AS=0p AD=0p PS=0u PD=0u rfmode=0
* device instance PAD03_IOVDD.I1.N0<113> r0 *1 0,0 sg13_hv_nmos
MPAD03_IOVDD.I1.N0<113> IOVSS PAD03_IOVDD.NET4 IOVDD SUBSTRATE_NODE
+ sg13_hv_nmos L=0.6u W=4.4u AS=0p AD=0p PS=0u PD=0u rfmode=0
* device instance PAD03_IOVDD.I1.N0<114> r0 *1 0,0 sg13_hv_nmos
MPAD03_IOVDD.I1.N0<114> IOVSS PAD03_IOVDD.NET4 IOVDD SUBSTRATE_NODE
+ sg13_hv_nmos L=0.6u W=4.4u AS=0p AD=0p PS=0u PD=0u rfmode=0
* device instance PAD03_IOVDD.I1.N0<115> r0 *1 0,0 sg13_hv_nmos
MPAD03_IOVDD.I1.N0<115> IOVSS PAD03_IOVDD.NET4 IOVDD SUBSTRATE_NODE
+ sg13_hv_nmos L=0.6u W=4.4u AS=0p AD=0p PS=0u PD=0u rfmode=0
* device instance PAD03_IOVDD.I1.N0<116> r0 *1 0,0 sg13_hv_nmos
MPAD03_IOVDD.I1.N0<116> IOVSS PAD03_IOVDD.NET4 IOVDD SUBSTRATE_NODE
+ sg13_hv_nmos L=0.6u W=4.4u AS=0p AD=0p PS=0u PD=0u rfmode=0
* device instance PAD03_IOVDD.I1.N0<117> r0 *1 0,0 sg13_hv_nmos
MPAD03_IOVDD.I1.N0<117> IOVSS PAD03_IOVDD.NET4 IOVDD SUBSTRATE_NODE
+ sg13_hv_nmos L=0.6u W=4.4u AS=0p AD=0p PS=0u PD=0u rfmode=0
* device instance PAD03_IOVDD.I1.N0<118> r0 *1 0,0 sg13_hv_nmos
MPAD03_IOVDD.I1.N0<118> IOVSS PAD03_IOVDD.NET4 IOVDD SUBSTRATE_NODE
+ sg13_hv_nmos L=0.6u W=4.4u AS=0p AD=0p PS=0u PD=0u rfmode=0
* device instance PAD03_IOVDD.I1.N0<119> r0 *1 0,0 sg13_hv_nmos
MPAD03_IOVDD.I1.N0<119> IOVSS PAD03_IOVDD.NET4 IOVDD SUBSTRATE_NODE
+ sg13_hv_nmos L=0.6u W=4.4u AS=0p AD=0p PS=0u PD=0u rfmode=0
* device instance PAD03_IOVDD.I1.N0<120> r0 *1 0,0 sg13_hv_nmos
MPAD03_IOVDD.I1.N0<120> IOVSS PAD03_IOVDD.NET4 IOVDD SUBSTRATE_NODE
+ sg13_hv_nmos L=0.6u W=4.4u AS=0p AD=0p PS=0u PD=0u rfmode=0
* device instance PAD03_IOVDD.I1.N0<121> r0 *1 0,0 sg13_hv_nmos
MPAD03_IOVDD.I1.N0<121> IOVSS PAD03_IOVDD.NET4 IOVDD SUBSTRATE_NODE
+ sg13_hv_nmos L=0.6u W=4.4u AS=0p AD=0p PS=0u PD=0u rfmode=0
* device instance PAD03_IOVDD.I1.N0<122> r0 *1 0,0 sg13_hv_nmos
MPAD03_IOVDD.I1.N0<122> IOVSS PAD03_IOVDD.NET4 IOVDD SUBSTRATE_NODE
+ sg13_hv_nmos L=0.6u W=4.4u AS=0p AD=0p PS=0u PD=0u rfmode=0
* device instance PAD03_IOVDD.I1.N0<123> r0 *1 0,0 sg13_hv_nmos
MPAD03_IOVDD.I1.N0<123> IOVSS PAD03_IOVDD.NET4 IOVDD SUBSTRATE_NODE
+ sg13_hv_nmos L=0.6u W=4.4u AS=0p AD=0p PS=0u PD=0u rfmode=0
* device instance PAD03_IOVDD.I1.N0<124> r0 *1 0,0 sg13_hv_nmos
MPAD03_IOVDD.I1.N0<124> IOVSS PAD03_IOVDD.NET4 IOVDD SUBSTRATE_NODE
+ sg13_hv_nmos L=0.6u W=4.4u AS=0p AD=0p PS=0u PD=0u rfmode=0
* device instance PAD03_IOVDD.I1.N0<125> r0 *1 0,0 sg13_hv_nmos
MPAD03_IOVDD.I1.N0<125> IOVSS PAD03_IOVDD.NET4 IOVDD SUBSTRATE_NODE
+ sg13_hv_nmos L=0.6u W=4.4u AS=0p AD=0p PS=0u PD=0u rfmode=0
* device instance PAD03_IOVDD.I1.N0<126> r0 *1 0,0 sg13_hv_nmos
MPAD03_IOVDD.I1.N0<126> IOVSS PAD03_IOVDD.NET4 IOVDD SUBSTRATE_NODE
+ sg13_hv_nmos L=0.6u W=4.4u AS=0p AD=0p PS=0u PD=0u rfmode=0
* device instance PAD03_IOVDD.I1.N0<127> r0 *1 0,0 sg13_hv_nmos
MPAD03_IOVDD.I1.N0<127> IOVSS PAD03_IOVDD.NET4 IOVDD SUBSTRATE_NODE
+ sg13_hv_nmos L=0.6u W=4.4u AS=0p AD=0p PS=0u PD=0u rfmode=0
* device instance PAD03_IOVDD.I1.N0<128> r0 *1 0,0 sg13_hv_nmos
MPAD03_IOVDD.I1.N0<128> IOVSS PAD03_IOVDD.NET4 IOVDD SUBSTRATE_NODE
+ sg13_hv_nmos L=0.6u W=4.4u AS=0p AD=0p PS=0u PD=0u rfmode=0
* device instance PAD03_IOVDD.I1.N0<129> r0 *1 0,0 sg13_hv_nmos
MPAD03_IOVDD.I1.N0<129> IOVSS PAD03_IOVDD.NET4 IOVDD SUBSTRATE_NODE
+ sg13_hv_nmos L=0.6u W=4.4u AS=0p AD=0p PS=0u PD=0u rfmode=0
* device instance PAD03_IOVDD.I1.N0<130> r0 *1 0,0 sg13_hv_nmos
MPAD03_IOVDD.I1.N0<130> IOVSS PAD03_IOVDD.NET4 IOVDD SUBSTRATE_NODE
+ sg13_hv_nmos L=0.6u W=4.4u AS=0p AD=0p PS=0u PD=0u rfmode=0
* device instance PAD03_IOVDD.I1.N0<131> r0 *1 0,0 sg13_hv_nmos
MPAD03_IOVDD.I1.N0<131> IOVSS PAD03_IOVDD.NET4 IOVDD SUBSTRATE_NODE
+ sg13_hv_nmos L=0.6u W=4.4u AS=0p AD=0p PS=0u PD=0u rfmode=0
* device instance PAD03_IOVDD.I1.N0<132> r0 *1 0,0 sg13_hv_nmos
MPAD03_IOVDD.I1.N0<132> IOVSS PAD03_IOVDD.NET4 IOVDD SUBSTRATE_NODE
+ sg13_hv_nmos L=0.6u W=4.4u AS=0p AD=0p PS=0u PD=0u rfmode=0
* device instance PAD03_IOVDD.I1.N0<133> r0 *1 0,0 sg13_hv_nmos
MPAD03_IOVDD.I1.N0<133> IOVSS PAD03_IOVDD.NET4 IOVDD SUBSTRATE_NODE
+ sg13_hv_nmos L=0.6u W=4.4u AS=0p AD=0p PS=0u PD=0u rfmode=0
* device instance PAD03_IOVDD.I1.N0<134> r0 *1 0,0 sg13_hv_nmos
MPAD03_IOVDD.I1.N0<134> IOVSS PAD03_IOVDD.NET4 IOVDD SUBSTRATE_NODE
+ sg13_hv_nmos L=0.6u W=4.4u AS=0p AD=0p PS=0u PD=0u rfmode=0
* device instance PAD03_IOVDD.I1.N0<135> r0 *1 0,0 sg13_hv_nmos
MPAD03_IOVDD.I1.N0<135> IOVSS PAD03_IOVDD.NET4 IOVDD SUBSTRATE_NODE
+ sg13_hv_nmos L=0.6u W=4.4u AS=0p AD=0p PS=0u PD=0u rfmode=0
* device instance PAD03_IOVDD.I1.N0<136> r0 *1 0,0 sg13_hv_nmos
MPAD03_IOVDD.I1.N0<136> IOVSS PAD03_IOVDD.NET4 IOVDD SUBSTRATE_NODE
+ sg13_hv_nmos L=0.6u W=4.4u AS=0p AD=0p PS=0u PD=0u rfmode=0
* device instance PAD03_IOVDD.I1.N0<137> r0 *1 0,0 sg13_hv_nmos
MPAD03_IOVDD.I1.N0<137> IOVSS PAD03_IOVDD.NET4 IOVDD SUBSTRATE_NODE
+ sg13_hv_nmos L=0.6u W=4.4u AS=0p AD=0p PS=0u PD=0u rfmode=0
* device instance PAD03_IOVDD.I1.N0<138> r0 *1 0,0 sg13_hv_nmos
MPAD03_IOVDD.I1.N0<138> IOVSS PAD03_IOVDD.NET4 IOVDD SUBSTRATE_NODE
+ sg13_hv_nmos L=0.6u W=4.4u AS=0p AD=0p PS=0u PD=0u rfmode=0
* device instance PAD03_IOVDD.I1.N0<139> r0 *1 0,0 sg13_hv_nmos
MPAD03_IOVDD.I1.N0<139> IOVSS PAD03_IOVDD.NET4 IOVDD SUBSTRATE_NODE
+ sg13_hv_nmos L=0.6u W=4.4u AS=0p AD=0p PS=0u PD=0u rfmode=0
* device instance PAD03_IOVDD.I1.N0<140> r0 *1 0,0 sg13_hv_nmos
MPAD03_IOVDD.I1.N0<140> IOVSS PAD03_IOVDD.NET4 IOVDD SUBSTRATE_NODE
+ sg13_hv_nmos L=0.6u W=4.4u AS=0p AD=0p PS=0u PD=0u rfmode=0
* device instance PAD03_IOVDD.I1.N0<141> r0 *1 0,0 sg13_hv_nmos
MPAD03_IOVDD.I1.N0<141> IOVSS PAD03_IOVDD.NET4 IOVDD SUBSTRATE_NODE
+ sg13_hv_nmos L=0.6u W=4.4u AS=0p AD=0p PS=0u PD=0u rfmode=0
* device instance PAD03_IOVDD.I1.N0<142> r0 *1 0,0 sg13_hv_nmos
MPAD03_IOVDD.I1.N0<142> IOVSS PAD03_IOVDD.NET4 IOVDD SUBSTRATE_NODE
+ sg13_hv_nmos L=0.6u W=4.4u AS=0p AD=0p PS=0u PD=0u rfmode=0
* device instance PAD03_IOVDD.I1.N0<143> r0 *1 0,0 sg13_hv_nmos
MPAD03_IOVDD.I1.N0<143> IOVSS PAD03_IOVDD.NET4 IOVDD SUBSTRATE_NODE
+ sg13_hv_nmos L=0.6u W=4.4u AS=0p AD=0p PS=0u PD=0u rfmode=0
* device instance PAD03_IOVDD.I1.N0<144> r0 *1 0,0 sg13_hv_nmos
MPAD03_IOVDD.I1.N0<144> IOVSS PAD03_IOVDD.NET4 IOVDD SUBSTRATE_NODE
+ sg13_hv_nmos L=0.6u W=4.4u AS=0p AD=0p PS=0u PD=0u rfmode=0
* device instance PAD03_IOVDD.I1.N0<145> r0 *1 0,0 sg13_hv_nmos
MPAD03_IOVDD.I1.N0<145> IOVSS PAD03_IOVDD.NET4 IOVDD SUBSTRATE_NODE
+ sg13_hv_nmos L=0.6u W=4.4u AS=0p AD=0p PS=0u PD=0u rfmode=0
* device instance PAD03_IOVDD.I1.N0<146> r0 *1 0,0 sg13_hv_nmos
MPAD03_IOVDD.I1.N0<146> IOVSS PAD03_IOVDD.NET4 IOVDD SUBSTRATE_NODE
+ sg13_hv_nmos L=0.6u W=4.4u AS=0p AD=0p PS=0u PD=0u rfmode=0
* device instance PAD03_IOVDD.I1.N0<147> r0 *1 0,0 sg13_hv_nmos
MPAD03_IOVDD.I1.N0<147> IOVSS PAD03_IOVDD.NET4 IOVDD SUBSTRATE_NODE
+ sg13_hv_nmos L=0.6u W=4.4u AS=0p AD=0p PS=0u PD=0u rfmode=0
* device instance PAD03_IOVDD.I1.N0<148> r0 *1 0,0 sg13_hv_nmos
MPAD03_IOVDD.I1.N0<148> IOVSS PAD03_IOVDD.NET4 IOVDD SUBSTRATE_NODE
+ sg13_hv_nmos L=0.6u W=4.4u AS=0p AD=0p PS=0u PD=0u rfmode=0
* device instance PAD03_IOVDD.I1.N0<149> r0 *1 0,0 sg13_hv_nmos
MPAD03_IOVDD.I1.N0<149> IOVSS PAD03_IOVDD.NET4 IOVDD SUBSTRATE_NODE
+ sg13_hv_nmos L=0.6u W=4.4u AS=0p AD=0p PS=0u PD=0u rfmode=0
* device instance PAD03_IOVDD.I1.N0<150> r0 *1 0,0 sg13_hv_nmos
MPAD03_IOVDD.I1.N0<150> IOVSS PAD03_IOVDD.NET4 IOVDD SUBSTRATE_NODE
+ sg13_hv_nmos L=0.6u W=4.4u AS=0p AD=0p PS=0u PD=0u rfmode=0
* device instance PAD03_IOVDD.I1.N0<151> r0 *1 0,0 sg13_hv_nmos
MPAD03_IOVDD.I1.N0<151> IOVSS PAD03_IOVDD.NET4 IOVDD SUBSTRATE_NODE
+ sg13_hv_nmos L=0.6u W=4.4u AS=0p AD=0p PS=0u PD=0u rfmode=0
* device instance PAD03_IOVDD.I1.N0<152> r0 *1 0,0 sg13_hv_nmos
MPAD03_IOVDD.I1.N0<152> IOVSS PAD03_IOVDD.NET4 IOVDD SUBSTRATE_NODE
+ sg13_hv_nmos L=0.6u W=4.4u AS=0p AD=0p PS=0u PD=0u rfmode=0
* device instance PAD03_IOVDD.I1.N0<153> r0 *1 0,0 sg13_hv_nmos
MPAD03_IOVDD.I1.N0<153> IOVSS PAD03_IOVDD.NET4 IOVDD SUBSTRATE_NODE
+ sg13_hv_nmos L=0.6u W=4.4u AS=0p AD=0p PS=0u PD=0u rfmode=0
* device instance PAD03_IOVDD.I1.N0<154> r0 *1 0,0 sg13_hv_nmos
MPAD03_IOVDD.I1.N0<154> IOVSS PAD03_IOVDD.NET4 IOVDD SUBSTRATE_NODE
+ sg13_hv_nmos L=0.6u W=4.4u AS=0p AD=0p PS=0u PD=0u rfmode=0
* device instance PAD03_IOVDD.I1.N0<155> r0 *1 0,0 sg13_hv_nmos
MPAD03_IOVDD.I1.N0<155> IOVSS PAD03_IOVDD.NET4 IOVDD SUBSTRATE_NODE
+ sg13_hv_nmos L=0.6u W=4.4u AS=0p AD=0p PS=0u PD=0u rfmode=0
* device instance PAD03_IOVDD.I1.N0<156> r0 *1 0,0 sg13_hv_nmos
MPAD03_IOVDD.I1.N0<156> IOVSS PAD03_IOVDD.NET4 IOVDD SUBSTRATE_NODE
+ sg13_hv_nmos L=0.6u W=4.4u AS=0p AD=0p PS=0u PD=0u rfmode=0
* device instance PAD03_IOVDD.I1.N0<157> r0 *1 0,0 sg13_hv_nmos
MPAD03_IOVDD.I1.N0<157> IOVSS PAD03_IOVDD.NET4 IOVDD SUBSTRATE_NODE
+ sg13_hv_nmos L=0.6u W=4.4u AS=0p AD=0p PS=0u PD=0u rfmode=0
* device instance PAD03_IOVDD.I1.N0<158> r0 *1 0,0 sg13_hv_nmos
MPAD03_IOVDD.I1.N0<158> IOVSS PAD03_IOVDD.NET4 IOVDD SUBSTRATE_NODE
+ sg13_hv_nmos L=0.6u W=4.4u AS=0p AD=0p PS=0u PD=0u rfmode=0
* device instance PAD03_IOVDD.I1.N0<159> r0 *1 0,0 sg13_hv_nmos
MPAD03_IOVDD.I1.N0<159> IOVSS PAD03_IOVDD.NET4 IOVDD SUBSTRATE_NODE
+ sg13_hv_nmos L=0.6u W=4.4u AS=0p AD=0p PS=0u PD=0u rfmode=0
* device instance PAD03_IOVDD.I1.N0<160> r0 *1 0,0 sg13_hv_nmos
MPAD03_IOVDD.I1.N0<160> IOVSS PAD03_IOVDD.NET4 IOVDD SUBSTRATE_NODE
+ sg13_hv_nmos L=0.6u W=4.4u AS=0p AD=0p PS=0u PD=0u rfmode=0
* device instance PAD03_IOVDD.I1.N0<161> r0 *1 0,0 sg13_hv_nmos
MPAD03_IOVDD.I1.N0<161> IOVSS PAD03_IOVDD.NET4 IOVDD SUBSTRATE_NODE
+ sg13_hv_nmos L=0.6u W=4.4u AS=0p AD=0p PS=0u PD=0u rfmode=0
* device instance PAD03_IOVDD.I1.N0<162> r0 *1 0,0 sg13_hv_nmos
MPAD03_IOVDD.I1.N0<162> IOVSS PAD03_IOVDD.NET4 IOVDD SUBSTRATE_NODE
+ sg13_hv_nmos L=0.6u W=4.4u AS=0p AD=0p PS=0u PD=0u rfmode=0
* device instance PAD03_IOVDD.I1.N0<163> r0 *1 0,0 sg13_hv_nmos
MPAD03_IOVDD.I1.N0<163> IOVSS PAD03_IOVDD.NET4 IOVDD SUBSTRATE_NODE
+ sg13_hv_nmos L=0.6u W=4.4u AS=0p AD=0p PS=0u PD=0u rfmode=0
* device instance PAD03_IOVDD.I1.N0<164> r0 *1 0,0 sg13_hv_nmos
MPAD03_IOVDD.I1.N0<164> IOVSS PAD03_IOVDD.NET4 IOVDD SUBSTRATE_NODE
+ sg13_hv_nmos L=0.6u W=4.4u AS=0p AD=0p PS=0u PD=0u rfmode=0
* device instance PAD03_IOVDD.I1.N0<165> r0 *1 0,0 sg13_hv_nmos
MPAD03_IOVDD.I1.N0<165> IOVSS PAD03_IOVDD.NET4 IOVDD SUBSTRATE_NODE
+ sg13_hv_nmos L=0.6u W=4.4u AS=0p AD=0p PS=0u PD=0u rfmode=0
* device instance PAD03_IOVDD.I1.N0<166> r0 *1 0,0 sg13_hv_nmos
MPAD03_IOVDD.I1.N0<166> IOVSS PAD03_IOVDD.NET4 IOVDD SUBSTRATE_NODE
+ sg13_hv_nmos L=0.6u W=4.4u AS=0p AD=0p PS=0u PD=0u rfmode=0
* device instance PAD03_IOVDD.I1.N0<167> r0 *1 0,0 sg13_hv_nmos
MPAD03_IOVDD.I1.N0<167> IOVSS PAD03_IOVDD.NET4 IOVDD SUBSTRATE_NODE
+ sg13_hv_nmos L=0.6u W=4.4u AS=0p AD=0p PS=0u PD=0u rfmode=0
* device instance PAD03_IOVDD.I1.N0<168> r0 *1 0,0 sg13_hv_nmos
MPAD03_IOVDD.I1.N0<168> IOVSS PAD03_IOVDD.NET4 IOVDD SUBSTRATE_NODE
+ sg13_hv_nmos L=0.6u W=4.4u AS=0p AD=0p PS=0u PD=0u rfmode=0
* device instance PAD03_IOVDD.I1.N0<169> r0 *1 0,0 sg13_hv_nmos
MPAD03_IOVDD.I1.N0<169> IOVSS PAD03_IOVDD.NET4 IOVDD SUBSTRATE_NODE
+ sg13_hv_nmos L=0.6u W=4.4u AS=0p AD=0p PS=0u PD=0u rfmode=0
* device instance PAD03_IOVDD.I1.N0<170> r0 *1 0,0 sg13_hv_nmos
MPAD03_IOVDD.I1.N0<170> IOVSS PAD03_IOVDD.NET4 IOVDD SUBSTRATE_NODE
+ sg13_hv_nmos L=0.6u W=4.4u AS=0p AD=0p PS=0u PD=0u rfmode=0
* device instance PAD03_IOVDD.I1.N0<171> r0 *1 0,0 sg13_hv_nmos
MPAD03_IOVDD.I1.N0<171> IOVSS PAD03_IOVDD.NET4 IOVDD SUBSTRATE_NODE
+ sg13_hv_nmos L=0.6u W=4.4u AS=0p AD=0p PS=0u PD=0u rfmode=0
* device instance PAD03_IOVDD.I1.N0<172> r0 *1 0,0 sg13_hv_nmos
MPAD03_IOVDD.I1.N0<172> IOVSS PAD03_IOVDD.NET4 IOVDD SUBSTRATE_NODE
+ sg13_hv_nmos L=0.6u W=4.4u AS=0p AD=0p PS=0u PD=0u rfmode=0
* device instance PAD03_IOVDD.I1._G1_TAP_SYNTAX_XR0 r0 *1 0,0 PTAP1
R399PAD03_IOVDD.I1._G1_TAP_SYNTAX_XR0 IOVSS SUBSTRATE_NODE PTAP1 A=65.6472p
+ P=386.16u
* device instance PAD03_IOVDD.I1.D0 r0 *1 0,0 DANTENNA
D400PAD03_IOVDD.I1.D0 SUBSTRATE_NODE PAD03_IOVDD.NET4 DANTENNA A=0.2304p P=1.92u
+ m=1
* device instance PAD03_IOVDD.I3.R15 r0 *1 0,0 RPPD
R401PAD03_IOVDD.I3.R15 PAD03_IOVDD.I3.NET15 PAD03_IOVDD.I3.NET16 SUBSTRATE_NODE
+ RPPD w=1u l=20u ps=0u b=0 m=1
* device instance PAD03_IOVDD.I3.R20 r0 *1 0,0 RPPD
R402PAD03_IOVDD.I3.R20 PAD03_IOVDD.I3.NET20 PAD03_IOVDD.I3.NET21 SUBSTRATE_NODE
+ RPPD w=1u l=20u ps=0u b=0 m=1
* device instance PAD03_IOVDD.I3.R23 r0 *1 0,0 RPPD
R403PAD03_IOVDD.I3.R23 PAD03_IOVDD.I3.NET23 PAD03_IOVDD.I3.NET24 SUBSTRATE_NODE
+ RPPD w=1u l=20u ps=0u b=0 m=1
* device instance PAD03_IOVDD.I3.R17 r0 *1 0,0 RPPD
R404PAD03_IOVDD.I3.R17 PAD03_IOVDD.I3.NET17 PAD03_IOVDD.I3.NET18 SUBSTRATE_NODE
+ RPPD w=1u l=20u ps=0u b=0 m=1
* device instance PAD03_IOVDD.I3.R16 r0 *1 0,0 RPPD
R405PAD03_IOVDD.I3.R16 PAD03_IOVDD.I3.NET16 PAD03_IOVDD.I3.NET17 SUBSTRATE_NODE
+ RPPD w=1u l=20u ps=0u b=0 m=1
* device instance PAD03_IOVDD.I3.R25 r0 *1 0,0 RPPD
R406PAD03_IOVDD.I3.R25 PAD03_IOVDD.I3.NET25 PAD03_IOVDD.NET1 SUBSTRATE_NODE RPPD
+ w=1u l=20u ps=0u b=0 m=1
* device instance PAD03_IOVDD.I3.R22 r0 *1 0,0 RPPD
R407PAD03_IOVDD.I3.R22 PAD03_IOVDD.I3.NET22 PAD03_IOVDD.I3.NET23 SUBSTRATE_NODE
+ RPPD w=1u l=20u ps=0u b=0 m=1
* device instance PAD03_IOVDD.I3.R19 r0 *1 0,0 RPPD
R408PAD03_IOVDD.I3.R19 PAD03_IOVDD.I3.NET19 PAD03_IOVDD.I3.NET20 SUBSTRATE_NODE
+ RPPD w=1u l=20u ps=0u b=0 m=1
* device instance PAD03_IOVDD.I3.R24 r0 *1 0,0 RPPD
R409PAD03_IOVDD.I3.R24 PAD03_IOVDD.I3.NET24 PAD03_IOVDD.I3.NET25 SUBSTRATE_NODE
+ RPPD w=1u l=20u ps=0u b=0 m=1
* device instance PAD03_IOVDD.I3.R21 r0 *1 0,0 RPPD
R410PAD03_IOVDD.I3.R21 PAD03_IOVDD.I3.NET21 PAD03_IOVDD.I3.NET22 SUBSTRATE_NODE
+ RPPD w=1u l=20u ps=0u b=0 m=1
* device instance PAD03_IOVDD.I3.R18 r0 *1 0,0 RPPD
R411PAD03_IOVDD.I3.R18 PAD03_IOVDD.I3.NET18 PAD03_IOVDD.I3.NET19 SUBSTRATE_NODE
+ RPPD w=1u l=20u ps=0u b=0 m=1
* device instance PAD03_IOVDD.I3.R5 r0 *1 0,0 RPPD
R412PAD03_IOVDD.I3.R5 PAD03_IOVDD.I3.NET5 PAD03_IOVDD.I3.NET6 SUBSTRATE_NODE
+ RPPD w=1u l=20u ps=0u b=0 m=1
* device instance PAD03_IOVDD.I3.R8 r0 *1 0,0 RPPD
R413PAD03_IOVDD.I3.R8 PAD03_IOVDD.I3.NET8 PAD03_IOVDD.I3.NET9 SUBSTRATE_NODE
+ RPPD w=1u l=20u ps=0u b=0 m=1
* device instance PAD03_IOVDD.I3.R11 r0 *1 0,0 RPPD
R414PAD03_IOVDD.I3.R11 PAD03_IOVDD.I3.NET11 PAD03_IOVDD.I3.NET12 SUBSTRATE_NODE
+ RPPD w=1u l=20u ps=0u b=0 m=1
* device instance PAD03_IOVDD.I3.R14 r0 *1 0,0 RPPD
R415PAD03_IOVDD.I3.R14 PAD03_IOVDD.I3.NET14 PAD03_IOVDD.I3.NET15 SUBSTRATE_NODE
+ RPPD w=1u l=20u ps=0u b=0 m=1
* device instance PAD03_IOVDD.I3.R2 r0 *1 0,0 RPPD
R416PAD03_IOVDD.I3.R2 PAD03_IOVDD.I3.NET2 PAD03_IOVDD.I3.NET3 SUBSTRATE_NODE
+ RPPD w=1u l=20u ps=0u b=0 m=1
* device instance PAD03_IOVDD.I3.R1 r0 *1 0,0 RPPD
R417PAD03_IOVDD.I3.R1 PAD03_IOVDD.I3.NET1 PAD03_IOVDD.I3.NET2 SUBSTRATE_NODE
+ RPPD w=1u l=20u ps=0u b=0 m=1
* device instance PAD03_IOVDD.I3.R13 r0 *1 0,0 RPPD
R418PAD03_IOVDD.I3.R13 PAD03_IOVDD.I3.NET13 PAD03_IOVDD.I3.NET14 SUBSTRATE_NODE
+ RPPD w=1u l=20u ps=0u b=0 m=1
* device instance PAD03_IOVDD.I3.R10 r0 *1 0,0 RPPD
R419PAD03_IOVDD.I3.R10 PAD03_IOVDD.I3.NET10 PAD03_IOVDD.I3.NET11 SUBSTRATE_NODE
+ RPPD w=1u l=20u ps=0u b=0 m=1
* device instance PAD03_IOVDD.I3.R7 r0 *1 0,0 RPPD
R420PAD03_IOVDD.I3.R7 PAD03_IOVDD.I3.NET7 PAD03_IOVDD.I3.NET8 SUBSTRATE_NODE
+ RPPD w=1u l=20u ps=0u b=0 m=1
* device instance PAD03_IOVDD.I3.R4 r0 *1 0,0 RPPD
R421PAD03_IOVDD.I3.R4 PAD03_IOVDD.I3.NET4 PAD03_IOVDD.I3.NET5 SUBSTRATE_NODE
+ RPPD w=1u l=20u ps=0u b=0 m=1
* device instance PAD03_IOVDD.I3.R12 r0 *1 0,0 RPPD
R422PAD03_IOVDD.I3.R12 PAD03_IOVDD.I3.NET12 PAD03_IOVDD.I3.NET13 SUBSTRATE_NODE
+ RPPD w=1u l=20u ps=0u b=0 m=1
* device instance PAD03_IOVDD.I3.R9 r0 *1 0,0 RPPD
R423PAD03_IOVDD.I3.R9 PAD03_IOVDD.I3.NET9 PAD03_IOVDD.I3.NET10 SUBSTRATE_NODE
+ RPPD w=1u l=20u ps=0u b=0 m=1
* device instance PAD03_IOVDD.I3.R6 r0 *1 0,0 RPPD
R424PAD03_IOVDD.I3.R6 PAD03_IOVDD.I3.NET6 PAD03_IOVDD.I3.NET7 SUBSTRATE_NODE
+ RPPD w=1u l=20u ps=0u b=0 m=1
* device instance PAD03_IOVDD.I3.R3 r0 *1 0,0 RPPD
R425PAD03_IOVDD.I3.R3 PAD03_IOVDD.I3.NET3 PAD03_IOVDD.I3.NET4 SUBSTRATE_NODE
+ RPPD w=1u l=20u ps=0u b=0 m=1
* device instance PAD03_IOVDD.I3.R0 r0 *1 0,0 RPPD
R426PAD03_IOVDD.I3.R0 IOVDD PAD03_IOVDD.I3.NET1 SUBSTRATE_NODE RPPD w=1u l=20u
+ ps=0u b=0 m=1
* device instance PAD03_IOVDD.I2.N1 r0 *1 0,0 sg13_hv_nmos
MPAD03_IOVDD.I2.N1 IOVSS PAD03_IOVDD.NET1 IOVSS SUBSTRATE_NODE sg13_hv_nmos
+ L=9.5u W=63u AS=0p AD=0p PS=0u PD=0u rfmode=0
* device instance PAD03_IOVDD.I2.N3 r0 *1 0,0 sg13_hv_nmos
MPAD03_IOVDD.I2.N3 IOVSS PAD03_IOVDD.NET1 PAD03_IOVDD.NET4 SUBSTRATE_NODE
+ sg13_hv_nmos L=0.5u W=54u AS=0p AD=0p PS=0u PD=0u rfmode=0
* device instance PAD03_IOVDD.I2.N0 r0 *1 0,0 sg13_hv_nmos
MPAD03_IOVDD.I2.N0 IOVSS PAD03_IOVDD.NET1 IOVSS SUBSTRATE_NODE sg13_hv_nmos
+ L=9.5u W=63u AS=0p AD=0p PS=0u PD=0u rfmode=0
* device instance PAD03_IOVDD.I2.N2 r0 *1 0,0 sg13_hv_nmos
MPAD03_IOVDD.I2.N2 IOVSS PAD03_IOVDD.NET1 PAD03_IOVDD.NET4 SUBSTRATE_NODE
+ sg13_hv_nmos L=0.5u W=54u AS=0p AD=0p PS=0u PD=0u rfmode=0
* device instance PAD03_IOVDD.I2._G1_TAP_SYNTAX_XR0 r0 *1 0,0 PTAP1
R431PAD03_IOVDD.I2._G1_TAP_SYNTAX_XR0 IOVSS SUBSTRATE_NODE PTAP1 A=69.122p
+ P=406.6u
* device instance PAD03_IOVDD.I2.P0 r0 *1 0,0 sg13_hv_pmos
MPAD03_IOVDD.I2.P0 IOVDD PAD03_IOVDD.NET1 PAD03_IOVDD.NET4 IOVDD sg13_hv_pmos
+ L=0.5u W=350u AS=0p AD=0p PS=0u PD=0u rfmode=0
* device instance PAD04_IOVSS._G1_TAP_SYNTAX_XR1 r0 *1 0,0 PTAP1
R433PAD04_IOVSS._G1_TAP_SYNTAX_XR1 VSS SUBSTRATE_NODE PTAP1 A=24p P=160.6u
* device instance PAD04_IOVSS._G1_TAP_SYNTAX_XR0 r0 *1 0,0 PTAP1
R434PAD04_IOVSS._G1_TAP_SYNTAX_XR0 IOVSS SUBSTRATE_NODE PTAP1 A=5379.0466p
+ P=677.04u
* device instance PAD04_IOVSS.I3.D1 r0 *1 0,0 DANTENNA
D435PAD04_IOVSS.I3.D1 SUBSTRATE_NODE IOVSS DANTENNA A=35.003p P=58.08u m=1
* device instance PAD04_IOVSS.I3.D0 r0 *1 0,0 DANTENNA
D436PAD04_IOVSS.I3.D0 SUBSTRATE_NODE IOVSS DANTENNA A=35.003p P=58.08u m=1
* device instance PAD04_IOVSS.I3._G1_TAP_SYNTAX_XR0 r0 *1 0,0 PTAP1
R437PAD04_IOVSS.I3._G1_TAP_SYNTAX_XR0 IOVSS SUBSTRATE_NODE PTAP1 A=141.2964p
+ P=221.76u
* device instance PAD04_IOVSS.I2.D1 r0 *1 0,0 DPANTENNA
D438PAD04_IOVSS.I2.D1 IOVSS IOVDD DPANTENNA A=35.003p P=58.08u m=1
* device instance PAD04_IOVSS.I2.D0 r0 *1 0,0 DPANTENNA
D439PAD04_IOVSS.I2.D0 IOVSS IOVDD DPANTENNA A=35.003p P=58.08u m=1
* device instance PAD04_IOVSS.I2._G1_TAP_SYNTAX_XR0 r0 *1 0,0 PTAP1
R440PAD04_IOVSS.I2._G1_TAP_SYNTAX_XR0 IOVSS SUBSTRATE_NODE PTAP1 A=33.5104p
+ P=197.12u
* device instance PAD06_IOVSS._G1_TAP_SYNTAX_XR1 r0 *1 0,0 PTAP1
R441PAD06_IOVSS._G1_TAP_SYNTAX_XR1 VSS SUBSTRATE_NODE PTAP1 A=24p P=160.6u
* device instance PAD06_IOVSS._G1_TAP_SYNTAX_XR0 r0 *1 0,0 PTAP1
R442PAD06_IOVSS._G1_TAP_SYNTAX_XR0 IOVSS SUBSTRATE_NODE PTAP1 A=5379.0466p
+ P=677.04u
* device instance PAD06_IOVSS.I3.D1 r0 *1 0,0 DANTENNA
D443PAD06_IOVSS.I3.D1 SUBSTRATE_NODE IOVSS DANTENNA A=35.003p P=58.08u m=1
* device instance PAD06_IOVSS.I3.D0 r0 *1 0,0 DANTENNA
D444PAD06_IOVSS.I3.D0 SUBSTRATE_NODE IOVSS DANTENNA A=35.003p P=58.08u m=1
* device instance PAD06_IOVSS.I3._G1_TAP_SYNTAX_XR0 r0 *1 0,0 PTAP1
R445PAD06_IOVSS.I3._G1_TAP_SYNTAX_XR0 IOVSS SUBSTRATE_NODE PTAP1 A=141.2964p
+ P=221.76u
* device instance PAD06_IOVSS.I2.D1 r0 *1 0,0 DPANTENNA
D446PAD06_IOVSS.I2.D1 IOVSS IOVDD DPANTENNA A=35.003p P=58.08u m=1
* device instance PAD06_IOVSS.I2.D0 r0 *1 0,0 DPANTENNA
D447PAD06_IOVSS.I2.D0 IOVSS IOVDD DPANTENNA A=35.003p P=58.08u m=1
* device instance PAD06_IOVSS.I2._G1_TAP_SYNTAX_XR0 r0 *1 0,0 PTAP1
R448PAD06_IOVSS.I2._G1_TAP_SYNTAX_XR0 IOVSS SUBSTRATE_NODE PTAP1 A=33.5104p
+ P=197.12u
* device instance PAD07_VDDA._G1_TAP_SYNTAX_XR0 r0 *1 0,0 PTAP1
R449PAD07_VDDA._G1_TAP_SYNTAX_XR0 VSS SUBSTRATE_NODE PTAP1 A=23.85p P=159.6u
* device instance PAD07_VDDA._G1_TAP_SYNTAX_XR1 r0 *1 0,0 PTAP1
R450PAD07_VDDA._G1_TAP_SYNTAX_XR1 IOVSS SUBSTRATE_NODE PTAP1 A=4273.4p P=593.62u
* device instance PAD07_VDDA.I3.R0 r0 *1 0,0 RPPD
R451PAD07_VDDA.I3.R0 VDDA \_NC1 SUBSTRATE_NODE RPPD w=1u l=2u ps=0u b=0 m=1
* device instance PAD07_VDDA.I3.D1 r0 *1 0,0 DANTENNA
D452PAD07_VDDA.I3.D1 SUBSTRATE_NODE \_NC1 DANTENNA A=1.984p P=7.48u m=1
* device instance PAD07_VDDA.I3._G1_TAP_SYNTAX_XR1 r0 *1 0,0 PTAP1
R453PAD07_VDDA.I3._G1_TAP_SYNTAX_XR1 IOVSS SUBSTRATE_NODE PTAP1 A=9.0304p
+ P=53.12u
* device instance PAD07_VDDA.I3.D0 r0 *1 0,0 DPANTENNA
D454PAD07_VDDA.I3.D0 \_NC1 IOVDD DPANTENNA A=3.187p P=11.24u m=1
* device instance PAD07_VDDA.I5.D1 r0 *1 0,0 DANTENNA
D455PAD07_VDDA.I5.D1 SUBSTRATE_NODE VDDA DANTENNA A=35.003p P=58.08u m=1
* device instance PAD07_VDDA.I5.D0 r0 *1 0,0 DANTENNA
D456PAD07_VDDA.I5.D0 SUBSTRATE_NODE VDDA DANTENNA A=35.003p P=58.08u m=1
* device instance PAD07_VDDA.I5._G1_TAP_SYNTAX_XR0 r0 *1 0,0 PTAP1
R457PAD07_VDDA.I5._G1_TAP_SYNTAX_XR0 IOVSS SUBSTRATE_NODE PTAP1 A=141.2964p
+ P=221.76u
* device instance PAD07_VDDA.I2.D1 r0 *1 0,0 DPANTENNA
D458PAD07_VDDA.I2.D1 VDDA IOVDD DPANTENNA A=35.003p P=58.08u m=1
* device instance PAD07_VDDA.I2.D0 r0 *1 0,0 DPANTENNA
D459PAD07_VDDA.I2.D0 VDDA IOVDD DPANTENNA A=35.003p P=58.08u m=1
* device instance PAD07_VDDA.I2._G1_TAP_SYNTAX_XR0 r0 *1 0,0 PTAP1
R460PAD07_VDDA.I2._G1_TAP_SYNTAX_XR0 IOVSS SUBSTRATE_NODE PTAP1 A=33.5104p
+ P=197.12u
* device instance PAD07_VDDA.I0.P1 r0 *1 0,0 sg13_hv_pmos
MPAD07_VDDA.I0.P1 IOVDD PAD07_VDDA.I0.NET2 VDDA IOVDD sg13_hv_pmos L=0.6u
+ W=133.2u AS=0p AD=0p PS=0u PD=0u rfmode=0
* device instance PAD07_VDDA.I0.P0 r0 *1 0,0 sg13_hv_pmos
MPAD07_VDDA.I0.P0 IOVDD PAD07_VDDA.I0.NET2 VDDA IOVDD sg13_hv_pmos L=0.6u
+ W=133.2u AS=0p AD=0p PS=0u PD=0u rfmode=0
* device instance PAD07_VDDA.I0.R0 r0 *1 0,0 RPPD
R463PAD07_VDDA.I0.R0 PAD07_VDDA.I0.NET2 IOVDD IOVDD RPPD w=0.5u l=12.9u ps=0u
+ b=0 m=1
* device instance PAD07_VDDA.I0._G1_TAP_SYNTAX_XR1 r0 *1 0,0 PTAP1
R464PAD07_VDDA.I0._G1_TAP_SYNTAX_XR1 IOVSS SUBSTRATE_NODE PTAP1 A=67.0344p
+ P=394.32u
* device instance PAD07_VDDA.I4.N0 r0 *1 0,0 sg13_hv_nmos
MPAD07_VDDA.I4.N0 IOVSS PAD07_VDDA.I4.NET2 VDDA SUBSTRATE_NODE sg13_hv_nmos
+ L=0.6u W=88u AS=0p AD=0p PS=0u PD=0u rfmode=0
* device instance PAD07_VDDA.I4._G1_TAP_SYNTAX_XR1 r0 *1 0,0 PTAP1
R466PAD07_VDDA.I4._G1_TAP_SYNTAX_XR1 IOVSS SUBSTRATE_NODE PTAP1 A=55.7736p
+ P=328.08u
* device instance PAD07_VDDA.I4.R0 r0 *1 0,0 RPPD
R467PAD07_VDDA.I4.R0 IOVSS PAD07_VDDA.I4.NET2 SUBSTRATE_NODE RPPD w=0.5u l=3.54u
+ ps=0u b=0 m=1
* device instance PAD08_ISA_P._G1_TAP_SYNTAX_XR0 r0 *1 0,0 PTAP1
R468PAD08_ISA_P._G1_TAP_SYNTAX_XR0 VSS SUBSTRATE_NODE PTAP1 A=23.85p P=159.6u
* device instance PAD08_ISA_P._G1_TAP_SYNTAX_XR1 r0 *1 0,0 PTAP1
R469PAD08_ISA_P._G1_TAP_SYNTAX_XR1 IOVSS SUBSTRATE_NODE PTAP1 A=4273.4p P=593.62u
* device instance PAD08_ISA_P.I3.R0 r0 *1 0,0 RPPD
R470PAD08_ISA_P.I3.R0 ISA_P \_NC2 SUBSTRATE_NODE RPPD w=1u l=2u ps=0u b=0 m=1
* device instance PAD08_ISA_P.I3.D1 r0 *1 0,0 DANTENNA
D471PAD08_ISA_P.I3.D1 SUBSTRATE_NODE \_NC2 DANTENNA A=1.984p P=7.48u m=1
* device instance PAD08_ISA_P.I3._G1_TAP_SYNTAX_XR1 r0 *1 0,0 PTAP1
R472PAD08_ISA_P.I3._G1_TAP_SYNTAX_XR1 IOVSS SUBSTRATE_NODE PTAP1 A=9.0304p
+ P=53.12u
* device instance PAD08_ISA_P.I3.D0 r0 *1 0,0 DPANTENNA
D473PAD08_ISA_P.I3.D0 \_NC2 IOVDD DPANTENNA A=3.187p P=11.24u m=1
* device instance PAD08_ISA_P.I5.D1 r0 *1 0,0 DANTENNA
D474PAD08_ISA_P.I5.D1 SUBSTRATE_NODE ISA_P DANTENNA A=35.003p P=58.08u m=1
* device instance PAD08_ISA_P.I5.D0 r0 *1 0,0 DANTENNA
D475PAD08_ISA_P.I5.D0 SUBSTRATE_NODE ISA_P DANTENNA A=35.003p P=58.08u m=1
* device instance PAD08_ISA_P.I5._G1_TAP_SYNTAX_XR0 r0 *1 0,0 PTAP1
R476PAD08_ISA_P.I5._G1_TAP_SYNTAX_XR0 IOVSS SUBSTRATE_NODE PTAP1 A=141.2964p
+ P=221.76u
* device instance PAD08_ISA_P.I2.D1 r0 *1 0,0 DPANTENNA
D477PAD08_ISA_P.I2.D1 ISA_P IOVDD DPANTENNA A=35.003p P=58.08u m=1
* device instance PAD08_ISA_P.I2.D0 r0 *1 0,0 DPANTENNA
D478PAD08_ISA_P.I2.D0 ISA_P IOVDD DPANTENNA A=35.003p P=58.08u m=1
* device instance PAD08_ISA_P.I2._G1_TAP_SYNTAX_XR0 r0 *1 0,0 PTAP1
R479PAD08_ISA_P.I2._G1_TAP_SYNTAX_XR0 IOVSS SUBSTRATE_NODE PTAP1 A=33.5104p
+ P=197.12u
* device instance PAD08_ISA_P.I0.P1 r0 *1 0,0 sg13_hv_pmos
MPAD08_ISA_P.I0.P1 IOVDD PAD08_ISA_P.I0.NET2 ISA_P IOVDD sg13_hv_pmos L=0.6u
+ W=133.2u AS=0p AD=0p PS=0u PD=0u rfmode=0
* device instance PAD08_ISA_P.I0.P0 r0 *1 0,0 sg13_hv_pmos
MPAD08_ISA_P.I0.P0 IOVDD PAD08_ISA_P.I0.NET2 ISA_P IOVDD sg13_hv_pmos L=0.6u
+ W=133.2u AS=0p AD=0p PS=0u PD=0u rfmode=0
* device instance PAD08_ISA_P.I0.R0 r0 *1 0,0 RPPD
R482PAD08_ISA_P.I0.R0 PAD08_ISA_P.I0.NET2 IOVDD IOVDD RPPD w=0.5u l=12.9u ps=0u
+ b=0 m=1
* device instance PAD08_ISA_P.I0._G1_TAP_SYNTAX_XR1 r0 *1 0,0 PTAP1
R483PAD08_ISA_P.I0._G1_TAP_SYNTAX_XR1 IOVSS SUBSTRATE_NODE PTAP1 A=67.0344p
+ P=394.32u
* device instance PAD08_ISA_P.I4.N0 r0 *1 0,0 sg13_hv_nmos
MPAD08_ISA_P.I4.N0 IOVSS PAD08_ISA_P.I4.NET2 ISA_P SUBSTRATE_NODE sg13_hv_nmos
+ L=0.6u W=88u AS=0p AD=0p PS=0u PD=0u rfmode=0
* device instance PAD08_ISA_P.I4._G1_TAP_SYNTAX_XR1 r0 *1 0,0 PTAP1
R485PAD08_ISA_P.I4._G1_TAP_SYNTAX_XR1 IOVSS SUBSTRATE_NODE PTAP1 A=55.7736p
+ P=328.08u
* device instance PAD08_ISA_P.I4.R0 r0 *1 0,0 RPPD
R486PAD08_ISA_P.I4.R0 IOVSS PAD08_ISA_P.I4.NET2 SUBSTRATE_NODE RPPD w=0.5u
+ l=3.54u ps=0u b=0 m=1
* device instance PAD09_ISA_N._G1_TAP_SYNTAX_XR0 r0 *1 0,0 PTAP1
R487PAD09_ISA_N._G1_TAP_SYNTAX_XR0 VSS SUBSTRATE_NODE PTAP1 A=23.85p P=159.6u
* device instance PAD09_ISA_N._G1_TAP_SYNTAX_XR1 r0 *1 0,0 PTAP1
R488PAD09_ISA_N._G1_TAP_SYNTAX_XR1 IOVSS SUBSTRATE_NODE PTAP1 A=4273.4p P=593.62u
* device instance PAD09_ISA_N.I3.R0 r0 *1 0,0 RPPD
R489PAD09_ISA_N.I3.R0 ISA_N \_NC3 SUBSTRATE_NODE RPPD w=1u l=2u ps=0u b=0 m=1
* device instance PAD09_ISA_N.I3.D1 r0 *1 0,0 DANTENNA
D490PAD09_ISA_N.I3.D1 SUBSTRATE_NODE \_NC3 DANTENNA A=1.984p P=7.48u m=1
* device instance PAD09_ISA_N.I3._G1_TAP_SYNTAX_XR1 r0 *1 0,0 PTAP1
R491PAD09_ISA_N.I3._G1_TAP_SYNTAX_XR1 IOVSS SUBSTRATE_NODE PTAP1 A=9.0304p
+ P=53.12u
* device instance PAD09_ISA_N.I3.D0 r0 *1 0,0 DPANTENNA
D492PAD09_ISA_N.I3.D0 \_NC3 IOVDD DPANTENNA A=3.187p P=11.24u m=1
* device instance PAD09_ISA_N.I5.D1 r0 *1 0,0 DANTENNA
D493PAD09_ISA_N.I5.D1 SUBSTRATE_NODE ISA_N DANTENNA A=35.003p P=58.08u m=1
* device instance PAD09_ISA_N.I5.D0 r0 *1 0,0 DANTENNA
D494PAD09_ISA_N.I5.D0 SUBSTRATE_NODE ISA_N DANTENNA A=35.003p P=58.08u m=1
* device instance PAD09_ISA_N.I5._G1_TAP_SYNTAX_XR0 r0 *1 0,0 PTAP1
R495PAD09_ISA_N.I5._G1_TAP_SYNTAX_XR0 IOVSS SUBSTRATE_NODE PTAP1 A=141.2964p
+ P=221.76u
* device instance PAD09_ISA_N.I2.D1 r0 *1 0,0 DPANTENNA
D496PAD09_ISA_N.I2.D1 ISA_N IOVDD DPANTENNA A=35.003p P=58.08u m=1
* device instance PAD09_ISA_N.I2.D0 r0 *1 0,0 DPANTENNA
D497PAD09_ISA_N.I2.D0 ISA_N IOVDD DPANTENNA A=35.003p P=58.08u m=1
* device instance PAD09_ISA_N.I2._G1_TAP_SYNTAX_XR0 r0 *1 0,0 PTAP1
R498PAD09_ISA_N.I2._G1_TAP_SYNTAX_XR0 IOVSS SUBSTRATE_NODE PTAP1 A=33.5104p
+ P=197.12u
* device instance PAD09_ISA_N.I0.P1 r0 *1 0,0 sg13_hv_pmos
MPAD09_ISA_N.I0.P1 IOVDD PAD09_ISA_N.I0.NET2 ISA_N IOVDD sg13_hv_pmos L=0.6u
+ W=133.2u AS=0p AD=0p PS=0u PD=0u rfmode=0
* device instance PAD09_ISA_N.I0.P0 r0 *1 0,0 sg13_hv_pmos
MPAD09_ISA_N.I0.P0 IOVDD PAD09_ISA_N.I0.NET2 ISA_N IOVDD sg13_hv_pmos L=0.6u
+ W=133.2u AS=0p AD=0p PS=0u PD=0u rfmode=0
* device instance PAD09_ISA_N.I0.R0 r0 *1 0,0 RPPD
R501PAD09_ISA_N.I0.R0 PAD09_ISA_N.I0.NET2 IOVDD IOVDD RPPD w=0.5u l=12.9u ps=0u
+ b=0 m=1
* device instance PAD09_ISA_N.I0._G1_TAP_SYNTAX_XR1 r0 *1 0,0 PTAP1
R502PAD09_ISA_N.I0._G1_TAP_SYNTAX_XR1 IOVSS SUBSTRATE_NODE PTAP1 A=67.0344p
+ P=394.32u
* device instance PAD09_ISA_N.I4.N0 r0 *1 0,0 sg13_hv_nmos
MPAD09_ISA_N.I4.N0 IOVSS PAD09_ISA_N.I4.NET2 ISA_N SUBSTRATE_NODE sg13_hv_nmos
+ L=0.6u W=88u AS=0p AD=0p PS=0u PD=0u rfmode=0
* device instance PAD09_ISA_N.I4._G1_TAP_SYNTAX_XR1 r0 *1 0,0 PTAP1
R504PAD09_ISA_N.I4._G1_TAP_SYNTAX_XR1 IOVSS SUBSTRATE_NODE PTAP1 A=55.7736p
+ P=328.08u
* device instance PAD09_ISA_N.I4.R0 r0 *1 0,0 RPPD
R505PAD09_ISA_N.I4.R0 IOVSS PAD09_ISA_N.I4.NET2 SUBSTRATE_NODE RPPD w=0.5u
+ l=3.54u ps=0u b=0 m=1
* device instance PAD10_ISB_P._G1_TAP_SYNTAX_XR0 r0 *1 0,0 PTAP1
R506PAD10_ISB_P._G1_TAP_SYNTAX_XR0 VSS SUBSTRATE_NODE PTAP1 A=23.85p P=159.6u
* device instance PAD10_ISB_P._G1_TAP_SYNTAX_XR1 r0 *1 0,0 PTAP1
R507PAD10_ISB_P._G1_TAP_SYNTAX_XR1 IOVSS SUBSTRATE_NODE PTAP1 A=4273.4p P=593.62u
* device instance PAD10_ISB_P.I3.R0 r0 *1 0,0 RPPD
R508PAD10_ISB_P.I3.R0 ISB_P \_NC4 SUBSTRATE_NODE RPPD w=1u l=2u ps=0u b=0 m=1
* device instance PAD10_ISB_P.I3.D1 r0 *1 0,0 DANTENNA
D509PAD10_ISB_P.I3.D1 SUBSTRATE_NODE \_NC4 DANTENNA A=1.984p P=7.48u m=1
* device instance PAD10_ISB_P.I3._G1_TAP_SYNTAX_XR1 r0 *1 0,0 PTAP1
R510PAD10_ISB_P.I3._G1_TAP_SYNTAX_XR1 IOVSS SUBSTRATE_NODE PTAP1 A=9.0304p
+ P=53.12u
* device instance PAD10_ISB_P.I3.D0 r0 *1 0,0 DPANTENNA
D511PAD10_ISB_P.I3.D0 \_NC4 IOVDD DPANTENNA A=3.187p P=11.24u m=1
* device instance PAD10_ISB_P.I5.D1 r0 *1 0,0 DANTENNA
D512PAD10_ISB_P.I5.D1 SUBSTRATE_NODE ISB_P DANTENNA A=35.003p P=58.08u m=1
* device instance PAD10_ISB_P.I5.D0 r0 *1 0,0 DANTENNA
D513PAD10_ISB_P.I5.D0 SUBSTRATE_NODE ISB_P DANTENNA A=35.003p P=58.08u m=1
* device instance PAD10_ISB_P.I5._G1_TAP_SYNTAX_XR0 r0 *1 0,0 PTAP1
R514PAD10_ISB_P.I5._G1_TAP_SYNTAX_XR0 IOVSS SUBSTRATE_NODE PTAP1 A=141.2964p
+ P=221.76u
* device instance PAD10_ISB_P.I2.D1 r0 *1 0,0 DPANTENNA
D515PAD10_ISB_P.I2.D1 ISB_P IOVDD DPANTENNA A=35.003p P=58.08u m=1
* device instance PAD10_ISB_P.I2.D0 r0 *1 0,0 DPANTENNA
D516PAD10_ISB_P.I2.D0 ISB_P IOVDD DPANTENNA A=35.003p P=58.08u m=1
* device instance PAD10_ISB_P.I2._G1_TAP_SYNTAX_XR0 r0 *1 0,0 PTAP1
R517PAD10_ISB_P.I2._G1_TAP_SYNTAX_XR0 IOVSS SUBSTRATE_NODE PTAP1 A=33.5104p
+ P=197.12u
* device instance PAD10_ISB_P.I0.P1 r0 *1 0,0 sg13_hv_pmos
MPAD10_ISB_P.I0.P1 IOVDD PAD10_ISB_P.I0.NET2 ISB_P IOVDD sg13_hv_pmos L=0.6u
+ W=133.2u AS=0p AD=0p PS=0u PD=0u rfmode=0
* device instance PAD10_ISB_P.I0.P0 r0 *1 0,0 sg13_hv_pmos
MPAD10_ISB_P.I0.P0 IOVDD PAD10_ISB_P.I0.NET2 ISB_P IOVDD sg13_hv_pmos L=0.6u
+ W=133.2u AS=0p AD=0p PS=0u PD=0u rfmode=0
* device instance PAD10_ISB_P.I0.R0 r0 *1 0,0 RPPD
R520PAD10_ISB_P.I0.R0 PAD10_ISB_P.I0.NET2 IOVDD IOVDD RPPD w=0.5u l=12.9u ps=0u
+ b=0 m=1
* device instance PAD10_ISB_P.I0._G1_TAP_SYNTAX_XR1 r0 *1 0,0 PTAP1
R521PAD10_ISB_P.I0._G1_TAP_SYNTAX_XR1 IOVSS SUBSTRATE_NODE PTAP1 A=67.0344p
+ P=394.32u
* device instance PAD10_ISB_P.I4.N0 r0 *1 0,0 sg13_hv_nmos
MPAD10_ISB_P.I4.N0 IOVSS PAD10_ISB_P.I4.NET2 ISB_P SUBSTRATE_NODE sg13_hv_nmos
+ L=0.6u W=88u AS=0p AD=0p PS=0u PD=0u rfmode=0
* device instance PAD10_ISB_P.I4._G1_TAP_SYNTAX_XR1 r0 *1 0,0 PTAP1
R523PAD10_ISB_P.I4._G1_TAP_SYNTAX_XR1 IOVSS SUBSTRATE_NODE PTAP1 A=55.7736p
+ P=328.08u
* device instance PAD10_ISB_P.I4.R0 r0 *1 0,0 RPPD
R524PAD10_ISB_P.I4.R0 IOVSS PAD10_ISB_P.I4.NET2 SUBSTRATE_NODE RPPD w=0.5u
+ l=3.54u ps=0u b=0 m=1
* device instance PAD11_ISB_N._G1_TAP_SYNTAX_XR0 r0 *1 0,0 PTAP1
R525PAD11_ISB_N._G1_TAP_SYNTAX_XR0 VSS SUBSTRATE_NODE PTAP1 A=23.85p P=159.6u
* device instance PAD11_ISB_N._G1_TAP_SYNTAX_XR1 r0 *1 0,0 PTAP1
R526PAD11_ISB_N._G1_TAP_SYNTAX_XR1 IOVSS SUBSTRATE_NODE PTAP1 A=4273.4p P=593.62u
* device instance PAD11_ISB_N.I3.R0 r0 *1 0,0 RPPD
R527PAD11_ISB_N.I3.R0 ISB_N \_NC5 SUBSTRATE_NODE RPPD w=1u l=2u ps=0u b=0 m=1
* device instance PAD11_ISB_N.I3.D1 r0 *1 0,0 DANTENNA
D528PAD11_ISB_N.I3.D1 SUBSTRATE_NODE \_NC5 DANTENNA A=1.984p P=7.48u m=1
* device instance PAD11_ISB_N.I3._G1_TAP_SYNTAX_XR1 r0 *1 0,0 PTAP1
R529PAD11_ISB_N.I3._G1_TAP_SYNTAX_XR1 IOVSS SUBSTRATE_NODE PTAP1 A=9.0304p
+ P=53.12u
* device instance PAD11_ISB_N.I3.D0 r0 *1 0,0 DPANTENNA
D530PAD11_ISB_N.I3.D0 \_NC5 IOVDD DPANTENNA A=3.187p P=11.24u m=1
* device instance PAD11_ISB_N.I5.D1 r0 *1 0,0 DANTENNA
D531PAD11_ISB_N.I5.D1 SUBSTRATE_NODE ISB_N DANTENNA A=35.003p P=58.08u m=1
* device instance PAD11_ISB_N.I5.D0 r0 *1 0,0 DANTENNA
D532PAD11_ISB_N.I5.D0 SUBSTRATE_NODE ISB_N DANTENNA A=35.003p P=58.08u m=1
* device instance PAD11_ISB_N.I5._G1_TAP_SYNTAX_XR0 r0 *1 0,0 PTAP1
R533PAD11_ISB_N.I5._G1_TAP_SYNTAX_XR0 IOVSS SUBSTRATE_NODE PTAP1 A=141.2964p
+ P=221.76u
* device instance PAD11_ISB_N.I2.D1 r0 *1 0,0 DPANTENNA
D534PAD11_ISB_N.I2.D1 ISB_N IOVDD DPANTENNA A=35.003p P=58.08u m=1
* device instance PAD11_ISB_N.I2.D0 r0 *1 0,0 DPANTENNA
D535PAD11_ISB_N.I2.D0 ISB_N IOVDD DPANTENNA A=35.003p P=58.08u m=1
* device instance PAD11_ISB_N.I2._G1_TAP_SYNTAX_XR0 r0 *1 0,0 PTAP1
R536PAD11_ISB_N.I2._G1_TAP_SYNTAX_XR0 IOVSS SUBSTRATE_NODE PTAP1 A=33.5104p
+ P=197.12u
* device instance PAD11_ISB_N.I0.P1 r0 *1 0,0 sg13_hv_pmos
MPAD11_ISB_N.I0.P1 IOVDD PAD11_ISB_N.I0.NET2 ISB_N IOVDD sg13_hv_pmos L=0.6u
+ W=133.2u AS=0p AD=0p PS=0u PD=0u rfmode=0
* device instance PAD11_ISB_N.I0.P0 r0 *1 0,0 sg13_hv_pmos
MPAD11_ISB_N.I0.P0 IOVDD PAD11_ISB_N.I0.NET2 ISB_N IOVDD sg13_hv_pmos L=0.6u
+ W=133.2u AS=0p AD=0p PS=0u PD=0u rfmode=0
* device instance PAD11_ISB_N.I0.R0 r0 *1 0,0 RPPD
R539PAD11_ISB_N.I0.R0 PAD11_ISB_N.I0.NET2 IOVDD IOVDD RPPD w=0.5u l=12.9u ps=0u
+ b=0 m=1
* device instance PAD11_ISB_N.I0._G1_TAP_SYNTAX_XR1 r0 *1 0,0 PTAP1
R540PAD11_ISB_N.I0._G1_TAP_SYNTAX_XR1 IOVSS SUBSTRATE_NODE PTAP1 A=67.0344p
+ P=394.32u
* device instance PAD11_ISB_N.I4.N0 r0 *1 0,0 sg13_hv_nmos
MPAD11_ISB_N.I4.N0 IOVSS PAD11_ISB_N.I4.NET2 ISB_N SUBSTRATE_NODE sg13_hv_nmos
+ L=0.6u W=88u AS=0p AD=0p PS=0u PD=0u rfmode=0
* device instance PAD11_ISB_N.I4._G1_TAP_SYNTAX_XR1 r0 *1 0,0 PTAP1
R542PAD11_ISB_N.I4._G1_TAP_SYNTAX_XR1 IOVSS SUBSTRATE_NODE PTAP1 A=55.7736p
+ P=328.08u
* device instance PAD11_ISB_N.I4.R0 r0 *1 0,0 RPPD
R543PAD11_ISB_N.I4.R0 IOVSS PAD11_ISB_N.I4.NET2 SUBSTRATE_NODE RPPD w=0.5u
+ l=3.54u ps=0u b=0 m=1
* device instance PAD21_SIN_P._G1_TAP_SYNTAX_XR0 r0 *1 0,0 PTAP1
R544PAD21_SIN_P._G1_TAP_SYNTAX_XR0 VSS SUBSTRATE_NODE PTAP1 A=23.85p P=159.6u
* device instance PAD21_SIN_P._G1_TAP_SYNTAX_XR1 r0 *1 0,0 PTAP1
R545PAD21_SIN_P._G1_TAP_SYNTAX_XR1 IOVSS SUBSTRATE_NODE PTAP1 A=4273.4p P=593.62u
* device instance PAD21_SIN_P.I3.R0 r0 *1 0,0 RPPD
R546PAD21_SIN_P.I3.R0 SIN_P \_NC6 SUBSTRATE_NODE RPPD w=1u l=2u ps=0u b=0 m=1
* device instance PAD21_SIN_P.I3.D1 r0 *1 0,0 DANTENNA
D547PAD21_SIN_P.I3.D1 SUBSTRATE_NODE \_NC6 DANTENNA A=1.984p P=7.48u m=1
* device instance PAD21_SIN_P.I3._G1_TAP_SYNTAX_XR1 r0 *1 0,0 PTAP1
R548PAD21_SIN_P.I3._G1_TAP_SYNTAX_XR1 IOVSS SUBSTRATE_NODE PTAP1 A=9.0304p
+ P=53.12u
* device instance PAD21_SIN_P.I3.D0 r0 *1 0,0 DPANTENNA
D549PAD21_SIN_P.I3.D0 \_NC6 IOVDD DPANTENNA A=3.187p P=11.24u m=1
* device instance PAD21_SIN_P.I5.D1 r0 *1 0,0 DANTENNA
D550PAD21_SIN_P.I5.D1 SUBSTRATE_NODE SIN_P DANTENNA A=35.003p P=58.08u m=1
* device instance PAD21_SIN_P.I5.D0 r0 *1 0,0 DANTENNA
D551PAD21_SIN_P.I5.D0 SUBSTRATE_NODE SIN_P DANTENNA A=35.003p P=58.08u m=1
* device instance PAD21_SIN_P.I5._G1_TAP_SYNTAX_XR0 r0 *1 0,0 PTAP1
R552PAD21_SIN_P.I5._G1_TAP_SYNTAX_XR0 IOVSS SUBSTRATE_NODE PTAP1 A=141.2964p
+ P=221.76u
* device instance PAD21_SIN_P.I2.D1 r0 *1 0,0 DPANTENNA
D553PAD21_SIN_P.I2.D1 SIN_P IOVDD DPANTENNA A=35.003p P=58.08u m=1
* device instance PAD21_SIN_P.I2.D0 r0 *1 0,0 DPANTENNA
D554PAD21_SIN_P.I2.D0 SIN_P IOVDD DPANTENNA A=35.003p P=58.08u m=1
* device instance PAD21_SIN_P.I2._G1_TAP_SYNTAX_XR0 r0 *1 0,0 PTAP1
R555PAD21_SIN_P.I2._G1_TAP_SYNTAX_XR0 IOVSS SUBSTRATE_NODE PTAP1 A=33.5104p
+ P=197.12u
* device instance PAD21_SIN_P.I0.P1 r0 *1 0,0 sg13_hv_pmos
MPAD21_SIN_P.I0.P1 IOVDD PAD21_SIN_P.I0.NET2 SIN_P IOVDD sg13_hv_pmos L=0.6u
+ W=133.2u AS=0p AD=0p PS=0u PD=0u rfmode=0
* device instance PAD21_SIN_P.I0.P0 r0 *1 0,0 sg13_hv_pmos
MPAD21_SIN_P.I0.P0 IOVDD PAD21_SIN_P.I0.NET2 SIN_P IOVDD sg13_hv_pmos L=0.6u
+ W=133.2u AS=0p AD=0p PS=0u PD=0u rfmode=0
* device instance PAD21_SIN_P.I0.R0 r0 *1 0,0 RPPD
R558PAD21_SIN_P.I0.R0 PAD21_SIN_P.I0.NET2 IOVDD IOVDD RPPD w=0.5u l=12.9u ps=0u
+ b=0 m=1
* device instance PAD21_SIN_P.I0._G1_TAP_SYNTAX_XR1 r0 *1 0,0 PTAP1
R559PAD21_SIN_P.I0._G1_TAP_SYNTAX_XR1 IOVSS SUBSTRATE_NODE PTAP1 A=67.0344p
+ P=394.32u
* device instance PAD21_SIN_P.I4.N0 r0 *1 0,0 sg13_hv_nmos
MPAD21_SIN_P.I4.N0 IOVSS PAD21_SIN_P.I4.NET2 SIN_P SUBSTRATE_NODE sg13_hv_nmos
+ L=0.6u W=88u AS=0p AD=0p PS=0u PD=0u rfmode=0
* device instance PAD21_SIN_P.I4._G1_TAP_SYNTAX_XR1 r0 *1 0,0 PTAP1
R561PAD21_SIN_P.I4._G1_TAP_SYNTAX_XR1 IOVSS SUBSTRATE_NODE PTAP1 A=55.7736p
+ P=328.08u
* device instance PAD21_SIN_P.I4.R0 r0 *1 0,0 RPPD
R562PAD21_SIN_P.I4.R0 IOVSS PAD21_SIN_P.I4.NET2 SUBSTRATE_NODE RPPD w=0.5u
+ l=3.54u ps=0u b=0 m=1
* device instance PAD22_SIN_N._G1_TAP_SYNTAX_XR0 r0 *1 0,0 PTAP1
R563PAD22_SIN_N._G1_TAP_SYNTAX_XR0 VSS SUBSTRATE_NODE PTAP1 A=23.85p P=159.6u
* device instance PAD22_SIN_N._G1_TAP_SYNTAX_XR1 r0 *1 0,0 PTAP1
R564PAD22_SIN_N._G1_TAP_SYNTAX_XR1 IOVSS SUBSTRATE_NODE PTAP1 A=4273.4p P=593.62u
* device instance PAD22_SIN_N.I3.R0 r0 *1 0,0 RPPD
R565PAD22_SIN_N.I3.R0 SIN_N \_NC7 SUBSTRATE_NODE RPPD w=1u l=2u ps=0u b=0 m=1
* device instance PAD22_SIN_N.I3.D1 r0 *1 0,0 DANTENNA
D566PAD22_SIN_N.I3.D1 SUBSTRATE_NODE \_NC7 DANTENNA A=1.984p P=7.48u m=1
* device instance PAD22_SIN_N.I3._G1_TAP_SYNTAX_XR1 r0 *1 0,0 PTAP1
R567PAD22_SIN_N.I3._G1_TAP_SYNTAX_XR1 IOVSS SUBSTRATE_NODE PTAP1 A=9.0304p
+ P=53.12u
* device instance PAD22_SIN_N.I3.D0 r0 *1 0,0 DPANTENNA
D568PAD22_SIN_N.I3.D0 \_NC7 IOVDD DPANTENNA A=3.187p P=11.24u m=1
* device instance PAD22_SIN_N.I5.D1 r0 *1 0,0 DANTENNA
D569PAD22_SIN_N.I5.D1 SUBSTRATE_NODE SIN_N DANTENNA A=35.003p P=58.08u m=1
* device instance PAD22_SIN_N.I5.D0 r0 *1 0,0 DANTENNA
D570PAD22_SIN_N.I5.D0 SUBSTRATE_NODE SIN_N DANTENNA A=35.003p P=58.08u m=1
* device instance PAD22_SIN_N.I5._G1_TAP_SYNTAX_XR0 r0 *1 0,0 PTAP1
R571PAD22_SIN_N.I5._G1_TAP_SYNTAX_XR0 IOVSS SUBSTRATE_NODE PTAP1 A=141.2964p
+ P=221.76u
* device instance PAD22_SIN_N.I2.D1 r0 *1 0,0 DPANTENNA
D572PAD22_SIN_N.I2.D1 SIN_N IOVDD DPANTENNA A=35.003p P=58.08u m=1
* device instance PAD22_SIN_N.I2.D0 r0 *1 0,0 DPANTENNA
D573PAD22_SIN_N.I2.D0 SIN_N IOVDD DPANTENNA A=35.003p P=58.08u m=1
* device instance PAD22_SIN_N.I2._G1_TAP_SYNTAX_XR0 r0 *1 0,0 PTAP1
R574PAD22_SIN_N.I2._G1_TAP_SYNTAX_XR0 IOVSS SUBSTRATE_NODE PTAP1 A=33.5104p
+ P=197.12u
* device instance PAD22_SIN_N.I0.P1 r0 *1 0,0 sg13_hv_pmos
MPAD22_SIN_N.I0.P1 IOVDD PAD22_SIN_N.I0.NET2 SIN_N IOVDD sg13_hv_pmos L=0.6u
+ W=133.2u AS=0p AD=0p PS=0u PD=0u rfmode=0
* device instance PAD22_SIN_N.I0.P0 r0 *1 0,0 sg13_hv_pmos
MPAD22_SIN_N.I0.P0 IOVDD PAD22_SIN_N.I0.NET2 SIN_N IOVDD sg13_hv_pmos L=0.6u
+ W=133.2u AS=0p AD=0p PS=0u PD=0u rfmode=0
* device instance PAD22_SIN_N.I0.R0 r0 *1 0,0 RPPD
R577PAD22_SIN_N.I0.R0 PAD22_SIN_N.I0.NET2 IOVDD IOVDD RPPD w=0.5u l=12.9u ps=0u
+ b=0 m=1
* device instance PAD22_SIN_N.I0._G1_TAP_SYNTAX_XR1 r0 *1 0,0 PTAP1
R578PAD22_SIN_N.I0._G1_TAP_SYNTAX_XR1 IOVSS SUBSTRATE_NODE PTAP1 A=67.0344p
+ P=394.32u
* device instance PAD22_SIN_N.I4.N0 r0 *1 0,0 sg13_hv_nmos
MPAD22_SIN_N.I4.N0 IOVSS PAD22_SIN_N.I4.NET2 SIN_N SUBSTRATE_NODE sg13_hv_nmos
+ L=0.6u W=88u AS=0p AD=0p PS=0u PD=0u rfmode=0
* device instance PAD22_SIN_N.I4._G1_TAP_SYNTAX_XR1 r0 *1 0,0 PTAP1
R580PAD22_SIN_N.I4._G1_TAP_SYNTAX_XR1 IOVSS SUBSTRATE_NODE PTAP1 A=55.7736p
+ P=328.08u
* device instance PAD22_SIN_N.I4.R0 r0 *1 0,0 RPPD
R581PAD22_SIN_N.I4.R0 IOVSS PAD22_SIN_N.I4.NET2 SUBSTRATE_NODE RPPD w=0.5u
+ l=3.54u ps=0u b=0 m=1
* device instance PAD23_COS_P._G1_TAP_SYNTAX_XR0 r0 *1 0,0 PTAP1
R582PAD23_COS_P._G1_TAP_SYNTAX_XR0 VSS SUBSTRATE_NODE PTAP1 A=23.85p P=159.6u
* device instance PAD23_COS_P._G1_TAP_SYNTAX_XR1 r0 *1 0,0 PTAP1
R583PAD23_COS_P._G1_TAP_SYNTAX_XR1 IOVSS SUBSTRATE_NODE PTAP1 A=4273.4p P=593.62u
* device instance PAD23_COS_P.I3.R0 r0 *1 0,0 RPPD
R584PAD23_COS_P.I3.R0 COS_P \_NC8 SUBSTRATE_NODE RPPD w=1u l=2u ps=0u b=0 m=1
* device instance PAD23_COS_P.I3.D1 r0 *1 0,0 DANTENNA
D585PAD23_COS_P.I3.D1 SUBSTRATE_NODE \_NC8 DANTENNA A=1.984p P=7.48u m=1
* device instance PAD23_COS_P.I3._G1_TAP_SYNTAX_XR1 r0 *1 0,0 PTAP1
R586PAD23_COS_P.I3._G1_TAP_SYNTAX_XR1 IOVSS SUBSTRATE_NODE PTAP1 A=9.0304p
+ P=53.12u
* device instance PAD23_COS_P.I3.D0 r0 *1 0,0 DPANTENNA
D587PAD23_COS_P.I3.D0 \_NC8 IOVDD DPANTENNA A=3.187p P=11.24u m=1
* device instance PAD23_COS_P.I5.D1 r0 *1 0,0 DANTENNA
D588PAD23_COS_P.I5.D1 SUBSTRATE_NODE COS_P DANTENNA A=35.003p P=58.08u m=1
* device instance PAD23_COS_P.I5.D0 r0 *1 0,0 DANTENNA
D589PAD23_COS_P.I5.D0 SUBSTRATE_NODE COS_P DANTENNA A=35.003p P=58.08u m=1
* device instance PAD23_COS_P.I5._G1_TAP_SYNTAX_XR0 r0 *1 0,0 PTAP1
R590PAD23_COS_P.I5._G1_TAP_SYNTAX_XR0 IOVSS SUBSTRATE_NODE PTAP1 A=141.2964p
+ P=221.76u
* device instance PAD23_COS_P.I2.D1 r0 *1 0,0 DPANTENNA
D591PAD23_COS_P.I2.D1 COS_P IOVDD DPANTENNA A=35.003p P=58.08u m=1
* device instance PAD23_COS_P.I2.D0 r0 *1 0,0 DPANTENNA
D592PAD23_COS_P.I2.D0 COS_P IOVDD DPANTENNA A=35.003p P=58.08u m=1
* device instance PAD23_COS_P.I2._G1_TAP_SYNTAX_XR0 r0 *1 0,0 PTAP1
R593PAD23_COS_P.I2._G1_TAP_SYNTAX_XR0 IOVSS SUBSTRATE_NODE PTAP1 A=33.5104p
+ P=197.12u
* device instance PAD23_COS_P.I0.P1 r0 *1 0,0 sg13_hv_pmos
MPAD23_COS_P.I0.P1 IOVDD PAD23_COS_P.I0.NET2 COS_P IOVDD sg13_hv_pmos L=0.6u
+ W=133.2u AS=0p AD=0p PS=0u PD=0u rfmode=0
* device instance PAD23_COS_P.I0.P0 r0 *1 0,0 sg13_hv_pmos
MPAD23_COS_P.I0.P0 IOVDD PAD23_COS_P.I0.NET2 COS_P IOVDD sg13_hv_pmos L=0.6u
+ W=133.2u AS=0p AD=0p PS=0u PD=0u rfmode=0
* device instance PAD23_COS_P.I0.R0 r0 *1 0,0 RPPD
R596PAD23_COS_P.I0.R0 PAD23_COS_P.I0.NET2 IOVDD IOVDD RPPD w=0.5u l=12.9u ps=0u
+ b=0 m=1
* device instance PAD23_COS_P.I0._G1_TAP_SYNTAX_XR1 r0 *1 0,0 PTAP1
R597PAD23_COS_P.I0._G1_TAP_SYNTAX_XR1 IOVSS SUBSTRATE_NODE PTAP1 A=67.0344p
+ P=394.32u
* device instance PAD23_COS_P.I4.N0 r0 *1 0,0 sg13_hv_nmos
MPAD23_COS_P.I4.N0 IOVSS PAD23_COS_P.I4.NET2 COS_P SUBSTRATE_NODE sg13_hv_nmos
+ L=0.6u W=88u AS=0p AD=0p PS=0u PD=0u rfmode=0
* device instance PAD23_COS_P.I4._G1_TAP_SYNTAX_XR1 r0 *1 0,0 PTAP1
R599PAD23_COS_P.I4._G1_TAP_SYNTAX_XR1 IOVSS SUBSTRATE_NODE PTAP1 A=55.7736p
+ P=328.08u
* device instance PAD23_COS_P.I4.R0 r0 *1 0,0 RPPD
R600PAD23_COS_P.I4.R0 IOVSS PAD23_COS_P.I4.NET2 SUBSTRATE_NODE RPPD w=0.5u
+ l=3.54u ps=0u b=0 m=1
* device instance PAD24_COS_N._G1_TAP_SYNTAX_XR0 r0 *1 0,0 PTAP1
R601PAD24_COS_N._G1_TAP_SYNTAX_XR0 VSS SUBSTRATE_NODE PTAP1 A=23.85p P=159.6u
* device instance PAD24_COS_N._G1_TAP_SYNTAX_XR1 r0 *1 0,0 PTAP1
R602PAD24_COS_N._G1_TAP_SYNTAX_XR1 IOVSS SUBSTRATE_NODE PTAP1 A=4273.4p P=593.62u
* device instance PAD24_COS_N.I3.R0 r0 *1 0,0 RPPD
R603PAD24_COS_N.I3.R0 COS_N \_NC9 SUBSTRATE_NODE RPPD w=1u l=2u ps=0u b=0 m=1
* device instance PAD24_COS_N.I3.D1 r0 *1 0,0 DANTENNA
D604PAD24_COS_N.I3.D1 SUBSTRATE_NODE \_NC9 DANTENNA A=1.984p P=7.48u m=1
* device instance PAD24_COS_N.I3._G1_TAP_SYNTAX_XR1 r0 *1 0,0 PTAP1
R605PAD24_COS_N.I3._G1_TAP_SYNTAX_XR1 IOVSS SUBSTRATE_NODE PTAP1 A=9.0304p
+ P=53.12u
* device instance PAD24_COS_N.I3.D0 r0 *1 0,0 DPANTENNA
D606PAD24_COS_N.I3.D0 \_NC9 IOVDD DPANTENNA A=3.187p P=11.24u m=1
* device instance PAD24_COS_N.I5.D1 r0 *1 0,0 DANTENNA
D607PAD24_COS_N.I5.D1 SUBSTRATE_NODE COS_N DANTENNA A=35.003p P=58.08u m=1
* device instance PAD24_COS_N.I5.D0 r0 *1 0,0 DANTENNA
D608PAD24_COS_N.I5.D0 SUBSTRATE_NODE COS_N DANTENNA A=35.003p P=58.08u m=1
* device instance PAD24_COS_N.I5._G1_TAP_SYNTAX_XR0 r0 *1 0,0 PTAP1
R609PAD24_COS_N.I5._G1_TAP_SYNTAX_XR0 IOVSS SUBSTRATE_NODE PTAP1 A=141.2964p
+ P=221.76u
* device instance PAD24_COS_N.I2.D1 r0 *1 0,0 DPANTENNA
D610PAD24_COS_N.I2.D1 COS_N IOVDD DPANTENNA A=35.003p P=58.08u m=1
* device instance PAD24_COS_N.I2.D0 r0 *1 0,0 DPANTENNA
D611PAD24_COS_N.I2.D0 COS_N IOVDD DPANTENNA A=35.003p P=58.08u m=1
* device instance PAD24_COS_N.I2._G1_TAP_SYNTAX_XR0 r0 *1 0,0 PTAP1
R612PAD24_COS_N.I2._G1_TAP_SYNTAX_XR0 IOVSS SUBSTRATE_NODE PTAP1 A=33.5104p
+ P=197.12u
* device instance PAD24_COS_N.I0.P1 r0 *1 0,0 sg13_hv_pmos
MPAD24_COS_N.I0.P1 IOVDD PAD24_COS_N.I0.NET2 COS_N IOVDD sg13_hv_pmos L=0.6u
+ W=133.2u AS=0p AD=0p PS=0u PD=0u rfmode=0
* device instance PAD24_COS_N.I0.P0 r0 *1 0,0 sg13_hv_pmos
MPAD24_COS_N.I0.P0 IOVDD PAD24_COS_N.I0.NET2 COS_N IOVDD sg13_hv_pmos L=0.6u
+ W=133.2u AS=0p AD=0p PS=0u PD=0u rfmode=0
* device instance PAD24_COS_N.I0.R0 r0 *1 0,0 RPPD
R615PAD24_COS_N.I0.R0 PAD24_COS_N.I0.NET2 IOVDD IOVDD RPPD w=0.5u l=12.9u ps=0u
+ b=0 m=1
* device instance PAD24_COS_N.I0._G1_TAP_SYNTAX_XR1 r0 *1 0,0 PTAP1
R616PAD24_COS_N.I0._G1_TAP_SYNTAX_XR1 IOVSS SUBSTRATE_NODE PTAP1 A=67.0344p
+ P=394.32u
* device instance PAD24_COS_N.I4.N0 r0 *1 0,0 sg13_hv_nmos
MPAD24_COS_N.I4.N0 IOVSS PAD24_COS_N.I4.NET2 COS_N SUBSTRATE_NODE sg13_hv_nmos
+ L=0.6u W=88u AS=0p AD=0p PS=0u PD=0u rfmode=0
* device instance PAD24_COS_N.I4._G1_TAP_SYNTAX_XR1 r0 *1 0,0 PTAP1
R618PAD24_COS_N.I4._G1_TAP_SYNTAX_XR1 IOVSS SUBSTRATE_NODE PTAP1 A=55.7736p
+ P=328.08u
* device instance PAD24_COS_N.I4.R0 r0 *1 0,0 RPPD
R619PAD24_COS_N.I4.R0 IOVSS PAD24_COS_N.I4.NET2 SUBSTRATE_NODE RPPD w=0.5u
+ l=3.54u ps=0u b=0 m=1
* device instance PAD12_FAULT_N._G1_TAP_SYNTAX_XR1 r0 *1 0,0 PTAP1
R620PAD12_FAULT_N._G1_TAP_SYNTAX_XR1 IOVSS SUBSTRATE_NODE PTAP1 A=4319.178p
+ P=671.66u
* device instance PAD12_FAULT_N._G1_TAP_SYNTAX_XR0 r0 *1 0,0 PTAP1
R621PAD12_FAULT_N._G1_TAP_SYNTAX_XR0 VSS SUBSTRATE_NODE PTAP1 A=24p P=160.6u
* device instance PAD12_FAULT_N.I2.I1.N1 r0 *1 0,0 sg13_lv_nmos
MPAD12_FAULT_N.I2.I1.N1 VSS FAULT_N_C2P PAD12_FAULT_N.I2.I1.NET2 SUBSTRATE_NODE
+ sg13_lv_nmos L=0.13u W=2.75u AS=0p AD=0p PS=0u PD=0u rfmode=0
* device instance PAD12_FAULT_N.I2.I1.P3 r0 *1 0,0 sg13_lv_pmos
MPAD12_FAULT_N.I2.I1.P3 VDD FAULT_N_C2P PAD12_FAULT_N.I2.I1.NET2 VDD
+ sg13_lv_pmos L=0.13u W=4.75u AS=0p AD=0p PS=0u PD=0u rfmode=0
* device instance PAD12_FAULT_N.I2.I1.N0 r0 *1 0,0 sg13_hv_nmos
MPAD12_FAULT_N.I2.I1.N0 VSS PAD12_FAULT_N.I2.I1.NET4 PAD12_FAULT_N.NET1
+ SUBSTRATE_NODE sg13_hv_nmos L=0.45u W=1.9u AS=0p AD=0p PS=0u PD=0u rfmode=0
* device instance PAD12_FAULT_N.I2.I1.N3 r0 *1 0,0 sg13_hv_nmos
MPAD12_FAULT_N.I2.I1.N3 VSS PAD12_FAULT_N.I2.I1.NET2 PAD12_FAULT_N.I2.I1.NET4
+ SUBSTRATE_NODE sg13_hv_nmos L=0.45u W=1.9u AS=0p AD=0p PS=0u PD=0u rfmode=0
* device instance PAD12_FAULT_N.I2.I1.N2 r0 *1 0,0 sg13_hv_nmos
MPAD12_FAULT_N.I2.I1.N2 VSS FAULT_N_C2P PAD12_FAULT_N.I2.I1.NET3 SUBSTRATE_NODE
+ sg13_hv_nmos L=0.45u W=1.9u AS=0p AD=0p PS=0u PD=0u rfmode=0
* device instance PAD12_FAULT_N.I2.I1.P0 r0 *1 0,0 sg13_hv_pmos
MPAD12_FAULT_N.I2.I1.P0 IOVDD PAD12_FAULT_N.I2.I1.NET4 PAD12_FAULT_N.NET1 IOVDD
+ sg13_hv_pmos L=0.45u W=3.9u AS=0p AD=0p PS=0u PD=0u rfmode=0
* device instance PAD12_FAULT_N.I2.I1.P1 r0 *1 0,0 sg13_hv_pmos
MPAD12_FAULT_N.I2.I1.P1 IOVDD PAD12_FAULT_N.I2.I1.NET4 PAD12_FAULT_N.I2.I1.NET3
+ IOVDD sg13_hv_pmos L=0.45u W=0.3u AS=0p AD=0p PS=0u PD=0u rfmode=0
* device instance PAD12_FAULT_N.I2.I1.P2 r0 *1 0,0 sg13_hv_pmos
MPAD12_FAULT_N.I2.I1.P2 IOVDD PAD12_FAULT_N.I2.I1.NET3 PAD12_FAULT_N.I2.I1.NET4
+ IOVDD sg13_hv_pmos L=0.45u W=0.3u AS=0p AD=0p PS=0u PD=0u rfmode=0
* device instance PAD12_FAULT_N.I2.I1._G1_TAP_SYNTAX_XR0 r0 *1 0,0 PTAP1
R630PAD12_FAULT_N.I2.I1._G1_TAP_SYNTAX_XR0 VSS SUBSTRATE_NODE PTAP1 A=1.053p
+ P=7.62u
* device instance PAD12_FAULT_N.I2.I0.N1 r0 *1 0,0 sg13_lv_nmos
MPAD12_FAULT_N.I2.I0.N1 VSS FAULT_N_C2P PAD12_FAULT_N.I2.I0.NET2 SUBSTRATE_NODE
+ sg13_lv_nmos L=0.13u W=2.75u AS=0p AD=0p PS=0u PD=0u rfmode=0
* device instance PAD12_FAULT_N.I2.I0.P3 r0 *1 0,0 sg13_lv_pmos
MPAD12_FAULT_N.I2.I0.P3 VDD FAULT_N_C2P PAD12_FAULT_N.I2.I0.NET2 VDD
+ sg13_lv_pmos L=0.13u W=4.75u AS=0p AD=0p PS=0u PD=0u rfmode=0
* device instance PAD12_FAULT_N.I2.I0.N0 r0 *1 0,0 sg13_hv_nmos
MPAD12_FAULT_N.I2.I0.N0 VSS PAD12_FAULT_N.I2.I0.NET4 PAD12_FAULT_N.NET2
+ SUBSTRATE_NODE sg13_hv_nmos L=0.45u W=1.9u AS=0p AD=0p PS=0u PD=0u rfmode=0
* device instance PAD12_FAULT_N.I2.I0.N3 r0 *1 0,0 sg13_hv_nmos
MPAD12_FAULT_N.I2.I0.N3 VSS PAD12_FAULT_N.I2.I0.NET2 PAD12_FAULT_N.I2.I0.NET4
+ SUBSTRATE_NODE sg13_hv_nmos L=0.45u W=1.9u AS=0p AD=0p PS=0u PD=0u rfmode=0
* device instance PAD12_FAULT_N.I2.I0.N2 r0 *1 0,0 sg13_hv_nmos
MPAD12_FAULT_N.I2.I0.N2 VSS FAULT_N_C2P PAD12_FAULT_N.I2.I0.NET3 SUBSTRATE_NODE
+ sg13_hv_nmos L=0.45u W=1.9u AS=0p AD=0p PS=0u PD=0u rfmode=0
* device instance PAD12_FAULT_N.I2.I0.P0 r0 *1 0,0 sg13_hv_pmos
MPAD12_FAULT_N.I2.I0.P0 IOVDD PAD12_FAULT_N.I2.I0.NET4 PAD12_FAULT_N.NET2 IOVDD
+ sg13_hv_pmos L=0.45u W=3.9u AS=0p AD=0p PS=0u PD=0u rfmode=0
* device instance PAD12_FAULT_N.I2.I0.P1 r0 *1 0,0 sg13_hv_pmos
MPAD12_FAULT_N.I2.I0.P1 IOVDD PAD12_FAULT_N.I2.I0.NET4 PAD12_FAULT_N.I2.I0.NET3
+ IOVDD sg13_hv_pmos L=0.45u W=0.3u AS=0p AD=0p PS=0u PD=0u rfmode=0
* device instance PAD12_FAULT_N.I2.I0.P2 r0 *1 0,0 sg13_hv_pmos
MPAD12_FAULT_N.I2.I0.P2 IOVDD PAD12_FAULT_N.I2.I0.NET3 PAD12_FAULT_N.I2.I0.NET4
+ IOVDD sg13_hv_pmos L=0.45u W=0.3u AS=0p AD=0p PS=0u PD=0u rfmode=0
* device instance PAD12_FAULT_N.I2.I0._G1_TAP_SYNTAX_XR0 r0 *1 0,0 PTAP1
R639PAD12_FAULT_N.I2.I0._G1_TAP_SYNTAX_XR0 VSS SUBSTRATE_NODE PTAP1 A=1.053p
+ P=7.62u
* device instance PAD12_FAULT_N.I4.D1 r0 *1 0,0 DANTENNA
D640PAD12_FAULT_N.I4.D1 SUBSTRATE_NODE FAULT_N DANTENNA A=35.003p P=58.08u m=1
* device instance PAD12_FAULT_N.I4.D0 r0 *1 0,0 DANTENNA
D641PAD12_FAULT_N.I4.D0 SUBSTRATE_NODE FAULT_N DANTENNA A=35.003p P=58.08u m=1
* device instance PAD12_FAULT_N.I4._G1_TAP_SYNTAX_XR0 r0 *1 0,0 PTAP1
R642PAD12_FAULT_N.I4._G1_TAP_SYNTAX_XR0 IOVSS SUBSTRATE_NODE PTAP1 A=141.2964p
+ P=221.76u
* device instance PAD12_FAULT_N.I1.D1 r0 *1 0,0 DPANTENNA
D643PAD12_FAULT_N.I1.D1 FAULT_N IOVDD DPANTENNA A=35.003p P=58.08u m=1
* device instance PAD12_FAULT_N.I1.D0 r0 *1 0,0 DPANTENNA
D644PAD12_FAULT_N.I1.D0 FAULT_N IOVDD DPANTENNA A=35.003p P=58.08u m=1
* device instance PAD12_FAULT_N.I1._G1_TAP_SYNTAX_XR0 r0 *1 0,0 PTAP1
R645PAD12_FAULT_N.I1._G1_TAP_SYNTAX_XR0 IOVSS SUBSTRATE_NODE PTAP1 A=33.5104p
+ P=197.12u
* device instance PAD12_FAULT_N.I0.D0 r0 *1 0,0 DPANTENNA
D646PAD12_FAULT_N.I0.D0 PAD12_FAULT_N.NET1 IOVDD DPANTENNA A=0.2304p P=1.92u m=1
* device instance PAD12_FAULT_N.I0.P1 r0 *1 0,0 sg13_hv_pmos
MPAD12_FAULT_N.I0.P1 IOVDD PAD12_FAULT_N.NET1 FAULT_N IOVDD sg13_hv_pmos L=0.6u
+ W=13.32u AS=0p AD=0p PS=0u PD=0u rfmode=0
* device instance PAD12_FAULT_N.I0.P0 r0 *1 0,0 sg13_hv_pmos
MPAD12_FAULT_N.I0.P0 IOVDD PAD12_FAULT_N.NET1 FAULT_N IOVDD sg13_hv_pmos L=0.6u
+ W=13.32u AS=0p AD=0p PS=0u PD=0u rfmode=0
* device instance PAD12_FAULT_N.I0._G1_TAP_SYNTAX_XR0 r0 *1 0,0 PTAP1
R649PAD12_FAULT_N.I0._G1_TAP_SYNTAX_XR0 IOVSS SUBSTRATE_NODE PTAP1 A=67.0344p
+ P=394.32u
* device instance PAD12_FAULT_N.I3._G1_TAP_SYNTAX_XR0 r0 *1 0,0 PTAP1
R650PAD12_FAULT_N.I3._G1_TAP_SYNTAX_XR0 IOVSS SUBSTRATE_NODE PTAP1 A=55.7736p
+ P=328.08u
* device instance PAD12_FAULT_N.I3.N1 r0 *1 0,0 sg13_hv_nmos
MPAD12_FAULT_N.I3.N1 IOVSS PAD12_FAULT_N.NET2 FAULT_N SUBSTRATE_NODE
+ sg13_hv_nmos L=0.6u W=8.8u AS=0p AD=0p PS=0u PD=0u rfmode=0
* device instance PAD12_FAULT_N.I3.D0 r0 *1 0,0 DANTENNA
D652PAD12_FAULT_N.I3.D0 SUBSTRATE_NODE PAD12_FAULT_N.NET2 DANTENNA A=0.6084p
+ P=3.12u m=1
* device instance PAD18_SLO_SDO._G1_TAP_SYNTAX_XR1 r0 *1 0,0 PTAP1
R653PAD18_SLO_SDO._G1_TAP_SYNTAX_XR1 IOVSS SUBSTRATE_NODE PTAP1 A=4319.178p
+ P=671.66u
* device instance PAD18_SLO_SDO._G1_TAP_SYNTAX_XR0 r0 *1 0,0 PTAP1
R654PAD18_SLO_SDO._G1_TAP_SYNTAX_XR0 VSS SUBSTRATE_NODE PTAP1 A=24p P=160.6u
* device instance PAD18_SLO_SDO.I2.I1.N1 r0 *1 0,0 sg13_lv_nmos
MPAD18_SLO_SDO.I2.I1.N1 VSS SLO_SDO_C2P PAD18_SLO_SDO.I2.I1.NET2 SUBSTRATE_NODE
+ sg13_lv_nmos L=0.13u W=2.75u AS=0p AD=0p PS=0u PD=0u rfmode=0
* device instance PAD18_SLO_SDO.I2.I1.P3 r0 *1 0,0 sg13_lv_pmos
MPAD18_SLO_SDO.I2.I1.P3 VDD SLO_SDO_C2P PAD18_SLO_SDO.I2.I1.NET2 VDD
+ sg13_lv_pmos L=0.13u W=4.75u AS=0p AD=0p PS=0u PD=0u rfmode=0
* device instance PAD18_SLO_SDO.I2.I1.N0 r0 *1 0,0 sg13_hv_nmos
MPAD18_SLO_SDO.I2.I1.N0 VSS PAD18_SLO_SDO.I2.I1.NET4 PAD18_SLO_SDO.NET1
+ SUBSTRATE_NODE sg13_hv_nmos L=0.45u W=1.9u AS=0p AD=0p PS=0u PD=0u rfmode=0
* device instance PAD18_SLO_SDO.I2.I1.N3 r0 *1 0,0 sg13_hv_nmos
MPAD18_SLO_SDO.I2.I1.N3 VSS PAD18_SLO_SDO.I2.I1.NET2 PAD18_SLO_SDO.I2.I1.NET4
+ SUBSTRATE_NODE sg13_hv_nmos L=0.45u W=1.9u AS=0p AD=0p PS=0u PD=0u rfmode=0
* device instance PAD18_SLO_SDO.I2.I1.N2 r0 *1 0,0 sg13_hv_nmos
MPAD18_SLO_SDO.I2.I1.N2 VSS SLO_SDO_C2P PAD18_SLO_SDO.I2.I1.NET3 SUBSTRATE_NODE
+ sg13_hv_nmos L=0.45u W=1.9u AS=0p AD=0p PS=0u PD=0u rfmode=0
* device instance PAD18_SLO_SDO.I2.I1.P0 r0 *1 0,0 sg13_hv_pmos
MPAD18_SLO_SDO.I2.I1.P0 IOVDD PAD18_SLO_SDO.I2.I1.NET4 PAD18_SLO_SDO.NET1 IOVDD
+ sg13_hv_pmos L=0.45u W=3.9u AS=0p AD=0p PS=0u PD=0u rfmode=0
* device instance PAD18_SLO_SDO.I2.I1.P1 r0 *1 0,0 sg13_hv_pmos
MPAD18_SLO_SDO.I2.I1.P1 IOVDD PAD18_SLO_SDO.I2.I1.NET4 PAD18_SLO_SDO.I2.I1.NET3
+ IOVDD sg13_hv_pmos L=0.45u W=0.3u AS=0p AD=0p PS=0u PD=0u rfmode=0
* device instance PAD18_SLO_SDO.I2.I1.P2 r0 *1 0,0 sg13_hv_pmos
MPAD18_SLO_SDO.I2.I1.P2 IOVDD PAD18_SLO_SDO.I2.I1.NET3 PAD18_SLO_SDO.I2.I1.NET4
+ IOVDD sg13_hv_pmos L=0.45u W=0.3u AS=0p AD=0p PS=0u PD=0u rfmode=0
* device instance PAD18_SLO_SDO.I2.I1._G1_TAP_SYNTAX_XR0 r0 *1 0,0 PTAP1
R663PAD18_SLO_SDO.I2.I1._G1_TAP_SYNTAX_XR0 VSS SUBSTRATE_NODE PTAP1 A=1.053p
+ P=7.62u
* device instance PAD18_SLO_SDO.I2.I0.N1 r0 *1 0,0 sg13_lv_nmos
MPAD18_SLO_SDO.I2.I0.N1 VSS SLO_SDO_C2P PAD18_SLO_SDO.I2.I0.NET2 SUBSTRATE_NODE
+ sg13_lv_nmos L=0.13u W=2.75u AS=0p AD=0p PS=0u PD=0u rfmode=0
* device instance PAD18_SLO_SDO.I2.I0.P3 r0 *1 0,0 sg13_lv_pmos
MPAD18_SLO_SDO.I2.I0.P3 VDD SLO_SDO_C2P PAD18_SLO_SDO.I2.I0.NET2 VDD
+ sg13_lv_pmos L=0.13u W=4.75u AS=0p AD=0p PS=0u PD=0u rfmode=0
* device instance PAD18_SLO_SDO.I2.I0.N0 r0 *1 0,0 sg13_hv_nmos
MPAD18_SLO_SDO.I2.I0.N0 VSS PAD18_SLO_SDO.I2.I0.NET4 PAD18_SLO_SDO.NET2
+ SUBSTRATE_NODE sg13_hv_nmos L=0.45u W=1.9u AS=0p AD=0p PS=0u PD=0u rfmode=0
* device instance PAD18_SLO_SDO.I2.I0.N3 r0 *1 0,0 sg13_hv_nmos
MPAD18_SLO_SDO.I2.I0.N3 VSS PAD18_SLO_SDO.I2.I0.NET2 PAD18_SLO_SDO.I2.I0.NET4
+ SUBSTRATE_NODE sg13_hv_nmos L=0.45u W=1.9u AS=0p AD=0p PS=0u PD=0u rfmode=0
* device instance PAD18_SLO_SDO.I2.I0.N2 r0 *1 0,0 sg13_hv_nmos
MPAD18_SLO_SDO.I2.I0.N2 VSS SLO_SDO_C2P PAD18_SLO_SDO.I2.I0.NET3 SUBSTRATE_NODE
+ sg13_hv_nmos L=0.45u W=1.9u AS=0p AD=0p PS=0u PD=0u rfmode=0
* device instance PAD18_SLO_SDO.I2.I0.P0 r0 *1 0,0 sg13_hv_pmos
MPAD18_SLO_SDO.I2.I0.P0 IOVDD PAD18_SLO_SDO.I2.I0.NET4 PAD18_SLO_SDO.NET2 IOVDD
+ sg13_hv_pmos L=0.45u W=3.9u AS=0p AD=0p PS=0u PD=0u rfmode=0
* device instance PAD18_SLO_SDO.I2.I0.P1 r0 *1 0,0 sg13_hv_pmos
MPAD18_SLO_SDO.I2.I0.P1 IOVDD PAD18_SLO_SDO.I2.I0.NET4 PAD18_SLO_SDO.I2.I0.NET3
+ IOVDD sg13_hv_pmos L=0.45u W=0.3u AS=0p AD=0p PS=0u PD=0u rfmode=0
* device instance PAD18_SLO_SDO.I2.I0.P2 r0 *1 0,0 sg13_hv_pmos
MPAD18_SLO_SDO.I2.I0.P2 IOVDD PAD18_SLO_SDO.I2.I0.NET3 PAD18_SLO_SDO.I2.I0.NET4
+ IOVDD sg13_hv_pmos L=0.45u W=0.3u AS=0p AD=0p PS=0u PD=0u rfmode=0
* device instance PAD18_SLO_SDO.I2.I0._G1_TAP_SYNTAX_XR0 r0 *1 0,0 PTAP1
R672PAD18_SLO_SDO.I2.I0._G1_TAP_SYNTAX_XR0 VSS SUBSTRATE_NODE PTAP1 A=1.053p
+ P=7.62u
* device instance PAD18_SLO_SDO.I4.D1 r0 *1 0,0 DANTENNA
D673PAD18_SLO_SDO.I4.D1 SUBSTRATE_NODE SLO_SDO DANTENNA A=35.003p P=58.08u m=1
* device instance PAD18_SLO_SDO.I4.D0 r0 *1 0,0 DANTENNA
D674PAD18_SLO_SDO.I4.D0 SUBSTRATE_NODE SLO_SDO DANTENNA A=35.003p P=58.08u m=1
* device instance PAD18_SLO_SDO.I4._G1_TAP_SYNTAX_XR0 r0 *1 0,0 PTAP1
R675PAD18_SLO_SDO.I4._G1_TAP_SYNTAX_XR0 IOVSS SUBSTRATE_NODE PTAP1 A=141.2964p
+ P=221.76u
* device instance PAD18_SLO_SDO.I1.D1 r0 *1 0,0 DPANTENNA
D676PAD18_SLO_SDO.I1.D1 SLO_SDO IOVDD DPANTENNA A=35.003p P=58.08u m=1
* device instance PAD18_SLO_SDO.I1.D0 r0 *1 0,0 DPANTENNA
D677PAD18_SLO_SDO.I1.D0 SLO_SDO IOVDD DPANTENNA A=35.003p P=58.08u m=1
* device instance PAD18_SLO_SDO.I1._G1_TAP_SYNTAX_XR0 r0 *1 0,0 PTAP1
R678PAD18_SLO_SDO.I1._G1_TAP_SYNTAX_XR0 IOVSS SUBSTRATE_NODE PTAP1 A=33.5104p
+ P=197.12u
* device instance PAD18_SLO_SDO.I0.D0 r0 *1 0,0 DPANTENNA
D679PAD18_SLO_SDO.I0.D0 PAD18_SLO_SDO.NET1 IOVDD DPANTENNA A=0.2304p P=1.92u m=1
* device instance PAD18_SLO_SDO.I0.P1 r0 *1 0,0 sg13_hv_pmos
MPAD18_SLO_SDO.I0.P1 IOVDD PAD18_SLO_SDO.NET1 SLO_SDO IOVDD sg13_hv_pmos L=0.6u
+ W=13.32u AS=0p AD=0p PS=0u PD=0u rfmode=0
* device instance PAD18_SLO_SDO.I0.P0 r0 *1 0,0 sg13_hv_pmos
MPAD18_SLO_SDO.I0.P0 IOVDD PAD18_SLO_SDO.NET1 SLO_SDO IOVDD sg13_hv_pmos L=0.6u
+ W=13.32u AS=0p AD=0p PS=0u PD=0u rfmode=0
* device instance PAD18_SLO_SDO.I0._G1_TAP_SYNTAX_XR0 r0 *1 0,0 PTAP1
R682PAD18_SLO_SDO.I0._G1_TAP_SYNTAX_XR0 IOVSS SUBSTRATE_NODE PTAP1 A=67.0344p
+ P=394.32u
* device instance PAD18_SLO_SDO.I3._G1_TAP_SYNTAX_XR0 r0 *1 0,0 PTAP1
R683PAD18_SLO_SDO.I3._G1_TAP_SYNTAX_XR0 IOVSS SUBSTRATE_NODE PTAP1 A=55.7736p
+ P=328.08u
* device instance PAD18_SLO_SDO.I3.N1 r0 *1 0,0 sg13_hv_nmos
MPAD18_SLO_SDO.I3.N1 IOVSS PAD18_SLO_SDO.NET2 SLO_SDO SUBSTRATE_NODE
+ sg13_hv_nmos L=0.6u W=8.8u AS=0p AD=0p PS=0u PD=0u rfmode=0
* device instance PAD18_SLO_SDO.I3.D0 r0 *1 0,0 DANTENNA
D685PAD18_SLO_SDO.I3.D0 SUBSTRATE_NODE PAD18_SLO_SDO.NET2 DANTENNA A=0.6084p
+ P=3.12u m=1
* device instance PAD13_GATE_A._G1_TAP_SYNTAX_XR0 r0 *1 0,0 PTAP1
R686PAD13_GATE_A._G1_TAP_SYNTAX_XR0 VSS SUBSTRATE_NODE PTAP1 A=24p P=160.6u
* device instance PAD13_GATE_A._G1_TAP_SYNTAX_XR1 r0 *1 0,0 PTAP1
R687PAD13_GATE_A._G1_TAP_SYNTAX_XR1 IOVSS SUBSTRATE_NODE PTAP1 A=4319.178p
+ P=671.66u
* device instance PAD13_GATE_A.I2.I1.N1 r0 *1 0,0 sg13_lv_nmos
MPAD13_GATE_A.I2.I1.N1 VSS GATE_A_C2P PAD13_GATE_A.I2.I1.NET2 SUBSTRATE_NODE
+ sg13_lv_nmos L=0.13u W=2.75u AS=0p AD=0p PS=0u PD=0u rfmode=0
* device instance PAD13_GATE_A.I2.I1.P3 r0 *1 0,0 sg13_lv_pmos
MPAD13_GATE_A.I2.I1.P3 VDD GATE_A_C2P PAD13_GATE_A.I2.I1.NET2 VDD sg13_lv_pmos
+ L=0.13u W=4.75u AS=0p AD=0p PS=0u PD=0u rfmode=0
* device instance PAD13_GATE_A.I2.I1.N0 r0 *1 0,0 sg13_hv_nmos
MPAD13_GATE_A.I2.I1.N0 VSS PAD13_GATE_A.I2.I1.NET4 PAD13_GATE_A.NET1
+ SUBSTRATE_NODE sg13_hv_nmos L=0.45u W=1.9u AS=0p AD=0p PS=0u PD=0u rfmode=0
* device instance PAD13_GATE_A.I2.I1.N3 r0 *1 0,0 sg13_hv_nmos
MPAD13_GATE_A.I2.I1.N3 VSS PAD13_GATE_A.I2.I1.NET2 PAD13_GATE_A.I2.I1.NET4
+ SUBSTRATE_NODE sg13_hv_nmos L=0.45u W=1.9u AS=0p AD=0p PS=0u PD=0u rfmode=0
* device instance PAD13_GATE_A.I2.I1.N2 r0 *1 0,0 sg13_hv_nmos
MPAD13_GATE_A.I2.I1.N2 VSS GATE_A_C2P PAD13_GATE_A.I2.I1.NET3 SUBSTRATE_NODE
+ sg13_hv_nmos L=0.45u W=1.9u AS=0p AD=0p PS=0u PD=0u rfmode=0
* device instance PAD13_GATE_A.I2.I1.P0 r0 *1 0,0 sg13_hv_pmos
MPAD13_GATE_A.I2.I1.P0 IOVDD PAD13_GATE_A.I2.I1.NET4 PAD13_GATE_A.NET1 IOVDD
+ sg13_hv_pmos L=0.45u W=3.9u AS=0p AD=0p PS=0u PD=0u rfmode=0
* device instance PAD13_GATE_A.I2.I1.P1 r0 *1 0,0 sg13_hv_pmos
MPAD13_GATE_A.I2.I1.P1 IOVDD PAD13_GATE_A.I2.I1.NET4 PAD13_GATE_A.I2.I1.NET3
+ IOVDD sg13_hv_pmos L=0.45u W=0.3u AS=0p AD=0p PS=0u PD=0u rfmode=0
* device instance PAD13_GATE_A.I2.I1.P2 r0 *1 0,0 sg13_hv_pmos
MPAD13_GATE_A.I2.I1.P2 IOVDD PAD13_GATE_A.I2.I1.NET3 PAD13_GATE_A.I2.I1.NET4
+ IOVDD sg13_hv_pmos L=0.45u W=0.3u AS=0p AD=0p PS=0u PD=0u rfmode=0
* device instance PAD13_GATE_A.I2.I1._G1_TAP_SYNTAX_XR0 r0 *1 0,0 PTAP1
R696PAD13_GATE_A.I2.I1._G1_TAP_SYNTAX_XR0 VSS SUBSTRATE_NODE PTAP1 A=1.053p
+ P=7.62u
* device instance PAD13_GATE_A.I2.I0.N1 r0 *1 0,0 sg13_lv_nmos
MPAD13_GATE_A.I2.I0.N1 VSS GATE_A_C2P PAD13_GATE_A.I2.I0.NET2 SUBSTRATE_NODE
+ sg13_lv_nmos L=0.13u W=2.75u AS=0p AD=0p PS=0u PD=0u rfmode=0
* device instance PAD13_GATE_A.I2.I0.P3 r0 *1 0,0 sg13_lv_pmos
MPAD13_GATE_A.I2.I0.P3 VDD GATE_A_C2P PAD13_GATE_A.I2.I0.NET2 VDD sg13_lv_pmos
+ L=0.13u W=4.75u AS=0p AD=0p PS=0u PD=0u rfmode=0
* device instance PAD13_GATE_A.I2.I0.N0 r0 *1 0,0 sg13_hv_nmos
MPAD13_GATE_A.I2.I0.N0 VSS PAD13_GATE_A.I2.I0.NET4 PAD13_GATE_A.NET2
+ SUBSTRATE_NODE sg13_hv_nmos L=0.45u W=1.9u AS=0p AD=0p PS=0u PD=0u rfmode=0
* device instance PAD13_GATE_A.I2.I0.N3 r0 *1 0,0 sg13_hv_nmos
MPAD13_GATE_A.I2.I0.N3 VSS PAD13_GATE_A.I2.I0.NET2 PAD13_GATE_A.I2.I0.NET4
+ SUBSTRATE_NODE sg13_hv_nmos L=0.45u W=1.9u AS=0p AD=0p PS=0u PD=0u rfmode=0
* device instance PAD13_GATE_A.I2.I0.N2 r0 *1 0,0 sg13_hv_nmos
MPAD13_GATE_A.I2.I0.N2 VSS GATE_A_C2P PAD13_GATE_A.I2.I0.NET3 SUBSTRATE_NODE
+ sg13_hv_nmos L=0.45u W=1.9u AS=0p AD=0p PS=0u PD=0u rfmode=0
* device instance PAD13_GATE_A.I2.I0.P0 r0 *1 0,0 sg13_hv_pmos
MPAD13_GATE_A.I2.I0.P0 IOVDD PAD13_GATE_A.I2.I0.NET4 PAD13_GATE_A.NET2 IOVDD
+ sg13_hv_pmos L=0.45u W=3.9u AS=0p AD=0p PS=0u PD=0u rfmode=0
* device instance PAD13_GATE_A.I2.I0.P1 r0 *1 0,0 sg13_hv_pmos
MPAD13_GATE_A.I2.I0.P1 IOVDD PAD13_GATE_A.I2.I0.NET4 PAD13_GATE_A.I2.I0.NET3
+ IOVDD sg13_hv_pmos L=0.45u W=0.3u AS=0p AD=0p PS=0u PD=0u rfmode=0
* device instance PAD13_GATE_A.I2.I0.P2 r0 *1 0,0 sg13_hv_pmos
MPAD13_GATE_A.I2.I0.P2 IOVDD PAD13_GATE_A.I2.I0.NET3 PAD13_GATE_A.I2.I0.NET4
+ IOVDD sg13_hv_pmos L=0.45u W=0.3u AS=0p AD=0p PS=0u PD=0u rfmode=0
* device instance PAD13_GATE_A.I2.I0._G1_TAP_SYNTAX_XR0 r0 *1 0,0 PTAP1
R705PAD13_GATE_A.I2.I0._G1_TAP_SYNTAX_XR0 VSS SUBSTRATE_NODE PTAP1 A=1.053p
+ P=7.62u
* device instance PAD13_GATE_A.I4.D1 r0 *1 0,0 DANTENNA
D706PAD13_GATE_A.I4.D1 SUBSTRATE_NODE GATE_A DANTENNA A=35.003p P=58.08u m=1
* device instance PAD13_GATE_A.I4.D0 r0 *1 0,0 DANTENNA
D707PAD13_GATE_A.I4.D0 SUBSTRATE_NODE GATE_A DANTENNA A=35.003p P=58.08u m=1
* device instance PAD13_GATE_A.I4._G1_TAP_SYNTAX_XR0 r0 *1 0,0 PTAP1
R708PAD13_GATE_A.I4._G1_TAP_SYNTAX_XR0 IOVSS SUBSTRATE_NODE PTAP1 A=141.2964p
+ P=221.76u
* device instance PAD13_GATE_A.I0.D1 r0 *1 0,0 DPANTENNA
D709PAD13_GATE_A.I0.D1 GATE_A IOVDD DPANTENNA A=35.003p P=58.08u m=1
* device instance PAD13_GATE_A.I0.D0 r0 *1 0,0 DPANTENNA
D710PAD13_GATE_A.I0.D0 GATE_A IOVDD DPANTENNA A=35.003p P=58.08u m=1
* device instance PAD13_GATE_A.I0._G1_TAP_SYNTAX_XR0 r0 *1 0,0 PTAP1
R711PAD13_GATE_A.I0._G1_TAP_SYNTAX_XR0 IOVSS SUBSTRATE_NODE PTAP1 A=33.5104p
+ P=197.12u
* device instance PAD13_GATE_A.I1.D0 r0 *1 0,0 DPANTENNA
D712PAD13_GATE_A.I1.D0 PAD13_GATE_A.NET1 IOVDD DPANTENNA A=0.6084p P=3.12u m=1
* device instance PAD13_GATE_A.I1._G1_TAP_SYNTAX_XR0 r0 *1 0,0 PTAP1
R713PAD13_GATE_A.I1._G1_TAP_SYNTAX_XR0 IOVSS SUBSTRATE_NODE PTAP1 A=67.0344p
+ P=394.32u
* device instance PAD13_GATE_A.I1.P1 r0 *1 0,0 sg13_hv_pmos
MPAD13_GATE_A.I1.P1 IOVDD PAD13_GATE_A.NET1 GATE_A IOVDD sg13_hv_pmos L=0.6u
+ W=99.9u AS=0p AD=0p PS=0u PD=0u rfmode=0
* device instance PAD13_GATE_A.I1.P0 r0 *1 0,0 sg13_hv_pmos
MPAD13_GATE_A.I1.P0 IOVDD PAD13_GATE_A.NET1 GATE_A IOVDD sg13_hv_pmos L=0.6u
+ W=99.9u AS=0p AD=0p PS=0u PD=0u rfmode=0
* device instance PAD13_GATE_A.I3._G1_TAP_SYNTAX_XR0 r0 *1 0,0 PTAP1
R716PAD13_GATE_A.I3._G1_TAP_SYNTAX_XR0 IOVSS SUBSTRATE_NODE PTAP1 A=55.7736p
+ P=328.08u
* device instance PAD13_GATE_A.I3.N0 r0 *1 0,0 sg13_hv_nmos
MPAD13_GATE_A.I3.N0 IOVSS PAD13_GATE_A.NET2 GATE_A SUBSTRATE_NODE sg13_hv_nmos
+ L=0.6u W=66u AS=0p AD=0p PS=0u PD=0u rfmode=0
* device instance PAD13_GATE_A.I3.D0 r0 *1 0,0 DANTENNA
D718PAD13_GATE_A.I3.D0 SUBSTRATE_NODE PAD13_GATE_A.NET2 DANTENNA A=0.6084p
+ P=3.12u m=1
* device instance PAD14_GATE_B._G1_TAP_SYNTAX_XR0 r0 *1 0,0 PTAP1
R719PAD14_GATE_B._G1_TAP_SYNTAX_XR0 VSS SUBSTRATE_NODE PTAP1 A=24p P=160.6u
* device instance PAD14_GATE_B._G1_TAP_SYNTAX_XR1 r0 *1 0,0 PTAP1
R720PAD14_GATE_B._G1_TAP_SYNTAX_XR1 IOVSS SUBSTRATE_NODE PTAP1 A=4319.178p
+ P=671.66u
* device instance PAD14_GATE_B.I2.I1.N1 r0 *1 0,0 sg13_lv_nmos
MPAD14_GATE_B.I2.I1.N1 VSS GATE_B_C2P PAD14_GATE_B.I2.I1.NET2 SUBSTRATE_NODE
+ sg13_lv_nmos L=0.13u W=2.75u AS=0p AD=0p PS=0u PD=0u rfmode=0
* device instance PAD14_GATE_B.I2.I1.P3 r0 *1 0,0 sg13_lv_pmos
MPAD14_GATE_B.I2.I1.P3 VDD GATE_B_C2P PAD14_GATE_B.I2.I1.NET2 VDD sg13_lv_pmos
+ L=0.13u W=4.75u AS=0p AD=0p PS=0u PD=0u rfmode=0
* device instance PAD14_GATE_B.I2.I1.N0 r0 *1 0,0 sg13_hv_nmos
MPAD14_GATE_B.I2.I1.N0 VSS PAD14_GATE_B.I2.I1.NET4 PAD14_GATE_B.NET1
+ SUBSTRATE_NODE sg13_hv_nmos L=0.45u W=1.9u AS=0p AD=0p PS=0u PD=0u rfmode=0
* device instance PAD14_GATE_B.I2.I1.N3 r0 *1 0,0 sg13_hv_nmos
MPAD14_GATE_B.I2.I1.N3 VSS PAD14_GATE_B.I2.I1.NET2 PAD14_GATE_B.I2.I1.NET4
+ SUBSTRATE_NODE sg13_hv_nmos L=0.45u W=1.9u AS=0p AD=0p PS=0u PD=0u rfmode=0
* device instance PAD14_GATE_B.I2.I1.N2 r0 *1 0,0 sg13_hv_nmos
MPAD14_GATE_B.I2.I1.N2 VSS GATE_B_C2P PAD14_GATE_B.I2.I1.NET3 SUBSTRATE_NODE
+ sg13_hv_nmos L=0.45u W=1.9u AS=0p AD=0p PS=0u PD=0u rfmode=0
* device instance PAD14_GATE_B.I2.I1.P0 r0 *1 0,0 sg13_hv_pmos
MPAD14_GATE_B.I2.I1.P0 IOVDD PAD14_GATE_B.I2.I1.NET4 PAD14_GATE_B.NET1 IOVDD
+ sg13_hv_pmos L=0.45u W=3.9u AS=0p AD=0p PS=0u PD=0u rfmode=0
* device instance PAD14_GATE_B.I2.I1.P1 r0 *1 0,0 sg13_hv_pmos
MPAD14_GATE_B.I2.I1.P1 IOVDD PAD14_GATE_B.I2.I1.NET4 PAD14_GATE_B.I2.I1.NET3
+ IOVDD sg13_hv_pmos L=0.45u W=0.3u AS=0p AD=0p PS=0u PD=0u rfmode=0
* device instance PAD14_GATE_B.I2.I1.P2 r0 *1 0,0 sg13_hv_pmos
MPAD14_GATE_B.I2.I1.P2 IOVDD PAD14_GATE_B.I2.I1.NET3 PAD14_GATE_B.I2.I1.NET4
+ IOVDD sg13_hv_pmos L=0.45u W=0.3u AS=0p AD=0p PS=0u PD=0u rfmode=0
* device instance PAD14_GATE_B.I2.I1._G1_TAP_SYNTAX_XR0 r0 *1 0,0 PTAP1
R729PAD14_GATE_B.I2.I1._G1_TAP_SYNTAX_XR0 VSS SUBSTRATE_NODE PTAP1 A=1.053p
+ P=7.62u
* device instance PAD14_GATE_B.I2.I0.N1 r0 *1 0,0 sg13_lv_nmos
MPAD14_GATE_B.I2.I0.N1 VSS GATE_B_C2P PAD14_GATE_B.I2.I0.NET2 SUBSTRATE_NODE
+ sg13_lv_nmos L=0.13u W=2.75u AS=0p AD=0p PS=0u PD=0u rfmode=0
* device instance PAD14_GATE_B.I2.I0.P3 r0 *1 0,0 sg13_lv_pmos
MPAD14_GATE_B.I2.I0.P3 VDD GATE_B_C2P PAD14_GATE_B.I2.I0.NET2 VDD sg13_lv_pmos
+ L=0.13u W=4.75u AS=0p AD=0p PS=0u PD=0u rfmode=0
* device instance PAD14_GATE_B.I2.I0.N0 r0 *1 0,0 sg13_hv_nmos
MPAD14_GATE_B.I2.I0.N0 VSS PAD14_GATE_B.I2.I0.NET4 PAD14_GATE_B.NET2
+ SUBSTRATE_NODE sg13_hv_nmos L=0.45u W=1.9u AS=0p AD=0p PS=0u PD=0u rfmode=0
* device instance PAD14_GATE_B.I2.I0.N3 r0 *1 0,0 sg13_hv_nmos
MPAD14_GATE_B.I2.I0.N3 VSS PAD14_GATE_B.I2.I0.NET2 PAD14_GATE_B.I2.I0.NET4
+ SUBSTRATE_NODE sg13_hv_nmos L=0.45u W=1.9u AS=0p AD=0p PS=0u PD=0u rfmode=0
* device instance PAD14_GATE_B.I2.I0.N2 r0 *1 0,0 sg13_hv_nmos
MPAD14_GATE_B.I2.I0.N2 VSS GATE_B_C2P PAD14_GATE_B.I2.I0.NET3 SUBSTRATE_NODE
+ sg13_hv_nmos L=0.45u W=1.9u AS=0p AD=0p PS=0u PD=0u rfmode=0
* device instance PAD14_GATE_B.I2.I0.P0 r0 *1 0,0 sg13_hv_pmos
MPAD14_GATE_B.I2.I0.P0 IOVDD PAD14_GATE_B.I2.I0.NET4 PAD14_GATE_B.NET2 IOVDD
+ sg13_hv_pmos L=0.45u W=3.9u AS=0p AD=0p PS=0u PD=0u rfmode=0
* device instance PAD14_GATE_B.I2.I0.P1 r0 *1 0,0 sg13_hv_pmos
MPAD14_GATE_B.I2.I0.P1 IOVDD PAD14_GATE_B.I2.I0.NET4 PAD14_GATE_B.I2.I0.NET3
+ IOVDD sg13_hv_pmos L=0.45u W=0.3u AS=0p AD=0p PS=0u PD=0u rfmode=0
* device instance PAD14_GATE_B.I2.I0.P2 r0 *1 0,0 sg13_hv_pmos
MPAD14_GATE_B.I2.I0.P2 IOVDD PAD14_GATE_B.I2.I0.NET3 PAD14_GATE_B.I2.I0.NET4
+ IOVDD sg13_hv_pmos L=0.45u W=0.3u AS=0p AD=0p PS=0u PD=0u rfmode=0
* device instance PAD14_GATE_B.I2.I0._G1_TAP_SYNTAX_XR0 r0 *1 0,0 PTAP1
R738PAD14_GATE_B.I2.I0._G1_TAP_SYNTAX_XR0 VSS SUBSTRATE_NODE PTAP1 A=1.053p
+ P=7.62u
* device instance PAD14_GATE_B.I4.D1 r0 *1 0,0 DANTENNA
D739PAD14_GATE_B.I4.D1 SUBSTRATE_NODE GATE_B DANTENNA A=35.003p P=58.08u m=1
* device instance PAD14_GATE_B.I4.D0 r0 *1 0,0 DANTENNA
D740PAD14_GATE_B.I4.D0 SUBSTRATE_NODE GATE_B DANTENNA A=35.003p P=58.08u m=1
* device instance PAD14_GATE_B.I4._G1_TAP_SYNTAX_XR0 r0 *1 0,0 PTAP1
R741PAD14_GATE_B.I4._G1_TAP_SYNTAX_XR0 IOVSS SUBSTRATE_NODE PTAP1 A=141.2964p
+ P=221.76u
* device instance PAD14_GATE_B.I0.D1 r0 *1 0,0 DPANTENNA
D742PAD14_GATE_B.I0.D1 GATE_B IOVDD DPANTENNA A=35.003p P=58.08u m=1
* device instance PAD14_GATE_B.I0.D0 r0 *1 0,0 DPANTENNA
D743PAD14_GATE_B.I0.D0 GATE_B IOVDD DPANTENNA A=35.003p P=58.08u m=1
* device instance PAD14_GATE_B.I0._G1_TAP_SYNTAX_XR0 r0 *1 0,0 PTAP1
R744PAD14_GATE_B.I0._G1_TAP_SYNTAX_XR0 IOVSS SUBSTRATE_NODE PTAP1 A=33.5104p
+ P=197.12u
* device instance PAD14_GATE_B.I1.D0 r0 *1 0,0 DPANTENNA
D745PAD14_GATE_B.I1.D0 PAD14_GATE_B.NET1 IOVDD DPANTENNA A=0.6084p P=3.12u m=1
* device instance PAD14_GATE_B.I1._G1_TAP_SYNTAX_XR0 r0 *1 0,0 PTAP1
R746PAD14_GATE_B.I1._G1_TAP_SYNTAX_XR0 IOVSS SUBSTRATE_NODE PTAP1 A=67.0344p
+ P=394.32u
* device instance PAD14_GATE_B.I1.P1 r0 *1 0,0 sg13_hv_pmos
MPAD14_GATE_B.I1.P1 IOVDD PAD14_GATE_B.NET1 GATE_B IOVDD sg13_hv_pmos L=0.6u
+ W=99.9u AS=0p AD=0p PS=0u PD=0u rfmode=0
* device instance PAD14_GATE_B.I1.P0 r0 *1 0,0 sg13_hv_pmos
MPAD14_GATE_B.I1.P0 IOVDD PAD14_GATE_B.NET1 GATE_B IOVDD sg13_hv_pmos L=0.6u
+ W=99.9u AS=0p AD=0p PS=0u PD=0u rfmode=0
* device instance PAD14_GATE_B.I3._G1_TAP_SYNTAX_XR0 r0 *1 0,0 PTAP1
R749PAD14_GATE_B.I3._G1_TAP_SYNTAX_XR0 IOVSS SUBSTRATE_NODE PTAP1 A=55.7736p
+ P=328.08u
* device instance PAD14_GATE_B.I3.N0 r0 *1 0,0 sg13_hv_nmos
MPAD14_GATE_B.I3.N0 IOVSS PAD14_GATE_B.NET2 GATE_B SUBSTRATE_NODE sg13_hv_nmos
+ L=0.6u W=66u AS=0p AD=0p PS=0u PD=0u rfmode=0
* device instance PAD14_GATE_B.I3.D0 r0 *1 0,0 DANTENNA
D751PAD14_GATE_B.I3.D0 SUBSTRATE_NODE PAD14_GATE_B.NET2 DANTENNA A=0.6084p
+ P=3.12u m=1
* device instance PAD15_GATE_C._G1_TAP_SYNTAX_XR0 r0 *1 0,0 PTAP1
R752PAD15_GATE_C._G1_TAP_SYNTAX_XR0 VSS SUBSTRATE_NODE PTAP1 A=24p P=160.6u
* device instance PAD15_GATE_C._G1_TAP_SYNTAX_XR1 r0 *1 0,0 PTAP1
R753PAD15_GATE_C._G1_TAP_SYNTAX_XR1 IOVSS SUBSTRATE_NODE PTAP1 A=4319.178p
+ P=671.66u
* device instance PAD15_GATE_C.I2.I1.N1 r0 *1 0,0 sg13_lv_nmos
MPAD15_GATE_C.I2.I1.N1 VSS GATE_C_C2P PAD15_GATE_C.I2.I1.NET2 SUBSTRATE_NODE
+ sg13_lv_nmos L=0.13u W=2.75u AS=0p AD=0p PS=0u PD=0u rfmode=0
* device instance PAD15_GATE_C.I2.I1.P3 r0 *1 0,0 sg13_lv_pmos
MPAD15_GATE_C.I2.I1.P3 VDD GATE_C_C2P PAD15_GATE_C.I2.I1.NET2 VDD sg13_lv_pmos
+ L=0.13u W=4.75u AS=0p AD=0p PS=0u PD=0u rfmode=0
* device instance PAD15_GATE_C.I2.I1.N0 r0 *1 0,0 sg13_hv_nmos
MPAD15_GATE_C.I2.I1.N0 VSS PAD15_GATE_C.I2.I1.NET4 PAD15_GATE_C.NET1
+ SUBSTRATE_NODE sg13_hv_nmos L=0.45u W=1.9u AS=0p AD=0p PS=0u PD=0u rfmode=0
* device instance PAD15_GATE_C.I2.I1.N3 r0 *1 0,0 sg13_hv_nmos
MPAD15_GATE_C.I2.I1.N3 VSS PAD15_GATE_C.I2.I1.NET2 PAD15_GATE_C.I2.I1.NET4
+ SUBSTRATE_NODE sg13_hv_nmos L=0.45u W=1.9u AS=0p AD=0p PS=0u PD=0u rfmode=0
* device instance PAD15_GATE_C.I2.I1.N2 r0 *1 0,0 sg13_hv_nmos
MPAD15_GATE_C.I2.I1.N2 VSS GATE_C_C2P PAD15_GATE_C.I2.I1.NET3 SUBSTRATE_NODE
+ sg13_hv_nmos L=0.45u W=1.9u AS=0p AD=0p PS=0u PD=0u rfmode=0
* device instance PAD15_GATE_C.I2.I1.P0 r0 *1 0,0 sg13_hv_pmos
MPAD15_GATE_C.I2.I1.P0 IOVDD PAD15_GATE_C.I2.I1.NET4 PAD15_GATE_C.NET1 IOVDD
+ sg13_hv_pmos L=0.45u W=3.9u AS=0p AD=0p PS=0u PD=0u rfmode=0
* device instance PAD15_GATE_C.I2.I1.P1 r0 *1 0,0 sg13_hv_pmos
MPAD15_GATE_C.I2.I1.P1 IOVDD PAD15_GATE_C.I2.I1.NET4 PAD15_GATE_C.I2.I1.NET3
+ IOVDD sg13_hv_pmos L=0.45u W=0.3u AS=0p AD=0p PS=0u PD=0u rfmode=0
* device instance PAD15_GATE_C.I2.I1.P2 r0 *1 0,0 sg13_hv_pmos
MPAD15_GATE_C.I2.I1.P2 IOVDD PAD15_GATE_C.I2.I1.NET3 PAD15_GATE_C.I2.I1.NET4
+ IOVDD sg13_hv_pmos L=0.45u W=0.3u AS=0p AD=0p PS=0u PD=0u rfmode=0
* device instance PAD15_GATE_C.I2.I1._G1_TAP_SYNTAX_XR0 r0 *1 0,0 PTAP1
R762PAD15_GATE_C.I2.I1._G1_TAP_SYNTAX_XR0 VSS SUBSTRATE_NODE PTAP1 A=1.053p
+ P=7.62u
* device instance PAD15_GATE_C.I2.I0.N1 r0 *1 0,0 sg13_lv_nmos
MPAD15_GATE_C.I2.I0.N1 VSS GATE_C_C2P PAD15_GATE_C.I2.I0.NET2 SUBSTRATE_NODE
+ sg13_lv_nmos L=0.13u W=2.75u AS=0p AD=0p PS=0u PD=0u rfmode=0
* device instance PAD15_GATE_C.I2.I0.P3 r0 *1 0,0 sg13_lv_pmos
MPAD15_GATE_C.I2.I0.P3 VDD GATE_C_C2P PAD15_GATE_C.I2.I0.NET2 VDD sg13_lv_pmos
+ L=0.13u W=4.75u AS=0p AD=0p PS=0u PD=0u rfmode=0
* device instance PAD15_GATE_C.I2.I0.N0 r0 *1 0,0 sg13_hv_nmos
MPAD15_GATE_C.I2.I0.N0 VSS PAD15_GATE_C.I2.I0.NET4 PAD15_GATE_C.NET2
+ SUBSTRATE_NODE sg13_hv_nmos L=0.45u W=1.9u AS=0p AD=0p PS=0u PD=0u rfmode=0
* device instance PAD15_GATE_C.I2.I0.N3 r0 *1 0,0 sg13_hv_nmos
MPAD15_GATE_C.I2.I0.N3 VSS PAD15_GATE_C.I2.I0.NET2 PAD15_GATE_C.I2.I0.NET4
+ SUBSTRATE_NODE sg13_hv_nmos L=0.45u W=1.9u AS=0p AD=0p PS=0u PD=0u rfmode=0
* device instance PAD15_GATE_C.I2.I0.N2 r0 *1 0,0 sg13_hv_nmos
MPAD15_GATE_C.I2.I0.N2 VSS GATE_C_C2P PAD15_GATE_C.I2.I0.NET3 SUBSTRATE_NODE
+ sg13_hv_nmos L=0.45u W=1.9u AS=0p AD=0p PS=0u PD=0u rfmode=0
* device instance PAD15_GATE_C.I2.I0.P0 r0 *1 0,0 sg13_hv_pmos
MPAD15_GATE_C.I2.I0.P0 IOVDD PAD15_GATE_C.I2.I0.NET4 PAD15_GATE_C.NET2 IOVDD
+ sg13_hv_pmos L=0.45u W=3.9u AS=0p AD=0p PS=0u PD=0u rfmode=0
* device instance PAD15_GATE_C.I2.I0.P1 r0 *1 0,0 sg13_hv_pmos
MPAD15_GATE_C.I2.I0.P1 IOVDD PAD15_GATE_C.I2.I0.NET4 PAD15_GATE_C.I2.I0.NET3
+ IOVDD sg13_hv_pmos L=0.45u W=0.3u AS=0p AD=0p PS=0u PD=0u rfmode=0
* device instance PAD15_GATE_C.I2.I0.P2 r0 *1 0,0 sg13_hv_pmos
MPAD15_GATE_C.I2.I0.P2 IOVDD PAD15_GATE_C.I2.I0.NET3 PAD15_GATE_C.I2.I0.NET4
+ IOVDD sg13_hv_pmos L=0.45u W=0.3u AS=0p AD=0p PS=0u PD=0u rfmode=0
* device instance PAD15_GATE_C.I2.I0._G1_TAP_SYNTAX_XR0 r0 *1 0,0 PTAP1
R771PAD15_GATE_C.I2.I0._G1_TAP_SYNTAX_XR0 VSS SUBSTRATE_NODE PTAP1 A=1.053p
+ P=7.62u
* device instance PAD15_GATE_C.I4.D1 r0 *1 0,0 DANTENNA
D772PAD15_GATE_C.I4.D1 SUBSTRATE_NODE GATE_C DANTENNA A=35.003p P=58.08u m=1
* device instance PAD15_GATE_C.I4.D0 r0 *1 0,0 DANTENNA
D773PAD15_GATE_C.I4.D0 SUBSTRATE_NODE GATE_C DANTENNA A=35.003p P=58.08u m=1
* device instance PAD15_GATE_C.I4._G1_TAP_SYNTAX_XR0 r0 *1 0,0 PTAP1
R774PAD15_GATE_C.I4._G1_TAP_SYNTAX_XR0 IOVSS SUBSTRATE_NODE PTAP1 A=141.2964p
+ P=221.76u
* device instance PAD15_GATE_C.I0.D1 r0 *1 0,0 DPANTENNA
D775PAD15_GATE_C.I0.D1 GATE_C IOVDD DPANTENNA A=35.003p P=58.08u m=1
* device instance PAD15_GATE_C.I0.D0 r0 *1 0,0 DPANTENNA
D776PAD15_GATE_C.I0.D0 GATE_C IOVDD DPANTENNA A=35.003p P=58.08u m=1
* device instance PAD15_GATE_C.I0._G1_TAP_SYNTAX_XR0 r0 *1 0,0 PTAP1
R777PAD15_GATE_C.I0._G1_TAP_SYNTAX_XR0 IOVSS SUBSTRATE_NODE PTAP1 A=33.5104p
+ P=197.12u
* device instance PAD15_GATE_C.I1.D0 r0 *1 0,0 DPANTENNA
D778PAD15_GATE_C.I1.D0 PAD15_GATE_C.NET1 IOVDD DPANTENNA A=0.6084p P=3.12u m=1
* device instance PAD15_GATE_C.I1._G1_TAP_SYNTAX_XR0 r0 *1 0,0 PTAP1
R779PAD15_GATE_C.I1._G1_TAP_SYNTAX_XR0 IOVSS SUBSTRATE_NODE PTAP1 A=67.0344p
+ P=394.32u
* device instance PAD15_GATE_C.I1.P1 r0 *1 0,0 sg13_hv_pmos
MPAD15_GATE_C.I1.P1 IOVDD PAD15_GATE_C.NET1 GATE_C IOVDD sg13_hv_pmos L=0.6u
+ W=99.9u AS=0p AD=0p PS=0u PD=0u rfmode=0
* device instance PAD15_GATE_C.I1.P0 r0 *1 0,0 sg13_hv_pmos
MPAD15_GATE_C.I1.P0 IOVDD PAD15_GATE_C.NET1 GATE_C IOVDD sg13_hv_pmos L=0.6u
+ W=99.9u AS=0p AD=0p PS=0u PD=0u rfmode=0
* device instance PAD15_GATE_C.I3._G1_TAP_SYNTAX_XR0 r0 *1 0,0 PTAP1
R782PAD15_GATE_C.I3._G1_TAP_SYNTAX_XR0 IOVSS SUBSTRATE_NODE PTAP1 A=55.7736p
+ P=328.08u
* device instance PAD15_GATE_C.I3.N0 r0 *1 0,0 sg13_hv_nmos
MPAD15_GATE_C.I3.N0 IOVSS PAD15_GATE_C.NET2 GATE_C SUBSTRATE_NODE sg13_hv_nmos
+ L=0.6u W=66u AS=0p AD=0p PS=0u PD=0u rfmode=0
* device instance PAD15_GATE_C.I3.D0 r0 *1 0,0 DANTENNA
D784PAD15_GATE_C.I3.D0 SUBSTRATE_NODE PAD15_GATE_C.NET2 DANTENNA A=0.6084p
+ P=3.12u m=1
* device instance PAD16_CS_N._G1_TAP_SYNTAX_XR0 r0 *1 0,0 PTAP1
R785PAD16_CS_N._G1_TAP_SYNTAX_XR0 VSS SUBSTRATE_NODE PTAP1 A=21.981p P=147.74u
* device instance PAD16_CS_N._G1_TAP_SYNTAX_XR1 r0 *1 0,0 PTAP1
R786PAD16_CS_N._G1_TAP_SYNTAX_XR1 IOVSS SUBSTRATE_NODE PTAP1 A=5379.0466p
+ P=677.04u
* device instance PAD16_CS_N.I2.D1 r0 *1 0,0 DANTENNA
D787PAD16_CS_N.I2.D1 SUBSTRATE_NODE CS_N DANTENNA A=35.003p P=58.08u m=1
* device instance PAD16_CS_N.I2.D0 r0 *1 0,0 DANTENNA
D788PAD16_CS_N.I2.D0 SUBSTRATE_NODE CS_N DANTENNA A=35.003p P=58.08u m=1
* device instance PAD16_CS_N.I2._G1_TAP_SYNTAX_XR0 r0 *1 0,0 PTAP1
R789PAD16_CS_N.I2._G1_TAP_SYNTAX_XR0 IOVSS SUBSTRATE_NODE PTAP1 A=141.2964p
+ P=221.76u
* device instance PAD16_CS_N.I1.D1 r0 *1 0,0 DPANTENNA
D790PAD16_CS_N.I1.D1 CS_N IOVDD DPANTENNA A=35.003p P=58.08u m=1
* device instance PAD16_CS_N.I1.D0 r0 *1 0,0 DPANTENNA
D791PAD16_CS_N.I1.D0 CS_N IOVDD DPANTENNA A=35.003p P=58.08u m=1
* device instance PAD16_CS_N.I1._G1_TAP_SYNTAX_XR0 r0 *1 0,0 PTAP1
R792PAD16_CS_N.I1._G1_TAP_SYNTAX_XR0 IOVSS SUBSTRATE_NODE PTAP1 A=33.5104p
+ P=197.12u
* device instance PAD16_CS_N.I0.P2 r0 *1 0,0 sg13_hv_pmos
MPAD16_CS_N.I0.P2 IOVDD PAD16_CS_N.I0.NET7 PAD16_CS_N.I0.NET4 IOVDD
+ sg13_hv_pmos L=0.45u W=4.6u AS=0p AD=0p PS=0u PD=0u rfmode=0
* device instance PAD16_CS_N.I0.P3 r0 *1 0,0 sg13_hv_pmos
MPAD16_CS_N.I0.P3 IOVDD PAD16_CS_N.I0.NET1 PAD16_CS_N.I0.NET7 IOVDD
+ sg13_hv_pmos L=0.45u W=4.6u AS=0p AD=0p PS=0u PD=0u rfmode=0
* device instance PAD16_CS_N.I0.N3 r0 *1 0,0 sg13_hv_nmos
MPAD16_CS_N.I0.N3 IOVSS PAD16_CS_N.I0.NET7 PAD16_CS_N.I0.NET4 SUBSTRATE_NODE
+ sg13_hv_nmos L=0.45u W=1.3u AS=0p AD=0p PS=0u PD=0u rfmode=0
* device instance PAD16_CS_N.I0.N4 r0 *1 0,0 sg13_hv_nmos
MPAD16_CS_N.I0.N4 IOVSS PAD16_CS_N.I0.NET1 PAD16_CS_N.I0.NET7 SUBSTRATE_NODE
+ sg13_hv_nmos L=0.45u W=1.3u AS=0p AD=0p PS=0u PD=0u rfmode=0
* device instance PAD16_CS_N.I0.N2 r0 *1 0,0 sg13_hv_nmos
MPAD16_CS_N.I0.N2 VSS PAD16_CS_N.I0.NET4 PAD16_CS_N.I0.NET2 SUBSTRATE_NODE
+ sg13_hv_nmos L=0.45u W=2.65u AS=0p AD=0p PS=0u PD=0u rfmode=0
* device instance PAD16_CS_N.I0.N0 r0 *1 0,0 sg13_hv_nmos
MPAD16_CS_N.I0.N0 PAD16_CS_N.I0.NET2 PAD16_CS_N.I0.NET7 VDD SUBSTRATE_NODE
+ sg13_hv_nmos L=0.45u W=2.65u AS=0p AD=0p PS=0u PD=0u rfmode=0
* device instance PAD16_CS_N.I0.N1 r0 *1 0,0 sg13_lv_nmos
MPAD16_CS_N.I0.N1 VSS PAD16_CS_N.I0.NET2 CS_N_P2C SUBSTRATE_NODE sg13_lv_nmos
+ L=0.13u W=2.75u AS=0p AD=0p PS=0u PD=0u rfmode=0
* device instance PAD16_CS_N.I0.P1 r0 *1 0,0 sg13_lv_pmos
MPAD16_CS_N.I0.P1 VDD PAD16_CS_N.I0.NET2 CS_N_P2C VDD sg13_lv_pmos L=0.13u
+ W=4.75u AS=0p AD=0p PS=0u PD=0u rfmode=0
* device instance PAD16_CS_N.I0._G1_TAP_SYNTAX_XR1 r0 *1 0,0 PTAP1
R801PAD16_CS_N.I0._G1_TAP_SYNTAX_XR1 IOVSS SUBSTRATE_NODE PTAP1 A=0.804p P=5.96u
* device instance PAD16_CS_N.I0._G1_TAP_SYNTAX_XR0 r0 *1 0,0 PTAP1
R802PAD16_CS_N.I0._G1_TAP_SYNTAX_XR0 VSS SUBSTRATE_NODE PTAP1 A=2.019p P=14.06u
* device instance PAD16_CS_N.I0.I0.R0 r0 *1 0,0 RPPD
R803PAD16_CS_N.I0.I0.R0 CS_N PAD16_CS_N.I0.NET1 SUBSTRATE_NODE RPPD w=1u l=2u
+ ps=0u b=0 m=1
* device instance PAD16_CS_N.I0.I0.D1 r0 *1 0,0 DANTENNA
D804PAD16_CS_N.I0.I0.D1 SUBSTRATE_NODE PAD16_CS_N.I0.NET1 DANTENNA A=1.984p
+ P=7.48u m=1
* device instance PAD16_CS_N.I0.I0._G1_TAP_SYNTAX_XR1 r0 *1 0,0 PTAP1
R805PAD16_CS_N.I0.I0._G1_TAP_SYNTAX_XR1 IOVSS SUBSTRATE_NODE PTAP1 A=9.0304p
+ P=53.12u
* device instance PAD16_CS_N.I0.I0.D0 r0 *1 0,0 DPANTENNA
D806PAD16_CS_N.I0.I0.D0 PAD16_CS_N.I0.NET1 IOVDD DPANTENNA A=3.187p P=11.24u m=1
* device instance PAD17_MA_SCLK._G1_TAP_SYNTAX_XR0 r0 *1 0,0 PTAP1
R807PAD17_MA_SCLK._G1_TAP_SYNTAX_XR0 VSS SUBSTRATE_NODE PTAP1 A=21.981p P=147.74u
* device instance PAD17_MA_SCLK._G1_TAP_SYNTAX_XR1 r0 *1 0,0 PTAP1
R808PAD17_MA_SCLK._G1_TAP_SYNTAX_XR1 IOVSS SUBSTRATE_NODE PTAP1 A=5379.0466p
+ P=677.04u
* device instance PAD17_MA_SCLK.I2.D1 r0 *1 0,0 DANTENNA
D809PAD17_MA_SCLK.I2.D1 SUBSTRATE_NODE MA_SCLK DANTENNA A=35.003p P=58.08u m=1
* device instance PAD17_MA_SCLK.I2.D0 r0 *1 0,0 DANTENNA
D810PAD17_MA_SCLK.I2.D0 SUBSTRATE_NODE MA_SCLK DANTENNA A=35.003p P=58.08u m=1
* device instance PAD17_MA_SCLK.I2._G1_TAP_SYNTAX_XR0 r0 *1 0,0 PTAP1
R811PAD17_MA_SCLK.I2._G1_TAP_SYNTAX_XR0 IOVSS SUBSTRATE_NODE PTAP1 A=141.2964p
+ P=221.76u
* device instance PAD17_MA_SCLK.I1.D1 r0 *1 0,0 DPANTENNA
D812PAD17_MA_SCLK.I1.D1 MA_SCLK IOVDD DPANTENNA A=35.003p P=58.08u m=1
* device instance PAD17_MA_SCLK.I1.D0 r0 *1 0,0 DPANTENNA
D813PAD17_MA_SCLK.I1.D0 MA_SCLK IOVDD DPANTENNA A=35.003p P=58.08u m=1
* device instance PAD17_MA_SCLK.I1._G1_TAP_SYNTAX_XR0 r0 *1 0,0 PTAP1
R814PAD17_MA_SCLK.I1._G1_TAP_SYNTAX_XR0 IOVSS SUBSTRATE_NODE PTAP1 A=33.5104p
+ P=197.12u
* device instance PAD17_MA_SCLK.I0.P2 r0 *1 0,0 sg13_hv_pmos
MPAD17_MA_SCLK.I0.P2 IOVDD PAD17_MA_SCLK.I0.NET7 PAD17_MA_SCLK.I0.NET4 IOVDD
+ sg13_hv_pmos L=0.45u W=4.6u AS=0p AD=0p PS=0u PD=0u rfmode=0
* device instance PAD17_MA_SCLK.I0.P3 r0 *1 0,0 sg13_hv_pmos
MPAD17_MA_SCLK.I0.P3 IOVDD PAD17_MA_SCLK.I0.NET1 PAD17_MA_SCLK.I0.NET7 IOVDD
+ sg13_hv_pmos L=0.45u W=4.6u AS=0p AD=0p PS=0u PD=0u rfmode=0
* device instance PAD17_MA_SCLK.I0.N3 r0 *1 0,0 sg13_hv_nmos
MPAD17_MA_SCLK.I0.N3 IOVSS PAD17_MA_SCLK.I0.NET7 PAD17_MA_SCLK.I0.NET4
+ SUBSTRATE_NODE sg13_hv_nmos L=0.45u W=1.3u AS=0p AD=0p PS=0u PD=0u rfmode=0
* device instance PAD17_MA_SCLK.I0.N4 r0 *1 0,0 sg13_hv_nmos
MPAD17_MA_SCLK.I0.N4 IOVSS PAD17_MA_SCLK.I0.NET1 PAD17_MA_SCLK.I0.NET7
+ SUBSTRATE_NODE sg13_hv_nmos L=0.45u W=1.3u AS=0p AD=0p PS=0u PD=0u rfmode=0
* device instance PAD17_MA_SCLK.I0.N2 r0 *1 0,0 sg13_hv_nmos
MPAD17_MA_SCLK.I0.N2 VSS PAD17_MA_SCLK.I0.NET4 PAD17_MA_SCLK.I0.NET2
+ SUBSTRATE_NODE sg13_hv_nmos L=0.45u W=2.65u AS=0p AD=0p PS=0u PD=0u rfmode=0
* device instance PAD17_MA_SCLK.I0.N0 r0 *1 0,0 sg13_hv_nmos
MPAD17_MA_SCLK.I0.N0 PAD17_MA_SCLK.I0.NET2 PAD17_MA_SCLK.I0.NET7 VDD
+ SUBSTRATE_NODE sg13_hv_nmos L=0.45u W=2.65u AS=0p AD=0p PS=0u PD=0u rfmode=0
* device instance PAD17_MA_SCLK.I0.N1 r0 *1 0,0 sg13_lv_nmos
MPAD17_MA_SCLK.I0.N1 VSS PAD17_MA_SCLK.I0.NET2 MA_SCLK_P2C SUBSTRATE_NODE
+ sg13_lv_nmos L=0.13u W=2.75u AS=0p AD=0p PS=0u PD=0u rfmode=0
* device instance PAD17_MA_SCLK.I0.P1 r0 *1 0,0 sg13_lv_pmos
MPAD17_MA_SCLK.I0.P1 VDD PAD17_MA_SCLK.I0.NET2 MA_SCLK_P2C VDD sg13_lv_pmos
+ L=0.13u W=4.75u AS=0p AD=0p PS=0u PD=0u rfmode=0
* device instance PAD17_MA_SCLK.I0._G1_TAP_SYNTAX_XR1 r0 *1 0,0 PTAP1
R823PAD17_MA_SCLK.I0._G1_TAP_SYNTAX_XR1 IOVSS SUBSTRATE_NODE PTAP1 A=0.804p
+ P=5.96u
* device instance PAD17_MA_SCLK.I0._G1_TAP_SYNTAX_XR0 r0 *1 0,0 PTAP1
R824PAD17_MA_SCLK.I0._G1_TAP_SYNTAX_XR0 VSS SUBSTRATE_NODE PTAP1 A=2.019p
+ P=14.06u
* device instance PAD17_MA_SCLK.I0.I0.R0 r0 *1 0,0 RPPD
R825PAD17_MA_SCLK.I0.I0.R0 MA_SCLK PAD17_MA_SCLK.I0.NET1 SUBSTRATE_NODE RPPD
+ w=1u l=2u ps=0u b=0 m=1
* device instance PAD17_MA_SCLK.I0.I0.D1 r0 *1 0,0 DANTENNA
D826PAD17_MA_SCLK.I0.I0.D1 SUBSTRATE_NODE PAD17_MA_SCLK.I0.NET1 DANTENNA
+ A=1.984p P=7.48u m=1
* device instance PAD17_MA_SCLK.I0.I0._G1_TAP_SYNTAX_XR1 r0 *1 0,0 PTAP1
R827PAD17_MA_SCLK.I0.I0._G1_TAP_SYNTAX_XR1 IOVSS SUBSTRATE_NODE PTAP1 A=9.0304p
+ P=53.12u
* device instance PAD17_MA_SCLK.I0.I0.D0 r0 *1 0,0 DPANTENNA
D828PAD17_MA_SCLK.I0.I0.D0 PAD17_MA_SCLK.I0.NET1 IOVDD DPANTENNA A=3.187p
+ P=11.24u m=1
* device instance PAD19_SDI._G1_TAP_SYNTAX_XR0 r0 *1 0,0 PTAP1
R829PAD19_SDI._G1_TAP_SYNTAX_XR0 VSS SUBSTRATE_NODE PTAP1 A=21.981p P=147.74u
* device instance PAD19_SDI._G1_TAP_SYNTAX_XR1 r0 *1 0,0 PTAP1
R830PAD19_SDI._G1_TAP_SYNTAX_XR1 IOVSS SUBSTRATE_NODE PTAP1 A=5379.0466p
+ P=677.04u
* device instance PAD19_SDI.I2.D1 r0 *1 0,0 DANTENNA
D831PAD19_SDI.I2.D1 SUBSTRATE_NODE SDI DANTENNA A=35.003p P=58.08u m=1
* device instance PAD19_SDI.I2.D0 r0 *1 0,0 DANTENNA
D832PAD19_SDI.I2.D0 SUBSTRATE_NODE SDI DANTENNA A=35.003p P=58.08u m=1
* device instance PAD19_SDI.I2._G1_TAP_SYNTAX_XR0 r0 *1 0,0 PTAP1
R833PAD19_SDI.I2._G1_TAP_SYNTAX_XR0 IOVSS SUBSTRATE_NODE PTAP1 A=141.2964p
+ P=221.76u
* device instance PAD19_SDI.I1.D1 r0 *1 0,0 DPANTENNA
D834PAD19_SDI.I1.D1 SDI IOVDD DPANTENNA A=35.003p P=58.08u m=1
* device instance PAD19_SDI.I1.D0 r0 *1 0,0 DPANTENNA
D835PAD19_SDI.I1.D0 SDI IOVDD DPANTENNA A=35.003p P=58.08u m=1
* device instance PAD19_SDI.I1._G1_TAP_SYNTAX_XR0 r0 *1 0,0 PTAP1
R836PAD19_SDI.I1._G1_TAP_SYNTAX_XR0 IOVSS SUBSTRATE_NODE PTAP1 A=33.5104p
+ P=197.12u
* device instance PAD19_SDI.I0.P2 r0 *1 0,0 sg13_hv_pmos
MPAD19_SDI.I0.P2 IOVDD PAD19_SDI.I0.NET7 PAD19_SDI.I0.NET4 IOVDD sg13_hv_pmos
+ L=0.45u W=4.6u AS=0p AD=0p PS=0u PD=0u rfmode=0
* device instance PAD19_SDI.I0.P3 r0 *1 0,0 sg13_hv_pmos
MPAD19_SDI.I0.P3 IOVDD PAD19_SDI.I0.NET1 PAD19_SDI.I0.NET7 IOVDD sg13_hv_pmos
+ L=0.45u W=4.6u AS=0p AD=0p PS=0u PD=0u rfmode=0
* device instance PAD19_SDI.I0.N3 r0 *1 0,0 sg13_hv_nmos
MPAD19_SDI.I0.N3 IOVSS PAD19_SDI.I0.NET7 PAD19_SDI.I0.NET4 SUBSTRATE_NODE
+ sg13_hv_nmos L=0.45u W=1.3u AS=0p AD=0p PS=0u PD=0u rfmode=0
* device instance PAD19_SDI.I0.N4 r0 *1 0,0 sg13_hv_nmos
MPAD19_SDI.I0.N4 IOVSS PAD19_SDI.I0.NET1 PAD19_SDI.I0.NET7 SUBSTRATE_NODE
+ sg13_hv_nmos L=0.45u W=1.3u AS=0p AD=0p PS=0u PD=0u rfmode=0
* device instance PAD19_SDI.I0.N2 r0 *1 0,0 sg13_hv_nmos
MPAD19_SDI.I0.N2 VSS PAD19_SDI.I0.NET4 PAD19_SDI.I0.NET2 SUBSTRATE_NODE
+ sg13_hv_nmos L=0.45u W=2.65u AS=0p AD=0p PS=0u PD=0u rfmode=0
* device instance PAD19_SDI.I0.N0 r0 *1 0,0 sg13_hv_nmos
MPAD19_SDI.I0.N0 PAD19_SDI.I0.NET2 PAD19_SDI.I0.NET7 VDD SUBSTRATE_NODE
+ sg13_hv_nmos L=0.45u W=2.65u AS=0p AD=0p PS=0u PD=0u rfmode=0
* device instance PAD19_SDI.I0.N1 r0 *1 0,0 sg13_lv_nmos
MPAD19_SDI.I0.N1 VSS PAD19_SDI.I0.NET2 SDI_P2C SUBSTRATE_NODE sg13_lv_nmos
+ L=0.13u W=2.75u AS=0p AD=0p PS=0u PD=0u rfmode=0
* device instance PAD19_SDI.I0.P1 r0 *1 0,0 sg13_lv_pmos
MPAD19_SDI.I0.P1 VDD PAD19_SDI.I0.NET2 SDI_P2C VDD sg13_lv_pmos L=0.13u W=4.75u
+ AS=0p AD=0p PS=0u PD=0u rfmode=0
* device instance PAD19_SDI.I0._G1_TAP_SYNTAX_XR1 r0 *1 0,0 PTAP1
R845PAD19_SDI.I0._G1_TAP_SYNTAX_XR1 IOVSS SUBSTRATE_NODE PTAP1 A=0.804p P=5.96u
* device instance PAD19_SDI.I0._G1_TAP_SYNTAX_XR0 r0 *1 0,0 PTAP1
R846PAD19_SDI.I0._G1_TAP_SYNTAX_XR0 VSS SUBSTRATE_NODE PTAP1 A=2.019p P=14.06u
* device instance PAD19_SDI.I0.I0.R0 r0 *1 0,0 RPPD
R847PAD19_SDI.I0.I0.R0 SDI PAD19_SDI.I0.NET1 SUBSTRATE_NODE RPPD w=1u l=2u ps=0u
+ b=0 m=1
* device instance PAD19_SDI.I0.I0.D1 r0 *1 0,0 DANTENNA
D848PAD19_SDI.I0.I0.D1 SUBSTRATE_NODE PAD19_SDI.I0.NET1 DANTENNA A=1.984p
+ P=7.48u m=1
* device instance PAD19_SDI.I0.I0._G1_TAP_SYNTAX_XR1 r0 *1 0,0 PTAP1
R849PAD19_SDI.I0.I0._G1_TAP_SYNTAX_XR1 IOVSS SUBSTRATE_NODE PTAP1 A=9.0304p
+ P=53.12u
* device instance PAD19_SDI.I0.I0.D0 r0 *1 0,0 DPANTENNA
D850PAD19_SDI.I0.I0.D0 PAD19_SDI.I0.NET1 IOVDD DPANTENNA A=3.187p P=11.24u m=1
* device instance PAD20_EN_STO_IN._G1_TAP_SYNTAX_XR0 r0 *1 0,0 PTAP1
R851PAD20_EN_STO_IN._G1_TAP_SYNTAX_XR0 VSS SUBSTRATE_NODE PTAP1 A=21.981p
+ P=147.74u
* device instance PAD20_EN_STO_IN._G1_TAP_SYNTAX_XR1 r0 *1 0,0 PTAP1
R852PAD20_EN_STO_IN._G1_TAP_SYNTAX_XR1 IOVSS SUBSTRATE_NODE PTAP1 A=5379.0466p
+ P=677.04u
* device instance PAD20_EN_STO_IN.I2.D1 r0 *1 0,0 DANTENNA
D853PAD20_EN_STO_IN.I2.D1 SUBSTRATE_NODE EN_STO_IN DANTENNA A=35.003p P=58.08u
+ m=1
* device instance PAD20_EN_STO_IN.I2.D0 r0 *1 0,0 DANTENNA
D854PAD20_EN_STO_IN.I2.D0 SUBSTRATE_NODE EN_STO_IN DANTENNA A=35.003p P=58.08u
+ m=1
* device instance PAD20_EN_STO_IN.I2._G1_TAP_SYNTAX_XR0 r0 *1 0,0 PTAP1
R855PAD20_EN_STO_IN.I2._G1_TAP_SYNTAX_XR0 IOVSS SUBSTRATE_NODE PTAP1 A=141.2964p
+ P=221.76u
* device instance PAD20_EN_STO_IN.I1.D1 r0 *1 0,0 DPANTENNA
D856PAD20_EN_STO_IN.I1.D1 EN_STO_IN IOVDD DPANTENNA A=35.003p P=58.08u m=1
* device instance PAD20_EN_STO_IN.I1.D0 r0 *1 0,0 DPANTENNA
D857PAD20_EN_STO_IN.I1.D0 EN_STO_IN IOVDD DPANTENNA A=35.003p P=58.08u m=1
* device instance PAD20_EN_STO_IN.I1._G1_TAP_SYNTAX_XR0 r0 *1 0,0 PTAP1
R858PAD20_EN_STO_IN.I1._G1_TAP_SYNTAX_XR0 IOVSS SUBSTRATE_NODE PTAP1 A=33.5104p
+ P=197.12u
* device instance PAD20_EN_STO_IN.I0.P2 r0 *1 0,0 sg13_hv_pmos
MPAD20_EN_STO_IN.I0.P2 IOVDD PAD20_EN_STO_IN.I0.NET7 PAD20_EN_STO_IN.I0.NET4
+ IOVDD sg13_hv_pmos L=0.45u W=4.6u AS=0p AD=0p PS=0u PD=0u rfmode=0
* device instance PAD20_EN_STO_IN.I0.P3 r0 *1 0,0 sg13_hv_pmos
MPAD20_EN_STO_IN.I0.P3 IOVDD PAD20_EN_STO_IN.I0.NET1 PAD20_EN_STO_IN.I0.NET7
+ IOVDD sg13_hv_pmos L=0.45u W=4.6u AS=0p AD=0p PS=0u PD=0u rfmode=0
* device instance PAD20_EN_STO_IN.I0.N3 r0 *1 0,0 sg13_hv_nmos
MPAD20_EN_STO_IN.I0.N3 IOVSS PAD20_EN_STO_IN.I0.NET7 PAD20_EN_STO_IN.I0.NET4
+ SUBSTRATE_NODE sg13_hv_nmos L=0.45u W=1.3u AS=0p AD=0p PS=0u PD=0u rfmode=0
* device instance PAD20_EN_STO_IN.I0.N4 r0 *1 0,0 sg13_hv_nmos
MPAD20_EN_STO_IN.I0.N4 IOVSS PAD20_EN_STO_IN.I0.NET1 PAD20_EN_STO_IN.I0.NET7
+ SUBSTRATE_NODE sg13_hv_nmos L=0.45u W=1.3u AS=0p AD=0p PS=0u PD=0u rfmode=0
* device instance PAD20_EN_STO_IN.I0.N2 r0 *1 0,0 sg13_hv_nmos
MPAD20_EN_STO_IN.I0.N2 VSS PAD20_EN_STO_IN.I0.NET4 PAD20_EN_STO_IN.I0.NET2
+ SUBSTRATE_NODE sg13_hv_nmos L=0.45u W=2.65u AS=0p AD=0p PS=0u PD=0u rfmode=0
* device instance PAD20_EN_STO_IN.I0.N0 r0 *1 0,0 sg13_hv_nmos
MPAD20_EN_STO_IN.I0.N0 PAD20_EN_STO_IN.I0.NET2 PAD20_EN_STO_IN.I0.NET7 VDD
+ SUBSTRATE_NODE sg13_hv_nmos L=0.45u W=2.65u AS=0p AD=0p PS=0u PD=0u rfmode=0
* device instance PAD20_EN_STO_IN.I0.N1 r0 *1 0,0 sg13_lv_nmos
MPAD20_EN_STO_IN.I0.N1 VSS PAD20_EN_STO_IN.I0.NET2 EN_STO_IN_P2C SUBSTRATE_NODE
+ sg13_lv_nmos L=0.13u W=2.75u AS=0p AD=0p PS=0u PD=0u rfmode=0
* device instance PAD20_EN_STO_IN.I0.P1 r0 *1 0,0 sg13_lv_pmos
MPAD20_EN_STO_IN.I0.P1 VDD PAD20_EN_STO_IN.I0.NET2 EN_STO_IN_P2C VDD
+ sg13_lv_pmos L=0.13u W=4.75u AS=0p AD=0p PS=0u PD=0u rfmode=0
* device instance PAD20_EN_STO_IN.I0._G1_TAP_SYNTAX_XR1 r0 *1 0,0 PTAP1
R867PAD20_EN_STO_IN.I0._G1_TAP_SYNTAX_XR1 IOVSS SUBSTRATE_NODE PTAP1 A=0.804p
+ P=5.96u
* device instance PAD20_EN_STO_IN.I0._G1_TAP_SYNTAX_XR0 r0 *1 0,0 PTAP1
R868PAD20_EN_STO_IN.I0._G1_TAP_SYNTAX_XR0 VSS SUBSTRATE_NODE PTAP1 A=2.019p
+ P=14.06u
* device instance PAD20_EN_STO_IN.I0.I0.R0 r0 *1 0,0 RPPD
R869PAD20_EN_STO_IN.I0.I0.R0 EN_STO_IN PAD20_EN_STO_IN.I0.NET1 SUBSTRATE_NODE
+ RPPD w=1u l=2u ps=0u b=0 m=1
* device instance PAD20_EN_STO_IN.I0.I0.D1 r0 *1 0,0 DANTENNA
D870PAD20_EN_STO_IN.I0.I0.D1 SUBSTRATE_NODE PAD20_EN_STO_IN.I0.NET1 DANTENNA
+ A=1.984p P=7.48u m=1
* device instance PAD20_EN_STO_IN.I0.I0._G1_TAP_SYNTAX_XR1 r0 *1 0,0 PTAP1
R871PAD20_EN_STO_IN.I0.I0._G1_TAP_SYNTAX_XR1 IOVSS SUBSTRATE_NODE PTAP1
+ A=9.0304p P=53.12u
* device instance PAD20_EN_STO_IN.I0.I0.D0 r0 *1 0,0 DPANTENNA
D872PAD20_EN_STO_IN.I0.I0.D0 PAD20_EN_STO_IN.I0.NET1 IOVDD DPANTENNA A=3.187p
+ P=11.24u m=1
* device instance IO_CORNER_NORTH_EAST_INST._G1_TAP_SYNTAX_XR1 r0 *1 0,0 PTAP1
R873IO_CORNER_NORTH_EAST_INST._G1_TAP_SYNTAX_XR1 VSS SUBSTRATE_NODE PTAP1
+ A=13.1934p P=84.704u
* device instance IO_CORNER_NORTH_EAST_INST._G1_TAP_SYNTAX_XR0 r0 *1 0,0 PTAP1
R874IO_CORNER_NORTH_EAST_INST._G1_TAP_SYNTAX_XR0 IOVSS SUBSTRATE_NODE PTAP1
+ A=10168.74p P=982.422u
* device instance IO_CORNER_NORTH_WEST_INST._G1_TAP_SYNTAX_XR1 r0 *1 0,0 PTAP1
R875IO_CORNER_NORTH_WEST_INST._G1_TAP_SYNTAX_XR1 VSS SUBSTRATE_NODE PTAP1
+ A=13.1934p P=84.704u
* device instance IO_CORNER_NORTH_WEST_INST._G1_TAP_SYNTAX_XR0 r0 *1 0,0 PTAP1
R876IO_CORNER_NORTH_WEST_INST._G1_TAP_SYNTAX_XR0 IOVSS SUBSTRATE_NODE PTAP1
+ A=10168.74p P=982.422u
* device instance IO_CORNER_SOUTH_EAST_INST._G1_TAP_SYNTAX_XR1 r0 *1 0,0 PTAP1
R877IO_CORNER_SOUTH_EAST_INST._G1_TAP_SYNTAX_XR1 VSS SUBSTRATE_NODE PTAP1
+ A=13.1934p P=84.704u
* device instance IO_CORNER_SOUTH_EAST_INST._G1_TAP_SYNTAX_XR0 r0 *1 0,0 PTAP1
R878IO_CORNER_SOUTH_EAST_INST._G1_TAP_SYNTAX_XR0 IOVSS SUBSTRATE_NODE PTAP1
+ A=10168.74p P=982.422u
* device instance IO_CORNER_SOUTH_WEST_INST._G1_TAP_SYNTAX_XR1 r0 *1 0,0 PTAP1
R879IO_CORNER_SOUTH_WEST_INST._G1_TAP_SYNTAX_XR1 VSS SUBSTRATE_NODE PTAP1
+ A=13.1934p P=84.704u
* device instance IO_CORNER_SOUTH_WEST_INST._G1_TAP_SYNTAX_XR0 r0 *1 0,0 PTAP1
R880IO_CORNER_SOUTH_WEST_INST._G1_TAP_SYNTAX_XR0 IOVSS SUBSTRATE_NODE PTAP1
+ A=10168.74p P=982.422u
* device instance IO_FILL_IO_EAST_0_0._G1_TAP_SYNTAX_XR1 r0 *1 0,0 PTAP1
R881IO_FILL_IO_EAST_0_0._G1_TAP_SYNTAX_XR1 VSS SUBSTRATE_NODE PTAP1 A=5.85p
+ P=39.6u
* device instance IO_FILL_IO_EAST_0_0._G1_TAP_SYNTAX_XR0 r0 *1 0,0 PTAP1
R882IO_FILL_IO_EAST_0_0._G1_TAP_SYNTAX_XR0 IOVSS SUBSTRATE_NODE PTAP1
+ A=1426.815p P=263.34u
* device instance IO_FILL_IO_EAST_1_0._G1_TAP_SYNTAX_XR1 r0 *1 0,0 PTAP1
R883IO_FILL_IO_EAST_1_0._G1_TAP_SYNTAX_XR1 VSS SUBSTRATE_NODE PTAP1 A=5.85p
+ P=39.6u
* device instance IO_FILL_IO_EAST_1_0._G1_TAP_SYNTAX_XR0 r0 *1 0,0 PTAP1
R884IO_FILL_IO_EAST_1_0._G1_TAP_SYNTAX_XR0 IOVSS SUBSTRATE_NODE PTAP1
+ A=1426.815p P=263.34u
* device instance IO_FILL_IO_EAST_2_0._G1_TAP_SYNTAX_XR1 r0 *1 0,0 PTAP1
R885IO_FILL_IO_EAST_2_0._G1_TAP_SYNTAX_XR1 VSS SUBSTRATE_NODE PTAP1 A=5.85p
+ P=39.6u
* device instance IO_FILL_IO_EAST_2_0._G1_TAP_SYNTAX_XR0 r0 *1 0,0 PTAP1
R886IO_FILL_IO_EAST_2_0._G1_TAP_SYNTAX_XR0 IOVSS SUBSTRATE_NODE PTAP1
+ A=1426.815p P=263.34u
* device instance IO_FILL_IO_EAST_3_0._G1_TAP_SYNTAX_XR1 r0 *1 0,0 PTAP1
R887IO_FILL_IO_EAST_3_0._G1_TAP_SYNTAX_XR1 VSS SUBSTRATE_NODE PTAP1 A=5.85p
+ P=39.6u
* device instance IO_FILL_IO_EAST_3_0._G1_TAP_SYNTAX_XR0 r0 *1 0,0 PTAP1
R888IO_FILL_IO_EAST_3_0._G1_TAP_SYNTAX_XR0 IOVSS SUBSTRATE_NODE PTAP1
+ A=1426.815p P=263.34u
* device instance IO_FILL_IO_EAST_4_0._G1_TAP_SYNTAX_XR1 r0 *1 0,0 PTAP1
R889IO_FILL_IO_EAST_4_0._G1_TAP_SYNTAX_XR1 VSS SUBSTRATE_NODE PTAP1 A=5.85p
+ P=39.6u
* device instance IO_FILL_IO_EAST_4_0._G1_TAP_SYNTAX_XR0 r0 *1 0,0 PTAP1
R890IO_FILL_IO_EAST_4_0._G1_TAP_SYNTAX_XR0 IOVSS SUBSTRATE_NODE PTAP1
+ A=1426.815p P=263.34u
* device instance IO_FILL_IO_EAST_5_0._G1_TAP_SYNTAX_XR1 r0 *1 0,0 PTAP1
R891IO_FILL_IO_EAST_5_0._G1_TAP_SYNTAX_XR1 VSS SUBSTRATE_NODE PTAP1 A=5.85p
+ P=39.6u
* device instance IO_FILL_IO_EAST_5_0._G1_TAP_SYNTAX_XR0 r0 *1 0,0 PTAP1
R892IO_FILL_IO_EAST_5_0._G1_TAP_SYNTAX_XR0 IOVSS SUBSTRATE_NODE PTAP1
+ A=1426.815p P=263.34u
* device instance IO_FILL_IO_EAST_6_0._G1_TAP_SYNTAX_XR1 r0 *1 0,0 PTAP1
R893IO_FILL_IO_EAST_6_0._G1_TAP_SYNTAX_XR1 VSS SUBSTRATE_NODE PTAP1 A=5.85p
+ P=39.6u
* device instance IO_FILL_IO_EAST_6_0._G1_TAP_SYNTAX_XR0 r0 *1 0,0 PTAP1
R894IO_FILL_IO_EAST_6_0._G1_TAP_SYNTAX_XR0 IOVSS SUBSTRATE_NODE PTAP1
+ A=1426.815p P=263.34u
* device instance IO_FILL_IO_NORTH_0_0._G1_TAP_SYNTAX_XR1 r0 *1 0,0 PTAP1
R895IO_FILL_IO_NORTH_0_0._G1_TAP_SYNTAX_XR1 VSS SUBSTRATE_NODE PTAP1 A=5.85p
+ P=39.6u
* device instance IO_FILL_IO_NORTH_0_0._G1_TAP_SYNTAX_XR0 r0 *1 0,0 PTAP1
R896IO_FILL_IO_NORTH_0_0._G1_TAP_SYNTAX_XR0 IOVSS SUBSTRATE_NODE PTAP1
+ A=1426.815p P=263.34u
* device instance IO_FILL_IO_NORTH_1_0._G1_TAP_SYNTAX_XR1 r0 *1 0,0 PTAP1
R897IO_FILL_IO_NORTH_1_0._G1_TAP_SYNTAX_XR1 VSS SUBSTRATE_NODE PTAP1 A=5.85p
+ P=39.6u
* device instance IO_FILL_IO_NORTH_1_0._G1_TAP_SYNTAX_XR0 r0 *1 0,0 PTAP1
R898IO_FILL_IO_NORTH_1_0._G1_TAP_SYNTAX_XR0 IOVSS SUBSTRATE_NODE PTAP1
+ A=1426.815p P=263.34u
* device instance IO_FILL_IO_NORTH_2_0._G1_TAP_SYNTAX_XR1 r0 *1 0,0 PTAP1
R899IO_FILL_IO_NORTH_2_0._G1_TAP_SYNTAX_XR1 VSS SUBSTRATE_NODE PTAP1 A=5.85p
+ P=39.6u
* device instance IO_FILL_IO_NORTH_2_0._G1_TAP_SYNTAX_XR0 r0 *1 0,0 PTAP1
R900IO_FILL_IO_NORTH_2_0._G1_TAP_SYNTAX_XR0 IOVSS SUBSTRATE_NODE PTAP1
+ A=1426.815p P=263.34u
* device instance IO_FILL_IO_NORTH_3_0._G1_TAP_SYNTAX_XR1 r0 *1 0,0 PTAP1
R901IO_FILL_IO_NORTH_3_0._G1_TAP_SYNTAX_XR1 VSS SUBSTRATE_NODE PTAP1 A=5.85p
+ P=39.6u
* device instance IO_FILL_IO_NORTH_3_0._G1_TAP_SYNTAX_XR0 r0 *1 0,0 PTAP1
R902IO_FILL_IO_NORTH_3_0._G1_TAP_SYNTAX_XR0 IOVSS SUBSTRATE_NODE PTAP1
+ A=1426.815p P=263.34u
* device instance IO_FILL_IO_NORTH_4_0._G1_TAP_SYNTAX_XR1 r0 *1 0,0 PTAP1
R903IO_FILL_IO_NORTH_4_0._G1_TAP_SYNTAX_XR1 VSS SUBSTRATE_NODE PTAP1 A=5.85p
+ P=39.6u
* device instance IO_FILL_IO_NORTH_4_0._G1_TAP_SYNTAX_XR0 r0 *1 0,0 PTAP1
R904IO_FILL_IO_NORTH_4_0._G1_TAP_SYNTAX_XR0 IOVSS SUBSTRATE_NODE PTAP1
+ A=1426.815p P=263.34u
* device instance IO_FILL_IO_NORTH_5_0._G1_TAP_SYNTAX_XR1 r0 *1 0,0 PTAP1
R905IO_FILL_IO_NORTH_5_0._G1_TAP_SYNTAX_XR1 VSS SUBSTRATE_NODE PTAP1 A=5.85p
+ P=39.6u
* device instance IO_FILL_IO_NORTH_5_0._G1_TAP_SYNTAX_XR0 r0 *1 0,0 PTAP1
R906IO_FILL_IO_NORTH_5_0._G1_TAP_SYNTAX_XR0 IOVSS SUBSTRATE_NODE PTAP1
+ A=1426.815p P=263.34u
* device instance IO_FILL_IO_NORTH_6_0._G1_TAP_SYNTAX_XR1 r0 *1 0,0 PTAP1
R907IO_FILL_IO_NORTH_6_0._G1_TAP_SYNTAX_XR1 VSS SUBSTRATE_NODE PTAP1 A=5.85p
+ P=39.6u
* device instance IO_FILL_IO_NORTH_6_0._G1_TAP_SYNTAX_XR0 r0 *1 0,0 PTAP1
R908IO_FILL_IO_NORTH_6_0._G1_TAP_SYNTAX_XR0 IOVSS SUBSTRATE_NODE PTAP1
+ A=1426.815p P=263.34u
* device instance IO_FILL_IO_SOUTH_0_0._G1_TAP_SYNTAX_XR1 r0 *1 0,0 PTAP1
R909IO_FILL_IO_SOUTH_0_0._G1_TAP_SYNTAX_XR1 VSS SUBSTRATE_NODE PTAP1 A=5.85p
+ P=39.6u
* device instance IO_FILL_IO_SOUTH_0_0._G1_TAP_SYNTAX_XR0 r0 *1 0,0 PTAP1
R910IO_FILL_IO_SOUTH_0_0._G1_TAP_SYNTAX_XR0 IOVSS SUBSTRATE_NODE PTAP1
+ A=1426.815p P=263.34u
* device instance IO_FILL_IO_SOUTH_1_0._G1_TAP_SYNTAX_XR1 r0 *1 0,0 PTAP1
R911IO_FILL_IO_SOUTH_1_0._G1_TAP_SYNTAX_XR1 VSS SUBSTRATE_NODE PTAP1 A=5.85p
+ P=39.6u
* device instance IO_FILL_IO_SOUTH_1_0._G1_TAP_SYNTAX_XR0 r0 *1 0,0 PTAP1
R912IO_FILL_IO_SOUTH_1_0._G1_TAP_SYNTAX_XR0 IOVSS SUBSTRATE_NODE PTAP1
+ A=1426.815p P=263.34u
* device instance IO_FILL_IO_SOUTH_2_0._G1_TAP_SYNTAX_XR1 r0 *1 0,0 PTAP1
R913IO_FILL_IO_SOUTH_2_0._G1_TAP_SYNTAX_XR1 VSS SUBSTRATE_NODE PTAP1 A=5.85p
+ P=39.6u
* device instance IO_FILL_IO_SOUTH_2_0._G1_TAP_SYNTAX_XR0 r0 *1 0,0 PTAP1
R914IO_FILL_IO_SOUTH_2_0._G1_TAP_SYNTAX_XR0 IOVSS SUBSTRATE_NODE PTAP1
+ A=1426.815p P=263.34u
* device instance IO_FILL_IO_SOUTH_3_0._G1_TAP_SYNTAX_XR1 r0 *1 0,0 PTAP1
R915IO_FILL_IO_SOUTH_3_0._G1_TAP_SYNTAX_XR1 VSS SUBSTRATE_NODE PTAP1 A=5.85p
+ P=39.6u
* device instance IO_FILL_IO_SOUTH_3_0._G1_TAP_SYNTAX_XR0 r0 *1 0,0 PTAP1
R916IO_FILL_IO_SOUTH_3_0._G1_TAP_SYNTAX_XR0 IOVSS SUBSTRATE_NODE PTAP1
+ A=1426.815p P=263.34u
* device instance IO_FILL_IO_SOUTH_4_0._G1_TAP_SYNTAX_XR1 r0 *1 0,0 PTAP1
R917IO_FILL_IO_SOUTH_4_0._G1_TAP_SYNTAX_XR1 VSS SUBSTRATE_NODE PTAP1 A=5.85p
+ P=39.6u
* device instance IO_FILL_IO_SOUTH_4_0._G1_TAP_SYNTAX_XR0 r0 *1 0,0 PTAP1
R918IO_FILL_IO_SOUTH_4_0._G1_TAP_SYNTAX_XR0 IOVSS SUBSTRATE_NODE PTAP1
+ A=1426.815p P=263.34u
* device instance IO_FILL_IO_SOUTH_5_0._G1_TAP_SYNTAX_XR1 r0 *1 0,0 PTAP1
R919IO_FILL_IO_SOUTH_5_0._G1_TAP_SYNTAX_XR1 VSS SUBSTRATE_NODE PTAP1 A=5.85p
+ P=39.6u
* device instance IO_FILL_IO_SOUTH_5_0._G1_TAP_SYNTAX_XR0 r0 *1 0,0 PTAP1
R920IO_FILL_IO_SOUTH_5_0._G1_TAP_SYNTAX_XR0 IOVSS SUBSTRATE_NODE PTAP1
+ A=1426.815p P=263.34u
* device instance IO_FILL_IO_SOUTH_6_0._G1_TAP_SYNTAX_XR1 r0 *1 0,0 PTAP1
R921IO_FILL_IO_SOUTH_6_0._G1_TAP_SYNTAX_XR1 VSS SUBSTRATE_NODE PTAP1 A=5.85p
+ P=39.6u
* device instance IO_FILL_IO_SOUTH_6_0._G1_TAP_SYNTAX_XR0 r0 *1 0,0 PTAP1
R922IO_FILL_IO_SOUTH_6_0._G1_TAP_SYNTAX_XR0 IOVSS SUBSTRATE_NODE PTAP1
+ A=1426.815p P=263.34u
* device instance IO_FILL_IO_WEST_0_0._G1_TAP_SYNTAX_XR1 r0 *1 0,0 PTAP1
R923IO_FILL_IO_WEST_0_0._G1_TAP_SYNTAX_XR1 VSS SUBSTRATE_NODE PTAP1 A=5.85p
+ P=39.6u
* device instance IO_FILL_IO_WEST_0_0._G1_TAP_SYNTAX_XR0 r0 *1 0,0 PTAP1
R924IO_FILL_IO_WEST_0_0._G1_TAP_SYNTAX_XR0 IOVSS SUBSTRATE_NODE PTAP1
+ A=1426.815p P=263.34u
* device instance IO_FILL_IO_WEST_1_0._G1_TAP_SYNTAX_XR1 r0 *1 0,0 PTAP1
R925IO_FILL_IO_WEST_1_0._G1_TAP_SYNTAX_XR1 VSS SUBSTRATE_NODE PTAP1 A=5.85p
+ P=39.6u
* device instance IO_FILL_IO_WEST_1_0._G1_TAP_SYNTAX_XR0 r0 *1 0,0 PTAP1
R926IO_FILL_IO_WEST_1_0._G1_TAP_SYNTAX_XR0 IOVSS SUBSTRATE_NODE PTAP1
+ A=1426.815p P=263.34u
* device instance IO_FILL_IO_WEST_2_0._G1_TAP_SYNTAX_XR1 r0 *1 0,0 PTAP1
R927IO_FILL_IO_WEST_2_0._G1_TAP_SYNTAX_XR1 VSS SUBSTRATE_NODE PTAP1 A=5.85p
+ P=39.6u
* device instance IO_FILL_IO_WEST_2_0._G1_TAP_SYNTAX_XR0 r0 *1 0,0 PTAP1
R928IO_FILL_IO_WEST_2_0._G1_TAP_SYNTAX_XR0 IOVSS SUBSTRATE_NODE PTAP1
+ A=1426.815p P=263.34u
* device instance IO_FILL_IO_WEST_3_0._G1_TAP_SYNTAX_XR1 r0 *1 0,0 PTAP1
R929IO_FILL_IO_WEST_3_0._G1_TAP_SYNTAX_XR1 VSS SUBSTRATE_NODE PTAP1 A=5.85p
+ P=39.6u
* device instance IO_FILL_IO_WEST_3_0._G1_TAP_SYNTAX_XR0 r0 *1 0,0 PTAP1
R930IO_FILL_IO_WEST_3_0._G1_TAP_SYNTAX_XR0 IOVSS SUBSTRATE_NODE PTAP1
+ A=1426.815p P=263.34u
* device instance IO_FILL_IO_WEST_4_0._G1_TAP_SYNTAX_XR1 r0 *1 0,0 PTAP1
R931IO_FILL_IO_WEST_4_0._G1_TAP_SYNTAX_XR1 VSS SUBSTRATE_NODE PTAP1 A=5.85p
+ P=39.6u
* device instance IO_FILL_IO_WEST_4_0._G1_TAP_SYNTAX_XR0 r0 *1 0,0 PTAP1
R932IO_FILL_IO_WEST_4_0._G1_TAP_SYNTAX_XR0 IOVSS SUBSTRATE_NODE PTAP1
+ A=1426.815p P=263.34u
* device instance IO_FILL_IO_WEST_5_0._G1_TAP_SYNTAX_XR1 r0 *1 0,0 PTAP1
R933IO_FILL_IO_WEST_5_0._G1_TAP_SYNTAX_XR1 VSS SUBSTRATE_NODE PTAP1 A=5.85p
+ P=39.6u
* device instance IO_FILL_IO_WEST_5_0._G1_TAP_SYNTAX_XR0 r0 *1 0,0 PTAP1
R934IO_FILL_IO_WEST_5_0._G1_TAP_SYNTAX_XR0 IOVSS SUBSTRATE_NODE PTAP1
+ A=1426.815p P=263.34u
* device instance IO_FILL_IO_WEST_6_0._G1_TAP_SYNTAX_XR1 r0 *1 0,0 PTAP1
R935IO_FILL_IO_WEST_6_0._G1_TAP_SYNTAX_XR1 VSS SUBSTRATE_NODE PTAP1 A=5.85p
+ P=39.6u
* device instance IO_FILL_IO_WEST_6_0._G1_TAP_SYNTAX_XR0 r0 *1 0,0 PTAP1
R936IO_FILL_IO_WEST_6_0._G1_TAP_SYNTAX_XR0 IOVSS SUBSTRATE_NODE PTAP1
+ A=1426.815p P=263.34u
* device instance IO_EXPAND_SOUTH_0._G1_TAP_SYNTAX_XR1 r0 *1 0,0 PTAP1
R937IO_EXPAND_SOUTH_0._G1_TAP_SYNTAX_XR1 VSS SUBSTRATE_NODE PTAP1 A=5.85p P=39.6u
* device instance IO_EXPAND_SOUTH_0._G1_TAP_SYNTAX_XR0 r0 *1 0,0 PTAP1
R938IO_EXPAND_SOUTH_0._G1_TAP_SYNTAX_XR0 IOVSS SUBSTRATE_NODE PTAP1 A=1426.815p
+ P=263.34u
* device instance IO_EXPAND_SOUTH_1._G1_TAP_SYNTAX_XR1 r0 *1 0,0 PTAP1
R939IO_EXPAND_SOUTH_1._G1_TAP_SYNTAX_XR1 VSS SUBSTRATE_NODE PTAP1 A=5.85p P=39.6u
* device instance IO_EXPAND_SOUTH_1._G1_TAP_SYNTAX_XR0 r0 *1 0,0 PTAP1
R940IO_EXPAND_SOUTH_1._G1_TAP_SYNTAX_XR0 IOVSS SUBSTRATE_NODE PTAP1 A=1426.815p
+ P=263.34u
* device instance IO_EXPAND_SOUTH_2._G1_TAP_SYNTAX_XR1 r0 *1 0,0 PTAP1
R941IO_EXPAND_SOUTH_2._G1_TAP_SYNTAX_XR1 VSS SUBSTRATE_NODE PTAP1 A=5.85p P=39.6u
* device instance IO_EXPAND_SOUTH_2._G1_TAP_SYNTAX_XR0 r0 *1 0,0 PTAP1
R942IO_EXPAND_SOUTH_2._G1_TAP_SYNTAX_XR0 IOVSS SUBSTRATE_NODE PTAP1 A=1426.815p
+ P=263.34u
* device instance IO_EXPAND_NORTH_0._G1_TAP_SYNTAX_XR1 r0 *1 0,0 PTAP1
R943IO_EXPAND_NORTH_0._G1_TAP_SYNTAX_XR1 VSS SUBSTRATE_NODE PTAP1 A=5.85p P=39.6u
* device instance IO_EXPAND_NORTH_0._G1_TAP_SYNTAX_XR0 r0 *1 0,0 PTAP1
R944IO_EXPAND_NORTH_0._G1_TAP_SYNTAX_XR0 IOVSS SUBSTRATE_NODE PTAP1 A=1426.815p
+ P=263.34u
* device instance IO_EXPAND_NORTH_1._G1_TAP_SYNTAX_XR1 r0 *1 0,0 PTAP1
R945IO_EXPAND_NORTH_1._G1_TAP_SYNTAX_XR1 VSS SUBSTRATE_NODE PTAP1 A=5.85p P=39.6u
* device instance IO_EXPAND_NORTH_1._G1_TAP_SYNTAX_XR0 r0 *1 0,0 PTAP1
R946IO_EXPAND_NORTH_1._G1_TAP_SYNTAX_XR0 IOVSS SUBSTRATE_NODE PTAP1 A=1426.815p
+ P=263.34u
* device instance IO_EXPAND_NORTH_2._G1_TAP_SYNTAX_XR1 r0 *1 0,0 PTAP1
R947IO_EXPAND_NORTH_2._G1_TAP_SYNTAX_XR1 VSS SUBSTRATE_NODE PTAP1 A=5.85p P=39.6u
* device instance IO_EXPAND_NORTH_2._G1_TAP_SYNTAX_XR0 r0 *1 0,0 PTAP1
R948IO_EXPAND_NORTH_2._G1_TAP_SYNTAX_XR0 IOVSS SUBSTRATE_NODE PTAP1 A=1426.815p
+ P=263.34u
* device instance IO_EXPAND_EAST_0._G1_TAP_SYNTAX_XR1 r0 *1 0,0 PTAP1
R949IO_EXPAND_EAST_0._G1_TAP_SYNTAX_XR1 VSS SUBSTRATE_NODE PTAP1 A=5.85p P=39.6u
* device instance IO_EXPAND_EAST_0._G1_TAP_SYNTAX_XR0 r0 *1 0,0 PTAP1
R950IO_EXPAND_EAST_0._G1_TAP_SYNTAX_XR0 IOVSS SUBSTRATE_NODE PTAP1 A=1426.815p
+ P=263.34u
* device instance IO_EXPAND_EAST_1._G1_TAP_SYNTAX_XR1 r0 *1 0,0 PTAP1
R951IO_EXPAND_EAST_1._G1_TAP_SYNTAX_XR1 VSS SUBSTRATE_NODE PTAP1 A=5.85p P=39.6u
* device instance IO_EXPAND_EAST_1._G1_TAP_SYNTAX_XR0 r0 *1 0,0 PTAP1
R952IO_EXPAND_EAST_1._G1_TAP_SYNTAX_XR0 IOVSS SUBSTRATE_NODE PTAP1 A=1426.815p
+ P=263.34u
* device instance IO_EXPAND_EAST_2._G1_TAP_SYNTAX_XR1 r0 *1 0,0 PTAP1
R953IO_EXPAND_EAST_2._G1_TAP_SYNTAX_XR1 VSS SUBSTRATE_NODE PTAP1 A=5.85p P=39.6u
* device instance IO_EXPAND_EAST_2._G1_TAP_SYNTAX_XR0 r0 *1 0,0 PTAP1
R954IO_EXPAND_EAST_2._G1_TAP_SYNTAX_XR0 IOVSS SUBSTRATE_NODE PTAP1 A=1426.815p
+ P=263.34u
* device instance IO_EXPAND_WEST_0._G1_TAP_SYNTAX_XR1 r0 *1 0,0 PTAP1
R955IO_EXPAND_WEST_0._G1_TAP_SYNTAX_XR1 VSS SUBSTRATE_NODE PTAP1 A=5.85p P=39.6u
* device instance IO_EXPAND_WEST_0._G1_TAP_SYNTAX_XR0 r0 *1 0,0 PTAP1
R956IO_EXPAND_WEST_0._G1_TAP_SYNTAX_XR0 IOVSS SUBSTRATE_NODE PTAP1 A=1426.815p
+ P=263.34u
* device instance IO_EXPAND_WEST_1._G1_TAP_SYNTAX_XR1 r0 *1 0,0 PTAP1
R957IO_EXPAND_WEST_1._G1_TAP_SYNTAX_XR1 VSS SUBSTRATE_NODE PTAP1 A=5.85p P=39.6u
* device instance IO_EXPAND_WEST_1._G1_TAP_SYNTAX_XR0 r0 *1 0,0 PTAP1
R958IO_EXPAND_WEST_1._G1_TAP_SYNTAX_XR0 IOVSS SUBSTRATE_NODE PTAP1 A=1426.815p
+ P=263.34u
* device instance IO_EXPAND_WEST_2._G1_TAP_SYNTAX_XR1 r0 *1 0,0 PTAP1
R959IO_EXPAND_WEST_2._G1_TAP_SYNTAX_XR1 VSS SUBSTRATE_NODE PTAP1 A=5.85p P=39.6u
* device instance IO_EXPAND_WEST_2._G1_TAP_SYNTAX_XR0 r0 *1 0,0 PTAP1
R960IO_EXPAND_WEST_2._G1_TAP_SYNTAX_XR0 IOVSS SUBSTRATE_NODE PTAP1 A=1426.815p
+ P=263.34u
* device instance IO_FILL_IO_EAST_0_20._G1_TAP_SYNTAX_XR1 r0 *1 0,0 PTAP1
R961IO_FILL_IO_EAST_0_20._G1_TAP_SYNTAX_XR1 VSS SUBSTRATE_NODE PTAP1 A=2.85p
+ P=19.6u
* device instance IO_FILL_IO_EAST_0_20._G1_TAP_SYNTAX_XR0 r0 *1 0,0 PTAP1
R962IO_FILL_IO_EAST_0_20._G1_TAP_SYNTAX_XR0 IOVSS SUBSTRATE_NODE PTAP1
+ A=695.115p P=203.34u
* device instance IO_FILL_IO_EAST_1_20._G1_TAP_SYNTAX_XR1 r0 *1 0,0 PTAP1
R963IO_FILL_IO_EAST_1_20._G1_TAP_SYNTAX_XR1 VSS SUBSTRATE_NODE PTAP1 A=2.85p
+ P=19.6u
* device instance IO_FILL_IO_EAST_1_20._G1_TAP_SYNTAX_XR0 r0 *1 0,0 PTAP1
R964IO_FILL_IO_EAST_1_20._G1_TAP_SYNTAX_XR0 IOVSS SUBSTRATE_NODE PTAP1
+ A=695.115p P=203.34u
* device instance IO_FILL_IO_EAST_2_20._G1_TAP_SYNTAX_XR1 r0 *1 0,0 PTAP1
R965IO_FILL_IO_EAST_2_20._G1_TAP_SYNTAX_XR1 VSS SUBSTRATE_NODE PTAP1 A=2.85p
+ P=19.6u
* device instance IO_FILL_IO_EAST_2_20._G1_TAP_SYNTAX_XR0 r0 *1 0,0 PTAP1
R966IO_FILL_IO_EAST_2_20._G1_TAP_SYNTAX_XR0 IOVSS SUBSTRATE_NODE PTAP1
+ A=695.115p P=203.34u
* device instance IO_FILL_IO_EAST_3_20._G1_TAP_SYNTAX_XR1 r0 *1 0,0 PTAP1
R967IO_FILL_IO_EAST_3_20._G1_TAP_SYNTAX_XR1 VSS SUBSTRATE_NODE PTAP1 A=2.85p
+ P=19.6u
* device instance IO_FILL_IO_EAST_3_20._G1_TAP_SYNTAX_XR0 r0 *1 0,0 PTAP1
R968IO_FILL_IO_EAST_3_20._G1_TAP_SYNTAX_XR0 IOVSS SUBSTRATE_NODE PTAP1
+ A=695.115p P=203.34u
* device instance IO_FILL_IO_EAST_4_20._G1_TAP_SYNTAX_XR1 r0 *1 0,0 PTAP1
R969IO_FILL_IO_EAST_4_20._G1_TAP_SYNTAX_XR1 VSS SUBSTRATE_NODE PTAP1 A=2.85p
+ P=19.6u
* device instance IO_FILL_IO_EAST_4_20._G1_TAP_SYNTAX_XR0 r0 *1 0,0 PTAP1
R970IO_FILL_IO_EAST_4_20._G1_TAP_SYNTAX_XR0 IOVSS SUBSTRATE_NODE PTAP1
+ A=695.115p P=203.34u
* device instance IO_FILL_IO_EAST_5_20._G1_TAP_SYNTAX_XR1 r0 *1 0,0 PTAP1
R971IO_FILL_IO_EAST_5_20._G1_TAP_SYNTAX_XR1 VSS SUBSTRATE_NODE PTAP1 A=2.85p
+ P=19.6u
* device instance IO_FILL_IO_EAST_5_20._G1_TAP_SYNTAX_XR0 r0 *1 0,0 PTAP1
R972IO_FILL_IO_EAST_5_20._G1_TAP_SYNTAX_XR0 IOVSS SUBSTRATE_NODE PTAP1
+ A=695.115p P=203.34u
* device instance IO_FILL_IO_EAST_6_20._G1_TAP_SYNTAX_XR1 r0 *1 0,0 PTAP1
R973IO_FILL_IO_EAST_6_20._G1_TAP_SYNTAX_XR1 VSS SUBSTRATE_NODE PTAP1 A=2.85p
+ P=19.6u
* device instance IO_FILL_IO_EAST_6_20._G1_TAP_SYNTAX_XR0 r0 *1 0,0 PTAP1
R974IO_FILL_IO_EAST_6_20._G1_TAP_SYNTAX_XR0 IOVSS SUBSTRATE_NODE PTAP1
+ A=695.115p P=203.34u
* device instance IO_FILL_IO_NORTH_0_20._G1_TAP_SYNTAX_XR1 r0 *1 0,0 PTAP1
R975IO_FILL_IO_NORTH_0_20._G1_TAP_SYNTAX_XR1 VSS SUBSTRATE_NODE PTAP1 A=2.85p
+ P=19.6u
* device instance IO_FILL_IO_NORTH_0_20._G1_TAP_SYNTAX_XR0 r0 *1 0,0 PTAP1
R976IO_FILL_IO_NORTH_0_20._G1_TAP_SYNTAX_XR0 IOVSS SUBSTRATE_NODE PTAP1
+ A=695.115p P=203.34u
* device instance IO_FILL_IO_NORTH_1_20._G1_TAP_SYNTAX_XR1 r0 *1 0,0 PTAP1
R977IO_FILL_IO_NORTH_1_20._G1_TAP_SYNTAX_XR1 VSS SUBSTRATE_NODE PTAP1 A=2.85p
+ P=19.6u
* device instance IO_FILL_IO_NORTH_1_20._G1_TAP_SYNTAX_XR0 r0 *1 0,0 PTAP1
R978IO_FILL_IO_NORTH_1_20._G1_TAP_SYNTAX_XR0 IOVSS SUBSTRATE_NODE PTAP1
+ A=695.115p P=203.34u
* device instance IO_FILL_IO_NORTH_2_20._G1_TAP_SYNTAX_XR1 r0 *1 0,0 PTAP1
R979IO_FILL_IO_NORTH_2_20._G1_TAP_SYNTAX_XR1 VSS SUBSTRATE_NODE PTAP1 A=2.85p
+ P=19.6u
* device instance IO_FILL_IO_NORTH_2_20._G1_TAP_SYNTAX_XR0 r0 *1 0,0 PTAP1
R980IO_FILL_IO_NORTH_2_20._G1_TAP_SYNTAX_XR0 IOVSS SUBSTRATE_NODE PTAP1
+ A=695.115p P=203.34u
* device instance IO_FILL_IO_NORTH_3_20._G1_TAP_SYNTAX_XR1 r0 *1 0,0 PTAP1
R981IO_FILL_IO_NORTH_3_20._G1_TAP_SYNTAX_XR1 VSS SUBSTRATE_NODE PTAP1 A=2.85p
+ P=19.6u
* device instance IO_FILL_IO_NORTH_3_20._G1_TAP_SYNTAX_XR0 r0 *1 0,0 PTAP1
R982IO_FILL_IO_NORTH_3_20._G1_TAP_SYNTAX_XR0 IOVSS SUBSTRATE_NODE PTAP1
+ A=695.115p P=203.34u
* device instance IO_FILL_IO_NORTH_4_20._G1_TAP_SYNTAX_XR1 r0 *1 0,0 PTAP1
R983IO_FILL_IO_NORTH_4_20._G1_TAP_SYNTAX_XR1 VSS SUBSTRATE_NODE PTAP1 A=2.85p
+ P=19.6u
* device instance IO_FILL_IO_NORTH_4_20._G1_TAP_SYNTAX_XR0 r0 *1 0,0 PTAP1
R984IO_FILL_IO_NORTH_4_20._G1_TAP_SYNTAX_XR0 IOVSS SUBSTRATE_NODE PTAP1
+ A=695.115p P=203.34u
* device instance IO_FILL_IO_NORTH_5_20._G1_TAP_SYNTAX_XR1 r0 *1 0,0 PTAP1
R985IO_FILL_IO_NORTH_5_20._G1_TAP_SYNTAX_XR1 VSS SUBSTRATE_NODE PTAP1 A=2.85p
+ P=19.6u
* device instance IO_FILL_IO_NORTH_5_20._G1_TAP_SYNTAX_XR0 r0 *1 0,0 PTAP1
R986IO_FILL_IO_NORTH_5_20._G1_TAP_SYNTAX_XR0 IOVSS SUBSTRATE_NODE PTAP1
+ A=695.115p P=203.34u
* device instance IO_FILL_IO_NORTH_6_20._G1_TAP_SYNTAX_XR1 r0 *1 0,0 PTAP1
R987IO_FILL_IO_NORTH_6_20._G1_TAP_SYNTAX_XR1 VSS SUBSTRATE_NODE PTAP1 A=2.85p
+ P=19.6u
* device instance IO_FILL_IO_NORTH_6_20._G1_TAP_SYNTAX_XR0 r0 *1 0,0 PTAP1
R988IO_FILL_IO_NORTH_6_20._G1_TAP_SYNTAX_XR0 IOVSS SUBSTRATE_NODE PTAP1
+ A=695.115p P=203.34u
* device instance IO_FILL_IO_SOUTH_0_20._G1_TAP_SYNTAX_XR1 r0 *1 0,0 PTAP1
R989IO_FILL_IO_SOUTH_0_20._G1_TAP_SYNTAX_XR1 VSS SUBSTRATE_NODE PTAP1 A=2.85p
+ P=19.6u
* device instance IO_FILL_IO_SOUTH_0_20._G1_TAP_SYNTAX_XR0 r0 *1 0,0 PTAP1
R990IO_FILL_IO_SOUTH_0_20._G1_TAP_SYNTAX_XR0 IOVSS SUBSTRATE_NODE PTAP1
+ A=695.115p P=203.34u
* device instance IO_FILL_IO_SOUTH_1_20._G1_TAP_SYNTAX_XR1 r0 *1 0,0 PTAP1
R991IO_FILL_IO_SOUTH_1_20._G1_TAP_SYNTAX_XR1 VSS SUBSTRATE_NODE PTAP1 A=2.85p
+ P=19.6u
* device instance IO_FILL_IO_SOUTH_1_20._G1_TAP_SYNTAX_XR0 r0 *1 0,0 PTAP1
R992IO_FILL_IO_SOUTH_1_20._G1_TAP_SYNTAX_XR0 IOVSS SUBSTRATE_NODE PTAP1
+ A=695.115p P=203.34u
* device instance IO_FILL_IO_SOUTH_2_20._G1_TAP_SYNTAX_XR1 r0 *1 0,0 PTAP1
R993IO_FILL_IO_SOUTH_2_20._G1_TAP_SYNTAX_XR1 VSS SUBSTRATE_NODE PTAP1 A=2.85p
+ P=19.6u
* device instance IO_FILL_IO_SOUTH_2_20._G1_TAP_SYNTAX_XR0 r0 *1 0,0 PTAP1
R994IO_FILL_IO_SOUTH_2_20._G1_TAP_SYNTAX_XR0 IOVSS SUBSTRATE_NODE PTAP1
+ A=695.115p P=203.34u
* device instance IO_FILL_IO_SOUTH_3_20._G1_TAP_SYNTAX_XR1 r0 *1 0,0 PTAP1
R995IO_FILL_IO_SOUTH_3_20._G1_TAP_SYNTAX_XR1 VSS SUBSTRATE_NODE PTAP1 A=2.85p
+ P=19.6u
* device instance IO_FILL_IO_SOUTH_3_20._G1_TAP_SYNTAX_XR0 r0 *1 0,0 PTAP1
R996IO_FILL_IO_SOUTH_3_20._G1_TAP_SYNTAX_XR0 IOVSS SUBSTRATE_NODE PTAP1
+ A=695.115p P=203.34u
* device instance IO_FILL_IO_SOUTH_4_20._G1_TAP_SYNTAX_XR1 r0 *1 0,0 PTAP1
R997IO_FILL_IO_SOUTH_4_20._G1_TAP_SYNTAX_XR1 VSS SUBSTRATE_NODE PTAP1 A=2.85p
+ P=19.6u
* device instance IO_FILL_IO_SOUTH_4_20._G1_TAP_SYNTAX_XR0 r0 *1 0,0 PTAP1
R998IO_FILL_IO_SOUTH_4_20._G1_TAP_SYNTAX_XR0 IOVSS SUBSTRATE_NODE PTAP1
+ A=695.115p P=203.34u
* device instance IO_FILL_IO_SOUTH_5_20._G1_TAP_SYNTAX_XR1 r0 *1 0,0 PTAP1
R999IO_FILL_IO_SOUTH_5_20._G1_TAP_SYNTAX_XR1 VSS SUBSTRATE_NODE PTAP1 A=2.85p
+ P=19.6u
* device instance IO_FILL_IO_SOUTH_5_20._G1_TAP_SYNTAX_XR0 r0 *1 0,0 PTAP1
R1000IO_FILL_IO_SOUTH_5_20._G1_TAP_SYNTAX_XR0 IOVSS SUBSTRATE_NODE PTAP1
+ A=695.115p P=203.34u
* device instance IO_FILL_IO_SOUTH_6_20._G1_TAP_SYNTAX_XR1 r0 *1 0,0 PTAP1
R1001IO_FILL_IO_SOUTH_6_20._G1_TAP_SYNTAX_XR1 VSS SUBSTRATE_NODE PTAP1 A=2.85p
+ P=19.6u
* device instance IO_FILL_IO_SOUTH_6_20._G1_TAP_SYNTAX_XR0 r0 *1 0,0 PTAP1
R1002IO_FILL_IO_SOUTH_6_20._G1_TAP_SYNTAX_XR0 IOVSS SUBSTRATE_NODE PTAP1
+ A=695.115p P=203.34u
* device instance IO_FILL_IO_WEST_0_20._G1_TAP_SYNTAX_XR1 r0 *1 0,0 PTAP1
R1003IO_FILL_IO_WEST_0_20._G1_TAP_SYNTAX_XR1 VSS SUBSTRATE_NODE PTAP1 A=2.85p
+ P=19.6u
* device instance IO_FILL_IO_WEST_0_20._G1_TAP_SYNTAX_XR0 r0 *1 0,0 PTAP1
R1004IO_FILL_IO_WEST_0_20._G1_TAP_SYNTAX_XR0 IOVSS SUBSTRATE_NODE PTAP1
+ A=695.115p P=203.34u
* device instance IO_FILL_IO_WEST_1_20._G1_TAP_SYNTAX_XR1 r0 *1 0,0 PTAP1
R1005IO_FILL_IO_WEST_1_20._G1_TAP_SYNTAX_XR1 VSS SUBSTRATE_NODE PTAP1 A=2.85p
+ P=19.6u
* device instance IO_FILL_IO_WEST_1_20._G1_TAP_SYNTAX_XR0 r0 *1 0,0 PTAP1
R1006IO_FILL_IO_WEST_1_20._G1_TAP_SYNTAX_XR0 IOVSS SUBSTRATE_NODE PTAP1
+ A=695.115p P=203.34u
* device instance IO_FILL_IO_WEST_2_20._G1_TAP_SYNTAX_XR1 r0 *1 0,0 PTAP1
R1007IO_FILL_IO_WEST_2_20._G1_TAP_SYNTAX_XR1 VSS SUBSTRATE_NODE PTAP1 A=2.85p
+ P=19.6u
* device instance IO_FILL_IO_WEST_2_20._G1_TAP_SYNTAX_XR0 r0 *1 0,0 PTAP1
R1008IO_FILL_IO_WEST_2_20._G1_TAP_SYNTAX_XR0 IOVSS SUBSTRATE_NODE PTAP1
+ A=695.115p P=203.34u
* device instance IO_FILL_IO_WEST_3_20._G1_TAP_SYNTAX_XR1 r0 *1 0,0 PTAP1
R1009IO_FILL_IO_WEST_3_20._G1_TAP_SYNTAX_XR1 VSS SUBSTRATE_NODE PTAP1 A=2.85p
+ P=19.6u
* device instance IO_FILL_IO_WEST_3_20._G1_TAP_SYNTAX_XR0 r0 *1 0,0 PTAP1
R1010IO_FILL_IO_WEST_3_20._G1_TAP_SYNTAX_XR0 IOVSS SUBSTRATE_NODE PTAP1
+ A=695.115p P=203.34u
* device instance IO_FILL_IO_WEST_4_20._G1_TAP_SYNTAX_XR1 r0 *1 0,0 PTAP1
R1011IO_FILL_IO_WEST_4_20._G1_TAP_SYNTAX_XR1 VSS SUBSTRATE_NODE PTAP1 A=2.85p
+ P=19.6u
* device instance IO_FILL_IO_WEST_4_20._G1_TAP_SYNTAX_XR0 r0 *1 0,0 PTAP1
R1012IO_FILL_IO_WEST_4_20._G1_TAP_SYNTAX_XR0 IOVSS SUBSTRATE_NODE PTAP1
+ A=695.115p P=203.34u
* device instance IO_FILL_IO_WEST_5_20._G1_TAP_SYNTAX_XR1 r0 *1 0,0 PTAP1
R1013IO_FILL_IO_WEST_5_20._G1_TAP_SYNTAX_XR1 VSS SUBSTRATE_NODE PTAP1 A=2.85p
+ P=19.6u
* device instance IO_FILL_IO_WEST_5_20._G1_TAP_SYNTAX_XR0 r0 *1 0,0 PTAP1
R1014IO_FILL_IO_WEST_5_20._G1_TAP_SYNTAX_XR0 IOVSS SUBSTRATE_NODE PTAP1
+ A=695.115p P=203.34u
* device instance IO_FILL_IO_WEST_6_20._G1_TAP_SYNTAX_XR1 r0 *1 0,0 PTAP1
R1015IO_FILL_IO_WEST_6_20._G1_TAP_SYNTAX_XR1 VSS SUBSTRATE_NODE PTAP1 A=2.85p
+ P=19.6u
* device instance IO_FILL_IO_WEST_6_20._G1_TAP_SYNTAX_XR0 r0 *1 0,0 PTAP1
R1016IO_FILL_IO_WEST_6_20._G1_TAP_SYNTAX_XR0 IOVSS SUBSTRATE_NODE PTAP1
+ A=695.115p P=203.34u
* device instance IO_FILL_IO_EAST_0_30._G1_TAP_SYNTAX_XR1 r0 *1 0,0 PTAP1
R1017IO_FILL_IO_EAST_0_30._G1_TAP_SYNTAX_XR1 VSS SUBSTRATE_NODE PTAP1 A=0.672p
+ P=5.08u
* device instance IO_FILL_IO_EAST_0_30._G1_TAP_SYNTAX_XR0 r0 *1 0,0 PTAP1
R1018IO_FILL_IO_EAST_0_30._G1_TAP_SYNTAX_XR0 IOVSS SUBSTRATE_NODE PTAP1
+ A=114.1452p P=155.7u
* device instance IO_FILL_IO_EAST_0_32._G1_TAP_SYNTAX_XR1 r0 *1 0,0 PTAP1
R1019IO_FILL_IO_EAST_0_32._G1_TAP_SYNTAX_XR1 VSS SUBSTRATE_NODE PTAP1 A=0.672p
+ P=5.08u
* device instance IO_FILL_IO_EAST_0_32._G1_TAP_SYNTAX_XR0 r0 *1 0,0 PTAP1
R1020IO_FILL_IO_EAST_0_32._G1_TAP_SYNTAX_XR0 IOVSS SUBSTRATE_NODE PTAP1
+ A=114.1452p P=155.7u
* device instance IO_FILL_IO_EAST_1_30._G1_TAP_SYNTAX_XR1 r0 *1 0,0 PTAP1
R1021IO_FILL_IO_EAST_1_30._G1_TAP_SYNTAX_XR1 VSS SUBSTRATE_NODE PTAP1 A=0.672p
+ P=5.08u
* device instance IO_FILL_IO_EAST_1_30._G1_TAP_SYNTAX_XR0 r0 *1 0,0 PTAP1
R1022IO_FILL_IO_EAST_1_30._G1_TAP_SYNTAX_XR0 IOVSS SUBSTRATE_NODE PTAP1
+ A=114.1452p P=155.7u
* device instance IO_FILL_IO_EAST_2_30._G1_TAP_SYNTAX_XR1 r0 *1 0,0 PTAP1
R1023IO_FILL_IO_EAST_2_30._G1_TAP_SYNTAX_XR1 VSS SUBSTRATE_NODE PTAP1 A=0.672p
+ P=5.08u
* device instance IO_FILL_IO_EAST_2_30._G1_TAP_SYNTAX_XR0 r0 *1 0,0 PTAP1
R1024IO_FILL_IO_EAST_2_30._G1_TAP_SYNTAX_XR0 IOVSS SUBSTRATE_NODE PTAP1
+ A=114.1452p P=155.7u
* device instance IO_FILL_IO_EAST_3_30._G1_TAP_SYNTAX_XR1 r0 *1 0,0 PTAP1
R1025IO_FILL_IO_EAST_3_30._G1_TAP_SYNTAX_XR1 VSS SUBSTRATE_NODE PTAP1 A=0.672p
+ P=5.08u
* device instance IO_FILL_IO_EAST_3_30._G1_TAP_SYNTAX_XR0 r0 *1 0,0 PTAP1
R1026IO_FILL_IO_EAST_3_30._G1_TAP_SYNTAX_XR0 IOVSS SUBSTRATE_NODE PTAP1
+ A=114.1452p P=155.7u
* device instance IO_FILL_IO_EAST_4_30._G1_TAP_SYNTAX_XR1 r0 *1 0,0 PTAP1
R1027IO_FILL_IO_EAST_4_30._G1_TAP_SYNTAX_XR1 VSS SUBSTRATE_NODE PTAP1 A=0.672p
+ P=5.08u
* device instance IO_FILL_IO_EAST_4_30._G1_TAP_SYNTAX_XR0 r0 *1 0,0 PTAP1
R1028IO_FILL_IO_EAST_4_30._G1_TAP_SYNTAX_XR0 IOVSS SUBSTRATE_NODE PTAP1
+ A=114.1452p P=155.7u
* device instance IO_FILL_IO_EAST_5_30._G1_TAP_SYNTAX_XR1 r0 *1 0,0 PTAP1
R1029IO_FILL_IO_EAST_5_30._G1_TAP_SYNTAX_XR1 VSS SUBSTRATE_NODE PTAP1 A=0.672p
+ P=5.08u
* device instance IO_FILL_IO_EAST_5_30._G1_TAP_SYNTAX_XR0 r0 *1 0,0 PTAP1
R1030IO_FILL_IO_EAST_5_30._G1_TAP_SYNTAX_XR0 IOVSS SUBSTRATE_NODE PTAP1
+ A=114.1452p P=155.7u
* device instance IO_FILL_IO_EAST_6_30._G1_TAP_SYNTAX_XR1 r0 *1 0,0 PTAP1
R1031IO_FILL_IO_EAST_6_30._G1_TAP_SYNTAX_XR1 VSS SUBSTRATE_NODE PTAP1 A=0.672p
+ P=5.08u
* device instance IO_FILL_IO_EAST_6_30._G1_TAP_SYNTAX_XR0 r0 *1 0,0 PTAP1
R1032IO_FILL_IO_EAST_6_30._G1_TAP_SYNTAX_XR0 IOVSS SUBSTRATE_NODE PTAP1
+ A=114.1452p P=155.7u
* device instance IO_FILL_IO_EAST_6_32._G1_TAP_SYNTAX_XR1 r0 *1 0,0 PTAP1
R1033IO_FILL_IO_EAST_6_32._G1_TAP_SYNTAX_XR1 VSS SUBSTRATE_NODE PTAP1 A=0.672p
+ P=5.08u
* device instance IO_FILL_IO_EAST_6_32._G1_TAP_SYNTAX_XR0 r0 *1 0,0 PTAP1
R1034IO_FILL_IO_EAST_6_32._G1_TAP_SYNTAX_XR0 IOVSS SUBSTRATE_NODE PTAP1
+ A=114.1452p P=155.7u
* device instance IO_FILL_IO_NORTH_0_30._G1_TAP_SYNTAX_XR1 r0 *1 0,0 PTAP1
R1035IO_FILL_IO_NORTH_0_30._G1_TAP_SYNTAX_XR1 VSS SUBSTRATE_NODE PTAP1 A=0.672p
+ P=5.08u
* device instance IO_FILL_IO_NORTH_0_30._G1_TAP_SYNTAX_XR0 r0 *1 0,0 PTAP1
R1036IO_FILL_IO_NORTH_0_30._G1_TAP_SYNTAX_XR0 IOVSS SUBSTRATE_NODE PTAP1
+ A=114.1452p P=155.7u
* device instance IO_FILL_IO_NORTH_0_32._G1_TAP_SYNTAX_XR1 r0 *1 0,0 PTAP1
R1037IO_FILL_IO_NORTH_0_32._G1_TAP_SYNTAX_XR1 VSS SUBSTRATE_NODE PTAP1 A=0.672p
+ P=5.08u
* device instance IO_FILL_IO_NORTH_0_32._G1_TAP_SYNTAX_XR0 r0 *1 0,0 PTAP1
R1038IO_FILL_IO_NORTH_0_32._G1_TAP_SYNTAX_XR0 IOVSS SUBSTRATE_NODE PTAP1
+ A=114.1452p P=155.7u
* device instance IO_FILL_IO_NORTH_1_30._G1_TAP_SYNTAX_XR1 r0 *1 0,0 PTAP1
R1039IO_FILL_IO_NORTH_1_30._G1_TAP_SYNTAX_XR1 VSS SUBSTRATE_NODE PTAP1 A=0.672p
+ P=5.08u
* device instance IO_FILL_IO_NORTH_1_30._G1_TAP_SYNTAX_XR0 r0 *1 0,0 PTAP1
R1040IO_FILL_IO_NORTH_1_30._G1_TAP_SYNTAX_XR0 IOVSS SUBSTRATE_NODE PTAP1
+ A=114.1452p P=155.7u
* device instance IO_FILL_IO_NORTH_2_30._G1_TAP_SYNTAX_XR1 r0 *1 0,0 PTAP1
R1041IO_FILL_IO_NORTH_2_30._G1_TAP_SYNTAX_XR1 VSS SUBSTRATE_NODE PTAP1 A=0.672p
+ P=5.08u
* device instance IO_FILL_IO_NORTH_2_30._G1_TAP_SYNTAX_XR0 r0 *1 0,0 PTAP1
R1042IO_FILL_IO_NORTH_2_30._G1_TAP_SYNTAX_XR0 IOVSS SUBSTRATE_NODE PTAP1
+ A=114.1452p P=155.7u
* device instance IO_FILL_IO_NORTH_3_30._G1_TAP_SYNTAX_XR1 r0 *1 0,0 PTAP1
R1043IO_FILL_IO_NORTH_3_30._G1_TAP_SYNTAX_XR1 VSS SUBSTRATE_NODE PTAP1 A=0.672p
+ P=5.08u
* device instance IO_FILL_IO_NORTH_3_30._G1_TAP_SYNTAX_XR0 r0 *1 0,0 PTAP1
R1044IO_FILL_IO_NORTH_3_30._G1_TAP_SYNTAX_XR0 IOVSS SUBSTRATE_NODE PTAP1
+ A=114.1452p P=155.7u
* device instance IO_FILL_IO_NORTH_4_30._G1_TAP_SYNTAX_XR1 r0 *1 0,0 PTAP1
R1045IO_FILL_IO_NORTH_4_30._G1_TAP_SYNTAX_XR1 VSS SUBSTRATE_NODE PTAP1 A=0.672p
+ P=5.08u
* device instance IO_FILL_IO_NORTH_4_30._G1_TAP_SYNTAX_XR0 r0 *1 0,0 PTAP1
R1046IO_FILL_IO_NORTH_4_30._G1_TAP_SYNTAX_XR0 IOVSS SUBSTRATE_NODE PTAP1
+ A=114.1452p P=155.7u
* device instance IO_FILL_IO_NORTH_5_30._G1_TAP_SYNTAX_XR1 r0 *1 0,0 PTAP1
R1047IO_FILL_IO_NORTH_5_30._G1_TAP_SYNTAX_XR1 VSS SUBSTRATE_NODE PTAP1 A=0.672p
+ P=5.08u
* device instance IO_FILL_IO_NORTH_5_30._G1_TAP_SYNTAX_XR0 r0 *1 0,0 PTAP1
R1048IO_FILL_IO_NORTH_5_30._G1_TAP_SYNTAX_XR0 IOVSS SUBSTRATE_NODE PTAP1
+ A=114.1452p P=155.7u
* device instance IO_FILL_IO_NORTH_6_30._G1_TAP_SYNTAX_XR1 r0 *1 0,0 PTAP1
R1049IO_FILL_IO_NORTH_6_30._G1_TAP_SYNTAX_XR1 VSS SUBSTRATE_NODE PTAP1 A=0.672p
+ P=5.08u
* device instance IO_FILL_IO_NORTH_6_30._G1_TAP_SYNTAX_XR0 r0 *1 0,0 PTAP1
R1050IO_FILL_IO_NORTH_6_30._G1_TAP_SYNTAX_XR0 IOVSS SUBSTRATE_NODE PTAP1
+ A=114.1452p P=155.7u
* device instance IO_FILL_IO_NORTH_6_32._G1_TAP_SYNTAX_XR1 r0 *1 0,0 PTAP1
R1051IO_FILL_IO_NORTH_6_32._G1_TAP_SYNTAX_XR1 VSS SUBSTRATE_NODE PTAP1 A=0.672p
+ P=5.08u
* device instance IO_FILL_IO_NORTH_6_32._G1_TAP_SYNTAX_XR0 r0 *1 0,0 PTAP1
R1052IO_FILL_IO_NORTH_6_32._G1_TAP_SYNTAX_XR0 IOVSS SUBSTRATE_NODE PTAP1
+ A=114.1452p P=155.7u
* device instance IO_FILL_IO_SOUTH_0_30._G1_TAP_SYNTAX_XR1 r0 *1 0,0 PTAP1
R1053IO_FILL_IO_SOUTH_0_30._G1_TAP_SYNTAX_XR1 VSS SUBSTRATE_NODE PTAP1 A=0.672p
+ P=5.08u
* device instance IO_FILL_IO_SOUTH_0_30._G1_TAP_SYNTAX_XR0 r0 *1 0,0 PTAP1
R1054IO_FILL_IO_SOUTH_0_30._G1_TAP_SYNTAX_XR0 IOVSS SUBSTRATE_NODE PTAP1
+ A=114.1452p P=155.7u
* device instance IO_FILL_IO_SOUTH_0_32._G1_TAP_SYNTAX_XR1 r0 *1 0,0 PTAP1
R1055IO_FILL_IO_SOUTH_0_32._G1_TAP_SYNTAX_XR1 VSS SUBSTRATE_NODE PTAP1 A=0.672p
+ P=5.08u
* device instance IO_FILL_IO_SOUTH_0_32._G1_TAP_SYNTAX_XR0 r0 *1 0,0 PTAP1
R1056IO_FILL_IO_SOUTH_0_32._G1_TAP_SYNTAX_XR0 IOVSS SUBSTRATE_NODE PTAP1
+ A=114.1452p P=155.7u
* device instance IO_FILL_IO_SOUTH_1_30._G1_TAP_SYNTAX_XR1 r0 *1 0,0 PTAP1
R1057IO_FILL_IO_SOUTH_1_30._G1_TAP_SYNTAX_XR1 VSS SUBSTRATE_NODE PTAP1 A=0.672p
+ P=5.08u
* device instance IO_FILL_IO_SOUTH_1_30._G1_TAP_SYNTAX_XR0 r0 *1 0,0 PTAP1
R1058IO_FILL_IO_SOUTH_1_30._G1_TAP_SYNTAX_XR0 IOVSS SUBSTRATE_NODE PTAP1
+ A=114.1452p P=155.7u
* device instance IO_FILL_IO_SOUTH_2_30._G1_TAP_SYNTAX_XR1 r0 *1 0,0 PTAP1
R1059IO_FILL_IO_SOUTH_2_30._G1_TAP_SYNTAX_XR1 VSS SUBSTRATE_NODE PTAP1 A=0.672p
+ P=5.08u
* device instance IO_FILL_IO_SOUTH_2_30._G1_TAP_SYNTAX_XR0 r0 *1 0,0 PTAP1
R1060IO_FILL_IO_SOUTH_2_30._G1_TAP_SYNTAX_XR0 IOVSS SUBSTRATE_NODE PTAP1
+ A=114.1452p P=155.7u
* device instance IO_FILL_IO_SOUTH_3_30._G1_TAP_SYNTAX_XR1 r0 *1 0,0 PTAP1
R1061IO_FILL_IO_SOUTH_3_30._G1_TAP_SYNTAX_XR1 VSS SUBSTRATE_NODE PTAP1 A=0.672p
+ P=5.08u
* device instance IO_FILL_IO_SOUTH_3_30._G1_TAP_SYNTAX_XR0 r0 *1 0,0 PTAP1
R1062IO_FILL_IO_SOUTH_3_30._G1_TAP_SYNTAX_XR0 IOVSS SUBSTRATE_NODE PTAP1
+ A=114.1452p P=155.7u
* device instance IO_FILL_IO_SOUTH_4_30._G1_TAP_SYNTAX_XR1 r0 *1 0,0 PTAP1
R1063IO_FILL_IO_SOUTH_4_30._G1_TAP_SYNTAX_XR1 VSS SUBSTRATE_NODE PTAP1 A=0.672p
+ P=5.08u
* device instance IO_FILL_IO_SOUTH_4_30._G1_TAP_SYNTAX_XR0 r0 *1 0,0 PTAP1
R1064IO_FILL_IO_SOUTH_4_30._G1_TAP_SYNTAX_XR0 IOVSS SUBSTRATE_NODE PTAP1
+ A=114.1452p P=155.7u
* device instance IO_FILL_IO_SOUTH_5_30._G1_TAP_SYNTAX_XR1 r0 *1 0,0 PTAP1
R1065IO_FILL_IO_SOUTH_5_30._G1_TAP_SYNTAX_XR1 VSS SUBSTRATE_NODE PTAP1 A=0.672p
+ P=5.08u
* device instance IO_FILL_IO_SOUTH_5_30._G1_TAP_SYNTAX_XR0 r0 *1 0,0 PTAP1
R1066IO_FILL_IO_SOUTH_5_30._G1_TAP_SYNTAX_XR0 IOVSS SUBSTRATE_NODE PTAP1
+ A=114.1452p P=155.7u
* device instance IO_FILL_IO_SOUTH_6_30._G1_TAP_SYNTAX_XR1 r0 *1 0,0 PTAP1
R1067IO_FILL_IO_SOUTH_6_30._G1_TAP_SYNTAX_XR1 VSS SUBSTRATE_NODE PTAP1 A=0.672p
+ P=5.08u
* device instance IO_FILL_IO_SOUTH_6_30._G1_TAP_SYNTAX_XR0 r0 *1 0,0 PTAP1
R1068IO_FILL_IO_SOUTH_6_30._G1_TAP_SYNTAX_XR0 IOVSS SUBSTRATE_NODE PTAP1
+ A=114.1452p P=155.7u
* device instance IO_FILL_IO_SOUTH_6_32._G1_TAP_SYNTAX_XR1 r0 *1 0,0 PTAP1
R1069IO_FILL_IO_SOUTH_6_32._G1_TAP_SYNTAX_XR1 VSS SUBSTRATE_NODE PTAP1 A=0.672p
+ P=5.08u
* device instance IO_FILL_IO_SOUTH_6_32._G1_TAP_SYNTAX_XR0 r0 *1 0,0 PTAP1
R1070IO_FILL_IO_SOUTH_6_32._G1_TAP_SYNTAX_XR0 IOVSS SUBSTRATE_NODE PTAP1
+ A=114.1452p P=155.7u
* device instance IO_FILL_IO_WEST_0_30._G1_TAP_SYNTAX_XR1 r0 *1 0,0 PTAP1
R1071IO_FILL_IO_WEST_0_30._G1_TAP_SYNTAX_XR1 VSS SUBSTRATE_NODE PTAP1 A=0.672p
+ P=5.08u
* device instance IO_FILL_IO_WEST_0_30._G1_TAP_SYNTAX_XR0 r0 *1 0,0 PTAP1
R1072IO_FILL_IO_WEST_0_30._G1_TAP_SYNTAX_XR0 IOVSS SUBSTRATE_NODE PTAP1
+ A=114.1452p P=155.7u
* device instance IO_FILL_IO_WEST_0_32._G1_TAP_SYNTAX_XR1 r0 *1 0,0 PTAP1
R1073IO_FILL_IO_WEST_0_32._G1_TAP_SYNTAX_XR1 VSS SUBSTRATE_NODE PTAP1 A=0.672p
+ P=5.08u
* device instance IO_FILL_IO_WEST_0_32._G1_TAP_SYNTAX_XR0 r0 *1 0,0 PTAP1
R1074IO_FILL_IO_WEST_0_32._G1_TAP_SYNTAX_XR0 IOVSS SUBSTRATE_NODE PTAP1
+ A=114.1452p P=155.7u
* device instance IO_FILL_IO_WEST_1_30._G1_TAP_SYNTAX_XR1 r0 *1 0,0 PTAP1
R1075IO_FILL_IO_WEST_1_30._G1_TAP_SYNTAX_XR1 VSS SUBSTRATE_NODE PTAP1 A=0.672p
+ P=5.08u
* device instance IO_FILL_IO_WEST_1_30._G1_TAP_SYNTAX_XR0 r0 *1 0,0 PTAP1
R1076IO_FILL_IO_WEST_1_30._G1_TAP_SYNTAX_XR0 IOVSS SUBSTRATE_NODE PTAP1
+ A=114.1452p P=155.7u
* device instance IO_FILL_IO_WEST_2_30._G1_TAP_SYNTAX_XR1 r0 *1 0,0 PTAP1
R1077IO_FILL_IO_WEST_2_30._G1_TAP_SYNTAX_XR1 VSS SUBSTRATE_NODE PTAP1 A=0.672p
+ P=5.08u
* device instance IO_FILL_IO_WEST_2_30._G1_TAP_SYNTAX_XR0 r0 *1 0,0 PTAP1
R1078IO_FILL_IO_WEST_2_30._G1_TAP_SYNTAX_XR0 IOVSS SUBSTRATE_NODE PTAP1
+ A=114.1452p P=155.7u
* device instance IO_FILL_IO_WEST_3_30._G1_TAP_SYNTAX_XR1 r0 *1 0,0 PTAP1
R1079IO_FILL_IO_WEST_3_30._G1_TAP_SYNTAX_XR1 VSS SUBSTRATE_NODE PTAP1 A=0.672p
+ P=5.08u
* device instance IO_FILL_IO_WEST_3_30._G1_TAP_SYNTAX_XR0 r0 *1 0,0 PTAP1
R1080IO_FILL_IO_WEST_3_30._G1_TAP_SYNTAX_XR0 IOVSS SUBSTRATE_NODE PTAP1
+ A=114.1452p P=155.7u
* device instance IO_FILL_IO_WEST_4_30._G1_TAP_SYNTAX_XR1 r0 *1 0,0 PTAP1
R1081IO_FILL_IO_WEST_4_30._G1_TAP_SYNTAX_XR1 VSS SUBSTRATE_NODE PTAP1 A=0.672p
+ P=5.08u
* device instance IO_FILL_IO_WEST_4_30._G1_TAP_SYNTAX_XR0 r0 *1 0,0 PTAP1
R1082IO_FILL_IO_WEST_4_30._G1_TAP_SYNTAX_XR0 IOVSS SUBSTRATE_NODE PTAP1
+ A=114.1452p P=155.7u
* device instance IO_FILL_IO_WEST_5_30._G1_TAP_SYNTAX_XR1 r0 *1 0,0 PTAP1
R1083IO_FILL_IO_WEST_5_30._G1_TAP_SYNTAX_XR1 VSS SUBSTRATE_NODE PTAP1 A=0.672p
+ P=5.08u
* device instance IO_FILL_IO_WEST_5_30._G1_TAP_SYNTAX_XR0 r0 *1 0,0 PTAP1
R1084IO_FILL_IO_WEST_5_30._G1_TAP_SYNTAX_XR0 IOVSS SUBSTRATE_NODE PTAP1
+ A=114.1452p P=155.7u
* device instance IO_FILL_IO_WEST_6_30._G1_TAP_SYNTAX_XR1 r0 *1 0,0 PTAP1
R1085IO_FILL_IO_WEST_6_30._G1_TAP_SYNTAX_XR1 VSS SUBSTRATE_NODE PTAP1 A=0.672p
+ P=5.08u
* device instance IO_FILL_IO_WEST_6_30._G1_TAP_SYNTAX_XR0 r0 *1 0,0 PTAP1
R1086IO_FILL_IO_WEST_6_30._G1_TAP_SYNTAX_XR0 IOVSS SUBSTRATE_NODE PTAP1
+ A=114.1452p P=155.7u
* device instance IO_FILL_IO_WEST_6_32._G1_TAP_SYNTAX_XR1 r0 *1 0,0 PTAP1
R1087IO_FILL_IO_WEST_6_32._G1_TAP_SYNTAX_XR1 VSS SUBSTRATE_NODE PTAP1 A=0.672p
+ P=5.08u
* device instance IO_FILL_IO_WEST_6_32._G1_TAP_SYNTAX_XR0 r0 *1 0,0 PTAP1
R1088IO_FILL_IO_WEST_6_32._G1_TAP_SYNTAX_XR0 IOVSS SUBSTRATE_NODE PTAP1
+ A=114.1452p P=155.7u
* device instance IO_EXPAND_SOUTH_3._G1_TAP_SYNTAX_XR1 r0 *1 0,0 PTAP1
R1089IO_EXPAND_SOUTH_3._G1_TAP_SYNTAX_XR1 VSS SUBSTRATE_NODE PTAP1 A=0.672p
+ P=5.08u
* device instance IO_EXPAND_SOUTH_3._G1_TAP_SYNTAX_XR0 r0 *1 0,0 PTAP1
R1090IO_EXPAND_SOUTH_3._G1_TAP_SYNTAX_XR0 IOVSS SUBSTRATE_NODE PTAP1 A=114.1452p
+ P=155.7u
* device instance IO_EXPAND_SOUTH_4._G1_TAP_SYNTAX_XR1 r0 *1 0,0 PTAP1
R1091IO_EXPAND_SOUTH_4._G1_TAP_SYNTAX_XR1 VSS SUBSTRATE_NODE PTAP1 A=0.672p
+ P=5.08u
* device instance IO_EXPAND_SOUTH_4._G1_TAP_SYNTAX_XR0 r0 *1 0,0 PTAP1
R1092IO_EXPAND_SOUTH_4._G1_TAP_SYNTAX_XR0 IOVSS SUBSTRATE_NODE PTAP1 A=114.1452p
+ P=155.7u
* device instance IO_EXPAND_NORTH_3._G1_TAP_SYNTAX_XR1 r0 *1 0,0 PTAP1
R1093IO_EXPAND_NORTH_3._G1_TAP_SYNTAX_XR1 VSS SUBSTRATE_NODE PTAP1 A=0.672p
+ P=5.08u
* device instance IO_EXPAND_NORTH_3._G1_TAP_SYNTAX_XR0 r0 *1 0,0 PTAP1
R1094IO_EXPAND_NORTH_3._G1_TAP_SYNTAX_XR0 IOVSS SUBSTRATE_NODE PTAP1 A=114.1452p
+ P=155.7u
* device instance IO_EXPAND_NORTH_4._G1_TAP_SYNTAX_XR1 r0 *1 0,0 PTAP1
R1095IO_EXPAND_NORTH_4._G1_TAP_SYNTAX_XR1 VSS SUBSTRATE_NODE PTAP1 A=0.672p
+ P=5.08u
* device instance IO_EXPAND_NORTH_4._G1_TAP_SYNTAX_XR0 r0 *1 0,0 PTAP1
R1096IO_EXPAND_NORTH_4._G1_TAP_SYNTAX_XR0 IOVSS SUBSTRATE_NODE PTAP1 A=114.1452p
+ P=155.7u
* device instance IO_EXPAND_EAST_3._G1_TAP_SYNTAX_XR1 r0 *1 0,0 PTAP1
R1097IO_EXPAND_EAST_3._G1_TAP_SYNTAX_XR1 VSS SUBSTRATE_NODE PTAP1 A=0.672p
+ P=5.08u
* device instance IO_EXPAND_EAST_3._G1_TAP_SYNTAX_XR0 r0 *1 0,0 PTAP1
R1098IO_EXPAND_EAST_3._G1_TAP_SYNTAX_XR0 IOVSS SUBSTRATE_NODE PTAP1 A=114.1452p
+ P=155.7u
* device instance IO_EXPAND_EAST_4._G1_TAP_SYNTAX_XR1 r0 *1 0,0 PTAP1
R1099IO_EXPAND_EAST_4._G1_TAP_SYNTAX_XR1 VSS SUBSTRATE_NODE PTAP1 A=0.672p
+ P=5.08u
* device instance IO_EXPAND_EAST_4._G1_TAP_SYNTAX_XR0 r0 *1 0,0 PTAP1
R1100IO_EXPAND_EAST_4._G1_TAP_SYNTAX_XR0 IOVSS SUBSTRATE_NODE PTAP1 A=114.1452p
+ P=155.7u
* device instance IO_EXPAND_WEST_3._G1_TAP_SYNTAX_XR1 r0 *1 0,0 PTAP1
R1101IO_EXPAND_WEST_3._G1_TAP_SYNTAX_XR1 VSS SUBSTRATE_NODE PTAP1 A=0.672p
+ P=5.08u
* device instance IO_EXPAND_WEST_3._G1_TAP_SYNTAX_XR0 r0 *1 0,0 PTAP1
R1102IO_EXPAND_WEST_3._G1_TAP_SYNTAX_XR0 IOVSS SUBSTRATE_NODE PTAP1 A=114.1452p
+ P=155.7u
* device instance IO_EXPAND_WEST_4._G1_TAP_SYNTAX_XR1 r0 *1 0,0 PTAP1
R1103IO_EXPAND_WEST_4._G1_TAP_SYNTAX_XR1 VSS SUBSTRATE_NODE PTAP1 A=0.672p
+ P=5.08u
* device instance IO_EXPAND_WEST_4._G1_TAP_SYNTAX_XR0 r0 *1 0,0 PTAP1
R1104IO_EXPAND_WEST_4._G1_TAP_SYNTAX_XR0 IOVSS SUBSTRATE_NODE PTAP1 A=114.1452p
+ P=155.7u
.ENDS R1_PADRING
