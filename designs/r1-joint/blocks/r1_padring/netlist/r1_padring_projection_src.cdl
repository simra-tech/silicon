* r1_padring comparison-only projection source: canonical minus the dummy all-VDD PMOS MP0 of the LevelDown derivative
* CDL ../../../g1-guardian/blocks/g1_padring/netlist/g1_chip_top_1414_r4.cdl sha256 e060c0c59a168e5b69b0c47dc31cbfe4f4444d2ec8af62960c339c1230a2c99f; top subckt generated by flow/make_cdl.py from the R1 pin map.
* Not LVS-qualified: the canonical IO-cell reference fails in the KLayout deck for the PDK reasons recorded for G1.
* BEGIN_SOURCE sg13g2_io.cdl
************************************************************************
*
* Copyright 2024 IHP PDK Authors
*
* Licensed under the Apache License, Version 2.0 (the "License");
* you may not use this file except in compliance with the License.
* You may obtain a copy of the License at
*
*    https://www.apache.org/licenses/LICENSE-2.0
*
* Unless required by applicable law or agreed to in writing, software
* distributed under the License is distributed on an "AS IS" BASIS,
* WITHOUT WARRANTIES OR CONDITIONS OF ANY KIND, either express or implied.
* See the License for the specific language governing permissions and
* limitations under the License.
*
************************************************************************

************************************************************************
* Library Name: sg13g2_io
* Cell Name:    sg13g2_DCNDiode
* View Name:    schematic
************************************************************************

.SUBCKT sg13g2_DCNDiode anode cathode guard
*.PININFO anode:B cathode:B guard:B
DD1 sub! cathode dantenna m=1 w=1.26u l=27.78u a=35.003p p=58.08u
DD0 sub! cathode dantenna m=1 w=1.26u l=27.78u a=35.003p p=58.08u
R_G1_TAP_SYNTAX_XR0 anode sub! ptap1 A=141.253p P=47.54u
.ENDS

************************************************************************
* Library Name: sg13g2_io
* Cell Name:    sg13g2_DCPDiode
* View Name:    schematic
************************************************************************

.SUBCKT sg13g2_DCPDiode anode cathode guard
*.PININFO anode:B cathode:B guard:B
DD1 anode cathode dpantenna m=1 w=1.26u l=27.78u a=35.003p p=58.08u
DD0 anode cathode dpantenna m=1 w=1.26u l=27.78u a=35.003p p=58.08u
R_G1_TAP_SYNTAX_XR0 guard sub! ptap1 A=33.524p P=23.16u
.ENDS

************************************************************************
* Library Name: sg13g2_io
* Cell Name:    sg13g2_IOPadIOVss
* View Name:    schematic
************************************************************************

.SUBCKT sg13g2_IOPadIOVss vdd vss iovdd iovss
*.PININFO iovdd:B iovss:B vdd:B vss:B
XI3 iovss iovss iovdd / sg13g2_DCNDiode
XI2 iovss iovdd iovss / sg13g2_DCPDiode
R_G1_TAP_SYNTAX_XR1 vss sub! ptap1 A=24.01p P=19.6u
R_G1_TAP_SYNTAX_XR0 iovss sub! ptap1 A=5.487n P=296.3u
.ENDS

************************************************************************
* Library Name: sg13g2_io
* Cell Name:    sg13g2_Clamp_N43N43D4R
* View Name:    schematic
************************************************************************

.SUBCKT sg13g2_Clamp_N43N43D4R gate iovss pad
*.PININFO gate:I iovss:B pad:B
MN0<1> pad gate iovss sub! sg13_hv_nmos m=1 w=4.4u l=600.0n ng=1
MN0<2> pad gate iovss sub! sg13_hv_nmos m=1 w=4.4u l=600.0n ng=1
MN0<3> pad gate iovss sub! sg13_hv_nmos m=1 w=4.4u l=600.0n ng=1
MN0<4> pad gate iovss sub! sg13_hv_nmos m=1 w=4.4u l=600.0n ng=1
MN0<5> pad gate iovss sub! sg13_hv_nmos m=1 w=4.4u l=600.0n ng=1
MN0<6> pad gate iovss sub! sg13_hv_nmos m=1 w=4.4u l=600.0n ng=1
MN0<7> pad gate iovss sub! sg13_hv_nmos m=1 w=4.4u l=600.0n ng=1
MN0<8> pad gate iovss sub! sg13_hv_nmos m=1 w=4.4u l=600.0n ng=1
MN0<9> pad gate iovss sub! sg13_hv_nmos m=1 w=4.4u l=600.0n ng=1
MN0<10> pad gate iovss sub! sg13_hv_nmos m=1 w=4.4u l=600.0n ng=1
MN0<11> pad gate iovss sub! sg13_hv_nmos m=1 w=4.4u l=600.0n ng=1
MN0<12> pad gate iovss sub! sg13_hv_nmos m=1 w=4.4u l=600.0n ng=1
MN0<13> pad gate iovss sub! sg13_hv_nmos m=1 w=4.4u l=600.0n ng=1
MN0<14> pad gate iovss sub! sg13_hv_nmos m=1 w=4.4u l=600.0n ng=1
MN0<15> pad gate iovss sub! sg13_hv_nmos m=1 w=4.4u l=600.0n ng=1
MN0<16> pad gate iovss sub! sg13_hv_nmos m=1 w=4.4u l=600.0n ng=1
MN0<17> pad gate iovss sub! sg13_hv_nmos m=1 w=4.4u l=600.0n ng=1
MN0<18> pad gate iovss sub! sg13_hv_nmos m=1 w=4.4u l=600.0n ng=1
MN0<19> pad gate iovss sub! sg13_hv_nmos m=1 w=4.4u l=600.0n ng=1
MN0<20> pad gate iovss sub! sg13_hv_nmos m=1 w=4.4u l=600.0n ng=1
MN0<21> pad gate iovss sub! sg13_hv_nmos m=1 w=4.4u l=600.0n ng=1
MN0<22> pad gate iovss sub! sg13_hv_nmos m=1 w=4.4u l=600.0n ng=1
MN0<23> pad gate iovss sub! sg13_hv_nmos m=1 w=4.4u l=600.0n ng=1
MN0<24> pad gate iovss sub! sg13_hv_nmos m=1 w=4.4u l=600.0n ng=1
MN0<25> pad gate iovss sub! sg13_hv_nmos m=1 w=4.4u l=600.0n ng=1
MN0<26> pad gate iovss sub! sg13_hv_nmos m=1 w=4.4u l=600.0n ng=1
MN0<27> pad gate iovss sub! sg13_hv_nmos m=1 w=4.4u l=600.0n ng=1
MN0<28> pad gate iovss sub! sg13_hv_nmos m=1 w=4.4u l=600.0n ng=1
MN0<29> pad gate iovss sub! sg13_hv_nmos m=1 w=4.4u l=600.0n ng=1
MN0<30> pad gate iovss sub! sg13_hv_nmos m=1 w=4.4u l=600.0n ng=1
MN0<31> pad gate iovss sub! sg13_hv_nmos m=1 w=4.4u l=600.0n ng=1
MN0<32> pad gate iovss sub! sg13_hv_nmos m=1 w=4.4u l=600.0n ng=1
MN0<33> pad gate iovss sub! sg13_hv_nmos m=1 w=4.4u l=600.0n ng=1
MN0<34> pad gate iovss sub! sg13_hv_nmos m=1 w=4.4u l=600.0n ng=1
MN0<35> pad gate iovss sub! sg13_hv_nmos m=1 w=4.4u l=600.0n ng=1
MN0<36> pad gate iovss sub! sg13_hv_nmos m=1 w=4.4u l=600.0n ng=1
MN0<37> pad gate iovss sub! sg13_hv_nmos m=1 w=4.4u l=600.0n ng=1
MN0<38> pad gate iovss sub! sg13_hv_nmos m=1 w=4.4u l=600.0n ng=1
MN0<39> pad gate iovss sub! sg13_hv_nmos m=1 w=4.4u l=600.0n ng=1
MN0<40> pad gate iovss sub! sg13_hv_nmos m=1 w=4.4u l=600.0n ng=1
MN0<41> pad gate iovss sub! sg13_hv_nmos m=1 w=4.4u l=600.0n ng=1
MN0<42> pad gate iovss sub! sg13_hv_nmos m=1 w=4.4u l=600.0n ng=1
MN0<43> pad gate iovss sub! sg13_hv_nmos m=1 w=4.4u l=600.0n ng=1
MN0<44> pad gate iovss sub! sg13_hv_nmos m=1 w=4.4u l=600.0n ng=1
MN0<45> pad gate iovss sub! sg13_hv_nmos m=1 w=4.4u l=600.0n ng=1
MN0<46> pad gate iovss sub! sg13_hv_nmos m=1 w=4.4u l=600.0n ng=1
MN0<47> pad gate iovss sub! sg13_hv_nmos m=1 w=4.4u l=600.0n ng=1
MN0<48> pad gate iovss sub! sg13_hv_nmos m=1 w=4.4u l=600.0n ng=1
MN0<49> pad gate iovss sub! sg13_hv_nmos m=1 w=4.4u l=600.0n ng=1
MN0<50> pad gate iovss sub! sg13_hv_nmos m=1 w=4.4u l=600.0n ng=1
MN0<51> pad gate iovss sub! sg13_hv_nmos m=1 w=4.4u l=600.0n ng=1
MN0<52> pad gate iovss sub! sg13_hv_nmos m=1 w=4.4u l=600.0n ng=1
MN0<53> pad gate iovss sub! sg13_hv_nmos m=1 w=4.4u l=600.0n ng=1
MN0<54> pad gate iovss sub! sg13_hv_nmos m=1 w=4.4u l=600.0n ng=1
MN0<55> pad gate iovss sub! sg13_hv_nmos m=1 w=4.4u l=600.0n ng=1
MN0<56> pad gate iovss sub! sg13_hv_nmos m=1 w=4.4u l=600.0n ng=1
MN0<57> pad gate iovss sub! sg13_hv_nmos m=1 w=4.4u l=600.0n ng=1
MN0<58> pad gate iovss sub! sg13_hv_nmos m=1 w=4.4u l=600.0n ng=1
MN0<59> pad gate iovss sub! sg13_hv_nmos m=1 w=4.4u l=600.0n ng=1
MN0<60> pad gate iovss sub! sg13_hv_nmos m=1 w=4.4u l=600.0n ng=1
MN0<61> pad gate iovss sub! sg13_hv_nmos m=1 w=4.4u l=600.0n ng=1
MN0<62> pad gate iovss sub! sg13_hv_nmos m=1 w=4.4u l=600.0n ng=1
MN0<63> pad gate iovss sub! sg13_hv_nmos m=1 w=4.4u l=600.0n ng=1
MN0<64> pad gate iovss sub! sg13_hv_nmos m=1 w=4.4u l=600.0n ng=1
MN0<65> pad gate iovss sub! sg13_hv_nmos m=1 w=4.4u l=600.0n ng=1
MN0<66> pad gate iovss sub! sg13_hv_nmos m=1 w=4.4u l=600.0n ng=1
MN0<67> pad gate iovss sub! sg13_hv_nmos m=1 w=4.4u l=600.0n ng=1
MN0<68> pad gate iovss sub! sg13_hv_nmos m=1 w=4.4u l=600.0n ng=1
MN0<69> pad gate iovss sub! sg13_hv_nmos m=1 w=4.4u l=600.0n ng=1
MN0<70> pad gate iovss sub! sg13_hv_nmos m=1 w=4.4u l=600.0n ng=1
MN0<71> pad gate iovss sub! sg13_hv_nmos m=1 w=4.4u l=600.0n ng=1
MN0<72> pad gate iovss sub! sg13_hv_nmos m=1 w=4.4u l=600.0n ng=1
MN0<73> pad gate iovss sub! sg13_hv_nmos m=1 w=4.4u l=600.0n ng=1
MN0<74> pad gate iovss sub! sg13_hv_nmos m=1 w=4.4u l=600.0n ng=1
MN0<75> pad gate iovss sub! sg13_hv_nmos m=1 w=4.4u l=600.0n ng=1
MN0<76> pad gate iovss sub! sg13_hv_nmos m=1 w=4.4u l=600.0n ng=1
MN0<77> pad gate iovss sub! sg13_hv_nmos m=1 w=4.4u l=600.0n ng=1
MN0<78> pad gate iovss sub! sg13_hv_nmos m=1 w=4.4u l=600.0n ng=1
MN0<79> pad gate iovss sub! sg13_hv_nmos m=1 w=4.4u l=600.0n ng=1
MN0<80> pad gate iovss sub! sg13_hv_nmos m=1 w=4.4u l=600.0n ng=1
MN0<81> pad gate iovss sub! sg13_hv_nmos m=1 w=4.4u l=600.0n ng=1
MN0<82> pad gate iovss sub! sg13_hv_nmos m=1 w=4.4u l=600.0n ng=1
MN0<83> pad gate iovss sub! sg13_hv_nmos m=1 w=4.4u l=600.0n ng=1
MN0<84> pad gate iovss sub! sg13_hv_nmos m=1 w=4.4u l=600.0n ng=1
MN0<85> pad gate iovss sub! sg13_hv_nmos m=1 w=4.4u l=600.0n ng=1
MN0<86> pad gate iovss sub! sg13_hv_nmos m=1 w=4.4u l=600.0n ng=1
MN0<87> pad gate iovss sub! sg13_hv_nmos m=1 w=4.4u l=600.0n ng=1
MN0<88> pad gate iovss sub! sg13_hv_nmos m=1 w=4.4u l=600.0n ng=1
MN0<89> pad gate iovss sub! sg13_hv_nmos m=1 w=4.4u l=600.0n ng=1
MN0<90> pad gate iovss sub! sg13_hv_nmos m=1 w=4.4u l=600.0n ng=1
MN0<91> pad gate iovss sub! sg13_hv_nmos m=1 w=4.4u l=600.0n ng=1
MN0<92> pad gate iovss sub! sg13_hv_nmos m=1 w=4.4u l=600.0n ng=1
MN0<93> pad gate iovss sub! sg13_hv_nmos m=1 w=4.4u l=600.0n ng=1
MN0<94> pad gate iovss sub! sg13_hv_nmos m=1 w=4.4u l=600.0n ng=1
MN0<95> pad gate iovss sub! sg13_hv_nmos m=1 w=4.4u l=600.0n ng=1
MN0<96> pad gate iovss sub! sg13_hv_nmos m=1 w=4.4u l=600.0n ng=1
MN0<97> pad gate iovss sub! sg13_hv_nmos m=1 w=4.4u l=600.0n ng=1
MN0<98> pad gate iovss sub! sg13_hv_nmos m=1 w=4.4u l=600.0n ng=1
MN0<99> pad gate iovss sub! sg13_hv_nmos m=1 w=4.4u l=600.0n ng=1
MN0<100> pad gate iovss sub! sg13_hv_nmos m=1 w=4.4u l=600.0n ng=1
MN0<101> pad gate iovss sub! sg13_hv_nmos m=1 w=4.4u l=600.0n ng=1
MN0<102> pad gate iovss sub! sg13_hv_nmos m=1 w=4.4u l=600.0n ng=1
MN0<103> pad gate iovss sub! sg13_hv_nmos m=1 w=4.4u l=600.0n ng=1
MN0<104> pad gate iovss sub! sg13_hv_nmos m=1 w=4.4u l=600.0n ng=1
MN0<105> pad gate iovss sub! sg13_hv_nmos m=1 w=4.4u l=600.0n ng=1
MN0<106> pad gate iovss sub! sg13_hv_nmos m=1 w=4.4u l=600.0n ng=1
MN0<107> pad gate iovss sub! sg13_hv_nmos m=1 w=4.4u l=600.0n ng=1
MN0<108> pad gate iovss sub! sg13_hv_nmos m=1 w=4.4u l=600.0n ng=1
MN0<109> pad gate iovss sub! sg13_hv_nmos m=1 w=4.4u l=600.0n ng=1
MN0<110> pad gate iovss sub! sg13_hv_nmos m=1 w=4.4u l=600.0n ng=1
MN0<111> pad gate iovss sub! sg13_hv_nmos m=1 w=4.4u l=600.0n ng=1
MN0<112> pad gate iovss sub! sg13_hv_nmos m=1 w=4.4u l=600.0n ng=1
MN0<113> pad gate iovss sub! sg13_hv_nmos m=1 w=4.4u l=600.0n ng=1
MN0<114> pad gate iovss sub! sg13_hv_nmos m=1 w=4.4u l=600.0n ng=1
MN0<115> pad gate iovss sub! sg13_hv_nmos m=1 w=4.4u l=600.0n ng=1
MN0<116> pad gate iovss sub! sg13_hv_nmos m=1 w=4.4u l=600.0n ng=1
MN0<117> pad gate iovss sub! sg13_hv_nmos m=1 w=4.4u l=600.0n ng=1
MN0<118> pad gate iovss sub! sg13_hv_nmos m=1 w=4.4u l=600.0n ng=1
MN0<119> pad gate iovss sub! sg13_hv_nmos m=1 w=4.4u l=600.0n ng=1
MN0<120> pad gate iovss sub! sg13_hv_nmos m=1 w=4.4u l=600.0n ng=1
MN0<121> pad gate iovss sub! sg13_hv_nmos m=1 w=4.4u l=600.0n ng=1
MN0<122> pad gate iovss sub! sg13_hv_nmos m=1 w=4.4u l=600.0n ng=1
MN0<123> pad gate iovss sub! sg13_hv_nmos m=1 w=4.4u l=600.0n ng=1
MN0<124> pad gate iovss sub! sg13_hv_nmos m=1 w=4.4u l=600.0n ng=1
MN0<125> pad gate iovss sub! sg13_hv_nmos m=1 w=4.4u l=600.0n ng=1
MN0<126> pad gate iovss sub! sg13_hv_nmos m=1 w=4.4u l=600.0n ng=1
MN0<127> pad gate iovss sub! sg13_hv_nmos m=1 w=4.4u l=600.0n ng=1
MN0<128> pad gate iovss sub! sg13_hv_nmos m=1 w=4.4u l=600.0n ng=1
MN0<129> pad gate iovss sub! sg13_hv_nmos m=1 w=4.4u l=600.0n ng=1
MN0<130> pad gate iovss sub! sg13_hv_nmos m=1 w=4.4u l=600.0n ng=1
MN0<131> pad gate iovss sub! sg13_hv_nmos m=1 w=4.4u l=600.0n ng=1
MN0<132> pad gate iovss sub! sg13_hv_nmos m=1 w=4.4u l=600.0n ng=1
MN0<133> pad gate iovss sub! sg13_hv_nmos m=1 w=4.4u l=600.0n ng=1
MN0<134> pad gate iovss sub! sg13_hv_nmos m=1 w=4.4u l=600.0n ng=1
MN0<135> pad gate iovss sub! sg13_hv_nmos m=1 w=4.4u l=600.0n ng=1
MN0<136> pad gate iovss sub! sg13_hv_nmos m=1 w=4.4u l=600.0n ng=1
MN0<137> pad gate iovss sub! sg13_hv_nmos m=1 w=4.4u l=600.0n ng=1
MN0<138> pad gate iovss sub! sg13_hv_nmos m=1 w=4.4u l=600.0n ng=1
MN0<139> pad gate iovss sub! sg13_hv_nmos m=1 w=4.4u l=600.0n ng=1
MN0<140> pad gate iovss sub! sg13_hv_nmos m=1 w=4.4u l=600.0n ng=1
MN0<141> pad gate iovss sub! sg13_hv_nmos m=1 w=4.4u l=600.0n ng=1
MN0<142> pad gate iovss sub! sg13_hv_nmos m=1 w=4.4u l=600.0n ng=1
MN0<143> pad gate iovss sub! sg13_hv_nmos m=1 w=4.4u l=600.0n ng=1
MN0<144> pad gate iovss sub! sg13_hv_nmos m=1 w=4.4u l=600.0n ng=1
MN0<145> pad gate iovss sub! sg13_hv_nmos m=1 w=4.4u l=600.0n ng=1
MN0<146> pad gate iovss sub! sg13_hv_nmos m=1 w=4.4u l=600.0n ng=1
MN0<147> pad gate iovss sub! sg13_hv_nmos m=1 w=4.4u l=600.0n ng=1
MN0<148> pad gate iovss sub! sg13_hv_nmos m=1 w=4.4u l=600.0n ng=1
MN0<149> pad gate iovss sub! sg13_hv_nmos m=1 w=4.4u l=600.0n ng=1
MN0<150> pad gate iovss sub! sg13_hv_nmos m=1 w=4.4u l=600.0n ng=1
MN0<151> pad gate iovss sub! sg13_hv_nmos m=1 w=4.4u l=600.0n ng=1
MN0<152> pad gate iovss sub! sg13_hv_nmos m=1 w=4.4u l=600.0n ng=1
MN0<153> pad gate iovss sub! sg13_hv_nmos m=1 w=4.4u l=600.0n ng=1
MN0<154> pad gate iovss sub! sg13_hv_nmos m=1 w=4.4u l=600.0n ng=1
MN0<155> pad gate iovss sub! sg13_hv_nmos m=1 w=4.4u l=600.0n ng=1
MN0<156> pad gate iovss sub! sg13_hv_nmos m=1 w=4.4u l=600.0n ng=1
MN0<157> pad gate iovss sub! sg13_hv_nmos m=1 w=4.4u l=600.0n ng=1
MN0<158> pad gate iovss sub! sg13_hv_nmos m=1 w=4.4u l=600.0n ng=1
MN0<159> pad gate iovss sub! sg13_hv_nmos m=1 w=4.4u l=600.0n ng=1
MN0<160> pad gate iovss sub! sg13_hv_nmos m=1 w=4.4u l=600.0n ng=1
MN0<161> pad gate iovss sub! sg13_hv_nmos m=1 w=4.4u l=600.0n ng=1
MN0<162> pad gate iovss sub! sg13_hv_nmos m=1 w=4.4u l=600.0n ng=1
MN0<163> pad gate iovss sub! sg13_hv_nmos m=1 w=4.4u l=600.0n ng=1
MN0<164> pad gate iovss sub! sg13_hv_nmos m=1 w=4.4u l=600.0n ng=1
MN0<165> pad gate iovss sub! sg13_hv_nmos m=1 w=4.4u l=600.0n ng=1
MN0<166> pad gate iovss sub! sg13_hv_nmos m=1 w=4.4u l=600.0n ng=1
MN0<167> pad gate iovss sub! sg13_hv_nmos m=1 w=4.4u l=600.0n ng=1
MN0<168> pad gate iovss sub! sg13_hv_nmos m=1 w=4.4u l=600.0n ng=1
MN0<169> pad gate iovss sub! sg13_hv_nmos m=1 w=4.4u l=600.0n ng=1
MN0<170> pad gate iovss sub! sg13_hv_nmos m=1 w=4.4u l=600.0n ng=1
MN0<171> pad gate iovss sub! sg13_hv_nmos m=1 w=4.4u l=600.0n ng=1
MN0<172> pad gate iovss sub! sg13_hv_nmos m=1 w=4.4u l=600.0n ng=1
R_G1_TAP_SYNTAX_XR0 iovss sub! ptap1 A=65.61p P=32.4u
DD0 sub! gate dantenna m=1 w=480n l=480n a=230.4f p=1.92u
.ENDS

************************************************************************
* Library Name: sg13g2_io
* Cell Name:    sg13g2_RCClampResistor
* View Name:    schematic
************************************************************************

.SUBCKT sg13g2_RCClampResistor pin1 pin2
*.PININFO pin1:B pin2:B
RR15 net15 net16 5.239K $SUB=sub! $[rppd] l=20u w=1u b=0 m=1
RR20 net20 net21 5.239K $SUB=sub! $[rppd] l=20u w=1u b=0 m=1
RR23 net23 net24 5.239K $SUB=sub! $[rppd] l=20u w=1u b=0 m=1
RR17 net17 net18 5.239K $SUB=sub! $[rppd] l=20u w=1u b=0 m=1
RR16 net16 net17 5.239K $SUB=sub! $[rppd] l=20u w=1u b=0 m=1
RR25 net25 pin2 5.239K $SUB=sub! $[rppd] l=20u w=1u b=0 m=1
RR22 net22 net23 5.239K $SUB=sub! $[rppd] l=20u w=1u b=0 m=1
RR19 net19 net20 5.239K $SUB=sub! $[rppd] l=20u w=1u b=0 m=1
RR24 net24 net25 5.239K $SUB=sub! $[rppd] l=20u w=1u b=0 m=1
RR21 net21 net22 5.239K $SUB=sub! $[rppd] l=20u w=1u b=0 m=1
RR18 net18 net19 5.239K $SUB=sub! $[rppd] l=20u w=1u b=0 m=1
RR5 net5 net6 5.239K $SUB=sub! $[rppd] l=20u w=1u b=0 m=1
RR8 net8 net9 5.239K $SUB=sub! $[rppd] l=20u w=1u b=0 m=1
RR11 net11 net12 5.239K $SUB=sub! $[rppd] l=20u w=1u b=0 m=1
RR14 net14 net15 5.239K $SUB=sub! $[rppd] l=20u w=1u b=0 m=1
RR2 net2 net3 5.239K $SUB=sub! $[rppd] l=20u w=1u b=0 m=1
RR1 net1 net2 5.239K $SUB=sub! $[rppd] l=20u w=1u b=0 m=1
RR13 net13 net14 5.239K $SUB=sub! $[rppd] l=20u w=1u b=0 m=1
RR10 net10 net11 5.239K $SUB=sub! $[rppd] l=20u w=1u b=0 m=1
RR7 net7 net8 5.239K $SUB=sub! $[rppd] l=20u w=1u b=0 m=1
RR4 net4 net5 5.239K $SUB=sub! $[rppd] l=20u w=1u b=0 m=1
RR12 net12 net13 5.239K $SUB=sub! $[rppd] l=20u w=1u b=0 m=1
RR9 net9 net10 5.239K $SUB=sub! $[rppd] l=20u w=1u b=0 m=1
RR6 net6 net7 5.239K $SUB=sub! $[rppd] l=20u w=1u b=0 m=1
RR3 net3 net4 5.239K $SUB=sub! $[rppd] l=20u w=1u b=0 m=1
RR0 pin1 net1 5.239K $SUB=sub! $[rppd] l=20u w=1u b=0 m=1
.ENDS

************************************************************************
* Library Name: sg13g2_io
* Cell Name:    sg13g2_RCClampInverter
* View Name:    schematic
************************************************************************

.SUBCKT sg13g2_RCClampInverter out in iovss supply
*.PININFO in:I out:O iovss:B supply:B
MN1 iovss in iovss sub! sg13_hv_nmos m=1 w=63.000u l=9.5u ng=7
MN3 out in iovss sub! sg13_hv_nmos m=1 w=54.000u l=500.0n ng=6
MN0 iovss in iovss sub! sg13_hv_nmos m=1 w=63.000u l=9.5u ng=7
MN2 out in iovss sub! sg13_hv_nmos m=1 w=54.000u l=500.0n ng=6
R_G1_TAP_SYNTAX_XR0 iovss sub! ptap1 A=68.973p P=33.22u
MP0 out in supply supply sg13_hv_pmos m=1 w=350.000u l=500.0n ng=50
.ENDS

************************************************************************
* Library Name: sg13g2_io
* Cell Name:    sg13g2_IOPadVdd
* View Name:    schematic
************************************************************************

.SUBCKT sg13g2_IOPadVdd vdd vss iovdd iovss
*.PININFO iovdd:B iovss:B vdd:B vss:B
XI1 net3 iovss vdd / sg13g2_Clamp_N43N43D4R
XI4 vdd net1 / sg13g2_RCClampResistor
R_G1_TAP_SYNTAX_XR1 iovss sub! ptap1 A=1.97n P=177.54u
R_G1_TAP_SYNTAX_XR0 vss sub! ptap1 A=24.01p P=19.6u
XI3 net3 net1 iovss vdd / sg13g2_RCClampInverter
.ENDS

************************************************************************
* Library Name: sg13g2_io
* Cell Name:    sg13g2_IOPadIOVdd
* View Name:    schematic
************************************************************************

.SUBCKT sg13g2_IOPadIOVdd vdd vss iovdd iovss
*.PININFO iovdd:B iovss:B vdd:B vss:B
XI1 net4 iovss iovdd / sg13g2_Clamp_N43N43D4R
XI3 iovdd net1 / sg13g2_RCClampResistor
XI2 net4 net1 iovss iovdd / sg13g2_RCClampInverter
R_G1_TAP_SYNTAX_XR0 vss sub! ptap1 A=24.01p P=19.6u
R_G1_TAP_SYNTAX_XR1 iovss sub! ptap1 A=1.983n P=178.14u
.ENDS

************************************************************************
* Library Name: sg13g2_io
* Cell Name:    sg13g2_IOPadVss
* View Name:    schematic
************************************************************************

.SUBCKT sg13g2_IOPadVss vdd vss iovdd iovss
*.PININFO iovdd:B iovss:B vdd:B vss:B
XI1 iovss vss iovdd / sg13g2_DCNDiode
XI2 vss iovdd iovss / sg13g2_DCPDiode
R_G1_TAP_SYNTAX_XR1 iovss sub! ptap1 A=5.329n P=292u
R_G1_TAP_SYNTAX_XR0 vss sub! ptap1 A=23.523p P=19.4u
.ENDS

************************************************************************
* Library Name: sg13g2_io
* Cell Name:    sg13g2_Filler2000
* View Name:    schematic
************************************************************************

.SUBCKT sg13g2_Filler2000 vdd vss iovdd iovss
*.PININFO iovdd:B iovss:B vdd:B vss:B
R_G1_TAP_SYNTAX_XR1 vss sub! ptap1 A=2.856p P=6.76u
R_G1_TAP_SYNTAX_XR0 iovss sub! ptap1 A=695.113p P=105.46u
.ENDS

************************************************************************
* Library Name: sg13g2_io
* Cell Name:    sg13g2_io_inv_x1
* View Name:    schematic
************************************************************************

.SUBCKT sg13g2_io_inv_x1 nq i vdd vss
*.PININFO i:I nq:O vdd:B vss:B
MN0 nq i vss sub! sg13_lv_nmos m=1 w=3.93u l=130.00n ng=1
MP0 nq i vdd vdd sg13_lv_pmos m=1 w=4.41u l=130.00n ng=1
R_G1_TAP_SYNTAX_XR0 vss sub! ptap1 A=624.1f P=3.16
.ENDS

************************************************************************
* Library Name: sg13g2_io
* Cell Name:    sg13g2_LevelUp
* View Name:    schematic
************************************************************************

.SUBCKT sg13g2_LevelUp o i iovdd vdd vss
*.PININFO i:I o:O iovdd:B vdd:B vss:B
MN1 net2 i vss sub! sg13_lv_nmos m=1 w=2.75u l=130.00n ng=1
MP3 net2 i vdd vdd sg13_lv_pmos m=1 w=4.75u l=130.00n ng=1
MN0 o net4 vss sub! sg13_hv_nmos m=1 w=1.9u l=450.00n ng=1
MN3 net4 i vss sub! sg13_hv_nmos m=1 w=1.9u l=450.00n ng=1
MN2 net3 net2 vss sub! sg13_hv_nmos m=1 w=1.9u l=450.00n ng=1
MP0 o net4 iovdd iovdd sg13_hv_pmos m=1 w=3.9u l=450.00n ng=1
MP1 net3 net4 iovdd iovdd sg13_hv_pmos m=1 w=300.0n l=450.00n ng=1
MP2 net4 net3 iovdd iovdd sg13_hv_pmos m=1 w=300.0n l=450.00n ng=1
R_G1_TAP_SYNTAX_XR0 vss sub! ptap1 A=912.025f P=3.82u
.ENDS

************************************************************************
* Library Name: sg13g2_io
* Cell Name:    sg13g2_io_nor2_x1
* View Name:    schematic
************************************************************************

.SUBCKT sg13g2_io_nor2_x1 nq i0 i1 vdd vss
*.PININFO i0:I i1:I nq:O vdd:B vss:B
MN0 nq i0 vss sub! sg13_lv_nmos m=1 w=3.93u l=130.00n ng=1
MN1 nq i1 vss sub! sg13_lv_nmos m=1 w=3.93u l=130.00n ng=1
MP0 net1 i0 vdd vdd sg13_lv_pmos m=1 w=4.41u l=130.00n ng=1
MP1 nq i1 net1 vdd sg13_lv_pmos m=1 w=4.41u l=130.00n ng=1
R_G1_TAP_SYNTAX_XR0 vss sub! ptap1 A=656.1f P=3.24u
.ENDS

************************************************************************
* Library Name: sg13g2_io
* Cell Name:    sg13g2_io_tie
* View Name:    schematic
************************************************************************

.SUBCKT sg13g2_io_tie vdd vss
*.PININFO vdd:B vss:B
R_G1_TAP_SYNTAX_XR0 vss sub! ptap1 A=624.1f P=3.16u
.ENDS

************************************************************************
* Library Name: sg13g2_io
* Cell Name:    sg13g2_io_nand2_x1
* View Name:    schematic
************************************************************************

.SUBCKT sg13g2_io_nand2_x1 nq i0 i1 vdd vss
*.PININFO i0:I i1:I nq:O vdd:B vss:B
MP1 nq i1 vdd vdd sg13_lv_pmos m=1 w=4.41u l=130.00n ng=1
MP0 nq i0 vdd vdd sg13_lv_pmos m=1 w=4.41u l=130.00n ng=1
MN1 net1 i0 vss sub! sg13_lv_nmos m=1 w=3.93u l=130.00n ng=1
MN0 nq i1 net1 sub! sg13_lv_nmos m=1 w=3.93u l=130.00n ng=1
R_G1_TAP_SYNTAX_XR0 vss sub! ptap1 A=656.1f P=3.24u
.ENDS

************************************************************************
* Library Name: sg13g2_io
* Cell Name:    sg13g2_GateDecode
* View Name:    schematic
************************************************************************

.SUBCKT sg13g2_GateDecode ngate pgate core en iovdd vdd vss
*.PININFO core:I en:I ngate:O pgate:O iovdd:B vdd:B vss:B
XI1 net3 en vdd vss / sg13g2_io_inv_x1
XI4 ngate net4 iovdd vdd vss / sg13g2_LevelUp
XI2 pgate net2 iovdd vdd vss / sg13g2_LevelUp
XI3 net4 core net3 vdd vss / sg13g2_io_nor2_x1
XI0 vdd vss / sg13g2_io_tie
XI5 net2 core en vdd vss / sg13g2_io_nand2_x1
.ENDS

************************************************************************
* Library Name: sg13g2_io
* Cell Name:    sg13g2_Clamp_N2N2D
* View Name:    schematic
************************************************************************

.SUBCKT sg13g2_Clamp_N2N2D gate iovss pad
*.PININFO gate:I iovss:B pad:B
R_G1_TAP_SYNTAX_XR0 iovss sub! ptap1 A=55.801p P=29.88u
MN1 pad gate iovss sub! sg13_hv_nmos m=1 w=8.8u l=600.0n ng=2
DD0 sub! gate dantenna m=1 w=780.00n l=780.00n a=608.400f p=3.12u
.ENDS

************************************************************************
* Library Name: sg13g2_io
* Cell Name:    sg13g2_Clamp_P2N2D
* View Name:    schematic
************************************************************************

.SUBCKT sg13g2_Clamp_P2N2D gate iovdd iovss pad
*.PININFO gate:I iovdd:B iovss:B pad:B
DD0 gate iovdd dpantenna m=1 w=480n l=480n a=230.4f p=1.92u
MP1 pad gate iovdd iovdd sg13_hv_pmos m=1 w=13.32u l=600.0n ng=2
MP0 pad gate iovdd iovdd sg13_hv_pmos m=1 w=13.32u l=600.0n ng=2
R_G1_TAP_SYNTAX_XR0 iovss sub! ptap1 A=66.994p P=32.74u
.ENDS

************************************************************************
* Library Name: sg13g2_io
* Cell Name:    sg13g2_SecondaryProtection
* View Name:    schematic
************************************************************************

.SUBCKT sg13g2_SecondaryProtection core minus pad plus
*.PININFO core:B minus:B pad:B plus:B
RR0 pad core 586.899 $SUB=sub! $[rppd] m=1 l=2u w=1u b=0 m=1
DD1 sub! core dantenna m=1 w=640n l=3.1u a=1.984p p=7.48u
R_G1_TAP_SYNTAX_XR1 minus sub! ptap1 A=9.03p P=12.02u
DD0 core plus dpantenna m=1 w=640n l=4.98u a=3.187p p=11.24u
.ENDS

************************************************************************
* Library Name: sg13g2_io
* Cell Name:    g1_LevelDown_polyres
* View Name:    schematic
************************************************************************

.SUBCKT g1_LevelDown_polyres core pad iovdd iovss vdd vss
*.PININFO pad:I core:O iovdd:B iovss:B vdd:B vss:B
MP0 vdd vdd vdd vdd sg13_hv_pmos m=1 w=4.65u l=450.00n ng=1
MP2 net4 net7 iovdd iovdd sg13_hv_pmos m=1 w=4.6u l=450.00n ng=2
MP3 net7 net1 iovdd iovdd sg13_hv_pmos m=1 w=4.6u l=450.00n ng=2
MN3 net4 net7 iovss sub! sg13_hv_nmos m=1 w=1.3u l=450.00n ng=1
MN4 net7 net1 iovss sub! sg13_hv_nmos m=1 w=1.3u l=450.00n ng=1
MN2 net2 net4 vss sub! sg13_hv_nmos m=1 w=2.65u l=450.00n ng=1
MN0 vdd net7 net2 sub! sg13_hv_nmos m=1 w=2.65u l=450.00n ng=1
MN1 core net2 vss sub! sg13_lv_nmos m=1 w=2.75u l=130.00n ng=1
MP1 core net2 vdd vdd sg13_lv_pmos m=1 w=4.75u l=130.00n ng=1
R_G1_TAP_SYNTAX_XR1 iovss sub! ptap1 A=970.225f P=3.94u
R_G1_TAP_SYNTAX_XR0 vss sub! ptap1 A=2.016p P=5.68u
XI0 net1 iovss pad iovdd / sg13g2_SecondaryProtection
.ENDS

************************************************************************
* Library Name: sg13g2_io
* Cell Name:    sg13g2_IOPadInOut4mA
* View Name:    schematic
************************************************************************

.SUBCKT sg13g2_IOPadInOut4mA pad c2p p2c c2p_en vdd vss iovdd iovss
*.PININFO c2p:I c2p_en:I p2c:O iovdd:B iovss:B pad:B vdd:B vss:B
XI1 pad iovdd iovss / sg13g2_DCPDiode
XI2 net2 net1 c2p c2p_en iovdd vdd vss / sg13g2_GateDecode
XI3 net2 iovss pad / sg13g2_Clamp_N2N2D
XI0 net1 iovdd iovss pad / sg13g2_Clamp_P2N2D
XI4 p2c pad iovdd iovss vdd vss / g1_LevelDown_polyres
R_G1_TAP_SYNTAX_XR0 vss sub! ptap1 A=18.966p P=17.42u
R_G1_TAP_SYNTAX_XR1 iovss sub! ptap1 A=4.314n P=262.72u
XI5 iovss pad iovdd / sg13g2_DCNDiode
.ENDS

************************************************************************
* Library Name: sg13g2_io
* Cell Name:    sg13g2_Clamp_P15N15D
* View Name:    schematic
************************************************************************

.SUBCKT sg13g2_Clamp_P15N15D gate iovdd iovss pad
*.PININFO gate:I iovdd:B iovss:B pad:B
DD0 gate iovdd dpantenna m=1 w=780.00n l=780.00n a=608.400f p=3.12u
R_G1_TAP_SYNTAX_XR0 iovss sub! ptap1 A=66.994p P=32.74u
MP1 pad gate iovdd iovdd sg13_hv_pmos m=1 w=99.9u l=600.0n ng=15
MP0 pad gate iovdd iovdd sg13_hv_pmos m=1 w=99.9u l=600.0n ng=15
.ENDS

************************************************************************
* Library Name: sg13g2_io
* Cell Name:    sg13g2_Clamp_N15N15D
* View Name:    schematic
************************************************************************

.SUBCKT sg13g2_Clamp_N15N15D gate iovss pad
*.PININFO gate:I iovss:B pad:B
R_G1_TAP_SYNTAX_XR0 iovss sub! ptap1 A=55.801p P=29.88u
MN0 pad gate iovss sub! sg13_hv_nmos m=1 w=66.000u l=600.0n ng=15
DD0 sub! gate dantenna m=1 w=780.00n l=780.00n a=608.400f p=3.12u
.ENDS

************************************************************************
* Library Name: sg13g2_io
* Cell Name:    sg13g2_IOPadInOut30mA
* View Name:    schematic
************************************************************************

.SUBCKT sg13g2_IOPadInOut30mA pad c2p p2c c2p_en vdd vss iovdd iovss
*.PININFO c2p:I c2p_en:I p2c:O iovdd:B iovss:B pad:B vdd:B vss:B
XI4 p2c pad iovdd iovss vdd vss / g1_LevelDown_polyres
XI1 pad iovdd iovss / sg13g2_DCPDiode
XI0 net1 iovdd iovss pad / sg13g2_Clamp_P15N15D
XI5 iovss pad iovdd / sg13g2_DCNDiode
XI3 net2 iovss pad / sg13g2_Clamp_N15N15D
XR0 vss sub! A=19.141p P=17.5u
XR1 iovss sub! A=4.313n P=262.7u
XI2 net2 net1 c2p c2p_en iovdd vdd vss / sg13g2_GateDecode
.ENDS

************************************************************************
* Library Name: sg13g2_io
* Cell Name:    sg13g2_LevelUpInv
* View Name:    schematic
************************************************************************

.SUBCKT sg13g2_LevelUpInv o i iovdd vdd vss
*.PININFO i:I o:O iovdd:B vdd:B vss:B
MN1 net2 i vss sub! sg13_lv_nmos m=1 w=2.75u l=130.00n ng=1
MP3 net2 i vdd vdd sg13_lv_pmos m=1 w=4.75u l=130.00n ng=1
MN0 o net4 vss sub! sg13_hv_nmos m=1 w=1.9u l=450.00n ng=1
MN3 net4 net2 vss sub! sg13_hv_nmos m=1 w=1.9u l=450.00n ng=1
MN2 net3 i vss sub! sg13_hv_nmos m=1 w=1.9u l=450.00n ng=1
MP0 o net4 iovdd iovdd sg13_hv_pmos m=1 w=3.9u l=450.00n ng=1
MP1 net3 net4 iovdd iovdd sg13_hv_pmos m=1 w=300.0n l=450.00n ng=1
MP2 net4 net3 iovdd iovdd sg13_hv_pmos m=1 w=300.0n l=450.00n ng=1
R_G1_TAP_SYNTAX_XR0 vss sub! ptap1 A=1.051p P=4.1u
.ENDS

************************************************************************
* Library Name: sg13g2_io
* Cell Name:    sg13g2_GateLevelUpInv
* View Name:    schematic
************************************************************************

.SUBCKT sg13g2_GateLevelUpInv ngate pgate iovdd core vdd vss
*.PININFO core:I ngate:O pgate:O iovdd:B vdd:B vss:B
XI1 pgate core iovdd vdd vss / sg13g2_LevelUpInv
XI0 ngate core iovdd vdd vss / sg13g2_LevelUpInv
.ENDS

************************************************************************
* Library Name: sg13g2_io
* Cell Name:    sg13g2_IOPadOut4mA
* View Name:    schematic
************************************************************************

.SUBCKT sg13g2_IOPadOut4mA pad c2p vdd vss iovdd iovss
*.PININFO c2p:I pad:O iovdd:B iovss:B vdd:B vss:B
XI2 net2 net1 iovdd c2p vdd vss / sg13g2_GateLevelUpInv
XI0 net1 iovdd iovss pad / sg13g2_Clamp_P2N2D
XI3 net2 iovss pad / sg13g2_Clamp_N2N2D
XI4 iovss pad iovdd / sg13g2_DCNDiode
XI1 pad iovdd iovss / sg13g2_DCPDiode
R_G1_TAP_SYNTAX_XR1 iovss sub! ptap1 A=4.343n P=263.6u
R_G1_TAP_SYNTAX_XR0 vss sub! ptap1 A=21.902p P=18.72u
.ENDS

************************************************************************
* Library Name: sg13g2_io
* Cell Name:    sg13g2_IOPadOut30mA
* View Name:    schematic
************************************************************************

.SUBCKT sg13g2_IOPadOut30mA pad c2p vdd vss iovdd iovss
*.PININFO c2p:I pad:O iovdd:B iovss:B vdd:B vss:B
XI2 net2 net1 iovdd c2p vdd vss / sg13g2_GateLevelUpInv
XI1 net1 iovdd iovss pad / sg13g2_Clamp_P15N15D
XI3 net2 iovss pad / sg13g2_Clamp_N15N15D
XI4 iovss pad iovdd / sg13g2_DCNDiode
XI0 pad iovdd iovss / sg13g2_DCPDiode
R_G1_TAP_SYNTAX_XR0 vss sub! ptap1 A=21.902p P=18.72u
R_G1_TAP_SYNTAX_XR1 iovss sub! ptap1 A=4.313n P=262.7u
.ENDS

************************************************************************
* Library Name: sg13g2_io
* Cell Name:    sg13g2_IOPadIn
* View Name:    schematic
************************************************************************

.SUBCKT sg13g2_IOPadIn pad p2c vdd vss iovdd iovss
*.PININFO pad:I p2c:O iovdd:B iovss:B vdd:B vss:B
XI0 p2c pad iovdd iovss vdd vss / g1_LevelDown_polyres
XI2 iovss pad iovdd / sg13g2_DCNDiode
XI1 pad iovdd iovss / sg13g2_DCPDiode
R_G1_TAP_SYNTAX_XR0 vss sub! ptap1 A=21.252p P=18.44u
R_G1_TAP_SYNTAX_XR1 iovss sub! ptap1 A=5.35n P=292.58u
.ENDS

************************************************************************
* Library Name: sg13g2_io
* Cell Name:    sg13g2_Clamp_P8N8D
* View Name:    schematic
************************************************************************

.SUBCKT sg13g2_Clamp_P8N8D gate iovdd iovss pad
*.PININFO gate:I iovdd:B iovss:B pad:B
R_G1_TAP_SYNTAX_XR0 iovss sub! ptap1 A=66.994p P=32.74u
MP2 pad gate iovdd iovdd sg13_hv_pmos m=1 w=53.28u l=600.0n ng=8
MP0 pad gate iovdd iovdd sg13_hv_pmos m=1 w=53.28u l=600.0n ng=8
DD0 gate iovdd dpantenna m=1 w=480n l=480n a=230.4f p=1.92u
.ENDS

************************************************************************
* Library Name: sg13g2_io
* Cell Name:    sg13g2_Clamp_N8N8D
* View Name:    schematic
************************************************************************

.SUBCKT sg13g2_Clamp_N8N8D gate iovss pad
*.PININFO gate:I iovss:B pad:B
R_G1_TAP_SYNTAX_XR0 iovss sub! ptap1 A=55.801p P=29.88u
MN0 pad gate iovss sub! sg13_hv_nmos m=1 w=35.2u l=600.0n ng=8
DD0 sub! gate dantenna m=1 w=780.00n l=780.00n a=608.400f p=3.12u
.ENDS

************************************************************************
* Library Name: sg13g2_io
* Cell Name:    sg13g2_IOPadInOut16mA
* View Name:    schematic
************************************************************************

.SUBCKT sg13g2_IOPadInOut16mA pad c2p p2c c2p_en vdd vss iovdd iovss
*.PININFO c2p:I c2p_en:I p2c:O iovdd:B iovss:B pad:B vdd:B vss:B
XI1 pad iovdd iovss / sg13g2_DCPDiode
XI2 net2 net1 c2p c2p_en iovdd vdd vss / sg13g2_GateDecode
XI5 iovss pad iovdd / sg13g2_DCNDiode
XI0 net1 iovdd iovss pad / sg13g2_Clamp_P8N8D
XI4 p2c pad iovdd iovss vdd vss / g1_LevelDown_polyres
XI3 net2 iovss pad / sg13g2_Clamp_N8N8D
R_G1_TAP_SYNTAX_XR0 vss sub! ptap1 A=18.966p P=17.42u
R_G1_TAP_SYNTAX_XR1 iovss sub! ptap1 A=4.45n P=266.84u
.ENDS

************************************************************************
* Library Name: sg13g2_io
* Cell Name:    sg13g2_IOPadOut16mA
* View Name:    schematic
************************************************************************

.SUBCKT sg13g2_IOPadOut16mA pad c2p vdd vss iovdd iovss
*.PININFO c2p:I pad:O iovdd:B iovss:B vdd:B vss:B
XI2 net2 net1 iovdd c2p vdd vss / sg13g2_GateLevelUpInv
XI0 net1 iovdd iovss pad / sg13g2_Clamp_P8N8D
XI4 iovss pad iovdd / sg13g2_DCNDiode
XI3 net2 iovss pad / sg13g2_Clamp_N8N8D
XI1 pad iovdd iovss / sg13g2_DCPDiode
R_G1_TAP_SYNTAX_XR0 vss sub! ptap1 A=22.184p P=18.84u
R_G1_TAP_SYNTAX_XR1 iovss sub! ptap1 A=4.43n P=266.24u
.ENDS

************************************************************************
* Library Name: sg13g2_io
* Cell Name:    sg13g2_IOPadTriOut4mA
* View Name:    schematic
************************************************************************

.SUBCKT sg13g2_IOPadTriOut4mA pad c2p c2p_en vdd vss iovdd iovss
*.PININFO c2p:I c2p_en:I pad:O iovdd:B iovss:B vdd:B vss:B
XI2 net2 net1 c2p c2p_en iovdd vdd vss / sg13g2_GateDecode
XI4 iovss pad iovdd / sg13g2_DCNDiode
XI3 net2 iovss pad / sg13g2_Clamp_N2N2D
XI0 net1 iovdd iovss pad / sg13g2_Clamp_P2N2D
XI1 pad iovdd iovss / sg13g2_DCPDiode
R_G1_TAP_SYNTAX_XR0 vss sub! ptap1 A=21.391p P=18.5u
R_G1_TAP_SYNTAX_XR1 iovss sub! ptap1 A=4.43n P=266.24u
.ENDS

************************************************************************
* Library Name: sg13g2_io
* Cell Name:    sg13g2_IOPadTriOut16mA
* View Name:    schematic
************************************************************************

.SUBCKT sg13g2_IOPadTriOut16mA pad c2p c2p_en vdd vss iovdd iovss
*.PININFO c2p:I c2p_en:I pad:O iovdd:B iovss:B vdd:B vss:B
XI2 net2 net1 c2p c2p_en iovdd vdd vss / sg13g2_GateDecode
XI0 net1 iovdd iovss pad / sg13g2_Clamp_P8N8D
XI3 net2 iovss pad / sg13g2_Clamp_N8N8D
XI4 iovss pad iovdd / sg13g2_DCNDiode
XI1 pad iovdd iovss / sg13g2_DCPDiode
R_G1_TAP_SYNTAX_XR0 vss sub! ptap1 A=21.022p P=18.34u
R_G1_TAP_SYNTAX_XR1 iovss sub! ptap1 A=4.44n P=266.54u
.ENDS

************************************************************************
* Library Name: sg13g2_io
* Cell Name:    sg13g2_IOPadTriOut30mA
* View Name:    schematic
************************************************************************

.SUBCKT sg13g2_IOPadTriOut30mA pad c2p c2p_en vdd vss iovdd iovss
*.PININFO c2p:I c2p_en:I pad:O iovdd:B iovss:B vdd:B vss:B
XI2 net2 net1 c2p c2p_en iovdd vdd vss / sg13g2_GateDecode
XI4 iovss pad iovdd / sg13g2_DCNDiode
XI3 net2 iovss pad / sg13g2_Clamp_N15N15D
XI0 net1 iovdd iovss pad / sg13g2_Clamp_P15N15D
XI1 pad iovdd iovss / sg13g2_DCPDiode
R_G1_TAP_SYNTAX_XR0 vss sub! ptap1 A=21.298p P=18.46u
R_G1_TAP_SYNTAX_XR1 iovss sub! ptap1 A=4.43n P=266.24u
.ENDS

************************************************************************
* Library Name: sg13g2_io
* Cell Name:    sg13g2_Corner
* View Name:    schematic
************************************************************************

.SUBCKT sg13g2_Corner vdd vss iovdd iovss
*.PININFO iovdd:B iovss:B vdd:B vss:B
R_G1_TAP_SYNTAX_XR1 vss sub! ptap1 A=13.177p P=14.52u
R_G1_TAP_SYNTAX_XR0 iovss sub! ptap1 A=10.13n P=402.6u
.ENDS

************************************************************************
* Library Name: sg13g2_io
* Cell Name:    sg13g2_Filler4000
* View Name:    schematic
************************************************************************

.SUBCKT sg13g2_Filler4000 vdd vss iovdd iovss
*.PININFO iovdd:B iovss:B vdd:B vss:B
R_G1_TAP_SYNTAX_XR1 vss sub! ptap1 A=5.856p P=9.68u
R_G1_TAP_SYNTAX_XR0 iovss sub! ptap1 A=1.416n P=150.5u
.ENDS

************************************************************************
* Library Name: sg13g2_io
* Cell Name:    sg13g2_Filler1000
* View Name:    schematic
************************************************************************

.SUBCKT sg13g2_Filler1000 vdd vss iovdd iovss
*.PININFO iovdd:B iovss:B vdd:B vss:B
R_G1_TAP_SYNTAX_XR1 vss sub! ptap1 A=1.369p P=4.68u
R_G1_TAP_SYNTAX_XR0 iovss sub! ptap1 A=328.697p P=72.52u
.ENDS

************************************************************************
* Library Name: sg13g2_io
* Cell Name:    sg13g2_Filler200
* View Name:    schematic
************************************************************************

.SUBCKT sg13g2_Filler200 vdd vss iovdd iovss
*.PININFO iovdd:B iovss:B vdd:B vss:B
R_G1_TAP_SYNTAX_XR1 vss sub! ptap1 A=680.625f P=3.3u
R_G1_TAP_SYNTAX_XR0 iovss sub! ptap1 A=40.96p P=25.6u
.ENDS

************************************************************************
* Library Name: sg13g2_io
* Cell Name:    sg13g2_Filler400
* View Name:    schematic
************************************************************************

.SUBCKT sg13g2_Filler400 vdd vss iovdd iovss
*.PININFO iovdd:B iovss:B vdd:B vss:B
R_G1_TAP_SYNTAX_XR1 vss sub! ptap1 A=680.625f P=3.3u
R_G1_TAP_SYNTAX_XR0 iovss sub! ptap1 A=114.169p P=42.74u
.ENDS

************************************************************************
* Library Name: sg13g2_io
* Cell Name:    sg13g2_Filler10000
* View Name:    schematic
************************************************************************

.SUBCKT sg13g2_Filler10000 vdd vss iovdd iovss
*.PININFO iovdd:B iovss:B vdd:B vss:B
R_G1_TAP_SYNTAX_XR1 vss sub! ptap1 A=14.861p Perim=15.42u
R_G1_TAP_SYNTAX_XR0 iovss sub! ptap1 A=3.622n Perim=240.72u
.ENDS

************************************************************************
* Library Name: sg13g2_io
* Cell Name:    sg13g2_Clamp_P20N0D
* View Name:    schematic
************************************************************************

.SUBCKT sg13g2_Clamp_P20N0D iovdd iovss pad
*.PININFO iovdd:B iovss:B pad:B
MP1 pad net2 iovdd iovdd sg13_hv_pmos m=1 w=133.2u l=600.0n ng=20
MP0 pad net2 iovdd iovdd sg13_hv_pmos m=1 w=133.2u l=600.0n ng=20
RR0 net2 iovdd 6.768K $SUB=iovdd $[rppd] l=12.9u w=500n b=0 m=1
R_G1_TAP_SYNTAX_XR1 iovss sub! ptap1 A=66.994p P=32.74u
.ENDS

************************************************************************
* Library Name: sg13g2_io
* Cell Name:    sg13g2_Clamp_N20N0D
* View Name:    schematic
************************************************************************

.SUBCKT sg13g2_Clamp_N20N0D iovss pad
*.PININFO iovss:B pad:B
MN0 pad net2 iovss sub! sg13_hv_nmos m=1 w=88.000u l=600.0n ng=20
R_G1_TAP_SYNTAX_XR1 iovss sub! ptap1 A=55.801p P=29.88u
RR0 iovss net2 1.959K $SUB=sub! $[rppd] l=3.54u w=500n b=0 m=1
.ENDS

************************************************************************
* Library Name: sg13g2_io
* Cell Name:    sg13g2_IOPadAnalog
* View Name:    schematic
************************************************************************

.SUBCKT sg13g2_IOPadAnalog pad padres vdd vss iovdd iovss
*.PININFO iovdd:B iovss:B pad:B padres:B vdd:B vss:B
XI0 iovdd iovss pad / sg13g2_Clamp_P20N0D
XI5 iovss pad iovdd / sg13g2_DCNDiode
XI2 pad iovdd iovss / sg13g2_DCPDiode
XI3 padres iovss pad iovdd / sg13g2_SecondaryProtection
XI4 iovss pad / sg13g2_Clamp_N20N0D
R_G1_TAP_SYNTAX_XR0 vss sub! ptap1 A=23.863p P=19.54u
R_G1_TAP_SYNTAX_XR1 iovss sub! ptap1 A=4.3n P=262.3u
.ENDS

* END_SOURCE sg13g2_io.cdl
.SUBCKT bondpad_70x70_tm1 pad
* Original metal-only bondpad interface
.ENDS
* BEGIN_TOP
.SUBCKT r1_padring VDDA ISA_P ISA_N ISB_P ISB_N FAULT_N GATE_A GATE_B GATE_C CS_N MA_SCLK SLO_SDO SDI EN_STO_IN SIN_P SIN_N COS_P COS_N VDD VSS IOVDD IOVSS
Xpad01_vdd VDD VSS IOVDD IOVSS VSS / G1_VSS_DERIVATIVE__sg13g2_IOPadVdd
Xpad02_vss VDD VSS IOVDD IOVSS VSS / G1_VSS_DERIVATIVE__sg13g2_IOPadVss
Xpad03_iovdd VDD VSS IOVDD IOVSS VSS / G1_VSS_DERIVATIVE__sg13g2_IOPadIOVdd
Xpad04_iovss VDD VSS IOVDD IOVSS VSS / G1_VSS_DERIVATIVE__sg13g2_IOPadIOVss
Xpad05_vss VDD VSS IOVDD IOVSS VSS / G1_VSS_DERIVATIVE__sg13g2_IOPadVss
Xpad06_iovss VDD VSS IOVDD IOVSS VSS / G1_VSS_DERIVATIVE__sg13g2_IOPadIOVss
Xpad07_vdda VDDA _nc1 VDD VSS IOVDD IOVSS VSS / G1_VSS_DERIVATIVE__sg13g2_IOPadAnalog
Xpad08_isa_p ISA_P _nc2 VDD VSS IOVDD IOVSS VSS / G1_VSS_DERIVATIVE__sg13g2_IOPadAnalog
Xpad09_isa_n ISA_N _nc3 VDD VSS IOVDD IOVSS VSS / G1_VSS_DERIVATIVE__sg13g2_IOPadAnalog
Xpad10_isb_p ISB_P _nc4 VDD VSS IOVDD IOVSS VSS / G1_VSS_DERIVATIVE__sg13g2_IOPadAnalog
Xpad11_isb_n ISB_N _nc5 VDD VSS IOVDD IOVSS VSS / G1_VSS_DERIVATIVE__sg13g2_IOPadAnalog
Xpad12_fault_n FAULT_N fault_n_c2p VDD VSS IOVDD IOVSS VSS / G1_VSS_DERIVATIVE__sg13g2_IOPadOut4mA
Xpad13_gate_a GATE_A gate_a_c2p VDD VSS IOVDD IOVSS VSS / G1_VSS_DERIVATIVE__sg13g2_IOPadOut30mA
Xpad14_gate_b GATE_B gate_b_c2p VDD VSS IOVDD IOVSS VSS / G1_VSS_DERIVATIVE__sg13g2_IOPadOut30mA
Xpad15_gate_c GATE_C gate_c_c2p VDD VSS IOVDD IOVSS VSS / G1_VSS_DERIVATIVE__sg13g2_IOPadOut30mA
Xpad16_cs_n CS_N cs_n_p2c VDD VSS IOVDD IOVSS VSS / G1_VSS_DERIVATIVE__sg13g2_IOPadIn
Xpad17_ma_sclk MA_SCLK ma_sclk_p2c VDD VSS IOVDD IOVSS VSS / G1_VSS_DERIVATIVE__sg13g2_IOPadIn
Xpad18_slo_sdo SLO_SDO slo_sdo_c2p VDD VSS IOVDD IOVSS VSS / G1_VSS_DERIVATIVE__sg13g2_IOPadOut4mA
Xpad19_sdi SDI sdi_p2c VDD VSS IOVDD IOVSS VSS / G1_VSS_DERIVATIVE__sg13g2_IOPadIn
Xpad20_en_sto_in EN_STO_IN en_sto_in_p2c VDD VSS IOVDD IOVSS VSS / G1_VSS_DERIVATIVE__sg13g2_IOPadIn
Xpad21_sin_p SIN_P _nc6 VDD VSS IOVDD IOVSS VSS / G1_VSS_DERIVATIVE__sg13g2_IOPadAnalog
Xpad22_sin_n SIN_N _nc7 VDD VSS IOVDD IOVSS VSS / G1_VSS_DERIVATIVE__sg13g2_IOPadAnalog
Xpad23_cos_p COS_P _nc8 VDD VSS IOVDD IOVSS VSS / G1_VSS_DERIVATIVE__sg13g2_IOPadAnalog
Xpad24_cos_n COS_N _nc9 VDD VSS IOVDD IOVSS VSS / G1_VSS_DERIVATIVE__sg13g2_IOPadAnalog
XIO_BOND_pad01_vdd VDD / bondpad_70x70_tm1
XIO_BOND_pad02_vss VSS / bondpad_70x70_tm1
XIO_BOND_pad03_iovdd IOVDD / bondpad_70x70_tm1
XIO_BOND_pad04_iovss IOVSS / bondpad_70x70_tm1
XIO_BOND_pad05_vss VSS / bondpad_70x70_tm1
XIO_BOND_pad06_iovss IOVSS / bondpad_70x70_tm1
XIO_BOND_pad07_vdda VDDA / bondpad_70x70_tm1
XIO_BOND_pad08_isa_p ISA_P / bondpad_70x70_tm1
XIO_BOND_pad09_isa_n ISA_N / bondpad_70x70_tm1
XIO_BOND_pad10_isb_p ISB_P / bondpad_70x70_tm1
XIO_BOND_pad11_isb_n ISB_N / bondpad_70x70_tm1
XIO_BOND_pad12_fault_n FAULT_N / bondpad_70x70_tm1
XIO_BOND_pad13_gate_a GATE_A / bondpad_70x70_tm1
XIO_BOND_pad14_gate_b GATE_B / bondpad_70x70_tm1
XIO_BOND_pad15_gate_c GATE_C / bondpad_70x70_tm1
XIO_BOND_pad16_cs_n CS_N / bondpad_70x70_tm1
XIO_BOND_pad17_ma_sclk MA_SCLK / bondpad_70x70_tm1
XIO_BOND_pad18_slo_sdo SLO_SDO / bondpad_70x70_tm1
XIO_BOND_pad19_sdi SDI / bondpad_70x70_tm1
XIO_BOND_pad20_en_sto_in EN_STO_IN / bondpad_70x70_tm1
XIO_BOND_pad21_sin_p SIN_P / bondpad_70x70_tm1
XIO_BOND_pad22_sin_n SIN_N / bondpad_70x70_tm1
XIO_BOND_pad23_cos_p COS_P / bondpad_70x70_tm1
XIO_BOND_pad24_cos_n COS_N / bondpad_70x70_tm1
XIO_CORNER_NORTH_EAST_INST VDD VSS IOVDD IOVSS VSS / G1_VSS_DERIVATIVE__sg13g2_Corner
XIO_CORNER_NORTH_WEST_INST VDD VSS IOVDD IOVSS VSS / G1_VSS_DERIVATIVE__sg13g2_Corner
XIO_CORNER_SOUTH_EAST_INST VDD VSS IOVDD IOVSS VSS / G1_VSS_DERIVATIVE__sg13g2_Corner
XIO_CORNER_SOUTH_WEST_INST VDD VSS IOVDD IOVSS VSS / G1_VSS_DERIVATIVE__sg13g2_Corner
XIO_FILL_IO_EAST_0_0 VDD VSS IOVDD IOVSS VSS / G1_VSS_DERIVATIVE__sg13g2_Filler4000
XIO_FILL_IO_EAST_0_20 VDD VSS IOVDD IOVSS VSS / G1_VSS_DERIVATIVE__sg13g2_Filler2000
XIO_FILL_IO_EAST_0_30 VDD VSS IOVDD IOVSS VSS / G1_VSS_DERIVATIVE__sg13g2_Filler400
XIO_FILL_IO_EAST_0_32 VDD VSS IOVDD IOVSS VSS / G1_VSS_DERIVATIVE__sg13g2_Filler400
XIO_FILL_IO_EAST_1_0 VDD VSS IOVDD IOVSS VSS / G1_VSS_DERIVATIVE__sg13g2_Filler4000
XIO_FILL_IO_EAST_1_20 VDD VSS IOVDD IOVSS VSS / G1_VSS_DERIVATIVE__sg13g2_Filler2000
XIO_FILL_IO_EAST_1_30 VDD VSS IOVDD IOVSS VSS / G1_VSS_DERIVATIVE__sg13g2_Filler400
XIO_FILL_IO_EAST_2_0 VDD VSS IOVDD IOVSS VSS / G1_VSS_DERIVATIVE__sg13g2_Filler4000
XIO_FILL_IO_EAST_2_20 VDD VSS IOVDD IOVSS VSS / G1_VSS_DERIVATIVE__sg13g2_Filler2000
XIO_FILL_IO_EAST_2_30 VDD VSS IOVDD IOVSS VSS / G1_VSS_DERIVATIVE__sg13g2_Filler400
XIO_FILL_IO_EAST_3_0 VDD VSS IOVDD IOVSS VSS / G1_VSS_DERIVATIVE__sg13g2_Filler4000
XIO_FILL_IO_EAST_3_20 VDD VSS IOVDD IOVSS VSS / G1_VSS_DERIVATIVE__sg13g2_Filler2000
XIO_FILL_IO_EAST_3_30 VDD VSS IOVDD IOVSS VSS / G1_VSS_DERIVATIVE__sg13g2_Filler400
XIO_FILL_IO_EAST_4_0 VDD VSS IOVDD IOVSS VSS / G1_VSS_DERIVATIVE__sg13g2_Filler4000
XIO_FILL_IO_EAST_4_20 VDD VSS IOVDD IOVSS VSS / G1_VSS_DERIVATIVE__sg13g2_Filler2000
XIO_FILL_IO_EAST_4_30 VDD VSS IOVDD IOVSS VSS / G1_VSS_DERIVATIVE__sg13g2_Filler400
XIO_FILL_IO_EAST_5_0 VDD VSS IOVDD IOVSS VSS / G1_VSS_DERIVATIVE__sg13g2_Filler4000
XIO_FILL_IO_EAST_5_20 VDD VSS IOVDD IOVSS VSS / G1_VSS_DERIVATIVE__sg13g2_Filler2000
XIO_FILL_IO_EAST_5_30 VDD VSS IOVDD IOVSS VSS / G1_VSS_DERIVATIVE__sg13g2_Filler400
XIO_FILL_IO_EAST_6_0 VDD VSS IOVDD IOVSS VSS / G1_VSS_DERIVATIVE__sg13g2_Filler4000
XIO_FILL_IO_EAST_6_20 VDD VSS IOVDD IOVSS VSS / G1_VSS_DERIVATIVE__sg13g2_Filler2000
XIO_FILL_IO_EAST_6_30 VDD VSS IOVDD IOVSS VSS / G1_VSS_DERIVATIVE__sg13g2_Filler400
XIO_FILL_IO_EAST_6_32 VDD VSS IOVDD IOVSS VSS / G1_VSS_DERIVATIVE__sg13g2_Filler400
XIO_FILL_IO_NORTH_0_0 VDD VSS IOVDD IOVSS VSS / G1_VSS_DERIVATIVE__sg13g2_Filler4000
XIO_FILL_IO_NORTH_0_20 VDD VSS IOVDD IOVSS VSS / G1_VSS_DERIVATIVE__sg13g2_Filler2000
XIO_FILL_IO_NORTH_0_30 VDD VSS IOVDD IOVSS VSS / G1_VSS_DERIVATIVE__sg13g2_Filler400
XIO_FILL_IO_NORTH_0_32 VDD VSS IOVDD IOVSS VSS / G1_VSS_DERIVATIVE__sg13g2_Filler400
XIO_FILL_IO_NORTH_1_0 VDD VSS IOVDD IOVSS VSS / G1_VSS_DERIVATIVE__sg13g2_Filler4000
XIO_FILL_IO_NORTH_1_20 VDD VSS IOVDD IOVSS VSS / G1_VSS_DERIVATIVE__sg13g2_Filler2000
XIO_FILL_IO_NORTH_1_30 VDD VSS IOVDD IOVSS VSS / G1_VSS_DERIVATIVE__sg13g2_Filler400
XIO_FILL_IO_NORTH_2_0 VDD VSS IOVDD IOVSS VSS / G1_VSS_DERIVATIVE__sg13g2_Filler4000
XIO_FILL_IO_NORTH_2_20 VDD VSS IOVDD IOVSS VSS / G1_VSS_DERIVATIVE__sg13g2_Filler2000
XIO_FILL_IO_NORTH_2_30 VDD VSS IOVDD IOVSS VSS / G1_VSS_DERIVATIVE__sg13g2_Filler400
XIO_FILL_IO_NORTH_3_0 VDD VSS IOVDD IOVSS VSS / G1_VSS_DERIVATIVE__sg13g2_Filler4000
XIO_FILL_IO_NORTH_3_20 VDD VSS IOVDD IOVSS VSS / G1_VSS_DERIVATIVE__sg13g2_Filler2000
XIO_FILL_IO_NORTH_3_30 VDD VSS IOVDD IOVSS VSS / G1_VSS_DERIVATIVE__sg13g2_Filler400
XIO_FILL_IO_NORTH_4_0 VDD VSS IOVDD IOVSS VSS / G1_VSS_DERIVATIVE__sg13g2_Filler4000
XIO_FILL_IO_NORTH_4_20 VDD VSS IOVDD IOVSS VSS / G1_VSS_DERIVATIVE__sg13g2_Filler2000
XIO_FILL_IO_NORTH_4_30 VDD VSS IOVDD IOVSS VSS / G1_VSS_DERIVATIVE__sg13g2_Filler400
XIO_FILL_IO_NORTH_5_0 VDD VSS IOVDD IOVSS VSS / G1_VSS_DERIVATIVE__sg13g2_Filler4000
XIO_FILL_IO_NORTH_5_20 VDD VSS IOVDD IOVSS VSS / G1_VSS_DERIVATIVE__sg13g2_Filler2000
XIO_FILL_IO_NORTH_5_30 VDD VSS IOVDD IOVSS VSS / G1_VSS_DERIVATIVE__sg13g2_Filler400
XIO_FILL_IO_NORTH_6_0 VDD VSS IOVDD IOVSS VSS / G1_VSS_DERIVATIVE__sg13g2_Filler4000
XIO_FILL_IO_NORTH_6_20 VDD VSS IOVDD IOVSS VSS / G1_VSS_DERIVATIVE__sg13g2_Filler2000
XIO_FILL_IO_NORTH_6_30 VDD VSS IOVDD IOVSS VSS / G1_VSS_DERIVATIVE__sg13g2_Filler400
XIO_FILL_IO_NORTH_6_32 VDD VSS IOVDD IOVSS VSS / G1_VSS_DERIVATIVE__sg13g2_Filler400
XIO_FILL_IO_SOUTH_0_0 VDD VSS IOVDD IOVSS VSS / G1_VSS_DERIVATIVE__sg13g2_Filler4000
XIO_FILL_IO_SOUTH_0_20 VDD VSS IOVDD IOVSS VSS / G1_VSS_DERIVATIVE__sg13g2_Filler2000
XIO_FILL_IO_SOUTH_0_30 VDD VSS IOVDD IOVSS VSS / G1_VSS_DERIVATIVE__sg13g2_Filler400
XIO_FILL_IO_SOUTH_0_32 VDD VSS IOVDD IOVSS VSS / G1_VSS_DERIVATIVE__sg13g2_Filler400
XIO_FILL_IO_SOUTH_1_0 VDD VSS IOVDD IOVSS VSS / G1_VSS_DERIVATIVE__sg13g2_Filler4000
XIO_FILL_IO_SOUTH_1_20 VDD VSS IOVDD IOVSS VSS / G1_VSS_DERIVATIVE__sg13g2_Filler2000
XIO_FILL_IO_SOUTH_1_30 VDD VSS IOVDD IOVSS VSS / G1_VSS_DERIVATIVE__sg13g2_Filler400
XIO_FILL_IO_SOUTH_2_0 VDD VSS IOVDD IOVSS VSS / G1_VSS_DERIVATIVE__sg13g2_Filler4000
XIO_FILL_IO_SOUTH_2_20 VDD VSS IOVDD IOVSS VSS / G1_VSS_DERIVATIVE__sg13g2_Filler2000
XIO_FILL_IO_SOUTH_2_30 VDD VSS IOVDD IOVSS VSS / G1_VSS_DERIVATIVE__sg13g2_Filler400
XIO_FILL_IO_SOUTH_3_0 VDD VSS IOVDD IOVSS VSS / G1_VSS_DERIVATIVE__sg13g2_Filler4000
XIO_FILL_IO_SOUTH_3_20 VDD VSS IOVDD IOVSS VSS / G1_VSS_DERIVATIVE__sg13g2_Filler2000
XIO_FILL_IO_SOUTH_3_30 VDD VSS IOVDD IOVSS VSS / G1_VSS_DERIVATIVE__sg13g2_Filler400
XIO_FILL_IO_SOUTH_4_0 VDD VSS IOVDD IOVSS VSS / G1_VSS_DERIVATIVE__sg13g2_Filler4000
XIO_FILL_IO_SOUTH_4_20 VDD VSS IOVDD IOVSS VSS / G1_VSS_DERIVATIVE__sg13g2_Filler2000
XIO_FILL_IO_SOUTH_4_30 VDD VSS IOVDD IOVSS VSS / G1_VSS_DERIVATIVE__sg13g2_Filler400
XIO_FILL_IO_SOUTH_5_0 VDD VSS IOVDD IOVSS VSS / G1_VSS_DERIVATIVE__sg13g2_Filler4000
XIO_FILL_IO_SOUTH_5_20 VDD VSS IOVDD IOVSS VSS / G1_VSS_DERIVATIVE__sg13g2_Filler2000
XIO_FILL_IO_SOUTH_5_30 VDD VSS IOVDD IOVSS VSS / G1_VSS_DERIVATIVE__sg13g2_Filler400
XIO_FILL_IO_SOUTH_6_0 VDD VSS IOVDD IOVSS VSS / G1_VSS_DERIVATIVE__sg13g2_Filler4000
XIO_FILL_IO_SOUTH_6_20 VDD VSS IOVDD IOVSS VSS / G1_VSS_DERIVATIVE__sg13g2_Filler2000
XIO_FILL_IO_SOUTH_6_30 VDD VSS IOVDD IOVSS VSS / G1_VSS_DERIVATIVE__sg13g2_Filler400
XIO_FILL_IO_SOUTH_6_32 VDD VSS IOVDD IOVSS VSS / G1_VSS_DERIVATIVE__sg13g2_Filler400
XIO_FILL_IO_WEST_0_0 VDD VSS IOVDD IOVSS VSS / G1_VSS_DERIVATIVE__sg13g2_Filler4000
XIO_FILL_IO_WEST_0_20 VDD VSS IOVDD IOVSS VSS / G1_VSS_DERIVATIVE__sg13g2_Filler2000
XIO_FILL_IO_WEST_0_30 VDD VSS IOVDD IOVSS VSS / G1_VSS_DERIVATIVE__sg13g2_Filler400
XIO_FILL_IO_WEST_0_32 VDD VSS IOVDD IOVSS VSS / G1_VSS_DERIVATIVE__sg13g2_Filler400
XIO_FILL_IO_WEST_1_0 VDD VSS IOVDD IOVSS VSS / G1_VSS_DERIVATIVE__sg13g2_Filler4000
XIO_FILL_IO_WEST_1_20 VDD VSS IOVDD IOVSS VSS / G1_VSS_DERIVATIVE__sg13g2_Filler2000
XIO_FILL_IO_WEST_1_30 VDD VSS IOVDD IOVSS VSS / G1_VSS_DERIVATIVE__sg13g2_Filler400
XIO_FILL_IO_WEST_2_0 VDD VSS IOVDD IOVSS VSS / G1_VSS_DERIVATIVE__sg13g2_Filler4000
XIO_FILL_IO_WEST_2_20 VDD VSS IOVDD IOVSS VSS / G1_VSS_DERIVATIVE__sg13g2_Filler2000
XIO_FILL_IO_WEST_2_30 VDD VSS IOVDD IOVSS VSS / G1_VSS_DERIVATIVE__sg13g2_Filler400
XIO_FILL_IO_WEST_3_0 VDD VSS IOVDD IOVSS VSS / G1_VSS_DERIVATIVE__sg13g2_Filler4000
XIO_FILL_IO_WEST_3_20 VDD VSS IOVDD IOVSS VSS / G1_VSS_DERIVATIVE__sg13g2_Filler2000
XIO_FILL_IO_WEST_3_30 VDD VSS IOVDD IOVSS VSS / G1_VSS_DERIVATIVE__sg13g2_Filler400
XIO_FILL_IO_WEST_4_0 VDD VSS IOVDD IOVSS VSS / G1_VSS_DERIVATIVE__sg13g2_Filler4000
XIO_FILL_IO_WEST_4_20 VDD VSS IOVDD IOVSS VSS / G1_VSS_DERIVATIVE__sg13g2_Filler2000
XIO_FILL_IO_WEST_4_30 VDD VSS IOVDD IOVSS VSS / G1_VSS_DERIVATIVE__sg13g2_Filler400
XIO_FILL_IO_WEST_5_0 VDD VSS IOVDD IOVSS VSS / G1_VSS_DERIVATIVE__sg13g2_Filler4000
XIO_FILL_IO_WEST_5_20 VDD VSS IOVDD IOVSS VSS / G1_VSS_DERIVATIVE__sg13g2_Filler2000
XIO_FILL_IO_WEST_5_30 VDD VSS IOVDD IOVSS VSS / G1_VSS_DERIVATIVE__sg13g2_Filler400
XIO_FILL_IO_WEST_6_0 VDD VSS IOVDD IOVSS VSS / G1_VSS_DERIVATIVE__sg13g2_Filler4000
XIO_FILL_IO_WEST_6_20 VDD VSS IOVDD IOVSS VSS / G1_VSS_DERIVATIVE__sg13g2_Filler2000
XIO_FILL_IO_WEST_6_30 VDD VSS IOVDD IOVSS VSS / G1_VSS_DERIVATIVE__sg13g2_Filler400
XIO_FILL_IO_WEST_6_32 VDD VSS IOVDD IOVSS VSS / G1_VSS_DERIVATIVE__sg13g2_Filler400
XIO_EXPAND_SOUTH_0 VDD VSS IOVDD IOVSS VSS / G1_VSS_DERIVATIVE__sg13g2_Filler4000
XIO_EXPAND_SOUTH_1 VDD VSS IOVDD IOVSS VSS / G1_VSS_DERIVATIVE__sg13g2_Filler4000
XIO_EXPAND_SOUTH_2 VDD VSS IOVDD IOVSS VSS / G1_VSS_DERIVATIVE__sg13g2_Filler4000
XIO_EXPAND_SOUTH_3 VDD VSS IOVDD IOVSS VSS / G1_VSS_DERIVATIVE__sg13g2_Filler400
XIO_EXPAND_SOUTH_4 VDD VSS IOVDD IOVSS VSS / G1_VSS_DERIVATIVE__sg13g2_Filler400
XIO_EXPAND_NORTH_0 VDD VSS IOVDD IOVSS VSS / G1_VSS_DERIVATIVE__sg13g2_Filler4000
XIO_EXPAND_NORTH_1 VDD VSS IOVDD IOVSS VSS / G1_VSS_DERIVATIVE__sg13g2_Filler4000
XIO_EXPAND_NORTH_2 VDD VSS IOVDD IOVSS VSS / G1_VSS_DERIVATIVE__sg13g2_Filler4000
XIO_EXPAND_NORTH_3 VDD VSS IOVDD IOVSS VSS / G1_VSS_DERIVATIVE__sg13g2_Filler400
XIO_EXPAND_NORTH_4 VDD VSS IOVDD IOVSS VSS / G1_VSS_DERIVATIVE__sg13g2_Filler400
XIO_EXPAND_EAST_0 VDD VSS IOVDD IOVSS VSS / G1_VSS_DERIVATIVE__sg13g2_Filler4000
XIO_EXPAND_EAST_1 VDD VSS IOVDD IOVSS VSS / G1_VSS_DERIVATIVE__sg13g2_Filler4000
XIO_EXPAND_EAST_2 VDD VSS IOVDD IOVSS VSS / G1_VSS_DERIVATIVE__sg13g2_Filler4000
XIO_EXPAND_EAST_3 VDD VSS IOVDD IOVSS VSS / G1_VSS_DERIVATIVE__sg13g2_Filler400
XIO_EXPAND_EAST_4 VDD VSS IOVDD IOVSS VSS / G1_VSS_DERIVATIVE__sg13g2_Filler400
XIO_EXPAND_WEST_0 VDD VSS IOVDD IOVSS VSS / G1_VSS_DERIVATIVE__sg13g2_Filler4000
XIO_EXPAND_WEST_1 VDD VSS IOVDD IOVSS VSS / G1_VSS_DERIVATIVE__sg13g2_Filler4000
XIO_EXPAND_WEST_2 VDD VSS IOVDD IOVSS VSS / G1_VSS_DERIVATIVE__sg13g2_Filler4000
XIO_EXPAND_WEST_3 VDD VSS IOVDD IOVSS VSS / G1_VSS_DERIVATIVE__sg13g2_Filler400
XIO_EXPAND_WEST_4 VDD VSS IOVDD IOVSS VSS / G1_VSS_DERIVATIVE__sg13g2_Filler400
.ENDS
* END_TOP

* BEGIN_EXPLICIT_VSS_DESIGN_LOCAL_DERIVATIVES
.SUBCKT G1_VSS_DERIVATIVE__sg13g2_Clamp_N15N15D gate iovss pad G1_EXPLICIT_SUBSTRATE_VSS
*.PININFO gate:I iovss:B pad:B
R_G1_TAP_SYNTAX_XR0 iovss G1_EXPLICIT_SUBSTRATE_VSS ptap1 A=55.7736p P=328.08u
MN0 pad gate iovss G1_EXPLICIT_SUBSTRATE_VSS sg13_hv_nmos m=1 w=66.000u l=600.0n ng=15
DD0 G1_EXPLICIT_SUBSTRATE_VSS gate dantenna m=1 w=780.00n l=780.00n a=608.400f p=3.12u
.ENDS
.SUBCKT G1_VSS_DERIVATIVE__sg13g2_Clamp_N20N0D iovss pad G1_EXPLICIT_SUBSTRATE_VSS
*.PININFO iovss:B pad:B
MN0 pad net2 iovss G1_EXPLICIT_SUBSTRATE_VSS sg13_hv_nmos m=1 w=88.000u l=600.0n ng=20
R_G1_TAP_SYNTAX_XR1 iovss G1_EXPLICIT_SUBSTRATE_VSS ptap1 A=55.7736p P=328.08u
RR0 iovss net2 1.959K $SUB=G1_EXPLICIT_SUBSTRATE_VSS $[rppd] l=3.54u w=500n b=0 m=1
.ENDS
.SUBCKT G1_VSS_DERIVATIVE__sg13g2_Clamp_N2N2D gate iovss pad G1_EXPLICIT_SUBSTRATE_VSS
*.PININFO gate:I iovss:B pad:B
R_G1_TAP_SYNTAX_XR0 iovss G1_EXPLICIT_SUBSTRATE_VSS ptap1 A=55.7736p P=328.08u
MN1 pad gate iovss G1_EXPLICIT_SUBSTRATE_VSS sg13_hv_nmos m=1 w=8.8u l=600.0n ng=2
DD0 G1_EXPLICIT_SUBSTRATE_VSS gate dantenna m=1 w=780.00n l=780.00n a=608.400f p=3.12u
.ENDS
.SUBCKT G1_VSS_DERIVATIVE__sg13g2_Clamp_N43N43D4R gate iovss pad G1_EXPLICIT_SUBSTRATE_VSS
*.PININFO gate:I iovss:B pad:B
MN0<1> pad gate iovss G1_EXPLICIT_SUBSTRATE_VSS sg13_hv_nmos m=1 w=4.4u l=600.0n ng=1
MN0<2> pad gate iovss G1_EXPLICIT_SUBSTRATE_VSS sg13_hv_nmos m=1 w=4.4u l=600.0n ng=1
MN0<3> pad gate iovss G1_EXPLICIT_SUBSTRATE_VSS sg13_hv_nmos m=1 w=4.4u l=600.0n ng=1
MN0<4> pad gate iovss G1_EXPLICIT_SUBSTRATE_VSS sg13_hv_nmos m=1 w=4.4u l=600.0n ng=1
MN0<5> pad gate iovss G1_EXPLICIT_SUBSTRATE_VSS sg13_hv_nmos m=1 w=4.4u l=600.0n ng=1
MN0<6> pad gate iovss G1_EXPLICIT_SUBSTRATE_VSS sg13_hv_nmos m=1 w=4.4u l=600.0n ng=1
MN0<7> pad gate iovss G1_EXPLICIT_SUBSTRATE_VSS sg13_hv_nmos m=1 w=4.4u l=600.0n ng=1
MN0<8> pad gate iovss G1_EXPLICIT_SUBSTRATE_VSS sg13_hv_nmos m=1 w=4.4u l=600.0n ng=1
MN0<9> pad gate iovss G1_EXPLICIT_SUBSTRATE_VSS sg13_hv_nmos m=1 w=4.4u l=600.0n ng=1
MN0<10> pad gate iovss G1_EXPLICIT_SUBSTRATE_VSS sg13_hv_nmos m=1 w=4.4u l=600.0n ng=1
MN0<11> pad gate iovss G1_EXPLICIT_SUBSTRATE_VSS sg13_hv_nmos m=1 w=4.4u l=600.0n ng=1
MN0<12> pad gate iovss G1_EXPLICIT_SUBSTRATE_VSS sg13_hv_nmos m=1 w=4.4u l=600.0n ng=1
MN0<13> pad gate iovss G1_EXPLICIT_SUBSTRATE_VSS sg13_hv_nmos m=1 w=4.4u l=600.0n ng=1
MN0<14> pad gate iovss G1_EXPLICIT_SUBSTRATE_VSS sg13_hv_nmos m=1 w=4.4u l=600.0n ng=1
MN0<15> pad gate iovss G1_EXPLICIT_SUBSTRATE_VSS sg13_hv_nmos m=1 w=4.4u l=600.0n ng=1
MN0<16> pad gate iovss G1_EXPLICIT_SUBSTRATE_VSS sg13_hv_nmos m=1 w=4.4u l=600.0n ng=1
MN0<17> pad gate iovss G1_EXPLICIT_SUBSTRATE_VSS sg13_hv_nmos m=1 w=4.4u l=600.0n ng=1
MN0<18> pad gate iovss G1_EXPLICIT_SUBSTRATE_VSS sg13_hv_nmos m=1 w=4.4u l=600.0n ng=1
MN0<19> pad gate iovss G1_EXPLICIT_SUBSTRATE_VSS sg13_hv_nmos m=1 w=4.4u l=600.0n ng=1
MN0<20> pad gate iovss G1_EXPLICIT_SUBSTRATE_VSS sg13_hv_nmos m=1 w=4.4u l=600.0n ng=1
MN0<21> pad gate iovss G1_EXPLICIT_SUBSTRATE_VSS sg13_hv_nmos m=1 w=4.4u l=600.0n ng=1
MN0<22> pad gate iovss G1_EXPLICIT_SUBSTRATE_VSS sg13_hv_nmos m=1 w=4.4u l=600.0n ng=1
MN0<23> pad gate iovss G1_EXPLICIT_SUBSTRATE_VSS sg13_hv_nmos m=1 w=4.4u l=600.0n ng=1
MN0<24> pad gate iovss G1_EXPLICIT_SUBSTRATE_VSS sg13_hv_nmos m=1 w=4.4u l=600.0n ng=1
MN0<25> pad gate iovss G1_EXPLICIT_SUBSTRATE_VSS sg13_hv_nmos m=1 w=4.4u l=600.0n ng=1
MN0<26> pad gate iovss G1_EXPLICIT_SUBSTRATE_VSS sg13_hv_nmos m=1 w=4.4u l=600.0n ng=1
MN0<27> pad gate iovss G1_EXPLICIT_SUBSTRATE_VSS sg13_hv_nmos m=1 w=4.4u l=600.0n ng=1
MN0<28> pad gate iovss G1_EXPLICIT_SUBSTRATE_VSS sg13_hv_nmos m=1 w=4.4u l=600.0n ng=1
MN0<29> pad gate iovss G1_EXPLICIT_SUBSTRATE_VSS sg13_hv_nmos m=1 w=4.4u l=600.0n ng=1
MN0<30> pad gate iovss G1_EXPLICIT_SUBSTRATE_VSS sg13_hv_nmos m=1 w=4.4u l=600.0n ng=1
MN0<31> pad gate iovss G1_EXPLICIT_SUBSTRATE_VSS sg13_hv_nmos m=1 w=4.4u l=600.0n ng=1
MN0<32> pad gate iovss G1_EXPLICIT_SUBSTRATE_VSS sg13_hv_nmos m=1 w=4.4u l=600.0n ng=1
MN0<33> pad gate iovss G1_EXPLICIT_SUBSTRATE_VSS sg13_hv_nmos m=1 w=4.4u l=600.0n ng=1
MN0<34> pad gate iovss G1_EXPLICIT_SUBSTRATE_VSS sg13_hv_nmos m=1 w=4.4u l=600.0n ng=1
MN0<35> pad gate iovss G1_EXPLICIT_SUBSTRATE_VSS sg13_hv_nmos m=1 w=4.4u l=600.0n ng=1
MN0<36> pad gate iovss G1_EXPLICIT_SUBSTRATE_VSS sg13_hv_nmos m=1 w=4.4u l=600.0n ng=1
MN0<37> pad gate iovss G1_EXPLICIT_SUBSTRATE_VSS sg13_hv_nmos m=1 w=4.4u l=600.0n ng=1
MN0<38> pad gate iovss G1_EXPLICIT_SUBSTRATE_VSS sg13_hv_nmos m=1 w=4.4u l=600.0n ng=1
MN0<39> pad gate iovss G1_EXPLICIT_SUBSTRATE_VSS sg13_hv_nmos m=1 w=4.4u l=600.0n ng=1
MN0<40> pad gate iovss G1_EXPLICIT_SUBSTRATE_VSS sg13_hv_nmos m=1 w=4.4u l=600.0n ng=1
MN0<41> pad gate iovss G1_EXPLICIT_SUBSTRATE_VSS sg13_hv_nmos m=1 w=4.4u l=600.0n ng=1
MN0<42> pad gate iovss G1_EXPLICIT_SUBSTRATE_VSS sg13_hv_nmos m=1 w=4.4u l=600.0n ng=1
MN0<43> pad gate iovss G1_EXPLICIT_SUBSTRATE_VSS sg13_hv_nmos m=1 w=4.4u l=600.0n ng=1
MN0<44> pad gate iovss G1_EXPLICIT_SUBSTRATE_VSS sg13_hv_nmos m=1 w=4.4u l=600.0n ng=1
MN0<45> pad gate iovss G1_EXPLICIT_SUBSTRATE_VSS sg13_hv_nmos m=1 w=4.4u l=600.0n ng=1
MN0<46> pad gate iovss G1_EXPLICIT_SUBSTRATE_VSS sg13_hv_nmos m=1 w=4.4u l=600.0n ng=1
MN0<47> pad gate iovss G1_EXPLICIT_SUBSTRATE_VSS sg13_hv_nmos m=1 w=4.4u l=600.0n ng=1
MN0<48> pad gate iovss G1_EXPLICIT_SUBSTRATE_VSS sg13_hv_nmos m=1 w=4.4u l=600.0n ng=1
MN0<49> pad gate iovss G1_EXPLICIT_SUBSTRATE_VSS sg13_hv_nmos m=1 w=4.4u l=600.0n ng=1
MN0<50> pad gate iovss G1_EXPLICIT_SUBSTRATE_VSS sg13_hv_nmos m=1 w=4.4u l=600.0n ng=1
MN0<51> pad gate iovss G1_EXPLICIT_SUBSTRATE_VSS sg13_hv_nmos m=1 w=4.4u l=600.0n ng=1
MN0<52> pad gate iovss G1_EXPLICIT_SUBSTRATE_VSS sg13_hv_nmos m=1 w=4.4u l=600.0n ng=1
MN0<53> pad gate iovss G1_EXPLICIT_SUBSTRATE_VSS sg13_hv_nmos m=1 w=4.4u l=600.0n ng=1
MN0<54> pad gate iovss G1_EXPLICIT_SUBSTRATE_VSS sg13_hv_nmos m=1 w=4.4u l=600.0n ng=1
MN0<55> pad gate iovss G1_EXPLICIT_SUBSTRATE_VSS sg13_hv_nmos m=1 w=4.4u l=600.0n ng=1
MN0<56> pad gate iovss G1_EXPLICIT_SUBSTRATE_VSS sg13_hv_nmos m=1 w=4.4u l=600.0n ng=1
MN0<57> pad gate iovss G1_EXPLICIT_SUBSTRATE_VSS sg13_hv_nmos m=1 w=4.4u l=600.0n ng=1
MN0<58> pad gate iovss G1_EXPLICIT_SUBSTRATE_VSS sg13_hv_nmos m=1 w=4.4u l=600.0n ng=1
MN0<59> pad gate iovss G1_EXPLICIT_SUBSTRATE_VSS sg13_hv_nmos m=1 w=4.4u l=600.0n ng=1
MN0<60> pad gate iovss G1_EXPLICIT_SUBSTRATE_VSS sg13_hv_nmos m=1 w=4.4u l=600.0n ng=1
MN0<61> pad gate iovss G1_EXPLICIT_SUBSTRATE_VSS sg13_hv_nmos m=1 w=4.4u l=600.0n ng=1
MN0<62> pad gate iovss G1_EXPLICIT_SUBSTRATE_VSS sg13_hv_nmos m=1 w=4.4u l=600.0n ng=1
MN0<63> pad gate iovss G1_EXPLICIT_SUBSTRATE_VSS sg13_hv_nmos m=1 w=4.4u l=600.0n ng=1
MN0<64> pad gate iovss G1_EXPLICIT_SUBSTRATE_VSS sg13_hv_nmos m=1 w=4.4u l=600.0n ng=1
MN0<65> pad gate iovss G1_EXPLICIT_SUBSTRATE_VSS sg13_hv_nmos m=1 w=4.4u l=600.0n ng=1
MN0<66> pad gate iovss G1_EXPLICIT_SUBSTRATE_VSS sg13_hv_nmos m=1 w=4.4u l=600.0n ng=1
MN0<67> pad gate iovss G1_EXPLICIT_SUBSTRATE_VSS sg13_hv_nmos m=1 w=4.4u l=600.0n ng=1
MN0<68> pad gate iovss G1_EXPLICIT_SUBSTRATE_VSS sg13_hv_nmos m=1 w=4.4u l=600.0n ng=1
MN0<69> pad gate iovss G1_EXPLICIT_SUBSTRATE_VSS sg13_hv_nmos m=1 w=4.4u l=600.0n ng=1
MN0<70> pad gate iovss G1_EXPLICIT_SUBSTRATE_VSS sg13_hv_nmos m=1 w=4.4u l=600.0n ng=1
MN0<71> pad gate iovss G1_EXPLICIT_SUBSTRATE_VSS sg13_hv_nmos m=1 w=4.4u l=600.0n ng=1
MN0<72> pad gate iovss G1_EXPLICIT_SUBSTRATE_VSS sg13_hv_nmos m=1 w=4.4u l=600.0n ng=1
MN0<73> pad gate iovss G1_EXPLICIT_SUBSTRATE_VSS sg13_hv_nmos m=1 w=4.4u l=600.0n ng=1
MN0<74> pad gate iovss G1_EXPLICIT_SUBSTRATE_VSS sg13_hv_nmos m=1 w=4.4u l=600.0n ng=1
MN0<75> pad gate iovss G1_EXPLICIT_SUBSTRATE_VSS sg13_hv_nmos m=1 w=4.4u l=600.0n ng=1
MN0<76> pad gate iovss G1_EXPLICIT_SUBSTRATE_VSS sg13_hv_nmos m=1 w=4.4u l=600.0n ng=1
MN0<77> pad gate iovss G1_EXPLICIT_SUBSTRATE_VSS sg13_hv_nmos m=1 w=4.4u l=600.0n ng=1
MN0<78> pad gate iovss G1_EXPLICIT_SUBSTRATE_VSS sg13_hv_nmos m=1 w=4.4u l=600.0n ng=1
MN0<79> pad gate iovss G1_EXPLICIT_SUBSTRATE_VSS sg13_hv_nmos m=1 w=4.4u l=600.0n ng=1
MN0<80> pad gate iovss G1_EXPLICIT_SUBSTRATE_VSS sg13_hv_nmos m=1 w=4.4u l=600.0n ng=1
MN0<81> pad gate iovss G1_EXPLICIT_SUBSTRATE_VSS sg13_hv_nmos m=1 w=4.4u l=600.0n ng=1
MN0<82> pad gate iovss G1_EXPLICIT_SUBSTRATE_VSS sg13_hv_nmos m=1 w=4.4u l=600.0n ng=1
MN0<83> pad gate iovss G1_EXPLICIT_SUBSTRATE_VSS sg13_hv_nmos m=1 w=4.4u l=600.0n ng=1
MN0<84> pad gate iovss G1_EXPLICIT_SUBSTRATE_VSS sg13_hv_nmos m=1 w=4.4u l=600.0n ng=1
MN0<85> pad gate iovss G1_EXPLICIT_SUBSTRATE_VSS sg13_hv_nmos m=1 w=4.4u l=600.0n ng=1
MN0<86> pad gate iovss G1_EXPLICIT_SUBSTRATE_VSS sg13_hv_nmos m=1 w=4.4u l=600.0n ng=1
MN0<87> pad gate iovss G1_EXPLICIT_SUBSTRATE_VSS sg13_hv_nmos m=1 w=4.4u l=600.0n ng=1
MN0<88> pad gate iovss G1_EXPLICIT_SUBSTRATE_VSS sg13_hv_nmos m=1 w=4.4u l=600.0n ng=1
MN0<89> pad gate iovss G1_EXPLICIT_SUBSTRATE_VSS sg13_hv_nmos m=1 w=4.4u l=600.0n ng=1
MN0<90> pad gate iovss G1_EXPLICIT_SUBSTRATE_VSS sg13_hv_nmos m=1 w=4.4u l=600.0n ng=1
MN0<91> pad gate iovss G1_EXPLICIT_SUBSTRATE_VSS sg13_hv_nmos m=1 w=4.4u l=600.0n ng=1
MN0<92> pad gate iovss G1_EXPLICIT_SUBSTRATE_VSS sg13_hv_nmos m=1 w=4.4u l=600.0n ng=1
MN0<93> pad gate iovss G1_EXPLICIT_SUBSTRATE_VSS sg13_hv_nmos m=1 w=4.4u l=600.0n ng=1
MN0<94> pad gate iovss G1_EXPLICIT_SUBSTRATE_VSS sg13_hv_nmos m=1 w=4.4u l=600.0n ng=1
MN0<95> pad gate iovss G1_EXPLICIT_SUBSTRATE_VSS sg13_hv_nmos m=1 w=4.4u l=600.0n ng=1
MN0<96> pad gate iovss G1_EXPLICIT_SUBSTRATE_VSS sg13_hv_nmos m=1 w=4.4u l=600.0n ng=1
MN0<97> pad gate iovss G1_EXPLICIT_SUBSTRATE_VSS sg13_hv_nmos m=1 w=4.4u l=600.0n ng=1
MN0<98> pad gate iovss G1_EXPLICIT_SUBSTRATE_VSS sg13_hv_nmos m=1 w=4.4u l=600.0n ng=1
MN0<99> pad gate iovss G1_EXPLICIT_SUBSTRATE_VSS sg13_hv_nmos m=1 w=4.4u l=600.0n ng=1
MN0<100> pad gate iovss G1_EXPLICIT_SUBSTRATE_VSS sg13_hv_nmos m=1 w=4.4u l=600.0n ng=1
MN0<101> pad gate iovss G1_EXPLICIT_SUBSTRATE_VSS sg13_hv_nmos m=1 w=4.4u l=600.0n ng=1
MN0<102> pad gate iovss G1_EXPLICIT_SUBSTRATE_VSS sg13_hv_nmos m=1 w=4.4u l=600.0n ng=1
MN0<103> pad gate iovss G1_EXPLICIT_SUBSTRATE_VSS sg13_hv_nmos m=1 w=4.4u l=600.0n ng=1
MN0<104> pad gate iovss G1_EXPLICIT_SUBSTRATE_VSS sg13_hv_nmos m=1 w=4.4u l=600.0n ng=1
MN0<105> pad gate iovss G1_EXPLICIT_SUBSTRATE_VSS sg13_hv_nmos m=1 w=4.4u l=600.0n ng=1
MN0<106> pad gate iovss G1_EXPLICIT_SUBSTRATE_VSS sg13_hv_nmos m=1 w=4.4u l=600.0n ng=1
MN0<107> pad gate iovss G1_EXPLICIT_SUBSTRATE_VSS sg13_hv_nmos m=1 w=4.4u l=600.0n ng=1
MN0<108> pad gate iovss G1_EXPLICIT_SUBSTRATE_VSS sg13_hv_nmos m=1 w=4.4u l=600.0n ng=1
MN0<109> pad gate iovss G1_EXPLICIT_SUBSTRATE_VSS sg13_hv_nmos m=1 w=4.4u l=600.0n ng=1
MN0<110> pad gate iovss G1_EXPLICIT_SUBSTRATE_VSS sg13_hv_nmos m=1 w=4.4u l=600.0n ng=1
MN0<111> pad gate iovss G1_EXPLICIT_SUBSTRATE_VSS sg13_hv_nmos m=1 w=4.4u l=600.0n ng=1
MN0<112> pad gate iovss G1_EXPLICIT_SUBSTRATE_VSS sg13_hv_nmos m=1 w=4.4u l=600.0n ng=1
MN0<113> pad gate iovss G1_EXPLICIT_SUBSTRATE_VSS sg13_hv_nmos m=1 w=4.4u l=600.0n ng=1
MN0<114> pad gate iovss G1_EXPLICIT_SUBSTRATE_VSS sg13_hv_nmos m=1 w=4.4u l=600.0n ng=1
MN0<115> pad gate iovss G1_EXPLICIT_SUBSTRATE_VSS sg13_hv_nmos m=1 w=4.4u l=600.0n ng=1
MN0<116> pad gate iovss G1_EXPLICIT_SUBSTRATE_VSS sg13_hv_nmos m=1 w=4.4u l=600.0n ng=1
MN0<117> pad gate iovss G1_EXPLICIT_SUBSTRATE_VSS sg13_hv_nmos m=1 w=4.4u l=600.0n ng=1
MN0<118> pad gate iovss G1_EXPLICIT_SUBSTRATE_VSS sg13_hv_nmos m=1 w=4.4u l=600.0n ng=1
MN0<119> pad gate iovss G1_EXPLICIT_SUBSTRATE_VSS sg13_hv_nmos m=1 w=4.4u l=600.0n ng=1
MN0<120> pad gate iovss G1_EXPLICIT_SUBSTRATE_VSS sg13_hv_nmos m=1 w=4.4u l=600.0n ng=1
MN0<121> pad gate iovss G1_EXPLICIT_SUBSTRATE_VSS sg13_hv_nmos m=1 w=4.4u l=600.0n ng=1
MN0<122> pad gate iovss G1_EXPLICIT_SUBSTRATE_VSS sg13_hv_nmos m=1 w=4.4u l=600.0n ng=1
MN0<123> pad gate iovss G1_EXPLICIT_SUBSTRATE_VSS sg13_hv_nmos m=1 w=4.4u l=600.0n ng=1
MN0<124> pad gate iovss G1_EXPLICIT_SUBSTRATE_VSS sg13_hv_nmos m=1 w=4.4u l=600.0n ng=1
MN0<125> pad gate iovss G1_EXPLICIT_SUBSTRATE_VSS sg13_hv_nmos m=1 w=4.4u l=600.0n ng=1
MN0<126> pad gate iovss G1_EXPLICIT_SUBSTRATE_VSS sg13_hv_nmos m=1 w=4.4u l=600.0n ng=1
MN0<127> pad gate iovss G1_EXPLICIT_SUBSTRATE_VSS sg13_hv_nmos m=1 w=4.4u l=600.0n ng=1
MN0<128> pad gate iovss G1_EXPLICIT_SUBSTRATE_VSS sg13_hv_nmos m=1 w=4.4u l=600.0n ng=1
MN0<129> pad gate iovss G1_EXPLICIT_SUBSTRATE_VSS sg13_hv_nmos m=1 w=4.4u l=600.0n ng=1
MN0<130> pad gate iovss G1_EXPLICIT_SUBSTRATE_VSS sg13_hv_nmos m=1 w=4.4u l=600.0n ng=1
MN0<131> pad gate iovss G1_EXPLICIT_SUBSTRATE_VSS sg13_hv_nmos m=1 w=4.4u l=600.0n ng=1
MN0<132> pad gate iovss G1_EXPLICIT_SUBSTRATE_VSS sg13_hv_nmos m=1 w=4.4u l=600.0n ng=1
MN0<133> pad gate iovss G1_EXPLICIT_SUBSTRATE_VSS sg13_hv_nmos m=1 w=4.4u l=600.0n ng=1
MN0<134> pad gate iovss G1_EXPLICIT_SUBSTRATE_VSS sg13_hv_nmos m=1 w=4.4u l=600.0n ng=1
MN0<135> pad gate iovss G1_EXPLICIT_SUBSTRATE_VSS sg13_hv_nmos m=1 w=4.4u l=600.0n ng=1
MN0<136> pad gate iovss G1_EXPLICIT_SUBSTRATE_VSS sg13_hv_nmos m=1 w=4.4u l=600.0n ng=1
MN0<137> pad gate iovss G1_EXPLICIT_SUBSTRATE_VSS sg13_hv_nmos m=1 w=4.4u l=600.0n ng=1
MN0<138> pad gate iovss G1_EXPLICIT_SUBSTRATE_VSS sg13_hv_nmos m=1 w=4.4u l=600.0n ng=1
MN0<139> pad gate iovss G1_EXPLICIT_SUBSTRATE_VSS sg13_hv_nmos m=1 w=4.4u l=600.0n ng=1
MN0<140> pad gate iovss G1_EXPLICIT_SUBSTRATE_VSS sg13_hv_nmos m=1 w=4.4u l=600.0n ng=1
MN0<141> pad gate iovss G1_EXPLICIT_SUBSTRATE_VSS sg13_hv_nmos m=1 w=4.4u l=600.0n ng=1
MN0<142> pad gate iovss G1_EXPLICIT_SUBSTRATE_VSS sg13_hv_nmos m=1 w=4.4u l=600.0n ng=1
MN0<143> pad gate iovss G1_EXPLICIT_SUBSTRATE_VSS sg13_hv_nmos m=1 w=4.4u l=600.0n ng=1
MN0<144> pad gate iovss G1_EXPLICIT_SUBSTRATE_VSS sg13_hv_nmos m=1 w=4.4u l=600.0n ng=1
MN0<145> pad gate iovss G1_EXPLICIT_SUBSTRATE_VSS sg13_hv_nmos m=1 w=4.4u l=600.0n ng=1
MN0<146> pad gate iovss G1_EXPLICIT_SUBSTRATE_VSS sg13_hv_nmos m=1 w=4.4u l=600.0n ng=1
MN0<147> pad gate iovss G1_EXPLICIT_SUBSTRATE_VSS sg13_hv_nmos m=1 w=4.4u l=600.0n ng=1
MN0<148> pad gate iovss G1_EXPLICIT_SUBSTRATE_VSS sg13_hv_nmos m=1 w=4.4u l=600.0n ng=1
MN0<149> pad gate iovss G1_EXPLICIT_SUBSTRATE_VSS sg13_hv_nmos m=1 w=4.4u l=600.0n ng=1
MN0<150> pad gate iovss G1_EXPLICIT_SUBSTRATE_VSS sg13_hv_nmos m=1 w=4.4u l=600.0n ng=1
MN0<151> pad gate iovss G1_EXPLICIT_SUBSTRATE_VSS sg13_hv_nmos m=1 w=4.4u l=600.0n ng=1
MN0<152> pad gate iovss G1_EXPLICIT_SUBSTRATE_VSS sg13_hv_nmos m=1 w=4.4u l=600.0n ng=1
MN0<153> pad gate iovss G1_EXPLICIT_SUBSTRATE_VSS sg13_hv_nmos m=1 w=4.4u l=600.0n ng=1
MN0<154> pad gate iovss G1_EXPLICIT_SUBSTRATE_VSS sg13_hv_nmos m=1 w=4.4u l=600.0n ng=1
MN0<155> pad gate iovss G1_EXPLICIT_SUBSTRATE_VSS sg13_hv_nmos m=1 w=4.4u l=600.0n ng=1
MN0<156> pad gate iovss G1_EXPLICIT_SUBSTRATE_VSS sg13_hv_nmos m=1 w=4.4u l=600.0n ng=1
MN0<157> pad gate iovss G1_EXPLICIT_SUBSTRATE_VSS sg13_hv_nmos m=1 w=4.4u l=600.0n ng=1
MN0<158> pad gate iovss G1_EXPLICIT_SUBSTRATE_VSS sg13_hv_nmos m=1 w=4.4u l=600.0n ng=1
MN0<159> pad gate iovss G1_EXPLICIT_SUBSTRATE_VSS sg13_hv_nmos m=1 w=4.4u l=600.0n ng=1
MN0<160> pad gate iovss G1_EXPLICIT_SUBSTRATE_VSS sg13_hv_nmos m=1 w=4.4u l=600.0n ng=1
MN0<161> pad gate iovss G1_EXPLICIT_SUBSTRATE_VSS sg13_hv_nmos m=1 w=4.4u l=600.0n ng=1
MN0<162> pad gate iovss G1_EXPLICIT_SUBSTRATE_VSS sg13_hv_nmos m=1 w=4.4u l=600.0n ng=1
MN0<163> pad gate iovss G1_EXPLICIT_SUBSTRATE_VSS sg13_hv_nmos m=1 w=4.4u l=600.0n ng=1
MN0<164> pad gate iovss G1_EXPLICIT_SUBSTRATE_VSS sg13_hv_nmos m=1 w=4.4u l=600.0n ng=1
MN0<165> pad gate iovss G1_EXPLICIT_SUBSTRATE_VSS sg13_hv_nmos m=1 w=4.4u l=600.0n ng=1
MN0<166> pad gate iovss G1_EXPLICIT_SUBSTRATE_VSS sg13_hv_nmos m=1 w=4.4u l=600.0n ng=1
MN0<167> pad gate iovss G1_EXPLICIT_SUBSTRATE_VSS sg13_hv_nmos m=1 w=4.4u l=600.0n ng=1
MN0<168> pad gate iovss G1_EXPLICIT_SUBSTRATE_VSS sg13_hv_nmos m=1 w=4.4u l=600.0n ng=1
MN0<169> pad gate iovss G1_EXPLICIT_SUBSTRATE_VSS sg13_hv_nmos m=1 w=4.4u l=600.0n ng=1
MN0<170> pad gate iovss G1_EXPLICIT_SUBSTRATE_VSS sg13_hv_nmos m=1 w=4.4u l=600.0n ng=1
MN0<171> pad gate iovss G1_EXPLICIT_SUBSTRATE_VSS sg13_hv_nmos m=1 w=4.4u l=600.0n ng=1
MN0<172> pad gate iovss G1_EXPLICIT_SUBSTRATE_VSS sg13_hv_nmos m=1 w=4.4u l=600.0n ng=1
R_G1_TAP_SYNTAX_XR0 iovss G1_EXPLICIT_SUBSTRATE_VSS ptap1 A=65.6472p P=386.16u
DD0 G1_EXPLICIT_SUBSTRATE_VSS gate dantenna m=1 w=480n l=480n a=230.4f p=1.92u
.ENDS
.SUBCKT G1_VSS_DERIVATIVE__sg13g2_Clamp_N8N8D gate iovss pad G1_EXPLICIT_SUBSTRATE_VSS
*.PININFO gate:I iovss:B pad:B
R_G1_TAP_SYNTAX_XR0 iovss G1_EXPLICIT_SUBSTRATE_VSS ptap1 A=55.7736p P=328.08u
MN0 pad gate iovss G1_EXPLICIT_SUBSTRATE_VSS sg13_hv_nmos m=1 w=35.2u l=600.0n ng=8
DD0 G1_EXPLICIT_SUBSTRATE_VSS gate dantenna m=1 w=780.00n l=780.00n a=608.400f p=3.12u
.ENDS
.SUBCKT G1_VSS_DERIVATIVE__sg13g2_Clamp_P15N15D gate iovdd iovss pad G1_EXPLICIT_SUBSTRATE_VSS
*.PININFO gate:I iovdd:B iovss:B pad:B
DD0 gate iovdd dpantenna m=1 w=780.00n l=780.00n a=608.400f p=3.12u
R_G1_TAP_SYNTAX_XR0 iovss G1_EXPLICIT_SUBSTRATE_VSS ptap1 A=67.0344p P=394.32u
MP1 pad gate iovdd iovdd sg13_hv_pmos m=1 w=99.9u l=600.0n ng=15
MP0 pad gate iovdd iovdd sg13_hv_pmos m=1 w=99.9u l=600.0n ng=15
.ENDS
.SUBCKT G1_VSS_DERIVATIVE__sg13g2_Clamp_P20N0D iovdd iovss pad G1_EXPLICIT_SUBSTRATE_VSS
*.PININFO iovdd:B iovss:B pad:B
MP1 pad net2 iovdd iovdd sg13_hv_pmos m=1 w=133.2u l=600.0n ng=20
MP0 pad net2 iovdd iovdd sg13_hv_pmos m=1 w=133.2u l=600.0n ng=20
RR0 net2 iovdd 6.768K $SUB=iovdd $[rppd] l=12.9u w=500n b=0 m=1
R_G1_TAP_SYNTAX_XR1 iovss G1_EXPLICIT_SUBSTRATE_VSS ptap1 A=67.0344p P=394.32u
.ENDS
.SUBCKT G1_VSS_DERIVATIVE__sg13g2_Clamp_P2N2D gate iovdd iovss pad G1_EXPLICIT_SUBSTRATE_VSS
*.PININFO gate:I iovdd:B iovss:B pad:B
DD0 gate iovdd dpantenna m=1 w=480n l=480n a=230.4f p=1.92u
MP1 pad gate iovdd iovdd sg13_hv_pmos m=1 w=13.32u l=600.0n ng=2
MP0 pad gate iovdd iovdd sg13_hv_pmos m=1 w=13.32u l=600.0n ng=2
R_G1_TAP_SYNTAX_XR0 iovss G1_EXPLICIT_SUBSTRATE_VSS ptap1 A=67.0344p P=394.32u
.ENDS
.SUBCKT G1_VSS_DERIVATIVE__sg13g2_Clamp_P8N8D gate iovdd iovss pad G1_EXPLICIT_SUBSTRATE_VSS
*.PININFO gate:I iovdd:B iovss:B pad:B
R_G1_TAP_SYNTAX_XR0 iovss G1_EXPLICIT_SUBSTRATE_VSS ptap1 A=67.0344p P=394.32u
MP2 pad gate iovdd iovdd sg13_hv_pmos m=1 w=53.28u l=600.0n ng=8
MP0 pad gate iovdd iovdd sg13_hv_pmos m=1 w=53.28u l=600.0n ng=8
DD0 gate iovdd dpantenna m=1 w=480n l=480n a=230.4f p=1.92u
.ENDS
.SUBCKT G1_VSS_DERIVATIVE__sg13g2_Corner vdd vss iovdd iovss G1_EXPLICIT_SUBSTRATE_VSS
*.PININFO iovdd:B iovss:B vdd:B vss:B
R_G1_TAP_SYNTAX_XR1 vss G1_EXPLICIT_SUBSTRATE_VSS ptap1 A=13.1934p P=84.704u
R_G1_TAP_SYNTAX_XR0 iovss G1_EXPLICIT_SUBSTRATE_VSS ptap1 A=10168.74p P=982.422u
.ENDS
.SUBCKT G1_VSS_DERIVATIVE__sg13g2_DCNDiode anode cathode guard G1_EXPLICIT_SUBSTRATE_VSS
*.PININFO anode:B cathode:B guard:B
DD1 G1_EXPLICIT_SUBSTRATE_VSS cathode dantenna m=1 w=1.26u l=27.78u a=35.003p p=58.08u
DD0 G1_EXPLICIT_SUBSTRATE_VSS cathode dantenna m=1 w=1.26u l=27.78u a=35.003p p=58.08u
R_G1_TAP_SYNTAX_XR0 anode G1_EXPLICIT_SUBSTRATE_VSS ptap1 A=141.2964p P=221.76u
.ENDS
.SUBCKT G1_VSS_DERIVATIVE__sg13g2_DCPDiode anode cathode guard G1_EXPLICIT_SUBSTRATE_VSS
*.PININFO anode:B cathode:B guard:B
DD1 anode cathode dpantenna m=1 w=1.26u l=27.78u a=35.003p p=58.08u
DD0 anode cathode dpantenna m=1 w=1.26u l=27.78u a=35.003p p=58.08u
R_G1_TAP_SYNTAX_XR0 guard G1_EXPLICIT_SUBSTRATE_VSS ptap1 A=33.5104p P=197.12u
.ENDS
.SUBCKT G1_VSS_DERIVATIVE__sg13g2_Filler2000 vdd vss iovdd iovss G1_EXPLICIT_SUBSTRATE_VSS
*.PININFO iovdd:B iovss:B vdd:B vss:B
R_G1_TAP_SYNTAX_XR1 vss G1_EXPLICIT_SUBSTRATE_VSS ptap1 A=2.85p P=19.6u
R_G1_TAP_SYNTAX_XR0 iovss G1_EXPLICIT_SUBSTRATE_VSS ptap1 A=695.115p P=203.34u
.ENDS
.SUBCKT G1_VSS_DERIVATIVE__sg13g2_Filler400 vdd vss iovdd iovss G1_EXPLICIT_SUBSTRATE_VSS
*.PININFO iovdd:B iovss:B vdd:B vss:B
R_G1_TAP_SYNTAX_XR1 vss G1_EXPLICIT_SUBSTRATE_VSS ptap1 A=0.672p P=5.08u
R_G1_TAP_SYNTAX_XR0 iovss G1_EXPLICIT_SUBSTRATE_VSS ptap1 A=114.1452p P=155.7u
.ENDS
.SUBCKT G1_VSS_DERIVATIVE__sg13g2_Filler4000 vdd vss iovdd iovss G1_EXPLICIT_SUBSTRATE_VSS
*.PININFO iovdd:B iovss:B vdd:B vss:B
R_G1_TAP_SYNTAX_XR1 vss G1_EXPLICIT_SUBSTRATE_VSS ptap1 A=5.85p P=39.6u
R_G1_TAP_SYNTAX_XR0 iovss G1_EXPLICIT_SUBSTRATE_VSS ptap1 A=1426.815p P=263.34u
.ENDS
.SUBCKT G1_VSS_DERIVATIVE__sg13g2_GateLevelUpInv ngate pgate iovdd core vdd vss G1_EXPLICIT_SUBSTRATE_VSS
*.PININFO core:I ngate:O pgate:O iovdd:B vdd:B vss:B
XI1 pgate core iovdd vdd vss G1_EXPLICIT_SUBSTRATE_VSS / G1_VSS_DERIVATIVE__sg13g2_LevelUpInv
XI0 ngate core iovdd vdd vss G1_EXPLICIT_SUBSTRATE_VSS / G1_VSS_DERIVATIVE__sg13g2_LevelUpInv
.ENDS
.SUBCKT G1_VSS_DERIVATIVE__sg13g2_IOPadAnalog pad padres vdd vss iovdd iovss G1_EXPLICIT_SUBSTRATE_VSS
*.PININFO iovdd:B iovss:B pad:B padres:B vdd:B vss:B
XI0 iovdd iovss pad G1_EXPLICIT_SUBSTRATE_VSS / G1_VSS_DERIVATIVE__sg13g2_Clamp_P20N0D
XI5 iovss pad iovdd G1_EXPLICIT_SUBSTRATE_VSS / G1_VSS_DERIVATIVE__sg13g2_DCNDiode
XI2 pad iovdd iovss G1_EXPLICIT_SUBSTRATE_VSS / G1_VSS_DERIVATIVE__sg13g2_DCPDiode
XI3 padres iovss pad iovdd G1_EXPLICIT_SUBSTRATE_VSS / G1_VSS_DERIVATIVE__sg13g2_SecondaryProtection
XI4 iovss pad G1_EXPLICIT_SUBSTRATE_VSS / G1_VSS_DERIVATIVE__sg13g2_Clamp_N20N0D
R_G1_TAP_SYNTAX_XR0 vss G1_EXPLICIT_SUBSTRATE_VSS ptap1 A=23.85p P=159.6u
R_G1_TAP_SYNTAX_XR1 iovss G1_EXPLICIT_SUBSTRATE_VSS ptap1 A=4273.4p P=593.62u
.ENDS
.SUBCKT G1_VSS_DERIVATIVE__sg13g2_IOPadIn pad p2c vdd vss iovdd iovss G1_EXPLICIT_SUBSTRATE_VSS
*.PININFO pad:I p2c:O iovdd:B iovss:B vdd:B vss:B
XI0 p2c pad iovdd iovss vdd vss G1_EXPLICIT_SUBSTRATE_VSS / G1_VSS_DERIVATIVE__sg13g2_LevelDown
XI2 iovss pad iovdd G1_EXPLICIT_SUBSTRATE_VSS / G1_VSS_DERIVATIVE__sg13g2_DCNDiode
XI1 pad iovdd iovss G1_EXPLICIT_SUBSTRATE_VSS / G1_VSS_DERIVATIVE__sg13g2_DCPDiode
R_G1_TAP_SYNTAX_XR0 vss G1_EXPLICIT_SUBSTRATE_VSS ptap1 A=21.981p P=147.74u
R_G1_TAP_SYNTAX_XR1 iovss G1_EXPLICIT_SUBSTRATE_VSS ptap1 A=5379.0466p P=677.04u
.ENDS
.SUBCKT G1_VSS_DERIVATIVE__sg13g2_IOPadIOVdd vdd vss iovdd iovss G1_EXPLICIT_SUBSTRATE_VSS
*.PININFO iovdd:B iovss:B vdd:B vss:B
XI1 net4 iovss iovdd G1_EXPLICIT_SUBSTRATE_VSS / G1_VSS_DERIVATIVE__sg13g2_Clamp_N43N43D4R
XI3 iovdd net1 G1_EXPLICIT_SUBSTRATE_VSS / G1_VSS_DERIVATIVE__sg13g2_RCClampResistor
XI2 net4 net1 iovss iovdd G1_EXPLICIT_SUBSTRATE_VSS / G1_VSS_DERIVATIVE__sg13g2_RCClampInverter
R_G1_TAP_SYNTAX_XR0 vss G1_EXPLICIT_SUBSTRATE_VSS ptap1 A=24p P=160.6u
R_G1_TAP_SYNTAX_XR1 iovss G1_EXPLICIT_SUBSTRATE_VSS ptap1 A=1997.9154p P=411.58u
.ENDS
.SUBCKT G1_VSS_DERIVATIVE__sg13g2_IOPadIOVss vdd vss iovdd iovss G1_EXPLICIT_SUBSTRATE_VSS
*.PININFO iovdd:B iovss:B vdd:B vss:B
XI3 iovss iovss iovdd G1_EXPLICIT_SUBSTRATE_VSS / G1_VSS_DERIVATIVE__sg13g2_DCNDiode
XI2 iovss iovdd iovss G1_EXPLICIT_SUBSTRATE_VSS / G1_VSS_DERIVATIVE__sg13g2_DCPDiode
R_G1_TAP_SYNTAX_XR1 vss G1_EXPLICIT_SUBSTRATE_VSS ptap1 A=24p P=160.6u
R_G1_TAP_SYNTAX_XR0 iovss G1_EXPLICIT_SUBSTRATE_VSS ptap1 A=5379.0466p P=677.04u
.ENDS
.SUBCKT G1_VSS_DERIVATIVE__sg13g2_IOPadOut16mA pad c2p vdd vss iovdd iovss G1_EXPLICIT_SUBSTRATE_VSS
*.PININFO c2p:I pad:O iovdd:B iovss:B vdd:B vss:B
XI2 net2 net1 iovdd c2p vdd vss G1_EXPLICIT_SUBSTRATE_VSS / G1_VSS_DERIVATIVE__sg13g2_GateLevelUpInv
XI0 net1 iovdd iovss pad G1_EXPLICIT_SUBSTRATE_VSS / G1_VSS_DERIVATIVE__sg13g2_Clamp_P8N8D
XI4 iovss pad iovdd G1_EXPLICIT_SUBSTRATE_VSS / G1_VSS_DERIVATIVE__sg13g2_DCNDiode
XI3 net2 iovss pad G1_EXPLICIT_SUBSTRATE_VSS / G1_VSS_DERIVATIVE__sg13g2_Clamp_N8N8D
XI1 pad iovdd iovss G1_EXPLICIT_SUBSTRATE_VSS / G1_VSS_DERIVATIVE__sg13g2_DCPDiode
R_G1_TAP_SYNTAX_XR0 vss G1_EXPLICIT_SUBSTRATE_VSS ptap1 A=24p P=160.6u
R_G1_TAP_SYNTAX_XR1 iovss G1_EXPLICIT_SUBSTRATE_VSS ptap1 A=4313.4p P=594.62u
.ENDS
.SUBCKT G1_VSS_DERIVATIVE__sg13g2_IOPadOut30mA pad c2p vdd vss iovdd iovss G1_EXPLICIT_SUBSTRATE_VSS
*.PININFO c2p:I pad:O iovdd:B iovss:B vdd:B vss:B
XI2 net2 net1 iovdd c2p vdd vss G1_EXPLICIT_SUBSTRATE_VSS / G1_VSS_DERIVATIVE__sg13g2_GateLevelUpInv
XI1 net1 iovdd iovss pad G1_EXPLICIT_SUBSTRATE_VSS / G1_VSS_DERIVATIVE__sg13g2_Clamp_P15N15D
XI3 net2 iovss pad G1_EXPLICIT_SUBSTRATE_VSS / G1_VSS_DERIVATIVE__sg13g2_Clamp_N15N15D
XI4 iovss pad iovdd G1_EXPLICIT_SUBSTRATE_VSS / G1_VSS_DERIVATIVE__sg13g2_DCNDiode
XI0 pad iovdd iovss G1_EXPLICIT_SUBSTRATE_VSS / G1_VSS_DERIVATIVE__sg13g2_DCPDiode
R_G1_TAP_SYNTAX_XR0 vss G1_EXPLICIT_SUBSTRATE_VSS ptap1 A=24p P=160.6u
R_G1_TAP_SYNTAX_XR1 iovss G1_EXPLICIT_SUBSTRATE_VSS ptap1 A=4319.178p P=671.66u
.ENDS
.SUBCKT G1_VSS_DERIVATIVE__sg13g2_IOPadOut4mA pad c2p vdd vss iovdd iovss G1_EXPLICIT_SUBSTRATE_VSS
*.PININFO c2p:I pad:O iovdd:B iovss:B vdd:B vss:B
XI2 net2 net1 iovdd c2p vdd vss G1_EXPLICIT_SUBSTRATE_VSS / G1_VSS_DERIVATIVE__sg13g2_GateLevelUpInv
XI0 net1 iovdd iovss pad G1_EXPLICIT_SUBSTRATE_VSS / G1_VSS_DERIVATIVE__sg13g2_Clamp_P2N2D
XI3 net2 iovss pad G1_EXPLICIT_SUBSTRATE_VSS / G1_VSS_DERIVATIVE__sg13g2_Clamp_N2N2D
XI4 iovss pad iovdd G1_EXPLICIT_SUBSTRATE_VSS / G1_VSS_DERIVATIVE__sg13g2_DCNDiode
XI1 pad iovdd iovss G1_EXPLICIT_SUBSTRATE_VSS / G1_VSS_DERIVATIVE__sg13g2_DCPDiode
R_G1_TAP_SYNTAX_XR1 iovss G1_EXPLICIT_SUBSTRATE_VSS ptap1 A=4319.178p P=671.66u
R_G1_TAP_SYNTAX_XR0 vss G1_EXPLICIT_SUBSTRATE_VSS ptap1 A=24p P=160.6u
.ENDS
.SUBCKT G1_VSS_DERIVATIVE__sg13g2_IOPadVdd vdd vss iovdd iovss G1_EXPLICIT_SUBSTRATE_VSS
*.PININFO iovdd:B iovss:B vdd:B vss:B
XI1 net3 iovss vdd G1_EXPLICIT_SUBSTRATE_VSS / G1_VSS_DERIVATIVE__sg13g2_Clamp_N43N43D4R
XI4 vdd net1 G1_EXPLICIT_SUBSTRATE_VSS / G1_VSS_DERIVATIVE__sg13g2_RCClampResistor
R_G1_TAP_SYNTAX_XR1 iovss G1_EXPLICIT_SUBSTRATE_VSS ptap1 A=1997.6623p P=411.58u
R_G1_TAP_SYNTAX_XR0 vss G1_EXPLICIT_SUBSTRATE_VSS ptap1 A=24p P=160.6u
XI3 net3 net1 iovss vdd G1_EXPLICIT_SUBSTRATE_VSS / G1_VSS_DERIVATIVE__sg13g2_RCClampInverter
.ENDS
.SUBCKT G1_VSS_DERIVATIVE__sg13g2_IOPadVss vdd vss iovdd iovss G1_EXPLICIT_SUBSTRATE_VSS
*.PININFO iovdd:B iovss:B vdd:B vss:B
XI1 iovss vss iovdd G1_EXPLICIT_SUBSTRATE_VSS / G1_VSS_DERIVATIVE__sg13g2_DCNDiode
XI2 vss iovdd iovss G1_EXPLICIT_SUBSTRATE_VSS / G1_VSS_DERIVATIVE__sg13g2_DCPDiode
R_G1_TAP_SYNTAX_XR1 iovss G1_EXPLICIT_SUBSTRATE_VSS ptap1 A=5379.0466p P=677.04u
R_G1_TAP_SYNTAX_XR0 vss G1_EXPLICIT_SUBSTRATE_VSS ptap1 A=24p P=160.6u
.ENDS
.SUBCKT G1_VSS_DERIVATIVE__sg13g2_LevelDown core pad iovdd iovss vdd vss G1_EXPLICIT_SUBSTRATE_VSS
*.PININFO pad:I core:O iovdd:B iovss:B vdd:B vss:B
MP2 net4 net7 iovdd iovdd sg13_hv_pmos m=1 w=4.6u l=450.00n ng=2
MP3 net7 net1 iovdd iovdd sg13_hv_pmos m=1 w=4.6u l=450.00n ng=2
MN3 net4 net7 iovss G1_EXPLICIT_SUBSTRATE_VSS sg13_hv_nmos m=1 w=1.3u l=450.00n ng=1
MN4 net7 net1 iovss G1_EXPLICIT_SUBSTRATE_VSS sg13_hv_nmos m=1 w=1.3u l=450.00n ng=1
MN2 net2 net4 vss G1_EXPLICIT_SUBSTRATE_VSS sg13_hv_nmos m=1 w=2.65u l=450.00n ng=1
MN0 vdd net7 net2 G1_EXPLICIT_SUBSTRATE_VSS sg13_hv_nmos m=1 w=2.65u l=450.00n ng=1
MN1 core net2 vss G1_EXPLICIT_SUBSTRATE_VSS sg13_lv_nmos m=1 w=2.75u l=130.00n ng=1
MP1 core net2 vdd vdd sg13_lv_pmos m=1 w=4.75u l=130.00n ng=1
R_G1_TAP_SYNTAX_XR1 iovss G1_EXPLICIT_SUBSTRATE_VSS ptap1 A=0.804p P=5.96u
R_G1_TAP_SYNTAX_XR0 vss G1_EXPLICIT_SUBSTRATE_VSS ptap1 A=2.019p P=14.06u
XI0 net1 iovss pad iovdd G1_EXPLICIT_SUBSTRATE_VSS / G1_VSS_DERIVATIVE__sg13g2_SecondaryProtection
.ENDS
.SUBCKT G1_VSS_DERIVATIVE__sg13g2_LevelUpInv o i iovdd vdd vss G1_EXPLICIT_SUBSTRATE_VSS
*.PININFO i:I o:O iovdd:B vdd:B vss:B
MN1 net2 i vss G1_EXPLICIT_SUBSTRATE_VSS sg13_lv_nmos m=1 w=2.75u l=130.00n ng=1
MP3 net2 i vdd vdd sg13_lv_pmos m=1 w=4.75u l=130.00n ng=1
MN0 o net4 vss G1_EXPLICIT_SUBSTRATE_VSS sg13_hv_nmos m=1 w=1.9u l=450.00n ng=1
MN3 net4 net2 vss G1_EXPLICIT_SUBSTRATE_VSS sg13_hv_nmos m=1 w=1.9u l=450.00n ng=1
MN2 net3 i vss G1_EXPLICIT_SUBSTRATE_VSS sg13_hv_nmos m=1 w=1.9u l=450.00n ng=1
MP0 o net4 iovdd iovdd sg13_hv_pmos m=1 w=3.9u l=450.00n ng=1
MP1 net3 net4 iovdd iovdd sg13_hv_pmos m=1 w=300.0n l=450.00n ng=1
MP2 net4 net3 iovdd iovdd sg13_hv_pmos m=1 w=300.0n l=450.00n ng=1
R_G1_TAP_SYNTAX_XR0 vss G1_EXPLICIT_SUBSTRATE_VSS ptap1 A=1.053p P=7.62u
.ENDS
.SUBCKT G1_VSS_DERIVATIVE__sg13g2_RCClampInverter out in iovss supply G1_EXPLICIT_SUBSTRATE_VSS
*.PININFO in:I out:O iovss:B supply:B
MN1 iovss in iovss G1_EXPLICIT_SUBSTRATE_VSS sg13_hv_nmos m=1 w=63.000u l=9.5u ng=7
MN3 out in iovss G1_EXPLICIT_SUBSTRATE_VSS sg13_hv_nmos m=1 w=54.000u l=500.0n ng=6
MN0 iovss in iovss G1_EXPLICIT_SUBSTRATE_VSS sg13_hv_nmos m=1 w=63.000u l=9.5u ng=7
MN2 out in iovss G1_EXPLICIT_SUBSTRATE_VSS sg13_hv_nmos m=1 w=54.000u l=500.0n ng=6
R_G1_TAP_SYNTAX_XR0 iovss G1_EXPLICIT_SUBSTRATE_VSS ptap1 A=69.122p P=406.6u
MP0 out in supply supply sg13_hv_pmos m=1 w=350.000u l=500.0n ng=50
.ENDS
.SUBCKT G1_VSS_DERIVATIVE__sg13g2_RCClampResistor pin1 pin2 G1_EXPLICIT_SUBSTRATE_VSS
*.PININFO pin1:B pin2:B
RR15 net15 net16 5.239K $SUB=G1_EXPLICIT_SUBSTRATE_VSS $[rppd] l=20u w=1u b=0 m=1
RR20 net20 net21 5.239K $SUB=G1_EXPLICIT_SUBSTRATE_VSS $[rppd] l=20u w=1u b=0 m=1
RR23 net23 net24 5.239K $SUB=G1_EXPLICIT_SUBSTRATE_VSS $[rppd] l=20u w=1u b=0 m=1
RR17 net17 net18 5.239K $SUB=G1_EXPLICIT_SUBSTRATE_VSS $[rppd] l=20u w=1u b=0 m=1
RR16 net16 net17 5.239K $SUB=G1_EXPLICIT_SUBSTRATE_VSS $[rppd] l=20u w=1u b=0 m=1
RR25 net25 pin2 5.239K $SUB=G1_EXPLICIT_SUBSTRATE_VSS $[rppd] l=20u w=1u b=0 m=1
RR22 net22 net23 5.239K $SUB=G1_EXPLICIT_SUBSTRATE_VSS $[rppd] l=20u w=1u b=0 m=1
RR19 net19 net20 5.239K $SUB=G1_EXPLICIT_SUBSTRATE_VSS $[rppd] l=20u w=1u b=0 m=1
RR24 net24 net25 5.239K $SUB=G1_EXPLICIT_SUBSTRATE_VSS $[rppd] l=20u w=1u b=0 m=1
RR21 net21 net22 5.239K $SUB=G1_EXPLICIT_SUBSTRATE_VSS $[rppd] l=20u w=1u b=0 m=1
RR18 net18 net19 5.239K $SUB=G1_EXPLICIT_SUBSTRATE_VSS $[rppd] l=20u w=1u b=0 m=1
RR5 net5 net6 5.239K $SUB=G1_EXPLICIT_SUBSTRATE_VSS $[rppd] l=20u w=1u b=0 m=1
RR8 net8 net9 5.239K $SUB=G1_EXPLICIT_SUBSTRATE_VSS $[rppd] l=20u w=1u b=0 m=1
RR11 net11 net12 5.239K $SUB=G1_EXPLICIT_SUBSTRATE_VSS $[rppd] l=20u w=1u b=0 m=1
RR14 net14 net15 5.239K $SUB=G1_EXPLICIT_SUBSTRATE_VSS $[rppd] l=20u w=1u b=0 m=1
RR2 net2 net3 5.239K $SUB=G1_EXPLICIT_SUBSTRATE_VSS $[rppd] l=20u w=1u b=0 m=1
RR1 net1 net2 5.239K $SUB=G1_EXPLICIT_SUBSTRATE_VSS $[rppd] l=20u w=1u b=0 m=1
RR13 net13 net14 5.239K $SUB=G1_EXPLICIT_SUBSTRATE_VSS $[rppd] l=20u w=1u b=0 m=1
RR10 net10 net11 5.239K $SUB=G1_EXPLICIT_SUBSTRATE_VSS $[rppd] l=20u w=1u b=0 m=1
RR7 net7 net8 5.239K $SUB=G1_EXPLICIT_SUBSTRATE_VSS $[rppd] l=20u w=1u b=0 m=1
RR4 net4 net5 5.239K $SUB=G1_EXPLICIT_SUBSTRATE_VSS $[rppd] l=20u w=1u b=0 m=1
RR12 net12 net13 5.239K $SUB=G1_EXPLICIT_SUBSTRATE_VSS $[rppd] l=20u w=1u b=0 m=1
RR9 net9 net10 5.239K $SUB=G1_EXPLICIT_SUBSTRATE_VSS $[rppd] l=20u w=1u b=0 m=1
RR6 net6 net7 5.239K $SUB=G1_EXPLICIT_SUBSTRATE_VSS $[rppd] l=20u w=1u b=0 m=1
RR3 net3 net4 5.239K $SUB=G1_EXPLICIT_SUBSTRATE_VSS $[rppd] l=20u w=1u b=0 m=1
RR0 pin1 net1 5.239K $SUB=G1_EXPLICIT_SUBSTRATE_VSS $[rppd] l=20u w=1u b=0 m=1
.ENDS
.SUBCKT G1_VSS_DERIVATIVE__sg13g2_SecondaryProtection core minus pad plus G1_EXPLICIT_SUBSTRATE_VSS
*.PININFO core:B minus:B pad:B plus:B
RR0 pad core 586.899 $SUB=G1_EXPLICIT_SUBSTRATE_VSS $[rppd] m=1 l=2u w=1u b=0 m=1
DD1 G1_EXPLICIT_SUBSTRATE_VSS core dantenna m=1 w=640n l=3.1u a=1.984p p=7.48u
R_G1_TAP_SYNTAX_XR1 minus G1_EXPLICIT_SUBSTRATE_VSS ptap1 A=9.0304p P=53.12u
DD0 core plus dpantenna m=1 w=640n l=4.98u a=3.187p p=11.24u
.ENDS
