* Extracted by KLayout with SG13G2 LVS runset on : 21/10/2026 02:31

* cell r1_padring
* pin $1.c2p
* pin $10.padres
* pin $11.padres
* pin $110239.padres
* pin $12.p2c
* pin $13.p2c
* pin $14.p2c
* pin $143822.c2p
* pin $2.c2p
* pin $3.c2p
* pin $4.padres
* pin $462636.p2c
* pin $5.padres
* pin $6.padres
* pin $7.padres
* pin $70812.c2p
* pin $8.padres
* pin $9.padres
* pin COS_N
* pin COS_P
* pin CS_N
* pin EN_STO_IN
* pin FAULT_N
* pin GATE_A
* pin GATE_B
* pin GATE_C
* pin IOVDD
* pin IOVSS
* pin ISA_N
* pin ISA_P
* pin ISB_N
* pin ISB_P
* pin MA_SCLK
* pin SDI
* pin SIN_N
* pin SIN_P
* pin SLO_SDO
* pin VDD
* pin VDDA
* pin VSS
.SUBCKT r1_padring \$1.c2p \$10.padres \$11.padres \$110239.padres \$12.p2c
+ \$13.p2c \$14.p2c \$143822.c2p \$2.c2p \$3.c2p \$4.padres \$462636.p2c
+ \$5.padres \$6.padres \$7.padres \$70812.c2p \$8.padres \$9.padres COS_N
+ COS_P CS_N EN_STO_IN FAULT_N GATE_A GATE_B GATE_C IOVDD IOVSS ISA_N ISA_P
+ ISB_N ISB_P MA_SCLK SDI SIN_N SIN_P SLO_SDO VDD VDDA VSS
* device instance $1 r0 *1 1150,243.585 ptap1
R$1 IOVSS \$1 ptap1 A=288962.0397p P=70906.208u
* device instance $2 r0 *1 1150,298 ptap1
R$2 VSS \$1 ptap1 A=1203.0816p P=8111.936u
* device instance $597 r90 *1 1114.54,224.19 dpantenna
D$597 IOVSS IOVDD dpantenna A=35.0028p P=58.08u m=4
* device instance $603 r90 *1 1114.54,165.19 dantenna
D$603 \$1 IOVSS dantenna A=35.0028p P=58.08u m=4
* device instance $634 m0 *1 750.12,198.715 rppd
R$634 \$I475101 IOVDD \$1 rppd w=1u l=520u ps=0u b=0 m=1
* device instance $635 r0 *1 698.155,151.95 sg13_hv_nmos
M$635 IOVSS \$I475102 IOVDD \$1 sg13_hv_nmos L=0.6u W=756.8u AS=344.608p
+ AD=349.36p PS=931.04u PD=933.2u rfmode=0
* device instance $807 r0 *1 694.77,167.98 dantenna
D$807 \$1 \$I475102 dantenna A=0.2304p P=1.92u m=1
* device instance $809 m90 *1 762.28,221.79 sg13_hv_nmos
M$809 IOVSS \$I475101 IOVSS \$1 sg13_hv_nmos L=9.5u W=126u AS=26.64p AD=23.94p
+ PS=149.92u PD=131.32u rfmode=0
* device instance $816 m90 *1 697.62,221.79 sg13_hv_nmos
M$816 IOVSS \$I475101 \$I475102 \$1 sg13_hv_nmos L=0.5u W=108u AS=20.52p
+ AD=23.22p PS=112.56u PD=131.16u rfmode=0
* device instance $835 m90 *1 751.56,235.91 sg13_hv_pmos
M$835 IOVDD \$I475101 \$I475102 IOVDD sg13_hv_pmos L=0.5u W=350u AS=67.55p
+ AD=67.55p PS=376.3u PD=376.3u rfmode=0
* device instance $911 m0 *1 470.12,198.715 rppd
R$911 \$I475103 VDD \$1 rppd w=1u l=520u ps=0u b=0 m=1
* device instance $912 r0 *1 418.155,151.95 sg13_hv_nmos
M$912 IOVSS \$I475104 VDD \$1 sg13_hv_nmos L=0.6u W=756.8u AS=344.608p
+ AD=349.36p PS=931.04u PD=933.2u rfmode=0
* device instance $1084 r0 *1 414.77,167.98 dantenna
D$1084 \$1 \$I475104 dantenna A=0.2304p P=1.92u m=1
* device instance $1086 m90 *1 482.28,221.79 sg13_hv_nmos
M$1086 IOVSS \$I475103 IOVSS \$1 sg13_hv_nmos L=9.5u W=126u AS=26.64p AD=23.94p
+ PS=149.92u PD=131.32u rfmode=0
* device instance $1093 m90 *1 417.62,221.79 sg13_hv_nmos
M$1093 IOVSS \$I475103 \$I475104 \$1 sg13_hv_nmos L=0.5u W=108u AS=20.52p
+ AD=23.22p PS=112.56u PD=131.16u rfmode=0
* device instance $1112 m90 *1 471.56,235.91 sg13_hv_pmos
M$1112 VDD \$I475103 \$I475104 VDD sg13_hv_pmos L=0.5u W=350u AS=67.55p
+ AD=67.55p PS=376.3u PD=376.3u rfmode=0
* device instance $1163 r90 *1 974.54,224.19 dpantenna
D$1163 VSS IOVDD dpantenna A=35.0028p P=58.08u m=4
* device instance $1169 r90 *1 974.54,165.19 dantenna
D$1169 \$1 VSS dantenna A=35.0028p P=58.08u m=4
* device instance $1175 m0 *1 719.295,1448.05 sg13_hv_nmos
M$1175 IOVSS \$I475105 GATE_C \$1 sg13_hv_nmos L=0.6u W=66u AS=30.096p
+ AD=31.284p PS=84.08u PD=84.62u rfmode=0
* device instance $1190 m0 *1 705.32,1446.295 dantenna
D$1190 \$1 \$I475105 dantenna A=0.6084p P=3.12u m=1
* device instance $1192 m0 *1 579.295,1448.05 sg13_hv_nmos
M$1192 IOVSS \$I475108 GATE_B \$1 sg13_hv_nmos L=0.6u W=66u AS=30.096p
+ AD=31.284p PS=84.08u PD=84.62u rfmode=0
* device instance $1207 m0 *1 565.32,1446.295 dantenna
D$1207 \$1 \$I475108 dantenna A=0.6084p P=3.12u m=1
* device instance $1209 m0 *1 439.295,1448.05 sg13_hv_nmos
M$1209 IOVSS \$I475111 GATE_A \$1 sg13_hv_nmos L=0.6u W=66u AS=30.096p
+ AD=31.284p PS=84.08u PD=84.62u rfmode=0
* device instance $1224 m0 *1 425.32,1446.295 dantenna
D$1224 \$1 \$I475111 dantenna A=0.6084p P=3.12u m=1
* device instance $1226 m0 *1 719.295,1387.92 sg13_hv_pmos
M$1226 IOVDD \$I475106 GATE_C IOVDD sg13_hv_pmos L=0.6u W=199.8u AS=91.1088p
+ AD=94.7052p PS=240.48u PD=241.56u rfmode=0
* device instance $1256 m0 *1 705.35,1377.9 dpantenna
D$1256 \$I475106 IOVDD dpantenna A=0.6084p P=3.12u m=1
* device instance $1258 m0 *1 579.295,1387.92 sg13_hv_pmos
M$1258 IOVDD \$I475109 GATE_B IOVDD sg13_hv_pmos L=0.6u W=199.8u AS=91.1088p
+ AD=94.7052p PS=240.48u PD=241.56u rfmode=0
* device instance $1288 m0 *1 565.35,1377.9 dpantenna
D$1288 \$I475109 IOVDD dpantenna A=0.6084p P=3.12u m=1
* device instance $1290 m0 *1 439.295,1387.92 sg13_hv_pmos
M$1290 IOVDD \$I475112 GATE_A IOVDD sg13_hv_pmos L=0.6u W=199.8u AS=91.1088p
+ AD=94.7052p PS=240.48u PD=241.56u rfmode=0
* device instance $1320 m0 *1 425.35,1377.9 dpantenna
D$1320 \$I475112 IOVDD dpantenna A=0.6084p P=3.12u m=1
* device instance $1322 m0 *1 730,1398.54 dpantenna
D$1322 GATE_C IOVDD dpantenna A=35.0028p P=58.08u m=2
* device instance $1325 m0 *1 590,1398.54 dpantenna
D$1325 GATE_B IOVDD dpantenna A=35.0028p P=58.08u m=2
* device instance $1328 m0 *1 450,1398.54 dpantenna
D$1328 GATE_A IOVDD dpantenna A=35.0028p P=58.08u m=2
* device instance $1331 m0 *1 730,1434.06 dantenna
D$1331 \$1 GATE_C dantenna A=35.0028p P=58.08u m=2
* device instance $1334 m0 *1 590,1434.06 dantenna
D$1334 \$1 GATE_B dantenna A=35.0028p P=58.08u m=2
* device instance $1337 m0 *1 450,1434.06 dantenna
D$1337 \$1 GATE_A dantenna A=35.0028p P=58.08u m=2
* device instance $1340 m45 *1 283.54,1027.63 dantenna
D$1340 \$1 \$4.padres dantenna A=1.984p P=7.48u m=1
* device instance $1341 m45 *1 288.51,1025.46 dpantenna
D$1341 \$4.padres IOVDD dpantenna A=3.1872p P=11.24u m=1
* device instance $1342 m45 *1 282.535,1023.085 rppd
R$1342 COS_P \$4.padres \$1 rppd w=1u l=2u ps=0u b=0 m=1
* device instance $1345 m45 *1 283.54,887.63 dantenna
D$1345 \$1 \$5.padres dantenna A=1.984p P=7.48u m=1
* device instance $1346 m45 *1 288.51,885.46 dpantenna
D$1346 \$5.padres IOVDD dpantenna A=3.1872p P=11.24u m=1
* device instance $1347 m45 *1 282.535,883.085 rppd
R$1347 SIN_N \$5.padres \$1 rppd w=1u l=2u ps=0u b=0 m=1
* device instance $1350 m45 *1 283.54,1167.63 dantenna
D$1350 \$1 \$6.padres dantenna A=1.984p P=7.48u m=1
* device instance $1351 m45 *1 288.51,1165.46 dpantenna
D$1351 \$6.padres IOVDD dpantenna A=3.1872p P=11.24u m=1
* device instance $1352 m45 *1 282.535,1163.085 rppd
R$1352 COS_N \$6.padres \$1 rppd w=1u l=2u ps=0u b=0 m=1
* device instance $1355 m45 *1 283.54,747.63 dantenna
D$1355 \$1 \$7.padres dantenna A=1.984p P=7.48u m=1
* device instance $1356 m45 *1 288.51,745.46 dpantenna
D$1356 \$7.padres IOVDD dpantenna A=3.1872p P=11.24u m=1
* device instance $1357 m45 *1 282.535,743.085 rppd
R$1357 SIN_P \$7.padres \$1 rppd w=1u l=2u ps=0u b=0 m=1
* device instance $1360 r90 *1 1316.46,1027.63 dantenna
D$1360 \$1 \$8.padres dantenna A=1.984p P=7.48u m=1
* device instance $1361 r90 *1 1311.49,1025.46 dpantenna
D$1361 \$8.padres IOVDD dpantenna A=3.1872p P=11.24u m=1
* device instance $1362 r90 *1 1317.465,1023.085 rppd
R$1362 ISB_N \$8.padres \$1 rppd w=1u l=2u ps=0u b=0 m=1
* device instance $1365 r90 *1 1316.46,887.63 dantenna
D$1365 \$1 \$9.padres dantenna A=1.984p P=7.48u m=1
* device instance $1366 r90 *1 1311.49,885.46 dpantenna
D$1366 \$9.padres IOVDD dpantenna A=3.1872p P=11.24u m=1
* device instance $1367 r90 *1 1317.465,883.085 rppd
R$1367 ISB_P \$9.padres \$1 rppd w=1u l=2u ps=0u b=0 m=1
* device instance $1370 r90 *1 1316.46,607.63 dantenna
D$1370 \$1 \$10.padres dantenna A=1.984p P=7.48u m=1
* device instance $1371 r90 *1 1311.49,605.46 dpantenna
D$1371 \$10.padres IOVDD dpantenna A=3.1872p P=11.24u m=1
* device instance $1372 r90 *1 1317.465,603.085 rppd
R$1372 ISA_P \$10.padres \$1 rppd w=1u l=2u ps=0u b=0 m=1
* device instance $1375 r90 *1 1316.46,747.63 dantenna
D$1375 \$1 \$11.padres dantenna A=1.984p P=7.48u m=1
* device instance $1376 r90 *1 1311.49,745.46 dpantenna
D$1376 \$11.padres IOVDD dpantenna A=3.1872p P=11.24u m=1
* device instance $1377 r90 *1 1317.465,743.085 rppd
R$1377 ISA_N \$11.padres \$1 rppd w=1u l=2u ps=0u b=0 m=1
* device instance $1380 r90 *1 1316.46,467.63 dantenna
D$1380 \$1 \$110239.padres dantenna A=1.984p P=7.48u m=1
* device instance $1381 r90 *1 1311.49,465.46 dpantenna
D$1381 \$110239.padres IOVDD dpantenna A=3.1872p P=11.24u m=1
* device instance $1382 r90 *1 1317.465,463.085 rppd
R$1382 VDDA \$110239.padres \$1 rppd w=1u l=2u ps=0u b=0 m=1
* device instance $1385 m45 *1 201.46,1010 dpantenna
D$1385 COS_P IOVDD dpantenna A=35.0028p P=58.08u m=2
* device instance $1388 m45 *1 201.46,870 dpantenna
D$1388 SIN_N IOVDD dpantenna A=35.0028p P=58.08u m=2
* device instance $1391 m45 *1 201.46,1150 dpantenna
D$1391 COS_N IOVDD dpantenna A=35.0028p P=58.08u m=2
* device instance $1394 m45 *1 201.46,730 dpantenna
D$1394 SIN_P IOVDD dpantenna A=35.0028p P=58.08u m=2
* device instance $1397 r90 *1 1398.54,1010 dpantenna
D$1397 ISB_N IOVDD dpantenna A=35.0028p P=58.08u m=2
* device instance $1400 r90 *1 1398.54,870 dpantenna
D$1400 ISB_P IOVDD dpantenna A=35.0028p P=58.08u m=2
* device instance $1403 r90 *1 1398.54,590 dpantenna
D$1403 ISA_P IOVDD dpantenna A=35.0028p P=58.08u m=2
* device instance $1406 r90 *1 1398.54,730 dpantenna
D$1406 ISA_N IOVDD dpantenna A=35.0028p P=58.08u m=2
* device instance $1409 r90 *1 1398.54,450 dpantenna
D$1409 VDDA IOVDD dpantenna A=35.0028p P=58.08u m=2
* device instance $1412 m45 *1 165.94,1010 dantenna
D$1412 \$1 COS_P dantenna A=35.0028p P=58.08u m=2
* device instance $1415 m45 *1 165.94,870 dantenna
D$1415 \$1 SIN_N dantenna A=35.0028p P=58.08u m=2
* device instance $1418 m45 *1 165.94,1150 dantenna
D$1418 \$1 COS_N dantenna A=35.0028p P=58.08u m=2
* device instance $1421 m45 *1 165.94,730 dantenna
D$1421 \$1 SIN_P dantenna A=35.0028p P=58.08u m=2
* device instance $1424 r90 *1 1434.06,1010 dantenna
D$1424 \$1 ISB_N dantenna A=35.0028p P=58.08u m=2
* device instance $1427 r90 *1 1434.06,870 dantenna
D$1427 \$1 ISB_P dantenna A=35.0028p P=58.08u m=2
* device instance $1430 r90 *1 1434.06,590 dantenna
D$1430 \$1 ISA_P dantenna A=35.0028p P=58.08u m=2
* device instance $1433 r90 *1 1434.06,730 dantenna
D$1433 \$1 ISA_N dantenna A=35.0028p P=58.08u m=2
* device instance $1436 r90 *1 1434.06,450 dantenna
D$1436 \$1 VDDA dantenna A=35.0028p P=58.08u m=2
* device instance $1439 m45 *1 219.18,995.52 sg13_hv_pmos
M$1439 IOVDD \$I475183 COS_P IOVDD sg13_hv_pmos L=0.6u W=266.4u AS=123.21p
+ AD=123.21p PS=316.72u PD=316.72u rfmode=0
* device instance $1479 m45 *1 209.175,1036.3 rppd
R$1479 IOVDD \$I475183 IOVDD rppd w=0.5u l=12.9u ps=0u b=0 m=1
* device instance $1481 m45 *1 219.18,855.52 sg13_hv_pmos
M$1481 IOVDD \$I475184 SIN_N IOVDD sg13_hv_pmos L=0.6u W=266.4u AS=123.21p
+ AD=123.21p PS=316.72u PD=316.72u rfmode=0
* device instance $1521 m45 *1 209.175,896.3 rppd
R$1521 IOVDD \$I475184 IOVDD rppd w=0.5u l=12.9u ps=0u b=0 m=1
* device instance $1523 m45 *1 219.18,1135.52 sg13_hv_pmos
M$1523 IOVDD \$I475185 COS_N IOVDD sg13_hv_pmos L=0.6u W=266.4u AS=123.21p
+ AD=123.21p PS=316.72u PD=316.72u rfmode=0
* device instance $1563 m45 *1 209.175,1176.3 rppd
R$1563 IOVDD \$I475185 IOVDD rppd w=0.5u l=12.9u ps=0u b=0 m=1
* device instance $1565 m45 *1 219.18,715.52 sg13_hv_pmos
M$1565 IOVDD \$I475186 SIN_P IOVDD sg13_hv_pmos L=0.6u W=266.4u AS=123.21p
+ AD=123.21p PS=316.72u PD=316.72u rfmode=0
* device instance $1605 m45 *1 209.175,756.3 rppd
R$1605 IOVDD \$I475186 IOVDD rppd w=0.5u l=12.9u ps=0u b=0 m=1
* device instance $1607 r90 *1 1380.82,995.52 sg13_hv_pmos
M$1607 IOVDD \$I475187 ISB_N IOVDD sg13_hv_pmos L=0.6u W=266.4u AS=123.21p
+ AD=123.21p PS=316.72u PD=316.72u rfmode=0
* device instance $1647 r90 *1 1390.825,1036.3 rppd
R$1647 IOVDD \$I475187 IOVDD rppd w=0.5u l=12.9u ps=0u b=0 m=1
* device instance $1649 r90 *1 1380.82,855.52 sg13_hv_pmos
M$1649 IOVDD \$I475188 ISB_P IOVDD sg13_hv_pmos L=0.6u W=266.4u AS=123.21p
+ AD=123.21p PS=316.72u PD=316.72u rfmode=0
* device instance $1689 r90 *1 1390.825,896.3 rppd
R$1689 IOVDD \$I475188 IOVDD rppd w=0.5u l=12.9u ps=0u b=0 m=1
* device instance $1691 r90 *1 1380.82,575.52 sg13_hv_pmos
M$1691 IOVDD \$I475189 ISA_P IOVDD sg13_hv_pmos L=0.6u W=266.4u AS=123.21p
+ AD=123.21p PS=316.72u PD=316.72u rfmode=0
* device instance $1731 r90 *1 1390.825,616.3 rppd
R$1731 IOVDD \$I475189 IOVDD rppd w=0.5u l=12.9u ps=0u b=0 m=1
* device instance $1733 r90 *1 1380.82,715.52 sg13_hv_pmos
M$1733 IOVDD \$I475190 ISA_N IOVDD sg13_hv_pmos L=0.6u W=266.4u AS=123.21p
+ AD=123.21p PS=316.72u PD=316.72u rfmode=0
* device instance $1773 r90 *1 1390.825,756.3 rppd
R$1773 IOVDD \$I475190 IOVDD rppd w=0.5u l=12.9u ps=0u b=0 m=1
* device instance $1775 r90 *1 1380.82,435.52 sg13_hv_pmos
M$1775 IOVDD \$I475191 VDDA IOVDD sg13_hv_pmos L=0.6u W=266.4u AS=123.21p
+ AD=123.21p PS=316.72u PD=316.72u rfmode=0
* device instance $1815 r90 *1 1390.825,476.3 rppd
R$1815 IOVDD \$I475191 IOVDD rppd w=0.5u l=12.9u ps=0u b=0 m=1
* device instance $1817 m45 *1 151.95,995.52 sg13_hv_nmos
M$1817 IOVSS \$I475192 COS_P \$1 sg13_hv_nmos L=0.6u W=88u AS=40.7p AD=40.7p
+ PS=110.9u PD=110.9u rfmode=0
* device instance $1837 m45 *1 150.175,1036.3 rppd
R$1837 IOVSS \$I475192 \$1 rppd w=0.5u l=3.54u ps=0u b=0 m=1
* device instance $1839 m45 *1 151.95,855.52 sg13_hv_nmos
M$1839 IOVSS \$I475193 SIN_N \$1 sg13_hv_nmos L=0.6u W=88u AS=40.7p AD=40.7p
+ PS=110.9u PD=110.9u rfmode=0
* device instance $1859 m45 *1 150.175,896.3 rppd
R$1859 IOVSS \$I475193 \$1 rppd w=0.5u l=3.54u ps=0u b=0 m=1
* device instance $1861 m45 *1 151.95,1135.52 sg13_hv_nmos
M$1861 IOVSS \$I475194 COS_N \$1 sg13_hv_nmos L=0.6u W=88u AS=40.7p AD=40.7p
+ PS=110.9u PD=110.9u rfmode=0
* device instance $1881 m45 *1 150.175,1176.3 rppd
R$1881 IOVSS \$I475194 \$1 rppd w=0.5u l=3.54u ps=0u b=0 m=1
* device instance $1883 m45 *1 151.95,715.52 sg13_hv_nmos
M$1883 IOVSS \$I475195 SIN_P \$1 sg13_hv_nmos L=0.6u W=88u AS=40.7p AD=40.7p
+ PS=110.9u PD=110.9u rfmode=0
* device instance $1903 m45 *1 150.175,756.3 rppd
R$1903 IOVSS \$I475195 \$1 rppd w=0.5u l=3.54u ps=0u b=0 m=1
* device instance $1905 r90 *1 1448.05,995.52 sg13_hv_nmos
M$1905 IOVSS \$I475196 ISB_N \$1 sg13_hv_nmos L=0.6u W=88u AS=40.7p AD=40.7p
+ PS=110.9u PD=110.9u rfmode=0
* device instance $1925 r90 *1 1449.825,1036.3 rppd
R$1925 IOVSS \$I475196 \$1 rppd w=0.5u l=3.54u ps=0u b=0 m=1
* device instance $1927 r90 *1 1448.05,855.52 sg13_hv_nmos
M$1927 IOVSS \$I475197 ISB_P \$1 sg13_hv_nmos L=0.6u W=88u AS=40.7p AD=40.7p
+ PS=110.9u PD=110.9u rfmode=0
* device instance $1947 r90 *1 1449.825,896.3 rppd
R$1947 IOVSS \$I475197 \$1 rppd w=0.5u l=3.54u ps=0u b=0 m=1
* device instance $1949 r90 *1 1448.05,575.52 sg13_hv_nmos
M$1949 IOVSS \$I475198 ISA_P \$1 sg13_hv_nmos L=0.6u W=88u AS=40.7p AD=40.7p
+ PS=110.9u PD=110.9u rfmode=0
* device instance $1969 r90 *1 1449.825,616.3 rppd
R$1969 IOVSS \$I475198 \$1 rppd w=0.5u l=3.54u ps=0u b=0 m=1
* device instance $1971 r90 *1 1448.05,715.52 sg13_hv_nmos
M$1971 IOVSS \$I475199 ISA_N \$1 sg13_hv_nmos L=0.6u W=88u AS=40.7p AD=40.7p
+ PS=110.9u PD=110.9u rfmode=0
* device instance $1991 r90 *1 1449.825,756.3 rppd
R$1991 IOVSS \$I475199 \$1 rppd w=0.5u l=3.54u ps=0u b=0 m=1
* device instance $1993 r90 *1 1448.05,435.52 sg13_hv_nmos
M$1993 IOVSS \$I475200 VDDA \$1 sg13_hv_nmos L=0.6u W=88u AS=40.7p AD=40.7p
+ PS=110.9u PD=110.9u rfmode=0
* device instance $2013 r90 *1 1449.825,476.3 rppd
R$2013 IOVSS \$I475200 \$1 rppd w=0.5u l=3.54u ps=0u b=0 m=1
* device instance $2015 m0 *1 1149.11,1380.82 sg13_hv_pmos
M$2015 IOVDD \$I475124 SLO_SDO IOVDD sg13_hv_pmos L=0.6u W=26.64u AS=14.1192p
+ AD=14.1192p PS=44.2u PD=44.2u rfmode=0
* device instance $2019 m0 *1 1130.24,1377.93 dpantenna
D$2019 \$I475124 IOVDD dpantenna A=0.2304p P=1.92u m=1
* device instance $2021 r90 *1 1380.82,1149.11 sg13_hv_pmos
M$2021 IOVDD \$I475127 FAULT_N IOVDD sg13_hv_pmos L=0.6u W=26.64u AS=14.1192p
+ AD=14.1192p PS=44.2u PD=44.2u rfmode=0
* device instance $2025 r90 *1 1377.93,1130.24 dpantenna
D$2025 \$I475127 IOVDD dpantenna A=0.2304p P=1.92u m=1
* device instance $2027 m0 *1 1149.11,1448.05 sg13_hv_nmos
M$2027 IOVSS \$I475123 SLO_SDO \$1 sg13_hv_nmos L=0.6u W=8.8u AS=4.664p
+ AD=4.664p PS=15.32u PD=15.32u rfmode=0
* device instance $2029 m0 *1 1130.24,1446.26 dantenna
D$2029 \$1 \$I475123 dantenna A=0.6084p P=3.12u m=1
* device instance $2031 r90 *1 1448.05,1149.11 sg13_hv_nmos
M$2031 IOVSS \$I475126 FAULT_N \$1 sg13_hv_nmos L=0.6u W=8.8u AS=4.664p
+ AD=4.664p PS=15.32u PD=15.32u rfmode=0
* device instance $2033 r90 *1 1446.26,1130.24 dantenna
D$2033 \$1 \$I475126 dantenna A=0.6084p P=3.12u m=1
* device instance $2035 m0 *1 1150,1398.54 dpantenna
D$2035 SLO_SDO IOVDD dpantenna A=35.0028p P=58.08u m=2
* device instance $2038 r90 *1 1398.54,1150 dpantenna
D$2038 FAULT_N IOVDD dpantenna A=35.0028p P=58.08u m=2
* device instance $2041 m0 *1 1150,1434.06 dantenna
D$2041 \$1 SLO_SDO dantenna A=35.0028p P=58.08u m=2
* device instance $2044 r90 *1 1434.06,1150 dantenna
D$2044 \$1 FAULT_N dantenna A=35.0028p P=58.08u m=2
* device instance $2047 m45 *1 300.005,590.255 sg13_lv_nmos
M$2047 \$12.p2c \$I475204 VSS \$1 sg13_lv_nmos L=0.13u W=2.75u AS=0.935p
+ AD=0.935p PS=6.18u PD=6.18u rfmode=0
* device instance $2048 m45 *1 300.055,591.765 sg13_hv_nmos
M$2048 VSS \$I475202 \$I475204 \$1 sg13_hv_nmos L=0.45u W=2.65u AS=0.901p
+ AD=0.5035p PS=5.98u PD=3.03u rfmode=0
* device instance $2049 m45 *1 300.055,592.595 sg13_hv_nmos
M$2049 \$I475204 \$I475201 VDD \$1 sg13_hv_nmos L=0.45u W=2.65u AS=0.5035p
+ AD=0.901p PS=3.03u PD=5.98u rfmode=0
* device instance $2050 m45 *1 282.87,599.755 sg13_hv_nmos
M$2050 \$I475201 \$I475203 IOVSS \$1 sg13_hv_nmos L=0.45u W=1.3u AS=0.442p
+ AD=0.247p PS=3.28u PD=1.68u rfmode=0
* device instance $2051 m45 *1 282.87,600.585 sg13_hv_nmos
M$2051 IOVSS \$I475201 \$I475202 \$1 sg13_hv_nmos L=0.45u W=1.3u AS=0.247p
+ AD=0.442p PS=1.68u PD=3.28u rfmode=0
* device instance $2052 m45 *1 304.995,590.255 sg13_lv_pmos
M$2052 \$12.p2c \$I475204 VDD VDD sg13_lv_pmos L=0.13u W=4.75u AS=1.615p
+ AD=1.615p PS=10.18u PD=10.18u rfmode=0
* device instance $2053 m45 *1 287.27,598.925 sg13_hv_pmos
M$2053 IOVDD \$I475203 \$I475201 IOVDD sg13_hv_pmos L=0.45u W=4.6u AS=1.219p
+ AD=0.874p PS=7.96u PD=5.36u rfmode=0
* device instance $2055 m45 *1 287.27,600.585 sg13_hv_pmos
M$2055 IOVDD \$I475201 \$I475202 IOVDD sg13_hv_pmos L=0.45u W=4.6u AS=0.874p
+ AD=1.219p PS=5.36u PD=7.96u rfmode=0
* device instance $2059 m0 *1 870.255,1299.995 sg13_lv_nmos
M$2059 \$13.p2c \$I475208 VSS \$1 sg13_lv_nmos L=0.13u W=2.75u AS=0.935p
+ AD=0.935p PS=6.18u PD=6.18u rfmode=0
* device instance $2060 m0 *1 871.765,1299.945 sg13_hv_nmos
M$2060 VSS \$I475206 \$I475208 \$1 sg13_hv_nmos L=0.45u W=2.65u AS=0.901p
+ AD=0.5035p PS=5.98u PD=3.03u rfmode=0
* device instance $2061 m0 *1 872.595,1299.945 sg13_hv_nmos
M$2061 \$I475208 \$I475205 VDD \$1 sg13_hv_nmos L=0.45u W=2.65u AS=0.5035p
+ AD=0.901p PS=3.03u PD=5.98u rfmode=0
* device instance $2062 m0 *1 879.755,1317.13 sg13_hv_nmos
M$2062 \$I475205 \$I475207 IOVSS \$1 sg13_hv_nmos L=0.45u W=1.3u AS=0.442p
+ AD=0.247p PS=3.28u PD=1.68u rfmode=0
* device instance $2063 m0 *1 880.585,1317.13 sg13_hv_nmos
M$2063 IOVSS \$I475205 \$I475206 \$1 sg13_hv_nmos L=0.45u W=1.3u AS=0.247p
+ AD=0.442p PS=1.68u PD=3.28u rfmode=0
* device instance $2064 m0 *1 870.255,1295.005 sg13_lv_pmos
M$2064 \$13.p2c \$I475208 VDD VDD sg13_lv_pmos L=0.13u W=4.75u AS=1.615p
+ AD=1.615p PS=10.18u PD=10.18u rfmode=0
* device instance $2065 m0 *1 878.925,1312.73 sg13_hv_pmos
M$2065 IOVDD \$I475207 \$I475205 IOVDD sg13_hv_pmos L=0.45u W=4.6u AS=1.219p
+ AD=0.874p PS=7.96u PD=5.36u rfmode=0
* device instance $2067 m0 *1 880.585,1312.73 sg13_hv_pmos
M$2067 IOVDD \$I475205 \$I475206 IOVDD sg13_hv_pmos L=0.45u W=4.6u AS=0.874p
+ AD=1.219p PS=5.36u PD=7.96u rfmode=0
* device instance $2071 m0 *1 1010.255,1299.995 sg13_lv_nmos
M$2071 \$14.p2c \$I475212 VSS \$1 sg13_lv_nmos L=0.13u W=2.75u AS=0.935p
+ AD=0.935p PS=6.18u PD=6.18u rfmode=0
* device instance $2072 m0 *1 1011.765,1299.945 sg13_hv_nmos
M$2072 VSS \$I475210 \$I475212 \$1 sg13_hv_nmos L=0.45u W=2.65u AS=0.901p
+ AD=0.5035p PS=5.98u PD=3.03u rfmode=0
* device instance $2073 m0 *1 1012.595,1299.945 sg13_hv_nmos
M$2073 \$I475212 \$I475209 VDD \$1 sg13_hv_nmos L=0.45u W=2.65u AS=0.5035p
+ AD=0.901p PS=3.03u PD=5.98u rfmode=0
* device instance $2074 m0 *1 1019.755,1317.13 sg13_hv_nmos
M$2074 \$I475209 \$I475211 IOVSS \$1 sg13_hv_nmos L=0.45u W=1.3u AS=0.442p
+ AD=0.247p PS=3.28u PD=1.68u rfmode=0
* device instance $2075 m0 *1 1020.585,1317.13 sg13_hv_nmos
M$2075 IOVSS \$I475209 \$I475210 \$1 sg13_hv_nmos L=0.45u W=1.3u AS=0.247p
+ AD=0.442p PS=1.68u PD=3.28u rfmode=0
* device instance $2076 m0 *1 1010.255,1295.005 sg13_lv_pmos
M$2076 \$14.p2c \$I475212 VDD VDD sg13_lv_pmos L=0.13u W=4.75u AS=1.615p
+ AD=1.615p PS=10.18u PD=10.18u rfmode=0
* device instance $2077 m0 *1 1018.925,1312.73 sg13_hv_pmos
M$2077 IOVDD \$I475211 \$I475209 IOVDD sg13_hv_pmos L=0.45u W=4.6u AS=1.219p
+ AD=0.874p PS=7.96u PD=5.36u rfmode=0
* device instance $2079 m0 *1 1020.585,1312.73 sg13_hv_pmos
M$2079 IOVDD \$I475209 \$I475210 IOVDD sg13_hv_pmos L=0.45u W=4.6u AS=0.874p
+ AD=1.219p PS=5.36u PD=7.96u rfmode=0
* device instance $2083 m45 *1 300.005,450.255 sg13_lv_nmos
M$2083 \$462636.p2c \$I475216 VSS \$1 sg13_lv_nmos L=0.13u W=2.75u AS=0.935p
+ AD=0.935p PS=6.18u PD=6.18u rfmode=0
* device instance $2084 m45 *1 300.055,451.765 sg13_hv_nmos
M$2084 VSS \$I475214 \$I475216 \$1 sg13_hv_nmos L=0.45u W=2.65u AS=0.901p
+ AD=0.5035p PS=5.98u PD=3.03u rfmode=0
* device instance $2085 m45 *1 300.055,452.595 sg13_hv_nmos
M$2085 \$I475216 \$I475213 VDD \$1 sg13_hv_nmos L=0.45u W=2.65u AS=0.5035p
+ AD=0.901p PS=3.03u PD=5.98u rfmode=0
* device instance $2086 m45 *1 282.87,459.755 sg13_hv_nmos
M$2086 \$I475213 \$I475215 IOVSS \$1 sg13_hv_nmos L=0.45u W=1.3u AS=0.442p
+ AD=0.247p PS=3.28u PD=1.68u rfmode=0
* device instance $2087 m45 *1 282.87,460.585 sg13_hv_nmos
M$2087 IOVSS \$I475213 \$I475214 \$1 sg13_hv_nmos L=0.45u W=1.3u AS=0.247p
+ AD=0.442p PS=1.68u PD=3.28u rfmode=0
* device instance $2088 m45 *1 304.995,450.255 sg13_lv_pmos
M$2088 \$462636.p2c \$I475216 VDD VDD sg13_lv_pmos L=0.13u W=4.75u AS=1.615p
+ AD=1.615p PS=10.18u PD=10.18u rfmode=0
* device instance $2089 m45 *1 287.27,458.925 sg13_hv_pmos
M$2089 IOVDD \$I475215 \$I475213 IOVDD sg13_hv_pmos L=0.45u W=4.6u AS=1.219p
+ AD=0.874p PS=7.96u PD=5.36u rfmode=0
* device instance $2091 m45 *1 287.27,460.585 sg13_hv_pmos
M$2091 IOVDD \$I475213 \$I475214 IOVDD sg13_hv_pmos L=0.45u W=4.6u AS=0.874p
+ AD=1.219p PS=5.36u PD=7.96u rfmode=0
* device instance $2095 m0 *1 224.19,554.54 dpantenna
D$2095 EN_STO_IN IOVDD dpantenna A=35.0028p P=58.08u m=2
* device instance $2098 m135 *1 834.54,1375.81 dpantenna
D$2098 CS_N IOVDD dpantenna A=35.0028p P=58.08u m=2
* device instance $2101 m135 *1 974.54,1375.81 dpantenna
D$2101 MA_SCLK IOVDD dpantenna A=35.0028p P=58.08u m=2
* device instance $2104 m0 *1 224.19,414.54 dpantenna
D$2104 SDI IOVDD dpantenna A=35.0028p P=58.08u m=2
* device instance $2107 m0 *1 165.19,554.54 dantenna
D$2107 \$1 EN_STO_IN dantenna A=35.0028p P=58.08u m=2
* device instance $2110 m135 *1 834.54,1434.81 dantenna
D$2110 \$1 CS_N dantenna A=35.0028p P=58.08u m=2
* device instance $2113 m135 *1 974.54,1434.81 dantenna
D$2113 \$1 MA_SCLK dantenna A=35.0028p P=58.08u m=2
* device instance $2116 m0 *1 165.19,414.54 dantenna
D$2116 \$1 SDI dantenna A=35.0028p P=58.08u m=2
* device instance $2119 m0 *1 727.48,1299.995 sg13_lv_nmos
M$2119 \$I475219 \$1.c2p VSS \$1 sg13_lv_nmos L=0.13u W=2.75u AS=0.935p
+ AD=0.935p PS=6.18u PD=6.18u rfmode=0
* device instance $2120 m0 *1 729.81,1303.68 sg13_hv_nmos
M$2120 VSS \$I475218 \$I475105 \$1 sg13_hv_nmos L=0.45u W=1.9u AS=0.646p
+ AD=0.646p PS=4.48u PD=4.48u rfmode=0
* device instance $2121 m0 *1 727.64,1303.68 sg13_hv_nmos
M$2121 \$I475217 \$1.c2p VSS \$1 sg13_hv_nmos L=0.45u W=1.9u AS=0.646p
+ AD=0.361p PS=4.48u PD=2.28u rfmode=0
* device instance $2122 m0 *1 728.47,1303.68 sg13_hv_nmos
M$2122 VSS \$I475219 \$I475218 \$1 sg13_hv_nmos L=0.45u W=1.9u AS=0.361p
+ AD=0.646p PS=2.28u PD=4.48u rfmode=0
* device instance $2123 m0 *1 727.48,1295.005 sg13_lv_pmos
M$2123 \$I475219 \$1.c2p VDD VDD sg13_lv_pmos L=0.13u W=4.75u AS=1.615p
+ AD=1.615p PS=10.18u PD=10.18u rfmode=0
* device instance $2124 m0 *1 729.81,1307.82 sg13_hv_pmos
M$2124 IOVDD \$I475218 \$I475105 IOVDD sg13_hv_pmos L=0.45u W=3.9u AS=1.326p
+ AD=1.326p PS=8.48u PD=8.48u rfmode=0
* device instance $2125 m0 *1 727.64,1307.82 sg13_hv_pmos
M$2125 \$I475217 \$I475218 IOVDD IOVDD sg13_hv_pmos L=0.45u W=0.3u AS=0.102p
+ AD=0.057p PS=1.28u PD=0.68u rfmode=0
* device instance $2126 m0 *1 728.47,1307.82 sg13_hv_pmos
M$2126 IOVDD \$I475217 \$I475218 IOVDD sg13_hv_pmos L=0.45u W=0.3u AS=0.057p
+ AD=0.102p PS=0.68u PD=1.28u rfmode=0
* device instance $2128 m0 *1 730.99,1299.995 sg13_lv_nmos
M$2128 \$I475222 \$1.c2p VSS \$1 sg13_lv_nmos L=0.13u W=2.75u AS=0.935p
+ AD=0.935p PS=6.18u PD=6.18u rfmode=0
* device instance $2129 m0 *1 733.32,1303.68 sg13_hv_nmos
M$2129 VSS \$I475221 \$I475106 \$1 sg13_hv_nmos L=0.45u W=1.9u AS=0.646p
+ AD=0.646p PS=4.48u PD=4.48u rfmode=0
* device instance $2130 m0 *1 731.15,1303.68 sg13_hv_nmos
M$2130 \$I475220 \$1.c2p VSS \$1 sg13_hv_nmos L=0.45u W=1.9u AS=0.646p
+ AD=0.361p PS=4.48u PD=2.28u rfmode=0
* device instance $2131 m0 *1 731.98,1303.68 sg13_hv_nmos
M$2131 VSS \$I475222 \$I475221 \$1 sg13_hv_nmos L=0.45u W=1.9u AS=0.361p
+ AD=0.646p PS=2.28u PD=4.48u rfmode=0
* device instance $2132 m0 *1 730.99,1295.005 sg13_lv_pmos
M$2132 \$I475222 \$1.c2p VDD VDD sg13_lv_pmos L=0.13u W=4.75u AS=1.615p
+ AD=1.615p PS=10.18u PD=10.18u rfmode=0
* device instance $2133 m0 *1 733.32,1307.82 sg13_hv_pmos
M$2133 IOVDD \$I475221 \$I475106 IOVDD sg13_hv_pmos L=0.45u W=3.9u AS=1.326p
+ AD=1.326p PS=8.48u PD=8.48u rfmode=0
* device instance $2134 m0 *1 731.15,1307.82 sg13_hv_pmos
M$2134 \$I475220 \$I475221 IOVDD IOVDD sg13_hv_pmos L=0.45u W=0.3u AS=0.102p
+ AD=0.057p PS=1.28u PD=0.68u rfmode=0
* device instance $2135 m0 *1 731.98,1307.82 sg13_hv_pmos
M$2135 IOVDD \$I475220 \$I475221 IOVDD sg13_hv_pmos L=0.45u W=0.3u AS=0.057p
+ AD=0.102p PS=0.68u PD=1.28u rfmode=0
* device instance $2137 m0 *1 587.48,1299.995 sg13_lv_nmos
M$2137 \$I475225 \$2.c2p VSS \$1 sg13_lv_nmos L=0.13u W=2.75u AS=0.935p
+ AD=0.935p PS=6.18u PD=6.18u rfmode=0
* device instance $2138 m0 *1 589.81,1303.68 sg13_hv_nmos
M$2138 VSS \$I475224 \$I475108 \$1 sg13_hv_nmos L=0.45u W=1.9u AS=0.646p
+ AD=0.646p PS=4.48u PD=4.48u rfmode=0
* device instance $2139 m0 *1 587.64,1303.68 sg13_hv_nmos
M$2139 \$I475223 \$2.c2p VSS \$1 sg13_hv_nmos L=0.45u W=1.9u AS=0.646p
+ AD=0.361p PS=4.48u PD=2.28u rfmode=0
* device instance $2140 m0 *1 588.47,1303.68 sg13_hv_nmos
M$2140 VSS \$I475225 \$I475224 \$1 sg13_hv_nmos L=0.45u W=1.9u AS=0.361p
+ AD=0.646p PS=2.28u PD=4.48u rfmode=0
* device instance $2141 m0 *1 587.48,1295.005 sg13_lv_pmos
M$2141 \$I475225 \$2.c2p VDD VDD sg13_lv_pmos L=0.13u W=4.75u AS=1.615p
+ AD=1.615p PS=10.18u PD=10.18u rfmode=0
* device instance $2142 m0 *1 589.81,1307.82 sg13_hv_pmos
M$2142 IOVDD \$I475224 \$I475108 IOVDD sg13_hv_pmos L=0.45u W=3.9u AS=1.326p
+ AD=1.326p PS=8.48u PD=8.48u rfmode=0
* device instance $2143 m0 *1 587.64,1307.82 sg13_hv_pmos
M$2143 \$I475223 \$I475224 IOVDD IOVDD sg13_hv_pmos L=0.45u W=0.3u AS=0.102p
+ AD=0.057p PS=1.28u PD=0.68u rfmode=0
* device instance $2144 m0 *1 588.47,1307.82 sg13_hv_pmos
M$2144 IOVDD \$I475223 \$I475224 IOVDD sg13_hv_pmos L=0.45u W=0.3u AS=0.057p
+ AD=0.102p PS=0.68u PD=1.28u rfmode=0
* device instance $2146 m0 *1 590.99,1299.995 sg13_lv_nmos
M$2146 \$I475228 \$2.c2p VSS \$1 sg13_lv_nmos L=0.13u W=2.75u AS=0.935p
+ AD=0.935p PS=6.18u PD=6.18u rfmode=0
* device instance $2147 m0 *1 593.32,1303.68 sg13_hv_nmos
M$2147 VSS \$I475227 \$I475109 \$1 sg13_hv_nmos L=0.45u W=1.9u AS=0.646p
+ AD=0.646p PS=4.48u PD=4.48u rfmode=0
* device instance $2148 m0 *1 591.15,1303.68 sg13_hv_nmos
M$2148 \$I475226 \$2.c2p VSS \$1 sg13_hv_nmos L=0.45u W=1.9u AS=0.646p
+ AD=0.361p PS=4.48u PD=2.28u rfmode=0
* device instance $2149 m0 *1 591.98,1303.68 sg13_hv_nmos
M$2149 VSS \$I475228 \$I475227 \$1 sg13_hv_nmos L=0.45u W=1.9u AS=0.361p
+ AD=0.646p PS=2.28u PD=4.48u rfmode=0
* device instance $2150 m0 *1 590.99,1295.005 sg13_lv_pmos
M$2150 \$I475228 \$2.c2p VDD VDD sg13_lv_pmos L=0.13u W=4.75u AS=1.615p
+ AD=1.615p PS=10.18u PD=10.18u rfmode=0
* device instance $2151 m0 *1 593.32,1307.82 sg13_hv_pmos
M$2151 IOVDD \$I475227 \$I475109 IOVDD sg13_hv_pmos L=0.45u W=3.9u AS=1.326p
+ AD=1.326p PS=8.48u PD=8.48u rfmode=0
* device instance $2152 m0 *1 591.15,1307.82 sg13_hv_pmos
M$2152 \$I475226 \$I475227 IOVDD IOVDD sg13_hv_pmos L=0.45u W=0.3u AS=0.102p
+ AD=0.057p PS=1.28u PD=0.68u rfmode=0
* device instance $2153 m0 *1 591.98,1307.82 sg13_hv_pmos
M$2153 IOVDD \$I475226 \$I475227 IOVDD sg13_hv_pmos L=0.45u W=0.3u AS=0.057p
+ AD=0.102p PS=0.68u PD=1.28u rfmode=0
* device instance $2155 m0 *1 447.48,1299.995 sg13_lv_nmos
M$2155 \$I475231 \$143822.c2p VSS \$1 sg13_lv_nmos L=0.13u W=2.75u AS=0.935p
+ AD=0.935p PS=6.18u PD=6.18u rfmode=0
* device instance $2156 m0 *1 449.81,1303.68 sg13_hv_nmos
M$2156 VSS \$I475230 \$I475111 \$1 sg13_hv_nmos L=0.45u W=1.9u AS=0.646p
+ AD=0.646p PS=4.48u PD=4.48u rfmode=0
* device instance $2157 m0 *1 447.64,1303.68 sg13_hv_nmos
M$2157 \$I475229 \$143822.c2p VSS \$1 sg13_hv_nmos L=0.45u W=1.9u AS=0.646p
+ AD=0.361p PS=4.48u PD=2.28u rfmode=0
* device instance $2158 m0 *1 448.47,1303.68 sg13_hv_nmos
M$2158 VSS \$I475231 \$I475230 \$1 sg13_hv_nmos L=0.45u W=1.9u AS=0.361p
+ AD=0.646p PS=2.28u PD=4.48u rfmode=0
* device instance $2159 m0 *1 447.48,1295.005 sg13_lv_pmos
M$2159 \$I475231 \$143822.c2p VDD VDD sg13_lv_pmos L=0.13u W=4.75u AS=1.615p
+ AD=1.615p PS=10.18u PD=10.18u rfmode=0
* device instance $2160 m0 *1 449.81,1307.82 sg13_hv_pmos
M$2160 IOVDD \$I475230 \$I475111 IOVDD sg13_hv_pmos L=0.45u W=3.9u AS=1.326p
+ AD=1.326p PS=8.48u PD=8.48u rfmode=0
* device instance $2161 m0 *1 447.64,1307.82 sg13_hv_pmos
M$2161 \$I475229 \$I475230 IOVDD IOVDD sg13_hv_pmos L=0.45u W=0.3u AS=0.102p
+ AD=0.057p PS=1.28u PD=0.68u rfmode=0
* device instance $2162 m0 *1 448.47,1307.82 sg13_hv_pmos
M$2162 IOVDD \$I475229 \$I475230 IOVDD sg13_hv_pmos L=0.45u W=0.3u AS=0.057p
+ AD=0.102p PS=0.68u PD=1.28u rfmode=0
* device instance $2164 m0 *1 450.99,1299.995 sg13_lv_nmos
M$2164 \$I475234 \$143822.c2p VSS \$1 sg13_lv_nmos L=0.13u W=2.75u AS=0.935p
+ AD=0.935p PS=6.18u PD=6.18u rfmode=0
* device instance $2165 m0 *1 453.32,1303.68 sg13_hv_nmos
M$2165 VSS \$I475233 \$I475112 \$1 sg13_hv_nmos L=0.45u W=1.9u AS=0.646p
+ AD=0.646p PS=4.48u PD=4.48u rfmode=0
* device instance $2166 m0 *1 451.15,1303.68 sg13_hv_nmos
M$2166 \$I475232 \$143822.c2p VSS \$1 sg13_hv_nmos L=0.45u W=1.9u AS=0.646p
+ AD=0.361p PS=4.48u PD=2.28u rfmode=0
* device instance $2167 m0 *1 451.98,1303.68 sg13_hv_nmos
M$2167 VSS \$I475234 \$I475233 \$1 sg13_hv_nmos L=0.45u W=1.9u AS=0.361p
+ AD=0.646p PS=2.28u PD=4.48u rfmode=0
* device instance $2168 m0 *1 450.99,1295.005 sg13_lv_pmos
M$2168 \$I475234 \$143822.c2p VDD VDD sg13_lv_pmos L=0.13u W=4.75u AS=1.615p
+ AD=1.615p PS=10.18u PD=10.18u rfmode=0
* device instance $2169 m0 *1 453.32,1307.82 sg13_hv_pmos
M$2169 IOVDD \$I475233 \$I475112 IOVDD sg13_hv_pmos L=0.45u W=3.9u AS=1.326p
+ AD=1.326p PS=8.48u PD=8.48u rfmode=0
* device instance $2170 m0 *1 451.15,1307.82 sg13_hv_pmos
M$2170 \$I475232 \$I475233 IOVDD IOVDD sg13_hv_pmos L=0.45u W=0.3u AS=0.102p
+ AD=0.057p PS=1.28u PD=0.68u rfmode=0
* device instance $2171 m0 *1 451.98,1307.82 sg13_hv_pmos
M$2171 IOVDD \$I475232 \$I475233 IOVDD sg13_hv_pmos L=0.45u W=0.3u AS=0.057p
+ AD=0.102p PS=0.68u PD=1.28u rfmode=0
* device instance $2173 m0 *1 1147.48,1299.995 sg13_lv_nmos
M$2173 \$I475237 \$3.c2p VSS \$1 sg13_lv_nmos L=0.13u W=2.75u AS=0.935p
+ AD=0.935p PS=6.18u PD=6.18u rfmode=0
* device instance $2174 m0 *1 1149.81,1303.68 sg13_hv_nmos
M$2174 VSS \$I475236 \$I475123 \$1 sg13_hv_nmos L=0.45u W=1.9u AS=0.646p
+ AD=0.646p PS=4.48u PD=4.48u rfmode=0
* device instance $2175 m0 *1 1147.64,1303.68 sg13_hv_nmos
M$2175 \$I475235 \$3.c2p VSS \$1 sg13_hv_nmos L=0.45u W=1.9u AS=0.646p
+ AD=0.361p PS=4.48u PD=2.28u rfmode=0
* device instance $2176 m0 *1 1148.47,1303.68 sg13_hv_nmos
M$2176 VSS \$I475237 \$I475236 \$1 sg13_hv_nmos L=0.45u W=1.9u AS=0.361p
+ AD=0.646p PS=2.28u PD=4.48u rfmode=0
* device instance $2177 m0 *1 1147.48,1295.005 sg13_lv_pmos
M$2177 \$I475237 \$3.c2p VDD VDD sg13_lv_pmos L=0.13u W=4.75u AS=1.615p
+ AD=1.615p PS=10.18u PD=10.18u rfmode=0
* device instance $2178 m0 *1 1149.81,1307.82 sg13_hv_pmos
M$2178 IOVDD \$I475236 \$I475123 IOVDD sg13_hv_pmos L=0.45u W=3.9u AS=1.326p
+ AD=1.326p PS=8.48u PD=8.48u rfmode=0
* device instance $2179 m0 *1 1147.64,1307.82 sg13_hv_pmos
M$2179 \$I475235 \$I475236 IOVDD IOVDD sg13_hv_pmos L=0.45u W=0.3u AS=0.102p
+ AD=0.057p PS=1.28u PD=0.68u rfmode=0
* device instance $2180 m0 *1 1148.47,1307.82 sg13_hv_pmos
M$2180 IOVDD \$I475235 \$I475236 IOVDD sg13_hv_pmos L=0.45u W=0.3u AS=0.057p
+ AD=0.102p PS=0.68u PD=1.28u rfmode=0
* device instance $2182 m0 *1 1150.99,1299.995 sg13_lv_nmos
M$2182 \$I475240 \$3.c2p VSS \$1 sg13_lv_nmos L=0.13u W=2.75u AS=0.935p
+ AD=0.935p PS=6.18u PD=6.18u rfmode=0
* device instance $2183 m0 *1 1153.32,1303.68 sg13_hv_nmos
M$2183 VSS \$I475239 \$I475124 \$1 sg13_hv_nmos L=0.45u W=1.9u AS=0.646p
+ AD=0.646p PS=4.48u PD=4.48u rfmode=0
* device instance $2184 m0 *1 1151.15,1303.68 sg13_hv_nmos
M$2184 \$I475238 \$3.c2p VSS \$1 sg13_hv_nmos L=0.45u W=1.9u AS=0.646p
+ AD=0.361p PS=4.48u PD=2.28u rfmode=0
* device instance $2185 m0 *1 1151.98,1303.68 sg13_hv_nmos
M$2185 VSS \$I475240 \$I475239 \$1 sg13_hv_nmos L=0.45u W=1.9u AS=0.361p
+ AD=0.646p PS=2.28u PD=4.48u rfmode=0
* device instance $2186 m0 *1 1150.99,1295.005 sg13_lv_pmos
M$2186 \$I475240 \$3.c2p VDD VDD sg13_lv_pmos L=0.13u W=4.75u AS=1.615p
+ AD=1.615p PS=10.18u PD=10.18u rfmode=0
* device instance $2187 m0 *1 1153.32,1307.82 sg13_hv_pmos
M$2187 IOVDD \$I475239 \$I475124 IOVDD sg13_hv_pmos L=0.45u W=3.9u AS=1.326p
+ AD=1.326p PS=8.48u PD=8.48u rfmode=0
* device instance $2188 m0 *1 1151.15,1307.82 sg13_hv_pmos
M$2188 \$I475238 \$I475239 IOVDD IOVDD sg13_hv_pmos L=0.45u W=0.3u AS=0.102p
+ AD=0.057p PS=1.28u PD=0.68u rfmode=0
* device instance $2189 m0 *1 1151.98,1307.82 sg13_hv_pmos
M$2189 IOVDD \$I475238 \$I475239 IOVDD sg13_hv_pmos L=0.45u W=0.3u AS=0.057p
+ AD=0.102p PS=0.68u PD=1.28u rfmode=0
* device instance $2191 r90 *1 1299.995,1147.48 sg13_lv_nmos
M$2191 \$I475243 \$70812.c2p VSS \$1 sg13_lv_nmos L=0.13u W=2.75u AS=0.935p
+ AD=0.935p PS=6.18u PD=6.18u rfmode=0
* device instance $2192 r90 *1 1303.68,1149.81 sg13_hv_nmos
M$2192 VSS \$I475242 \$I475126 \$1 sg13_hv_nmos L=0.45u W=1.9u AS=0.646p
+ AD=0.646p PS=4.48u PD=4.48u rfmode=0
* device instance $2193 r90 *1 1303.68,1147.64 sg13_hv_nmos
M$2193 \$I475241 \$70812.c2p VSS \$1 sg13_hv_nmos L=0.45u W=1.9u AS=0.646p
+ AD=0.361p PS=4.48u PD=2.28u rfmode=0
* device instance $2194 r90 *1 1303.68,1148.47 sg13_hv_nmos
M$2194 VSS \$I475243 \$I475242 \$1 sg13_hv_nmos L=0.45u W=1.9u AS=0.361p
+ AD=0.646p PS=2.28u PD=4.48u rfmode=0
* device instance $2195 r90 *1 1295.005,1147.48 sg13_lv_pmos
M$2195 \$I475243 \$70812.c2p VDD VDD sg13_lv_pmos L=0.13u W=4.75u AS=1.615p
+ AD=1.615p PS=10.18u PD=10.18u rfmode=0
* device instance $2196 r90 *1 1307.82,1149.81 sg13_hv_pmos
M$2196 IOVDD \$I475242 \$I475126 IOVDD sg13_hv_pmos L=0.45u W=3.9u AS=1.326p
+ AD=1.326p PS=8.48u PD=8.48u rfmode=0
* device instance $2197 r90 *1 1307.82,1147.64 sg13_hv_pmos
M$2197 \$I475241 \$I475242 IOVDD IOVDD sg13_hv_pmos L=0.45u W=0.3u AS=0.102p
+ AD=0.057p PS=1.28u PD=0.68u rfmode=0
* device instance $2198 r90 *1 1307.82,1148.47 sg13_hv_pmos
M$2198 IOVDD \$I475241 \$I475242 IOVDD sg13_hv_pmos L=0.45u W=0.3u AS=0.057p
+ AD=0.102p PS=0.68u PD=1.28u rfmode=0
* device instance $2200 r90 *1 1299.995,1150.99 sg13_lv_nmos
M$2200 \$I475246 \$70812.c2p VSS \$1 sg13_lv_nmos L=0.13u W=2.75u AS=0.935p
+ AD=0.935p PS=6.18u PD=6.18u rfmode=0
* device instance $2201 r90 *1 1303.68,1153.32 sg13_hv_nmos
M$2201 VSS \$I475245 \$I475127 \$1 sg13_hv_nmos L=0.45u W=1.9u AS=0.646p
+ AD=0.646p PS=4.48u PD=4.48u rfmode=0
* device instance $2202 r90 *1 1303.68,1151.15 sg13_hv_nmos
M$2202 \$I475244 \$70812.c2p VSS \$1 sg13_hv_nmos L=0.45u W=1.9u AS=0.646p
+ AD=0.361p PS=4.48u PD=2.28u rfmode=0
* device instance $2203 r90 *1 1303.68,1151.98 sg13_hv_nmos
M$2203 VSS \$I475246 \$I475245 \$1 sg13_hv_nmos L=0.45u W=1.9u AS=0.361p
+ AD=0.646p PS=2.28u PD=4.48u rfmode=0
* device instance $2204 r90 *1 1295.005,1150.99 sg13_lv_pmos
M$2204 \$I475246 \$70812.c2p VDD VDD sg13_lv_pmos L=0.13u W=4.75u AS=1.615p
+ AD=1.615p PS=10.18u PD=10.18u rfmode=0
* device instance $2205 r90 *1 1307.82,1153.32 sg13_hv_pmos
M$2205 IOVDD \$I475245 \$I475127 IOVDD sg13_hv_pmos L=0.45u W=3.9u AS=1.326p
+ AD=1.326p PS=8.48u PD=8.48u rfmode=0
* device instance $2206 r90 *1 1307.82,1151.15 sg13_hv_pmos
M$2206 \$I475244 \$I475245 IOVDD IOVDD sg13_hv_pmos L=0.45u W=0.3u AS=0.102p
+ AD=0.057p PS=1.28u PD=0.68u rfmode=0
* device instance $2207 r90 *1 1307.82,1151.98 sg13_hv_pmos
M$2207 IOVDD \$I475244 \$I475245 IOVDD sg13_hv_pmos L=0.45u W=0.3u AS=0.057p
+ AD=0.102p PS=0.68u PD=1.28u rfmode=0
* device instance $2209 m45 *1 283.54,595.225 dantenna
D$2209 \$1 \$I475203 dantenna A=1.984p P=7.48u m=1
* device instance $2210 m45 *1 288.51,593.055 dpantenna
D$2210 \$I475203 IOVDD dpantenna A=3.1872p P=11.24u m=1
* device instance $2211 m45 *1 282.535,590.68 rppd
R$2211 EN_STO_IN \$I475203 \$1 rppd w=1u l=2u ps=0u b=0 m=1
* device instance $2214 m0 *1 875.225,1316.46 dantenna
D$2214 \$1 \$I475207 dantenna A=1.984p P=7.48u m=1
* device instance $2215 m0 *1 873.055,1311.49 dpantenna
D$2215 \$I475207 IOVDD dpantenna A=3.1872p P=11.24u m=1
* device instance $2216 m0 *1 870.68,1317.465 rppd
R$2216 CS_N \$I475207 \$1 rppd w=1u l=2u ps=0u b=0 m=1
* device instance $2219 m0 *1 1015.225,1316.46 dantenna
D$2219 \$1 \$I475211 dantenna A=1.984p P=7.48u m=1
* device instance $2220 m0 *1 1013.055,1311.49 dpantenna
D$2220 \$I475211 IOVDD dpantenna A=3.1872p P=11.24u m=1
* device instance $2221 m0 *1 1010.68,1317.465 rppd
R$2221 MA_SCLK \$I475211 \$1 rppd w=1u l=2u ps=0u b=0 m=1
* device instance $2224 m45 *1 283.54,455.225 dantenna
D$2224 \$1 \$I475215 dantenna A=1.984p P=7.48u m=1
* device instance $2225 m45 *1 288.51,453.055 dpantenna
D$2225 \$I475215 IOVDD dpantenna A=3.1872p P=11.24u m=1
* device instance $2226 m45 *1 282.535,450.68 rppd
R$2226 SDI \$I475215 \$1 rppd w=1u l=2u ps=0u b=0 m=1
.ENDS r1_padring
