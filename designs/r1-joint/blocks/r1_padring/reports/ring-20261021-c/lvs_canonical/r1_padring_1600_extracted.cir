* Extracted by KLayout with SG13G2 LVS runset on : 21/10/2026 03:36

* cell r1_padring
* pin $1.c2p
* pin $10.padres
* pin $11.padres
* pin $110239.padres
* pin $12.p2c
* pin $13.p2c
* pin $14.p2c
* pin $143822.c2p
* pin $2.c2p
* pin $3.c2p
* pin $4.padres
* pin $462636.p2c
* pin $5.padres
* pin $6.padres
* pin $7.padres
* pin $70812.c2p
* pin $8.padres
* pin $9.padres
* pin COS_N
* pin COS_P
* pin CS_N
* pin EN_STO_IN
* pin FAULT_N
* pin GATE_A
* pin GATE_B
* pin GATE_C
* pin IOVDD
* pin IOVSS
* pin ISA_N
* pin ISA_P
* pin ISB_N
* pin ISB_P
* pin MA_SCLK
* pin SDI
* pin SIN_N
* pin SIN_P
* pin SLO_SDO
* pin VDD
* pin VDDA
* pin VSS
.SUBCKT r1_padring \$1.c2p \$10.padres \$11.padres \$110239.padres \$12.p2c
+ \$13.p2c \$14.p2c \$143822.c2p \$2.c2p \$3.c2p \$4.padres \$462636.p2c
+ \$5.padres \$6.padres \$7.padres \$70812.c2p \$8.padres \$9.padres COS_N
+ COS_P CS_N EN_STO_IN FAULT_N GATE_A GATE_B GATE_C IOVDD IOVSS ISA_N ISA_P
+ ISB_N ISB_P MA_SCLK SDI SIN_N SIN_P SLO_SDO VDD VDDA VSS
* cell instance $462644 r0 *1 410,147
X$462644 \$1 IOVSS VDD VDD VDD VDD VDD VDD VDD VDD VDD VDD VDD VDD VDD VDD VDD
+ VDD VDD VDD VDD VDD VDD VDD \$I475104 sg13g2_Clamp_N43N43D4R
* cell instance $462646 m90 *1 490,206
X$462646 \$1 IOVSS \$I475103 \$I475104 VDD sg13g2_RCClampInverter
* cell instance $462647 r90 *1 981.92,148.66
X$462647 \$1 IOVSS VSS VSS sg13g2_DCNDiode
* cell instance $462648 r90 *1 981.92,207.66
X$462648 \$1 IOVSS IOVDD VSS VSS sg13g2_DCPDiode
* cell instance $462649 r90 *1 561.92,148.66
X$462649 \$1 IOVSS VSS VSS sg13g2_DCNDiode
* cell instance $462650 r90 *1 561.92,207.66
X$462650 \$1 IOVSS IOVDD VSS VSS sg13g2_DCPDiode
* cell instance $462652 m0 *1 690,1394
X$462652 \$1 IOVSS IOVDD GATE_C GATE_C GATE_C GATE_C GATE_C GATE_C GATE_C
+ GATE_C \$I475106 sg13g2_Clamp_P15N15D
* cell instance $462654 m0 *1 690,1453
X$462654 \$1 IOVSS GATE_C GATE_C GATE_C GATE_C GATE_C GATE_C GATE_C GATE_C
+ \$I475105 sg13g2_Clamp_N15N15D
* cell instance $462655 m0 *1 726.97,1291
X$462655 IOVDD VDD VSS \$I475106 \$I475105 \$1.c2p \$1 sg13g2_GateLevelUpInv
* cell instance $462657 m0 *1 550,1394
X$462657 \$1 IOVSS IOVDD GATE_B GATE_B GATE_B GATE_B GATE_B GATE_B GATE_B
+ GATE_B \$I475109 sg13g2_Clamp_P15N15D
* cell instance $462659 m0 *1 550,1453
X$462659 \$1 IOVSS GATE_B GATE_B GATE_B GATE_B GATE_B GATE_B GATE_B GATE_B
+ \$I475108 sg13g2_Clamp_N15N15D
* cell instance $462660 m0 *1 586.97,1291
X$462660 IOVDD VDD VSS \$I475109 \$I475108 \$2.c2p \$1 sg13g2_GateLevelUpInv
* cell instance $462662 m0 *1 410,1394
X$462662 \$1 IOVSS IOVDD GATE_A GATE_A GATE_A GATE_A GATE_A GATE_A GATE_A
+ GATE_A \$I475112 sg13g2_Clamp_P15N15D
* cell instance $462664 m0 *1 410,1453
X$462664 \$1 IOVSS GATE_A GATE_A GATE_A GATE_A GATE_A GATE_A GATE_A GATE_A
+ \$I475111 sg13g2_Clamp_N15N15D
* cell instance $462665 m0 *1 446.97,1291
X$462665 IOVDD VDD VSS \$I475112 \$I475111 \$143822.c2p \$1
+ sg13g2_GateLevelUpInv
* cell instance $462667 m45 *1 206,970
X$462667 \$1 IOVSS IOVDD COS_P COS_P COS_P COS_P COS_P COS_P COS_P COS_P COS_P
+ COS_P sg13g2_Clamp_P20N0D
* cell instance $462669 m45 *1 147,970
X$462669 \$1 IOVSS COS_P COS_P COS_P COS_P COS_P COS_P COS_P COS_P COS_P COS_P
+ sg13g2_Clamp_N20N0D
* cell instance $462672 m45 *1 206,830
X$462672 \$1 IOVSS IOVDD SIN_N SIN_N SIN_N SIN_N SIN_N SIN_N SIN_N SIN_N SIN_N
+ SIN_N sg13g2_Clamp_P20N0D
* cell instance $462674 m45 *1 147,830
X$462674 \$1 IOVSS SIN_N SIN_N SIN_N SIN_N SIN_N SIN_N SIN_N SIN_N SIN_N SIN_N
+ sg13g2_Clamp_N20N0D
* cell instance $462677 m45 *1 206,1110
X$462677 \$1 IOVSS IOVDD COS_N COS_N COS_N COS_N COS_N COS_N COS_N COS_N COS_N
+ COS_N sg13g2_Clamp_P20N0D
* cell instance $462679 m45 *1 147,1110
X$462679 \$1 IOVSS COS_N COS_N COS_N COS_N COS_N COS_N COS_N COS_N COS_N COS_N
+ sg13g2_Clamp_N20N0D
* cell instance $462682 m45 *1 206,690
X$462682 \$1 IOVSS IOVDD SIN_P SIN_P SIN_P SIN_P SIN_P SIN_P SIN_P SIN_P SIN_P
+ SIN_P sg13g2_Clamp_P20N0D
* cell instance $462684 m45 *1 147,690
X$462684 \$1 IOVSS SIN_P SIN_P SIN_P SIN_P SIN_P SIN_P SIN_P SIN_P SIN_P SIN_P
+ sg13g2_Clamp_N20N0D
* cell instance $462687 r90 *1 1394,970
X$462687 \$1 IOVSS IOVDD ISB_N ISB_N ISB_N ISB_N ISB_N ISB_N ISB_N ISB_N ISB_N
+ ISB_N sg13g2_Clamp_P20N0D
* cell instance $462689 r90 *1 1453,970
X$462689 \$1 IOVSS ISB_N ISB_N ISB_N ISB_N ISB_N ISB_N ISB_N ISB_N ISB_N ISB_N
+ sg13g2_Clamp_N20N0D
* cell instance $462692 r90 *1 1394,830
X$462692 \$1 IOVSS IOVDD ISB_P ISB_P ISB_P ISB_P ISB_P ISB_P ISB_P ISB_P ISB_P
+ ISB_P sg13g2_Clamp_P20N0D
* cell instance $462694 r90 *1 1453,830
X$462694 \$1 IOVSS ISB_P ISB_P ISB_P ISB_P ISB_P ISB_P ISB_P ISB_P ISB_P ISB_P
+ sg13g2_Clamp_N20N0D
* cell instance $462697 r90 *1 1394,550
X$462697 \$1 IOVSS IOVDD ISA_P ISA_P ISA_P ISA_P ISA_P ISA_P ISA_P ISA_P ISA_P
+ ISA_P sg13g2_Clamp_P20N0D
* cell instance $462699 r90 *1 1453,550
X$462699 \$1 IOVSS ISA_P ISA_P ISA_P ISA_P ISA_P ISA_P ISA_P ISA_P ISA_P ISA_P
+ sg13g2_Clamp_N20N0D
* cell instance $462702 r90 *1 1394,690
X$462702 \$1 IOVSS IOVDD ISA_N ISA_N ISA_N ISA_N ISA_N ISA_N ISA_N ISA_N ISA_N
+ ISA_N sg13g2_Clamp_P20N0D
* cell instance $462704 r90 *1 1453,690
X$462704 \$1 IOVSS ISA_N ISA_N ISA_N ISA_N ISA_N ISA_N ISA_N ISA_N ISA_N ISA_N
+ sg13g2_Clamp_N20N0D
* cell instance $462707 r90 *1 1394,410
X$462707 \$1 IOVSS IOVDD VDDA VDDA VDDA VDDA VDDA VDDA VDDA VDDA VDDA VDDA
+ sg13g2_Clamp_P20N0D
* cell instance $462709 r90 *1 1453,410
X$462709 \$1 IOVSS VDDA VDDA VDDA VDDA VDDA VDDA VDDA VDDA VDDA VDDA
+ sg13g2_Clamp_N20N0D
* cell instance $462712 m0 *1 1110,1394
X$462712 \$1 IOVSS IOVDD SLO_SDO \$I475124 sg13g2_Clamp_P2N2D
* cell instance $462714 m0 *1 1110,1453
X$462714 \$1 IOVSS \$I475123 SLO_SDO sg13g2_Clamp_N2N2D
* cell instance $462717 r90 *1 1394,1110
X$462717 \$1 IOVSS IOVDD FAULT_N \$I475127 sg13g2_Clamp_P2N2D
* cell instance $462719 r90 *1 1453,1110
X$462719 \$1 IOVSS \$I475126 FAULT_N sg13g2_Clamp_N2N2D
* cell instance $462722 m45 *1 289.5,589.745
X$462722 \$1 IOVSS EN_STO_IN IOVDD VSS \$12.p2c VDD g1_LevelDown_polyres
* cell instance $462725 m0 *1 869.745,1310.5
X$462725 \$1 IOVSS CS_N IOVDD VSS \$13.p2c VDD g1_LevelDown_polyres
* cell instance $462728 m0 *1 1009.745,1310.5
X$462728 \$1 IOVSS MA_SCLK IOVDD VSS \$14.p2c VDD g1_LevelDown_polyres
* cell instance $462731 m45 *1 289.5,449.745
X$462731 \$1 IOVSS SDI IOVDD VSS \$462636.p2c VDD g1_LevelDown_polyres
* device instance $1 r0 *1 1150,243.585 ptap1
R$1 IOVSS \$1 ptap1 A=286719.0073p P=58925.768u
* device instance $2 r0 *1 1150,298 ptap1
R$2 VSS \$1 ptap1 A=1188.6876p P=8009.976u
* device instance $597 r90 *1 1114.54,224.19 dpantenna
D$597 IOVSS IOVDD dpantenna A=35.0028p P=58.08u m=4
* device instance $603 r90 *1 1114.54,165.19 dantenna
D$603 \$1 IOVSS dantenna A=35.0028p P=58.08u m=4
* device instance $634 m0 *1 750.12,198.715 rppd
R$634 \$I475101 IOVDD \$1 rppd w=1u l=520u ps=0u b=0 m=1
* device instance $635 r0 *1 698.155,151.95 sg13_hv_nmos
M$635 IOVSS \$I475102 IOVDD \$1 sg13_hv_nmos L=0.6u W=756.8u AS=344.608p
+ AD=349.36p PS=931.04u PD=933.2u rfmode=0
* device instance $807 r0 *1 694.77,167.98 dantenna
D$807 \$1 \$I475102 dantenna A=0.2304p P=1.92u m=1
* device instance $809 m90 *1 762.28,221.79 sg13_hv_nmos
M$809 IOVSS \$I475101 IOVSS \$1 sg13_hv_nmos L=9.5u W=126u AS=26.64p AD=23.94p
+ PS=149.92u PD=131.32u rfmode=0
* device instance $816 m90 *1 697.62,221.79 sg13_hv_nmos
M$816 IOVSS \$I475101 \$I475102 \$1 sg13_hv_nmos L=0.5u W=108u AS=20.52p
+ AD=23.22p PS=112.56u PD=131.16u rfmode=0
* device instance $835 m90 *1 751.56,235.91 sg13_hv_pmos
M$835 IOVDD \$I475101 \$I475102 IOVDD sg13_hv_pmos L=0.5u W=350u AS=67.55p
+ AD=67.55p PS=376.3u PD=376.3u rfmode=0
* device instance $911 m0 *1 470.12,198.715 rppd
R$911 \$I475103 VDD \$1 rppd w=1u l=520u ps=0u b=0 m=1
* device instance $912 m0 *1 730,1398.54 dpantenna
D$912 GATE_C IOVDD dpantenna A=35.0028p P=58.08u m=2
* device instance $915 m0 *1 590,1398.54 dpantenna
D$915 GATE_B IOVDD dpantenna A=35.0028p P=58.08u m=2
* device instance $918 m0 *1 450,1398.54 dpantenna
D$918 GATE_A IOVDD dpantenna A=35.0028p P=58.08u m=2
* device instance $921 m0 *1 730,1434.06 dantenna
D$921 \$1 GATE_C dantenna A=35.0028p P=58.08u m=2
* device instance $924 m0 *1 590,1434.06 dantenna
D$924 \$1 GATE_B dantenna A=35.0028p P=58.08u m=2
* device instance $927 m0 *1 450,1434.06 dantenna
D$927 \$1 GATE_A dantenna A=35.0028p P=58.08u m=2
* device instance $930 m45 *1 283.54,1027.63 dantenna
D$930 \$1 \$4.padres dantenna A=1.984p P=7.48u m=1
* device instance $931 m45 *1 288.51,1025.46 dpantenna
D$931 \$4.padres IOVDD dpantenna A=3.1872p P=11.24u m=1
* device instance $932 m45 *1 282.535,1023.085 rppd
R$932 COS_P \$4.padres \$1 rppd w=1u l=2u ps=0u b=0 m=1
* device instance $935 m45 *1 283.54,887.63 dantenna
D$935 \$1 \$5.padres dantenna A=1.984p P=7.48u m=1
* device instance $936 m45 *1 288.51,885.46 dpantenna
D$936 \$5.padres IOVDD dpantenna A=3.1872p P=11.24u m=1
* device instance $937 m45 *1 282.535,883.085 rppd
R$937 SIN_N \$5.padres \$1 rppd w=1u l=2u ps=0u b=0 m=1
* device instance $940 m45 *1 283.54,1167.63 dantenna
D$940 \$1 \$6.padres dantenna A=1.984p P=7.48u m=1
* device instance $941 m45 *1 288.51,1165.46 dpantenna
D$941 \$6.padres IOVDD dpantenna A=3.1872p P=11.24u m=1
* device instance $942 m45 *1 282.535,1163.085 rppd
R$942 COS_N \$6.padres \$1 rppd w=1u l=2u ps=0u b=0 m=1
* device instance $945 m45 *1 283.54,747.63 dantenna
D$945 \$1 \$7.padres dantenna A=1.984p P=7.48u m=1
* device instance $946 m45 *1 288.51,745.46 dpantenna
D$946 \$7.padres IOVDD dpantenna A=3.1872p P=11.24u m=1
* device instance $947 m45 *1 282.535,743.085 rppd
R$947 SIN_P \$7.padres \$1 rppd w=1u l=2u ps=0u b=0 m=1
* device instance $950 r90 *1 1316.46,1027.63 dantenna
D$950 \$1 \$8.padres dantenna A=1.984p P=7.48u m=1
* device instance $951 r90 *1 1311.49,1025.46 dpantenna
D$951 \$8.padres IOVDD dpantenna A=3.1872p P=11.24u m=1
* device instance $952 r90 *1 1317.465,1023.085 rppd
R$952 ISB_N \$8.padres \$1 rppd w=1u l=2u ps=0u b=0 m=1
* device instance $955 r90 *1 1316.46,887.63 dantenna
D$955 \$1 \$9.padres dantenna A=1.984p P=7.48u m=1
* device instance $956 r90 *1 1311.49,885.46 dpantenna
D$956 \$9.padres IOVDD dpantenna A=3.1872p P=11.24u m=1
* device instance $957 r90 *1 1317.465,883.085 rppd
R$957 ISB_P \$9.padres \$1 rppd w=1u l=2u ps=0u b=0 m=1
* device instance $960 r90 *1 1316.46,607.63 dantenna
D$960 \$1 \$10.padres dantenna A=1.984p P=7.48u m=1
* device instance $961 r90 *1 1311.49,605.46 dpantenna
D$961 \$10.padres IOVDD dpantenna A=3.1872p P=11.24u m=1
* device instance $962 r90 *1 1317.465,603.085 rppd
R$962 ISA_P \$10.padres \$1 rppd w=1u l=2u ps=0u b=0 m=1
* device instance $965 r90 *1 1316.46,747.63 dantenna
D$965 \$1 \$11.padres dantenna A=1.984p P=7.48u m=1
* device instance $966 r90 *1 1311.49,745.46 dpantenna
D$966 \$11.padres IOVDD dpantenna A=3.1872p P=11.24u m=1
* device instance $967 r90 *1 1317.465,743.085 rppd
R$967 ISA_N \$11.padres \$1 rppd w=1u l=2u ps=0u b=0 m=1
* device instance $970 r90 *1 1316.46,467.63 dantenna
D$970 \$1 \$110239.padres dantenna A=1.984p P=7.48u m=1
* device instance $971 r90 *1 1311.49,465.46 dpantenna
D$971 \$110239.padres IOVDD dpantenna A=3.1872p P=11.24u m=1
* device instance $972 r90 *1 1317.465,463.085 rppd
R$972 VDDA \$110239.padres \$1 rppd w=1u l=2u ps=0u b=0 m=1
* device instance $975 m45 *1 201.46,1010 dpantenna
D$975 COS_P IOVDD dpantenna A=35.0028p P=58.08u m=2
* device instance $978 m45 *1 201.46,870 dpantenna
D$978 SIN_N IOVDD dpantenna A=35.0028p P=58.08u m=2
* device instance $981 m45 *1 201.46,1150 dpantenna
D$981 COS_N IOVDD dpantenna A=35.0028p P=58.08u m=2
* device instance $984 m45 *1 201.46,730 dpantenna
D$984 SIN_P IOVDD dpantenna A=35.0028p P=58.08u m=2
* device instance $987 r90 *1 1398.54,1010 dpantenna
D$987 ISB_N IOVDD dpantenna A=35.0028p P=58.08u m=2
* device instance $990 r90 *1 1398.54,870 dpantenna
D$990 ISB_P IOVDD dpantenna A=35.0028p P=58.08u m=2
* device instance $993 r90 *1 1398.54,590 dpantenna
D$993 ISA_P IOVDD dpantenna A=35.0028p P=58.08u m=2
* device instance $996 r90 *1 1398.54,730 dpantenna
D$996 ISA_N IOVDD dpantenna A=35.0028p P=58.08u m=2
* device instance $999 r90 *1 1398.54,450 dpantenna
D$999 VDDA IOVDD dpantenna A=35.0028p P=58.08u m=2
* device instance $1002 m45 *1 165.94,1010 dantenna
D$1002 \$1 COS_P dantenna A=35.0028p P=58.08u m=2
* device instance $1005 m45 *1 165.94,870 dantenna
D$1005 \$1 SIN_N dantenna A=35.0028p P=58.08u m=2
* device instance $1008 m45 *1 165.94,1150 dantenna
D$1008 \$1 COS_N dantenna A=35.0028p P=58.08u m=2
* device instance $1011 m45 *1 165.94,730 dantenna
D$1011 \$1 SIN_P dantenna A=35.0028p P=58.08u m=2
* device instance $1014 r90 *1 1434.06,1010 dantenna
D$1014 \$1 ISB_N dantenna A=35.0028p P=58.08u m=2
* device instance $1017 r90 *1 1434.06,870 dantenna
D$1017 \$1 ISB_P dantenna A=35.0028p P=58.08u m=2
* device instance $1020 r90 *1 1434.06,590 dantenna
D$1020 \$1 ISA_P dantenna A=35.0028p P=58.08u m=2
* device instance $1023 r90 *1 1434.06,730 dantenna
D$1023 \$1 ISA_N dantenna A=35.0028p P=58.08u m=2
* device instance $1026 r90 *1 1434.06,450 dantenna
D$1026 \$1 VDDA dantenna A=35.0028p P=58.08u m=2
* device instance $1029 m0 *1 1150,1398.54 dpantenna
D$1029 SLO_SDO IOVDD dpantenna A=35.0028p P=58.08u m=2
* device instance $1032 r90 *1 1398.54,1150 dpantenna
D$1032 FAULT_N IOVDD dpantenna A=35.0028p P=58.08u m=2
* device instance $1035 m0 *1 1150,1434.06 dantenna
D$1035 \$1 SLO_SDO dantenna A=35.0028p P=58.08u m=2
* device instance $1038 r90 *1 1434.06,1150 dantenna
D$1038 \$1 FAULT_N dantenna A=35.0028p P=58.08u m=2
* device instance $1041 m0 *1 224.19,554.54 dpantenna
D$1041 EN_STO_IN IOVDD dpantenna A=35.0028p P=58.08u m=2
* device instance $1044 m135 *1 834.54,1375.81 dpantenna
D$1044 CS_N IOVDD dpantenna A=35.0028p P=58.08u m=2
* device instance $1047 m135 *1 974.54,1375.81 dpantenna
D$1047 MA_SCLK IOVDD dpantenna A=35.0028p P=58.08u m=2
* device instance $1050 m0 *1 224.19,414.54 dpantenna
D$1050 SDI IOVDD dpantenna A=35.0028p P=58.08u m=2
* device instance $1053 m0 *1 165.19,554.54 dantenna
D$1053 \$1 EN_STO_IN dantenna A=35.0028p P=58.08u m=2
* device instance $1056 m135 *1 834.54,1434.81 dantenna
D$1056 \$1 CS_N dantenna A=35.0028p P=58.08u m=2
* device instance $1059 m135 *1 974.54,1434.81 dantenna
D$1059 \$1 MA_SCLK dantenna A=35.0028p P=58.08u m=2
* device instance $1062 m0 *1 165.19,414.54 dantenna
D$1062 \$1 SDI dantenna A=35.0028p P=58.08u m=2
* device instance $1065 m0 *1 1147.48,1299.995 sg13_lv_nmos
M$1065 \$I475185 \$3.c2p VSS \$1 sg13_lv_nmos L=0.13u W=2.75u AS=0.935p
+ AD=0.935p PS=6.18u PD=6.18u rfmode=0
* device instance $1066 m0 *1 1149.81,1303.68 sg13_hv_nmos
M$1066 VSS \$I475184 \$I475123 \$1 sg13_hv_nmos L=0.45u W=1.9u AS=0.646p
+ AD=0.646p PS=4.48u PD=4.48u rfmode=0
* device instance $1067 m0 *1 1147.64,1303.68 sg13_hv_nmos
M$1067 \$I475183 \$3.c2p VSS \$1 sg13_hv_nmos L=0.45u W=1.9u AS=0.646p
+ AD=0.361p PS=4.48u PD=2.28u rfmode=0
* device instance $1068 m0 *1 1148.47,1303.68 sg13_hv_nmos
M$1068 VSS \$I475185 \$I475184 \$1 sg13_hv_nmos L=0.45u W=1.9u AS=0.361p
+ AD=0.646p PS=2.28u PD=4.48u rfmode=0
* device instance $1069 m0 *1 1147.48,1295.005 sg13_lv_pmos
M$1069 \$I475185 \$3.c2p VDD VDD sg13_lv_pmos L=0.13u W=4.75u AS=1.615p
+ AD=1.615p PS=10.18u PD=10.18u rfmode=0
* device instance $1070 m0 *1 1149.81,1307.82 sg13_hv_pmos
M$1070 IOVDD \$I475184 \$I475123 IOVDD sg13_hv_pmos L=0.45u W=3.9u AS=1.326p
+ AD=1.326p PS=8.48u PD=8.48u rfmode=0
* device instance $1071 m0 *1 1147.64,1307.82 sg13_hv_pmos
M$1071 \$I475183 \$I475184 IOVDD IOVDD sg13_hv_pmos L=0.45u W=0.3u AS=0.102p
+ AD=0.057p PS=1.28u PD=0.68u rfmode=0
* device instance $1072 m0 *1 1148.47,1307.82 sg13_hv_pmos
M$1072 IOVDD \$I475183 \$I475184 IOVDD sg13_hv_pmos L=0.45u W=0.3u AS=0.057p
+ AD=0.102p PS=0.68u PD=1.28u rfmode=0
* device instance $1074 m0 *1 1150.99,1299.995 sg13_lv_nmos
M$1074 \$I475188 \$3.c2p VSS \$1 sg13_lv_nmos L=0.13u W=2.75u AS=0.935p
+ AD=0.935p PS=6.18u PD=6.18u rfmode=0
* device instance $1075 m0 *1 1153.32,1303.68 sg13_hv_nmos
M$1075 VSS \$I475187 \$I475124 \$1 sg13_hv_nmos L=0.45u W=1.9u AS=0.646p
+ AD=0.646p PS=4.48u PD=4.48u rfmode=0
* device instance $1076 m0 *1 1151.15,1303.68 sg13_hv_nmos
M$1076 \$I475186 \$3.c2p VSS \$1 sg13_hv_nmos L=0.45u W=1.9u AS=0.646p
+ AD=0.361p PS=4.48u PD=2.28u rfmode=0
* device instance $1077 m0 *1 1151.98,1303.68 sg13_hv_nmos
M$1077 VSS \$I475188 \$I475187 \$1 sg13_hv_nmos L=0.45u W=1.9u AS=0.361p
+ AD=0.646p PS=2.28u PD=4.48u rfmode=0
* device instance $1078 m0 *1 1150.99,1295.005 sg13_lv_pmos
M$1078 \$I475188 \$3.c2p VDD VDD sg13_lv_pmos L=0.13u W=4.75u AS=1.615p
+ AD=1.615p PS=10.18u PD=10.18u rfmode=0
* device instance $1079 m0 *1 1153.32,1307.82 sg13_hv_pmos
M$1079 IOVDD \$I475187 \$I475124 IOVDD sg13_hv_pmos L=0.45u W=3.9u AS=1.326p
+ AD=1.326p PS=8.48u PD=8.48u rfmode=0
* device instance $1080 m0 *1 1151.15,1307.82 sg13_hv_pmos
M$1080 \$I475186 \$I475187 IOVDD IOVDD sg13_hv_pmos L=0.45u W=0.3u AS=0.102p
+ AD=0.057p PS=1.28u PD=0.68u rfmode=0
* device instance $1081 m0 *1 1151.98,1307.82 sg13_hv_pmos
M$1081 IOVDD \$I475186 \$I475187 IOVDD sg13_hv_pmos L=0.45u W=0.3u AS=0.057p
+ AD=0.102p PS=0.68u PD=1.28u rfmode=0
* device instance $1083 r90 *1 1299.995,1147.48 sg13_lv_nmos
M$1083 \$I475191 \$70812.c2p VSS \$1 sg13_lv_nmos L=0.13u W=2.75u AS=0.935p
+ AD=0.935p PS=6.18u PD=6.18u rfmode=0
* device instance $1084 r90 *1 1303.68,1149.81 sg13_hv_nmos
M$1084 VSS \$I475190 \$I475126 \$1 sg13_hv_nmos L=0.45u W=1.9u AS=0.646p
+ AD=0.646p PS=4.48u PD=4.48u rfmode=0
* device instance $1085 r90 *1 1303.68,1147.64 sg13_hv_nmos
M$1085 \$I475189 \$70812.c2p VSS \$1 sg13_hv_nmos L=0.45u W=1.9u AS=0.646p
+ AD=0.361p PS=4.48u PD=2.28u rfmode=0
* device instance $1086 r90 *1 1303.68,1148.47 sg13_hv_nmos
M$1086 VSS \$I475191 \$I475190 \$1 sg13_hv_nmos L=0.45u W=1.9u AS=0.361p
+ AD=0.646p PS=2.28u PD=4.48u rfmode=0
* device instance $1087 r90 *1 1295.005,1147.48 sg13_lv_pmos
M$1087 \$I475191 \$70812.c2p VDD VDD sg13_lv_pmos L=0.13u W=4.75u AS=1.615p
+ AD=1.615p PS=10.18u PD=10.18u rfmode=0
* device instance $1088 r90 *1 1307.82,1149.81 sg13_hv_pmos
M$1088 IOVDD \$I475190 \$I475126 IOVDD sg13_hv_pmos L=0.45u W=3.9u AS=1.326p
+ AD=1.326p PS=8.48u PD=8.48u rfmode=0
* device instance $1089 r90 *1 1307.82,1147.64 sg13_hv_pmos
M$1089 \$I475189 \$I475190 IOVDD IOVDD sg13_hv_pmos L=0.45u W=0.3u AS=0.102p
+ AD=0.057p PS=1.28u PD=0.68u rfmode=0
* device instance $1090 r90 *1 1307.82,1148.47 sg13_hv_pmos
M$1090 IOVDD \$I475189 \$I475190 IOVDD sg13_hv_pmos L=0.45u W=0.3u AS=0.057p
+ AD=0.102p PS=0.68u PD=1.28u rfmode=0
* device instance $1092 r90 *1 1299.995,1150.99 sg13_lv_nmos
M$1092 \$I475194 \$70812.c2p VSS \$1 sg13_lv_nmos L=0.13u W=2.75u AS=0.935p
+ AD=0.935p PS=6.18u PD=6.18u rfmode=0
* device instance $1093 r90 *1 1303.68,1153.32 sg13_hv_nmos
M$1093 VSS \$I475193 \$I475127 \$1 sg13_hv_nmos L=0.45u W=1.9u AS=0.646p
+ AD=0.646p PS=4.48u PD=4.48u rfmode=0
* device instance $1094 r90 *1 1303.68,1151.15 sg13_hv_nmos
M$1094 \$I475192 \$70812.c2p VSS \$1 sg13_hv_nmos L=0.45u W=1.9u AS=0.646p
+ AD=0.361p PS=4.48u PD=2.28u rfmode=0
* device instance $1095 r90 *1 1303.68,1151.98 sg13_hv_nmos
M$1095 VSS \$I475194 \$I475193 \$1 sg13_hv_nmos L=0.45u W=1.9u AS=0.361p
+ AD=0.646p PS=2.28u PD=4.48u rfmode=0
* device instance $1096 r90 *1 1295.005,1150.99 sg13_lv_pmos
M$1096 \$I475194 \$70812.c2p VDD VDD sg13_lv_pmos L=0.13u W=4.75u AS=1.615p
+ AD=1.615p PS=10.18u PD=10.18u rfmode=0
* device instance $1097 r90 *1 1307.82,1153.32 sg13_hv_pmos
M$1097 IOVDD \$I475193 \$I475127 IOVDD sg13_hv_pmos L=0.45u W=3.9u AS=1.326p
+ AD=1.326p PS=8.48u PD=8.48u rfmode=0
* device instance $1098 r90 *1 1307.82,1151.15 sg13_hv_pmos
M$1098 \$I475192 \$I475193 IOVDD IOVDD sg13_hv_pmos L=0.45u W=0.3u AS=0.102p
+ AD=0.057p PS=1.28u PD=0.68u rfmode=0
* device instance $1099 r90 *1 1307.82,1151.98 sg13_hv_pmos
M$1099 IOVDD \$I475192 \$I475193 IOVDD sg13_hv_pmos L=0.45u W=0.3u AS=0.057p
+ AD=0.102p PS=0.68u PD=1.28u rfmode=0
.ENDS r1_padring

* cell sg13g2_Clamp_N43N43D4R
* pin
* pin iovss
* pin pad
* pin pad
* pin pad
* pin pad
* pin pad
* pin pad
* pin pad
* pin pad
* pin pad
* pin pad
* pin pad
* pin pad
* pin pad
* pin pad
* pin pad
* pin pad
* pin pad
* pin pad
* pin pad
* pin pad
* pin pad
* pin pad
* pin gate
.SUBCKT sg13g2_Clamp_N43N43D4R \$2 iovss pad pad$1 pad$2 pad$3 pad$4 pad$5
+ pad$6 pad$7 pad$8 pad$9 pad$10 pad$11 pad$12 pad$13 pad$14 pad$15 pad$16
+ pad$17 pad$18 pad$19 pad$20 pad$21 gate
* device instance $1 r0 *1 8.155,4.95 sg13_hv_nmos
M$1 iovss gate pad \$2 sg13_hv_nmos L=0.6u W=35.2u AS=18.656p AD=16.016p
+ PS=61.28u PD=42.48u rfmode=0
* device instance $3 r0 *1 11.175,4.95 sg13_hv_nmos
M$3 iovss gate pad$1 \$2 sg13_hv_nmos L=0.6u W=35.2u AS=16.016p AD=16.016p
+ PS=42.48u PD=42.48u rfmode=0
* device instance $5 r0 *1 14.195,4.95 sg13_hv_nmos
M$5 iovss gate pad$2 \$2 sg13_hv_nmos L=0.6u W=35.2u AS=16.016p AD=16.016p
+ PS=42.48u PD=42.48u rfmode=0
* device instance $7 r0 *1 17.215,4.95 sg13_hv_nmos
M$7 iovss gate pad$3 \$2 sg13_hv_nmos L=0.6u W=35.2u AS=16.016p AD=16.016p
+ PS=42.48u PD=42.48u rfmode=0
* device instance $9 r0 *1 20.235,4.95 sg13_hv_nmos
M$9 iovss gate pad$4 \$2 sg13_hv_nmos L=0.6u W=35.2u AS=16.016p AD=16.016p
+ PS=42.48u PD=42.48u rfmode=0
* device instance $11 r0 *1 23.255,4.95 sg13_hv_nmos
M$11 iovss gate pad$5 \$2 sg13_hv_nmos L=0.6u W=35.2u AS=16.016p AD=16.016p
+ PS=42.48u PD=42.48u rfmode=0
* device instance $13 r0 *1 26.275,4.95 sg13_hv_nmos
M$13 iovss gate pad$6 \$2 sg13_hv_nmos L=0.6u W=35.2u AS=16.016p AD=16.016p
+ PS=42.48u PD=42.48u rfmode=0
* device instance $15 r0 *1 29.295,4.95 sg13_hv_nmos
M$15 iovss gate pad$7 \$2 sg13_hv_nmos L=0.6u W=35.2u AS=16.016p AD=16.016p
+ PS=42.48u PD=42.48u rfmode=0
* device instance $17 r0 *1 32.315,4.95 sg13_hv_nmos
M$17 iovss gate pad$8 \$2 sg13_hv_nmos L=0.6u W=35.2u AS=16.016p AD=16.016p
+ PS=42.48u PD=42.48u rfmode=0
* device instance $19 r0 *1 35.335,4.95 sg13_hv_nmos
M$19 iovss gate pad$9 \$2 sg13_hv_nmos L=0.6u W=35.2u AS=16.016p AD=16.016p
+ PS=42.48u PD=42.48u rfmode=0
* device instance $21 r0 *1 38.355,4.95 sg13_hv_nmos
M$21 iovss gate pad$10 \$2 sg13_hv_nmos L=0.6u W=35.2u AS=16.016p AD=16.016p
+ PS=42.48u PD=42.48u rfmode=0
* device instance $23 r0 *1 41.375,4.95 sg13_hv_nmos
M$23 iovss gate pad$11 \$2 sg13_hv_nmos L=0.6u W=35.2u AS=16.016p AD=16.016p
+ PS=42.48u PD=42.48u rfmode=0
* device instance $25 r0 *1 44.395,4.95 sg13_hv_nmos
M$25 iovss gate pad$12 \$2 sg13_hv_nmos L=0.6u W=35.2u AS=16.016p AD=16.016p
+ PS=42.48u PD=42.48u rfmode=0
* device instance $27 r0 *1 47.415,4.95 sg13_hv_nmos
M$27 iovss gate pad$13 \$2 sg13_hv_nmos L=0.6u W=35.2u AS=16.016p AD=16.016p
+ PS=42.48u PD=42.48u rfmode=0
* device instance $29 r0 *1 50.435,4.95 sg13_hv_nmos
M$29 iovss gate pad$14 \$2 sg13_hv_nmos L=0.6u W=35.2u AS=16.016p AD=16.016p
+ PS=42.48u PD=42.48u rfmode=0
* device instance $31 r0 *1 53.455,4.95 sg13_hv_nmos
M$31 iovss gate pad$15 \$2 sg13_hv_nmos L=0.6u W=35.2u AS=16.016p AD=16.016p
+ PS=42.48u PD=42.48u rfmode=0
* device instance $33 r0 *1 56.475,4.95 sg13_hv_nmos
M$33 iovss gate pad$16 \$2 sg13_hv_nmos L=0.6u W=35.2u AS=16.016p AD=16.016p
+ PS=42.48u PD=42.48u rfmode=0
* device instance $35 r0 *1 59.495,4.95 sg13_hv_nmos
M$35 iovss gate pad$17 \$2 sg13_hv_nmos L=0.6u W=35.2u AS=16.016p AD=16.016p
+ PS=42.48u PD=42.48u rfmode=0
* device instance $37 r0 *1 62.515,4.95 sg13_hv_nmos
M$37 iovss gate pad$18 \$2 sg13_hv_nmos L=0.6u W=35.2u AS=16.016p AD=16.016p
+ PS=42.48u PD=42.48u rfmode=0
* device instance $39 r0 *1 65.535,4.95 sg13_hv_nmos
M$39 iovss gate pad$19 \$2 sg13_hv_nmos L=0.6u W=35.2u AS=16.016p AD=16.016p
+ PS=42.48u PD=42.48u rfmode=0
* device instance $41 r0 *1 68.555,4.95 sg13_hv_nmos
M$41 iovss gate pad$20 \$2 sg13_hv_nmos L=0.6u W=35.2u AS=16.016p AD=16.016p
+ PS=42.48u PD=42.48u rfmode=0
* device instance $43 r0 *1 71.575,4.95 sg13_hv_nmos
M$43 iovss gate pad$21 \$2 sg13_hv_nmos L=0.6u W=17.6u AS=5.632p AD=13.024p
+ PS=20.16u PD=41.12u rfmode=0
* device instance $173 r0 *1 4.77,20.98 dantenna
D$173 \$2 gate dantenna A=0.2304p P=1.92u m=1
* device instance $174 r0 *1 40,12.21 ptap1
R$174 iovss \$2 ptap1 A=65.6472p P=386.16u
.ENDS sg13g2_Clamp_N43N43D4R

* cell sg13g2_RCClampInverter
* pin
* pin iovss
* pin in
* pin out
* pin supply
.SUBCKT sg13g2_RCClampInverter \$1 iovss in out supply
* device instance $1 r0 *1 7.72,15.79 sg13_hv_nmos
M$1 iovss in iovss \$1 sg13_hv_nmos L=9.5u W=126u AS=26.64p AD=23.94p
+ PS=149.92u PD=131.32u rfmode=0
* device instance $8 r0 *1 72.38,15.79 sg13_hv_nmos
M$8 iovss in out \$1 sg13_hv_nmos L=0.5u W=108u AS=20.52p AD=23.22p PS=112.56u
+ PD=131.16u rfmode=0
* device instance $27 r0 *1 18.44,29.91 sg13_hv_pmos
M$27 supply in out supply sg13_hv_pmos L=0.5u W=350u AS=67.55p AD=67.55p
+ PS=376.3u PD=376.3u rfmode=0
* device instance $77 r0 *1 40,11.165 ptap1
R$77 iovss \$1 ptap1 A=69.122p P=406.6u
.ENDS sg13g2_RCClampInverter

* cell sg13g2_DCPDiode
* pin
* pin guard
* pin cathode
* pin anode
* pin anode
.SUBCKT sg13g2_DCPDiode \$1 guard cathode anode anode$1
* device instance $1 r0 *1 16.53,7.38 dpantenna
D$1 anode$1 cathode dpantenna A=35.0028p P=58.08u m=1
* device instance $2 r0 *1 16.53,2.88 dpantenna
D$2 anode cathode dpantenna A=35.0028p P=58.08u m=1
* device instance $3 r0 *1 16.53,5.13 ptap1
R$3 guard \$1 ptap1 A=33.5104p P=197.12u
.ENDS sg13g2_DCPDiode

* cell sg13g2_DCNDiode
* pin
* pin anode
* pin cathode
* pin cathode
.SUBCKT sg13g2_DCNDiode \$2 anode cathode cathode$1
* device instance $1 r0 *1 16.53,7.38 dantenna
D$1 \$2 cathode$1 dantenna A=35.0028p P=58.08u m=1
* device instance $2 r0 *1 16.53,2.88 dantenna
D$2 \$2 cathode dantenna A=35.0028p P=58.08u m=1
* device instance $3 r0 *1 16.53,5.13 ptap1
R$3 anode \$2 ptap1 A=141.2964p P=221.76u
.ENDS sg13g2_DCNDiode

* cell sg13g2_GateLevelUpInv
* pin iovdd
* pin vdd
* pin vss
* pin pgate
* pin ngate
* pin core
* pin
.SUBCKT sg13g2_GateLevelUpInv iovdd vdd vss pgate ngate core \$7
* cell instance $1 r0 *1 0,-19.5
X$1 iovdd ngate \$7 core vss vdd sg13g2_LevelUpInv
* cell instance $2 r0 *1 3.51,-19.5
X$2 iovdd pgate \$7 core vss vdd sg13g2_LevelUpInv
.ENDS sg13g2_GateLevelUpInv

* cell sg13g2_Clamp_N15N15D
* pin
* pin iovss
* pin pad
* pin pad
* pin pad
* pin pad
* pin pad
* pin pad
* pin pad
* pin pad
* pin gate
.SUBCKT sg13g2_Clamp_N15N15D \$2 iovss pad pad$1 pad$2 pad$3 pad$4 pad$5 pad$6
+ pad$7 gate
* device instance $1 r0 *1 29.295,4.95 sg13_hv_nmos
M$1 iovss gate pad \$2 sg13_hv_nmos L=0.6u W=8.8u AS=4.664p AD=4.004p PS=15.32u
+ PD=10.62u rfmode=0
* device instance $3 r0 *1 32.315,4.95 sg13_hv_nmos
M$3 iovss gate pad$1 \$2 sg13_hv_nmos L=0.6u W=8.8u AS=4.004p AD=4.004p
+ PS=10.62u PD=10.62u rfmode=0
* device instance $5 r0 *1 35.335,4.95 sg13_hv_nmos
M$5 iovss gate pad$2 \$2 sg13_hv_nmos L=0.6u W=8.8u AS=4.004p AD=4.004p
+ PS=10.62u PD=10.62u rfmode=0
* device instance $7 r0 *1 38.355,4.95 sg13_hv_nmos
M$7 iovss gate pad$3 \$2 sg13_hv_nmos L=0.6u W=8.8u AS=4.004p AD=4.004p
+ PS=10.62u PD=10.62u rfmode=0
* device instance $9 r0 *1 41.375,4.95 sg13_hv_nmos
M$9 iovss gate pad$4 \$2 sg13_hv_nmos L=0.6u W=8.8u AS=4.004p AD=4.004p
+ PS=10.62u PD=10.62u rfmode=0
* device instance $11 r0 *1 44.395,4.95 sg13_hv_nmos
M$11 iovss gate pad$5 \$2 sg13_hv_nmos L=0.6u W=8.8u AS=4.004p AD=4.004p
+ PS=10.62u PD=10.62u rfmode=0
* device instance $13 r0 *1 47.415,4.95 sg13_hv_nmos
M$13 iovss gate pad$6 \$2 sg13_hv_nmos L=0.6u W=8.8u AS=4.004p AD=4.004p
+ PS=10.62u PD=10.62u rfmode=0
* device instance $15 r0 *1 50.435,4.95 sg13_hv_nmos
M$15 iovss gate pad$7 \$2 sg13_hv_nmos L=0.6u W=4.4u AS=1.408p AD=3.256p
+ PS=5.04u PD=10.28u rfmode=0
* device instance $16 r0 *1 15.32,6.705 dantenna
D$16 \$2 gate dantenna A=0.6084p P=3.12u m=1
* device instance $17 r0 *1 40,4.95 ptap1
R$17 iovss \$2 ptap1 A=55.7736p P=328.08u
.ENDS sg13g2_Clamp_N15N15D

* cell sg13g2_Clamp_P15N15D
* pin
* pin iovss
* pin iovdd
* pin pad
* pin pad
* pin pad
* pin pad
* pin pad
* pin pad
* pin pad
* pin pad
* pin gate
.SUBCKT sg13g2_Clamp_P15N15D \$1 iovss iovdd pad pad$1 pad$2 pad$3 pad$4 pad$5
+ pad$6 pad$7 gate
* device instance $1 r0 *1 29.295,6.08 sg13_hv_pmos
M$1 iovdd gate pad iovdd sg13_hv_pmos L=0.6u W=26.64u AS=14.1192p AD=12.1212p
+ PS=44.2u PD=30.28u rfmode=0
* device instance $3 r0 *1 32.315,6.08 sg13_hv_pmos
M$3 iovdd gate pad$1 iovdd sg13_hv_pmos L=0.6u W=26.64u AS=12.1212p AD=12.1212p
+ PS=30.28u PD=30.28u rfmode=0
* device instance $5 r0 *1 35.335,6.08 sg13_hv_pmos
M$5 iovdd gate pad$2 iovdd sg13_hv_pmos L=0.6u W=26.64u AS=12.1212p AD=12.1212p
+ PS=30.28u PD=30.28u rfmode=0
* device instance $7 r0 *1 38.355,6.08 sg13_hv_pmos
M$7 iovdd gate pad$3 iovdd sg13_hv_pmos L=0.6u W=26.64u AS=12.1212p AD=12.1212p
+ PS=30.28u PD=30.28u rfmode=0
* device instance $9 r0 *1 41.375,6.08 sg13_hv_pmos
M$9 iovdd gate pad$4 iovdd sg13_hv_pmos L=0.6u W=26.64u AS=12.1212p AD=12.1212p
+ PS=30.28u PD=30.28u rfmode=0
* device instance $11 r0 *1 44.395,6.08 sg13_hv_pmos
M$11 iovdd gate pad$5 iovdd sg13_hv_pmos L=0.6u W=26.64u AS=12.1212p
+ AD=12.1212p PS=30.28u PD=30.28u rfmode=0
* device instance $13 r0 *1 47.415,6.08 sg13_hv_pmos
M$13 iovdd gate pad$6 iovdd sg13_hv_pmos L=0.6u W=26.64u AS=12.1212p
+ AD=12.1212p PS=30.28u PD=30.28u rfmode=0
* device instance $15 r0 *1 50.435,6.08 sg13_hv_pmos
M$15 iovdd gate pad$7 iovdd sg13_hv_pmos L=0.6u W=13.32u AS=4.2624p AD=9.8568p
+ PS=14.6u PD=29.6u rfmode=0
* device instance $31 r0 *1 15.35,16.1 dpantenna
D$31 gate iovdd dpantenna A=0.6084p P=3.12u m=1
* device instance $32 r0 *1 40,9.63 ptap1
R$32 iovss \$1 ptap1 A=67.0344p P=394.32u
.ENDS sg13g2_Clamp_P15N15D

* cell sg13g2_Clamp_P20N0D
* pin
* pin iovss
* pin iovdd
* pin pad
* pin pad
* pin pad
* pin pad
* pin pad
* pin pad
* pin pad
* pin pad
* pin pad
* pin pad
.SUBCKT sg13g2_Clamp_P20N0D \$1 iovss iovdd pad pad$1 pad$2 pad$3 pad$4 pad$5
+ pad$6 pad$7 pad$8 pad$9
* device instance $1 r0 *1 25.52,13.18 sg13_hv_pmos
M$1 iovdd \$5 pad iovdd sg13_hv_pmos L=0.6u W=26.64u AS=14.1192p AD=12.1212p
+ PS=44.2u PD=30.28u rfmode=0
* device instance $3 r0 *1 28.54,13.18 sg13_hv_pmos
M$3 iovdd \$5 pad$1 iovdd sg13_hv_pmos L=0.6u W=26.64u AS=12.1212p AD=12.1212p
+ PS=30.28u PD=30.28u rfmode=0
* device instance $5 r0 *1 31.56,13.18 sg13_hv_pmos
M$5 iovdd \$5 pad$2 iovdd sg13_hv_pmos L=0.6u W=26.64u AS=12.1212p AD=12.1212p
+ PS=30.28u PD=30.28u rfmode=0
* device instance $7 r0 *1 34.58,13.18 sg13_hv_pmos
M$7 iovdd \$5 pad$3 iovdd sg13_hv_pmos L=0.6u W=26.64u AS=12.1212p AD=12.1212p
+ PS=30.28u PD=30.28u rfmode=0
* device instance $9 r0 *1 37.6,13.18 sg13_hv_pmos
M$9 iovdd \$5 pad$4 iovdd sg13_hv_pmos L=0.6u W=26.64u AS=12.1212p AD=12.1212p
+ PS=30.28u PD=30.28u rfmode=0
* device instance $11 r0 *1 40.62,13.18 sg13_hv_pmos
M$11 iovdd \$5 pad$5 iovdd sg13_hv_pmos L=0.6u W=26.64u AS=12.1212p AD=12.1212p
+ PS=30.28u PD=30.28u rfmode=0
* device instance $13 r0 *1 43.64,13.18 sg13_hv_pmos
M$13 iovdd \$5 pad$6 iovdd sg13_hv_pmos L=0.6u W=26.64u AS=12.1212p AD=12.1212p
+ PS=30.28u PD=30.28u rfmode=0
* device instance $15 r0 *1 46.66,13.18 sg13_hv_pmos
M$15 iovdd \$5 pad$7 iovdd sg13_hv_pmos L=0.6u W=26.64u AS=12.1212p AD=12.1212p
+ PS=30.28u PD=30.28u rfmode=0
* device instance $17 r0 *1 49.68,13.18 sg13_hv_pmos
M$17 iovdd \$5 pad$8 iovdd sg13_hv_pmos L=0.6u W=26.64u AS=12.1212p AD=12.1212p
+ PS=30.28u PD=30.28u rfmode=0
* device instance $19 r0 *1 52.7,13.18 sg13_hv_pmos
M$19 iovdd \$5 pad$9 iovdd sg13_hv_pmos L=0.6u W=26.64u AS=12.1212p AD=14.1192p
+ PS=30.28u PD=44.2u rfmode=0
* device instance $41 r0 *1 66.3,3.175 rppd
R$41 iovdd \$5 iovdd rppd w=0.5u l=12.9u ps=0u b=0 m=1
* device instance $42 r0 *1 40,9.63 ptap1
R$42 iovss \$1 ptap1 A=67.0344p P=394.32u
.ENDS sg13g2_Clamp_P20N0D

* cell sg13g2_Clamp_N20N0D
* pin
* pin iovss
* pin pad
* pin pad
* pin pad
* pin pad
* pin pad
* pin pad
* pin pad
* pin pad
* pin pad
* pin pad
.SUBCKT sg13g2_Clamp_N20N0D \$2 iovss pad pad$1 pad$2 pad$3 pad$4 pad$5 pad$6
+ pad$7 pad$8 pad$9
* device instance $1 r0 *1 25.52,4.95 sg13_hv_nmos
M$1 iovss \$4 pad \$2 sg13_hv_nmos L=0.6u W=8.8u AS=4.664p AD=4.004p PS=15.32u
+ PD=10.62u rfmode=0
* device instance $3 r0 *1 28.54,4.95 sg13_hv_nmos
M$3 iovss \$4 pad$1 \$2 sg13_hv_nmos L=0.6u W=8.8u AS=4.004p AD=4.004p
+ PS=10.62u PD=10.62u rfmode=0
* device instance $5 r0 *1 31.56,4.95 sg13_hv_nmos
M$5 iovss \$4 pad$2 \$2 sg13_hv_nmos L=0.6u W=8.8u AS=4.004p AD=4.004p
+ PS=10.62u PD=10.62u rfmode=0
* device instance $7 r0 *1 34.58,4.95 sg13_hv_nmos
M$7 iovss \$4 pad$3 \$2 sg13_hv_nmos L=0.6u W=8.8u AS=4.004p AD=4.004p
+ PS=10.62u PD=10.62u rfmode=0
* device instance $9 r0 *1 37.6,4.95 sg13_hv_nmos
M$9 iovss \$4 pad$4 \$2 sg13_hv_nmos L=0.6u W=8.8u AS=4.004p AD=4.004p
+ PS=10.62u PD=10.62u rfmode=0
* device instance $11 r0 *1 40.62,4.95 sg13_hv_nmos
M$11 iovss \$4 pad$5 \$2 sg13_hv_nmos L=0.6u W=8.8u AS=4.004p AD=4.004p
+ PS=10.62u PD=10.62u rfmode=0
* device instance $13 r0 *1 43.64,4.95 sg13_hv_nmos
M$13 iovss \$4 pad$6 \$2 sg13_hv_nmos L=0.6u W=8.8u AS=4.004p AD=4.004p
+ PS=10.62u PD=10.62u rfmode=0
* device instance $15 r0 *1 46.66,4.95 sg13_hv_nmos
M$15 iovss \$4 pad$7 \$2 sg13_hv_nmos L=0.6u W=8.8u AS=4.004p AD=4.004p
+ PS=10.62u PD=10.62u rfmode=0
* device instance $17 r0 *1 49.68,4.95 sg13_hv_nmos
M$17 iovss \$4 pad$8 \$2 sg13_hv_nmos L=0.6u W=8.8u AS=4.004p AD=4.004p
+ PS=10.62u PD=10.62u rfmode=0
* device instance $19 r0 *1 52.7,4.95 sg13_hv_nmos
M$19 iovss \$4 pad$9 \$2 sg13_hv_nmos L=0.6u W=8.8u AS=4.004p AD=4.664p
+ PS=10.62u PD=15.32u rfmode=0
* device instance $21 r0 *1 66.3,3.175 rppd
R$21 iovss \$4 \$2 rppd w=0.5u l=3.54u ps=0u b=0 m=1
* device instance $22 r0 *1 40,5 ptap1
R$22 iovss \$2 ptap1 A=55.7736p P=328.08u
.ENDS sg13g2_Clamp_N20N0D

* cell sg13g2_Clamp_P2N2D
* pin
* pin iovss
* pin iovdd
* pin pad
* pin gate
.SUBCKT sg13g2_Clamp_P2N2D \$1 iovss iovdd pad gate
* device instance $1 r0 *1 39.11,13.18 sg13_hv_pmos
M$1 iovdd gate pad iovdd sg13_hv_pmos L=0.6u W=26.64u AS=14.1192p AD=14.1192p
+ PS=44.2u PD=44.2u rfmode=0
* device instance $5 r0 *1 20.24,16.07 dpantenna
D$5 gate iovdd dpantenna A=0.2304p P=1.92u m=1
* device instance $6 r0 *1 40,9.63 ptap1
R$6 iovss \$1 ptap1 A=67.0344p P=394.32u
.ENDS sg13g2_Clamp_P2N2D

* cell sg13g2_Clamp_N2N2D
* pin
* pin iovss
* pin gate
* pin pad
.SUBCKT sg13g2_Clamp_N2N2D \$2 iovss gate pad
* device instance $1 r0 *1 39.11,4.95 sg13_hv_nmos
M$1 iovss gate pad \$2 sg13_hv_nmos L=0.6u W=8.8u AS=4.664p AD=4.664p PS=15.32u
+ PD=15.32u rfmode=0
* device instance $3 r0 *1 20.24,6.74 dantenna
D$3 \$2 gate dantenna A=0.6084p P=3.12u m=1
* device instance $4 r0 *1 40,4.95 ptap1
R$4 iovss \$2 ptap1 A=55.7736p P=328.08u
.ENDS sg13g2_Clamp_N2N2D

* cell g1_LevelDown_polyres
* pin
* pin iovss
* pin pad
* pin iovdd
* pin vss
* pin core
* pin vdd
.SUBCKT g1_LevelDown_polyres \$1 iovss pad iovdd vss core vdd
* device instance $1 r0 *1 0.51,10.505 sg13_lv_nmos
M$1 core \$20 vss \$1 sg13_lv_nmos L=0.13u W=2.75u AS=0.935p AD=0.935p PS=6.18u
+ PD=6.18u rfmode=0
* device instance $2 r0 *1 2.02,10.555 sg13_hv_nmos
M$2 vss \$7 \$20 \$1 sg13_hv_nmos L=0.45u W=2.65u AS=0.901p AD=0.5035p PS=5.98u
+ PD=3.03u rfmode=0
* device instance $3 r0 *1 2.85,10.555 sg13_hv_nmos
M$3 \$20 \$6 vdd \$1 sg13_hv_nmos L=0.45u W=2.65u AS=0.5035p AD=0.901p PS=3.03u
+ PD=5.98u rfmode=0
* device instance $4 r0 *1 10.01,-6.63 sg13_hv_nmos
M$4 \$6 \$10 iovss \$1 sg13_hv_nmos L=0.45u W=1.3u AS=0.442p AD=0.247p PS=3.28u
+ PD=1.68u rfmode=0
* device instance $5 r0 *1 10.84,-6.63 sg13_hv_nmos
M$5 iovss \$6 \$7 \$1 sg13_hv_nmos L=0.45u W=1.3u AS=0.247p AD=0.442p PS=1.68u
+ PD=3.28u rfmode=0
* device instance $6 r0 *1 0.51,15.495 sg13_lv_pmos
M$6 core \$20 vdd vdd sg13_lv_pmos L=0.13u W=4.75u AS=1.615p AD=1.615p
+ PS=10.18u PD=10.18u rfmode=0
* device instance $8 r0 *1 9.18,-2.23 sg13_hv_pmos
M$8 iovdd \$10 \$6 iovdd sg13_hv_pmos L=0.45u W=4.6u AS=1.219p AD=0.874p
+ PS=7.96u PD=5.36u rfmode=0
* device instance $10 r0 *1 10.84,-2.23 sg13_hv_pmos
M$10 iovdd \$6 \$7 iovdd sg13_hv_pmos L=0.45u W=4.6u AS=0.874p AD=1.219p
+ PS=5.36u PD=7.96u rfmode=0
* device instance $12 r0 *1 3.365,8.5 ptap1
R$12 vss \$1 ptap1 A=2.019p P=14.06u
* device instance $13 r0 *1 10.47,-8.18 ptap1
R$13 iovss \$1 ptap1 A=9.8344p P=59.08u
* device instance $14 r0 *1 5.48,-5.96 dantenna
D$14 \$1 \$10 dantenna A=1.984p P=7.48u m=1
* device instance $15 r0 *1 3.31,-0.99 dpantenna
D$15 \$10 iovdd dpantenna A=3.1872p P=11.24u m=1
* device instance $16 r0 *1 0.935,-6.965 rppd
R$16 pad \$10 \$1 rppd w=1u l=2u ps=0u b=0 m=1
.ENDS g1_LevelDown_polyres

* cell sg13g2_LevelUpInv
* pin iovdd
* pin o
* pin
* pin i
* pin vss
* pin vdd
.SUBCKT sg13g2_LevelUpInv iovdd o \$5 i vss vdd
* device instance $1 r0 *1 0.51,10.505 sg13_lv_nmos
M$1 \$6 i vss \$5 sg13_lv_nmos L=0.13u W=2.75u AS=0.935p AD=0.935p PS=6.18u
+ PD=6.18u rfmode=0
* device instance $2 r0 *1 2.84,6.82 sg13_hv_nmos
M$2 vss \$4 o \$5 sg13_hv_nmos L=0.45u W=1.9u AS=0.646p AD=0.646p PS=4.48u
+ PD=4.48u rfmode=0
* device instance $3 r0 *1 0.67,6.82 sg13_hv_nmos
M$3 \$3 i vss \$5 sg13_hv_nmos L=0.45u W=1.9u AS=0.646p AD=0.361p PS=4.48u
+ PD=2.28u rfmode=0
* device instance $4 r0 *1 1.5,6.82 sg13_hv_nmos
M$4 vss \$6 \$4 \$5 sg13_hv_nmos L=0.45u W=1.9u AS=0.361p AD=0.646p PS=2.28u
+ PD=4.48u rfmode=0
* device instance $5 r0 *1 0.51,15.495 sg13_lv_pmos
M$5 \$6 i vdd vdd sg13_lv_pmos L=0.13u W=4.75u AS=1.615p AD=1.615p PS=10.18u
+ PD=10.18u rfmode=0
* device instance $6 r0 *1 2.84,2.68 sg13_hv_pmos
M$6 iovdd \$4 o iovdd sg13_hv_pmos L=0.45u W=3.9u AS=1.326p AD=1.326p PS=8.48u
+ PD=8.48u rfmode=0
* device instance $7 r0 *1 0.67,2.68 sg13_hv_pmos
M$7 \$3 \$4 iovdd iovdd sg13_hv_pmos L=0.45u W=0.3u AS=0.102p AD=0.057p
+ PS=1.28u PD=0.68u rfmode=0
* device instance $8 r0 *1 1.5,2.68 sg13_hv_pmos
M$8 iovdd \$3 \$4 iovdd sg13_hv_pmos L=0.45u W=0.3u AS=0.057p AD=0.102p
+ PS=0.68u PD=1.28u rfmode=0
* device instance $9 r0 *1 1.755,8.5 ptap1
R$9 vss \$5 ptap1 A=1.053p P=7.62u
.ENDS sg13g2_LevelUpInv
