* Extracted by KLayout with SG13G2 LVS runset on : 20/10/2026 12:58

* cell r1_padring
* pin $1.c2p
* pin $10.padres
* pin $11.padres
* pin $12.p2c
* pin $13.p2c
* pin $14.p2c
* pin $2.c2p
* pin $237182.padres
* pin $3.c2p
* pin $344752.c2p
* pin $344864.p2c
* pin $4.padres
* pin $5.padres
* pin $6.padres
* pin $7.padres
* pin $8.padres
* pin $88229.c2p
* pin $9.padres
* pin COS_N
* pin COS_P
* pin CS_N
* pin EN_STO_IN
* pin FAULT_N
* pin GATE_A
* pin GATE_B
* pin GATE_C
* pin IOVDD
* pin IOVSS
* pin ISA_N
* pin ISA_P
* pin ISB_N
* pin ISB_P
* pin MA_SCLK
* pin SDI
* pin SIN_N
* pin SIN_P
* pin SLO_SDO
* pin VDD
* pin VDDA
* pin VSS
.SUBCKT r1_padring \$1.c2p \$10.padres \$11.padres \$12.p2c \$13.p2c \$14.p2c
+ \$2.c2p \$237182.padres \$3.c2p \$344752.c2p \$344864.p2c \$4.padres
+ \$5.padres \$6.padres \$7.padres \$8.padres \$88229.c2p \$9.padres COS_N
+ COS_P CS_N EN_STO_IN FAULT_N GATE_A GATE_B GATE_C IOVDD IOVSS ISA_N ISA_P
+ ISB_N ISB_P MA_SCLK SDI SIN_N SIN_P SLO_SDO VDD VDDA VSS
* cell instance $344865 r0 *1 355,147
X$344865 \$1 IOVSS VDD VDD VDD VDD VDD VDD VDD VDD VDD VDD VDD VDD VDD VDD VDD
+ VDD VDD VDD VDD VDD VDD VDD \$I354861 sg13g2_Clamp_N43N43D4R
* cell instance $344867 m90 *1 435,206
X$344867 \$1 IOVSS \$I354860 \$I354861 VDD sg13g2_RCClampInverter
* cell instance $344868 r90 *1 814.92,148.66
X$344868 \$1 IOVSS VSS VSS sg13g2_DCNDiode
* cell instance $344869 r90 *1 814.92,207.66
X$344869 \$1 IOVSS IOVDD VSS VSS sg13g2_DCPDiode
* cell instance $344870 r90 *1 478.92,148.66
X$344870 \$1 IOVSS VSS VSS sg13g2_DCNDiode
* cell instance $344871 r90 *1 478.92,207.66
X$344871 \$1 IOVSS IOVDD VSS VSS sg13g2_DCPDiode
* cell instance $344876 m0 *1 467,1208
X$344876 \$1 IOVSS IOVDD GATE_B GATE_B GATE_B GATE_B GATE_B GATE_B GATE_B
+ GATE_B \$I354865 sg13g2_Clamp_P15N15D
* cell instance $344878 m0 *1 467,1267
X$344878 \$1 IOVSS GATE_B GATE_B GATE_B GATE_B GATE_B GATE_B GATE_B GATE_B
+ \$I354864 sg13g2_Clamp_N15N15D
* cell instance $344879 m0 *1 503.97,1105
X$344879 IOVDD VDD VSS \$I354865 \$I354864 \$1.c2p \$1 sg13g2_GateLevelUpInv
* cell instance $344881 m0 *1 579,1208
X$344881 \$1 IOVSS IOVDD GATE_C GATE_C GATE_C GATE_C GATE_C GATE_C GATE_C
+ GATE_C \$I354868 sg13g2_Clamp_P15N15D
* cell instance $344883 m0 *1 579,1267
X$344883 \$1 IOVSS GATE_C GATE_C GATE_C GATE_C GATE_C GATE_C GATE_C GATE_C
+ \$I354867 sg13g2_Clamp_N15N15D
* cell instance $344884 m0 *1 615.97,1105
X$344884 IOVDD VDD VSS \$I354868 \$I354867 \$2.c2p \$1 sg13g2_GateLevelUpInv
* cell instance $344886 m0 *1 355,1208
X$344886 \$1 IOVSS IOVDD GATE_A GATE_A GATE_A GATE_A GATE_A GATE_A GATE_A
+ GATE_A \$I354871 sg13g2_Clamp_P15N15D
* cell instance $344888 m0 *1 355,1267
X$344888 \$1 IOVSS GATE_A GATE_A GATE_A GATE_A GATE_A GATE_A GATE_A GATE_A
+ \$I354870 sg13g2_Clamp_N15N15D
* cell instance $344889 m0 *1 391.97,1105
X$344889 IOVDD VDD VSS \$I354871 \$I354870 \$344752.c2p \$1
+ sg13g2_GateLevelUpInv
* cell instance $344891 m0 *1 915,1208
X$344891 \$1 IOVSS IOVDD SLO_SDO \$I354874 sg13g2_Clamp_P2N2D
* cell instance $344893 m0 *1 915,1267
X$344893 \$1 IOVSS \$I354873 SLO_SDO sg13g2_Clamp_N2N2D
* cell instance $344896 r90 *1 1208,915
X$344896 \$1 IOVSS IOVDD FAULT_N \$I354877 sg13g2_Clamp_P2N2D
* cell instance $344898 r90 *1 1267,915
X$344898 \$1 IOVSS \$I354876 FAULT_N sg13g2_Clamp_N2N2D
* cell instance $344905 m45 *1 206,579
X$344905 \$1 IOVSS IOVDD SIN_P SIN_P SIN_P SIN_P SIN_P SIN_P SIN_P SIN_P SIN_P
+ SIN_P sg13g2_Clamp_P20N0D
* cell instance $344907 m45 *1 147,579
X$344907 \$1 IOVSS SIN_P SIN_P SIN_P SIN_P SIN_P SIN_P SIN_P SIN_P SIN_P SIN_P
+ sg13g2_Clamp_N20N0D
* cell instance $344910 m45 *1 206,915
X$344910 \$1 IOVSS IOVDD COS_N COS_N COS_N COS_N COS_N COS_N COS_N COS_N COS_N
+ COS_N sg13g2_Clamp_P20N0D
* cell instance $344912 m45 *1 147,915
X$344912 \$1 IOVSS COS_N COS_N COS_N COS_N COS_N COS_N COS_N COS_N COS_N COS_N
+ sg13g2_Clamp_N20N0D
* cell instance $344915 m45 *1 206,691
X$344915 \$1 IOVSS IOVDD SIN_N SIN_N SIN_N SIN_N SIN_N SIN_N SIN_N SIN_N SIN_N
+ SIN_N sg13g2_Clamp_P20N0D
* cell instance $344917 m45 *1 147,691
X$344917 \$1 IOVSS SIN_N SIN_N SIN_N SIN_N SIN_N SIN_N SIN_N SIN_N SIN_N SIN_N
+ sg13g2_Clamp_N20N0D
* cell instance $344920 m45 *1 206,803
X$344920 \$1 IOVSS IOVDD COS_P COS_P COS_P COS_P COS_P COS_P COS_P COS_P COS_P
+ COS_P sg13g2_Clamp_P20N0D
* cell instance $344922 m45 *1 147,803
X$344922 \$1 IOVSS COS_P COS_P COS_P COS_P COS_P COS_P COS_P COS_P COS_P COS_P
+ sg13g2_Clamp_N20N0D
* cell instance $344925 r90 *1 1208,579
X$344925 \$1 IOVSS IOVDD ISA_N ISA_N ISA_N ISA_N ISA_N ISA_N ISA_N ISA_N ISA_N
+ ISA_N sg13g2_Clamp_P20N0D
* cell instance $344927 r90 *1 1267,579
X$344927 \$1 IOVSS ISA_N ISA_N ISA_N ISA_N ISA_N ISA_N ISA_N ISA_N ISA_N ISA_N
+ sg13g2_Clamp_N20N0D
* cell instance $344930 r90 *1 1208,467
X$344930 \$1 IOVSS IOVDD ISA_P ISA_P ISA_P ISA_P ISA_P ISA_P ISA_P ISA_P ISA_P
+ ISA_P sg13g2_Clamp_P20N0D
* cell instance $344932 r90 *1 1267,467
X$344932 \$1 IOVSS ISA_P ISA_P ISA_P ISA_P ISA_P ISA_P ISA_P ISA_P ISA_P ISA_P
+ sg13g2_Clamp_N20N0D
* cell instance $344935 r90 *1 1208,803
X$344935 \$1 IOVSS IOVDD ISB_N ISB_N ISB_N ISB_N ISB_N ISB_N ISB_N ISB_N ISB_N
+ ISB_N sg13g2_Clamp_P20N0D
* cell instance $344937 r90 *1 1267,803
X$344937 \$1 IOVSS ISB_N ISB_N ISB_N ISB_N ISB_N ISB_N ISB_N ISB_N ISB_N ISB_N
+ sg13g2_Clamp_N20N0D
* cell instance $344940 r90 *1 1208,691
X$344940 \$1 IOVSS IOVDD ISB_P ISB_P ISB_P ISB_P ISB_P ISB_P ISB_P ISB_P ISB_P
+ ISB_P sg13g2_Clamp_P20N0D
* cell instance $344942 r90 *1 1267,691
X$344942 \$1 IOVSS ISB_P ISB_P ISB_P ISB_P ISB_P ISB_P ISB_P ISB_P ISB_P ISB_P
+ sg13g2_Clamp_N20N0D
* cell instance $344945 r90 *1 1208,355
X$344945 \$1 IOVSS IOVDD VDDA VDDA VDDA VDDA VDDA VDDA VDDA VDDA VDDA VDDA
+ sg13g2_Clamp_P20N0D
* cell instance $344947 r90 *1 1267,355
X$344947 \$1 IOVSS VDDA VDDA VDDA VDDA VDDA VDDA VDDA VDDA VDDA VDDA
+ sg13g2_Clamp_N20N0D
* cell instance $344951 m45 *1 289.5,506.745
X$344951 \$1 IOVSS EN_STO_IN IOVDD VSS \$12.p2c VDD g1_LevelDown_polyres
* cell instance $344954 m0 *1 730.745,1124.5
X$344954 \$1 IOVSS CS_N IOVDD VSS \$13.p2c VDD g1_LevelDown_polyres
* cell instance $344957 m0 *1 842.745,1124.5
X$344957 \$1 IOVSS MA_SCLK IOVDD VSS \$14.p2c VDD g1_LevelDown_polyres
* cell instance $344960 m45 *1 289.5,394.745
X$344960 \$1 IOVSS SDI IOVDD VSS \$344864.p2c VDD g1_LevelDown_polyres
* device instance $1 r0 *1 395,243.585 ptap1
R$1 IOVSS \$1 ptap1 A=233029.7881p P=51596.408u
* device instance $2 r0 *1 395,298 ptap1
R$2 VSS \$1 ptap1 A=966.9276p P=6519.576u
* device instance $542 m0 *1 415.12,198.715 rppd
R$542 \$I354860 VDD \$1 rppd w=1u l=520u ps=0u b=0 m=1
* device instance $568 m0 *1 639.12,198.715 rppd
R$568 \$I354862 IOVDD \$1 rppd w=1u l=520u ps=0u b=0 m=1
* device instance $569 r0 *1 587.155,151.95 sg13_hv_nmos
M$569 IOVSS \$I354863 IOVDD \$1 sg13_hv_nmos L=0.6u W=756.8u AS=344.608p
+ AD=349.36p PS=931.04u PD=933.2u rfmode=0
* device instance $741 r0 *1 583.77,167.98 dantenna
D$741 \$1 \$I354863 dantenna A=0.2304p P=1.92u m=1
* device instance $743 m90 *1 651.28,221.79 sg13_hv_nmos
M$743 IOVSS \$I354862 IOVSS \$1 sg13_hv_nmos L=9.5u W=126u AS=26.64p AD=23.94p
+ PS=149.92u PD=131.32u rfmode=0
* device instance $750 m90 *1 586.62,221.79 sg13_hv_nmos
M$750 IOVSS \$I354862 \$I354863 \$1 sg13_hv_nmos L=0.5u W=108u AS=20.52p
+ AD=23.22p PS=112.56u PD=131.16u rfmode=0
* device instance $769 m90 *1 640.56,235.91 sg13_hv_pmos
M$769 IOVDD \$I354862 \$I354863 IOVDD sg13_hv_pmos L=0.5u W=350u AS=67.55p
+ AD=67.55p PS=376.3u PD=376.3u rfmode=0
* device instance $820 m0 *1 507,1212.54 dpantenna
D$820 GATE_B IOVDD dpantenna A=35.0028p P=58.08u m=2
* device instance $823 m0 *1 619,1212.54 dpantenna
D$823 GATE_C IOVDD dpantenna A=35.0028p P=58.08u m=2
* device instance $826 m0 *1 395,1212.54 dpantenna
D$826 GATE_A IOVDD dpantenna A=35.0028p P=58.08u m=2
* device instance $829 m0 *1 507,1248.06 dantenna
D$829 \$1 GATE_B dantenna A=35.0028p P=58.08u m=2
* device instance $832 m0 *1 619,1248.06 dantenna
D$832 \$1 GATE_C dantenna A=35.0028p P=58.08u m=2
* device instance $835 m0 *1 395,1248.06 dantenna
D$835 \$1 GATE_A dantenna A=35.0028p P=58.08u m=2
* device instance $838 m0 *1 955,1212.54 dpantenna
D$838 SLO_SDO IOVDD dpantenna A=35.0028p P=58.08u m=2
* device instance $841 r90 *1 1212.54,955 dpantenna
D$841 FAULT_N IOVDD dpantenna A=35.0028p P=58.08u m=2
* device instance $844 m0 *1 955,1248.06 dantenna
D$844 \$1 SLO_SDO dantenna A=35.0028p P=58.08u m=2
* device instance $847 r90 *1 1248.06,955 dantenna
D$847 \$1 FAULT_N dantenna A=35.0028p P=58.08u m=2
* device instance $850 r90 *1 919.54,224.19 dpantenna
D$850 IOVSS IOVDD dpantenna A=35.0028p P=58.08u m=4
* device instance $856 r90 *1 919.54,165.19 dantenna
D$856 \$1 IOVSS dantenna A=35.0028p P=58.08u m=4
* device instance $862 m45 *1 283.54,636.63 dantenna
D$862 \$1 \$4.padres dantenna A=1.984p P=7.48u m=1
* device instance $863 m45 *1 288.51,634.46 dpantenna
D$863 \$4.padres IOVDD dpantenna A=3.1872p P=11.24u m=1
* device instance $864 m45 *1 282.535,632.085 rppd
R$864 SIN_P \$4.padres \$1 rppd w=1u l=2u ps=0u b=0 m=1
* device instance $867 m45 *1 283.54,972.63 dantenna
D$867 \$1 \$5.padres dantenna A=1.984p P=7.48u m=1
* device instance $868 m45 *1 288.51,970.46 dpantenna
D$868 \$5.padres IOVDD dpantenna A=3.1872p P=11.24u m=1
* device instance $869 m45 *1 282.535,968.085 rppd
R$869 COS_N \$5.padres \$1 rppd w=1u l=2u ps=0u b=0 m=1
* device instance $872 m45 *1 283.54,748.63 dantenna
D$872 \$1 \$6.padres dantenna A=1.984p P=7.48u m=1
* device instance $873 m45 *1 288.51,746.46 dpantenna
D$873 \$6.padres IOVDD dpantenna A=3.1872p P=11.24u m=1
* device instance $874 m45 *1 282.535,744.085 rppd
R$874 SIN_N \$6.padres \$1 rppd w=1u l=2u ps=0u b=0 m=1
* device instance $877 m45 *1 283.54,860.63 dantenna
D$877 \$1 \$7.padres dantenna A=1.984p P=7.48u m=1
* device instance $878 m45 *1 288.51,858.46 dpantenna
D$878 \$7.padres IOVDD dpantenna A=3.1872p P=11.24u m=1
* device instance $879 m45 *1 282.535,856.085 rppd
R$879 COS_P \$7.padres \$1 rppd w=1u l=2u ps=0u b=0 m=1
* device instance $882 r90 *1 1130.46,636.63 dantenna
D$882 \$1 \$8.padres dantenna A=1.984p P=7.48u m=1
* device instance $883 r90 *1 1125.49,634.46 dpantenna
D$883 \$8.padres IOVDD dpantenna A=3.1872p P=11.24u m=1
* device instance $884 r90 *1 1131.465,632.085 rppd
R$884 ISA_N \$8.padres \$1 rppd w=1u l=2u ps=0u b=0 m=1
* device instance $887 r90 *1 1130.46,524.63 dantenna
D$887 \$1 \$9.padres dantenna A=1.984p P=7.48u m=1
* device instance $888 r90 *1 1125.49,522.46 dpantenna
D$888 \$9.padres IOVDD dpantenna A=3.1872p P=11.24u m=1
* device instance $889 r90 *1 1131.465,520.085 rppd
R$889 ISA_P \$9.padres \$1 rppd w=1u l=2u ps=0u b=0 m=1
* device instance $892 r90 *1 1130.46,860.63 dantenna
D$892 \$1 \$10.padres dantenna A=1.984p P=7.48u m=1
* device instance $893 r90 *1 1125.49,858.46 dpantenna
D$893 \$10.padres IOVDD dpantenna A=3.1872p P=11.24u m=1
* device instance $894 r90 *1 1131.465,856.085 rppd
R$894 ISB_N \$10.padres \$1 rppd w=1u l=2u ps=0u b=0 m=1
* device instance $897 r90 *1 1130.46,748.63 dantenna
D$897 \$1 \$11.padres dantenna A=1.984p P=7.48u m=1
* device instance $898 r90 *1 1125.49,746.46 dpantenna
D$898 \$11.padres IOVDD dpantenna A=3.1872p P=11.24u m=1
* device instance $899 r90 *1 1131.465,744.085 rppd
R$899 ISB_P \$11.padres \$1 rppd w=1u l=2u ps=0u b=0 m=1
* device instance $902 r90 *1 1130.46,412.63 dantenna
D$902 \$1 \$237182.padres dantenna A=1.984p P=7.48u m=1
* device instance $903 r90 *1 1125.49,410.46 dpantenna
D$903 \$237182.padres IOVDD dpantenna A=3.1872p P=11.24u m=1
* device instance $904 r90 *1 1131.465,408.085 rppd
R$904 VDDA \$237182.padres \$1 rppd w=1u l=2u ps=0u b=0 m=1
* device instance $907 m45 *1 201.46,619 dpantenna
D$907 SIN_P IOVDD dpantenna A=35.0028p P=58.08u m=2
* device instance $910 m45 *1 201.46,955 dpantenna
D$910 COS_N IOVDD dpantenna A=35.0028p P=58.08u m=2
* device instance $913 m45 *1 201.46,731 dpantenna
D$913 SIN_N IOVDD dpantenna A=35.0028p P=58.08u m=2
* device instance $916 m45 *1 201.46,843 dpantenna
D$916 COS_P IOVDD dpantenna A=35.0028p P=58.08u m=2
* device instance $919 r90 *1 1212.54,619 dpantenna
D$919 ISA_N IOVDD dpantenna A=35.0028p P=58.08u m=2
* device instance $922 r90 *1 1212.54,507 dpantenna
D$922 ISA_P IOVDD dpantenna A=35.0028p P=58.08u m=2
* device instance $925 r90 *1 1212.54,843 dpantenna
D$925 ISB_N IOVDD dpantenna A=35.0028p P=58.08u m=2
* device instance $928 r90 *1 1212.54,731 dpantenna
D$928 ISB_P IOVDD dpantenna A=35.0028p P=58.08u m=2
* device instance $931 r90 *1 1212.54,395 dpantenna
D$931 VDDA IOVDD dpantenna A=35.0028p P=58.08u m=2
* device instance $934 m45 *1 165.94,619 dantenna
D$934 \$1 SIN_P dantenna A=35.0028p P=58.08u m=2
* device instance $937 m45 *1 165.94,955 dantenna
D$937 \$1 COS_N dantenna A=35.0028p P=58.08u m=2
* device instance $940 m45 *1 165.94,731 dantenna
D$940 \$1 SIN_N dantenna A=35.0028p P=58.08u m=2
* device instance $943 m45 *1 165.94,843 dantenna
D$943 \$1 COS_P dantenna A=35.0028p P=58.08u m=2
* device instance $946 r90 *1 1248.06,619 dantenna
D$946 \$1 ISA_N dantenna A=35.0028p P=58.08u m=2
* device instance $949 r90 *1 1248.06,507 dantenna
D$949 \$1 ISA_P dantenna A=35.0028p P=58.08u m=2
* device instance $952 r90 *1 1248.06,843 dantenna
D$952 \$1 ISB_N dantenna A=35.0028p P=58.08u m=2
* device instance $955 r90 *1 1248.06,731 dantenna
D$955 \$1 ISB_P dantenna A=35.0028p P=58.08u m=2
* device instance $958 r90 *1 1248.06,395 dantenna
D$958 \$1 VDDA dantenna A=35.0028p P=58.08u m=2
* device instance $961 m0 *1 224.19,471.54 dpantenna
D$961 EN_STO_IN IOVDD dpantenna A=35.0028p P=58.08u m=2
* device instance $964 m135 *1 695.54,1189.81 dpantenna
D$964 CS_N IOVDD dpantenna A=35.0028p P=58.08u m=2
* device instance $967 m135 *1 807.54,1189.81 dpantenna
D$967 MA_SCLK IOVDD dpantenna A=35.0028p P=58.08u m=2
* device instance $970 m0 *1 224.19,359.54 dpantenna
D$970 SDI IOVDD dpantenna A=35.0028p P=58.08u m=2
* device instance $973 m0 *1 165.19,471.54 dantenna
D$973 \$1 EN_STO_IN dantenna A=35.0028p P=58.08u m=2
* device instance $976 m135 *1 695.54,1248.81 dantenna
D$976 \$1 CS_N dantenna A=35.0028p P=58.08u m=2
* device instance $979 m135 *1 807.54,1248.81 dantenna
D$979 \$1 MA_SCLK dantenna A=35.0028p P=58.08u m=2
* device instance $982 m0 *1 165.19,359.54 dantenna
D$982 \$1 SDI dantenna A=35.0028p P=58.08u m=2
* device instance $985 m0 *1 952.48,1113.995 sg13_lv_nmos
M$985 \$I354944 \$3.c2p VSS \$1 sg13_lv_nmos L=0.13u W=2.75u AS=0.935p
+ AD=0.935p PS=6.18u PD=6.18u rfmode=0
* device instance $986 m0 *1 954.81,1117.68 sg13_hv_nmos
M$986 VSS \$I354943 \$I354873 \$1 sg13_hv_nmos L=0.45u W=1.9u AS=0.646p
+ AD=0.646p PS=4.48u PD=4.48u rfmode=0
* device instance $987 m0 *1 952.64,1117.68 sg13_hv_nmos
M$987 \$I354942 \$3.c2p VSS \$1 sg13_hv_nmos L=0.45u W=1.9u AS=0.646p AD=0.361p
+ PS=4.48u PD=2.28u rfmode=0
* device instance $988 m0 *1 953.47,1117.68 sg13_hv_nmos
M$988 VSS \$I354944 \$I354943 \$1 sg13_hv_nmos L=0.45u W=1.9u AS=0.361p
+ AD=0.646p PS=2.28u PD=4.48u rfmode=0
* device instance $989 m0 *1 952.48,1109.005 sg13_lv_pmos
M$989 \$I354944 \$3.c2p VDD VDD sg13_lv_pmos L=0.13u W=4.75u AS=1.615p
+ AD=1.615p PS=10.18u PD=10.18u rfmode=0
* device instance $990 m0 *1 954.81,1121.82 sg13_hv_pmos
M$990 IOVDD \$I354943 \$I354873 IOVDD sg13_hv_pmos L=0.45u W=3.9u AS=1.326p
+ AD=1.326p PS=8.48u PD=8.48u rfmode=0
* device instance $991 m0 *1 952.64,1121.82 sg13_hv_pmos
M$991 \$I354942 \$I354943 IOVDD IOVDD sg13_hv_pmos L=0.45u W=0.3u AS=0.102p
+ AD=0.057p PS=1.28u PD=0.68u rfmode=0
* device instance $992 m0 *1 953.47,1121.82 sg13_hv_pmos
M$992 IOVDD \$I354942 \$I354943 IOVDD sg13_hv_pmos L=0.45u W=0.3u AS=0.057p
+ AD=0.102p PS=0.68u PD=1.28u rfmode=0
* device instance $994 m0 *1 955.99,1113.995 sg13_lv_nmos
M$994 \$I354947 \$3.c2p VSS \$1 sg13_lv_nmos L=0.13u W=2.75u AS=0.935p
+ AD=0.935p PS=6.18u PD=6.18u rfmode=0
* device instance $995 m0 *1 958.32,1117.68 sg13_hv_nmos
M$995 VSS \$I354946 \$I354874 \$1 sg13_hv_nmos L=0.45u W=1.9u AS=0.646p
+ AD=0.646p PS=4.48u PD=4.48u rfmode=0
* device instance $996 m0 *1 956.15,1117.68 sg13_hv_nmos
M$996 \$I354945 \$3.c2p VSS \$1 sg13_hv_nmos L=0.45u W=1.9u AS=0.646p AD=0.361p
+ PS=4.48u PD=2.28u rfmode=0
* device instance $997 m0 *1 956.98,1117.68 sg13_hv_nmos
M$997 VSS \$I354947 \$I354946 \$1 sg13_hv_nmos L=0.45u W=1.9u AS=0.361p
+ AD=0.646p PS=2.28u PD=4.48u rfmode=0
* device instance $998 m0 *1 955.99,1109.005 sg13_lv_pmos
M$998 \$I354947 \$3.c2p VDD VDD sg13_lv_pmos L=0.13u W=4.75u AS=1.615p
+ AD=1.615p PS=10.18u PD=10.18u rfmode=0
* device instance $999 m0 *1 958.32,1121.82 sg13_hv_pmos
M$999 IOVDD \$I354946 \$I354874 IOVDD sg13_hv_pmos L=0.45u W=3.9u AS=1.326p
+ AD=1.326p PS=8.48u PD=8.48u rfmode=0
* device instance $1000 m0 *1 956.15,1121.82 sg13_hv_pmos
M$1000 \$I354945 \$I354946 IOVDD IOVDD sg13_hv_pmos L=0.45u W=0.3u AS=0.102p
+ AD=0.057p PS=1.28u PD=0.68u rfmode=0
* device instance $1001 m0 *1 956.98,1121.82 sg13_hv_pmos
M$1001 IOVDD \$I354945 \$I354946 IOVDD sg13_hv_pmos L=0.45u W=0.3u AS=0.057p
+ AD=0.102p PS=0.68u PD=1.28u rfmode=0
* device instance $1003 r90 *1 1113.995,952.48 sg13_lv_nmos
M$1003 \$I354950 \$88229.c2p VSS \$1 sg13_lv_nmos L=0.13u W=2.75u AS=0.935p
+ AD=0.935p PS=6.18u PD=6.18u rfmode=0
* device instance $1004 r90 *1 1117.68,954.81 sg13_hv_nmos
M$1004 VSS \$I354949 \$I354876 \$1 sg13_hv_nmos L=0.45u W=1.9u AS=0.646p
+ AD=0.646p PS=4.48u PD=4.48u rfmode=0
* device instance $1005 r90 *1 1117.68,952.64 sg13_hv_nmos
M$1005 \$I354948 \$88229.c2p VSS \$1 sg13_hv_nmos L=0.45u W=1.9u AS=0.646p
+ AD=0.361p PS=4.48u PD=2.28u rfmode=0
* device instance $1006 r90 *1 1117.68,953.47 sg13_hv_nmos
M$1006 VSS \$I354950 \$I354949 \$1 sg13_hv_nmos L=0.45u W=1.9u AS=0.361p
+ AD=0.646p PS=2.28u PD=4.48u rfmode=0
* device instance $1007 r90 *1 1109.005,952.48 sg13_lv_pmos
M$1007 \$I354950 \$88229.c2p VDD VDD sg13_lv_pmos L=0.13u W=4.75u AS=1.615p
+ AD=1.615p PS=10.18u PD=10.18u rfmode=0
* device instance $1008 r90 *1 1121.82,954.81 sg13_hv_pmos
M$1008 IOVDD \$I354949 \$I354876 IOVDD sg13_hv_pmos L=0.45u W=3.9u AS=1.326p
+ AD=1.326p PS=8.48u PD=8.48u rfmode=0
* device instance $1009 r90 *1 1121.82,952.64 sg13_hv_pmos
M$1009 \$I354948 \$I354949 IOVDD IOVDD sg13_hv_pmos L=0.45u W=0.3u AS=0.102p
+ AD=0.057p PS=1.28u PD=0.68u rfmode=0
* device instance $1010 r90 *1 1121.82,953.47 sg13_hv_pmos
M$1010 IOVDD \$I354948 \$I354949 IOVDD sg13_hv_pmos L=0.45u W=0.3u AS=0.057p
+ AD=0.102p PS=0.68u PD=1.28u rfmode=0
* device instance $1012 r90 *1 1113.995,955.99 sg13_lv_nmos
M$1012 \$I354953 \$88229.c2p VSS \$1 sg13_lv_nmos L=0.13u W=2.75u AS=0.935p
+ AD=0.935p PS=6.18u PD=6.18u rfmode=0
* device instance $1013 r90 *1 1117.68,958.32 sg13_hv_nmos
M$1013 VSS \$I354952 \$I354877 \$1 sg13_hv_nmos L=0.45u W=1.9u AS=0.646p
+ AD=0.646p PS=4.48u PD=4.48u rfmode=0
* device instance $1014 r90 *1 1117.68,956.15 sg13_hv_nmos
M$1014 \$I354951 \$88229.c2p VSS \$1 sg13_hv_nmos L=0.45u W=1.9u AS=0.646p
+ AD=0.361p PS=4.48u PD=2.28u rfmode=0
* device instance $1015 r90 *1 1117.68,956.98 sg13_hv_nmos
M$1015 VSS \$I354953 \$I354952 \$1 sg13_hv_nmos L=0.45u W=1.9u AS=0.361p
+ AD=0.646p PS=2.28u PD=4.48u rfmode=0
* device instance $1016 r90 *1 1109.005,955.99 sg13_lv_pmos
M$1016 \$I354953 \$88229.c2p VDD VDD sg13_lv_pmos L=0.13u W=4.75u AS=1.615p
+ AD=1.615p PS=10.18u PD=10.18u rfmode=0
* device instance $1017 r90 *1 1121.82,958.32 sg13_hv_pmos
M$1017 IOVDD \$I354952 \$I354877 IOVDD sg13_hv_pmos L=0.45u W=3.9u AS=1.326p
+ AD=1.326p PS=8.48u PD=8.48u rfmode=0
* device instance $1018 r90 *1 1121.82,956.15 sg13_hv_pmos
M$1018 \$I354951 \$I354952 IOVDD IOVDD sg13_hv_pmos L=0.45u W=0.3u AS=0.102p
+ AD=0.057p PS=1.28u PD=0.68u rfmode=0
* device instance $1019 r90 *1 1121.82,956.98 sg13_hv_pmos
M$1019 IOVDD \$I354951 \$I354952 IOVDD sg13_hv_pmos L=0.45u W=0.3u AS=0.057p
+ AD=0.102p PS=0.68u PD=1.28u rfmode=0
.ENDS r1_padring

* cell sg13g2_Clamp_N43N43D4R
* pin
* pin iovss
* pin pad
* pin pad
* pin pad
* pin pad
* pin pad
* pin pad
* pin pad
* pin pad
* pin pad
* pin pad
* pin pad
* pin pad
* pin pad
* pin pad
* pin pad
* pin pad
* pin pad
* pin pad
* pin pad
* pin pad
* pin pad
* pin pad
* pin gate
.SUBCKT sg13g2_Clamp_N43N43D4R \$2 iovss pad pad$1 pad$2 pad$3 pad$4 pad$5
+ pad$6 pad$7 pad$8 pad$9 pad$10 pad$11 pad$12 pad$13 pad$14 pad$15 pad$16
+ pad$17 pad$18 pad$19 pad$20 pad$21 gate
* device instance $1 r0 *1 8.155,4.95 sg13_hv_nmos
M$1 iovss gate pad \$2 sg13_hv_nmos L=0.6u W=35.2u AS=18.656p AD=16.016p
+ PS=61.28u PD=42.48u rfmode=0
* device instance $3 r0 *1 11.175,4.95 sg13_hv_nmos
M$3 iovss gate pad$1 \$2 sg13_hv_nmos L=0.6u W=35.2u AS=16.016p AD=16.016p
+ PS=42.48u PD=42.48u rfmode=0
* device instance $5 r0 *1 14.195,4.95 sg13_hv_nmos
M$5 iovss gate pad$2 \$2 sg13_hv_nmos L=0.6u W=35.2u AS=16.016p AD=16.016p
+ PS=42.48u PD=42.48u rfmode=0
* device instance $7 r0 *1 17.215,4.95 sg13_hv_nmos
M$7 iovss gate pad$3 \$2 sg13_hv_nmos L=0.6u W=35.2u AS=16.016p AD=16.016p
+ PS=42.48u PD=42.48u rfmode=0
* device instance $9 r0 *1 20.235,4.95 sg13_hv_nmos
M$9 iovss gate pad$4 \$2 sg13_hv_nmos L=0.6u W=35.2u AS=16.016p AD=16.016p
+ PS=42.48u PD=42.48u rfmode=0
* device instance $11 r0 *1 23.255,4.95 sg13_hv_nmos
M$11 iovss gate pad$5 \$2 sg13_hv_nmos L=0.6u W=35.2u AS=16.016p AD=16.016p
+ PS=42.48u PD=42.48u rfmode=0
* device instance $13 r0 *1 26.275,4.95 sg13_hv_nmos
M$13 iovss gate pad$6 \$2 sg13_hv_nmos L=0.6u W=35.2u AS=16.016p AD=16.016p
+ PS=42.48u PD=42.48u rfmode=0
* device instance $15 r0 *1 29.295,4.95 sg13_hv_nmos
M$15 iovss gate pad$7 \$2 sg13_hv_nmos L=0.6u W=35.2u AS=16.016p AD=16.016p
+ PS=42.48u PD=42.48u rfmode=0
* device instance $17 r0 *1 32.315,4.95 sg13_hv_nmos
M$17 iovss gate pad$8 \$2 sg13_hv_nmos L=0.6u W=35.2u AS=16.016p AD=16.016p
+ PS=42.48u PD=42.48u rfmode=0
* device instance $19 r0 *1 35.335,4.95 sg13_hv_nmos
M$19 iovss gate pad$9 \$2 sg13_hv_nmos L=0.6u W=35.2u AS=16.016p AD=16.016p
+ PS=42.48u PD=42.48u rfmode=0
* device instance $21 r0 *1 38.355,4.95 sg13_hv_nmos
M$21 iovss gate pad$10 \$2 sg13_hv_nmos L=0.6u W=35.2u AS=16.016p AD=16.016p
+ PS=42.48u PD=42.48u rfmode=0
* device instance $23 r0 *1 41.375,4.95 sg13_hv_nmos
M$23 iovss gate pad$11 \$2 sg13_hv_nmos L=0.6u W=35.2u AS=16.016p AD=16.016p
+ PS=42.48u PD=42.48u rfmode=0
* device instance $25 r0 *1 44.395,4.95 sg13_hv_nmos
M$25 iovss gate pad$12 \$2 sg13_hv_nmos L=0.6u W=35.2u AS=16.016p AD=16.016p
+ PS=42.48u PD=42.48u rfmode=0
* device instance $27 r0 *1 47.415,4.95 sg13_hv_nmos
M$27 iovss gate pad$13 \$2 sg13_hv_nmos L=0.6u W=35.2u AS=16.016p AD=16.016p
+ PS=42.48u PD=42.48u rfmode=0
* device instance $29 r0 *1 50.435,4.95 sg13_hv_nmos
M$29 iovss gate pad$14 \$2 sg13_hv_nmos L=0.6u W=35.2u AS=16.016p AD=16.016p
+ PS=42.48u PD=42.48u rfmode=0
* device instance $31 r0 *1 53.455,4.95 sg13_hv_nmos
M$31 iovss gate pad$15 \$2 sg13_hv_nmos L=0.6u W=35.2u AS=16.016p AD=16.016p
+ PS=42.48u PD=42.48u rfmode=0
* device instance $33 r0 *1 56.475,4.95 sg13_hv_nmos
M$33 iovss gate pad$16 \$2 sg13_hv_nmos L=0.6u W=35.2u AS=16.016p AD=16.016p
+ PS=42.48u PD=42.48u rfmode=0
* device instance $35 r0 *1 59.495,4.95 sg13_hv_nmos
M$35 iovss gate pad$17 \$2 sg13_hv_nmos L=0.6u W=35.2u AS=16.016p AD=16.016p
+ PS=42.48u PD=42.48u rfmode=0
* device instance $37 r0 *1 62.515,4.95 sg13_hv_nmos
M$37 iovss gate pad$18 \$2 sg13_hv_nmos L=0.6u W=35.2u AS=16.016p AD=16.016p
+ PS=42.48u PD=42.48u rfmode=0
* device instance $39 r0 *1 65.535,4.95 sg13_hv_nmos
M$39 iovss gate pad$19 \$2 sg13_hv_nmos L=0.6u W=35.2u AS=16.016p AD=16.016p
+ PS=42.48u PD=42.48u rfmode=0
* device instance $41 r0 *1 68.555,4.95 sg13_hv_nmos
M$41 iovss gate pad$20 \$2 sg13_hv_nmos L=0.6u W=35.2u AS=16.016p AD=16.016p
+ PS=42.48u PD=42.48u rfmode=0
* device instance $43 r0 *1 71.575,4.95 sg13_hv_nmos
M$43 iovss gate pad$21 \$2 sg13_hv_nmos L=0.6u W=17.6u AS=5.632p AD=13.024p
+ PS=20.16u PD=41.12u rfmode=0
* device instance $173 r0 *1 4.77,20.98 dantenna
D$173 \$2 gate dantenna A=0.2304p P=1.92u m=1
* device instance $174 r0 *1 40,12.21 ptap1
R$174 iovss \$2 ptap1 A=65.6472p P=386.16u
.ENDS sg13g2_Clamp_N43N43D4R

* cell sg13g2_RCClampInverter
* pin
* pin iovss
* pin in
* pin out
* pin supply
.SUBCKT sg13g2_RCClampInverter \$1 iovss in out supply
* device instance $1 r0 *1 7.72,15.79 sg13_hv_nmos
M$1 iovss in iovss \$1 sg13_hv_nmos L=9.5u W=126u AS=26.64p AD=23.94p
+ PS=149.92u PD=131.32u rfmode=0
* device instance $8 r0 *1 72.38,15.79 sg13_hv_nmos
M$8 iovss in out \$1 sg13_hv_nmos L=0.5u W=108u AS=20.52p AD=23.22p PS=112.56u
+ PD=131.16u rfmode=0
* device instance $27 r0 *1 18.44,29.91 sg13_hv_pmos
M$27 supply in out supply sg13_hv_pmos L=0.5u W=350u AS=67.55p AD=67.55p
+ PS=376.3u PD=376.3u rfmode=0
* device instance $77 r0 *1 40,11.165 ptap1
R$77 iovss \$1 ptap1 A=69.122p P=406.6u
.ENDS sg13g2_RCClampInverter

* cell sg13g2_DCPDiode
* pin
* pin guard
* pin cathode
* pin anode
* pin anode
.SUBCKT sg13g2_DCPDiode \$1 guard cathode anode anode$1
* device instance $1 r0 *1 16.53,7.38 dpantenna
D$1 anode$1 cathode dpantenna A=35.0028p P=58.08u m=1
* device instance $2 r0 *1 16.53,2.88 dpantenna
D$2 anode cathode dpantenna A=35.0028p P=58.08u m=1
* device instance $3 r0 *1 16.53,5.13 ptap1
R$3 guard \$1 ptap1 A=33.5104p P=197.12u
.ENDS sg13g2_DCPDiode

* cell sg13g2_DCNDiode
* pin
* pin anode
* pin cathode
* pin cathode
.SUBCKT sg13g2_DCNDiode \$2 anode cathode cathode$1
* device instance $1 r0 *1 16.53,7.38 dantenna
D$1 \$2 cathode$1 dantenna A=35.0028p P=58.08u m=1
* device instance $2 r0 *1 16.53,2.88 dantenna
D$2 \$2 cathode dantenna A=35.0028p P=58.08u m=1
* device instance $3 r0 *1 16.53,5.13 ptap1
R$3 anode \$2 ptap1 A=141.2964p P=221.76u
.ENDS sg13g2_DCNDiode

* cell sg13g2_GateLevelUpInv
* pin iovdd
* pin vdd
* pin vss
* pin pgate
* pin ngate
* pin core
* pin
.SUBCKT sg13g2_GateLevelUpInv iovdd vdd vss pgate ngate core \$7
* cell instance $1 r0 *1 0,-19.5
X$1 iovdd ngate \$7 core vss vdd sg13g2_LevelUpInv
* cell instance $2 r0 *1 3.51,-19.5
X$2 iovdd pgate \$7 core vss vdd sg13g2_LevelUpInv
.ENDS sg13g2_GateLevelUpInv

* cell sg13g2_Clamp_N15N15D
* pin
* pin iovss
* pin pad
* pin pad
* pin pad
* pin pad
* pin pad
* pin pad
* pin pad
* pin pad
* pin gate
.SUBCKT sg13g2_Clamp_N15N15D \$2 iovss pad pad$1 pad$2 pad$3 pad$4 pad$5 pad$6
+ pad$7 gate
* device instance $1 r0 *1 29.295,4.95 sg13_hv_nmos
M$1 iovss gate pad \$2 sg13_hv_nmos L=0.6u W=8.8u AS=4.664p AD=4.004p PS=15.32u
+ PD=10.62u rfmode=0
* device instance $3 r0 *1 32.315,4.95 sg13_hv_nmos
M$3 iovss gate pad$1 \$2 sg13_hv_nmos L=0.6u W=8.8u AS=4.004p AD=4.004p
+ PS=10.62u PD=10.62u rfmode=0
* device instance $5 r0 *1 35.335,4.95 sg13_hv_nmos
M$5 iovss gate pad$2 \$2 sg13_hv_nmos L=0.6u W=8.8u AS=4.004p AD=4.004p
+ PS=10.62u PD=10.62u rfmode=0
* device instance $7 r0 *1 38.355,4.95 sg13_hv_nmos
M$7 iovss gate pad$3 \$2 sg13_hv_nmos L=0.6u W=8.8u AS=4.004p AD=4.004p
+ PS=10.62u PD=10.62u rfmode=0
* device instance $9 r0 *1 41.375,4.95 sg13_hv_nmos
M$9 iovss gate pad$4 \$2 sg13_hv_nmos L=0.6u W=8.8u AS=4.004p AD=4.004p
+ PS=10.62u PD=10.62u rfmode=0
* device instance $11 r0 *1 44.395,4.95 sg13_hv_nmos
M$11 iovss gate pad$5 \$2 sg13_hv_nmos L=0.6u W=8.8u AS=4.004p AD=4.004p
+ PS=10.62u PD=10.62u rfmode=0
* device instance $13 r0 *1 47.415,4.95 sg13_hv_nmos
M$13 iovss gate pad$6 \$2 sg13_hv_nmos L=0.6u W=8.8u AS=4.004p AD=4.004p
+ PS=10.62u PD=10.62u rfmode=0
* device instance $15 r0 *1 50.435,4.95 sg13_hv_nmos
M$15 iovss gate pad$7 \$2 sg13_hv_nmos L=0.6u W=4.4u AS=1.408p AD=3.256p
+ PS=5.04u PD=10.28u rfmode=0
* device instance $16 r0 *1 15.32,6.705 dantenna
D$16 \$2 gate dantenna A=0.6084p P=3.12u m=1
* device instance $17 r0 *1 40,4.95 ptap1
R$17 iovss \$2 ptap1 A=55.7736p P=328.08u
.ENDS sg13g2_Clamp_N15N15D

* cell sg13g2_Clamp_P15N15D
* pin
* pin iovss
* pin iovdd
* pin pad
* pin pad
* pin pad
* pin pad
* pin pad
* pin pad
* pin pad
* pin pad
* pin gate
.SUBCKT sg13g2_Clamp_P15N15D \$1 iovss iovdd pad pad$1 pad$2 pad$3 pad$4 pad$5
+ pad$6 pad$7 gate
* device instance $1 r0 *1 29.295,6.08 sg13_hv_pmos
M$1 iovdd gate pad iovdd sg13_hv_pmos L=0.6u W=26.64u AS=14.1192p AD=12.1212p
+ PS=44.2u PD=30.28u rfmode=0
* device instance $3 r0 *1 32.315,6.08 sg13_hv_pmos
M$3 iovdd gate pad$1 iovdd sg13_hv_pmos L=0.6u W=26.64u AS=12.1212p AD=12.1212p
+ PS=30.28u PD=30.28u rfmode=0
* device instance $5 r0 *1 35.335,6.08 sg13_hv_pmos
M$5 iovdd gate pad$2 iovdd sg13_hv_pmos L=0.6u W=26.64u AS=12.1212p AD=12.1212p
+ PS=30.28u PD=30.28u rfmode=0
* device instance $7 r0 *1 38.355,6.08 sg13_hv_pmos
M$7 iovdd gate pad$3 iovdd sg13_hv_pmos L=0.6u W=26.64u AS=12.1212p AD=12.1212p
+ PS=30.28u PD=30.28u rfmode=0
* device instance $9 r0 *1 41.375,6.08 sg13_hv_pmos
M$9 iovdd gate pad$4 iovdd sg13_hv_pmos L=0.6u W=26.64u AS=12.1212p AD=12.1212p
+ PS=30.28u PD=30.28u rfmode=0
* device instance $11 r0 *1 44.395,6.08 sg13_hv_pmos
M$11 iovdd gate pad$5 iovdd sg13_hv_pmos L=0.6u W=26.64u AS=12.1212p
+ AD=12.1212p PS=30.28u PD=30.28u rfmode=0
* device instance $13 r0 *1 47.415,6.08 sg13_hv_pmos
M$13 iovdd gate pad$6 iovdd sg13_hv_pmos L=0.6u W=26.64u AS=12.1212p
+ AD=12.1212p PS=30.28u PD=30.28u rfmode=0
* device instance $15 r0 *1 50.435,6.08 sg13_hv_pmos
M$15 iovdd gate pad$7 iovdd sg13_hv_pmos L=0.6u W=13.32u AS=4.2624p AD=9.8568p
+ PS=14.6u PD=29.6u rfmode=0
* device instance $31 r0 *1 15.35,16.1 dpantenna
D$31 gate iovdd dpantenna A=0.6084p P=3.12u m=1
* device instance $32 r0 *1 40,9.63 ptap1
R$32 iovss \$1 ptap1 A=67.0344p P=394.32u
.ENDS sg13g2_Clamp_P15N15D

* cell sg13g2_Clamp_P2N2D
* pin
* pin iovss
* pin iovdd
* pin pad
* pin gate
.SUBCKT sg13g2_Clamp_P2N2D \$1 iovss iovdd pad gate
* device instance $1 r0 *1 39.11,13.18 sg13_hv_pmos
M$1 iovdd gate pad iovdd sg13_hv_pmos L=0.6u W=26.64u AS=14.1192p AD=14.1192p
+ PS=44.2u PD=44.2u rfmode=0
* device instance $5 r0 *1 20.24,16.07 dpantenna
D$5 gate iovdd dpantenna A=0.2304p P=1.92u m=1
* device instance $6 r0 *1 40,9.63 ptap1
R$6 iovss \$1 ptap1 A=67.0344p P=394.32u
.ENDS sg13g2_Clamp_P2N2D

* cell sg13g2_Clamp_N2N2D
* pin
* pin iovss
* pin gate
* pin pad
.SUBCKT sg13g2_Clamp_N2N2D \$2 iovss gate pad
* device instance $1 r0 *1 39.11,4.95 sg13_hv_nmos
M$1 iovss gate pad \$2 sg13_hv_nmos L=0.6u W=8.8u AS=4.664p AD=4.664p PS=15.32u
+ PD=15.32u rfmode=0
* device instance $3 r0 *1 20.24,6.74 dantenna
D$3 \$2 gate dantenna A=0.6084p P=3.12u m=1
* device instance $4 r0 *1 40,4.95 ptap1
R$4 iovss \$2 ptap1 A=55.7736p P=328.08u
.ENDS sg13g2_Clamp_N2N2D

* cell sg13g2_Clamp_P20N0D
* pin
* pin iovss
* pin iovdd
* pin pad
* pin pad
* pin pad
* pin pad
* pin pad
* pin pad
* pin pad
* pin pad
* pin pad
* pin pad
.SUBCKT sg13g2_Clamp_P20N0D \$1 iovss iovdd pad pad$1 pad$2 pad$3 pad$4 pad$5
+ pad$6 pad$7 pad$8 pad$9
* device instance $1 r0 *1 25.52,13.18 sg13_hv_pmos
M$1 iovdd \$5 pad iovdd sg13_hv_pmos L=0.6u W=26.64u AS=14.1192p AD=12.1212p
+ PS=44.2u PD=30.28u rfmode=0
* device instance $3 r0 *1 28.54,13.18 sg13_hv_pmos
M$3 iovdd \$5 pad$1 iovdd sg13_hv_pmos L=0.6u W=26.64u AS=12.1212p AD=12.1212p
+ PS=30.28u PD=30.28u rfmode=0
* device instance $5 r0 *1 31.56,13.18 sg13_hv_pmos
M$5 iovdd \$5 pad$2 iovdd sg13_hv_pmos L=0.6u W=26.64u AS=12.1212p AD=12.1212p
+ PS=30.28u PD=30.28u rfmode=0
* device instance $7 r0 *1 34.58,13.18 sg13_hv_pmos
M$7 iovdd \$5 pad$3 iovdd sg13_hv_pmos L=0.6u W=26.64u AS=12.1212p AD=12.1212p
+ PS=30.28u PD=30.28u rfmode=0
* device instance $9 r0 *1 37.6,13.18 sg13_hv_pmos
M$9 iovdd \$5 pad$4 iovdd sg13_hv_pmos L=0.6u W=26.64u AS=12.1212p AD=12.1212p
+ PS=30.28u PD=30.28u rfmode=0
* device instance $11 r0 *1 40.62,13.18 sg13_hv_pmos
M$11 iovdd \$5 pad$5 iovdd sg13_hv_pmos L=0.6u W=26.64u AS=12.1212p AD=12.1212p
+ PS=30.28u PD=30.28u rfmode=0
* device instance $13 r0 *1 43.64,13.18 sg13_hv_pmos
M$13 iovdd \$5 pad$6 iovdd sg13_hv_pmos L=0.6u W=26.64u AS=12.1212p AD=12.1212p
+ PS=30.28u PD=30.28u rfmode=0
* device instance $15 r0 *1 46.66,13.18 sg13_hv_pmos
M$15 iovdd \$5 pad$7 iovdd sg13_hv_pmos L=0.6u W=26.64u AS=12.1212p AD=12.1212p
+ PS=30.28u PD=30.28u rfmode=0
* device instance $17 r0 *1 49.68,13.18 sg13_hv_pmos
M$17 iovdd \$5 pad$8 iovdd sg13_hv_pmos L=0.6u W=26.64u AS=12.1212p AD=12.1212p
+ PS=30.28u PD=30.28u rfmode=0
* device instance $19 r0 *1 52.7,13.18 sg13_hv_pmos
M$19 iovdd \$5 pad$9 iovdd sg13_hv_pmos L=0.6u W=26.64u AS=12.1212p AD=14.1192p
+ PS=30.28u PD=44.2u rfmode=0
* device instance $41 r0 *1 66.3,3.175 rppd
R$41 iovdd \$5 iovdd rppd w=0.5u l=12.9u ps=0u b=0 m=1
* device instance $42 r0 *1 40,9.63 ptap1
R$42 iovss \$1 ptap1 A=67.0344p P=394.32u
.ENDS sg13g2_Clamp_P20N0D

* cell sg13g2_Clamp_N20N0D
* pin
* pin iovss
* pin pad
* pin pad
* pin pad
* pin pad
* pin pad
* pin pad
* pin pad
* pin pad
* pin pad
* pin pad
.SUBCKT sg13g2_Clamp_N20N0D \$2 iovss pad pad$1 pad$2 pad$3 pad$4 pad$5 pad$6
+ pad$7 pad$8 pad$9
* device instance $1 r0 *1 25.52,4.95 sg13_hv_nmos
M$1 iovss \$4 pad \$2 sg13_hv_nmos L=0.6u W=8.8u AS=4.664p AD=4.004p PS=15.32u
+ PD=10.62u rfmode=0
* device instance $3 r0 *1 28.54,4.95 sg13_hv_nmos
M$3 iovss \$4 pad$1 \$2 sg13_hv_nmos L=0.6u W=8.8u AS=4.004p AD=4.004p
+ PS=10.62u PD=10.62u rfmode=0
* device instance $5 r0 *1 31.56,4.95 sg13_hv_nmos
M$5 iovss \$4 pad$2 \$2 sg13_hv_nmos L=0.6u W=8.8u AS=4.004p AD=4.004p
+ PS=10.62u PD=10.62u rfmode=0
* device instance $7 r0 *1 34.58,4.95 sg13_hv_nmos
M$7 iovss \$4 pad$3 \$2 sg13_hv_nmos L=0.6u W=8.8u AS=4.004p AD=4.004p
+ PS=10.62u PD=10.62u rfmode=0
* device instance $9 r0 *1 37.6,4.95 sg13_hv_nmos
M$9 iovss \$4 pad$4 \$2 sg13_hv_nmos L=0.6u W=8.8u AS=4.004p AD=4.004p
+ PS=10.62u PD=10.62u rfmode=0
* device instance $11 r0 *1 40.62,4.95 sg13_hv_nmos
M$11 iovss \$4 pad$5 \$2 sg13_hv_nmos L=0.6u W=8.8u AS=4.004p AD=4.004p
+ PS=10.62u PD=10.62u rfmode=0
* device instance $13 r0 *1 43.64,4.95 sg13_hv_nmos
M$13 iovss \$4 pad$6 \$2 sg13_hv_nmos L=0.6u W=8.8u AS=4.004p AD=4.004p
+ PS=10.62u PD=10.62u rfmode=0
* device instance $15 r0 *1 46.66,4.95 sg13_hv_nmos
M$15 iovss \$4 pad$7 \$2 sg13_hv_nmos L=0.6u W=8.8u AS=4.004p AD=4.004p
+ PS=10.62u PD=10.62u rfmode=0
* device instance $17 r0 *1 49.68,4.95 sg13_hv_nmos
M$17 iovss \$4 pad$8 \$2 sg13_hv_nmos L=0.6u W=8.8u AS=4.004p AD=4.004p
+ PS=10.62u PD=10.62u rfmode=0
* device instance $19 r0 *1 52.7,4.95 sg13_hv_nmos
M$19 iovss \$4 pad$9 \$2 sg13_hv_nmos L=0.6u W=8.8u AS=4.004p AD=4.664p
+ PS=10.62u PD=15.32u rfmode=0
* device instance $21 r0 *1 66.3,3.175 rppd
R$21 iovss \$4 \$2 rppd w=0.5u l=3.54u ps=0u b=0 m=1
* device instance $22 r0 *1 40,5 ptap1
R$22 iovss \$2 ptap1 A=55.7736p P=328.08u
.ENDS sg13g2_Clamp_N20N0D

* cell g1_LevelDown_polyres
* pin
* pin iovss
* pin pad
* pin iovdd
* pin vss
* pin core
* pin vdd
.SUBCKT g1_LevelDown_polyres \$1 iovss pad iovdd vss core vdd
* device instance $1 r0 *1 0.51,10.505 sg13_lv_nmos
M$1 core \$20 vss \$1 sg13_lv_nmos L=0.13u W=2.75u AS=0.935p AD=0.935p PS=6.18u
+ PD=6.18u rfmode=0
* device instance $2 r0 *1 2.02,10.555 sg13_hv_nmos
M$2 vss \$7 \$20 \$1 sg13_hv_nmos L=0.45u W=2.65u AS=0.901p AD=0.5035p PS=5.98u
+ PD=3.03u rfmode=0
* device instance $3 r0 *1 2.85,10.555 sg13_hv_nmos
M$3 \$20 \$6 vdd \$1 sg13_hv_nmos L=0.45u W=2.65u AS=0.5035p AD=0.901p PS=3.03u
+ PD=5.98u rfmode=0
* device instance $4 r0 *1 10.01,-6.63 sg13_hv_nmos
M$4 \$6 \$10 iovss \$1 sg13_hv_nmos L=0.45u W=1.3u AS=0.442p AD=0.247p PS=3.28u
+ PD=1.68u rfmode=0
* device instance $5 r0 *1 10.84,-6.63 sg13_hv_nmos
M$5 iovss \$6 \$7 \$1 sg13_hv_nmos L=0.45u W=1.3u AS=0.247p AD=0.442p PS=1.68u
+ PD=3.28u rfmode=0
* device instance $6 r0 *1 0.51,15.495 sg13_lv_pmos
M$6 core \$20 vdd vdd sg13_lv_pmos L=0.13u W=4.75u AS=1.615p AD=1.615p
+ PS=10.18u PD=10.18u rfmode=0
* device instance $8 r0 *1 9.18,-2.23 sg13_hv_pmos
M$8 iovdd \$10 \$6 iovdd sg13_hv_pmos L=0.45u W=4.6u AS=1.219p AD=0.874p
+ PS=7.96u PD=5.36u rfmode=0
* device instance $10 r0 *1 10.84,-2.23 sg13_hv_pmos
M$10 iovdd \$6 \$7 iovdd sg13_hv_pmos L=0.45u W=4.6u AS=0.874p AD=1.219p
+ PS=5.36u PD=7.96u rfmode=0
* device instance $12 r0 *1 3.365,8.5 ptap1
R$12 vss \$1 ptap1 A=2.019p P=14.06u
* device instance $13 r0 *1 10.47,-8.18 ptap1
R$13 iovss \$1 ptap1 A=9.8344p P=59.08u
* device instance $14 r0 *1 5.48,-5.96 dantenna
D$14 \$1 \$10 dantenna A=1.984p P=7.48u m=1
* device instance $15 r0 *1 3.31,-0.99 dpantenna
D$15 \$10 iovdd dpantenna A=3.1872p P=11.24u m=1
* device instance $16 r0 *1 0.935,-6.965 rppd
R$16 pad \$10 \$1 rppd w=1u l=2u ps=0u b=0 m=1
.ENDS g1_LevelDown_polyres

* cell sg13g2_LevelUpInv
* pin iovdd
* pin o
* pin
* pin i
* pin vss
* pin vdd
.SUBCKT sg13g2_LevelUpInv iovdd o \$5 i vss vdd
* device instance $1 r0 *1 0.51,10.505 sg13_lv_nmos
M$1 \$6 i vss \$5 sg13_lv_nmos L=0.13u W=2.75u AS=0.935p AD=0.935p PS=6.18u
+ PD=6.18u rfmode=0
* device instance $2 r0 *1 2.84,6.82 sg13_hv_nmos
M$2 vss \$4 o \$5 sg13_hv_nmos L=0.45u W=1.9u AS=0.646p AD=0.646p PS=4.48u
+ PD=4.48u rfmode=0
* device instance $3 r0 *1 0.67,6.82 sg13_hv_nmos
M$3 \$3 i vss \$5 sg13_hv_nmos L=0.45u W=1.9u AS=0.646p AD=0.361p PS=4.48u
+ PD=2.28u rfmode=0
* device instance $4 r0 *1 1.5,6.82 sg13_hv_nmos
M$4 vss \$6 \$4 \$5 sg13_hv_nmos L=0.45u W=1.9u AS=0.361p AD=0.646p PS=2.28u
+ PD=4.48u rfmode=0
* device instance $5 r0 *1 0.51,15.495 sg13_lv_pmos
M$5 \$6 i vdd vdd sg13_lv_pmos L=0.13u W=4.75u AS=1.615p AD=1.615p PS=10.18u
+ PD=10.18u rfmode=0
* device instance $6 r0 *1 2.84,2.68 sg13_hv_pmos
M$6 iovdd \$4 o iovdd sg13_hv_pmos L=0.45u W=3.9u AS=1.326p AD=1.326p PS=8.48u
+ PD=8.48u rfmode=0
* device instance $7 r0 *1 0.67,2.68 sg13_hv_pmos
M$7 \$3 \$4 iovdd iovdd sg13_hv_pmos L=0.45u W=0.3u AS=0.102p AD=0.057p
+ PS=1.28u PD=0.68u rfmode=0
* device instance $8 r0 *1 1.5,2.68 sg13_hv_pmos
M$8 iovdd \$3 \$4 iovdd sg13_hv_pmos L=0.45u W=0.3u AS=0.057p AD=0.102p
+ PS=0.68u PD=1.28u rfmode=0
* device instance $9 r0 *1 1.755,8.5 ptap1
R$9 vss \$5 ptap1 A=1.053p P=7.62u
.ENDS sg13g2_LevelUpInv
