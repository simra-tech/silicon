* Extracted by KLayout with SG13G2 LVS runset on : 20/10/2026 12:41

* cell r1_padring
* pin $1.c2p
* pin $10.padres
* pin $11.padres
* pin $12.p2c
* pin $13.p2c
* pin $14.p2c
* pin $2.c2p
* pin $237182.padres
* pin $3.c2p
* pin $344752.c2p
* pin $344864.p2c
* pin $4.padres
* pin $5.padres
* pin $6.padres
* pin $7.padres
* pin $8.padres
* pin $88229.c2p
* pin $9.padres
* pin COS_N
* pin COS_P
* pin CS_N
* pin EN_STO_IN
* pin FAULT_N
* pin GATE_A
* pin GATE_B
* pin GATE_C
* pin IOVDD
* pin IOVSS
* pin ISA_N
* pin ISA_P
* pin ISB_N
* pin ISB_P
* pin MA_SCLK
* pin SDI
* pin SIN_N
* pin SIN_P
* pin SLO_SDO
* pin VDD
* pin VDDA
* pin VSS
.SUBCKT r1_padring \$1.c2p \$10.padres \$11.padres \$12.p2c \$13.p2c \$14.p2c
+ \$2.c2p \$237182.padres \$3.c2p \$344752.c2p \$344864.p2c \$4.padres
+ \$5.padres \$6.padres \$7.padres \$8.padres \$88229.c2p \$9.padres COS_N
+ COS_P CS_N EN_STO_IN FAULT_N GATE_A GATE_B GATE_C IOVDD IOVSS ISA_N ISA_P
+ ISB_N ISB_P MA_SCLK SDI SIN_N SIN_P SLO_SDO VDD VDDA VSS
* device instance $1 r0 *1 395,243.585 ptap1
R$1 IOVSS \$1 ptap1 A=235272.8205p P=63576.848u
* device instance $2 r0 *1 395,298 ptap1
R$2 VSS \$1 ptap1 A=981.3216p P=6621.536u
* device instance $542 m0 *1 415.12,198.715 rppd
R$542 \$I354860 VDD \$1 rppd w=1u l=520u ps=0u b=0 m=1
* device instance $543 r0 *1 363.155,151.95 sg13_hv_nmos
M$543 IOVSS \$I354861 VDD \$1 sg13_hv_nmos L=0.6u W=756.8u AS=344.608p
+ AD=349.36p PS=931.04u PD=933.2u rfmode=0
* device instance $715 r0 *1 359.77,167.98 dantenna
D$715 \$1 \$I354861 dantenna A=0.2304p P=1.92u m=1
* device instance $717 m90 *1 427.28,221.79 sg13_hv_nmos
M$717 IOVSS \$I354860 IOVSS \$1 sg13_hv_nmos L=9.5u W=126u AS=26.64p AD=23.94p
+ PS=149.92u PD=131.32u rfmode=0
* device instance $724 m90 *1 362.62,221.79 sg13_hv_nmos
M$724 IOVSS \$I354860 \$I354861 \$1 sg13_hv_nmos L=0.5u W=108u AS=20.52p
+ AD=23.22p PS=112.56u PD=131.16u rfmode=0
* device instance $743 m90 *1 416.56,235.91 sg13_hv_pmos
M$743 VDD \$I354860 \$I354861 VDD sg13_hv_pmos L=0.5u W=350u AS=67.55p
+ AD=67.55p PS=376.3u PD=376.3u rfmode=0
* device instance $794 r90 *1 807.54,224.19 dpantenna
D$794 VSS IOVDD dpantenna A=35.0028p P=58.08u m=4
* device instance $800 r90 *1 807.54,165.19 dantenna
D$800 \$1 VSS dantenna A=35.0028p P=58.08u m=4
* device instance $831 m0 *1 639.12,198.715 rppd
R$831 \$I354862 IOVDD \$1 rppd w=1u l=520u ps=0u b=0 m=1
* device instance $832 r0 *1 587.155,151.95 sg13_hv_nmos
M$832 IOVSS \$I354863 IOVDD \$1 sg13_hv_nmos L=0.6u W=756.8u AS=344.608p
+ AD=349.36p PS=931.04u PD=933.2u rfmode=0
* device instance $1004 r0 *1 583.77,167.98 dantenna
D$1004 \$1 \$I354863 dantenna A=0.2304p P=1.92u m=1
* device instance $1006 m90 *1 651.28,221.79 sg13_hv_nmos
M$1006 IOVSS \$I354862 IOVSS \$1 sg13_hv_nmos L=9.5u W=126u AS=26.64p AD=23.94p
+ PS=149.92u PD=131.32u rfmode=0
* device instance $1013 m90 *1 586.62,221.79 sg13_hv_nmos
M$1013 IOVSS \$I354862 \$I354863 \$1 sg13_hv_nmos L=0.5u W=108u AS=20.52p
+ AD=23.22p PS=112.56u PD=131.16u rfmode=0
* device instance $1032 m90 *1 640.56,235.91 sg13_hv_pmos
M$1032 IOVDD \$I354862 \$I354863 IOVDD sg13_hv_pmos L=0.5u W=350u AS=67.55p
+ AD=67.55p PS=376.3u PD=376.3u rfmode=0
* device instance $1083 m0 *1 496.295,1262.05 sg13_hv_nmos
M$1083 IOVSS \$I354864 GATE_B \$1 sg13_hv_nmos L=0.6u W=66u AS=30.096p
+ AD=31.284p PS=84.08u PD=84.62u rfmode=0
* device instance $1098 m0 *1 482.32,1260.295 dantenna
D$1098 \$1 \$I354864 dantenna A=0.6084p P=3.12u m=1
* device instance $1100 m0 *1 608.295,1262.05 sg13_hv_nmos
M$1100 IOVSS \$I354867 GATE_C \$1 sg13_hv_nmos L=0.6u W=66u AS=30.096p
+ AD=31.284p PS=84.08u PD=84.62u rfmode=0
* device instance $1115 m0 *1 594.32,1260.295 dantenna
D$1115 \$1 \$I354867 dantenna A=0.6084p P=3.12u m=1
* device instance $1117 m0 *1 384.295,1262.05 sg13_hv_nmos
M$1117 IOVSS \$I354870 GATE_A \$1 sg13_hv_nmos L=0.6u W=66u AS=30.096p
+ AD=31.284p PS=84.08u PD=84.62u rfmode=0
* device instance $1132 m0 *1 370.32,1260.295 dantenna
D$1132 \$1 \$I354870 dantenna A=0.6084p P=3.12u m=1
* device instance $1134 m0 *1 496.295,1201.92 sg13_hv_pmos
M$1134 IOVDD \$I354865 GATE_B IOVDD sg13_hv_pmos L=0.6u W=199.8u AS=91.1088p
+ AD=94.7052p PS=240.48u PD=241.56u rfmode=0
* device instance $1164 m0 *1 482.35,1191.9 dpantenna
D$1164 \$I354865 IOVDD dpantenna A=0.6084p P=3.12u m=1
* device instance $1166 m0 *1 608.295,1201.92 sg13_hv_pmos
M$1166 IOVDD \$I354868 GATE_C IOVDD sg13_hv_pmos L=0.6u W=199.8u AS=91.1088p
+ AD=94.7052p PS=240.48u PD=241.56u rfmode=0
* device instance $1196 m0 *1 594.35,1191.9 dpantenna
D$1196 \$I354868 IOVDD dpantenna A=0.6084p P=3.12u m=1
* device instance $1198 m0 *1 384.295,1201.92 sg13_hv_pmos
M$1198 IOVDD \$I354871 GATE_A IOVDD sg13_hv_pmos L=0.6u W=199.8u AS=91.1088p
+ AD=94.7052p PS=240.48u PD=241.56u rfmode=0
* device instance $1228 m0 *1 370.35,1191.9 dpantenna
D$1228 \$I354871 IOVDD dpantenna A=0.6084p P=3.12u m=1
* device instance $1230 m0 *1 507,1212.54 dpantenna
D$1230 GATE_B IOVDD dpantenna A=35.0028p P=58.08u m=2
* device instance $1233 m0 *1 619,1212.54 dpantenna
D$1233 GATE_C IOVDD dpantenna A=35.0028p P=58.08u m=2
* device instance $1236 m0 *1 395,1212.54 dpantenna
D$1236 GATE_A IOVDD dpantenna A=35.0028p P=58.08u m=2
* device instance $1239 m0 *1 507,1248.06 dantenna
D$1239 \$1 GATE_B dantenna A=35.0028p P=58.08u m=2
* device instance $1242 m0 *1 619,1248.06 dantenna
D$1242 \$1 GATE_C dantenna A=35.0028p P=58.08u m=2
* device instance $1245 m0 *1 395,1248.06 dantenna
D$1245 \$1 GATE_A dantenna A=35.0028p P=58.08u m=2
* device instance $1248 m0 *1 954.11,1194.82 sg13_hv_pmos
M$1248 IOVDD \$I354874 SLO_SDO IOVDD sg13_hv_pmos L=0.6u W=26.64u AS=14.1192p
+ AD=14.1192p PS=44.2u PD=44.2u rfmode=0
* device instance $1252 m0 *1 935.24,1191.93 dpantenna
D$1252 \$I354874 IOVDD dpantenna A=0.2304p P=1.92u m=1
* device instance $1254 r90 *1 1194.82,954.11 sg13_hv_pmos
M$1254 IOVDD \$I354877 FAULT_N IOVDD sg13_hv_pmos L=0.6u W=26.64u AS=14.1192p
+ AD=14.1192p PS=44.2u PD=44.2u rfmode=0
* device instance $1258 r90 *1 1191.93,935.24 dpantenna
D$1258 \$I354877 IOVDD dpantenna A=0.2304p P=1.92u m=1
* device instance $1260 m0 *1 954.11,1262.05 sg13_hv_nmos
M$1260 IOVSS \$I354873 SLO_SDO \$1 sg13_hv_nmos L=0.6u W=8.8u AS=4.664p
+ AD=4.664p PS=15.32u PD=15.32u rfmode=0
* device instance $1262 m0 *1 935.24,1260.26 dantenna
D$1262 \$1 \$I354873 dantenna A=0.6084p P=3.12u m=1
* device instance $1264 r90 *1 1262.05,954.11 sg13_hv_nmos
M$1264 IOVSS \$I354876 FAULT_N \$1 sg13_hv_nmos L=0.6u W=8.8u AS=4.664p
+ AD=4.664p PS=15.32u PD=15.32u rfmode=0
* device instance $1266 r90 *1 1260.26,935.24 dantenna
D$1266 \$1 \$I354876 dantenna A=0.6084p P=3.12u m=1
* device instance $1268 m0 *1 955,1212.54 dpantenna
D$1268 SLO_SDO IOVDD dpantenna A=35.0028p P=58.08u m=2
* device instance $1271 r90 *1 1212.54,955 dpantenna
D$1271 FAULT_N IOVDD dpantenna A=35.0028p P=58.08u m=2
* device instance $1274 m0 *1 955,1248.06 dantenna
D$1274 \$1 SLO_SDO dantenna A=35.0028p P=58.08u m=2
* device instance $1277 r90 *1 1248.06,955 dantenna
D$1277 \$1 FAULT_N dantenna A=35.0028p P=58.08u m=2
* device instance $1280 r90 *1 919.54,224.19 dpantenna
D$1280 IOVSS IOVDD dpantenna A=35.0028p P=58.08u m=4
* device instance $1286 r90 *1 919.54,165.19 dantenna
D$1286 \$1 IOVSS dantenna A=35.0028p P=58.08u m=4
* device instance $1292 m45 *1 283.54,636.63 dantenna
D$1292 \$1 \$4.padres dantenna A=1.984p P=7.48u m=1
* device instance $1293 m45 *1 288.51,634.46 dpantenna
D$1293 \$4.padres IOVDD dpantenna A=3.1872p P=11.24u m=1
* device instance $1294 m45 *1 282.535,632.085 rppd
R$1294 SIN_P \$4.padres \$1 rppd w=1u l=2u ps=0u b=0 m=1
* device instance $1297 m45 *1 283.54,972.63 dantenna
D$1297 \$1 \$5.padres dantenna A=1.984p P=7.48u m=1
* device instance $1298 m45 *1 288.51,970.46 dpantenna
D$1298 \$5.padres IOVDD dpantenna A=3.1872p P=11.24u m=1
* device instance $1299 m45 *1 282.535,968.085 rppd
R$1299 COS_N \$5.padres \$1 rppd w=1u l=2u ps=0u b=0 m=1
* device instance $1302 m45 *1 283.54,748.63 dantenna
D$1302 \$1 \$6.padres dantenna A=1.984p P=7.48u m=1
* device instance $1303 m45 *1 288.51,746.46 dpantenna
D$1303 \$6.padres IOVDD dpantenna A=3.1872p P=11.24u m=1
* device instance $1304 m45 *1 282.535,744.085 rppd
R$1304 SIN_N \$6.padres \$1 rppd w=1u l=2u ps=0u b=0 m=1
* device instance $1307 m45 *1 283.54,860.63 dantenna
D$1307 \$1 \$7.padres dantenna A=1.984p P=7.48u m=1
* device instance $1308 m45 *1 288.51,858.46 dpantenna
D$1308 \$7.padres IOVDD dpantenna A=3.1872p P=11.24u m=1
* device instance $1309 m45 *1 282.535,856.085 rppd
R$1309 COS_P \$7.padres \$1 rppd w=1u l=2u ps=0u b=0 m=1
* device instance $1312 r90 *1 1130.46,636.63 dantenna
D$1312 \$1 \$8.padres dantenna A=1.984p P=7.48u m=1
* device instance $1313 r90 *1 1125.49,634.46 dpantenna
D$1313 \$8.padres IOVDD dpantenna A=3.1872p P=11.24u m=1
* device instance $1314 r90 *1 1131.465,632.085 rppd
R$1314 ISA_N \$8.padres \$1 rppd w=1u l=2u ps=0u b=0 m=1
* device instance $1317 r90 *1 1130.46,524.63 dantenna
D$1317 \$1 \$9.padres dantenna A=1.984p P=7.48u m=1
* device instance $1318 r90 *1 1125.49,522.46 dpantenna
D$1318 \$9.padres IOVDD dpantenna A=3.1872p P=11.24u m=1
* device instance $1319 r90 *1 1131.465,520.085 rppd
R$1319 ISA_P \$9.padres \$1 rppd w=1u l=2u ps=0u b=0 m=1
* device instance $1322 r90 *1 1130.46,860.63 dantenna
D$1322 \$1 \$10.padres dantenna A=1.984p P=7.48u m=1
* device instance $1323 r90 *1 1125.49,858.46 dpantenna
D$1323 \$10.padres IOVDD dpantenna A=3.1872p P=11.24u m=1
* device instance $1324 r90 *1 1131.465,856.085 rppd
R$1324 ISB_N \$10.padres \$1 rppd w=1u l=2u ps=0u b=0 m=1
* device instance $1327 r90 *1 1130.46,748.63 dantenna
D$1327 \$1 \$11.padres dantenna A=1.984p P=7.48u m=1
* device instance $1328 r90 *1 1125.49,746.46 dpantenna
D$1328 \$11.padres IOVDD dpantenna A=3.1872p P=11.24u m=1
* device instance $1329 r90 *1 1131.465,744.085 rppd
R$1329 ISB_P \$11.padres \$1 rppd w=1u l=2u ps=0u b=0 m=1
* device instance $1332 r90 *1 1130.46,412.63 dantenna
D$1332 \$1 \$237182.padres dantenna A=1.984p P=7.48u m=1
* device instance $1333 r90 *1 1125.49,410.46 dpantenna
D$1333 \$237182.padres IOVDD dpantenna A=3.1872p P=11.24u m=1
* device instance $1334 r90 *1 1131.465,408.085 rppd
R$1334 VDDA \$237182.padres \$1 rppd w=1u l=2u ps=0u b=0 m=1
* device instance $1337 m45 *1 201.46,619 dpantenna
D$1337 SIN_P IOVDD dpantenna A=35.0028p P=58.08u m=2
* device instance $1340 m45 *1 201.46,955 dpantenna
D$1340 COS_N IOVDD dpantenna A=35.0028p P=58.08u m=2
* device instance $1343 m45 *1 201.46,731 dpantenna
D$1343 SIN_N IOVDD dpantenna A=35.0028p P=58.08u m=2
* device instance $1346 m45 *1 201.46,843 dpantenna
D$1346 COS_P IOVDD dpantenna A=35.0028p P=58.08u m=2
* device instance $1349 r90 *1 1212.54,619 dpantenna
D$1349 ISA_N IOVDD dpantenna A=35.0028p P=58.08u m=2
* device instance $1352 r90 *1 1212.54,507 dpantenna
D$1352 ISA_P IOVDD dpantenna A=35.0028p P=58.08u m=2
* device instance $1355 r90 *1 1212.54,843 dpantenna
D$1355 ISB_N IOVDD dpantenna A=35.0028p P=58.08u m=2
* device instance $1358 r90 *1 1212.54,731 dpantenna
D$1358 ISB_P IOVDD dpantenna A=35.0028p P=58.08u m=2
* device instance $1361 r90 *1 1212.54,395 dpantenna
D$1361 VDDA IOVDD dpantenna A=35.0028p P=58.08u m=2
* device instance $1364 m45 *1 165.94,619 dantenna
D$1364 \$1 SIN_P dantenna A=35.0028p P=58.08u m=2
* device instance $1367 m45 *1 165.94,955 dantenna
D$1367 \$1 COS_N dantenna A=35.0028p P=58.08u m=2
* device instance $1370 m45 *1 165.94,731 dantenna
D$1370 \$1 SIN_N dantenna A=35.0028p P=58.08u m=2
* device instance $1373 m45 *1 165.94,843 dantenna
D$1373 \$1 COS_P dantenna A=35.0028p P=58.08u m=2
* device instance $1376 r90 *1 1248.06,619 dantenna
D$1376 \$1 ISA_N dantenna A=35.0028p P=58.08u m=2
* device instance $1379 r90 *1 1248.06,507 dantenna
D$1379 \$1 ISA_P dantenna A=35.0028p P=58.08u m=2
* device instance $1382 r90 *1 1248.06,843 dantenna
D$1382 \$1 ISB_N dantenna A=35.0028p P=58.08u m=2
* device instance $1385 r90 *1 1248.06,731 dantenna
D$1385 \$1 ISB_P dantenna A=35.0028p P=58.08u m=2
* device instance $1388 r90 *1 1248.06,395 dantenna
D$1388 \$1 VDDA dantenna A=35.0028p P=58.08u m=2
* device instance $1391 m45 *1 219.18,604.52 sg13_hv_pmos
M$1391 IOVDD \$I354942 SIN_P IOVDD sg13_hv_pmos L=0.6u W=266.4u AS=123.21p
+ AD=123.21p PS=316.72u PD=316.72u rfmode=0
* device instance $1431 m45 *1 209.175,645.3 rppd
R$1431 IOVDD \$I354942 IOVDD rppd w=0.5u l=12.9u ps=0u b=0 m=1
* device instance $1433 m45 *1 219.18,940.52 sg13_hv_pmos
M$1433 IOVDD \$I354943 COS_N IOVDD sg13_hv_pmos L=0.6u W=266.4u AS=123.21p
+ AD=123.21p PS=316.72u PD=316.72u rfmode=0
* device instance $1473 m45 *1 209.175,981.3 rppd
R$1473 IOVDD \$I354943 IOVDD rppd w=0.5u l=12.9u ps=0u b=0 m=1
* device instance $1475 m45 *1 219.18,716.52 sg13_hv_pmos
M$1475 IOVDD \$I354944 SIN_N IOVDD sg13_hv_pmos L=0.6u W=266.4u AS=123.21p
+ AD=123.21p PS=316.72u PD=316.72u rfmode=0
* device instance $1515 m45 *1 209.175,757.3 rppd
R$1515 IOVDD \$I354944 IOVDD rppd w=0.5u l=12.9u ps=0u b=0 m=1
* device instance $1517 m45 *1 219.18,828.52 sg13_hv_pmos
M$1517 IOVDD \$I354945 COS_P IOVDD sg13_hv_pmos L=0.6u W=266.4u AS=123.21p
+ AD=123.21p PS=316.72u PD=316.72u rfmode=0
* device instance $1557 m45 *1 209.175,869.3 rppd
R$1557 IOVDD \$I354945 IOVDD rppd w=0.5u l=12.9u ps=0u b=0 m=1
* device instance $1559 r90 *1 1194.82,604.52 sg13_hv_pmos
M$1559 IOVDD \$I354946 ISA_N IOVDD sg13_hv_pmos L=0.6u W=266.4u AS=123.21p
+ AD=123.21p PS=316.72u PD=316.72u rfmode=0
* device instance $1599 r90 *1 1204.825,645.3 rppd
R$1599 IOVDD \$I354946 IOVDD rppd w=0.5u l=12.9u ps=0u b=0 m=1
* device instance $1601 r90 *1 1194.82,492.52 sg13_hv_pmos
M$1601 IOVDD \$I354947 ISA_P IOVDD sg13_hv_pmos L=0.6u W=266.4u AS=123.21p
+ AD=123.21p PS=316.72u PD=316.72u rfmode=0
* device instance $1641 r90 *1 1204.825,533.3 rppd
R$1641 IOVDD \$I354947 IOVDD rppd w=0.5u l=12.9u ps=0u b=0 m=1
* device instance $1643 r90 *1 1194.82,828.52 sg13_hv_pmos
M$1643 IOVDD \$I354948 ISB_N IOVDD sg13_hv_pmos L=0.6u W=266.4u AS=123.21p
+ AD=123.21p PS=316.72u PD=316.72u rfmode=0
* device instance $1683 r90 *1 1204.825,869.3 rppd
R$1683 IOVDD \$I354948 IOVDD rppd w=0.5u l=12.9u ps=0u b=0 m=1
* device instance $1685 r90 *1 1194.82,716.52 sg13_hv_pmos
M$1685 IOVDD \$I354949 ISB_P IOVDD sg13_hv_pmos L=0.6u W=266.4u AS=123.21p
+ AD=123.21p PS=316.72u PD=316.72u rfmode=0
* device instance $1725 r90 *1 1204.825,757.3 rppd
R$1725 IOVDD \$I354949 IOVDD rppd w=0.5u l=12.9u ps=0u b=0 m=1
* device instance $1727 r90 *1 1194.82,380.52 sg13_hv_pmos
M$1727 IOVDD \$I354950 VDDA IOVDD sg13_hv_pmos L=0.6u W=266.4u AS=123.21p
+ AD=123.21p PS=316.72u PD=316.72u rfmode=0
* device instance $1767 r90 *1 1204.825,421.3 rppd
R$1767 IOVDD \$I354950 IOVDD rppd w=0.5u l=12.9u ps=0u b=0 m=1
* device instance $1769 m45 *1 151.95,604.52 sg13_hv_nmos
M$1769 IOVSS \$I354951 SIN_P \$1 sg13_hv_nmos L=0.6u W=88u AS=40.7p AD=40.7p
+ PS=110.9u PD=110.9u rfmode=0
* device instance $1789 m45 *1 150.175,645.3 rppd
R$1789 IOVSS \$I354951 \$1 rppd w=0.5u l=3.54u ps=0u b=0 m=1
* device instance $1791 m45 *1 151.95,940.52 sg13_hv_nmos
M$1791 IOVSS \$I354952 COS_N \$1 sg13_hv_nmos L=0.6u W=88u AS=40.7p AD=40.7p
+ PS=110.9u PD=110.9u rfmode=0
* device instance $1811 m45 *1 150.175,981.3 rppd
R$1811 IOVSS \$I354952 \$1 rppd w=0.5u l=3.54u ps=0u b=0 m=1
* device instance $1813 m45 *1 151.95,716.52 sg13_hv_nmos
M$1813 IOVSS \$I354953 SIN_N \$1 sg13_hv_nmos L=0.6u W=88u AS=40.7p AD=40.7p
+ PS=110.9u PD=110.9u rfmode=0
* device instance $1833 m45 *1 150.175,757.3 rppd
R$1833 IOVSS \$I354953 \$1 rppd w=0.5u l=3.54u ps=0u b=0 m=1
* device instance $1835 m45 *1 151.95,828.52 sg13_hv_nmos
M$1835 IOVSS \$I354954 COS_P \$1 sg13_hv_nmos L=0.6u W=88u AS=40.7p AD=40.7p
+ PS=110.9u PD=110.9u rfmode=0
* device instance $1855 m45 *1 150.175,869.3 rppd
R$1855 IOVSS \$I354954 \$1 rppd w=0.5u l=3.54u ps=0u b=0 m=1
* device instance $1857 r90 *1 1262.05,604.52 sg13_hv_nmos
M$1857 IOVSS \$I354955 ISA_N \$1 sg13_hv_nmos L=0.6u W=88u AS=40.7p AD=40.7p
+ PS=110.9u PD=110.9u rfmode=0
* device instance $1877 r90 *1 1263.825,645.3 rppd
R$1877 IOVSS \$I354955 \$1 rppd w=0.5u l=3.54u ps=0u b=0 m=1
* device instance $1879 r90 *1 1262.05,492.52 sg13_hv_nmos
M$1879 IOVSS \$I354956 ISA_P \$1 sg13_hv_nmos L=0.6u W=88u AS=40.7p AD=40.7p
+ PS=110.9u PD=110.9u rfmode=0
* device instance $1899 r90 *1 1263.825,533.3 rppd
R$1899 IOVSS \$I354956 \$1 rppd w=0.5u l=3.54u ps=0u b=0 m=1
* device instance $1901 r90 *1 1262.05,828.52 sg13_hv_nmos
M$1901 IOVSS \$I354957 ISB_N \$1 sg13_hv_nmos L=0.6u W=88u AS=40.7p AD=40.7p
+ PS=110.9u PD=110.9u rfmode=0
* device instance $1921 r90 *1 1263.825,869.3 rppd
R$1921 IOVSS \$I354957 \$1 rppd w=0.5u l=3.54u ps=0u b=0 m=1
* device instance $1923 r90 *1 1262.05,716.52 sg13_hv_nmos
M$1923 IOVSS \$I354958 ISB_P \$1 sg13_hv_nmos L=0.6u W=88u AS=40.7p AD=40.7p
+ PS=110.9u PD=110.9u rfmode=0
* device instance $1943 r90 *1 1263.825,757.3 rppd
R$1943 IOVSS \$I354958 \$1 rppd w=0.5u l=3.54u ps=0u b=0 m=1
* device instance $1945 r90 *1 1262.05,380.52 sg13_hv_nmos
M$1945 IOVSS \$I354959 VDDA \$1 sg13_hv_nmos L=0.6u W=88u AS=40.7p AD=40.7p
+ PS=110.9u PD=110.9u rfmode=0
* device instance $1965 r90 *1 1263.825,421.3 rppd
R$1965 IOVSS \$I354959 \$1 rppd w=0.5u l=3.54u ps=0u b=0 m=1
* device instance $1967 m45 *1 300.005,507.255 sg13_lv_nmos
M$1967 \$12.p2c \$I354963 VSS \$1 sg13_lv_nmos L=0.13u W=2.75u AS=0.935p
+ AD=0.935p PS=6.18u PD=6.18u rfmode=0
* device instance $1968 m45 *1 300.055,508.765 sg13_hv_nmos
M$1968 VSS \$I354961 \$I354963 \$1 sg13_hv_nmos L=0.45u W=2.65u AS=0.901p
+ AD=0.5035p PS=5.98u PD=3.03u rfmode=0
* device instance $1969 m45 *1 300.055,509.595 sg13_hv_nmos
M$1969 \$I354963 \$I354960 VDD \$1 sg13_hv_nmos L=0.45u W=2.65u AS=0.5035p
+ AD=0.901p PS=3.03u PD=5.98u rfmode=0
* device instance $1970 m45 *1 282.87,516.755 sg13_hv_nmos
M$1970 \$I354960 \$I354962 IOVSS \$1 sg13_hv_nmos L=0.45u W=1.3u AS=0.442p
+ AD=0.247p PS=3.28u PD=1.68u rfmode=0
* device instance $1971 m45 *1 282.87,517.585 sg13_hv_nmos
M$1971 IOVSS \$I354960 \$I354961 \$1 sg13_hv_nmos L=0.45u W=1.3u AS=0.247p
+ AD=0.442p PS=1.68u PD=3.28u rfmode=0
* device instance $1972 m45 *1 304.995,507.255 sg13_lv_pmos
M$1972 \$12.p2c \$I354963 VDD VDD sg13_lv_pmos L=0.13u W=4.75u AS=1.615p
+ AD=1.615p PS=10.18u PD=10.18u rfmode=0
* device instance $1973 m45 *1 287.27,515.925 sg13_hv_pmos
M$1973 IOVDD \$I354962 \$I354960 IOVDD sg13_hv_pmos L=0.45u W=4.6u AS=1.219p
+ AD=0.874p PS=7.96u PD=5.36u rfmode=0
* device instance $1975 m45 *1 287.27,517.585 sg13_hv_pmos
M$1975 IOVDD \$I354960 \$I354961 IOVDD sg13_hv_pmos L=0.45u W=4.6u AS=0.874p
+ AD=1.219p PS=5.36u PD=7.96u rfmode=0
* device instance $1979 m0 *1 731.255,1113.995 sg13_lv_nmos
M$1979 \$13.p2c \$I354967 VSS \$1 sg13_lv_nmos L=0.13u W=2.75u AS=0.935p
+ AD=0.935p PS=6.18u PD=6.18u rfmode=0
* device instance $1980 m0 *1 732.765,1113.945 sg13_hv_nmos
M$1980 VSS \$I354965 \$I354967 \$1 sg13_hv_nmos L=0.45u W=2.65u AS=0.901p
+ AD=0.5035p PS=5.98u PD=3.03u rfmode=0
* device instance $1981 m0 *1 733.595,1113.945 sg13_hv_nmos
M$1981 \$I354967 \$I354964 VDD \$1 sg13_hv_nmos L=0.45u W=2.65u AS=0.5035p
+ AD=0.901p PS=3.03u PD=5.98u rfmode=0
* device instance $1982 m0 *1 740.755,1131.13 sg13_hv_nmos
M$1982 \$I354964 \$I354966 IOVSS \$1 sg13_hv_nmos L=0.45u W=1.3u AS=0.442p
+ AD=0.247p PS=3.28u PD=1.68u rfmode=0
* device instance $1983 m0 *1 741.585,1131.13 sg13_hv_nmos
M$1983 IOVSS \$I354964 \$I354965 \$1 sg13_hv_nmos L=0.45u W=1.3u AS=0.247p
+ AD=0.442p PS=1.68u PD=3.28u rfmode=0
* device instance $1984 m0 *1 731.255,1109.005 sg13_lv_pmos
M$1984 \$13.p2c \$I354967 VDD VDD sg13_lv_pmos L=0.13u W=4.75u AS=1.615p
+ AD=1.615p PS=10.18u PD=10.18u rfmode=0
* device instance $1985 m0 *1 739.925,1126.73 sg13_hv_pmos
M$1985 IOVDD \$I354966 \$I354964 IOVDD sg13_hv_pmos L=0.45u W=4.6u AS=1.219p
+ AD=0.874p PS=7.96u PD=5.36u rfmode=0
* device instance $1987 m0 *1 741.585,1126.73 sg13_hv_pmos
M$1987 IOVDD \$I354964 \$I354965 IOVDD sg13_hv_pmos L=0.45u W=4.6u AS=0.874p
+ AD=1.219p PS=5.36u PD=7.96u rfmode=0
* device instance $1991 m0 *1 843.255,1113.995 sg13_lv_nmos
M$1991 \$14.p2c \$I354971 VSS \$1 sg13_lv_nmos L=0.13u W=2.75u AS=0.935p
+ AD=0.935p PS=6.18u PD=6.18u rfmode=0
* device instance $1992 m0 *1 844.765,1113.945 sg13_hv_nmos
M$1992 VSS \$I354969 \$I354971 \$1 sg13_hv_nmos L=0.45u W=2.65u AS=0.901p
+ AD=0.5035p PS=5.98u PD=3.03u rfmode=0
* device instance $1993 m0 *1 845.595,1113.945 sg13_hv_nmos
M$1993 \$I354971 \$I354968 VDD \$1 sg13_hv_nmos L=0.45u W=2.65u AS=0.5035p
+ AD=0.901p PS=3.03u PD=5.98u rfmode=0
* device instance $1994 m0 *1 852.755,1131.13 sg13_hv_nmos
M$1994 \$I354968 \$I354970 IOVSS \$1 sg13_hv_nmos L=0.45u W=1.3u AS=0.442p
+ AD=0.247p PS=3.28u PD=1.68u rfmode=0
* device instance $1995 m0 *1 853.585,1131.13 sg13_hv_nmos
M$1995 IOVSS \$I354968 \$I354969 \$1 sg13_hv_nmos L=0.45u W=1.3u AS=0.247p
+ AD=0.442p PS=1.68u PD=3.28u rfmode=0
* device instance $1996 m0 *1 843.255,1109.005 sg13_lv_pmos
M$1996 \$14.p2c \$I354971 VDD VDD sg13_lv_pmos L=0.13u W=4.75u AS=1.615p
+ AD=1.615p PS=10.18u PD=10.18u rfmode=0
* device instance $1997 m0 *1 851.925,1126.73 sg13_hv_pmos
M$1997 IOVDD \$I354970 \$I354968 IOVDD sg13_hv_pmos L=0.45u W=4.6u AS=1.219p
+ AD=0.874p PS=7.96u PD=5.36u rfmode=0
* device instance $1999 m0 *1 853.585,1126.73 sg13_hv_pmos
M$1999 IOVDD \$I354968 \$I354969 IOVDD sg13_hv_pmos L=0.45u W=4.6u AS=0.874p
+ AD=1.219p PS=5.36u PD=7.96u rfmode=0
* device instance $2003 m45 *1 300.005,395.255 sg13_lv_nmos
M$2003 \$344864.p2c \$I354975 VSS \$1 sg13_lv_nmos L=0.13u W=2.75u AS=0.935p
+ AD=0.935p PS=6.18u PD=6.18u rfmode=0
* device instance $2004 m45 *1 300.055,396.765 sg13_hv_nmos
M$2004 VSS \$I354973 \$I354975 \$1 sg13_hv_nmos L=0.45u W=2.65u AS=0.901p
+ AD=0.5035p PS=5.98u PD=3.03u rfmode=0
* device instance $2005 m45 *1 300.055,397.595 sg13_hv_nmos
M$2005 \$I354975 \$I354972 VDD \$1 sg13_hv_nmos L=0.45u W=2.65u AS=0.5035p
+ AD=0.901p PS=3.03u PD=5.98u rfmode=0
* device instance $2006 m45 *1 282.87,404.755 sg13_hv_nmos
M$2006 \$I354972 \$I354974 IOVSS \$1 sg13_hv_nmos L=0.45u W=1.3u AS=0.442p
+ AD=0.247p PS=3.28u PD=1.68u rfmode=0
* device instance $2007 m45 *1 282.87,405.585 sg13_hv_nmos
M$2007 IOVSS \$I354972 \$I354973 \$1 sg13_hv_nmos L=0.45u W=1.3u AS=0.247p
+ AD=0.442p PS=1.68u PD=3.28u rfmode=0
* device instance $2008 m45 *1 304.995,395.255 sg13_lv_pmos
M$2008 \$344864.p2c \$I354975 VDD VDD sg13_lv_pmos L=0.13u W=4.75u AS=1.615p
+ AD=1.615p PS=10.18u PD=10.18u rfmode=0
* device instance $2009 m45 *1 287.27,403.925 sg13_hv_pmos
M$2009 IOVDD \$I354974 \$I354972 IOVDD sg13_hv_pmos L=0.45u W=4.6u AS=1.219p
+ AD=0.874p PS=7.96u PD=5.36u rfmode=0
* device instance $2011 m45 *1 287.27,405.585 sg13_hv_pmos
M$2011 IOVDD \$I354972 \$I354973 IOVDD sg13_hv_pmos L=0.45u W=4.6u AS=0.874p
+ AD=1.219p PS=5.36u PD=7.96u rfmode=0
* device instance $2015 m0 *1 224.19,471.54 dpantenna
D$2015 EN_STO_IN IOVDD dpantenna A=35.0028p P=58.08u m=2
* device instance $2018 m135 *1 695.54,1189.81 dpantenna
D$2018 CS_N IOVDD dpantenna A=35.0028p P=58.08u m=2
* device instance $2021 m135 *1 807.54,1189.81 dpantenna
D$2021 MA_SCLK IOVDD dpantenna A=35.0028p P=58.08u m=2
* device instance $2024 m0 *1 224.19,359.54 dpantenna
D$2024 SDI IOVDD dpantenna A=35.0028p P=58.08u m=2
* device instance $2027 m0 *1 165.19,471.54 dantenna
D$2027 \$1 EN_STO_IN dantenna A=35.0028p P=58.08u m=2
* device instance $2030 m135 *1 695.54,1248.81 dantenna
D$2030 \$1 CS_N dantenna A=35.0028p P=58.08u m=2
* device instance $2033 m135 *1 807.54,1248.81 dantenna
D$2033 \$1 MA_SCLK dantenna A=35.0028p P=58.08u m=2
* device instance $2036 m0 *1 165.19,359.54 dantenna
D$2036 \$1 SDI dantenna A=35.0028p P=58.08u m=2
* device instance $2039 m0 *1 504.48,1113.995 sg13_lv_nmos
M$2039 \$I354978 \$1.c2p VSS \$1 sg13_lv_nmos L=0.13u W=2.75u AS=0.935p
+ AD=0.935p PS=6.18u PD=6.18u rfmode=0
* device instance $2040 m0 *1 506.81,1117.68 sg13_hv_nmos
M$2040 VSS \$I354977 \$I354864 \$1 sg13_hv_nmos L=0.45u W=1.9u AS=0.646p
+ AD=0.646p PS=4.48u PD=4.48u rfmode=0
* device instance $2041 m0 *1 504.64,1117.68 sg13_hv_nmos
M$2041 \$I354976 \$1.c2p VSS \$1 sg13_hv_nmos L=0.45u W=1.9u AS=0.646p
+ AD=0.361p PS=4.48u PD=2.28u rfmode=0
* device instance $2042 m0 *1 505.47,1117.68 sg13_hv_nmos
M$2042 VSS \$I354978 \$I354977 \$1 sg13_hv_nmos L=0.45u W=1.9u AS=0.361p
+ AD=0.646p PS=2.28u PD=4.48u rfmode=0
* device instance $2043 m0 *1 504.48,1109.005 sg13_lv_pmos
M$2043 \$I354978 \$1.c2p VDD VDD sg13_lv_pmos L=0.13u W=4.75u AS=1.615p
+ AD=1.615p PS=10.18u PD=10.18u rfmode=0
* device instance $2044 m0 *1 506.81,1121.82 sg13_hv_pmos
M$2044 IOVDD \$I354977 \$I354864 IOVDD sg13_hv_pmos L=0.45u W=3.9u AS=1.326p
+ AD=1.326p PS=8.48u PD=8.48u rfmode=0
* device instance $2045 m0 *1 504.64,1121.82 sg13_hv_pmos
M$2045 \$I354976 \$I354977 IOVDD IOVDD sg13_hv_pmos L=0.45u W=0.3u AS=0.102p
+ AD=0.057p PS=1.28u PD=0.68u rfmode=0
* device instance $2046 m0 *1 505.47,1121.82 sg13_hv_pmos
M$2046 IOVDD \$I354976 \$I354977 IOVDD sg13_hv_pmos L=0.45u W=0.3u AS=0.057p
+ AD=0.102p PS=0.68u PD=1.28u rfmode=0
* device instance $2048 m0 *1 507.99,1113.995 sg13_lv_nmos
M$2048 \$I354981 \$1.c2p VSS \$1 sg13_lv_nmos L=0.13u W=2.75u AS=0.935p
+ AD=0.935p PS=6.18u PD=6.18u rfmode=0
* device instance $2049 m0 *1 510.32,1117.68 sg13_hv_nmos
M$2049 VSS \$I354980 \$I354865 \$1 sg13_hv_nmos L=0.45u W=1.9u AS=0.646p
+ AD=0.646p PS=4.48u PD=4.48u rfmode=0
* device instance $2050 m0 *1 508.15,1117.68 sg13_hv_nmos
M$2050 \$I354979 \$1.c2p VSS \$1 sg13_hv_nmos L=0.45u W=1.9u AS=0.646p
+ AD=0.361p PS=4.48u PD=2.28u rfmode=0
* device instance $2051 m0 *1 508.98,1117.68 sg13_hv_nmos
M$2051 VSS \$I354981 \$I354980 \$1 sg13_hv_nmos L=0.45u W=1.9u AS=0.361p
+ AD=0.646p PS=2.28u PD=4.48u rfmode=0
* device instance $2052 m0 *1 507.99,1109.005 sg13_lv_pmos
M$2052 \$I354981 \$1.c2p VDD VDD sg13_lv_pmos L=0.13u W=4.75u AS=1.615p
+ AD=1.615p PS=10.18u PD=10.18u rfmode=0
* device instance $2053 m0 *1 510.32,1121.82 sg13_hv_pmos
M$2053 IOVDD \$I354980 \$I354865 IOVDD sg13_hv_pmos L=0.45u W=3.9u AS=1.326p
+ AD=1.326p PS=8.48u PD=8.48u rfmode=0
* device instance $2054 m0 *1 508.15,1121.82 sg13_hv_pmos
M$2054 \$I354979 \$I354980 IOVDD IOVDD sg13_hv_pmos L=0.45u W=0.3u AS=0.102p
+ AD=0.057p PS=1.28u PD=0.68u rfmode=0
* device instance $2055 m0 *1 508.98,1121.82 sg13_hv_pmos
M$2055 IOVDD \$I354979 \$I354980 IOVDD sg13_hv_pmos L=0.45u W=0.3u AS=0.057p
+ AD=0.102p PS=0.68u PD=1.28u rfmode=0
* device instance $2057 m0 *1 616.48,1113.995 sg13_lv_nmos
M$2057 \$I354984 \$2.c2p VSS \$1 sg13_lv_nmos L=0.13u W=2.75u AS=0.935p
+ AD=0.935p PS=6.18u PD=6.18u rfmode=0
* device instance $2058 m0 *1 618.81,1117.68 sg13_hv_nmos
M$2058 VSS \$I354983 \$I354867 \$1 sg13_hv_nmos L=0.45u W=1.9u AS=0.646p
+ AD=0.646p PS=4.48u PD=4.48u rfmode=0
* device instance $2059 m0 *1 616.64,1117.68 sg13_hv_nmos
M$2059 \$I354982 \$2.c2p VSS \$1 sg13_hv_nmos L=0.45u W=1.9u AS=0.646p
+ AD=0.361p PS=4.48u PD=2.28u rfmode=0
* device instance $2060 m0 *1 617.47,1117.68 sg13_hv_nmos
M$2060 VSS \$I354984 \$I354983 \$1 sg13_hv_nmos L=0.45u W=1.9u AS=0.361p
+ AD=0.646p PS=2.28u PD=4.48u rfmode=0
* device instance $2061 m0 *1 616.48,1109.005 sg13_lv_pmos
M$2061 \$I354984 \$2.c2p VDD VDD sg13_lv_pmos L=0.13u W=4.75u AS=1.615p
+ AD=1.615p PS=10.18u PD=10.18u rfmode=0
* device instance $2062 m0 *1 618.81,1121.82 sg13_hv_pmos
M$2062 IOVDD \$I354983 \$I354867 IOVDD sg13_hv_pmos L=0.45u W=3.9u AS=1.326p
+ AD=1.326p PS=8.48u PD=8.48u rfmode=0
* device instance $2063 m0 *1 616.64,1121.82 sg13_hv_pmos
M$2063 \$I354982 \$I354983 IOVDD IOVDD sg13_hv_pmos L=0.45u W=0.3u AS=0.102p
+ AD=0.057p PS=1.28u PD=0.68u rfmode=0
* device instance $2064 m0 *1 617.47,1121.82 sg13_hv_pmos
M$2064 IOVDD \$I354982 \$I354983 IOVDD sg13_hv_pmos L=0.45u W=0.3u AS=0.057p
+ AD=0.102p PS=0.68u PD=1.28u rfmode=0
* device instance $2066 m0 *1 619.99,1113.995 sg13_lv_nmos
M$2066 \$I354987 \$2.c2p VSS \$1 sg13_lv_nmos L=0.13u W=2.75u AS=0.935p
+ AD=0.935p PS=6.18u PD=6.18u rfmode=0
* device instance $2067 m0 *1 622.32,1117.68 sg13_hv_nmos
M$2067 VSS \$I354986 \$I354868 \$1 sg13_hv_nmos L=0.45u W=1.9u AS=0.646p
+ AD=0.646p PS=4.48u PD=4.48u rfmode=0
* device instance $2068 m0 *1 620.15,1117.68 sg13_hv_nmos
M$2068 \$I354985 \$2.c2p VSS \$1 sg13_hv_nmos L=0.45u W=1.9u AS=0.646p
+ AD=0.361p PS=4.48u PD=2.28u rfmode=0
* device instance $2069 m0 *1 620.98,1117.68 sg13_hv_nmos
M$2069 VSS \$I354987 \$I354986 \$1 sg13_hv_nmos L=0.45u W=1.9u AS=0.361p
+ AD=0.646p PS=2.28u PD=4.48u rfmode=0
* device instance $2070 m0 *1 619.99,1109.005 sg13_lv_pmos
M$2070 \$I354987 \$2.c2p VDD VDD sg13_lv_pmos L=0.13u W=4.75u AS=1.615p
+ AD=1.615p PS=10.18u PD=10.18u rfmode=0
* device instance $2071 m0 *1 622.32,1121.82 sg13_hv_pmos
M$2071 IOVDD \$I354986 \$I354868 IOVDD sg13_hv_pmos L=0.45u W=3.9u AS=1.326p
+ AD=1.326p PS=8.48u PD=8.48u rfmode=0
* device instance $2072 m0 *1 620.15,1121.82 sg13_hv_pmos
M$2072 \$I354985 \$I354986 IOVDD IOVDD sg13_hv_pmos L=0.45u W=0.3u AS=0.102p
+ AD=0.057p PS=1.28u PD=0.68u rfmode=0
* device instance $2073 m0 *1 620.98,1121.82 sg13_hv_pmos
M$2073 IOVDD \$I354985 \$I354986 IOVDD sg13_hv_pmos L=0.45u W=0.3u AS=0.057p
+ AD=0.102p PS=0.68u PD=1.28u rfmode=0
* device instance $2075 m0 *1 392.48,1113.995 sg13_lv_nmos
M$2075 \$I354990 \$344752.c2p VSS \$1 sg13_lv_nmos L=0.13u W=2.75u AS=0.935p
+ AD=0.935p PS=6.18u PD=6.18u rfmode=0
* device instance $2076 m0 *1 394.81,1117.68 sg13_hv_nmos
M$2076 VSS \$I354989 \$I354870 \$1 sg13_hv_nmos L=0.45u W=1.9u AS=0.646p
+ AD=0.646p PS=4.48u PD=4.48u rfmode=0
* device instance $2077 m0 *1 392.64,1117.68 sg13_hv_nmos
M$2077 \$I354988 \$344752.c2p VSS \$1 sg13_hv_nmos L=0.45u W=1.9u AS=0.646p
+ AD=0.361p PS=4.48u PD=2.28u rfmode=0
* device instance $2078 m0 *1 393.47,1117.68 sg13_hv_nmos
M$2078 VSS \$I354990 \$I354989 \$1 sg13_hv_nmos L=0.45u W=1.9u AS=0.361p
+ AD=0.646p PS=2.28u PD=4.48u rfmode=0
* device instance $2079 m0 *1 392.48,1109.005 sg13_lv_pmos
M$2079 \$I354990 \$344752.c2p VDD VDD sg13_lv_pmos L=0.13u W=4.75u AS=1.615p
+ AD=1.615p PS=10.18u PD=10.18u rfmode=0
* device instance $2080 m0 *1 394.81,1121.82 sg13_hv_pmos
M$2080 IOVDD \$I354989 \$I354870 IOVDD sg13_hv_pmos L=0.45u W=3.9u AS=1.326p
+ AD=1.326p PS=8.48u PD=8.48u rfmode=0
* device instance $2081 m0 *1 392.64,1121.82 sg13_hv_pmos
M$2081 \$I354988 \$I354989 IOVDD IOVDD sg13_hv_pmos L=0.45u W=0.3u AS=0.102p
+ AD=0.057p PS=1.28u PD=0.68u rfmode=0
* device instance $2082 m0 *1 393.47,1121.82 sg13_hv_pmos
M$2082 IOVDD \$I354988 \$I354989 IOVDD sg13_hv_pmos L=0.45u W=0.3u AS=0.057p
+ AD=0.102p PS=0.68u PD=1.28u rfmode=0
* device instance $2084 m0 *1 395.99,1113.995 sg13_lv_nmos
M$2084 \$I354993 \$344752.c2p VSS \$1 sg13_lv_nmos L=0.13u W=2.75u AS=0.935p
+ AD=0.935p PS=6.18u PD=6.18u rfmode=0
* device instance $2085 m0 *1 398.32,1117.68 sg13_hv_nmos
M$2085 VSS \$I354992 \$I354871 \$1 sg13_hv_nmos L=0.45u W=1.9u AS=0.646p
+ AD=0.646p PS=4.48u PD=4.48u rfmode=0
* device instance $2086 m0 *1 396.15,1117.68 sg13_hv_nmos
M$2086 \$I354991 \$344752.c2p VSS \$1 sg13_hv_nmos L=0.45u W=1.9u AS=0.646p
+ AD=0.361p PS=4.48u PD=2.28u rfmode=0
* device instance $2087 m0 *1 396.98,1117.68 sg13_hv_nmos
M$2087 VSS \$I354993 \$I354992 \$1 sg13_hv_nmos L=0.45u W=1.9u AS=0.361p
+ AD=0.646p PS=2.28u PD=4.48u rfmode=0
* device instance $2088 m0 *1 395.99,1109.005 sg13_lv_pmos
M$2088 \$I354993 \$344752.c2p VDD VDD sg13_lv_pmos L=0.13u W=4.75u AS=1.615p
+ AD=1.615p PS=10.18u PD=10.18u rfmode=0
* device instance $2089 m0 *1 398.32,1121.82 sg13_hv_pmos
M$2089 IOVDD \$I354992 \$I354871 IOVDD sg13_hv_pmos L=0.45u W=3.9u AS=1.326p
+ AD=1.326p PS=8.48u PD=8.48u rfmode=0
* device instance $2090 m0 *1 396.15,1121.82 sg13_hv_pmos
M$2090 \$I354991 \$I354992 IOVDD IOVDD sg13_hv_pmos L=0.45u W=0.3u AS=0.102p
+ AD=0.057p PS=1.28u PD=0.68u rfmode=0
* device instance $2091 m0 *1 396.98,1121.82 sg13_hv_pmos
M$2091 IOVDD \$I354991 \$I354992 IOVDD sg13_hv_pmos L=0.45u W=0.3u AS=0.057p
+ AD=0.102p PS=0.68u PD=1.28u rfmode=0
* device instance $2093 m0 *1 952.48,1113.995 sg13_lv_nmos
M$2093 \$I354996 \$3.c2p VSS \$1 sg13_lv_nmos L=0.13u W=2.75u AS=0.935p
+ AD=0.935p PS=6.18u PD=6.18u rfmode=0
* device instance $2094 m0 *1 954.81,1117.68 sg13_hv_nmos
M$2094 VSS \$I354995 \$I354873 \$1 sg13_hv_nmos L=0.45u W=1.9u AS=0.646p
+ AD=0.646p PS=4.48u PD=4.48u rfmode=0
* device instance $2095 m0 *1 952.64,1117.68 sg13_hv_nmos
M$2095 \$I354994 \$3.c2p VSS \$1 sg13_hv_nmos L=0.45u W=1.9u AS=0.646p
+ AD=0.361p PS=4.48u PD=2.28u rfmode=0
* device instance $2096 m0 *1 953.47,1117.68 sg13_hv_nmos
M$2096 VSS \$I354996 \$I354995 \$1 sg13_hv_nmos L=0.45u W=1.9u AS=0.361p
+ AD=0.646p PS=2.28u PD=4.48u rfmode=0
* device instance $2097 m0 *1 952.48,1109.005 sg13_lv_pmos
M$2097 \$I354996 \$3.c2p VDD VDD sg13_lv_pmos L=0.13u W=4.75u AS=1.615p
+ AD=1.615p PS=10.18u PD=10.18u rfmode=0
* device instance $2098 m0 *1 954.81,1121.82 sg13_hv_pmos
M$2098 IOVDD \$I354995 \$I354873 IOVDD sg13_hv_pmos L=0.45u W=3.9u AS=1.326p
+ AD=1.326p PS=8.48u PD=8.48u rfmode=0
* device instance $2099 m0 *1 952.64,1121.82 sg13_hv_pmos
M$2099 \$I354994 \$I354995 IOVDD IOVDD sg13_hv_pmos L=0.45u W=0.3u AS=0.102p
+ AD=0.057p PS=1.28u PD=0.68u rfmode=0
* device instance $2100 m0 *1 953.47,1121.82 sg13_hv_pmos
M$2100 IOVDD \$I354994 \$I354995 IOVDD sg13_hv_pmos L=0.45u W=0.3u AS=0.057p
+ AD=0.102p PS=0.68u PD=1.28u rfmode=0
* device instance $2102 m0 *1 955.99,1113.995 sg13_lv_nmos
M$2102 \$I354999 \$3.c2p VSS \$1 sg13_lv_nmos L=0.13u W=2.75u AS=0.935p
+ AD=0.935p PS=6.18u PD=6.18u rfmode=0
* device instance $2103 m0 *1 958.32,1117.68 sg13_hv_nmos
M$2103 VSS \$I354998 \$I354874 \$1 sg13_hv_nmos L=0.45u W=1.9u AS=0.646p
+ AD=0.646p PS=4.48u PD=4.48u rfmode=0
* device instance $2104 m0 *1 956.15,1117.68 sg13_hv_nmos
M$2104 \$I354997 \$3.c2p VSS \$1 sg13_hv_nmos L=0.45u W=1.9u AS=0.646p
+ AD=0.361p PS=4.48u PD=2.28u rfmode=0
* device instance $2105 m0 *1 956.98,1117.68 sg13_hv_nmos
M$2105 VSS \$I354999 \$I354998 \$1 sg13_hv_nmos L=0.45u W=1.9u AS=0.361p
+ AD=0.646p PS=2.28u PD=4.48u rfmode=0
* device instance $2106 m0 *1 955.99,1109.005 sg13_lv_pmos
M$2106 \$I354999 \$3.c2p VDD VDD sg13_lv_pmos L=0.13u W=4.75u AS=1.615p
+ AD=1.615p PS=10.18u PD=10.18u rfmode=0
* device instance $2107 m0 *1 958.32,1121.82 sg13_hv_pmos
M$2107 IOVDD \$I354998 \$I354874 IOVDD sg13_hv_pmos L=0.45u W=3.9u AS=1.326p
+ AD=1.326p PS=8.48u PD=8.48u rfmode=0
* device instance $2108 m0 *1 956.15,1121.82 sg13_hv_pmos
M$2108 \$I354997 \$I354998 IOVDD IOVDD sg13_hv_pmos L=0.45u W=0.3u AS=0.102p
+ AD=0.057p PS=1.28u PD=0.68u rfmode=0
* device instance $2109 m0 *1 956.98,1121.82 sg13_hv_pmos
M$2109 IOVDD \$I354997 \$I354998 IOVDD sg13_hv_pmos L=0.45u W=0.3u AS=0.057p
+ AD=0.102p PS=0.68u PD=1.28u rfmode=0
* device instance $2111 r90 *1 1113.995,952.48 sg13_lv_nmos
M$2111 \$I355002 \$88229.c2p VSS \$1 sg13_lv_nmos L=0.13u W=2.75u AS=0.935p
+ AD=0.935p PS=6.18u PD=6.18u rfmode=0
* device instance $2112 r90 *1 1117.68,954.81 sg13_hv_nmos
M$2112 VSS \$I355001 \$I354876 \$1 sg13_hv_nmos L=0.45u W=1.9u AS=0.646p
+ AD=0.646p PS=4.48u PD=4.48u rfmode=0
* device instance $2113 r90 *1 1117.68,952.64 sg13_hv_nmos
M$2113 \$I355000 \$88229.c2p VSS \$1 sg13_hv_nmos L=0.45u W=1.9u AS=0.646p
+ AD=0.361p PS=4.48u PD=2.28u rfmode=0
* device instance $2114 r90 *1 1117.68,953.47 sg13_hv_nmos
M$2114 VSS \$I355002 \$I355001 \$1 sg13_hv_nmos L=0.45u W=1.9u AS=0.361p
+ AD=0.646p PS=2.28u PD=4.48u rfmode=0
* device instance $2115 r90 *1 1109.005,952.48 sg13_lv_pmos
M$2115 \$I355002 \$88229.c2p VDD VDD sg13_lv_pmos L=0.13u W=4.75u AS=1.615p
+ AD=1.615p PS=10.18u PD=10.18u rfmode=0
* device instance $2116 r90 *1 1121.82,954.81 sg13_hv_pmos
M$2116 IOVDD \$I355001 \$I354876 IOVDD sg13_hv_pmos L=0.45u W=3.9u AS=1.326p
+ AD=1.326p PS=8.48u PD=8.48u rfmode=0
* device instance $2117 r90 *1 1121.82,952.64 sg13_hv_pmos
M$2117 \$I355000 \$I355001 IOVDD IOVDD sg13_hv_pmos L=0.45u W=0.3u AS=0.102p
+ AD=0.057p PS=1.28u PD=0.68u rfmode=0
* device instance $2118 r90 *1 1121.82,953.47 sg13_hv_pmos
M$2118 IOVDD \$I355000 \$I355001 IOVDD sg13_hv_pmos L=0.45u W=0.3u AS=0.057p
+ AD=0.102p PS=0.68u PD=1.28u rfmode=0
* device instance $2120 r90 *1 1113.995,955.99 sg13_lv_nmos
M$2120 \$I355005 \$88229.c2p VSS \$1 sg13_lv_nmos L=0.13u W=2.75u AS=0.935p
+ AD=0.935p PS=6.18u PD=6.18u rfmode=0
* device instance $2121 r90 *1 1117.68,958.32 sg13_hv_nmos
M$2121 VSS \$I355004 \$I354877 \$1 sg13_hv_nmos L=0.45u W=1.9u AS=0.646p
+ AD=0.646p PS=4.48u PD=4.48u rfmode=0
* device instance $2122 r90 *1 1117.68,956.15 sg13_hv_nmos
M$2122 \$I355003 \$88229.c2p VSS \$1 sg13_hv_nmos L=0.45u W=1.9u AS=0.646p
+ AD=0.361p PS=4.48u PD=2.28u rfmode=0
* device instance $2123 r90 *1 1117.68,956.98 sg13_hv_nmos
M$2123 VSS \$I355005 \$I355004 \$1 sg13_hv_nmos L=0.45u W=1.9u AS=0.361p
+ AD=0.646p PS=2.28u PD=4.48u rfmode=0
* device instance $2124 r90 *1 1109.005,955.99 sg13_lv_pmos
M$2124 \$I355005 \$88229.c2p VDD VDD sg13_lv_pmos L=0.13u W=4.75u AS=1.615p
+ AD=1.615p PS=10.18u PD=10.18u rfmode=0
* device instance $2125 r90 *1 1121.82,958.32 sg13_hv_pmos
M$2125 IOVDD \$I355004 \$I354877 IOVDD sg13_hv_pmos L=0.45u W=3.9u AS=1.326p
+ AD=1.326p PS=8.48u PD=8.48u rfmode=0
* device instance $2126 r90 *1 1121.82,956.15 sg13_hv_pmos
M$2126 \$I355003 \$I355004 IOVDD IOVDD sg13_hv_pmos L=0.45u W=0.3u AS=0.102p
+ AD=0.057p PS=1.28u PD=0.68u rfmode=0
* device instance $2127 r90 *1 1121.82,956.98 sg13_hv_pmos
M$2127 IOVDD \$I355003 \$I355004 IOVDD sg13_hv_pmos L=0.45u W=0.3u AS=0.057p
+ AD=0.102p PS=0.68u PD=1.28u rfmode=0
* device instance $2129 m45 *1 283.54,512.225 dantenna
D$2129 \$1 \$I354962 dantenna A=1.984p P=7.48u m=1
* device instance $2130 m45 *1 288.51,510.055 dpantenna
D$2130 \$I354962 IOVDD dpantenna A=3.1872p P=11.24u m=1
* device instance $2131 m45 *1 282.535,507.68 rppd
R$2131 EN_STO_IN \$I354962 \$1 rppd w=1u l=2u ps=0u b=0 m=1
* device instance $2134 m0 *1 736.225,1130.46 dantenna
D$2134 \$1 \$I354966 dantenna A=1.984p P=7.48u m=1
* device instance $2135 m0 *1 734.055,1125.49 dpantenna
D$2135 \$I354966 IOVDD dpantenna A=3.1872p P=11.24u m=1
* device instance $2136 m0 *1 731.68,1131.465 rppd
R$2136 CS_N \$I354966 \$1 rppd w=1u l=2u ps=0u b=0 m=1
* device instance $2139 m0 *1 848.225,1130.46 dantenna
D$2139 \$1 \$I354970 dantenna A=1.984p P=7.48u m=1
* device instance $2140 m0 *1 846.055,1125.49 dpantenna
D$2140 \$I354970 IOVDD dpantenna A=3.1872p P=11.24u m=1
* device instance $2141 m0 *1 843.68,1131.465 rppd
R$2141 MA_SCLK \$I354970 \$1 rppd w=1u l=2u ps=0u b=0 m=1
* device instance $2144 m45 *1 283.54,400.225 dantenna
D$2144 \$1 \$I354974 dantenna A=1.984p P=7.48u m=1
* device instance $2145 m45 *1 288.51,398.055 dpantenna
D$2145 \$I354974 IOVDD dpantenna A=3.1872p P=11.24u m=1
* device instance $2146 m45 *1 282.535,395.68 rppd
R$2146 SDI \$I354974 \$1 rppd w=1u l=2u ps=0u b=0 m=1
.ENDS r1_padring
