* Extracted by KLayout with SG13G2 LVS runset on : 21/10/2026 09:21

* cell r1_padring
* pin $1.c2p
* pin $10.padres
* pin $11.padres
* pin $12.p2c
* pin $13.p2c
* pin $14.p2c
* pin $187433.c2p
* pin $2.c2p
* pin $3.c2p
* pin $4.padres
* pin $5.padres
* pin $509035.p2c
* pin $521187.padres
* pin $521188.c2p
* pin $6.padres
* pin $7.padres
* pin $8.padres
* pin $9.padres
* pin COS_N
* pin COS_P
* pin CS_N
* pin EN_STO_IN
* pin FAULT_N
* pin GATE_A
* pin GATE_B
* pin GATE_C
* pin IOVDD
* pin IOVSS
* pin ISA_N
* pin ISA_P
* pin ISB_N
* pin ISB_P
* pin MA_SCLK
* pin SDI
* pin SIN_N
* pin SIN_P
* pin SLO_SDO
* pin VDD
* pin VDDA
* pin VSS
.SUBCKT r1_padring \$1.c2p \$10.padres \$11.padres \$12.p2c \$13.p2c \$14.p2c
+ \$187433.c2p \$2.c2p \$3.c2p \$4.padres \$5.padres \$509035.p2c
+ \$521187.padres \$521188.c2p \$6.padres \$7.padres \$8.padres \$9.padres
+ COS_N COS_P CS_N EN_STO_IN FAULT_N GATE_A GATE_B GATE_C IOVDD IOVSS ISA_N
+ ISA_P ISB_N ISB_P MA_SCLK SDI SIN_N SIN_P SLO_SDO VDD VDDA VSS
* device instance $1 r0 *1 1205,243.585 ptap1
R$1 IOVSS \$1 ptap1 A=317480.7789p P=76171.568u
* device instance $2 r0 *1 1205,298 ptap1
R$2 VSS \$1 ptap1 A=1316.7456p P=8881.696u
* device instance $677 r90 *1 1169.54,224.19 dpantenna
D$677 IOVSS IOVDD dpantenna A=35.0028p P=58.08u m=4
* device instance $683 r90 *1 1169.54,165.19 dantenna
D$683 \$1 IOVSS dantenna A=35.0028p P=58.08u m=4
* device instance $714 m0 *1 799.12,198.715 rppd
R$714 \$I539891 IOVDD \$1 rppd w=1u l=520u ps=0u b=0 m=1
* device instance $715 r0 *1 747.155,151.95 sg13_hv_nmos
M$715 IOVSS \$I539892 IOVDD \$1 sg13_hv_nmos L=0.6u W=756.8u AS=344.608p
+ AD=349.36p PS=931.04u PD=933.2u rfmode=0
* device instance $887 r0 *1 743.77,167.98 dantenna
D$887 \$1 \$I539892 dantenna A=0.2304p P=1.92u m=1
* device instance $889 m90 *1 811.28,221.79 sg13_hv_nmos
M$889 IOVSS \$I539891 IOVSS \$1 sg13_hv_nmos L=9.5u W=126u AS=26.64p AD=23.94p
+ PS=149.92u PD=131.32u rfmode=0
* device instance $896 m90 *1 746.62,221.79 sg13_hv_nmos
M$896 IOVSS \$I539891 \$I539892 \$1 sg13_hv_nmos L=0.5u W=108u AS=20.52p
+ AD=23.22p PS=112.56u PD=131.16u rfmode=0
* device instance $915 m90 *1 800.56,235.91 sg13_hv_pmos
M$915 IOVDD \$I539891 \$I539892 IOVDD sg13_hv_pmos L=0.5u W=350u AS=67.55p
+ AD=67.55p PS=376.3u PD=376.3u rfmode=0
* device instance $991 m0 *1 515.12,198.715 rppd
R$991 \$I539893 VDD \$1 rppd w=1u l=520u ps=0u b=0 m=1
* device instance $992 r0 *1 463.155,151.95 sg13_hv_nmos
M$992 IOVSS \$I539894 VDD \$1 sg13_hv_nmos L=0.6u W=756.8u AS=344.608p
+ AD=349.36p PS=931.04u PD=933.2u rfmode=0
* device instance $1164 r0 *1 459.77,167.98 dantenna
D$1164 \$1 \$I539894 dantenna A=0.2304p P=1.92u m=1
* device instance $1166 m90 *1 527.28,221.79 sg13_hv_nmos
M$1166 IOVSS \$I539893 IOVSS \$1 sg13_hv_nmos L=9.5u W=126u AS=26.64p AD=23.94p
+ PS=149.92u PD=131.32u rfmode=0
* device instance $1173 m90 *1 462.62,221.79 sg13_hv_nmos
M$1173 IOVSS \$I539893 \$I539894 \$1 sg13_hv_nmos L=0.5u W=108u AS=20.52p
+ AD=23.22p PS=112.56u PD=131.16u rfmode=0
* device instance $1192 m90 *1 516.56,235.91 sg13_hv_pmos
M$1192 VDD \$I539893 \$I539894 VDD sg13_hv_pmos L=0.5u W=350u AS=67.55p
+ AD=67.55p PS=376.3u PD=376.3u rfmode=0
* device instance $1243 r90 *1 1027.54,224.19 dpantenna
D$1243 VSS IOVDD dpantenna A=35.0028p P=58.08u m=4
* device instance $1249 r90 *1 1027.54,165.19 dantenna
D$1249 \$1 VSS dantenna A=35.0028p P=58.08u m=4
* device instance $1255 m0 *1 626.295,1548.05 sg13_hv_nmos
M$1255 IOVSS \$I539895 GATE_B \$1 sg13_hv_nmos L=0.6u W=66u AS=30.096p
+ AD=31.284p PS=84.08u PD=84.62u rfmode=0
* device instance $1270 m0 *1 612.32,1546.295 dantenna
D$1270 \$1 \$I539895 dantenna A=0.6084p P=3.12u m=1
* device instance $1272 m0 *1 768.295,1548.05 sg13_hv_nmos
M$1272 IOVSS \$I539898 GATE_C \$1 sg13_hv_nmos L=0.6u W=66u AS=30.096p
+ AD=31.284p PS=84.08u PD=84.62u rfmode=0
* device instance $1287 m0 *1 754.32,1546.295 dantenna
D$1287 \$1 \$I539898 dantenna A=0.6084p P=3.12u m=1
* device instance $1289 m0 *1 484.295,1548.05 sg13_hv_nmos
M$1289 IOVSS \$I539901 GATE_A \$1 sg13_hv_nmos L=0.6u W=66u AS=30.096p
+ AD=31.284p PS=84.08u PD=84.62u rfmode=0
* device instance $1304 m0 *1 470.32,1546.295 dantenna
D$1304 \$1 \$I539901 dantenna A=0.6084p P=3.12u m=1
* device instance $1306 m0 *1 626.295,1487.92 sg13_hv_pmos
M$1306 IOVDD \$I539896 GATE_B IOVDD sg13_hv_pmos L=0.6u W=199.8u AS=91.1088p
+ AD=94.7052p PS=240.48u PD=241.56u rfmode=0
* device instance $1336 m0 *1 612.35,1477.9 dpantenna
D$1336 \$I539896 IOVDD dpantenna A=0.6084p P=3.12u m=1
* device instance $1338 m0 *1 768.295,1487.92 sg13_hv_pmos
M$1338 IOVDD \$I539899 GATE_C IOVDD sg13_hv_pmos L=0.6u W=199.8u AS=91.1088p
+ AD=94.7052p PS=240.48u PD=241.56u rfmode=0
* device instance $1368 m0 *1 754.35,1477.9 dpantenna
D$1368 \$I539899 IOVDD dpantenna A=0.6084p P=3.12u m=1
* device instance $1370 m0 *1 484.295,1487.92 sg13_hv_pmos
M$1370 IOVDD \$I539902 GATE_A IOVDD sg13_hv_pmos L=0.6u W=199.8u AS=91.1088p
+ AD=94.7052p PS=240.48u PD=241.56u rfmode=0
* device instance $1400 m0 *1 470.35,1477.9 dpantenna
D$1400 \$I539902 IOVDD dpantenna A=0.6084p P=3.12u m=1
* device instance $1402 m0 *1 637,1498.54 dpantenna
D$1402 GATE_B IOVDD dpantenna A=35.0028p P=58.08u m=2
* device instance $1405 m0 *1 779,1498.54 dpantenna
D$1405 GATE_C IOVDD dpantenna A=35.0028p P=58.08u m=2
* device instance $1408 m0 *1 495,1498.54 dpantenna
D$1408 GATE_A IOVDD dpantenna A=35.0028p P=58.08u m=2
* device instance $1411 m0 *1 637,1534.06 dantenna
D$1411 \$1 GATE_B dantenna A=35.0028p P=58.08u m=2
* device instance $1414 m0 *1 779,1534.06 dantenna
D$1414 \$1 GATE_C dantenna A=35.0028p P=58.08u m=2
* device instance $1417 m0 *1 495,1534.06 dantenna
D$1417 \$1 GATE_A dantenna A=35.0028p P=58.08u m=2
* device instance $1420 m45 *1 283.54,1080.63 dantenna
D$1420 \$1 \$4.padres dantenna A=1.984p P=7.48u m=1
* device instance $1421 m45 *1 288.51,1078.46 dpantenna
D$1421 \$4.padres IOVDD dpantenna A=3.1872p P=11.24u m=1
* device instance $1422 m45 *1 282.535,1076.085 rppd
R$1422 COS_P \$4.padres \$1 rppd w=1u l=2u ps=0u b=0 m=1
* device instance $1425 m45 *1 283.54,1222.63 dantenna
D$1425 \$1 \$5.padres dantenna A=1.984p P=7.48u m=1
* device instance $1426 m45 *1 288.51,1220.46 dpantenna
D$1426 \$5.padres IOVDD dpantenna A=3.1872p P=11.24u m=1
* device instance $1427 m45 *1 282.535,1218.085 rppd
R$1427 COS_N \$5.padres \$1 rppd w=1u l=2u ps=0u b=0 m=1
* device instance $1430 m45 *1 283.54,938.63 dantenna
D$1430 \$1 \$6.padres dantenna A=1.984p P=7.48u m=1
* device instance $1431 m45 *1 288.51,936.46 dpantenna
D$1431 \$6.padres IOVDD dpantenna A=3.1872p P=11.24u m=1
* device instance $1432 m45 *1 282.535,934.085 rppd
R$1432 SIN_N \$6.padres \$1 rppd w=1u l=2u ps=0u b=0 m=1
* device instance $1435 m45 *1 283.54,796.63 dantenna
D$1435 \$1 \$7.padres dantenna A=1.984p P=7.48u m=1
* device instance $1436 m45 *1 288.51,794.46 dpantenna
D$1436 \$7.padres IOVDD dpantenna A=3.1872p P=11.24u m=1
* device instance $1437 m45 *1 282.535,792.085 rppd
R$1437 SIN_P \$7.padres \$1 rppd w=1u l=2u ps=0u b=0 m=1
* device instance $1440 r90 *1 1416.46,938.63 dantenna
D$1440 \$1 \$8.padres dantenna A=1.984p P=7.48u m=1
* device instance $1441 r90 *1 1411.49,936.46 dpantenna
D$1441 \$8.padres IOVDD dpantenna A=3.1872p P=11.24u m=1
* device instance $1442 r90 *1 1417.465,934.085 rppd
R$1442 ISB_P \$8.padres \$1 rppd w=1u l=2u ps=0u b=0 m=1
* device instance $1445 r90 *1 1416.46,1080.63 dantenna
D$1445 \$1 \$9.padres dantenna A=1.984p P=7.48u m=1
* device instance $1446 r90 *1 1411.49,1078.46 dpantenna
D$1446 \$9.padres IOVDD dpantenna A=3.1872p P=11.24u m=1
* device instance $1447 r90 *1 1417.465,1076.085 rppd
R$1447 ISB_N \$9.padres \$1 rppd w=1u l=2u ps=0u b=0 m=1
* device instance $1450 r90 *1 1416.46,654.63 dantenna
D$1450 \$1 \$10.padres dantenna A=1.984p P=7.48u m=1
* device instance $1451 r90 *1 1411.49,652.46 dpantenna
D$1451 \$10.padres IOVDD dpantenna A=3.1872p P=11.24u m=1
* device instance $1452 r90 *1 1417.465,650.085 rppd
R$1452 ISA_P \$10.padres \$1 rppd w=1u l=2u ps=0u b=0 m=1
* device instance $1455 r90 *1 1416.46,796.63 dantenna
D$1455 \$1 \$11.padres dantenna A=1.984p P=7.48u m=1
* device instance $1456 r90 *1 1411.49,794.46 dpantenna
D$1456 \$11.padres IOVDD dpantenna A=3.1872p P=11.24u m=1
* device instance $1457 r90 *1 1417.465,792.085 rppd
R$1457 ISA_N \$11.padres \$1 rppd w=1u l=2u ps=0u b=0 m=1
* device instance $1460 r90 *1 1416.46,512.63 dantenna
D$1460 \$1 \$521187.padres dantenna A=1.984p P=7.48u m=1
* device instance $1461 r90 *1 1411.49,510.46 dpantenna
D$1461 \$521187.padres IOVDD dpantenna A=3.1872p P=11.24u m=1
* device instance $1462 r90 *1 1417.465,508.085 rppd
R$1462 VDDA \$521187.padres \$1 rppd w=1u l=2u ps=0u b=0 m=1
* device instance $1465 m45 *1 201.46,1063 dpantenna
D$1465 COS_P IOVDD dpantenna A=35.0028p P=58.08u m=2
* device instance $1468 m45 *1 201.46,1205 dpantenna
D$1468 COS_N IOVDD dpantenna A=35.0028p P=58.08u m=2
* device instance $1471 m45 *1 201.46,921 dpantenna
D$1471 SIN_N IOVDD dpantenna A=35.0028p P=58.08u m=2
* device instance $1474 m45 *1 201.46,779 dpantenna
D$1474 SIN_P IOVDD dpantenna A=35.0028p P=58.08u m=2
* device instance $1477 r90 *1 1498.54,921 dpantenna
D$1477 ISB_P IOVDD dpantenna A=35.0028p P=58.08u m=2
* device instance $1480 r90 *1 1498.54,1063 dpantenna
D$1480 ISB_N IOVDD dpantenna A=35.0028p P=58.08u m=2
* device instance $1483 r90 *1 1498.54,637 dpantenna
D$1483 ISA_P IOVDD dpantenna A=35.0028p P=58.08u m=2
* device instance $1486 r90 *1 1498.54,779 dpantenna
D$1486 ISA_N IOVDD dpantenna A=35.0028p P=58.08u m=2
* device instance $1489 r90 *1 1498.54,495 dpantenna
D$1489 VDDA IOVDD dpantenna A=35.0028p P=58.08u m=2
* device instance $1492 m45 *1 165.94,1063 dantenna
D$1492 \$1 COS_P dantenna A=35.0028p P=58.08u m=2
* device instance $1495 m45 *1 165.94,1205 dantenna
D$1495 \$1 COS_N dantenna A=35.0028p P=58.08u m=2
* device instance $1498 m45 *1 165.94,921 dantenna
D$1498 \$1 SIN_N dantenna A=35.0028p P=58.08u m=2
* device instance $1501 m45 *1 165.94,779 dantenna
D$1501 \$1 SIN_P dantenna A=35.0028p P=58.08u m=2
* device instance $1504 r90 *1 1534.06,921 dantenna
D$1504 \$1 ISB_P dantenna A=35.0028p P=58.08u m=2
* device instance $1507 r90 *1 1534.06,1063 dantenna
D$1507 \$1 ISB_N dantenna A=35.0028p P=58.08u m=2
* device instance $1510 r90 *1 1534.06,637 dantenna
D$1510 \$1 ISA_P dantenna A=35.0028p P=58.08u m=2
* device instance $1513 r90 *1 1534.06,779 dantenna
D$1513 \$1 ISA_N dantenna A=35.0028p P=58.08u m=2
* device instance $1516 r90 *1 1534.06,495 dantenna
D$1516 \$1 VDDA dantenna A=35.0028p P=58.08u m=2
* device instance $1519 m45 *1 219.18,1048.52 sg13_hv_pmos
M$1519 IOVDD \$I539973 COS_P IOVDD sg13_hv_pmos L=0.6u W=266.4u AS=123.21p
+ AD=123.21p PS=316.72u PD=316.72u rfmode=0
* device instance $1559 m45 *1 209.175,1089.3 rppd
R$1559 IOVDD \$I539973 IOVDD rppd w=0.5u l=12.9u ps=0u b=0 m=1
* device instance $1561 m45 *1 219.18,1190.52 sg13_hv_pmos
M$1561 IOVDD \$I539974 COS_N IOVDD sg13_hv_pmos L=0.6u W=266.4u AS=123.21p
+ AD=123.21p PS=316.72u PD=316.72u rfmode=0
* device instance $1601 m45 *1 209.175,1231.3 rppd
R$1601 IOVDD \$I539974 IOVDD rppd w=0.5u l=12.9u ps=0u b=0 m=1
* device instance $1603 m45 *1 219.18,906.52 sg13_hv_pmos
M$1603 IOVDD \$I539975 SIN_N IOVDD sg13_hv_pmos L=0.6u W=266.4u AS=123.21p
+ AD=123.21p PS=316.72u PD=316.72u rfmode=0
* device instance $1643 m45 *1 209.175,947.3 rppd
R$1643 IOVDD \$I539975 IOVDD rppd w=0.5u l=12.9u ps=0u b=0 m=1
* device instance $1645 m45 *1 219.18,764.52 sg13_hv_pmos
M$1645 IOVDD \$I539976 SIN_P IOVDD sg13_hv_pmos L=0.6u W=266.4u AS=123.21p
+ AD=123.21p PS=316.72u PD=316.72u rfmode=0
* device instance $1685 m45 *1 209.175,805.3 rppd
R$1685 IOVDD \$I539976 IOVDD rppd w=0.5u l=12.9u ps=0u b=0 m=1
* device instance $1687 r90 *1 1480.82,906.52 sg13_hv_pmos
M$1687 IOVDD \$I539977 ISB_P IOVDD sg13_hv_pmos L=0.6u W=266.4u AS=123.21p
+ AD=123.21p PS=316.72u PD=316.72u rfmode=0
* device instance $1727 r90 *1 1490.825,947.3 rppd
R$1727 IOVDD \$I539977 IOVDD rppd w=0.5u l=12.9u ps=0u b=0 m=1
* device instance $1729 r90 *1 1480.82,1048.52 sg13_hv_pmos
M$1729 IOVDD \$I539978 ISB_N IOVDD sg13_hv_pmos L=0.6u W=266.4u AS=123.21p
+ AD=123.21p PS=316.72u PD=316.72u rfmode=0
* device instance $1769 r90 *1 1490.825,1089.3 rppd
R$1769 IOVDD \$I539978 IOVDD rppd w=0.5u l=12.9u ps=0u b=0 m=1
* device instance $1771 r90 *1 1480.82,622.52 sg13_hv_pmos
M$1771 IOVDD \$I539979 ISA_P IOVDD sg13_hv_pmos L=0.6u W=266.4u AS=123.21p
+ AD=123.21p PS=316.72u PD=316.72u rfmode=0
* device instance $1811 r90 *1 1490.825,663.3 rppd
R$1811 IOVDD \$I539979 IOVDD rppd w=0.5u l=12.9u ps=0u b=0 m=1
* device instance $1813 r90 *1 1480.82,764.52 sg13_hv_pmos
M$1813 IOVDD \$I539980 ISA_N IOVDD sg13_hv_pmos L=0.6u W=266.4u AS=123.21p
+ AD=123.21p PS=316.72u PD=316.72u rfmode=0
* device instance $1853 r90 *1 1490.825,805.3 rppd
R$1853 IOVDD \$I539980 IOVDD rppd w=0.5u l=12.9u ps=0u b=0 m=1
* device instance $1855 r90 *1 1480.82,480.52 sg13_hv_pmos
M$1855 IOVDD \$I539981 VDDA IOVDD sg13_hv_pmos L=0.6u W=266.4u AS=123.21p
+ AD=123.21p PS=316.72u PD=316.72u rfmode=0
* device instance $1895 r90 *1 1490.825,521.3 rppd
R$1895 IOVDD \$I539981 IOVDD rppd w=0.5u l=12.9u ps=0u b=0 m=1
* device instance $1897 m45 *1 151.95,1048.52 sg13_hv_nmos
M$1897 IOVSS \$I539982 COS_P \$1 sg13_hv_nmos L=0.6u W=88u AS=40.7p AD=40.7p
+ PS=110.9u PD=110.9u rfmode=0
* device instance $1917 m45 *1 150.175,1089.3 rppd
R$1917 IOVSS \$I539982 \$1 rppd w=0.5u l=3.54u ps=0u b=0 m=1
* device instance $1919 m45 *1 151.95,1190.52 sg13_hv_nmos
M$1919 IOVSS \$I539983 COS_N \$1 sg13_hv_nmos L=0.6u W=88u AS=40.7p AD=40.7p
+ PS=110.9u PD=110.9u rfmode=0
* device instance $1939 m45 *1 150.175,1231.3 rppd
R$1939 IOVSS \$I539983 \$1 rppd w=0.5u l=3.54u ps=0u b=0 m=1
* device instance $1941 m45 *1 151.95,906.52 sg13_hv_nmos
M$1941 IOVSS \$I539984 SIN_N \$1 sg13_hv_nmos L=0.6u W=88u AS=40.7p AD=40.7p
+ PS=110.9u PD=110.9u rfmode=0
* device instance $1961 m45 *1 150.175,947.3 rppd
R$1961 IOVSS \$I539984 \$1 rppd w=0.5u l=3.54u ps=0u b=0 m=1
* device instance $1963 m45 *1 151.95,764.52 sg13_hv_nmos
M$1963 IOVSS \$I539985 SIN_P \$1 sg13_hv_nmos L=0.6u W=88u AS=40.7p AD=40.7p
+ PS=110.9u PD=110.9u rfmode=0
* device instance $1983 m45 *1 150.175,805.3 rppd
R$1983 IOVSS \$I539985 \$1 rppd w=0.5u l=3.54u ps=0u b=0 m=1
* device instance $1985 r90 *1 1548.05,906.52 sg13_hv_nmos
M$1985 IOVSS \$I539986 ISB_P \$1 sg13_hv_nmos L=0.6u W=88u AS=40.7p AD=40.7p
+ PS=110.9u PD=110.9u rfmode=0
* device instance $2005 r90 *1 1549.825,947.3 rppd
R$2005 IOVSS \$I539986 \$1 rppd w=0.5u l=3.54u ps=0u b=0 m=1
* device instance $2007 r90 *1 1548.05,1048.52 sg13_hv_nmos
M$2007 IOVSS \$I539987 ISB_N \$1 sg13_hv_nmos L=0.6u W=88u AS=40.7p AD=40.7p
+ PS=110.9u PD=110.9u rfmode=0
* device instance $2027 r90 *1 1549.825,1089.3 rppd
R$2027 IOVSS \$I539987 \$1 rppd w=0.5u l=3.54u ps=0u b=0 m=1
* device instance $2029 r90 *1 1548.05,622.52 sg13_hv_nmos
M$2029 IOVSS \$I539988 ISA_P \$1 sg13_hv_nmos L=0.6u W=88u AS=40.7p AD=40.7p
+ PS=110.9u PD=110.9u rfmode=0
* device instance $2049 r90 *1 1549.825,663.3 rppd
R$2049 IOVSS \$I539988 \$1 rppd w=0.5u l=3.54u ps=0u b=0 m=1
* device instance $2051 r90 *1 1548.05,764.52 sg13_hv_nmos
M$2051 IOVSS \$I539989 ISA_N \$1 sg13_hv_nmos L=0.6u W=88u AS=40.7p AD=40.7p
+ PS=110.9u PD=110.9u rfmode=0
* device instance $2071 r90 *1 1549.825,805.3 rppd
R$2071 IOVSS \$I539989 \$1 rppd w=0.5u l=3.54u ps=0u b=0 m=1
* device instance $2073 r90 *1 1548.05,480.52 sg13_hv_nmos
M$2073 IOVSS \$I539990 VDDA \$1 sg13_hv_nmos L=0.6u W=88u AS=40.7p AD=40.7p
+ PS=110.9u PD=110.9u rfmode=0
* device instance $2093 r90 *1 1549.825,521.3 rppd
R$2093 IOVSS \$I539990 \$1 rppd w=0.5u l=3.54u ps=0u b=0 m=1
* device instance $2095 m0 *1 1204.11,1480.82 sg13_hv_pmos
M$2095 IOVDD \$I539914 SLO_SDO IOVDD sg13_hv_pmos L=0.6u W=26.64u AS=14.1192p
+ AD=14.1192p PS=44.2u PD=44.2u rfmode=0
* device instance $2099 m0 *1 1185.24,1477.93 dpantenna
D$2099 \$I539914 IOVDD dpantenna A=0.2304p P=1.92u m=1
* device instance $2101 r90 *1 1480.82,1204.11 sg13_hv_pmos
M$2101 IOVDD \$I539917 FAULT_N IOVDD sg13_hv_pmos L=0.6u W=26.64u AS=14.1192p
+ AD=14.1192p PS=44.2u PD=44.2u rfmode=0
* device instance $2105 r90 *1 1477.93,1185.24 dpantenna
D$2105 \$I539917 IOVDD dpantenna A=0.2304p P=1.92u m=1
* device instance $2107 m0 *1 1204.11,1548.05 sg13_hv_nmos
M$2107 IOVSS \$I539913 SLO_SDO \$1 sg13_hv_nmos L=0.6u W=8.8u AS=4.664p
+ AD=4.664p PS=15.32u PD=15.32u rfmode=0
* device instance $2109 m0 *1 1185.24,1546.26 dantenna
D$2109 \$1 \$I539913 dantenna A=0.6084p P=3.12u m=1
* device instance $2111 r90 *1 1548.05,1204.11 sg13_hv_nmos
M$2111 IOVSS \$I539916 FAULT_N \$1 sg13_hv_nmos L=0.6u W=8.8u AS=4.664p
+ AD=4.664p PS=15.32u PD=15.32u rfmode=0
* device instance $2113 r90 *1 1546.26,1185.24 dantenna
D$2113 \$1 \$I539916 dantenna A=0.6084p P=3.12u m=1
* device instance $2115 m0 *1 1205,1498.54 dpantenna
D$2115 SLO_SDO IOVDD dpantenna A=35.0028p P=58.08u m=2
* device instance $2118 r90 *1 1498.54,1205 dpantenna
D$2118 FAULT_N IOVDD dpantenna A=35.0028p P=58.08u m=2
* device instance $2121 m0 *1 1205,1534.06 dantenna
D$2121 \$1 SLO_SDO dantenna A=35.0028p P=58.08u m=2
* device instance $2124 r90 *1 1534.06,1205 dantenna
D$2124 \$1 FAULT_N dantenna A=35.0028p P=58.08u m=2
* device instance $2127 m45 *1 300.005,637.255 sg13_lv_nmos
M$2127 \$12.p2c \$I539994 VSS \$1 sg13_lv_nmos L=0.13u W=2.75u AS=0.935p
+ AD=0.935p PS=6.18u PD=6.18u rfmode=0
* device instance $2128 m45 *1 300.055,638.765 sg13_hv_nmos
M$2128 VSS \$I539992 \$I539994 \$1 sg13_hv_nmos L=0.45u W=2.65u AS=0.901p
+ AD=0.5035p PS=5.98u PD=3.03u rfmode=0
* device instance $2129 m45 *1 300.055,639.595 sg13_hv_nmos
M$2129 \$I539994 \$I539991 VDD \$1 sg13_hv_nmos L=0.45u W=2.65u AS=0.5035p
+ AD=0.901p PS=3.03u PD=5.98u rfmode=0
* device instance $2130 m45 *1 282.87,646.755 sg13_hv_nmos
M$2130 \$I539991 \$I539993 IOVSS \$1 sg13_hv_nmos L=0.45u W=1.3u AS=0.442p
+ AD=0.247p PS=3.28u PD=1.68u rfmode=0
* device instance $2131 m45 *1 282.87,647.585 sg13_hv_nmos
M$2131 IOVSS \$I539991 \$I539992 \$1 sg13_hv_nmos L=0.45u W=1.3u AS=0.247p
+ AD=0.442p PS=1.68u PD=3.28u rfmode=0
* device instance $2132 m45 *1 304.995,637.255 sg13_lv_pmos
M$2132 \$12.p2c \$I539994 VDD VDD sg13_lv_pmos L=0.13u W=4.75u AS=1.615p
+ AD=1.615p PS=10.18u PD=10.18u rfmode=0
* device instance $2133 m45 *1 287.27,645.925 sg13_hv_pmos
M$2133 IOVDD \$I539993 \$I539991 IOVDD sg13_hv_pmos L=0.45u W=4.6u AS=1.219p
+ AD=0.874p PS=7.96u PD=5.36u rfmode=0
* device instance $2135 m45 *1 287.27,647.585 sg13_hv_pmos
M$2135 IOVDD \$I539991 \$I539992 IOVDD sg13_hv_pmos L=0.45u W=4.6u AS=0.874p
+ AD=1.219p PS=5.36u PD=7.96u rfmode=0
* device instance $2139 m0 *1 1063.255,1399.995 sg13_lv_nmos
M$2139 \$13.p2c \$I539998 VSS \$1 sg13_lv_nmos L=0.13u W=2.75u AS=0.935p
+ AD=0.935p PS=6.18u PD=6.18u rfmode=0
* device instance $2140 m0 *1 1064.765,1399.945 sg13_hv_nmos
M$2140 VSS \$I539996 \$I539998 \$1 sg13_hv_nmos L=0.45u W=2.65u AS=0.901p
+ AD=0.5035p PS=5.98u PD=3.03u rfmode=0
* device instance $2141 m0 *1 1065.595,1399.945 sg13_hv_nmos
M$2141 \$I539998 \$I539995 VDD \$1 sg13_hv_nmos L=0.45u W=2.65u AS=0.5035p
+ AD=0.901p PS=3.03u PD=5.98u rfmode=0
* device instance $2142 m0 *1 1072.755,1417.13 sg13_hv_nmos
M$2142 \$I539995 \$I539997 IOVSS \$1 sg13_hv_nmos L=0.45u W=1.3u AS=0.442p
+ AD=0.247p PS=3.28u PD=1.68u rfmode=0
* device instance $2143 m0 *1 1073.585,1417.13 sg13_hv_nmos
M$2143 IOVSS \$I539995 \$I539996 \$1 sg13_hv_nmos L=0.45u W=1.3u AS=0.247p
+ AD=0.442p PS=1.68u PD=3.28u rfmode=0
* device instance $2144 m0 *1 1063.255,1395.005 sg13_lv_pmos
M$2144 \$13.p2c \$I539998 VDD VDD sg13_lv_pmos L=0.13u W=4.75u AS=1.615p
+ AD=1.615p PS=10.18u PD=10.18u rfmode=0
* device instance $2145 m0 *1 1071.925,1412.73 sg13_hv_pmos
M$2145 IOVDD \$I539997 \$I539995 IOVDD sg13_hv_pmos L=0.45u W=4.6u AS=1.219p
+ AD=0.874p PS=7.96u PD=5.36u rfmode=0
* device instance $2147 m0 *1 1073.585,1412.73 sg13_hv_pmos
M$2147 IOVDD \$I539995 \$I539996 IOVDD sg13_hv_pmos L=0.45u W=4.6u AS=0.874p
+ AD=1.219p PS=5.36u PD=7.96u rfmode=0
* device instance $2151 m0 *1 921.255,1399.995 sg13_lv_nmos
M$2151 \$14.p2c \$I540002 VSS \$1 sg13_lv_nmos L=0.13u W=2.75u AS=0.935p
+ AD=0.935p PS=6.18u PD=6.18u rfmode=0
* device instance $2152 m0 *1 922.765,1399.945 sg13_hv_nmos
M$2152 VSS \$I540000 \$I540002 \$1 sg13_hv_nmos L=0.45u W=2.65u AS=0.901p
+ AD=0.5035p PS=5.98u PD=3.03u rfmode=0
* device instance $2153 m0 *1 923.595,1399.945 sg13_hv_nmos
M$2153 \$I540002 \$I539999 VDD \$1 sg13_hv_nmos L=0.45u W=2.65u AS=0.5035p
+ AD=0.901p PS=3.03u PD=5.98u rfmode=0
* device instance $2154 m0 *1 930.755,1417.13 sg13_hv_nmos
M$2154 \$I539999 \$I540001 IOVSS \$1 sg13_hv_nmos L=0.45u W=1.3u AS=0.442p
+ AD=0.247p PS=3.28u PD=1.68u rfmode=0
* device instance $2155 m0 *1 931.585,1417.13 sg13_hv_nmos
M$2155 IOVSS \$I539999 \$I540000 \$1 sg13_hv_nmos L=0.45u W=1.3u AS=0.247p
+ AD=0.442p PS=1.68u PD=3.28u rfmode=0
* device instance $2156 m0 *1 921.255,1395.005 sg13_lv_pmos
M$2156 \$14.p2c \$I540002 VDD VDD sg13_lv_pmos L=0.13u W=4.75u AS=1.615p
+ AD=1.615p PS=10.18u PD=10.18u rfmode=0
* device instance $2157 m0 *1 929.925,1412.73 sg13_hv_pmos
M$2157 IOVDD \$I540001 \$I539999 IOVDD sg13_hv_pmos L=0.45u W=4.6u AS=1.219p
+ AD=0.874p PS=7.96u PD=5.36u rfmode=0
* device instance $2159 m0 *1 931.585,1412.73 sg13_hv_pmos
M$2159 IOVDD \$I539999 \$I540000 IOVDD sg13_hv_pmos L=0.45u W=4.6u AS=0.874p
+ AD=1.219p PS=5.36u PD=7.96u rfmode=0
* device instance $2163 m45 *1 300.005,495.255 sg13_lv_nmos
M$2163 \$509035.p2c \$I540006 VSS \$1 sg13_lv_nmos L=0.13u W=2.75u AS=0.935p
+ AD=0.935p PS=6.18u PD=6.18u rfmode=0
* device instance $2164 m45 *1 300.055,496.765 sg13_hv_nmos
M$2164 VSS \$I540004 \$I540006 \$1 sg13_hv_nmos L=0.45u W=2.65u AS=0.901p
+ AD=0.5035p PS=5.98u PD=3.03u rfmode=0
* device instance $2165 m45 *1 300.055,497.595 sg13_hv_nmos
M$2165 \$I540006 \$I540003 VDD \$1 sg13_hv_nmos L=0.45u W=2.65u AS=0.5035p
+ AD=0.901p PS=3.03u PD=5.98u rfmode=0
* device instance $2166 m45 *1 282.87,504.755 sg13_hv_nmos
M$2166 \$I540003 \$I540005 IOVSS \$1 sg13_hv_nmos L=0.45u W=1.3u AS=0.442p
+ AD=0.247p PS=3.28u PD=1.68u rfmode=0
* device instance $2167 m45 *1 282.87,505.585 sg13_hv_nmos
M$2167 IOVSS \$I540003 \$I540004 \$1 sg13_hv_nmos L=0.45u W=1.3u AS=0.247p
+ AD=0.442p PS=1.68u PD=3.28u rfmode=0
* device instance $2168 m45 *1 304.995,495.255 sg13_lv_pmos
M$2168 \$509035.p2c \$I540006 VDD VDD sg13_lv_pmos L=0.13u W=4.75u AS=1.615p
+ AD=1.615p PS=10.18u PD=10.18u rfmode=0
* device instance $2169 m45 *1 287.27,503.925 sg13_hv_pmos
M$2169 IOVDD \$I540005 \$I540003 IOVDD sg13_hv_pmos L=0.45u W=4.6u AS=1.219p
+ AD=0.874p PS=7.96u PD=5.36u rfmode=0
* device instance $2171 m45 *1 287.27,505.585 sg13_hv_pmos
M$2171 IOVDD \$I540003 \$I540004 IOVDD sg13_hv_pmos L=0.45u W=4.6u AS=0.874p
+ AD=1.219p PS=5.36u PD=7.96u rfmode=0
* device instance $2175 m0 *1 224.19,601.54 dpantenna
D$2175 EN_STO_IN IOVDD dpantenna A=35.0028p P=58.08u m=2
* device instance $2178 m135 *1 1027.54,1475.81 dpantenna
D$2178 MA_SCLK IOVDD dpantenna A=35.0028p P=58.08u m=2
* device instance $2181 m135 *1 885.54,1475.81 dpantenna
D$2181 CS_N IOVDD dpantenna A=35.0028p P=58.08u m=2
* device instance $2184 m0 *1 224.19,459.54 dpantenna
D$2184 SDI IOVDD dpantenna A=35.0028p P=58.08u m=2
* device instance $2187 m0 *1 165.19,601.54 dantenna
D$2187 \$1 EN_STO_IN dantenna A=35.0028p P=58.08u m=2
* device instance $2190 m135 *1 1027.54,1534.81 dantenna
D$2190 \$1 MA_SCLK dantenna A=35.0028p P=58.08u m=2
* device instance $2193 m135 *1 885.54,1534.81 dantenna
D$2193 \$1 CS_N dantenna A=35.0028p P=58.08u m=2
* device instance $2196 m0 *1 165.19,459.54 dantenna
D$2196 \$1 SDI dantenna A=35.0028p P=58.08u m=2
* device instance $2199 m0 *1 634.48,1399.995 sg13_lv_nmos
M$2199 \$I540009 \$1.c2p VSS \$1 sg13_lv_nmos L=0.13u W=2.75u AS=0.935p
+ AD=0.935p PS=6.18u PD=6.18u rfmode=0
* device instance $2200 m0 *1 636.81,1403.68 sg13_hv_nmos
M$2200 VSS \$I540008 \$I539895 \$1 sg13_hv_nmos L=0.45u W=1.9u AS=0.646p
+ AD=0.646p PS=4.48u PD=4.48u rfmode=0
* device instance $2201 m0 *1 634.64,1403.68 sg13_hv_nmos
M$2201 \$I540007 \$1.c2p VSS \$1 sg13_hv_nmos L=0.45u W=1.9u AS=0.646p
+ AD=0.361p PS=4.48u PD=2.28u rfmode=0
* device instance $2202 m0 *1 635.47,1403.68 sg13_hv_nmos
M$2202 VSS \$I540009 \$I540008 \$1 sg13_hv_nmos L=0.45u W=1.9u AS=0.361p
+ AD=0.646p PS=2.28u PD=4.48u rfmode=0
* device instance $2203 m0 *1 634.48,1395.005 sg13_lv_pmos
M$2203 \$I540009 \$1.c2p VDD VDD sg13_lv_pmos L=0.13u W=4.75u AS=1.615p
+ AD=1.615p PS=10.18u PD=10.18u rfmode=0
* device instance $2204 m0 *1 636.81,1407.82 sg13_hv_pmos
M$2204 IOVDD \$I540008 \$I539895 IOVDD sg13_hv_pmos L=0.45u W=3.9u AS=1.326p
+ AD=1.326p PS=8.48u PD=8.48u rfmode=0
* device instance $2205 m0 *1 634.64,1407.82 sg13_hv_pmos
M$2205 \$I540007 \$I540008 IOVDD IOVDD sg13_hv_pmos L=0.45u W=0.3u AS=0.102p
+ AD=0.057p PS=1.28u PD=0.68u rfmode=0
* device instance $2206 m0 *1 635.47,1407.82 sg13_hv_pmos
M$2206 IOVDD \$I540007 \$I540008 IOVDD sg13_hv_pmos L=0.45u W=0.3u AS=0.057p
+ AD=0.102p PS=0.68u PD=1.28u rfmode=0
* device instance $2208 m0 *1 637.99,1399.995 sg13_lv_nmos
M$2208 \$I540012 \$1.c2p VSS \$1 sg13_lv_nmos L=0.13u W=2.75u AS=0.935p
+ AD=0.935p PS=6.18u PD=6.18u rfmode=0
* device instance $2209 m0 *1 640.32,1403.68 sg13_hv_nmos
M$2209 VSS \$I540011 \$I539896 \$1 sg13_hv_nmos L=0.45u W=1.9u AS=0.646p
+ AD=0.646p PS=4.48u PD=4.48u rfmode=0
* device instance $2210 m0 *1 638.15,1403.68 sg13_hv_nmos
M$2210 \$I540010 \$1.c2p VSS \$1 sg13_hv_nmos L=0.45u W=1.9u AS=0.646p
+ AD=0.361p PS=4.48u PD=2.28u rfmode=0
* device instance $2211 m0 *1 638.98,1403.68 sg13_hv_nmos
M$2211 VSS \$I540012 \$I540011 \$1 sg13_hv_nmos L=0.45u W=1.9u AS=0.361p
+ AD=0.646p PS=2.28u PD=4.48u rfmode=0
* device instance $2212 m0 *1 637.99,1395.005 sg13_lv_pmos
M$2212 \$I540012 \$1.c2p VDD VDD sg13_lv_pmos L=0.13u W=4.75u AS=1.615p
+ AD=1.615p PS=10.18u PD=10.18u rfmode=0
* device instance $2213 m0 *1 640.32,1407.82 sg13_hv_pmos
M$2213 IOVDD \$I540011 \$I539896 IOVDD sg13_hv_pmos L=0.45u W=3.9u AS=1.326p
+ AD=1.326p PS=8.48u PD=8.48u rfmode=0
* device instance $2214 m0 *1 638.15,1407.82 sg13_hv_pmos
M$2214 \$I540010 \$I540011 IOVDD IOVDD sg13_hv_pmos L=0.45u W=0.3u AS=0.102p
+ AD=0.057p PS=1.28u PD=0.68u rfmode=0
* device instance $2215 m0 *1 638.98,1407.82 sg13_hv_pmos
M$2215 IOVDD \$I540010 \$I540011 IOVDD sg13_hv_pmos L=0.45u W=0.3u AS=0.057p
+ AD=0.102p PS=0.68u PD=1.28u rfmode=0
* device instance $2217 m0 *1 776.48,1399.995 sg13_lv_nmos
M$2217 \$I540015 \$2.c2p VSS \$1 sg13_lv_nmos L=0.13u W=2.75u AS=0.935p
+ AD=0.935p PS=6.18u PD=6.18u rfmode=0
* device instance $2218 m0 *1 778.81,1403.68 sg13_hv_nmos
M$2218 VSS \$I540014 \$I539898 \$1 sg13_hv_nmos L=0.45u W=1.9u AS=0.646p
+ AD=0.646p PS=4.48u PD=4.48u rfmode=0
* device instance $2219 m0 *1 776.64,1403.68 sg13_hv_nmos
M$2219 \$I540013 \$2.c2p VSS \$1 sg13_hv_nmos L=0.45u W=1.9u AS=0.646p
+ AD=0.361p PS=4.48u PD=2.28u rfmode=0
* device instance $2220 m0 *1 777.47,1403.68 sg13_hv_nmos
M$2220 VSS \$I540015 \$I540014 \$1 sg13_hv_nmos L=0.45u W=1.9u AS=0.361p
+ AD=0.646p PS=2.28u PD=4.48u rfmode=0
* device instance $2221 m0 *1 776.48,1395.005 sg13_lv_pmos
M$2221 \$I540015 \$2.c2p VDD VDD sg13_lv_pmos L=0.13u W=4.75u AS=1.615p
+ AD=1.615p PS=10.18u PD=10.18u rfmode=0
* device instance $2222 m0 *1 778.81,1407.82 sg13_hv_pmos
M$2222 IOVDD \$I540014 \$I539898 IOVDD sg13_hv_pmos L=0.45u W=3.9u AS=1.326p
+ AD=1.326p PS=8.48u PD=8.48u rfmode=0
* device instance $2223 m0 *1 776.64,1407.82 sg13_hv_pmos
M$2223 \$I540013 \$I540014 IOVDD IOVDD sg13_hv_pmos L=0.45u W=0.3u AS=0.102p
+ AD=0.057p PS=1.28u PD=0.68u rfmode=0
* device instance $2224 m0 *1 777.47,1407.82 sg13_hv_pmos
M$2224 IOVDD \$I540013 \$I540014 IOVDD sg13_hv_pmos L=0.45u W=0.3u AS=0.057p
+ AD=0.102p PS=0.68u PD=1.28u rfmode=0
* device instance $2226 m0 *1 779.99,1399.995 sg13_lv_nmos
M$2226 \$I540018 \$2.c2p VSS \$1 sg13_lv_nmos L=0.13u W=2.75u AS=0.935p
+ AD=0.935p PS=6.18u PD=6.18u rfmode=0
* device instance $2227 m0 *1 782.32,1403.68 sg13_hv_nmos
M$2227 VSS \$I540017 \$I539899 \$1 sg13_hv_nmos L=0.45u W=1.9u AS=0.646p
+ AD=0.646p PS=4.48u PD=4.48u rfmode=0
* device instance $2228 m0 *1 780.15,1403.68 sg13_hv_nmos
M$2228 \$I540016 \$2.c2p VSS \$1 sg13_hv_nmos L=0.45u W=1.9u AS=0.646p
+ AD=0.361p PS=4.48u PD=2.28u rfmode=0
* device instance $2229 m0 *1 780.98,1403.68 sg13_hv_nmos
M$2229 VSS \$I540018 \$I540017 \$1 sg13_hv_nmos L=0.45u W=1.9u AS=0.361p
+ AD=0.646p PS=2.28u PD=4.48u rfmode=0
* device instance $2230 m0 *1 779.99,1395.005 sg13_lv_pmos
M$2230 \$I540018 \$2.c2p VDD VDD sg13_lv_pmos L=0.13u W=4.75u AS=1.615p
+ AD=1.615p PS=10.18u PD=10.18u rfmode=0
* device instance $2231 m0 *1 782.32,1407.82 sg13_hv_pmos
M$2231 IOVDD \$I540017 \$I539899 IOVDD sg13_hv_pmos L=0.45u W=3.9u AS=1.326p
+ AD=1.326p PS=8.48u PD=8.48u rfmode=0
* device instance $2232 m0 *1 780.15,1407.82 sg13_hv_pmos
M$2232 \$I540016 \$I540017 IOVDD IOVDD sg13_hv_pmos L=0.45u W=0.3u AS=0.102p
+ AD=0.057p PS=1.28u PD=0.68u rfmode=0
* device instance $2233 m0 *1 780.98,1407.82 sg13_hv_pmos
M$2233 IOVDD \$I540016 \$I540017 IOVDD sg13_hv_pmos L=0.45u W=0.3u AS=0.057p
+ AD=0.102p PS=0.68u PD=1.28u rfmode=0
* device instance $2235 m0 *1 492.48,1399.995 sg13_lv_nmos
M$2235 \$I540021 \$187433.c2p VSS \$1 sg13_lv_nmos L=0.13u W=2.75u AS=0.935p
+ AD=0.935p PS=6.18u PD=6.18u rfmode=0
* device instance $2236 m0 *1 494.81,1403.68 sg13_hv_nmos
M$2236 VSS \$I540020 \$I539901 \$1 sg13_hv_nmos L=0.45u W=1.9u AS=0.646p
+ AD=0.646p PS=4.48u PD=4.48u rfmode=0
* device instance $2237 m0 *1 492.64,1403.68 sg13_hv_nmos
M$2237 \$I540019 \$187433.c2p VSS \$1 sg13_hv_nmos L=0.45u W=1.9u AS=0.646p
+ AD=0.361p PS=4.48u PD=2.28u rfmode=0
* device instance $2238 m0 *1 493.47,1403.68 sg13_hv_nmos
M$2238 VSS \$I540021 \$I540020 \$1 sg13_hv_nmos L=0.45u W=1.9u AS=0.361p
+ AD=0.646p PS=2.28u PD=4.48u rfmode=0
* device instance $2239 m0 *1 492.48,1395.005 sg13_lv_pmos
M$2239 \$I540021 \$187433.c2p VDD VDD sg13_lv_pmos L=0.13u W=4.75u AS=1.615p
+ AD=1.615p PS=10.18u PD=10.18u rfmode=0
* device instance $2240 m0 *1 494.81,1407.82 sg13_hv_pmos
M$2240 IOVDD \$I540020 \$I539901 IOVDD sg13_hv_pmos L=0.45u W=3.9u AS=1.326p
+ AD=1.326p PS=8.48u PD=8.48u rfmode=0
* device instance $2241 m0 *1 492.64,1407.82 sg13_hv_pmos
M$2241 \$I540019 \$I540020 IOVDD IOVDD sg13_hv_pmos L=0.45u W=0.3u AS=0.102p
+ AD=0.057p PS=1.28u PD=0.68u rfmode=0
* device instance $2242 m0 *1 493.47,1407.82 sg13_hv_pmos
M$2242 IOVDD \$I540019 \$I540020 IOVDD sg13_hv_pmos L=0.45u W=0.3u AS=0.057p
+ AD=0.102p PS=0.68u PD=1.28u rfmode=0
* device instance $2244 m0 *1 495.99,1399.995 sg13_lv_nmos
M$2244 \$I540024 \$187433.c2p VSS \$1 sg13_lv_nmos L=0.13u W=2.75u AS=0.935p
+ AD=0.935p PS=6.18u PD=6.18u rfmode=0
* device instance $2245 m0 *1 498.32,1403.68 sg13_hv_nmos
M$2245 VSS \$I540023 \$I539902 \$1 sg13_hv_nmos L=0.45u W=1.9u AS=0.646p
+ AD=0.646p PS=4.48u PD=4.48u rfmode=0
* device instance $2246 m0 *1 496.15,1403.68 sg13_hv_nmos
M$2246 \$I540022 \$187433.c2p VSS \$1 sg13_hv_nmos L=0.45u W=1.9u AS=0.646p
+ AD=0.361p PS=4.48u PD=2.28u rfmode=0
* device instance $2247 m0 *1 496.98,1403.68 sg13_hv_nmos
M$2247 VSS \$I540024 \$I540023 \$1 sg13_hv_nmos L=0.45u W=1.9u AS=0.361p
+ AD=0.646p PS=2.28u PD=4.48u rfmode=0
* device instance $2248 m0 *1 495.99,1395.005 sg13_lv_pmos
M$2248 \$I540024 \$187433.c2p VDD VDD sg13_lv_pmos L=0.13u W=4.75u AS=1.615p
+ AD=1.615p PS=10.18u PD=10.18u rfmode=0
* device instance $2249 m0 *1 498.32,1407.82 sg13_hv_pmos
M$2249 IOVDD \$I540023 \$I539902 IOVDD sg13_hv_pmos L=0.45u W=3.9u AS=1.326p
+ AD=1.326p PS=8.48u PD=8.48u rfmode=0
* device instance $2250 m0 *1 496.15,1407.82 sg13_hv_pmos
M$2250 \$I540022 \$I540023 IOVDD IOVDD sg13_hv_pmos L=0.45u W=0.3u AS=0.102p
+ AD=0.057p PS=1.28u PD=0.68u rfmode=0
* device instance $2251 m0 *1 496.98,1407.82 sg13_hv_pmos
M$2251 IOVDD \$I540022 \$I540023 IOVDD sg13_hv_pmos L=0.45u W=0.3u AS=0.057p
+ AD=0.102p PS=0.68u PD=1.28u rfmode=0
* device instance $2253 m0 *1 1202.48,1399.995 sg13_lv_nmos
M$2253 \$I540027 \$3.c2p VSS \$1 sg13_lv_nmos L=0.13u W=2.75u AS=0.935p
+ AD=0.935p PS=6.18u PD=6.18u rfmode=0
* device instance $2254 m0 *1 1204.81,1403.68 sg13_hv_nmos
M$2254 VSS \$I540026 \$I539913 \$1 sg13_hv_nmos L=0.45u W=1.9u AS=0.646p
+ AD=0.646p PS=4.48u PD=4.48u rfmode=0
* device instance $2255 m0 *1 1202.64,1403.68 sg13_hv_nmos
M$2255 \$I540025 \$3.c2p VSS \$1 sg13_hv_nmos L=0.45u W=1.9u AS=0.646p
+ AD=0.361p PS=4.48u PD=2.28u rfmode=0
* device instance $2256 m0 *1 1203.47,1403.68 sg13_hv_nmos
M$2256 VSS \$I540027 \$I540026 \$1 sg13_hv_nmos L=0.45u W=1.9u AS=0.361p
+ AD=0.646p PS=2.28u PD=4.48u rfmode=0
* device instance $2257 m0 *1 1202.48,1395.005 sg13_lv_pmos
M$2257 \$I540027 \$3.c2p VDD VDD sg13_lv_pmos L=0.13u W=4.75u AS=1.615p
+ AD=1.615p PS=10.18u PD=10.18u rfmode=0
* device instance $2258 m0 *1 1204.81,1407.82 sg13_hv_pmos
M$2258 IOVDD \$I540026 \$I539913 IOVDD sg13_hv_pmos L=0.45u W=3.9u AS=1.326p
+ AD=1.326p PS=8.48u PD=8.48u rfmode=0
* device instance $2259 m0 *1 1202.64,1407.82 sg13_hv_pmos
M$2259 \$I540025 \$I540026 IOVDD IOVDD sg13_hv_pmos L=0.45u W=0.3u AS=0.102p
+ AD=0.057p PS=1.28u PD=0.68u rfmode=0
* device instance $2260 m0 *1 1203.47,1407.82 sg13_hv_pmos
M$2260 IOVDD \$I540025 \$I540026 IOVDD sg13_hv_pmos L=0.45u W=0.3u AS=0.057p
+ AD=0.102p PS=0.68u PD=1.28u rfmode=0
* device instance $2262 m0 *1 1205.99,1399.995 sg13_lv_nmos
M$2262 \$I540030 \$3.c2p VSS \$1 sg13_lv_nmos L=0.13u W=2.75u AS=0.935p
+ AD=0.935p PS=6.18u PD=6.18u rfmode=0
* device instance $2263 m0 *1 1208.32,1403.68 sg13_hv_nmos
M$2263 VSS \$I540029 \$I539914 \$1 sg13_hv_nmos L=0.45u W=1.9u AS=0.646p
+ AD=0.646p PS=4.48u PD=4.48u rfmode=0
* device instance $2264 m0 *1 1206.15,1403.68 sg13_hv_nmos
M$2264 \$I540028 \$3.c2p VSS \$1 sg13_hv_nmos L=0.45u W=1.9u AS=0.646p
+ AD=0.361p PS=4.48u PD=2.28u rfmode=0
* device instance $2265 m0 *1 1206.98,1403.68 sg13_hv_nmos
M$2265 VSS \$I540030 \$I540029 \$1 sg13_hv_nmos L=0.45u W=1.9u AS=0.361p
+ AD=0.646p PS=2.28u PD=4.48u rfmode=0
* device instance $2266 m0 *1 1205.99,1395.005 sg13_lv_pmos
M$2266 \$I540030 \$3.c2p VDD VDD sg13_lv_pmos L=0.13u W=4.75u AS=1.615p
+ AD=1.615p PS=10.18u PD=10.18u rfmode=0
* device instance $2267 m0 *1 1208.32,1407.82 sg13_hv_pmos
M$2267 IOVDD \$I540029 \$I539914 IOVDD sg13_hv_pmos L=0.45u W=3.9u AS=1.326p
+ AD=1.326p PS=8.48u PD=8.48u rfmode=0
* device instance $2268 m0 *1 1206.15,1407.82 sg13_hv_pmos
M$2268 \$I540028 \$I540029 IOVDD IOVDD sg13_hv_pmos L=0.45u W=0.3u AS=0.102p
+ AD=0.057p PS=1.28u PD=0.68u rfmode=0
* device instance $2269 m0 *1 1206.98,1407.82 sg13_hv_pmos
M$2269 IOVDD \$I540028 \$I540029 IOVDD sg13_hv_pmos L=0.45u W=0.3u AS=0.057p
+ AD=0.102p PS=0.68u PD=1.28u rfmode=0
* device instance $2271 r90 *1 1399.995,1202.48 sg13_lv_nmos
M$2271 \$I540033 \$521188.c2p VSS \$1 sg13_lv_nmos L=0.13u W=2.75u AS=0.935p
+ AD=0.935p PS=6.18u PD=6.18u rfmode=0
* device instance $2272 r90 *1 1403.68,1204.81 sg13_hv_nmos
M$2272 VSS \$I540032 \$I539916 \$1 sg13_hv_nmos L=0.45u W=1.9u AS=0.646p
+ AD=0.646p PS=4.48u PD=4.48u rfmode=0
* device instance $2273 r90 *1 1403.68,1202.64 sg13_hv_nmos
M$2273 \$I540031 \$521188.c2p VSS \$1 sg13_hv_nmos L=0.45u W=1.9u AS=0.646p
+ AD=0.361p PS=4.48u PD=2.28u rfmode=0
* device instance $2274 r90 *1 1403.68,1203.47 sg13_hv_nmos
M$2274 VSS \$I540033 \$I540032 \$1 sg13_hv_nmos L=0.45u W=1.9u AS=0.361p
+ AD=0.646p PS=2.28u PD=4.48u rfmode=0
* device instance $2275 r90 *1 1395.005,1202.48 sg13_lv_pmos
M$2275 \$I540033 \$521188.c2p VDD VDD sg13_lv_pmos L=0.13u W=4.75u AS=1.615p
+ AD=1.615p PS=10.18u PD=10.18u rfmode=0
* device instance $2276 r90 *1 1407.82,1204.81 sg13_hv_pmos
M$2276 IOVDD \$I540032 \$I539916 IOVDD sg13_hv_pmos L=0.45u W=3.9u AS=1.326p
+ AD=1.326p PS=8.48u PD=8.48u rfmode=0
* device instance $2277 r90 *1 1407.82,1202.64 sg13_hv_pmos
M$2277 \$I540031 \$I540032 IOVDD IOVDD sg13_hv_pmos L=0.45u W=0.3u AS=0.102p
+ AD=0.057p PS=1.28u PD=0.68u rfmode=0
* device instance $2278 r90 *1 1407.82,1203.47 sg13_hv_pmos
M$2278 IOVDD \$I540031 \$I540032 IOVDD sg13_hv_pmos L=0.45u W=0.3u AS=0.057p
+ AD=0.102p PS=0.68u PD=1.28u rfmode=0
* device instance $2280 r90 *1 1399.995,1205.99 sg13_lv_nmos
M$2280 \$I540036 \$521188.c2p VSS \$1 sg13_lv_nmos L=0.13u W=2.75u AS=0.935p
+ AD=0.935p PS=6.18u PD=6.18u rfmode=0
* device instance $2281 r90 *1 1403.68,1208.32 sg13_hv_nmos
M$2281 VSS \$I540035 \$I539917 \$1 sg13_hv_nmos L=0.45u W=1.9u AS=0.646p
+ AD=0.646p PS=4.48u PD=4.48u rfmode=0
* device instance $2282 r90 *1 1403.68,1206.15 sg13_hv_nmos
M$2282 \$I540034 \$521188.c2p VSS \$1 sg13_hv_nmos L=0.45u W=1.9u AS=0.646p
+ AD=0.361p PS=4.48u PD=2.28u rfmode=0
* device instance $2283 r90 *1 1403.68,1206.98 sg13_hv_nmos
M$2283 VSS \$I540036 \$I540035 \$1 sg13_hv_nmos L=0.45u W=1.9u AS=0.361p
+ AD=0.646p PS=2.28u PD=4.48u rfmode=0
* device instance $2284 r90 *1 1395.005,1205.99 sg13_lv_pmos
M$2284 \$I540036 \$521188.c2p VDD VDD sg13_lv_pmos L=0.13u W=4.75u AS=1.615p
+ AD=1.615p PS=10.18u PD=10.18u rfmode=0
* device instance $2285 r90 *1 1407.82,1208.32 sg13_hv_pmos
M$2285 IOVDD \$I540035 \$I539917 IOVDD sg13_hv_pmos L=0.45u W=3.9u AS=1.326p
+ AD=1.326p PS=8.48u PD=8.48u rfmode=0
* device instance $2286 r90 *1 1407.82,1206.15 sg13_hv_pmos
M$2286 \$I540034 \$I540035 IOVDD IOVDD sg13_hv_pmos L=0.45u W=0.3u AS=0.102p
+ AD=0.057p PS=1.28u PD=0.68u rfmode=0
* device instance $2287 r90 *1 1407.82,1206.98 sg13_hv_pmos
M$2287 IOVDD \$I540034 \$I540035 IOVDD sg13_hv_pmos L=0.45u W=0.3u AS=0.057p
+ AD=0.102p PS=0.68u PD=1.28u rfmode=0
* device instance $2289 m45 *1 283.54,642.225 dantenna
D$2289 \$1 \$I539993 dantenna A=1.984p P=7.48u m=1
* device instance $2290 m45 *1 288.51,640.055 dpantenna
D$2290 \$I539993 IOVDD dpantenna A=3.1872p P=11.24u m=1
* device instance $2291 m45 *1 282.535,637.68 rppd
R$2291 EN_STO_IN \$I539993 \$1 rppd w=1u l=2u ps=0u b=0 m=1
* device instance $2294 m0 *1 1068.225,1416.46 dantenna
D$2294 \$1 \$I539997 dantenna A=1.984p P=7.48u m=1
* device instance $2295 m0 *1 1066.055,1411.49 dpantenna
D$2295 \$I539997 IOVDD dpantenna A=3.1872p P=11.24u m=1
* device instance $2296 m0 *1 1063.68,1417.465 rppd
R$2296 MA_SCLK \$I539997 \$1 rppd w=1u l=2u ps=0u b=0 m=1
* device instance $2299 m0 *1 926.225,1416.46 dantenna
D$2299 \$1 \$I540001 dantenna A=1.984p P=7.48u m=1
* device instance $2300 m0 *1 924.055,1411.49 dpantenna
D$2300 \$I540001 IOVDD dpantenna A=3.1872p P=11.24u m=1
* device instance $2301 m0 *1 921.68,1417.465 rppd
R$2301 CS_N \$I540001 \$1 rppd w=1u l=2u ps=0u b=0 m=1
* device instance $2304 m45 *1 283.54,500.225 dantenna
D$2304 \$1 \$I540005 dantenna A=1.984p P=7.48u m=1
* device instance $2305 m45 *1 288.51,498.055 dpantenna
D$2305 \$I540005 IOVDD dpantenna A=3.1872p P=11.24u m=1
* device instance $2306 m45 *1 282.535,495.68 rppd
R$2306 SDI \$I540005 \$1 rppd w=1u l=2u ps=0u b=0 m=1
.ENDS r1_padring
