* r1_adc_r4p.spice -- R1 ADC revision 4, MSB pre-switch option (generated by gen_r1_adc_r4p.py; do not edit)
* Include after r1_adc_r4.spice (uses its cells).

* ---------------------------------------------------------------------------------------------
* r1_sar4p_logic: XSPICE SAR registers, 14 decisions, one register per slice (D17/D18: both slices convert
* in parallel, own comparator and own register). Timing inputs from r1_ctrl (ideal in the decks): mclk
* (from r1_cmp4_clkgen), wina/winb (conversion windows), stba0..13 / stbb0..13 (decision strobes, one set
* per slice: slice B may run N ticks after slice A), lata/latb, track signals (flag reset while tracking).
* Per decision: P <= outp at stb, V <= 1 at stb, N = V AND NOT P (exactly one side switches).
* Raw bits rX13..rX0 (rX13 = first decision) latched at latX.
* ---------------------------------------------------------------------------------------------
.subckt r1_sar4p_logic oap oan obp obn mclk wina winb trka0 trka1 trkb0 trkb1 lata latb stba0 stba1 stba2 stba3 stba4 stba5 stba6 stba7 stba8 stba9 stba10 stba11 stba12 stba13 stbb0 stbb1 stbb2 stbb3 stbb4 stbb5 stbb6 stbb7 stbb8 stbb9 stbb10 stbb11 stbb12 stbb13 clka clkab clkb clkbb cpa12 cpa11 cpa10 cpa9 cpa8 cpa7 cpa6 cpa5 cpa4 cpa3 cpa2 cpa1 cpa0 cna12 cna11 cna10 cna9 cna8 cna7 cna6 cna5 cna4 cna3 cna2 cna1 cna0 cpb12 cpb11 cpb10 cpb9 cpb8 cpb7 cpb6 cpb5 cpb4 cpb3 cpb2 cpb1 cpb0 cnb12 cnb11 cnb10 cnb9 cnb8 cnb7 cnb6 cnb5 cnb4 cnb3 cnb2 cnb1 cnb0 rawa rawb vdd gnd
.model r1_adcb adc_bridge(in_low=0.6 in_high=0.6 rise_delay=20p fall_delay=20p)
.model r1_dacb dac_bridge(out_low=0 out_high=1.2 out_undef=0.6 input_load=1e-15 t_rise=80p t_fall=80p)
.model r1_dff d_dff(clk_delay=80p set_delay=80p reset_delay=80p ic=0 rise_delay=20p fall_delay=20p)
.model r1_and d_and(rise_delay=30p fall_delay=30p)
.model r1_nand d_nand(rise_delay=30p fall_delay=30p)
.model r1_or d_or(rise_delay=30p fall_delay=30p)
ABR [vdd oap oan obp obn mclk wina winb trka0 trka1 trkb0 trkb1 lata latb stba0 stba1 stba2 stba3 stba4 stba5 stba6 stba7 stba8 stba9 stba10 stba11 stba12 stba13 stbb0 stbb1 stbb2 stbb3 stbb4 stbb5 stbb6 stbb7 stbb8 stbb9 stbb10 stbb11 stbb12 stbb13] [d_vdd d_oap d_oan d_obp d_obn d_mclk d_wina d_winb d_trka0 d_trka1 d_trkb0 d_trkb1 d_lata d_latb d_stba0 d_stba1 d_stba2 d_stba3 d_stba4 d_stba5 d_stba6 d_stba7 d_stba8 d_stba9 d_stba10 d_stba11 d_stba12 d_stba13 d_stbb0 d_stbb1 d_stbb2 d_stbb3 d_stbb4 d_stbb5 d_stbb6 d_stbb7 d_stbb8 d_stbb9 d_stbb10 d_stbb11 d_stbb12 d_stbb13] r1_adcb
AGA1 [d_mclk d_wina] g_clka r1_and
AGA2 [d_mclk d_wina] g_clkab r1_nand
AGB1 [d_mclk d_winb] g_clkb r1_and
AGB2 [d_mclk d_winb] g_clkbb r1_nand
AORA [d_trka0 d_trka1] d_rsta r1_or
AORB [d_trkb0 d_trkb1] d_rstb r1_or
AFPa0 d_oap d_stba0 NULL d_rsta fpa0 nfpa0 r1_dff
AFVa0 d_vdd d_stba0 NULL d_rsta fva0 nfva0 r1_dff
AFNa0 [fva0 nfpa0] fna0 r1_and
AQa0 fpa0 d_lata NULL NULL qa0 nqa0 r1_dff
AFPa1 d_oap d_stba1 NULL d_rsta fpa1 nfpa1 r1_dff
AFVa1 d_vdd d_stba1 NULL d_rsta fva1 nfva1 r1_dff
AFNa1 [fva1 nfpa1] fna1 r1_and
AQa1 fpa1 d_lata NULL NULL qa1 nqa1 r1_dff
AFPa2 d_oap d_stba2 NULL d_rsta fpa2 nfpa2 r1_dff
AFVa2 d_vdd d_stba2 NULL d_rsta fva2 nfva2 r1_dff
AFNa2 [fva2 nfpa2] fna2 r1_and
AQa2 fpa2 d_lata NULL NULL qa2 nqa2 r1_dff
AFPa3 d_oap d_stba3 NULL d_rsta fpa3 nfpa3 r1_dff
AFVa3 d_vdd d_stba3 NULL d_rsta fva3 nfva3 r1_dff
AFNa3 [fva3 nfpa3] fna3 r1_and
AQa3 fpa3 d_lata NULL NULL qa3 nqa3 r1_dff
AFPa4 d_oap d_stba4 NULL d_rsta fpa4 nfpa4 r1_dff
AFVa4 d_vdd d_stba4 NULL d_rsta fva4 nfva4 r1_dff
AFNa4 [fva4 nfpa4] fna4 r1_and
AQa4 fpa4 d_lata NULL NULL qa4 nqa4 r1_dff
AFPa5 d_oap d_stba5 NULL d_rsta fpa5 nfpa5 r1_dff
AFVa5 d_vdd d_stba5 NULL d_rsta fva5 nfva5 r1_dff
AFNa5 [fva5 nfpa5] fna5 r1_and
AQa5 fpa5 d_lata NULL NULL qa5 nqa5 r1_dff
AFPa6 d_oap d_stba6 NULL d_rsta fpa6 nfpa6 r1_dff
AFVa6 d_vdd d_stba6 NULL d_rsta fva6 nfva6 r1_dff
AFNa6 [fva6 nfpa6] fna6 r1_and
AQa6 fpa6 d_lata NULL NULL qa6 nqa6 r1_dff
AFPa7 d_oap d_stba7 NULL d_rsta fpa7 nfpa7 r1_dff
AFVa7 d_vdd d_stba7 NULL d_rsta fva7 nfva7 r1_dff
AFNa7 [fva7 nfpa7] fna7 r1_and
AQa7 fpa7 d_lata NULL NULL qa7 nqa7 r1_dff
AFPa8 d_oap d_stba8 NULL d_rsta fpa8 nfpa8 r1_dff
AFVa8 d_vdd d_stba8 NULL d_rsta fva8 nfva8 r1_dff
AFNa8 [fva8 nfpa8] fna8 r1_and
AQa8 fpa8 d_lata NULL NULL qa8 nqa8 r1_dff
AFPa9 d_oap d_stba9 NULL d_rsta fpa9 nfpa9 r1_dff
AFVa9 d_vdd d_stba9 NULL d_rsta fva9 nfva9 r1_dff
AFNa9 [fva9 nfpa9] fna9 r1_and
AQa9 fpa9 d_lata NULL NULL qa9 nqa9 r1_dff
AFPa10 d_oap d_stba10 NULL d_rsta fpa10 nfpa10 r1_dff
AFVa10 d_vdd d_stba10 NULL d_rsta fva10 nfva10 r1_dff
AFNa10 [fva10 nfpa10] fna10 r1_and
AQa10 fpa10 d_lata NULL NULL qa10 nqa10 r1_dff
AFPa11 d_oap d_stba11 NULL d_rsta fpa11 nfpa11 r1_dff
AFVa11 d_vdd d_stba11 NULL d_rsta fva11 nfva11 r1_dff
AFNa11 [fva11 nfpa11] fna11 r1_and
AQa11 fpa11 d_lata NULL NULL qa11 nqa11 r1_dff
AFPa12 d_oap d_stba12 NULL d_rsta fpa12 nfpa12 r1_dff
AFVa12 d_vdd d_stba12 NULL d_rsta fva12 nfva12 r1_dff
AFNa12 [fva12 nfpa12] fna12 r1_and
AQa12 fpa12 d_lata NULL NULL qa12 nqa12 r1_dff
AFPa13 d_oap d_stba13 NULL d_rsta fpa13 nfpa13 r1_dff
AQa13 fpa13 d_lata NULL NULL qa13 nqa13 r1_dff
AFPb0 d_obp d_stbb0 NULL d_rstb fpb0 nfpb0 r1_dff
AFVb0 d_vdd d_stbb0 NULL d_rstb fvb0 nfvb0 r1_dff
AFNb0 [fvb0 nfpb0] fnb0 r1_and
AQb0 fpb0 d_latb NULL NULL qb0 nqb0 r1_dff
AFPb1 d_obp d_stbb1 NULL d_rstb fpb1 nfpb1 r1_dff
AFVb1 d_vdd d_stbb1 NULL d_rstb fvb1 nfvb1 r1_dff
AFNb1 [fvb1 nfpb1] fnb1 r1_and
AQb1 fpb1 d_latb NULL NULL qb1 nqb1 r1_dff
AFPb2 d_obp d_stbb2 NULL d_rstb fpb2 nfpb2 r1_dff
AFVb2 d_vdd d_stbb2 NULL d_rstb fvb2 nfvb2 r1_dff
AFNb2 [fvb2 nfpb2] fnb2 r1_and
AQb2 fpb2 d_latb NULL NULL qb2 nqb2 r1_dff
AFPb3 d_obp d_stbb3 NULL d_rstb fpb3 nfpb3 r1_dff
AFVb3 d_vdd d_stbb3 NULL d_rstb fvb3 nfvb3 r1_dff
AFNb3 [fvb3 nfpb3] fnb3 r1_and
AQb3 fpb3 d_latb NULL NULL qb3 nqb3 r1_dff
AFPb4 d_obp d_stbb4 NULL d_rstb fpb4 nfpb4 r1_dff
AFVb4 d_vdd d_stbb4 NULL d_rstb fvb4 nfvb4 r1_dff
AFNb4 [fvb4 nfpb4] fnb4 r1_and
AQb4 fpb4 d_latb NULL NULL qb4 nqb4 r1_dff
AFPb5 d_obp d_stbb5 NULL d_rstb fpb5 nfpb5 r1_dff
AFVb5 d_vdd d_stbb5 NULL d_rstb fvb5 nfvb5 r1_dff
AFNb5 [fvb5 nfpb5] fnb5 r1_and
AQb5 fpb5 d_latb NULL NULL qb5 nqb5 r1_dff
AFPb6 d_obp d_stbb6 NULL d_rstb fpb6 nfpb6 r1_dff
AFVb6 d_vdd d_stbb6 NULL d_rstb fvb6 nfvb6 r1_dff
AFNb6 [fvb6 nfpb6] fnb6 r1_and
AQb6 fpb6 d_latb NULL NULL qb6 nqb6 r1_dff
AFPb7 d_obp d_stbb7 NULL d_rstb fpb7 nfpb7 r1_dff
AFVb7 d_vdd d_stbb7 NULL d_rstb fvb7 nfvb7 r1_dff
AFNb7 [fvb7 nfpb7] fnb7 r1_and
AQb7 fpb7 d_latb NULL NULL qb7 nqb7 r1_dff
AFPb8 d_obp d_stbb8 NULL d_rstb fpb8 nfpb8 r1_dff
AFVb8 d_vdd d_stbb8 NULL d_rstb fvb8 nfvb8 r1_dff
AFNb8 [fvb8 nfpb8] fnb8 r1_and
AQb8 fpb8 d_latb NULL NULL qb8 nqb8 r1_dff
AFPb9 d_obp d_stbb9 NULL d_rstb fpb9 nfpb9 r1_dff
AFVb9 d_vdd d_stbb9 NULL d_rstb fvb9 nfvb9 r1_dff
AFNb9 [fvb9 nfpb9] fnb9 r1_and
AQb9 fpb9 d_latb NULL NULL qb9 nqb9 r1_dff
AFPb10 d_obp d_stbb10 NULL d_rstb fpb10 nfpb10 r1_dff
AFVb10 d_vdd d_stbb10 NULL d_rstb fvb10 nfvb10 r1_dff
AFNb10 [fvb10 nfpb10] fnb10 r1_and
AQb10 fpb10 d_latb NULL NULL qb10 nqb10 r1_dff
AFPb11 d_obp d_stbb11 NULL d_rstb fpb11 nfpb11 r1_dff
AFVb11 d_vdd d_stbb11 NULL d_rstb fvb11 nfvb11 r1_dff
AFNb11 [fvb11 nfpb11] fnb11 r1_and
AQb11 fpb11 d_latb NULL NULL qb11 nqb11 r1_dff
AFPb12 d_obp d_stbb12 NULL d_rstb fpb12 nfpb12 r1_dff
AFVb12 d_vdd d_stbb12 NULL d_rstb fvb12 nfvb12 r1_dff
AFNb12 [fvb12 nfpb12] fnb12 r1_and
AQb12 fpb12 d_latb NULL NULL qb12 nqb12 r1_dff
AFPb13 d_obp d_stbb13 NULL d_rstb fpb13 nfpb13 r1_dff
AQb13 fpb13 d_latb NULL NULL qb13 nqb13 r1_dff
APREa [d_wina nfva0] prea r1_and
AOPa [fpa0 prea] fpxa0 r1_or
AONa [fna0 prea] fnxa0 r1_or
APREb [d_winb nfvb0] preb r1_and
AOPb [fpb0 preb] fpxb0 r1_or
AONb [fnb0 preb] fnxb0 r1_or
ADB [g_clka g_clkab g_clkb g_clkbb fpxa0 fnxa0 fpa1 fna1 fpa2 fna2 fpa3 fna3 fpa4 fna4 fpa5 fna5 fpa6 fna6 fpa7 fna7 fpa8 fna8 fpa9 fna9 fpa10 fna10 fpa11 fna11 fpa12 fna12 qa0 qa1 qa2 qa3 qa4 qa5 qa6 qa7 qa8 qa9 qa10 qa11 qa12 qa13 fpxb0 fnxb0 fpb1 fnb1 fpb2 fnb2 fpb3 fnb3 fpb4 fnb4 fpb5 fnb5 fpb6 fnb6 fpb7 fnb7 fpb8 fnb8 fpb9 fnb9 fpb10 fnb10 fpb11 fnb11 fpb12 fnb12 qb0 qb1 qb2 qb3 qb4 qb5 qb6 qb7 qb8 qb9 qb10 qb11 qb12 qb13] [clka clkab clkb clkbb cpa12 cna12 cpa11 cna11 cpa10 cna10 cpa9 cna9 cpa8 cna8 cpa7 cna7 cpa6 cna6 cpa5 cna5 cpa4 cna4 cpa3 cna3 cpa2 cna2 cpa1 cna1 cpa0 cna0 ra13 ra12 ra11 ra10 ra9 ra8 ra7 ra6 ra5 ra4 ra3 ra2 ra1 ra0 cpb12 cnb12 cpb11 cnb11 cpb10 cnb10 cpb9 cnb9 cpb8 cnb8 cpb7 cnb7 cpb6 cnb6 cpb5 cnb5 cpb4 cnb4 cpb3 cnb3 cpb2 cnb2 cpb1 cnb1 cpb0 cnb0 rb13 rb12 rb11 rb10 rb9 rb8 rb7 rb6 rb5 rb4 rb3 rb2 rb1 rb0] r1_dacb
Brawa rawa gnd v=(1*v(ra0)+2*v(ra1)+4*v(ra2)+8*v(ra3)+16*v(ra4)+32*v(ra5)+64*v(ra6)+128*v(ra7)+256*v(ra8)+512*v(ra9)+1024*v(ra10)+2048*v(ra11)+4096*v(ra12)+8192*v(ra13))/1.2
Brawb rawb gnd v=(1*v(rb0)+2*v(rb1)+4*v(rb2)+8*v(rb3)+16*v(rb4)+32*v(rb5)+64*v(rb6)+128*v(rb7)+256*v(rb8)+512*v(rb9)+1024*v(rb10)+2048*v(rb11)+4096*v(rb12)+8192*v(rb13))/1.2
.ends r1_sar4p_logic

* ---------------------------------------------------------------------------------------------
* r1_adc4p_core_fast: R1 ADC revision-4 core with the MSB pre-switch (r1_sar4p_logic). Slice A: in0 = SIN, in1 = ISA. Slice B: in0 = COS, in1 = ISB.
* Both slices convert in parallel (D18), one decision per clk30 tick; comparator clock from r1_cmp4_clkgen.
* Comparator bias r1_cmp4_bias shared by both comparators. vrefl: LSB-array reference (tie to vref).
* ---------------------------------------------------------------------------------------------
.subckt r1_adc4p_core_fast sinp sinn cosp cosn isap isan isbp isbn trka0 trka1 trkb0 trkb1 clk30 wina winb lata latb stba0 stba1 stba2 stba3 stba4 stba5 stba6 stba7 stba8 stba9 stba10 stba11 stba12 stba13 stbb0 stbb1 stbb2 stbb3 stbb4 stbb5 stbb6 stbb7 stbb8 stbb9 stbb10 stbb11 stbb12 stbb13 rawa rawb topap topan topbp topbn vdd vref vrefl gnd
XCKG clk30 mclk mclkb vdd gnd r1_cmp4_clkgen
XTHA sinp sinn isap isan trka0 trka1 topap topan cpa12 cpa11 cpa10 cpa9 cpa8 cpa7 cpa6 cpa5 cpa4 cpa3 cpa2 cpa1 cpa0 cna12 cna11 cna10 cna9 cna8 cna7 cna6 cna5 cna4 cna3 cna2 cna1 cna0 vdd vref vrefl gnd r1_th4_fast
XCBIAS vbp vdd gnd r1_cmp4_bias
XCMPA topap topan clka clkab oap oan vbp vdd gnd r1_cmp4
XTHB cosp cosn isbp isbn trkb0 trkb1 topbp topbn cpb12 cpb11 cpb10 cpb9 cpb8 cpb7 cpb6 cpb5 cpb4 cpb3 cpb2 cpb1 cpb0 cnb12 cnb11 cnb10 cnb9 cnb8 cnb7 cnb6 cnb5 cnb4 cnb3 cnb2 cnb1 cnb0 vdd vref vrefl gnd r1_th4_fast
XCMPB topbp topbn clkb clkbb obp obn vbp vdd gnd r1_cmp4
XSAR oap oan obp obn mclk wina winb trka0 trka1 trkb0 trkb1 lata latb stba0 stba1 stba2 stba3 stba4 stba5 stba6 stba7 stba8 stba9 stba10 stba11 stba12 stba13 stbb0 stbb1 stbb2 stbb3 stbb4 stbb5 stbb6 stbb7 stbb8 stbb9 stbb10 stbb11 stbb12 stbb13 clka clkab clkb clkbb cpa12 cpa11 cpa10 cpa9 cpa8 cpa7 cpa6 cpa5 cpa4 cpa3 cpa2 cpa1 cpa0 cna12 cna11 cna10 cna9 cna8 cna7 cna6 cna5 cna4 cna3 cna2 cna1 cna0 cpb12 cpb11 cpb10 cpb9 cpb8 cpb7 cpb6 cpb5 cpb4 cpb3 cpb2 cpb1 cpb0 cnb12 cnb11 cnb10 cnb9 cnb8 cnb7 cnb6 cnb5 cnb4 cnb3 cnb2 cnb1 cnb0 rawa rawb vdd gnd r1_sar4p_logic
.ends r1_adc4p_core_fast

* ---------------------------------------------------------------------------------------------
* r1_adc4p_core: R1 ADC revision-4 core with the MSB pre-switch (r1_sar4p_logic). Slice A: in0 = SIN, in1 = ISA. Slice B: in0 = COS, in1 = ISB.
* Both slices convert in parallel (D18), one decision per clk30 tick; comparator clock from r1_cmp4_clkgen.
* Comparator bias r1_cmp4_bias shared by both comparators. vrefl: LSB-array reference (tie to vref).
* ---------------------------------------------------------------------------------------------
.subckt r1_adc4p_core sinp sinn cosp cosn isap isan isbp isbn trka0 trka1 trkb0 trkb1 clk30 wina winb lata latb stba0 stba1 stba2 stba3 stba4 stba5 stba6 stba7 stba8 stba9 stba10 stba11 stba12 stba13 stbb0 stbb1 stbb2 stbb3 stbb4 stbb5 stbb6 stbb7 stbb8 stbb9 stbb10 stbb11 stbb12 stbb13 rawa rawb topap topan topbp topbn vdd vref vrefl gnd
XCKG clk30 mclk mclkb vdd gnd r1_cmp4_clkgen
XTHA sinp sinn isap isan trka0 trka1 topap topan cpa12 cpa11 cpa10 cpa9 cpa8 cpa7 cpa6 cpa5 cpa4 cpa3 cpa2 cpa1 cpa0 cna12 cna11 cna10 cna9 cna8 cna7 cna6 cna5 cna4 cna3 cna2 cna1 cna0 vdd vref vrefl gnd r1_th4
XCBIAS vbp vdd gnd r1_cmp4_bias
XCMPA topap topan clka clkab oap oan vbp vdd gnd r1_cmp4
XTHB cosp cosn isbp isbn trkb0 trkb1 topbp topbn cpb12 cpb11 cpb10 cpb9 cpb8 cpb7 cpb6 cpb5 cpb4 cpb3 cpb2 cpb1 cpb0 cnb12 cnb11 cnb10 cnb9 cnb8 cnb7 cnb6 cnb5 cnb4 cnb3 cnb2 cnb1 cnb0 vdd vref vrefl gnd r1_th4
XCMPB topbp topbn clkb clkbb obp obn vbp vdd gnd r1_cmp4
XSAR oap oan obp obn mclk wina winb trka0 trka1 trkb0 trkb1 lata latb stba0 stba1 stba2 stba3 stba4 stba5 stba6 stba7 stba8 stba9 stba10 stba11 stba12 stba13 stbb0 stbb1 stbb2 stbb3 stbb4 stbb5 stbb6 stbb7 stbb8 stbb9 stbb10 stbb11 stbb12 stbb13 clka clkab clkb clkbb cpa12 cpa11 cpa10 cpa9 cpa8 cpa7 cpa6 cpa5 cpa4 cpa3 cpa2 cpa1 cpa0 cna12 cna11 cna10 cna9 cna8 cna7 cna6 cna5 cna4 cna3 cna2 cna1 cna0 cpb12 cpb11 cpb10 cpb9 cpb8 cpb7 cpb6 cpb5 cpb4 cpb3 cpb2 cpb1 cpb0 cnb12 cnb11 cnb10 cnb9 cnb8 cnb7 cnb6 cnb5 cnb4 cnb3 cnb2 cnb1 cnb0 rawa rawb vdd gnd r1_sar4p_logic
.ends r1_adc4p_core
