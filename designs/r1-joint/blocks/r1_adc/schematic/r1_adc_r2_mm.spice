* r1_adc_r2_mm.spice -- R1 12-bit SAR ADC revision 2, schematic-level library (generated by gen_r1_adc_r2.py; do not edit)
* Requires: cornerMOSlv.lib, cornerMOShv.lib (r1_refbuf), cornerCAP.lib, cornerRES.lib (r1_refbuf), XSPICE digital code models, PSP/R3 OSDI.
* Mismatch-capable copy: MOS instances carry mm_ok={mmos} (deck sets .param mmos).

* ---------------------------------------------------------------------------------------------
* r1_bootsw: bootstrapped NMOS sampling switch (unchanged from revision 1).
* ---------------------------------------------------------------------------------------------
.subckt r1_bootsw vin out trk trkb vdd gnd wsw=6u cboot=200f
XMS   vin  g    out  gnd  sg13_lv_nmos w={wsw} l=0.13u ng=2 m=1 mm_ok={mmos}
Cboot cbp  cbn  {cboot}
XM1   cbn  trkb gnd  gnd  sg13_lv_nmos w=1u l=0.13u ng=1 m=1 mm_ok={mmos}
XM3   cbp  g    vdd  cbp  sg13_lv_pmos w=1u l=0.13u ng=1 m=1 mm_ok={mmos}
XM8   g    x    cbp  cbp  sg13_lv_pmos w=2u l=0.13u ng=1 m=1 mm_ok={mmos}
XM4   x    trk  vdd  vdd  sg13_lv_pmos w=0.5u l=0.13u ng=1 m=1 mm_ok={mmos}
XM5   x    trk  cbn  gnd  sg13_lv_nmos w=1u l=0.13u ng=1 m=1 mm_ok={mmos}
XM7   x    g    cbn  gnd  sg13_lv_nmos w=0.5u l=0.13u ng=1 m=1 mm_ok={mmos}
XM9   cbn  g    vin  gnd  sg13_lv_nmos w=2u l=0.13u ng=1 m=1 mm_ok={mmos}
XM10  g    vdd  n10  gnd  sg13_lv_nmos w=2u l=0.13u ng=1 m=1 mm_ok={mmos}
XM11  n10  trkb gnd  gnd  sg13_lv_nmos w=2u l=0.13u ng=1 m=1 mm_ok={mmos}
.ends r1_bootsw

.subckt r1_offsw vin out gnd wsw=6u
XMS   vin  gnd  out  gnd  sg13_lv_nmos w={wsw} l=0.13u ng=2 m=1 mm_ok={mmos}
.ends r1_offsw

* bottom-plate drivers (unchanged): in=0 -> out=VREF, in=1 -> out=GND
.subckt r1_drv in out vref gnd wp=1u wn=0.5u
XMP out in vref vref sg13_lv_pmos w={wp} l=0.13u ng=1 m=1 mm_ok={mmos}
XMN out in gnd  gnd  sg13_lv_nmos w={wn} l=0.13u ng=1 m=1 mm_ok={mmos}
.ends r1_drv

.subckt r1_drv_sw in out vref gnd
BU vref out i=(v(vref)-v(out))*(1e-12+2.5e-3*(0.5-0.5*tanh(20*(v(in)-0.6))))
BD out gnd i=(v(out)-v(gnd))*(1e-12+2.5e-3*(0.5+0.5*tanh(20*(v(in)-0.6))))
.ends r1_drv_sw

* ---------------------------------------------------------------------------------------------
* r1_cdac2_side: one side of the revision-2 split array. Unit Cu = cap_cmim 3.78u x 3.78u (22.04 fF).
* top: C11..C7 = 16, 8, 4, 2, 1 Cu; bridge Cb = cap_cmim 4.23u x 4.23u (1.249 Cu) top-lsb;
* lsb: C6..C0 = 64, 32, 16, 8, 4, 2, 1 Cu (sub-binary with the top array). Nominal (m=).
* ---------------------------------------------------------------------------------------------
.subckt r1_cdac2_side top lsb b11 b10 b9 b8 b7 b6 b5 b4 b3 b2 b1 b0
XC11 top b11 cap_cmim w=3.78u l=3.78u m=16
XC10 top b10 cap_cmim w=3.78u l=3.78u m=8
XC9 top b9 cap_cmim w=3.78u l=3.78u m=4
XC8 top b8 cap_cmim w=3.78u l=3.78u m=2
XC7 top b7 cap_cmim w=3.78u l=3.78u m=1
XC6 lsb b6 cap_cmim w=3.78u l=3.78u m=64
XC5 lsb b5 cap_cmim w=3.78u l=3.78u m=32
XC4 lsb b4 cap_cmim w=3.78u l=3.78u m=16
XC3 lsb b3 cap_cmim w=3.78u l=3.78u m=8
XC2 lsb b2 cap_cmim w=3.78u l=3.78u m=4
XC1 lsb b1 cap_cmim w=3.78u l=3.78u m=2
XC0 lsb b0 cap_cmim w=3.78u l=3.78u m=1
XCB top lsb cap_cmim w=4.23u l=4.23u m=1
.ends r1_cdac2_side

* ---------------------------------------------------------------------------------------------
* r1_cdac2_side_mc: one side of the revision-2 split array. Unit Cu = cap_cmim 3.78u x 3.78u (22.04 fF).
* top: C11..C7 = 16, 8, 4, 2, 1 Cu; bridge Cb = cap_cmim 4.23u x 4.23u (1.249 Cu) top-lsb;
* lsb: C6..C0 = 64, 32, 16, 8, 4, 2, 1 Cu (sub-binary with the top array). One instance per unit (mismatch MC, mm_ok={mm}).
* ---------------------------------------------------------------------------------------------
.subckt r1_cdac2_side_mc top lsb b11 b10 b9 b8 b7 b6 b5 b4 b3 b2 b1 b0 mm=1
XC11_0 top b11 cap_cmim w=3.78u l=3.78u mm_ok={mm}
XC11_1 top b11 cap_cmim w=3.78u l=3.78u mm_ok={mm}
XC11_2 top b11 cap_cmim w=3.78u l=3.78u mm_ok={mm}
XC11_3 top b11 cap_cmim w=3.78u l=3.78u mm_ok={mm}
XC11_4 top b11 cap_cmim w=3.78u l=3.78u mm_ok={mm}
XC11_5 top b11 cap_cmim w=3.78u l=3.78u mm_ok={mm}
XC11_6 top b11 cap_cmim w=3.78u l=3.78u mm_ok={mm}
XC11_7 top b11 cap_cmim w=3.78u l=3.78u mm_ok={mm}
XC11_8 top b11 cap_cmim w=3.78u l=3.78u mm_ok={mm}
XC11_9 top b11 cap_cmim w=3.78u l=3.78u mm_ok={mm}
XC11_10 top b11 cap_cmim w=3.78u l=3.78u mm_ok={mm}
XC11_11 top b11 cap_cmim w=3.78u l=3.78u mm_ok={mm}
XC11_12 top b11 cap_cmim w=3.78u l=3.78u mm_ok={mm}
XC11_13 top b11 cap_cmim w=3.78u l=3.78u mm_ok={mm}
XC11_14 top b11 cap_cmim w=3.78u l=3.78u mm_ok={mm}
XC11_15 top b11 cap_cmim w=3.78u l=3.78u mm_ok={mm}
XC10_0 top b10 cap_cmim w=3.78u l=3.78u mm_ok={mm}
XC10_1 top b10 cap_cmim w=3.78u l=3.78u mm_ok={mm}
XC10_2 top b10 cap_cmim w=3.78u l=3.78u mm_ok={mm}
XC10_3 top b10 cap_cmim w=3.78u l=3.78u mm_ok={mm}
XC10_4 top b10 cap_cmim w=3.78u l=3.78u mm_ok={mm}
XC10_5 top b10 cap_cmim w=3.78u l=3.78u mm_ok={mm}
XC10_6 top b10 cap_cmim w=3.78u l=3.78u mm_ok={mm}
XC10_7 top b10 cap_cmim w=3.78u l=3.78u mm_ok={mm}
XC9_0 top b9 cap_cmim w=3.78u l=3.78u mm_ok={mm}
XC9_1 top b9 cap_cmim w=3.78u l=3.78u mm_ok={mm}
XC9_2 top b9 cap_cmim w=3.78u l=3.78u mm_ok={mm}
XC9_3 top b9 cap_cmim w=3.78u l=3.78u mm_ok={mm}
XC8_0 top b8 cap_cmim w=3.78u l=3.78u mm_ok={mm}
XC8_1 top b8 cap_cmim w=3.78u l=3.78u mm_ok={mm}
XC7_0 top b7 cap_cmim w=3.78u l=3.78u mm_ok={mm}
XC6_0 lsb b6 cap_cmim w=3.78u l=3.78u mm_ok={mm}
XC6_1 lsb b6 cap_cmim w=3.78u l=3.78u mm_ok={mm}
XC6_2 lsb b6 cap_cmim w=3.78u l=3.78u mm_ok={mm}
XC6_3 lsb b6 cap_cmim w=3.78u l=3.78u mm_ok={mm}
XC6_4 lsb b6 cap_cmim w=3.78u l=3.78u mm_ok={mm}
XC6_5 lsb b6 cap_cmim w=3.78u l=3.78u mm_ok={mm}
XC6_6 lsb b6 cap_cmim w=3.78u l=3.78u mm_ok={mm}
XC6_7 lsb b6 cap_cmim w=3.78u l=3.78u mm_ok={mm}
XC6_8 lsb b6 cap_cmim w=3.78u l=3.78u mm_ok={mm}
XC6_9 lsb b6 cap_cmim w=3.78u l=3.78u mm_ok={mm}
XC6_10 lsb b6 cap_cmim w=3.78u l=3.78u mm_ok={mm}
XC6_11 lsb b6 cap_cmim w=3.78u l=3.78u mm_ok={mm}
XC6_12 lsb b6 cap_cmim w=3.78u l=3.78u mm_ok={mm}
XC6_13 lsb b6 cap_cmim w=3.78u l=3.78u mm_ok={mm}
XC6_14 lsb b6 cap_cmim w=3.78u l=3.78u mm_ok={mm}
XC6_15 lsb b6 cap_cmim w=3.78u l=3.78u mm_ok={mm}
XC6_16 lsb b6 cap_cmim w=3.78u l=3.78u mm_ok={mm}
XC6_17 lsb b6 cap_cmim w=3.78u l=3.78u mm_ok={mm}
XC6_18 lsb b6 cap_cmim w=3.78u l=3.78u mm_ok={mm}
XC6_19 lsb b6 cap_cmim w=3.78u l=3.78u mm_ok={mm}
XC6_20 lsb b6 cap_cmim w=3.78u l=3.78u mm_ok={mm}
XC6_21 lsb b6 cap_cmim w=3.78u l=3.78u mm_ok={mm}
XC6_22 lsb b6 cap_cmim w=3.78u l=3.78u mm_ok={mm}
XC6_23 lsb b6 cap_cmim w=3.78u l=3.78u mm_ok={mm}
XC6_24 lsb b6 cap_cmim w=3.78u l=3.78u mm_ok={mm}
XC6_25 lsb b6 cap_cmim w=3.78u l=3.78u mm_ok={mm}
XC6_26 lsb b6 cap_cmim w=3.78u l=3.78u mm_ok={mm}
XC6_27 lsb b6 cap_cmim w=3.78u l=3.78u mm_ok={mm}
XC6_28 lsb b6 cap_cmim w=3.78u l=3.78u mm_ok={mm}
XC6_29 lsb b6 cap_cmim w=3.78u l=3.78u mm_ok={mm}
XC6_30 lsb b6 cap_cmim w=3.78u l=3.78u mm_ok={mm}
XC6_31 lsb b6 cap_cmim w=3.78u l=3.78u mm_ok={mm}
XC6_32 lsb b6 cap_cmim w=3.78u l=3.78u mm_ok={mm}
XC6_33 lsb b6 cap_cmim w=3.78u l=3.78u mm_ok={mm}
XC6_34 lsb b6 cap_cmim w=3.78u l=3.78u mm_ok={mm}
XC6_35 lsb b6 cap_cmim w=3.78u l=3.78u mm_ok={mm}
XC6_36 lsb b6 cap_cmim w=3.78u l=3.78u mm_ok={mm}
XC6_37 lsb b6 cap_cmim w=3.78u l=3.78u mm_ok={mm}
XC6_38 lsb b6 cap_cmim w=3.78u l=3.78u mm_ok={mm}
XC6_39 lsb b6 cap_cmim w=3.78u l=3.78u mm_ok={mm}
XC6_40 lsb b6 cap_cmim w=3.78u l=3.78u mm_ok={mm}
XC6_41 lsb b6 cap_cmim w=3.78u l=3.78u mm_ok={mm}
XC6_42 lsb b6 cap_cmim w=3.78u l=3.78u mm_ok={mm}
XC6_43 lsb b6 cap_cmim w=3.78u l=3.78u mm_ok={mm}
XC6_44 lsb b6 cap_cmim w=3.78u l=3.78u mm_ok={mm}
XC6_45 lsb b6 cap_cmim w=3.78u l=3.78u mm_ok={mm}
XC6_46 lsb b6 cap_cmim w=3.78u l=3.78u mm_ok={mm}
XC6_47 lsb b6 cap_cmim w=3.78u l=3.78u mm_ok={mm}
XC6_48 lsb b6 cap_cmim w=3.78u l=3.78u mm_ok={mm}
XC6_49 lsb b6 cap_cmim w=3.78u l=3.78u mm_ok={mm}
XC6_50 lsb b6 cap_cmim w=3.78u l=3.78u mm_ok={mm}
XC6_51 lsb b6 cap_cmim w=3.78u l=3.78u mm_ok={mm}
XC6_52 lsb b6 cap_cmim w=3.78u l=3.78u mm_ok={mm}
XC6_53 lsb b6 cap_cmim w=3.78u l=3.78u mm_ok={mm}
XC6_54 lsb b6 cap_cmim w=3.78u l=3.78u mm_ok={mm}
XC6_55 lsb b6 cap_cmim w=3.78u l=3.78u mm_ok={mm}
XC6_56 lsb b6 cap_cmim w=3.78u l=3.78u mm_ok={mm}
XC6_57 lsb b6 cap_cmim w=3.78u l=3.78u mm_ok={mm}
XC6_58 lsb b6 cap_cmim w=3.78u l=3.78u mm_ok={mm}
XC6_59 lsb b6 cap_cmim w=3.78u l=3.78u mm_ok={mm}
XC6_60 lsb b6 cap_cmim w=3.78u l=3.78u mm_ok={mm}
XC6_61 lsb b6 cap_cmim w=3.78u l=3.78u mm_ok={mm}
XC6_62 lsb b6 cap_cmim w=3.78u l=3.78u mm_ok={mm}
XC6_63 lsb b6 cap_cmim w=3.78u l=3.78u mm_ok={mm}
XC5_0 lsb b5 cap_cmim w=3.78u l=3.78u mm_ok={mm}
XC5_1 lsb b5 cap_cmim w=3.78u l=3.78u mm_ok={mm}
XC5_2 lsb b5 cap_cmim w=3.78u l=3.78u mm_ok={mm}
XC5_3 lsb b5 cap_cmim w=3.78u l=3.78u mm_ok={mm}
XC5_4 lsb b5 cap_cmim w=3.78u l=3.78u mm_ok={mm}
XC5_5 lsb b5 cap_cmim w=3.78u l=3.78u mm_ok={mm}
XC5_6 lsb b5 cap_cmim w=3.78u l=3.78u mm_ok={mm}
XC5_7 lsb b5 cap_cmim w=3.78u l=3.78u mm_ok={mm}
XC5_8 lsb b5 cap_cmim w=3.78u l=3.78u mm_ok={mm}
XC5_9 lsb b5 cap_cmim w=3.78u l=3.78u mm_ok={mm}
XC5_10 lsb b5 cap_cmim w=3.78u l=3.78u mm_ok={mm}
XC5_11 lsb b5 cap_cmim w=3.78u l=3.78u mm_ok={mm}
XC5_12 lsb b5 cap_cmim w=3.78u l=3.78u mm_ok={mm}
XC5_13 lsb b5 cap_cmim w=3.78u l=3.78u mm_ok={mm}
XC5_14 lsb b5 cap_cmim w=3.78u l=3.78u mm_ok={mm}
XC5_15 lsb b5 cap_cmim w=3.78u l=3.78u mm_ok={mm}
XC5_16 lsb b5 cap_cmim w=3.78u l=3.78u mm_ok={mm}
XC5_17 lsb b5 cap_cmim w=3.78u l=3.78u mm_ok={mm}
XC5_18 lsb b5 cap_cmim w=3.78u l=3.78u mm_ok={mm}
XC5_19 lsb b5 cap_cmim w=3.78u l=3.78u mm_ok={mm}
XC5_20 lsb b5 cap_cmim w=3.78u l=3.78u mm_ok={mm}
XC5_21 lsb b5 cap_cmim w=3.78u l=3.78u mm_ok={mm}
XC5_22 lsb b5 cap_cmim w=3.78u l=3.78u mm_ok={mm}
XC5_23 lsb b5 cap_cmim w=3.78u l=3.78u mm_ok={mm}
XC5_24 lsb b5 cap_cmim w=3.78u l=3.78u mm_ok={mm}
XC5_25 lsb b5 cap_cmim w=3.78u l=3.78u mm_ok={mm}
XC5_26 lsb b5 cap_cmim w=3.78u l=3.78u mm_ok={mm}
XC5_27 lsb b5 cap_cmim w=3.78u l=3.78u mm_ok={mm}
XC5_28 lsb b5 cap_cmim w=3.78u l=3.78u mm_ok={mm}
XC5_29 lsb b5 cap_cmim w=3.78u l=3.78u mm_ok={mm}
XC5_30 lsb b5 cap_cmim w=3.78u l=3.78u mm_ok={mm}
XC5_31 lsb b5 cap_cmim w=3.78u l=3.78u mm_ok={mm}
XC4_0 lsb b4 cap_cmim w=3.78u l=3.78u mm_ok={mm}
XC4_1 lsb b4 cap_cmim w=3.78u l=3.78u mm_ok={mm}
XC4_2 lsb b4 cap_cmim w=3.78u l=3.78u mm_ok={mm}
XC4_3 lsb b4 cap_cmim w=3.78u l=3.78u mm_ok={mm}
XC4_4 lsb b4 cap_cmim w=3.78u l=3.78u mm_ok={mm}
XC4_5 lsb b4 cap_cmim w=3.78u l=3.78u mm_ok={mm}
XC4_6 lsb b4 cap_cmim w=3.78u l=3.78u mm_ok={mm}
XC4_7 lsb b4 cap_cmim w=3.78u l=3.78u mm_ok={mm}
XC4_8 lsb b4 cap_cmim w=3.78u l=3.78u mm_ok={mm}
XC4_9 lsb b4 cap_cmim w=3.78u l=3.78u mm_ok={mm}
XC4_10 lsb b4 cap_cmim w=3.78u l=3.78u mm_ok={mm}
XC4_11 lsb b4 cap_cmim w=3.78u l=3.78u mm_ok={mm}
XC4_12 lsb b4 cap_cmim w=3.78u l=3.78u mm_ok={mm}
XC4_13 lsb b4 cap_cmim w=3.78u l=3.78u mm_ok={mm}
XC4_14 lsb b4 cap_cmim w=3.78u l=3.78u mm_ok={mm}
XC4_15 lsb b4 cap_cmim w=3.78u l=3.78u mm_ok={mm}
XC3_0 lsb b3 cap_cmim w=3.78u l=3.78u mm_ok={mm}
XC3_1 lsb b3 cap_cmim w=3.78u l=3.78u mm_ok={mm}
XC3_2 lsb b3 cap_cmim w=3.78u l=3.78u mm_ok={mm}
XC3_3 lsb b3 cap_cmim w=3.78u l=3.78u mm_ok={mm}
XC3_4 lsb b3 cap_cmim w=3.78u l=3.78u mm_ok={mm}
XC3_5 lsb b3 cap_cmim w=3.78u l=3.78u mm_ok={mm}
XC3_6 lsb b3 cap_cmim w=3.78u l=3.78u mm_ok={mm}
XC3_7 lsb b3 cap_cmim w=3.78u l=3.78u mm_ok={mm}
XC2_0 lsb b2 cap_cmim w=3.78u l=3.78u mm_ok={mm}
XC2_1 lsb b2 cap_cmim w=3.78u l=3.78u mm_ok={mm}
XC2_2 lsb b2 cap_cmim w=3.78u l=3.78u mm_ok={mm}
XC2_3 lsb b2 cap_cmim w=3.78u l=3.78u mm_ok={mm}
XC1_0 lsb b1 cap_cmim w=3.78u l=3.78u mm_ok={mm}
XC1_1 lsb b1 cap_cmim w=3.78u l=3.78u mm_ok={mm}
XC0_0 lsb b0 cap_cmim w=3.78u l=3.78u mm_ok={mm}
XCB top lsb cap_cmim w=4.23u l=4.23u mm_ok={mm}
.ends r1_cdac2_side_mc

* ---------------------------------------------------------------------------------------------
* r1_cmp2: double-tail dynamic comparator, revision 2 (low noise). Same topology as r1_cmp.
* PMOS input pair 48u/0.3u ng=12; integration nodes dip/din loaded by PMOS gate capacitors 16u/4u
* (gate on the node, source/drain/bulk at VDD: inverted channel while the node is below VDD-|VT|), which sets
* the integration time and therefore the noise bandwidth. Reset devices 2u.
* clk=1, clkb=0: evaluate. clk=0: reset, outp = outn = VDD. inp > inn -> outp stays high.
* ---------------------------------------------------------------------------------------------
.subckt r1_cmp2_s1 inp inn dip din clkb vbp vdd gnd wi=48u li=0.3u ngi=12 wt=16u wtc=16u ltc=0.5u
* first (integrating) stage of r1_cmp2; separate so that the noise deck can bias dip/din externally.
* Tail = switch XMT1 (clkb) in series with current source XMTC (gate vbp from r1_cmp2_bias): the integration
* current, and therefore the integration time and noise, stays nearly constant while the input common mode
* falls from 0.6 V to 0.1 V during monotonic switching.
XMT1 tail0 clkb vdd  vdd sg13_lv_pmos w={wt} l=0.13u ng=4 m=1 mm_ok={mmos}
XMTC tail  vbp  tail0 vdd sg13_lv_pmos w={wtc} l={ltc} ng=2 m=1 mm_ok={mmos}
XM1  dip  inp  tail vdd sg13_lv_pmos w={wi} l={li} ng={ngi} m=1 mm_ok={mmos}
XM2  din  inn  tail vdd sg13_lv_pmos w={wi} l={li} ng={ngi} m=1 mm_ok={mmos}
.ends r1_cmp2_s1

.subckt r1_cmp2 inp inn clk clkb outp outn vbp vdd gnd wi=48u li=0.3u ngi=12 wt=16u wtc=16u ltc=0.5u wcap=16u lcap=4u wr=2u wh=8u
XS1  inp inn dip din clkb vbp vdd gnd r1_cmp2_s1 wi={wi} li={li} ngi={ngi} wt={wt} wtc={wtc} ltc={ltc}
XCI1 vdd  dip  vdd  vdd sg13_lv_pmos w={wcap} l={lcap} ng=2 m=1 mm_ok={mmos}
XCI2 vdd  din  vdd  vdd sg13_lv_pmos w={wcap} l={lcap} ng=2 m=1 mm_ok={mmos}
XMR1 dip  clkb gnd  gnd sg13_lv_nmos w={wr} l=0.13u ng=1 m=1 mm_ok={mmos}
XMR2 din  clkb gnd  gnd sg13_lv_nmos w={wr} l=0.13u ng=1 m=1 mm_ok={mmos}
XMT2 lt   clk  gnd  gnd sg13_lv_nmos w=4u l=0.13u ng=1 m=1 mm_ok={mmos}
XMN1 outp outn lt   gnd sg13_lv_nmos w=2u l=0.13u ng=1 m=1 mm_ok={mmos}
XMN2 outn outp lt   gnd sg13_lv_nmos w=2u l=0.13u ng=1 m=1 mm_ok={mmos}
XMP1 outp outn vdd  vdd sg13_lv_pmos w=2u l=0.13u ng=1 m=1 mm_ok={mmos}
XMP2 outn outp vdd  vdd sg13_lv_pmos w=2u l=0.13u ng=1 m=1 mm_ok={mmos}
XMH1 outp dip  vdd  vdd sg13_lv_pmos w={wh} l=0.13u ng=2 m=1 mm_ok={mmos}
XMH2 outn din  vdd  vdd sg13_lv_pmos w={wh} l=0.13u ng=2 m=1 mm_ok={mmos}
XBP1 outpb outp vdd vdd sg13_lv_pmos w=1u l=0.13u ng=1 m=1 mm_ok={mmos}
XBN1 outpb outp gnd gnd sg13_lv_nmos w=0.5u l=0.13u ng=1 m=1 mm_ok={mmos}
XBP2 outnb outn vdd vdd sg13_lv_pmos w=1u l=0.13u ng=1 m=1 mm_ok={mmos}
XBN2 outnb outn gnd gnd sg13_lv_nmos w=0.5u l=0.13u ng=1 m=1 mm_ok={mmos}
Cbp outpb gnd 3f
Cbn outnb gnd 3f
.ends r1_cmp2

* r1_cmp2_bias: bias of the comparator tail current sources. ib = ideal reference current (stands in for the
* bandgap-derived bias current; labelled ideal in the run records). Diode XMBD with w = wtc / 20.
.subckt r1_cmp2_bias vbp vdd gnd ib=14u
Ibc vbp gnd {ib}
XMBD vbp vbp vdd vdd sg13_lv_pmos w=0.8u l=0.5u ng=1 m=1 mm_ok={mmos}
.ends r1_cmp2_bias

* ---------------------------------------------------------------------------------------------
* r1_th2: one revision-2 track-and-hold slice (CDAC P and N, top-plate sampling).
* in0 sampled while trk0=1, in1 while trk1=1 (never both); sample on the falling edge. lsb nodes reset
* to VREF while either path tracks. cpK/cnK = 1: bottom plate K of side P/N goes VREF -> GND.
* Full variant: both input pairs with complete bootstrapped switches; transistor drivers r1_drv.
* ---------------------------------------------------------------------------------------------
.subckt r1_th2 in0p in0n in1p in1n trk0 trk1 top_p top_n cp11 cp10 cp9 cp8 cp7 cp6 cp5 cp4 cp3 cp2 cp1 cp0 cn11 cn10 cn9 cn8 cn7 cn6 cn5 cn4 cn3 cn2 cn1 cn0 vdd vref gnd
XPT0a t0b trk0 vdd vdd sg13_lv_pmos w=2u l=0.13u ng=1 m=1 mm_ok={mmos}
XNT0a t0b trk0 gnd gnd sg13_lv_nmos w=1u l=0.13u ng=1 m=1 mm_ok={mmos}
XPT0b t0 t0b vdd vdd sg13_lv_pmos w=4u l=0.13u ng=1 m=1 mm_ok={mmos}
XNT0b t0 t0b gnd gnd sg13_lv_nmos w=2u l=0.13u ng=1 m=1 mm_ok={mmos}
XPT1a t1b trk1 vdd vdd sg13_lv_pmos w=2u l=0.13u ng=1 m=1 mm_ok={mmos}
XNT1a t1b trk1 gnd gnd sg13_lv_nmos w=1u l=0.13u ng=1 m=1 mm_ok={mmos}
XPT1b t1 t1b vdd vdd sg13_lv_pmos w=4u l=0.13u ng=1 m=1 mm_ok={mmos}
XNT1b t1 t1b gnd gnd sg13_lv_nmos w=2u l=0.13u ng=1 m=1 mm_ok={mmos}
XS0P in0p top_p t0 t0b vdd gnd r1_bootsw
XS0N in0n top_n t0 t0b vdd gnd r1_bootsw
XS1P in1p top_p t1 t1b vdd gnd r1_bootsw
XS1N in1n top_n t1 t1b vdd gnd r1_bootsw
XPR1 rstb_n t0b vdd vdd sg13_lv_pmos w=1u l=0.13u ng=1 m=1 mm_ok={mmos}
XPR2 rstb_n t1b vdd vdd sg13_lv_pmos w=1u l=0.13u ng=1 m=1 mm_ok={mmos}
XNR1 rstb_n t0b nr gnd sg13_lv_nmos w=1u l=0.13u ng=1 m=1 mm_ok={mmos}
XNR2 nr t1b gnd gnd sg13_lv_nmos w=1u l=0.13u ng=1 m=1 mm_ok={mmos}
XPR3 rstb rstb_n vdd vdd sg13_lv_pmos w=1u l=0.13u ng=1 m=1 mm_ok={mmos}
XNR3 rstb rstb_n gnd gnd sg13_lv_nmos w=0.5u l=0.13u ng=1 m=1 mm_ok={mmos}
XLRP lsb_p rstb vref vref sg13_lv_pmos w=1u l=0.13u ng=1 m=1 mm_ok={mmos}
XLRN lsb_n rstb vref vref sg13_lv_pmos w=1u l=0.13u ng=1 m=1 mm_ok={mmos}
XDACP top_p lsb_p bp11 bp10 bp9 bp8 bp7 bp6 bp5 bp4 bp3 bp2 bp1 bp0 r1_cdac2_side
XDACN top_n lsb_n bn11 bn10 bn9 bn8 bn7 bn6 bn5 bn4 bn3 bn2 bn1 bn0 r1_cdac2_side
XDp11 cp11 bp11 vref gnd r1_drv wp=2u wn=1u
XDp10 cp10 bp10 vref gnd r1_drv wp=2u wn=1u
XDp9 cp9 bp9 vref gnd r1_drv wp=2u wn=1u
XDp8 cp8 bp8 vref gnd r1_drv wp=1u wn=0.5u
XDp7 cp7 bp7 vref gnd r1_drv wp=1u wn=0.5u
XDp6 cp6 bp6 vref gnd r1_drv wp=1u wn=0.5u
XDp5 cp5 bp5 vref gnd r1_drv wp=1u wn=0.5u
XDp4 cp4 bp4 vref gnd r1_drv wp=1u wn=0.5u
XDp3 cp3 bp3 vref gnd r1_drv wp=1u wn=0.5u
XDp2 cp2 bp2 vref gnd r1_drv wp=1u wn=0.5u
XDp1 cp1 bp1 vref gnd r1_drv wp=1u wn=0.5u
XDp0 cp0 bp0 vref gnd r1_drv wp=1u wn=0.5u
XDn11 cn11 bn11 vref gnd r1_drv wp=2u wn=1u
XDn10 cn10 bn10 vref gnd r1_drv wp=2u wn=1u
XDn9 cn9 bn9 vref gnd r1_drv wp=2u wn=1u
XDn8 cn8 bn8 vref gnd r1_drv wp=1u wn=0.5u
XDn7 cn7 bn7 vref gnd r1_drv wp=1u wn=0.5u
XDn6 cn6 bn6 vref gnd r1_drv wp=1u wn=0.5u
XDn5 cn5 bn5 vref gnd r1_drv wp=1u wn=0.5u
XDn4 cn4 bn4 vref gnd r1_drv wp=1u wn=0.5u
XDn3 cn3 bn3 vref gnd r1_drv wp=1u wn=0.5u
XDn2 cn2 bn2 vref gnd r1_drv wp=1u wn=0.5u
XDn1 cn1 bn1 vref gnd r1_drv wp=1u wn=0.5u
XDn0 cn0 bn0 vref gnd r1_drv wp=1u wn=0.5u
.ends r1_th2

* ---------------------------------------------------------------------------------------------
* r1_th2_fast: one revision-2 track-and-hold slice (CDAC P and N, top-plate sampling).
* in0 sampled while trk0=1, in1 while trk1=1 (never both); sample on the falling edge. lsb nodes reset
* to VREF while either path tracks. cpK/cnK = 1: bottom plate K of side P/N goes VREF -> GND.
* Fast variant: in1 pair reduced to r1_offsw (gate low), trk1 unused; drivers r1_drv_sw (ideal 400 ohm).
* ---------------------------------------------------------------------------------------------
.subckt r1_th2_fast in0p in0n in1p in1n trk0 trk1 top_p top_n cp11 cp10 cp9 cp8 cp7 cp6 cp5 cp4 cp3 cp2 cp1 cp0 cn11 cn10 cn9 cn8 cn7 cn6 cn5 cn4 cn3 cn2 cn1 cn0 vdd vref gnd
XPT0a t0b trk0 vdd vdd sg13_lv_pmos w=2u l=0.13u ng=1 m=1 mm_ok={mmos}
XNT0a t0b trk0 gnd gnd sg13_lv_nmos w=1u l=0.13u ng=1 m=1 mm_ok={mmos}
XPT0b t0 t0b vdd vdd sg13_lv_pmos w=4u l=0.13u ng=1 m=1 mm_ok={mmos}
XNT0b t0 t0b gnd gnd sg13_lv_nmos w=2u l=0.13u ng=1 m=1 mm_ok={mmos}
XS0P in0p top_p t0 t0b vdd gnd r1_bootsw
XS0N in0n top_n t0 t0b vdd gnd r1_bootsw
XS1P in1p top_p gnd r1_offsw
XS1N in1n top_n gnd r1_offsw
Rtrk1 trk1 gnd 1e9
XLRP lsb_p t0b vref vref sg13_lv_pmos w=1u l=0.13u ng=1 m=1 mm_ok={mmos}
XLRN lsb_n t0b vref vref sg13_lv_pmos w=1u l=0.13u ng=1 m=1 mm_ok={mmos}
XDACP top_p lsb_p bp11 bp10 bp9 bp8 bp7 bp6 bp5 bp4 bp3 bp2 bp1 bp0 r1_cdac2_side
XDACN top_n lsb_n bn11 bn10 bn9 bn8 bn7 bn6 bn5 bn4 bn3 bn2 bn1 bn0 r1_cdac2_side
XDp11 cp11 bp11 vref gnd r1_drv_sw
XDp10 cp10 bp10 vref gnd r1_drv_sw
XDp9 cp9 bp9 vref gnd r1_drv_sw
XDp8 cp8 bp8 vref gnd r1_drv_sw
XDp7 cp7 bp7 vref gnd r1_drv_sw
XDp6 cp6 bp6 vref gnd r1_drv_sw
XDp5 cp5 bp5 vref gnd r1_drv_sw
XDp4 cp4 bp4 vref gnd r1_drv_sw
XDp3 cp3 bp3 vref gnd r1_drv_sw
XDp2 cp2 bp2 vref gnd r1_drv_sw
XDp1 cp1 bp1 vref gnd r1_drv_sw
XDp0 cp0 bp0 vref gnd r1_drv_sw
XDn11 cn11 bn11 vref gnd r1_drv_sw
XDn10 cn10 bn10 vref gnd r1_drv_sw
XDn9 cn9 bn9 vref gnd r1_drv_sw
XDn8 cn8 bn8 vref gnd r1_drv_sw
XDn7 cn7 bn7 vref gnd r1_drv_sw
XDn6 cn6 bn6 vref gnd r1_drv_sw
XDn5 cn5 bn5 vref gnd r1_drv_sw
XDn4 cn4 bn4 vref gnd r1_drv_sw
XDn3 cn3 bn3 vref gnd r1_drv_sw
XDn2 cn2 bn2 vref gnd r1_drv_sw
XDn1 cn1 bn1 vref gnd r1_drv_sw
XDn0 cn0 bn0 vref gnd r1_drv_sw
.ends r1_th2_fast

* ---------------------------------------------------------------------------------------------
* r1_sar2_logic: XSPICE SAR register, 13 decisions per slice, raw-bit output (D12).
* Timing inputs from r1_ctrl (ideal sources in the decks): mclk, wina, winb, lata, latb, stb0..stb25,
* track signals trka0 trka1 trkb0 trkb1 (flag reset of slice X while either of its paths tracks).
* Comparator clocks: clkX = mclk AND winX. Raw bits: ra12..ra0 / rb12..rb0 (ra12 = first decision).
* Per decision: P <= outp at stb, V <= 1 at stb, N = V AND NOT P (one side switches per decision).
* ---------------------------------------------------------------------------------------------
.subckt r1_sar2_logic oap oan obp obn mclk wina winb trka0 trka1 trkb0 trkb1 lata latb stb0 stb1 stb2 stb3 stb4 stb5 stb6 stb7 stb8 stb9 stb10 stb11 stb12 stb13 stb14 stb15 stb16 stb17 stb18 stb19 stb20 stb21 stb22 stb23 stb24 stb25 clka clkab clkb clkbb cpa11 cpa10 cpa9 cpa8 cpa7 cpa6 cpa5 cpa4 cpa3 cpa2 cpa1 cpa0 cna11 cna10 cna9 cna8 cna7 cna6 cna5 cna4 cna3 cna2 cna1 cna0 cpb11 cpb10 cpb9 cpb8 cpb7 cpb6 cpb5 cpb4 cpb3 cpb2 cpb1 cpb0 cnb11 cnb10 cnb9 cnb8 cnb7 cnb6 cnb5 cnb4 cnb3 cnb2 cnb1 cnb0 rawa rawb vdd gnd
.model r1_adcb adc_bridge(in_low=0.6 in_high=0.6 rise_delay=20p fall_delay=20p)
.model r1_dacb dac_bridge(out_low=0 out_high=1.2 out_undef=0.6 input_load=1e-15 t_rise=80p t_fall=80p)
.model r1_dff d_dff(clk_delay=80p set_delay=80p reset_delay=80p ic=0 rise_delay=20p fall_delay=20p)
.model r1_and d_and(rise_delay=30p fall_delay=30p)
.model r1_nand d_nand(rise_delay=30p fall_delay=30p)
.model r1_or d_or(rise_delay=30p fall_delay=30p)
ABR [vdd oap oan obp obn mclk wina winb trka0 trka1 trkb0 trkb1 lata latb stb0 stb1 stb2 stb3 stb4 stb5 stb6 stb7 stb8 stb9 stb10 stb11 stb12 stb13 stb14 stb15 stb16 stb17 stb18 stb19 stb20 stb21 stb22 stb23 stb24 stb25] [d_vdd d_oap d_oan d_obp d_obn d_mclk d_wina d_winb d_trka0 d_trka1 d_trkb0 d_trkb1 d_lata d_latb d_stb0 d_stb1 d_stb2 d_stb3 d_stb4 d_stb5 d_stb6 d_stb7 d_stb8 d_stb9 d_stb10 d_stb11 d_stb12 d_stb13 d_stb14 d_stb15 d_stb16 d_stb17 d_stb18 d_stb19 d_stb20 d_stb21 d_stb22 d_stb23 d_stb24 d_stb25] r1_adcb
AGA1 [d_mclk d_wina] g_clka r1_and
AGA2 [d_mclk d_wina] g_clkab r1_nand
AGB1 [d_mclk d_winb] g_clkb r1_and
AGB2 [d_mclk d_winb] g_clkbb r1_nand
AORA [d_trka0 d_trka1] d_rsta r1_or
AORB [d_trkb0 d_trkb1] d_rstb r1_or
AFPa0 d_oap d_stb0 NULL d_rsta fpa0 nfpa0 r1_dff
AFVa0 d_vdd d_stb0 NULL d_rsta fva0 nfva0 r1_dff
AFNa0 [fva0 nfpa0] fna0 r1_and
AQa0 fpa0 d_lata NULL NULL qa0 nqa0 r1_dff
AFPa1 d_oap d_stb1 NULL d_rsta fpa1 nfpa1 r1_dff
AFVa1 d_vdd d_stb1 NULL d_rsta fva1 nfva1 r1_dff
AFNa1 [fva1 nfpa1] fna1 r1_and
AQa1 fpa1 d_lata NULL NULL qa1 nqa1 r1_dff
AFPa2 d_oap d_stb2 NULL d_rsta fpa2 nfpa2 r1_dff
AFVa2 d_vdd d_stb2 NULL d_rsta fva2 nfva2 r1_dff
AFNa2 [fva2 nfpa2] fna2 r1_and
AQa2 fpa2 d_lata NULL NULL qa2 nqa2 r1_dff
AFPa3 d_oap d_stb3 NULL d_rsta fpa3 nfpa3 r1_dff
AFVa3 d_vdd d_stb3 NULL d_rsta fva3 nfva3 r1_dff
AFNa3 [fva3 nfpa3] fna3 r1_and
AQa3 fpa3 d_lata NULL NULL qa3 nqa3 r1_dff
AFPa4 d_oap d_stb4 NULL d_rsta fpa4 nfpa4 r1_dff
AFVa4 d_vdd d_stb4 NULL d_rsta fva4 nfva4 r1_dff
AFNa4 [fva4 nfpa4] fna4 r1_and
AQa4 fpa4 d_lata NULL NULL qa4 nqa4 r1_dff
AFPa5 d_oap d_stb5 NULL d_rsta fpa5 nfpa5 r1_dff
AFVa5 d_vdd d_stb5 NULL d_rsta fva5 nfva5 r1_dff
AFNa5 [fva5 nfpa5] fna5 r1_and
AQa5 fpa5 d_lata NULL NULL qa5 nqa5 r1_dff
AFPa6 d_oap d_stb6 NULL d_rsta fpa6 nfpa6 r1_dff
AFVa6 d_vdd d_stb6 NULL d_rsta fva6 nfva6 r1_dff
AFNa6 [fva6 nfpa6] fna6 r1_and
AQa6 fpa6 d_lata NULL NULL qa6 nqa6 r1_dff
AFPa7 d_oap d_stb7 NULL d_rsta fpa7 nfpa7 r1_dff
AFVa7 d_vdd d_stb7 NULL d_rsta fva7 nfva7 r1_dff
AFNa7 [fva7 nfpa7] fna7 r1_and
AQa7 fpa7 d_lata NULL NULL qa7 nqa7 r1_dff
AFPa8 d_oap d_stb8 NULL d_rsta fpa8 nfpa8 r1_dff
AFVa8 d_vdd d_stb8 NULL d_rsta fva8 nfva8 r1_dff
AFNa8 [fva8 nfpa8] fna8 r1_and
AQa8 fpa8 d_lata NULL NULL qa8 nqa8 r1_dff
AFPa9 d_oap d_stb9 NULL d_rsta fpa9 nfpa9 r1_dff
AFVa9 d_vdd d_stb9 NULL d_rsta fva9 nfva9 r1_dff
AFNa9 [fva9 nfpa9] fna9 r1_and
AQa9 fpa9 d_lata NULL NULL qa9 nqa9 r1_dff
AFPa10 d_oap d_stb10 NULL d_rsta fpa10 nfpa10 r1_dff
AFVa10 d_vdd d_stb10 NULL d_rsta fva10 nfva10 r1_dff
AFNa10 [fva10 nfpa10] fna10 r1_and
AQa10 fpa10 d_lata NULL NULL qa10 nqa10 r1_dff
AFPa11 d_oap d_stb11 NULL d_rsta fpa11 nfpa11 r1_dff
AFVa11 d_vdd d_stb11 NULL d_rsta fva11 nfva11 r1_dff
AFNa11 [fva11 nfpa11] fna11 r1_and
AQa11 fpa11 d_lata NULL NULL qa11 nqa11 r1_dff
AFPa12 d_oap d_stb12 NULL d_rsta fpa12 nfpa12 r1_dff
AQa12 fpa12 d_lata NULL NULL qa12 nqa12 r1_dff
AFPb0 d_obp d_stb13 NULL d_rstb fpb0 nfpb0 r1_dff
AFVb0 d_vdd d_stb13 NULL d_rstb fvb0 nfvb0 r1_dff
AFNb0 [fvb0 nfpb0] fnb0 r1_and
AQb0 fpb0 d_latb NULL NULL qb0 nqb0 r1_dff
AFPb1 d_obp d_stb14 NULL d_rstb fpb1 nfpb1 r1_dff
AFVb1 d_vdd d_stb14 NULL d_rstb fvb1 nfvb1 r1_dff
AFNb1 [fvb1 nfpb1] fnb1 r1_and
AQb1 fpb1 d_latb NULL NULL qb1 nqb1 r1_dff
AFPb2 d_obp d_stb15 NULL d_rstb fpb2 nfpb2 r1_dff
AFVb2 d_vdd d_stb15 NULL d_rstb fvb2 nfvb2 r1_dff
AFNb2 [fvb2 nfpb2] fnb2 r1_and
AQb2 fpb2 d_latb NULL NULL qb2 nqb2 r1_dff
AFPb3 d_obp d_stb16 NULL d_rstb fpb3 nfpb3 r1_dff
AFVb3 d_vdd d_stb16 NULL d_rstb fvb3 nfvb3 r1_dff
AFNb3 [fvb3 nfpb3] fnb3 r1_and
AQb3 fpb3 d_latb NULL NULL qb3 nqb3 r1_dff
AFPb4 d_obp d_stb17 NULL d_rstb fpb4 nfpb4 r1_dff
AFVb4 d_vdd d_stb17 NULL d_rstb fvb4 nfvb4 r1_dff
AFNb4 [fvb4 nfpb4] fnb4 r1_and
AQb4 fpb4 d_latb NULL NULL qb4 nqb4 r1_dff
AFPb5 d_obp d_stb18 NULL d_rstb fpb5 nfpb5 r1_dff
AFVb5 d_vdd d_stb18 NULL d_rstb fvb5 nfvb5 r1_dff
AFNb5 [fvb5 nfpb5] fnb5 r1_and
AQb5 fpb5 d_latb NULL NULL qb5 nqb5 r1_dff
AFPb6 d_obp d_stb19 NULL d_rstb fpb6 nfpb6 r1_dff
AFVb6 d_vdd d_stb19 NULL d_rstb fvb6 nfvb6 r1_dff
AFNb6 [fvb6 nfpb6] fnb6 r1_and
AQb6 fpb6 d_latb NULL NULL qb6 nqb6 r1_dff
AFPb7 d_obp d_stb20 NULL d_rstb fpb7 nfpb7 r1_dff
AFVb7 d_vdd d_stb20 NULL d_rstb fvb7 nfvb7 r1_dff
AFNb7 [fvb7 nfpb7] fnb7 r1_and
AQb7 fpb7 d_latb NULL NULL qb7 nqb7 r1_dff
AFPb8 d_obp d_stb21 NULL d_rstb fpb8 nfpb8 r1_dff
AFVb8 d_vdd d_stb21 NULL d_rstb fvb8 nfvb8 r1_dff
AFNb8 [fvb8 nfpb8] fnb8 r1_and
AQb8 fpb8 d_latb NULL NULL qb8 nqb8 r1_dff
AFPb9 d_obp d_stb22 NULL d_rstb fpb9 nfpb9 r1_dff
AFVb9 d_vdd d_stb22 NULL d_rstb fvb9 nfvb9 r1_dff
AFNb9 [fvb9 nfpb9] fnb9 r1_and
AQb9 fpb9 d_latb NULL NULL qb9 nqb9 r1_dff
AFPb10 d_obp d_stb23 NULL d_rstb fpb10 nfpb10 r1_dff
AFVb10 d_vdd d_stb23 NULL d_rstb fvb10 nfvb10 r1_dff
AFNb10 [fvb10 nfpb10] fnb10 r1_and
AQb10 fpb10 d_latb NULL NULL qb10 nqb10 r1_dff
AFPb11 d_obp d_stb24 NULL d_rstb fpb11 nfpb11 r1_dff
AFVb11 d_vdd d_stb24 NULL d_rstb fvb11 nfvb11 r1_dff
AFNb11 [fvb11 nfpb11] fnb11 r1_and
AQb11 fpb11 d_latb NULL NULL qb11 nqb11 r1_dff
AFPb12 d_obp d_stb25 NULL d_rstb fpb12 nfpb12 r1_dff
AQb12 fpb12 d_latb NULL NULL qb12 nqb12 r1_dff
ADB [g_clka g_clkab g_clkb g_clkbb fpa0 fna0 fpa1 fna1 fpa2 fna2 fpa3 fna3 fpa4 fna4 fpa5 fna5 fpa6 fna6 fpa7 fna7 fpa8 fna8 fpa9 fna9 fpa10 fna10 fpa11 fna11 qa0 qa1 qa2 qa3 qa4 qa5 qa6 qa7 qa8 qa9 qa10 qa11 qa12 fpb0 fnb0 fpb1 fnb1 fpb2 fnb2 fpb3 fnb3 fpb4 fnb4 fpb5 fnb5 fpb6 fnb6 fpb7 fnb7 fpb8 fnb8 fpb9 fnb9 fpb10 fnb10 fpb11 fnb11 qb0 qb1 qb2 qb3 qb4 qb5 qb6 qb7 qb8 qb9 qb10 qb11 qb12] [clka clkab clkb clkbb cpa11 cna11 cpa10 cna10 cpa9 cna9 cpa8 cna8 cpa7 cna7 cpa6 cna6 cpa5 cna5 cpa4 cna4 cpa3 cna3 cpa2 cna2 cpa1 cna1 cpa0 cna0 ra12 ra11 ra10 ra9 ra8 ra7 ra6 ra5 ra4 ra3 ra2 ra1 ra0 cpb11 cnb11 cpb10 cnb10 cpb9 cnb9 cpb8 cnb8 cpb7 cnb7 cpb6 cnb6 cpb5 cnb5 cpb4 cnb4 cpb3 cnb3 cpb2 cnb2 cpb1 cnb1 cpb0 cnb0 rb12 rb11 rb10 rb9 rb8 rb7 rb6 rb5 rb4 rb3 rb2 rb1 rb0] r1_dacb
Brawa rawa gnd v=(1*v(ra0)+2*v(ra1)+4*v(ra2)+8*v(ra3)+16*v(ra4)+32*v(ra5)+64*v(ra6)+128*v(ra7)+256*v(ra8)+512*v(ra9)+1024*v(ra10)+2048*v(ra11)+4096*v(ra12))/1.2
Brawb rawb gnd v=(1*v(rb0)+2*v(rb1)+4*v(rb2)+8*v(rb3)+16*v(rb4)+32*v(rb5)+64*v(rb6)+128*v(rb7)+256*v(rb8)+512*v(rb9)+1024*v(rb10)+2048*v(rb11)+4096*v(rb12))/1.2
.ends r1_sar2_logic

* ---------------------------------------------------------------------------------------------
* r1_adc2_core: R1 ADC revision-2 core. Slice A: in0 = SIN, in1 = ISA. Slice B: in0 = COS, in1 = ISB.
* Frame (30 cycles of 30 MHz): A decides in cycles 0-12, B in 13-25; A tracks 13-29, B tracks 26-29.
* ---------------------------------------------------------------------------------------------
.subckt r1_adc2_core sinp sinn cosp cosn isap isan isbp isbn trka0 trka1 trkb0 trkb1 mclk wina winb lata latb stb0 stb1 stb2 stb3 stb4 stb5 stb6 stb7 stb8 stb9 stb10 stb11 stb12 stb13 stb14 stb15 stb16 stb17 stb18 stb19 stb20 stb21 stb22 stb23 stb24 stb25 rawa rawb topap topan topbp topbn vdd vref gnd
XTHA sinp sinn isap isan trka0 trka1 topap topan cpa11 cpa10 cpa9 cpa8 cpa7 cpa6 cpa5 cpa4 cpa3 cpa2 cpa1 cpa0 cna11 cna10 cna9 cna8 cna7 cna6 cna5 cna4 cna3 cna2 cna1 cna0 vdd vref gnd r1_th2
XCBIAS vbp vdd gnd r1_cmp2_bias
XCMPA topap topan clka clkab oap oan vbp vdd gnd r1_cmp2
XTHB cosp cosn isbp isbn trkb0 trkb1 topbp topbn cpb11 cpb10 cpb9 cpb8 cpb7 cpb6 cpb5 cpb4 cpb3 cpb2 cpb1 cpb0 cnb11 cnb10 cnb9 cnb8 cnb7 cnb6 cnb5 cnb4 cnb3 cnb2 cnb1 cnb0 vdd vref gnd r1_th2
XCMPB topbp topbn clkb clkbb obp obn vbp vdd gnd r1_cmp2
XSAR oap oan obp obn mclk wina winb trka0 trka1 trkb0 trkb1 lata latb stb0 stb1 stb2 stb3 stb4 stb5 stb6 stb7 stb8 stb9 stb10 stb11 stb12 stb13 stb14 stb15 stb16 stb17 stb18 stb19 stb20 stb21 stb22 stb23 stb24 stb25 clka clkab clkb clkbb cpa11 cpa10 cpa9 cpa8 cpa7 cpa6 cpa5 cpa4 cpa3 cpa2 cpa1 cpa0 cna11 cna10 cna9 cna8 cna7 cna6 cna5 cna4 cna3 cna2 cna1 cna0 cpb11 cpb10 cpb9 cpb8 cpb7 cpb6 cpb5 cpb4 cpb3 cpb2 cpb1 cpb0 cnb11 cnb10 cnb9 cnb8 cnb7 cnb6 cnb5 cnb4 cnb3 cnb2 cnb1 cnb0 rawa rawb vdd gnd r1_sar2_logic
.ends r1_adc2_core

* ---------------------------------------------------------------------------------------------
* r1_adc2_core_fast: R1 ADC revision-2 core. Slice A: in0 = SIN, in1 = ISA. Slice B: in0 = COS, in1 = ISB.
* Frame (30 cycles of 30 MHz): A decides in cycles 0-12, B in 13-25; A tracks 13-29, B tracks 26-29.
* ---------------------------------------------------------------------------------------------
.subckt r1_adc2_core_fast sinp sinn cosp cosn isap isan isbp isbn trka0 trka1 trkb0 trkb1 mclk wina winb lata latb stb0 stb1 stb2 stb3 stb4 stb5 stb6 stb7 stb8 stb9 stb10 stb11 stb12 stb13 stb14 stb15 stb16 stb17 stb18 stb19 stb20 stb21 stb22 stb23 stb24 stb25 rawa rawb topap topan topbp topbn vdd vref gnd
XTHA sinp sinn isap isan trka0 trka1 topap topan cpa11 cpa10 cpa9 cpa8 cpa7 cpa6 cpa5 cpa4 cpa3 cpa2 cpa1 cpa0 cna11 cna10 cna9 cna8 cna7 cna6 cna5 cna4 cna3 cna2 cna1 cna0 vdd vref gnd r1_th2_fast
XCBIAS vbp vdd gnd r1_cmp2_bias
XCMPA topap topan clka clkab oap oan vbp vdd gnd r1_cmp2
XTHB cosp cosn isbp isbn trkb0 trkb1 topbp topbn cpb11 cpb10 cpb9 cpb8 cpb7 cpb6 cpb5 cpb4 cpb3 cpb2 cpb1 cpb0 cnb11 cnb10 cnb9 cnb8 cnb7 cnb6 cnb5 cnb4 cnb3 cnb2 cnb1 cnb0 vdd vref gnd r1_th2_fast
XCMPB topbp topbn clkb clkbb obp obn vbp vdd gnd r1_cmp2
XSAR oap oan obp obn mclk wina winb trka0 trka1 trkb0 trkb1 lata latb stb0 stb1 stb2 stb3 stb4 stb5 stb6 stb7 stb8 stb9 stb10 stb11 stb12 stb13 stb14 stb15 stb16 stb17 stb18 stb19 stb20 stb21 stb22 stb23 stb24 stb25 clka clkab clkb clkbb cpa11 cpa10 cpa9 cpa8 cpa7 cpa6 cpa5 cpa4 cpa3 cpa2 cpa1 cpa0 cna11 cna10 cna9 cna8 cna7 cna6 cna5 cna4 cna3 cna2 cna1 cna0 cpb11 cpb10 cpb9 cpb8 cpb7 cpb6 cpb5 cpb4 cpb3 cpb2 cpb1 cpb0 cnb11 cnb10 cnb9 cnb8 cnb7 cnb6 cnb5 cnb4 cnb3 cnb2 cnb1 cnb0 rawa rawb vdd gnd r1_sar2_logic
.ends r1_adc2_core_fast

* ---------------------------------------------------------------------------------------------
* r1_adc2_core_fast_a: R1 ADC revision-2 core. Slice A: in0 = SIN, in1 = ISA. Slice B: in0 = COS, in1 = ISB.
* Slice A only (slice B and comparator B removed, comparator-B inputs of the SAR logic tied); static decks.
* ---------------------------------------------------------------------------------------------
.subckt r1_adc2_core_fast_a sinp sinn cosp cosn isap isan isbp isbn trka0 trka1 trkb0 trkb1 mclk wina winb lata latb stb0 stb1 stb2 stb3 stb4 stb5 stb6 stb7 stb8 stb9 stb10 stb11 stb12 stb13 stb14 stb15 stb16 stb17 stb18 stb19 stb20 stb21 stb22 stb23 stb24 stb25 rawa rawb topap topan topbp topbn vdd vref gnd
XTHA sinp sinn isap isan trka0 trka1 topap topan cpa11 cpa10 cpa9 cpa8 cpa7 cpa6 cpa5 cpa4 cpa3 cpa2 cpa1 cpa0 cna11 cna10 cna9 cna8 cna7 cna6 cna5 cna4 cna3 cna2 cna1 cna0 vdd vref gnd r1_th2_fast
XCBIAS vbp vdd gnd r1_cmp2_bias
XCMPA topap topan clka clkab oap oan vbp vdd gnd r1_cmp2
Vtieb1 obp gnd 1.2
Vtieb2 obn gnd 0
Rtb1 topbp gnd 1e9
Rtb2 topbn gnd 1e9
XSAR oap oan obp obn mclk wina winb trka0 trka1 trkb0 trkb1 lata latb stb0 stb1 stb2 stb3 stb4 stb5 stb6 stb7 stb8 stb9 stb10 stb11 stb12 stb13 stb14 stb15 stb16 stb17 stb18 stb19 stb20 stb21 stb22 stb23 stb24 stb25 clka clkab clkb clkbb cpa11 cpa10 cpa9 cpa8 cpa7 cpa6 cpa5 cpa4 cpa3 cpa2 cpa1 cpa0 cna11 cna10 cna9 cna8 cna7 cna6 cna5 cna4 cna3 cna2 cna1 cna0 cpb11 cpb10 cpb9 cpb8 cpb7 cpb6 cpb5 cpb4 cpb3 cpb2 cpb1 cpb0 cnb11 cnb10 cnb9 cnb8 cnb7 cnb6 cnb5 cnb4 cnb3 cnb2 cnb1 cnb0 rawa rawb vdd gnd r1_sar2_logic
.ends r1_adc2_core_fast_a

* ---------------------------------------------------------------------------------------------
* r1_refbuf: ADC reference buffer, 1.0 V from the bandgap node (vbg = 1.045 V, G1 lineage; ideal in the decks).
*  divider: 23 equal rhigh segments (w 1 um, l 10 um), tap 22/23 from ground: 0.99957 V; ~3 uA from vbg.
*  error amplifier (VDDA 3.3 V, thick oxide): HV NMOS pair (+ vtap, - vref), HV PMOS mirror, tail = 2 x bias.
*  output stage: HV NMOS source follower (drain VDDA, msf x 4 x 10/0.45 um) sunk by an HV NMOS mirror of
*  mib x the bias current at vref; gate node held by a MIM capacitor (cg MIM cells of 50 x 50 um, 3.76 pF each)
*  so that the fast CDAC charge is served by the follower (1/gm) and the decoupling capacitor.
*  decoupling: ndec MIM cells of 70 x 70 um (7.36 pF each) on vref.
*  bias: ibias (ideal 5 uA reference current; stands in for the bandgap-derived iptat bias).
* Ports: vbg vref vdda gnd.
* ---------------------------------------------------------------------------------------------
.subckt r1_refbuf vbg vref vdda gnd msf=8 mib=40 ndec=6 ncg=1
XRD1 vbg vtap gnd rhigh w=1e-6 l=10e-6 m=1
XRD2 vtap n3 gnd rhigh w=1e-6 l=10e-6 m=1
XRD3 n3 n4 gnd rhigh w=1e-6 l=10e-6 m=1
XRD4 n4 n5 gnd rhigh w=1e-6 l=10e-6 m=1
XRD5 n5 n6 gnd rhigh w=1e-6 l=10e-6 m=1
XRD6 n6 n7 gnd rhigh w=1e-6 l=10e-6 m=1
XRD7 n7 n8 gnd rhigh w=1e-6 l=10e-6 m=1
XRD8 n8 n9 gnd rhigh w=1e-6 l=10e-6 m=1
XRD9 n9 n10 gnd rhigh w=1e-6 l=10e-6 m=1
XRD10 n10 n11 gnd rhigh w=1e-6 l=10e-6 m=1
XRD11 n11 n12 gnd rhigh w=1e-6 l=10e-6 m=1
XRD12 n12 n13 gnd rhigh w=1e-6 l=10e-6 m=1
XRD13 n13 n14 gnd rhigh w=1e-6 l=10e-6 m=1
XRD14 n14 n15 gnd rhigh w=1e-6 l=10e-6 m=1
XRD15 n15 n16 gnd rhigh w=1e-6 l=10e-6 m=1
XRD16 n16 n17 gnd rhigh w=1e-6 l=10e-6 m=1
XRD17 n17 n18 gnd rhigh w=1e-6 l=10e-6 m=1
XRD18 n18 n19 gnd rhigh w=1e-6 l=10e-6 m=1
XRD19 n19 n20 gnd rhigh w=1e-6 l=10e-6 m=1
XRD20 n20 n21 gnd rhigh w=1e-6 l=10e-6 m=1
XRD21 n21 n22 gnd rhigh w=1e-6 l=10e-6 m=1
XRD22 n22 n23 gnd rhigh w=1e-6 l=10e-6 m=1
XRD23 n23 gnd gnd rhigh w=1e-6 l=10e-6 m=1
Ibias vdda nb 5u
XMB0 nb nb gnd gnd sg13_hv_nmos w=2u l=1u ng=1 m=1 mm_ok={mmos}
XMT  ntl nb gnd gnd sg13_hv_nmos w=2u l=1u ng=1 m=2
XM1  na  vtap ntl gnd sg13_hv_nmos w=10u l=1u ng=2 m=1 mm_ok={mmos}
XM2  ng  vref ntl gnd sg13_hv_nmos w=10u l=1u ng=2 m=1 mm_ok={mmos}
XM3  na  na  vdda vdda sg13_hv_pmos w=4u l=1u ng=1 m=1 mm_ok={mmos}
XM4  ng  na  vdda vdda sg13_hv_pmos w=4u l=1u ng=1 m=1 mm_ok={mmos}
XCG  ng  gnd cap_cmim w=50u l=50u m={ncg}
XMSF vdda ng vref gnd sg13_hv_nmos w=10u l=0.45u ng=4 m={msf} mm_ok={mmos}
XMIB vref nb gnd gnd sg13_hv_nmos w=2u l=1u ng=1 m={mib} mm_ok={mmos}
XCD  vref gnd cap_cmim w=70u l=70u m={ndec}
.ends r1_refbuf
