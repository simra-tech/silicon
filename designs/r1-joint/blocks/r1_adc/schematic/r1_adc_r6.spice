* r1_adc_r6.spice -- R1 12-bit SAR ADC revision 6, schematic-level library (generated by gen_r1_adc_r6.py; do not edit)
* Revision 6 (PLAN.md D28): the revision-5 library below, unchanged, plus r1_cmp6_clkgen (comparator strobe from the
* falling clk30 edge), r1_refbuf6 (LSB-array follower x3) and the cores r1_adc6_core(_fast, _fast_mc). The revision-5
* text follows from its second line on.
* Requires: cornerMOSlv.lib, cornerMOShv.lib (reference cells), cornerCAP.lib, cornerRES.lib, XSPICE digital code models, PSP/R3 OSDI.
* Unchanged revision-4 cells (same names): r1_bootsw, r1_offsw, r1_drv(_sw), r1_cdac3_side(_mc), r1_cmp4(_s1),
* r1_cmp4_bias, r1_cmp4_clkgen, r1_th4, r1_th4_fast, r1_th4_fast_mc.

* ---------------------------------------------------------------------------------------------
* r1_bootsw: bootstrapped NMOS sampling switch (unchanged from revision 1).
* ---------------------------------------------------------------------------------------------
.subckt r1_bootsw vin out trk trkb vdd gnd wsw=6u cboot=200f
XMS   vin  g    out  gnd  sg13_lv_nmos w={wsw} l=0.13u ng=2 m=1
Cboot cbp  cbn  {cboot}
XM1   cbn  trkb gnd  gnd  sg13_lv_nmos w=1u l=0.13u ng=1 m=1
XM3   cbp  g    vdd  cbp  sg13_lv_pmos w=1u l=0.13u ng=1 m=1
XM8   g    x    cbp  cbp  sg13_lv_pmos w=2u l=0.13u ng=1 m=1
XM4   x    trk  vdd  vdd  sg13_lv_pmos w=0.5u l=0.13u ng=1 m=1
XM5   x    trk  cbn  gnd  sg13_lv_nmos w=1u l=0.13u ng=1 m=1
XM7   x    g    cbn  gnd  sg13_lv_nmos w=0.5u l=0.13u ng=1 m=1
XM9   cbn  g    vin  gnd  sg13_lv_nmos w=2u l=0.13u ng=1 m=1
XM10  g    vdd  n10  gnd  sg13_lv_nmos w=2u l=0.13u ng=1 m=1
XM11  n10  trkb gnd  gnd  sg13_lv_nmos w=2u l=0.13u ng=1 m=1
.ends r1_bootsw

.subckt r1_offsw vin out gnd wsw=6u
XMS   vin  gnd  out  gnd  sg13_lv_nmos w={wsw} l=0.13u ng=2 m=1
.ends r1_offsw

* bottom-plate drivers (unchanged): in=0 -> out=VREF, in=1 -> out=GND
.subckt r1_drv in out vref gnd wp=1u wn=0.5u
XMP out in vref vref sg13_lv_pmos w={wp} l=0.13u ng=1 m=1
XMN out in gnd  gnd  sg13_lv_nmos w={wn} l=0.13u ng=1 m=1
.ends r1_drv

.subckt r1_drv_sw in out vref gnd
BU vref out i=(v(vref)-v(out))*(1e-12+2.5e-3*(0.5-0.5*tanh(20*(v(in)-0.6))))
BD out gnd i=(v(out)-v(gnd))*(1e-12+2.5e-3*(0.5+0.5*tanh(20*(v(in)-0.6))))
.ends r1_drv_sw

* ---------------------------------------------------------------------------------------------
* r1_cdac3_side: one side of the revision-3 split array (14 decisions). Unit Cu = cap_cmim 3.78u x 3.78u (22.04 fF).
* top: C12..C8 = 16, 8, 4, 2, 1 Cu; bridge Cb = cap_cmim 4.23u x 4.23u (1.249 Cu) top-lsb;
* lsb: C7..C1 = 64, 32, 16, 8, 4, 2, 1 Cu, C0 = cap_cmim 2.67u x 2.67u (half unit). Nominal (m=).
* ---------------------------------------------------------------------------------------------
.subckt r1_cdac3_side top lsb b12 b11 b10 b9 b8 b7 b6 b5 b4 b3 b2 b1 b0
XC12 top b12 cap_cmim w=3.78u l=3.78u m=16
XC11 top b11 cap_cmim w=3.78u l=3.78u m=8
XC10 top b10 cap_cmim w=3.78u l=3.78u m=4
XC9 top b9 cap_cmim w=3.78u l=3.78u m=2
XC8 top b8 cap_cmim w=3.78u l=3.78u m=1
XC7 lsb b7 cap_cmim w=3.78u l=3.78u m=64
XC6 lsb b6 cap_cmim w=3.78u l=3.78u m=32
XC5 lsb b5 cap_cmim w=3.78u l=3.78u m=16
XC4 lsb b4 cap_cmim w=3.78u l=3.78u m=8
XC3 lsb b3 cap_cmim w=3.78u l=3.78u m=4
XC2 lsb b2 cap_cmim w=3.78u l=3.78u m=2
XC1 lsb b1 cap_cmim w=3.78u l=3.78u m=1
XC0 lsb b0 cap_cmim w=2.67u l=2.67u m=1
XCB top lsb cap_cmim w=4.23u l=4.23u m=1
.ends r1_cdac3_side

* ---------------------------------------------------------------------------------------------
* r1_cdac3_side_mc: one side of the revision-3 split array (14 decisions). Unit Cu = cap_cmim 3.78u x 3.78u (22.04 fF).
* top: C12..C8 = 16, 8, 4, 2, 1 Cu; bridge Cb = cap_cmim 4.23u x 4.23u (1.249 Cu) top-lsb;
* lsb: C7..C1 = 64, 32, 16, 8, 4, 2, 1 Cu, C0 = cap_cmim 2.67u x 2.67u (half unit). One instance per unit (mismatch MC).
* ---------------------------------------------------------------------------------------------
.subckt r1_cdac3_side_mc top lsb b12 b11 b10 b9 b8 b7 b6 b5 b4 b3 b2 b1 b0 mm=1
XC12_0 top b12 cap_cmim w=3.78u l=3.78u mm_ok={mm}
XC12_1 top b12 cap_cmim w=3.78u l=3.78u mm_ok={mm}
XC12_2 top b12 cap_cmim w=3.78u l=3.78u mm_ok={mm}
XC12_3 top b12 cap_cmim w=3.78u l=3.78u mm_ok={mm}
XC12_4 top b12 cap_cmim w=3.78u l=3.78u mm_ok={mm}
XC12_5 top b12 cap_cmim w=3.78u l=3.78u mm_ok={mm}
XC12_6 top b12 cap_cmim w=3.78u l=3.78u mm_ok={mm}
XC12_7 top b12 cap_cmim w=3.78u l=3.78u mm_ok={mm}
XC12_8 top b12 cap_cmim w=3.78u l=3.78u mm_ok={mm}
XC12_9 top b12 cap_cmim w=3.78u l=3.78u mm_ok={mm}
XC12_10 top b12 cap_cmim w=3.78u l=3.78u mm_ok={mm}
XC12_11 top b12 cap_cmim w=3.78u l=3.78u mm_ok={mm}
XC12_12 top b12 cap_cmim w=3.78u l=3.78u mm_ok={mm}
XC12_13 top b12 cap_cmim w=3.78u l=3.78u mm_ok={mm}
XC12_14 top b12 cap_cmim w=3.78u l=3.78u mm_ok={mm}
XC12_15 top b12 cap_cmim w=3.78u l=3.78u mm_ok={mm}
XC11_0 top b11 cap_cmim w=3.78u l=3.78u mm_ok={mm}
XC11_1 top b11 cap_cmim w=3.78u l=3.78u mm_ok={mm}
XC11_2 top b11 cap_cmim w=3.78u l=3.78u mm_ok={mm}
XC11_3 top b11 cap_cmim w=3.78u l=3.78u mm_ok={mm}
XC11_4 top b11 cap_cmim w=3.78u l=3.78u mm_ok={mm}
XC11_5 top b11 cap_cmim w=3.78u l=3.78u mm_ok={mm}
XC11_6 top b11 cap_cmim w=3.78u l=3.78u mm_ok={mm}
XC11_7 top b11 cap_cmim w=3.78u l=3.78u mm_ok={mm}
XC10_0 top b10 cap_cmim w=3.78u l=3.78u mm_ok={mm}
XC10_1 top b10 cap_cmim w=3.78u l=3.78u mm_ok={mm}
XC10_2 top b10 cap_cmim w=3.78u l=3.78u mm_ok={mm}
XC10_3 top b10 cap_cmim w=3.78u l=3.78u mm_ok={mm}
XC9_0 top b9 cap_cmim w=3.78u l=3.78u mm_ok={mm}
XC9_1 top b9 cap_cmim w=3.78u l=3.78u mm_ok={mm}
XC8_0 top b8 cap_cmim w=3.78u l=3.78u mm_ok={mm}
XC7_0 lsb b7 cap_cmim w=3.78u l=3.78u mm_ok={mm}
XC7_1 lsb b7 cap_cmim w=3.78u l=3.78u mm_ok={mm}
XC7_2 lsb b7 cap_cmim w=3.78u l=3.78u mm_ok={mm}
XC7_3 lsb b7 cap_cmim w=3.78u l=3.78u mm_ok={mm}
XC7_4 lsb b7 cap_cmim w=3.78u l=3.78u mm_ok={mm}
XC7_5 lsb b7 cap_cmim w=3.78u l=3.78u mm_ok={mm}
XC7_6 lsb b7 cap_cmim w=3.78u l=3.78u mm_ok={mm}
XC7_7 lsb b7 cap_cmim w=3.78u l=3.78u mm_ok={mm}
XC7_8 lsb b7 cap_cmim w=3.78u l=3.78u mm_ok={mm}
XC7_9 lsb b7 cap_cmim w=3.78u l=3.78u mm_ok={mm}
XC7_10 lsb b7 cap_cmim w=3.78u l=3.78u mm_ok={mm}
XC7_11 lsb b7 cap_cmim w=3.78u l=3.78u mm_ok={mm}
XC7_12 lsb b7 cap_cmim w=3.78u l=3.78u mm_ok={mm}
XC7_13 lsb b7 cap_cmim w=3.78u l=3.78u mm_ok={mm}
XC7_14 lsb b7 cap_cmim w=3.78u l=3.78u mm_ok={mm}
XC7_15 lsb b7 cap_cmim w=3.78u l=3.78u mm_ok={mm}
XC7_16 lsb b7 cap_cmim w=3.78u l=3.78u mm_ok={mm}
XC7_17 lsb b7 cap_cmim w=3.78u l=3.78u mm_ok={mm}
XC7_18 lsb b7 cap_cmim w=3.78u l=3.78u mm_ok={mm}
XC7_19 lsb b7 cap_cmim w=3.78u l=3.78u mm_ok={mm}
XC7_20 lsb b7 cap_cmim w=3.78u l=3.78u mm_ok={mm}
XC7_21 lsb b7 cap_cmim w=3.78u l=3.78u mm_ok={mm}
XC7_22 lsb b7 cap_cmim w=3.78u l=3.78u mm_ok={mm}
XC7_23 lsb b7 cap_cmim w=3.78u l=3.78u mm_ok={mm}
XC7_24 lsb b7 cap_cmim w=3.78u l=3.78u mm_ok={mm}
XC7_25 lsb b7 cap_cmim w=3.78u l=3.78u mm_ok={mm}
XC7_26 lsb b7 cap_cmim w=3.78u l=3.78u mm_ok={mm}
XC7_27 lsb b7 cap_cmim w=3.78u l=3.78u mm_ok={mm}
XC7_28 lsb b7 cap_cmim w=3.78u l=3.78u mm_ok={mm}
XC7_29 lsb b7 cap_cmim w=3.78u l=3.78u mm_ok={mm}
XC7_30 lsb b7 cap_cmim w=3.78u l=3.78u mm_ok={mm}
XC7_31 lsb b7 cap_cmim w=3.78u l=3.78u mm_ok={mm}
XC7_32 lsb b7 cap_cmim w=3.78u l=3.78u mm_ok={mm}
XC7_33 lsb b7 cap_cmim w=3.78u l=3.78u mm_ok={mm}
XC7_34 lsb b7 cap_cmim w=3.78u l=3.78u mm_ok={mm}
XC7_35 lsb b7 cap_cmim w=3.78u l=3.78u mm_ok={mm}
XC7_36 lsb b7 cap_cmim w=3.78u l=3.78u mm_ok={mm}
XC7_37 lsb b7 cap_cmim w=3.78u l=3.78u mm_ok={mm}
XC7_38 lsb b7 cap_cmim w=3.78u l=3.78u mm_ok={mm}
XC7_39 lsb b7 cap_cmim w=3.78u l=3.78u mm_ok={mm}
XC7_40 lsb b7 cap_cmim w=3.78u l=3.78u mm_ok={mm}
XC7_41 lsb b7 cap_cmim w=3.78u l=3.78u mm_ok={mm}
XC7_42 lsb b7 cap_cmim w=3.78u l=3.78u mm_ok={mm}
XC7_43 lsb b7 cap_cmim w=3.78u l=3.78u mm_ok={mm}
XC7_44 lsb b7 cap_cmim w=3.78u l=3.78u mm_ok={mm}
XC7_45 lsb b7 cap_cmim w=3.78u l=3.78u mm_ok={mm}
XC7_46 lsb b7 cap_cmim w=3.78u l=3.78u mm_ok={mm}
XC7_47 lsb b7 cap_cmim w=3.78u l=3.78u mm_ok={mm}
XC7_48 lsb b7 cap_cmim w=3.78u l=3.78u mm_ok={mm}
XC7_49 lsb b7 cap_cmim w=3.78u l=3.78u mm_ok={mm}
XC7_50 lsb b7 cap_cmim w=3.78u l=3.78u mm_ok={mm}
XC7_51 lsb b7 cap_cmim w=3.78u l=3.78u mm_ok={mm}
XC7_52 lsb b7 cap_cmim w=3.78u l=3.78u mm_ok={mm}
XC7_53 lsb b7 cap_cmim w=3.78u l=3.78u mm_ok={mm}
XC7_54 lsb b7 cap_cmim w=3.78u l=3.78u mm_ok={mm}
XC7_55 lsb b7 cap_cmim w=3.78u l=3.78u mm_ok={mm}
XC7_56 lsb b7 cap_cmim w=3.78u l=3.78u mm_ok={mm}
XC7_57 lsb b7 cap_cmim w=3.78u l=3.78u mm_ok={mm}
XC7_58 lsb b7 cap_cmim w=3.78u l=3.78u mm_ok={mm}
XC7_59 lsb b7 cap_cmim w=3.78u l=3.78u mm_ok={mm}
XC7_60 lsb b7 cap_cmim w=3.78u l=3.78u mm_ok={mm}
XC7_61 lsb b7 cap_cmim w=3.78u l=3.78u mm_ok={mm}
XC7_62 lsb b7 cap_cmim w=3.78u l=3.78u mm_ok={mm}
XC7_63 lsb b7 cap_cmim w=3.78u l=3.78u mm_ok={mm}
XC6_0 lsb b6 cap_cmim w=3.78u l=3.78u mm_ok={mm}
XC6_1 lsb b6 cap_cmim w=3.78u l=3.78u mm_ok={mm}
XC6_2 lsb b6 cap_cmim w=3.78u l=3.78u mm_ok={mm}
XC6_3 lsb b6 cap_cmim w=3.78u l=3.78u mm_ok={mm}
XC6_4 lsb b6 cap_cmim w=3.78u l=3.78u mm_ok={mm}
XC6_5 lsb b6 cap_cmim w=3.78u l=3.78u mm_ok={mm}
XC6_6 lsb b6 cap_cmim w=3.78u l=3.78u mm_ok={mm}
XC6_7 lsb b6 cap_cmim w=3.78u l=3.78u mm_ok={mm}
XC6_8 lsb b6 cap_cmim w=3.78u l=3.78u mm_ok={mm}
XC6_9 lsb b6 cap_cmim w=3.78u l=3.78u mm_ok={mm}
XC6_10 lsb b6 cap_cmim w=3.78u l=3.78u mm_ok={mm}
XC6_11 lsb b6 cap_cmim w=3.78u l=3.78u mm_ok={mm}
XC6_12 lsb b6 cap_cmim w=3.78u l=3.78u mm_ok={mm}
XC6_13 lsb b6 cap_cmim w=3.78u l=3.78u mm_ok={mm}
XC6_14 lsb b6 cap_cmim w=3.78u l=3.78u mm_ok={mm}
XC6_15 lsb b6 cap_cmim w=3.78u l=3.78u mm_ok={mm}
XC6_16 lsb b6 cap_cmim w=3.78u l=3.78u mm_ok={mm}
XC6_17 lsb b6 cap_cmim w=3.78u l=3.78u mm_ok={mm}
XC6_18 lsb b6 cap_cmim w=3.78u l=3.78u mm_ok={mm}
XC6_19 lsb b6 cap_cmim w=3.78u l=3.78u mm_ok={mm}
XC6_20 lsb b6 cap_cmim w=3.78u l=3.78u mm_ok={mm}
XC6_21 lsb b6 cap_cmim w=3.78u l=3.78u mm_ok={mm}
XC6_22 lsb b6 cap_cmim w=3.78u l=3.78u mm_ok={mm}
XC6_23 lsb b6 cap_cmim w=3.78u l=3.78u mm_ok={mm}
XC6_24 lsb b6 cap_cmim w=3.78u l=3.78u mm_ok={mm}
XC6_25 lsb b6 cap_cmim w=3.78u l=3.78u mm_ok={mm}
XC6_26 lsb b6 cap_cmim w=3.78u l=3.78u mm_ok={mm}
XC6_27 lsb b6 cap_cmim w=3.78u l=3.78u mm_ok={mm}
XC6_28 lsb b6 cap_cmim w=3.78u l=3.78u mm_ok={mm}
XC6_29 lsb b6 cap_cmim w=3.78u l=3.78u mm_ok={mm}
XC6_30 lsb b6 cap_cmim w=3.78u l=3.78u mm_ok={mm}
XC6_31 lsb b6 cap_cmim w=3.78u l=3.78u mm_ok={mm}
XC5_0 lsb b5 cap_cmim w=3.78u l=3.78u mm_ok={mm}
XC5_1 lsb b5 cap_cmim w=3.78u l=3.78u mm_ok={mm}
XC5_2 lsb b5 cap_cmim w=3.78u l=3.78u mm_ok={mm}
XC5_3 lsb b5 cap_cmim w=3.78u l=3.78u mm_ok={mm}
XC5_4 lsb b5 cap_cmim w=3.78u l=3.78u mm_ok={mm}
XC5_5 lsb b5 cap_cmim w=3.78u l=3.78u mm_ok={mm}
XC5_6 lsb b5 cap_cmim w=3.78u l=3.78u mm_ok={mm}
XC5_7 lsb b5 cap_cmim w=3.78u l=3.78u mm_ok={mm}
XC5_8 lsb b5 cap_cmim w=3.78u l=3.78u mm_ok={mm}
XC5_9 lsb b5 cap_cmim w=3.78u l=3.78u mm_ok={mm}
XC5_10 lsb b5 cap_cmim w=3.78u l=3.78u mm_ok={mm}
XC5_11 lsb b5 cap_cmim w=3.78u l=3.78u mm_ok={mm}
XC5_12 lsb b5 cap_cmim w=3.78u l=3.78u mm_ok={mm}
XC5_13 lsb b5 cap_cmim w=3.78u l=3.78u mm_ok={mm}
XC5_14 lsb b5 cap_cmim w=3.78u l=3.78u mm_ok={mm}
XC5_15 lsb b5 cap_cmim w=3.78u l=3.78u mm_ok={mm}
XC4_0 lsb b4 cap_cmim w=3.78u l=3.78u mm_ok={mm}
XC4_1 lsb b4 cap_cmim w=3.78u l=3.78u mm_ok={mm}
XC4_2 lsb b4 cap_cmim w=3.78u l=3.78u mm_ok={mm}
XC4_3 lsb b4 cap_cmim w=3.78u l=3.78u mm_ok={mm}
XC4_4 lsb b4 cap_cmim w=3.78u l=3.78u mm_ok={mm}
XC4_5 lsb b4 cap_cmim w=3.78u l=3.78u mm_ok={mm}
XC4_6 lsb b4 cap_cmim w=3.78u l=3.78u mm_ok={mm}
XC4_7 lsb b4 cap_cmim w=3.78u l=3.78u mm_ok={mm}
XC3_0 lsb b3 cap_cmim w=3.78u l=3.78u mm_ok={mm}
XC3_1 lsb b3 cap_cmim w=3.78u l=3.78u mm_ok={mm}
XC3_2 lsb b3 cap_cmim w=3.78u l=3.78u mm_ok={mm}
XC3_3 lsb b3 cap_cmim w=3.78u l=3.78u mm_ok={mm}
XC2_0 lsb b2 cap_cmim w=3.78u l=3.78u mm_ok={mm}
XC2_1 lsb b2 cap_cmim w=3.78u l=3.78u mm_ok={mm}
XC1_0 lsb b1 cap_cmim w=3.78u l=3.78u mm_ok={mm}
XC0 lsb b0 cap_cmim w=2.67u l=2.67u mm_ok={mm}
XCB top lsb cap_cmim w=4.23u l=4.23u mm_ok={mm}
.ends r1_cdac3_side_mc

* ---------------------------------------------------------------------------------------------
* r1_cmp4: double-tail dynamic comparator, revision 3. Topology of r1_cmp2 (revision 2); integration
* capacitors 32u/4u (PMOS gate capacitors on dip/din). clk=1, clkb=0: evaluate; clk=0: reset.
* inp > inn -> outp stays high.
* ---------------------------------------------------------------------------------------------
.subckt r1_cmp4_s1 inp inn dip din clkb vbp vdd gnd wi=48u li=0.3u ngi=12 wt=16u wtc=16u ltc=0.5u
XMT1 tail0 clkb vdd  vdd sg13_lv_pmos w={wt} l=0.13u ng=4 m=1
XMTC tail  vbp  tail0 vdd sg13_lv_pmos w={wtc} l={ltc} ng=2 m=1
XM1  dip  inp  tail vdd sg13_lv_pmos w={wi} l={li} ng={ngi} m=1
XM2  din  inn  tail vdd sg13_lv_pmos w={wi} l={li} ng={ngi} m=1
.ends r1_cmp4_s1

.subckt r1_cmp4 inp inn clk clkb outp outn vbp vdd gnd wi=48u li=0.3u ngi=12 wt=16u wtc=16u ltc=0.5u wcap=80u lcap=4u wr=20u wh=8u
XS1  inp inn dip din clkb vbp vdd gnd r1_cmp4_s1 wi={wi} li={li} ngi={ngi} wt={wt} wtc={wtc} ltc={ltc}
XCI1 vdd  dip  vdd  vdd sg13_lv_pmos w={wcap} l={lcap} ng=4 m=1
XCI2 vdd  din  vdd  vdd sg13_lv_pmos w={wcap} l={lcap} ng=4 m=1
XMR1 dip  clkb gnd  gnd sg13_lv_nmos w={wr} l=0.13u ng=1 m=1
XMR2 din  clkb gnd  gnd sg13_lv_nmos w={wr} l=0.13u ng=1 m=1
XMT2 lt   clk  gnd  gnd sg13_lv_nmos w=4u l=0.13u ng=1 m=1
XMN1 outp outn lt   gnd sg13_lv_nmos w=2u l=0.13u ng=1 m=1
XMN2 outn outp lt   gnd sg13_lv_nmos w=2u l=0.13u ng=1 m=1
XMP1 outp outn vdd  vdd sg13_lv_pmos w=2u l=0.13u ng=1 m=1
XMP2 outn outp vdd  vdd sg13_lv_pmos w=2u l=0.13u ng=1 m=1
XMH1 outp dip  vdd  vdd sg13_lv_pmos w={wh} l=0.13u ng=2 m=1
XMH2 outn din  vdd  vdd sg13_lv_pmos w={wh} l=0.13u ng=2 m=1
XBP1 outpb outp vdd vdd sg13_lv_pmos w=1u l=0.13u ng=1 m=1
XBN1 outpb outp gnd gnd sg13_lv_nmos w=0.5u l=0.13u ng=1 m=1
XBP2 outnb outn vdd vdd sg13_lv_pmos w=1u l=0.13u ng=1 m=1
XBN2 outnb outn gnd gnd sg13_lv_nmos w=0.5u l=0.13u ng=1 m=1
Cbp outpb gnd 3f
Cbn outnb gnd 3f
.ends r1_cmp4

* r1_cmp4_bias: tail bias, I = (VDD - Vsg(XMBD)) / R with R = rppd 1u x 160u (about 42 kohm at
* 260 ohm/sq + heads). Diode XMBD w = wtc / 20. The current falls where VDD - |Vtp| falls (low VDD, slow
* PMOS), which keeps the integration time C_int (VDD - |Vtp|) / I nearly constant.
.subckt r1_cmp4_bias vbp vdd gnd rbw=1u rbl=160u
XMBD vbp vbp vdd vdd sg13_lv_pmos w=0.8u l=0.5u ng=1 m=1
XRB  vbp gnd gnd rppd w={rbw} l={rbl} m=1
.ends r1_cmp4_bias

* r1_cmp4_ibias: the revision-2 ideal-current bias, kept for comparison runs only.
.subckt r1_cmp4_ibias vbp vdd gnd ib=14u
Ibc vbp gnd {ib}
XMBD vbp vbp vdd vdd sg13_lv_pmos w=0.8u l=0.5u ng=1 m=1
.ends r1_cmp4_ibias

* ---------------------------------------------------------------------------------------------
* r1_cmp5n: NMOS-input double-tail dynamic comparator (revision 5, decision 0 at CM 0.6 V). The r1_cmp4
* topology mirrored: clk=1 (clkb=0) evaluate, the NMOS pair discharges the integration nodes dip/din from VDD
* (integration capacitors: NMOS gate capacitors 30u/4u); clk=0 reset (PMOS precharge to VDD, outputs
* held low by XMH1/2). inp > inn -> dip falls first -> XMH1 releases outp first -> outp goes high.
* Reset state of the outputs: low (r1_cmp4: high).
* ---------------------------------------------------------------------------------------------
.subckt r1_cmp5n_s1 inp inn dip din clk vbn vdd gnd wi=16u li=0.5u ngi=4 wt=8u wtc=4u ltc=0.5u
XMT1 tail0 clk gnd gnd sg13_lv_nmos w={wt} l=0.13u ng=2 m=1
XMTC tail  vbn tail0 gnd sg13_lv_nmos w={wtc} l={ltc} ng=1 m=1
XM1  dip  inp  tail gnd sg13_lv_nmos w={wi} l={li} ng={ngi} m=1
XM2  din  inn  tail gnd sg13_lv_nmos w={wi} l={li} ng={ngi} m=1
.ends r1_cmp5n_s1

.subckt r1_cmp5n inp inn clk clkb outp outn vbn vdd gnd wi=16u li=0.5u ngi=4 wt=8u wtc=4u ltc=0.5u wcap=30u lcap=4u wr=16u wh=8u wlp=4u wlt=8u
XS1  inp inn dip din clk vbn vdd gnd r1_cmp5n_s1 wi={wi} li={li} ngi={ngi} wt={wt} wtc={wtc} ltc={ltc}
XCI1 gnd  dip  gnd  gnd sg13_lv_nmos w={wcap} l={lcap} ng=2 m=1
XCI2 gnd  din  gnd  gnd sg13_lv_nmos w={wcap} l={lcap} ng=2 m=1
XMR1 dip  clk  vdd  vdd sg13_lv_pmos w={wr} l=0.13u ng=1 m=1
XMR2 din  clk  vdd  vdd sg13_lv_pmos w={wr} l=0.13u ng=1 m=1
XMT2 lt   clkb vdd  vdd sg13_lv_pmos w={wlt} l=0.13u ng=1 m=1
XMP1 outp outn lt   vdd sg13_lv_pmos w={wlp} l=0.13u ng=1 m=1
XMP2 outn outp lt   vdd sg13_lv_pmos w={wlp} l=0.13u ng=1 m=1
XMN1 outp outn gnd  gnd sg13_lv_nmos w=1u l=0.13u ng=1 m=1
XMN2 outn outp gnd  gnd sg13_lv_nmos w=1u l=0.13u ng=1 m=1
XMH1 outp dip  gnd  gnd sg13_lv_nmos w={wh} l=0.13u ng=1 m=1
XMH2 outn din  gnd  gnd sg13_lv_nmos w={wh} l=0.13u ng=1 m=1
XBP1 outpb outp vdd vdd sg13_lv_pmos w=1u l=0.13u ng=1 m=1
XBN1 outpb outp gnd gnd sg13_lv_nmos w=0.5u l=0.13u ng=1 m=1
XBP2 outnb outn vdd vdd sg13_lv_pmos w=1u l=0.13u ng=1 m=1
XBN2 outnb outn gnd gnd sg13_lv_nmos w=0.5u l=0.13u ng=1 m=1
Cbp outpb gnd 3f
Cbn outnb gnd 3f
.ends r1_cmp5n

* r1_cmp5n_bias: tail bias of r1_cmp5n, I = (VDD - Vgs(XMBD)) / R, R = rppd 1u x 160u from VDD (mirror of
* r1_cmp4_bias). Diode XMBD w = wtc / 20.
.subckt r1_cmp5n_bias vbn vdd gnd rbw=1u rbl=160u
XMBD vbn vbn gnd gnd sg13_lv_nmos w=0.2u l=0.5u ng=1 m=1
XRB  vdd vbn gnd rppd w={rbw} l={rbl} m=1
.ends r1_cmp5n_bias

* ---------------------------------------------------------------------------------------------
* r1_cmp4_clkgen: comparator clock from clk30 (revision 4). mclk = NAND(clk30, x), x = clk30 inverted and
* delayed by 5 inverters (wn 0.5u/0.5u, wp 1u/0.5u, 10f load each). A rising clk30 edge gives mclk = 0 (comparator
* reset) for the chain delay; then mclk = 1 (evaluate) until the next rising edge. mclkb = NOT mclk.
* clk30 low half: x = 1 after the falling edge -> NAND output = 1 (evaluate continues). Width: README.
* ---------------------------------------------------------------------------------------------
.subckt r1_cmp4_clkgen clk30 mclk mclkb vdd gnd
XPD0 d0 clk30 vdd vdd sg13_lv_pmos w=1u l=0.5u ng=1 m=1
XND0 d0 clk30 gnd gnd sg13_lv_nmos w=0.5u l=0.5u ng=1 m=1
CD0 d0 gnd 10f
XPD1 d1 d0 vdd vdd sg13_lv_pmos w=1u l=0.5u ng=1 m=1
XND1 d1 d0 gnd gnd sg13_lv_nmos w=0.5u l=0.5u ng=1 m=1
CD1 d1 gnd 10f
XPD2 d2 d1 vdd vdd sg13_lv_pmos w=1u l=0.5u ng=1 m=1
XND2 d2 d1 gnd gnd sg13_lv_nmos w=0.5u l=0.5u ng=1 m=1
CD2 d2 gnd 10f
XPD3 d3 d2 vdd vdd sg13_lv_pmos w=1u l=0.5u ng=1 m=1
XND3 d3 d2 gnd gnd sg13_lv_nmos w=0.5u l=0.5u ng=1 m=1
CD3 d3 gnd 10f
XPD4 x d3 vdd vdd sg13_lv_pmos w=1u l=0.5u ng=1 m=1
XND4 x d3 gnd gnd sg13_lv_nmos w=0.5u l=0.5u ng=1 m=1
CD4 x gnd 10f
XPA mclk clk30 vdd vdd sg13_lv_pmos w=2u l=0.13u ng=1 m=1
XPB mclk x vdd vdd sg13_lv_pmos w=2u l=0.13u ng=1 m=1
XNA mclk clk30 nn gnd sg13_lv_nmos w=2u l=0.13u ng=1 m=1
XNB nn x gnd gnd sg13_lv_nmos w=2u l=0.13u ng=1 m=1
XPI mclkb mclk vdd vdd sg13_lv_pmos w=2u l=0.13u ng=1 m=1
XNI mclkb mclk gnd gnd sg13_lv_nmos w=1u l=0.13u ng=1 m=1
.ends r1_cmp4_clkgen

* ---------------------------------------------------------------------------------------------
* r1_th4: one revision-4 track-and-hold slice (CDAC P and N, top-plate sampling, 13 caps per side).
* in0 sampled while trk0=1, in1 while trk1=1 (never both); sample on the falling edge. lsb nodes reset
* to VREF while either path tracks. cpK/cnK = 1: bottom plate K of side P/N goes VREF -> GND.
* Full variant: both input pairs with complete bootstrapped switches; transistor drivers r1_drv.
* ---------------------------------------------------------------------------------------------
.subckt r1_th4 in0p in0n in1p in1n trk0 trk1 top_p top_n cp12 cp11 cp10 cp9 cp8 cp7 cp6 cp5 cp4 cp3 cp2 cp1 cp0 cn12 cn11 cn10 cn9 cn8 cn7 cn6 cn5 cn4 cn3 cn2 cn1 cn0 vdd vref vrefl gnd
XPT0a t0b trk0 vdd vdd sg13_lv_pmos w=2u l=0.13u ng=1 m=1
XNT0a t0b trk0 gnd gnd sg13_lv_nmos w=1u l=0.13u ng=1 m=1
XPT0b t0 t0b vdd vdd sg13_lv_pmos w=4u l=0.13u ng=1 m=1
XNT0b t0 t0b gnd gnd sg13_lv_nmos w=2u l=0.13u ng=1 m=1
XPT1a t1b trk1 vdd vdd sg13_lv_pmos w=2u l=0.13u ng=1 m=1
XNT1a t1b trk1 gnd gnd sg13_lv_nmos w=1u l=0.13u ng=1 m=1
XPT1b t1 t1b vdd vdd sg13_lv_pmos w=4u l=0.13u ng=1 m=1
XNT1b t1 t1b gnd gnd sg13_lv_nmos w=2u l=0.13u ng=1 m=1
XS0P in0p top_p t0 t0b vdd gnd r1_bootsw
XS0N in0n top_n t0 t0b vdd gnd r1_bootsw
XS1P in1p top_p t1 t1b vdd gnd r1_bootsw
XS1N in1n top_n t1 t1b vdd gnd r1_bootsw
XPR1 rstb_n t0b vdd vdd sg13_lv_pmos w=1u l=0.13u ng=1 m=1
XPR2 rstb_n t1b vdd vdd sg13_lv_pmos w=1u l=0.13u ng=1 m=1
XNR1 rstb_n t0b nr gnd sg13_lv_nmos w=1u l=0.13u ng=1 m=1
XNR2 nr t1b gnd gnd sg13_lv_nmos w=1u l=0.13u ng=1 m=1
XPR3 rstb rstb_n vdd vdd sg13_lv_pmos w=1u l=0.13u ng=1 m=1
XNR3 rstb rstb_n gnd gnd sg13_lv_nmos w=0.5u l=0.13u ng=1 m=1
XLRP lsb_p rstb vrefl vrefl sg13_lv_pmos w=1u l=0.13u ng=1 m=1
XLRN lsb_n rstb vrefl vrefl sg13_lv_pmos w=1u l=0.13u ng=1 m=1
XDACP top_p lsb_p bp12 bp11 bp10 bp9 bp8 bp7 bp6 bp5 bp4 bp3 bp2 bp1 bp0 r1_cdac3_side
XDACN top_n lsb_n bn12 bn11 bn10 bn9 bn8 bn7 bn6 bn5 bn4 bn3 bn2 bn1 bn0 r1_cdac3_side
XDp12 cp12 bp12 vref gnd r1_drv wp=2u wn=1u
XDp11 cp11 bp11 vref gnd r1_drv wp=2u wn=1u
XDp10 cp10 bp10 vref gnd r1_drv wp=2u wn=1u
XDp9 cp9 bp9 vref gnd r1_drv wp=1u wn=0.5u
XDp8 cp8 bp8 vref gnd r1_drv wp=1u wn=0.5u
XDp7 cp7 bp7 vrefl gnd r1_drv wp=1u wn=0.5u
XDp6 cp6 bp6 vrefl gnd r1_drv wp=1u wn=0.5u
XDp5 cp5 bp5 vrefl gnd r1_drv wp=1u wn=0.5u
XDp4 cp4 bp4 vrefl gnd r1_drv wp=1u wn=0.5u
XDp3 cp3 bp3 vrefl gnd r1_drv wp=1u wn=0.5u
XDp2 cp2 bp2 vrefl gnd r1_drv wp=1u wn=0.5u
XDp1 cp1 bp1 vrefl gnd r1_drv wp=1u wn=0.5u
XDp0 cp0 bp0 vrefl gnd r1_drv wp=1u wn=0.5u
XDn12 cn12 bn12 vref gnd r1_drv wp=2u wn=1u
XDn11 cn11 bn11 vref gnd r1_drv wp=2u wn=1u
XDn10 cn10 bn10 vref gnd r1_drv wp=2u wn=1u
XDn9 cn9 bn9 vref gnd r1_drv wp=1u wn=0.5u
XDn8 cn8 bn8 vref gnd r1_drv wp=1u wn=0.5u
XDn7 cn7 bn7 vrefl gnd r1_drv wp=1u wn=0.5u
XDn6 cn6 bn6 vrefl gnd r1_drv wp=1u wn=0.5u
XDn5 cn5 bn5 vrefl gnd r1_drv wp=1u wn=0.5u
XDn4 cn4 bn4 vrefl gnd r1_drv wp=1u wn=0.5u
XDn3 cn3 bn3 vrefl gnd r1_drv wp=1u wn=0.5u
XDn2 cn2 bn2 vrefl gnd r1_drv wp=1u wn=0.5u
XDn1 cn1 bn1 vrefl gnd r1_drv wp=1u wn=0.5u
XDn0 cn0 bn0 vrefl gnd r1_drv wp=1u wn=0.5u
* revision 4: LSB-array drivers C7..C0 and the lsb-node reset on vrefl
.ends r1_th4

* ---------------------------------------------------------------------------------------------
* r1_th4_fast: one revision-4 track-and-hold slice (CDAC P and N, top-plate sampling, 13 caps per side).
* in0 sampled while trk0=1, in1 while trk1=1 (never both); sample on the falling edge. lsb nodes reset
* to VREF while either path tracks. cpK/cnK = 1: bottom plate K of side P/N goes VREF -> GND.
* Fast variant: in1 pair reduced to r1_offsw, trk1 unused; drivers r1_drv_sw (ideal 400 ohm).
* ---------------------------------------------------------------------------------------------
.subckt r1_th4_fast in0p in0n in1p in1n trk0 trk1 top_p top_n cp12 cp11 cp10 cp9 cp8 cp7 cp6 cp5 cp4 cp3 cp2 cp1 cp0 cn12 cn11 cn10 cn9 cn8 cn7 cn6 cn5 cn4 cn3 cn2 cn1 cn0 vdd vref vrefl gnd
XPT0a t0b trk0 vdd vdd sg13_lv_pmos w=2u l=0.13u ng=1 m=1
XNT0a t0b trk0 gnd gnd sg13_lv_nmos w=1u l=0.13u ng=1 m=1
XPT0b t0 t0b vdd vdd sg13_lv_pmos w=4u l=0.13u ng=1 m=1
XNT0b t0 t0b gnd gnd sg13_lv_nmos w=2u l=0.13u ng=1 m=1
XS0P in0p top_p t0 t0b vdd gnd r1_bootsw
XS0N in0n top_n t0 t0b vdd gnd r1_bootsw
XS1P in1p top_p gnd r1_offsw
XS1N in1n top_n gnd r1_offsw
Rtrk1 trk1 gnd 1e9
XLRP lsb_p t0b vrefl vrefl sg13_lv_pmos w=1u l=0.13u ng=1 m=1
XLRN lsb_n t0b vrefl vrefl sg13_lv_pmos w=1u l=0.13u ng=1 m=1
XDACP top_p lsb_p bp12 bp11 bp10 bp9 bp8 bp7 bp6 bp5 bp4 bp3 bp2 bp1 bp0 r1_cdac3_side
XDACN top_n lsb_n bn12 bn11 bn10 bn9 bn8 bn7 bn6 bn5 bn4 bn3 bn2 bn1 bn0 r1_cdac3_side
XDp12 cp12 bp12 vref gnd r1_drv_sw
XDp11 cp11 bp11 vref gnd r1_drv_sw
XDp10 cp10 bp10 vref gnd r1_drv_sw
XDp9 cp9 bp9 vref gnd r1_drv_sw
XDp8 cp8 bp8 vref gnd r1_drv_sw
XDp7 cp7 bp7 vrefl gnd r1_drv_sw
XDp6 cp6 bp6 vrefl gnd r1_drv_sw
XDp5 cp5 bp5 vrefl gnd r1_drv_sw
XDp4 cp4 bp4 vrefl gnd r1_drv_sw
XDp3 cp3 bp3 vrefl gnd r1_drv_sw
XDp2 cp2 bp2 vrefl gnd r1_drv_sw
XDp1 cp1 bp1 vrefl gnd r1_drv_sw
XDp0 cp0 bp0 vrefl gnd r1_drv_sw
XDn12 cn12 bn12 vref gnd r1_drv_sw
XDn11 cn11 bn11 vref gnd r1_drv_sw
XDn10 cn10 bn10 vref gnd r1_drv_sw
XDn9 cn9 bn9 vref gnd r1_drv_sw
XDn8 cn8 bn8 vref gnd r1_drv_sw
XDn7 cn7 bn7 vrefl gnd r1_drv_sw
XDn6 cn6 bn6 vrefl gnd r1_drv_sw
XDn5 cn5 bn5 vrefl gnd r1_drv_sw
XDn4 cn4 bn4 vrefl gnd r1_drv_sw
XDn3 cn3 bn3 vrefl gnd r1_drv_sw
XDn2 cn2 bn2 vrefl gnd r1_drv_sw
XDn1 cn1 bn1 vrefl gnd r1_drv_sw
XDn0 cn0 bn0 vrefl gnd r1_drv_sw
* revision 4: LSB-array drivers C7..C0 and the lsb-node reset on vrefl
.ends r1_th4_fast

* ---------------------------------------------------------------------------------------------
* r1_th4_fast_mc: one revision-4 track-and-hold slice (CDAC P and N, top-plate sampling, 13 caps per side).
* in0 sampled while trk0=1, in1 while trk1=1 (never both); sample on the falling edge. lsb nodes reset
* to VREF while either path tracks. cpK/cnK = 1: bottom plate K of side P/N goes VREF -> GND.
* Fast variant: in1 pair reduced to r1_offsw, trk1 unused; drivers r1_drv_sw (ideal 400 ohm).
* ---------------------------------------------------------------------------------------------
.subckt r1_th4_fast_mc in0p in0n in1p in1n trk0 trk1 top_p top_n cp12 cp11 cp10 cp9 cp8 cp7 cp6 cp5 cp4 cp3 cp2 cp1 cp0 cn12 cn11 cn10 cn9 cn8 cn7 cn6 cn5 cn4 cn3 cn2 cn1 cn0 vdd vref vrefl gnd
XPT0a t0b trk0 vdd vdd sg13_lv_pmos w=2u l=0.13u ng=1 m=1
XNT0a t0b trk0 gnd gnd sg13_lv_nmos w=1u l=0.13u ng=1 m=1
XPT0b t0 t0b vdd vdd sg13_lv_pmos w=4u l=0.13u ng=1 m=1
XNT0b t0 t0b gnd gnd sg13_lv_nmos w=2u l=0.13u ng=1 m=1
XS0P in0p top_p t0 t0b vdd gnd r1_bootsw
XS0N in0n top_n t0 t0b vdd gnd r1_bootsw
XS1P in1p top_p gnd r1_offsw
XS1N in1n top_n gnd r1_offsw
Rtrk1 trk1 gnd 1e9
XLRP lsb_p t0b vrefl vrefl sg13_lv_pmos w=1u l=0.13u ng=1 m=1
XLRN lsb_n t0b vrefl vrefl sg13_lv_pmos w=1u l=0.13u ng=1 m=1
XDACP top_p lsb_p bp12 bp11 bp10 bp9 bp8 bp7 bp6 bp5 bp4 bp3 bp2 bp1 bp0 r1_cdac3_side_mc mm=1
XDACN top_n lsb_n bn12 bn11 bn10 bn9 bn8 bn7 bn6 bn5 bn4 bn3 bn2 bn1 bn0 r1_cdac3_side_mc mm=1
XDp12 cp12 bp12 vref gnd r1_drv_sw
XDp11 cp11 bp11 vref gnd r1_drv_sw
XDp10 cp10 bp10 vref gnd r1_drv_sw
XDp9 cp9 bp9 vref gnd r1_drv_sw
XDp8 cp8 bp8 vref gnd r1_drv_sw
XDp7 cp7 bp7 vrefl gnd r1_drv_sw
XDp6 cp6 bp6 vrefl gnd r1_drv_sw
XDp5 cp5 bp5 vrefl gnd r1_drv_sw
XDp4 cp4 bp4 vrefl gnd r1_drv_sw
XDp3 cp3 bp3 vrefl gnd r1_drv_sw
XDp2 cp2 bp2 vrefl gnd r1_drv_sw
XDp1 cp1 bp1 vrefl gnd r1_drv_sw
XDp0 cp0 bp0 vrefl gnd r1_drv_sw
XDn12 cn12 bn12 vref gnd r1_drv_sw
XDn11 cn11 bn11 vref gnd r1_drv_sw
XDn10 cn10 bn10 vref gnd r1_drv_sw
XDn9 cn9 bn9 vref gnd r1_drv_sw
XDn8 cn8 bn8 vref gnd r1_drv_sw
XDn7 cn7 bn7 vrefl gnd r1_drv_sw
XDn6 cn6 bn6 vrefl gnd r1_drv_sw
XDn5 cn5 bn5 vrefl gnd r1_drv_sw
XDn4 cn4 bn4 vrefl gnd r1_drv_sw
XDn3 cn3 bn3 vrefl gnd r1_drv_sw
XDn2 cn2 bn2 vrefl gnd r1_drv_sw
XDn1 cn1 bn1 vrefl gnd r1_drv_sw
XDn0 cn0 bn0 vrefl gnd r1_drv_sw
* revision 4: LSB-array drivers C7..C0 and the lsb-node reset on vrefl
.ends r1_th4_fast_mc

* ---------------------------------------------------------------------------------------------
* r1_sar5_logic (revision 5: decision 0 from the NMOS comparator r1_cmp5n, clocks clkn*): XSPICE SAR registers, 14 decisions, one register per slice (D17/D18: both slices convert
* in parallel, own comparator and own register). Timing inputs from r1_ctrl (ideal in the decks): mclk
* (from r1_cmp4_clkgen), wina/winb (conversion windows), stba0..13 / stbb0..13 (decision strobes, one set
* per slice: slice B may run N ticks after slice A), lata/latb, track signals (flag reset while tracking).
* Per decision: P <= outp at stb, V <= 1 at stb, N = V AND NOT P (exactly one side switches).
* Raw bits rX13..rX0 (rX13 = first decision) latched at latX.
* ---------------------------------------------------------------------------------------------
.subckt r1_sar5_logic oap oan obp obn oanp obnp mclk wina winb trka0 trka1 trkb0 trkb1 lata latb stba0 stba1 stba2 stba3 stba4 stba5 stba6 stba7 stba8 stba9 stba10 stba11 stba12 stba13 stbb0 stbb1 stbb2 stbb3 stbb4 stbb5 stbb6 stbb7 stbb8 stbb9 stbb10 stbb11 stbb12 stbb13 clka clkab clkb clkbb clkna clknab clknb clknbb cpa12 cpa11 cpa10 cpa9 cpa8 cpa7 cpa6 cpa5 cpa4 cpa3 cpa2 cpa1 cpa0 cna12 cna11 cna10 cna9 cna8 cna7 cna6 cna5 cna4 cna3 cna2 cna1 cna0 cpb12 cpb11 cpb10 cpb9 cpb8 cpb7 cpb6 cpb5 cpb4 cpb3 cpb2 cpb1 cpb0 cnb12 cnb11 cnb10 cnb9 cnb8 cnb7 cnb6 cnb5 cnb4 cnb3 cnb2 cnb1 cnb0 rawa rawb vdd gnd
.model r1_adcb adc_bridge(in_low=0.6 in_high=0.6 rise_delay=20p fall_delay=20p)
.model r1_dacb dac_bridge(out_low=0 out_high=1.2 out_undef=0.6 input_load=1e-15 t_rise=80p t_fall=80p)
.model r1_dff d_dff(clk_delay=80p set_delay=80p reset_delay=80p ic=0 rise_delay=20p fall_delay=20p)
.model r1_and d_and(rise_delay=30p fall_delay=30p)
.model r1_nand d_nand(rise_delay=30p fall_delay=30p)
.model r1_or d_or(rise_delay=30p fall_delay=30p)
ABR [vdd oap oan obp obn oanp obnp mclk wina winb trka0 trka1 trkb0 trkb1 lata latb stba0 stba1 stba2 stba3 stba4 stba5 stba6 stba7 stba8 stba9 stba10 stba11 stba12 stba13 stbb0 stbb1 stbb2 stbb3 stbb4 stbb5 stbb6 stbb7 stbb8 stbb9 stbb10 stbb11 stbb12 stbb13] [d_vdd d_oap d_oan d_obp d_obn d_oanp d_obnp d_mclk d_wina d_winb d_trka0 d_trka1 d_trkb0 d_trkb1 d_lata d_latb d_stba0 d_stba1 d_stba2 d_stba3 d_stba4 d_stba5 d_stba6 d_stba7 d_stba8 d_stba9 d_stba10 d_stba11 d_stba12 d_stba13 d_stbb0 d_stbb1 d_stbb2 d_stbb3 d_stbb4 d_stbb5 d_stbb6 d_stbb7 d_stbb8 d_stbb9 d_stbb10 d_stbb11 d_stbb12 d_stbb13] r1_adcb
AGA1 [d_mclk d_wina] g_clka r1_and
AGA2 [d_mclk d_wina] g_clkab r1_nand
AGB1 [d_mclk d_winb] g_clkb r1_and
AGB2 [d_mclk d_winb] g_clkbb r1_nand
* revision 5: NMOS comparator clock, open only while decision 0 is open (V flag of decision 0 = 0)
AGNA1 [d_mclk d_wina nfva0] g_clkna r1_and
AGNA2 [d_mclk d_wina nfva0] g_clknab r1_nand
AGNB1 [d_mclk d_winb nfvb0] g_clknb r1_and
AGNB2 [d_mclk d_winb nfvb0] g_clknbb r1_nand
AORA [d_trka0 d_trka1] d_rsta r1_or
AORB [d_trkb0 d_trkb1] d_rstb r1_or
AFPa0 d_oanp d_stba0 NULL d_rsta fpa0 nfpa0 r1_dff
AFVa0 d_vdd d_stba0 NULL d_rsta fva0 nfva0 r1_dff
AFNa0 [fva0 nfpa0] fna0 r1_and
AQa0 fpa0 d_lata NULL NULL qa0 nqa0 r1_dff
AFPa1 d_oap d_stba1 NULL d_rsta fpa1 nfpa1 r1_dff
AFVa1 d_vdd d_stba1 NULL d_rsta fva1 nfva1 r1_dff
AFNa1 [fva1 nfpa1] fna1 r1_and
AQa1 fpa1 d_lata NULL NULL qa1 nqa1 r1_dff
AFPa2 d_oap d_stba2 NULL d_rsta fpa2 nfpa2 r1_dff
AFVa2 d_vdd d_stba2 NULL d_rsta fva2 nfva2 r1_dff
AFNa2 [fva2 nfpa2] fna2 r1_and
AQa2 fpa2 d_lata NULL NULL qa2 nqa2 r1_dff
AFPa3 d_oap d_stba3 NULL d_rsta fpa3 nfpa3 r1_dff
AFVa3 d_vdd d_stba3 NULL d_rsta fva3 nfva3 r1_dff
AFNa3 [fva3 nfpa3] fna3 r1_and
AQa3 fpa3 d_lata NULL NULL qa3 nqa3 r1_dff
AFPa4 d_oap d_stba4 NULL d_rsta fpa4 nfpa4 r1_dff
AFVa4 d_vdd d_stba4 NULL d_rsta fva4 nfva4 r1_dff
AFNa4 [fva4 nfpa4] fna4 r1_and
AQa4 fpa4 d_lata NULL NULL qa4 nqa4 r1_dff
AFPa5 d_oap d_stba5 NULL d_rsta fpa5 nfpa5 r1_dff
AFVa5 d_vdd d_stba5 NULL d_rsta fva5 nfva5 r1_dff
AFNa5 [fva5 nfpa5] fna5 r1_and
AQa5 fpa5 d_lata NULL NULL qa5 nqa5 r1_dff
AFPa6 d_oap d_stba6 NULL d_rsta fpa6 nfpa6 r1_dff
AFVa6 d_vdd d_stba6 NULL d_rsta fva6 nfva6 r1_dff
AFNa6 [fva6 nfpa6] fna6 r1_and
AQa6 fpa6 d_lata NULL NULL qa6 nqa6 r1_dff
AFPa7 d_oap d_stba7 NULL d_rsta fpa7 nfpa7 r1_dff
AFVa7 d_vdd d_stba7 NULL d_rsta fva7 nfva7 r1_dff
AFNa7 [fva7 nfpa7] fna7 r1_and
AQa7 fpa7 d_lata NULL NULL qa7 nqa7 r1_dff
AFPa8 d_oap d_stba8 NULL d_rsta fpa8 nfpa8 r1_dff
AFVa8 d_vdd d_stba8 NULL d_rsta fva8 nfva8 r1_dff
AFNa8 [fva8 nfpa8] fna8 r1_and
AQa8 fpa8 d_lata NULL NULL qa8 nqa8 r1_dff
AFPa9 d_oap d_stba9 NULL d_rsta fpa9 nfpa9 r1_dff
AFVa9 d_vdd d_stba9 NULL d_rsta fva9 nfva9 r1_dff
AFNa9 [fva9 nfpa9] fna9 r1_and
AQa9 fpa9 d_lata NULL NULL qa9 nqa9 r1_dff
AFPa10 d_oap d_stba10 NULL d_rsta fpa10 nfpa10 r1_dff
AFVa10 d_vdd d_stba10 NULL d_rsta fva10 nfva10 r1_dff
AFNa10 [fva10 nfpa10] fna10 r1_and
AQa10 fpa10 d_lata NULL NULL qa10 nqa10 r1_dff
AFPa11 d_oap d_stba11 NULL d_rsta fpa11 nfpa11 r1_dff
AFVa11 d_vdd d_stba11 NULL d_rsta fva11 nfva11 r1_dff
AFNa11 [fva11 nfpa11] fna11 r1_and
AQa11 fpa11 d_lata NULL NULL qa11 nqa11 r1_dff
AFPa12 d_oap d_stba12 NULL d_rsta fpa12 nfpa12 r1_dff
AFVa12 d_vdd d_stba12 NULL d_rsta fva12 nfva12 r1_dff
AFNa12 [fva12 nfpa12] fna12 r1_and
AQa12 fpa12 d_lata NULL NULL qa12 nqa12 r1_dff
AFPa13 d_oap d_stba13 NULL d_rsta fpa13 nfpa13 r1_dff
AQa13 fpa13 d_lata NULL NULL qa13 nqa13 r1_dff
AFPb0 d_obnp d_stbb0 NULL d_rstb fpb0 nfpb0 r1_dff
AFVb0 d_vdd d_stbb0 NULL d_rstb fvb0 nfvb0 r1_dff
AFNb0 [fvb0 nfpb0] fnb0 r1_and
AQb0 fpb0 d_latb NULL NULL qb0 nqb0 r1_dff
AFPb1 d_obp d_stbb1 NULL d_rstb fpb1 nfpb1 r1_dff
AFVb1 d_vdd d_stbb1 NULL d_rstb fvb1 nfvb1 r1_dff
AFNb1 [fvb1 nfpb1] fnb1 r1_and
AQb1 fpb1 d_latb NULL NULL qb1 nqb1 r1_dff
AFPb2 d_obp d_stbb2 NULL d_rstb fpb2 nfpb2 r1_dff
AFVb2 d_vdd d_stbb2 NULL d_rstb fvb2 nfvb2 r1_dff
AFNb2 [fvb2 nfpb2] fnb2 r1_and
AQb2 fpb2 d_latb NULL NULL qb2 nqb2 r1_dff
AFPb3 d_obp d_stbb3 NULL d_rstb fpb3 nfpb3 r1_dff
AFVb3 d_vdd d_stbb3 NULL d_rstb fvb3 nfvb3 r1_dff
AFNb3 [fvb3 nfpb3] fnb3 r1_and
AQb3 fpb3 d_latb NULL NULL qb3 nqb3 r1_dff
AFPb4 d_obp d_stbb4 NULL d_rstb fpb4 nfpb4 r1_dff
AFVb4 d_vdd d_stbb4 NULL d_rstb fvb4 nfvb4 r1_dff
AFNb4 [fvb4 nfpb4] fnb4 r1_and
AQb4 fpb4 d_latb NULL NULL qb4 nqb4 r1_dff
AFPb5 d_obp d_stbb5 NULL d_rstb fpb5 nfpb5 r1_dff
AFVb5 d_vdd d_stbb5 NULL d_rstb fvb5 nfvb5 r1_dff
AFNb5 [fvb5 nfpb5] fnb5 r1_and
AQb5 fpb5 d_latb NULL NULL qb5 nqb5 r1_dff
AFPb6 d_obp d_stbb6 NULL d_rstb fpb6 nfpb6 r1_dff
AFVb6 d_vdd d_stbb6 NULL d_rstb fvb6 nfvb6 r1_dff
AFNb6 [fvb6 nfpb6] fnb6 r1_and
AQb6 fpb6 d_latb NULL NULL qb6 nqb6 r1_dff
AFPb7 d_obp d_stbb7 NULL d_rstb fpb7 nfpb7 r1_dff
AFVb7 d_vdd d_stbb7 NULL d_rstb fvb7 nfvb7 r1_dff
AFNb7 [fvb7 nfpb7] fnb7 r1_and
AQb7 fpb7 d_latb NULL NULL qb7 nqb7 r1_dff
AFPb8 d_obp d_stbb8 NULL d_rstb fpb8 nfpb8 r1_dff
AFVb8 d_vdd d_stbb8 NULL d_rstb fvb8 nfvb8 r1_dff
AFNb8 [fvb8 nfpb8] fnb8 r1_and
AQb8 fpb8 d_latb NULL NULL qb8 nqb8 r1_dff
AFPb9 d_obp d_stbb9 NULL d_rstb fpb9 nfpb9 r1_dff
AFVb9 d_vdd d_stbb9 NULL d_rstb fvb9 nfvb9 r1_dff
AFNb9 [fvb9 nfpb9] fnb9 r1_and
AQb9 fpb9 d_latb NULL NULL qb9 nqb9 r1_dff
AFPb10 d_obp d_stbb10 NULL d_rstb fpb10 nfpb10 r1_dff
AFVb10 d_vdd d_stbb10 NULL d_rstb fvb10 nfvb10 r1_dff
AFNb10 [fvb10 nfpb10] fnb10 r1_and
AQb10 fpb10 d_latb NULL NULL qb10 nqb10 r1_dff
AFPb11 d_obp d_stbb11 NULL d_rstb fpb11 nfpb11 r1_dff
AFVb11 d_vdd d_stbb11 NULL d_rstb fvb11 nfvb11 r1_dff
AFNb11 [fvb11 nfpb11] fnb11 r1_and
AQb11 fpb11 d_latb NULL NULL qb11 nqb11 r1_dff
AFPb12 d_obp d_stbb12 NULL d_rstb fpb12 nfpb12 r1_dff
AFVb12 d_vdd d_stbb12 NULL d_rstb fvb12 nfvb12 r1_dff
AFNb12 [fvb12 nfpb12] fnb12 r1_and
AQb12 fpb12 d_latb NULL NULL qb12 nqb12 r1_dff
AFPb13 d_obp d_stbb13 NULL d_rstb fpb13 nfpb13 r1_dff
AQb13 fpb13 d_latb NULL NULL qb13 nqb13 r1_dff
ADB [g_clka g_clkab g_clkb g_clkbb g_clkna g_clknab g_clknb g_clknbb fpa0 fna0 fpa1 fna1 fpa2 fna2 fpa3 fna3 fpa4 fna4 fpa5 fna5 fpa6 fna6 fpa7 fna7 fpa8 fna8 fpa9 fna9 fpa10 fna10 fpa11 fna11 fpa12 fna12 qa0 qa1 qa2 qa3 qa4 qa5 qa6 qa7 qa8 qa9 qa10 qa11 qa12 qa13 fpb0 fnb0 fpb1 fnb1 fpb2 fnb2 fpb3 fnb3 fpb4 fnb4 fpb5 fnb5 fpb6 fnb6 fpb7 fnb7 fpb8 fnb8 fpb9 fnb9 fpb10 fnb10 fpb11 fnb11 fpb12 fnb12 qb0 qb1 qb2 qb3 qb4 qb5 qb6 qb7 qb8 qb9 qb10 qb11 qb12 qb13] [clka clkab clkb clkbb clkna clknab clknb clknbb cpa12 cna12 cpa11 cna11 cpa10 cna10 cpa9 cna9 cpa8 cna8 cpa7 cna7 cpa6 cna6 cpa5 cna5 cpa4 cna4 cpa3 cna3 cpa2 cna2 cpa1 cna1 cpa0 cna0 ra13 ra12 ra11 ra10 ra9 ra8 ra7 ra6 ra5 ra4 ra3 ra2 ra1 ra0 cpb12 cnb12 cpb11 cnb11 cpb10 cnb10 cpb9 cnb9 cpb8 cnb8 cpb7 cnb7 cpb6 cnb6 cpb5 cnb5 cpb4 cnb4 cpb3 cnb3 cpb2 cnb2 cpb1 cnb1 cpb0 cnb0 rb13 rb12 rb11 rb10 rb9 rb8 rb7 rb6 rb5 rb4 rb3 rb2 rb1 rb0] r1_dacb
Brawa rawa gnd v=(1*v(ra0)+2*v(ra1)+4*v(ra2)+8*v(ra3)+16*v(ra4)+32*v(ra5)+64*v(ra6)+128*v(ra7)+256*v(ra8)+512*v(ra9)+1024*v(ra10)+2048*v(ra11)+4096*v(ra12)+8192*v(ra13))/1.2
Brawb rawb gnd v=(1*v(rb0)+2*v(rb1)+4*v(rb2)+8*v(rb3)+16*v(rb4)+32*v(rb5)+64*v(rb6)+128*v(rb7)+256*v(rb8)+512*v(rb9)+1024*v(rb10)+2048*v(rb11)+4096*v(rb12)+8192*v(rb13))/1.2
.ends r1_sar5_logic

* ---------------------------------------------------------------------------------------------
* r1_adc5_core: R1 ADC revision-5 core. Slice A: in0 = SIN, in1 = ISA. Slice B: in0 = COS, in1 = ISB.
* Both slices convert in parallel (D18), one decision per clk30 tick. Decision 0: NMOS-input r1_cmp5n;
* decisions 1..13: PMOS-input r1_cmp4. Per-slice reference ports: vrefX (C12..C8 and C7..C0 drivers of the
* revision-4 split: MSB array) and vreflX (LSB array C7..C0 and lsb-node reset). Tie for one reference.
* ---------------------------------------------------------------------------------------------
.subckt r1_adc5_core sinp sinn cosp cosn isap isan isbp isbn trka0 trka1 trkb0 trkb1 clk30 wina winb lata latb stba0 stba1 stba2 stba3 stba4 stba5 stba6 stba7 stba8 stba9 stba10 stba11 stba12 stba13 stbb0 stbb1 stbb2 stbb3 stbb4 stbb5 stbb6 stbb7 stbb8 stbb9 stbb10 stbb11 stbb12 stbb13 rawa rawb topap topan topbp topbn vdd vrefa vrefb vrefla vreflb gnd
XCKG clk30 mclk mclkb vdd gnd r1_cmp4_clkgen
XTHA sinp sinn isap isan trka0 trka1 topap topan cpa12 cpa11 cpa10 cpa9 cpa8 cpa7 cpa6 cpa5 cpa4 cpa3 cpa2 cpa1 cpa0 cna12 cna11 cna10 cna9 cna8 cna7 cna6 cna5 cna4 cna3 cna2 cna1 cna0 vdd vrefa vrefla gnd r1_th4
XCBIAS vbp vdd gnd r1_cmp4_bias
XCBIASN vbn vdd gnd r1_cmp5n_bias
XCMPA topap topan clka clkab oap oan vbp vdd gnd r1_cmp4
XCMPNA topap topan clkna clknab oanp oann vbn vdd gnd r1_cmp5n
XTHB cosp cosn isbp isbn trkb0 trkb1 topbp topbn cpb12 cpb11 cpb10 cpb9 cpb8 cpb7 cpb6 cpb5 cpb4 cpb3 cpb2 cpb1 cpb0 cnb12 cnb11 cnb10 cnb9 cnb8 cnb7 cnb6 cnb5 cnb4 cnb3 cnb2 cnb1 cnb0 vdd vrefb vreflb gnd r1_th4
XCMPB topbp topbn clkb clkbb obp obn vbp vdd gnd r1_cmp4
XCMPNB topbp topbn clknb clknbb obnp obnn vbn vdd gnd r1_cmp5n
XSAR oap oan obp obn oanp obnp mclk wina winb trka0 trka1 trkb0 trkb1 lata latb stba0 stba1 stba2 stba3 stba4 stba5 stba6 stba7 stba8 stba9 stba10 stba11 stba12 stba13 stbb0 stbb1 stbb2 stbb3 stbb4 stbb5 stbb6 stbb7 stbb8 stbb9 stbb10 stbb11 stbb12 stbb13 clka clkab clkb clkbb clkna clknab clknb clknbb cpa12 cpa11 cpa10 cpa9 cpa8 cpa7 cpa6 cpa5 cpa4 cpa3 cpa2 cpa1 cpa0 cna12 cna11 cna10 cna9 cna8 cna7 cna6 cna5 cna4 cna3 cna2 cna1 cna0 cpb12 cpb11 cpb10 cpb9 cpb8 cpb7 cpb6 cpb5 cpb4 cpb3 cpb2 cpb1 cpb0 cnb12 cnb11 cnb10 cnb9 cnb8 cnb7 cnb6 cnb5 cnb4 cnb3 cnb2 cnb1 cnb0 rawa rawb vdd gnd r1_sar5_logic
.ends r1_adc5_core

* ---------------------------------------------------------------------------------------------
* r1_adc5_core_fast: R1 ADC revision-5 core. Slice A: in0 = SIN, in1 = ISA. Slice B: in0 = COS, in1 = ISB.
* Both slices convert in parallel (D18), one decision per clk30 tick. Decision 0: NMOS-input r1_cmp5n;
* decisions 1..13: PMOS-input r1_cmp4. Per-slice reference ports: vrefX (C12..C8 and C7..C0 drivers of the
* revision-4 split: MSB array) and vreflX (LSB array C7..C0 and lsb-node reset). Tie for one reference.
* ---------------------------------------------------------------------------------------------
.subckt r1_adc5_core_fast sinp sinn cosp cosn isap isan isbp isbn trka0 trka1 trkb0 trkb1 clk30 wina winb lata latb stba0 stba1 stba2 stba3 stba4 stba5 stba6 stba7 stba8 stba9 stba10 stba11 stba12 stba13 stbb0 stbb1 stbb2 stbb3 stbb4 stbb5 stbb6 stbb7 stbb8 stbb9 stbb10 stbb11 stbb12 stbb13 rawa rawb topap topan topbp topbn vdd vrefa vrefb vrefla vreflb gnd
XCKG clk30 mclk mclkb vdd gnd r1_cmp4_clkgen
XTHA sinp sinn isap isan trka0 trka1 topap topan cpa12 cpa11 cpa10 cpa9 cpa8 cpa7 cpa6 cpa5 cpa4 cpa3 cpa2 cpa1 cpa0 cna12 cna11 cna10 cna9 cna8 cna7 cna6 cna5 cna4 cna3 cna2 cna1 cna0 vdd vrefa vrefla gnd r1_th4_fast
XCBIAS vbp vdd gnd r1_cmp4_bias
XCBIASN vbn vdd gnd r1_cmp5n_bias
XCMPA topap topan clka clkab oap oan vbp vdd gnd r1_cmp4
XCMPNA topap topan clkna clknab oanp oann vbn vdd gnd r1_cmp5n
XTHB cosp cosn isbp isbn trkb0 trkb1 topbp topbn cpb12 cpb11 cpb10 cpb9 cpb8 cpb7 cpb6 cpb5 cpb4 cpb3 cpb2 cpb1 cpb0 cnb12 cnb11 cnb10 cnb9 cnb8 cnb7 cnb6 cnb5 cnb4 cnb3 cnb2 cnb1 cnb0 vdd vrefb vreflb gnd r1_th4_fast
XCMPB topbp topbn clkb clkbb obp obn vbp vdd gnd r1_cmp4
XCMPNB topbp topbn clknb clknbb obnp obnn vbn vdd gnd r1_cmp5n
XSAR oap oan obp obn oanp obnp mclk wina winb trka0 trka1 trkb0 trkb1 lata latb stba0 stba1 stba2 stba3 stba4 stba5 stba6 stba7 stba8 stba9 stba10 stba11 stba12 stba13 stbb0 stbb1 stbb2 stbb3 stbb4 stbb5 stbb6 stbb7 stbb8 stbb9 stbb10 stbb11 stbb12 stbb13 clka clkab clkb clkbb clkna clknab clknb clknbb cpa12 cpa11 cpa10 cpa9 cpa8 cpa7 cpa6 cpa5 cpa4 cpa3 cpa2 cpa1 cpa0 cna12 cna11 cna10 cna9 cna8 cna7 cna6 cna5 cna4 cna3 cna2 cna1 cna0 cpb12 cpb11 cpb10 cpb9 cpb8 cpb7 cpb6 cpb5 cpb4 cpb3 cpb2 cpb1 cpb0 cnb12 cnb11 cnb10 cnb9 cnb8 cnb7 cnb6 cnb5 cnb4 cnb3 cnb2 cnb1 cnb0 rawa rawb vdd gnd r1_sar5_logic
.ends r1_adc5_core_fast

* ---------------------------------------------------------------------------------------------
* r1_adc5_core_fast_mc: R1 ADC revision-5 core. Slice A: in0 = SIN, in1 = ISA. Slice B: in0 = COS, in1 = ISB.
* Both slices convert in parallel (D18), one decision per clk30 tick. Decision 0: NMOS-input r1_cmp5n;
* decisions 1..13: PMOS-input r1_cmp4. Per-slice reference ports: vrefX (C12..C8 and C7..C0 drivers of the
* revision-4 split: MSB array) and vreflX (LSB array C7..C0 and lsb-node reset). Tie for one reference.
* ---------------------------------------------------------------------------------------------
.subckt r1_adc5_core_fast_mc sinp sinn cosp cosn isap isan isbp isbn trka0 trka1 trkb0 trkb1 clk30 wina winb lata latb stba0 stba1 stba2 stba3 stba4 stba5 stba6 stba7 stba8 stba9 stba10 stba11 stba12 stba13 stbb0 stbb1 stbb2 stbb3 stbb4 stbb5 stbb6 stbb7 stbb8 stbb9 stbb10 stbb11 stbb12 stbb13 rawa rawb topap topan topbp topbn vdd vrefa vrefb vrefla vreflb gnd
XCKG clk30 mclk mclkb vdd gnd r1_cmp4_clkgen
XTHA sinp sinn isap isan trka0 trka1 topap topan cpa12 cpa11 cpa10 cpa9 cpa8 cpa7 cpa6 cpa5 cpa4 cpa3 cpa2 cpa1 cpa0 cna12 cna11 cna10 cna9 cna8 cna7 cna6 cna5 cna4 cna3 cna2 cna1 cna0 vdd vrefa vrefla gnd r1_th4_fast_mc
XCBIAS vbp vdd gnd r1_cmp4_bias
XCBIASN vbn vdd gnd r1_cmp5n_bias
XCMPA topap topan clka clkab oap oan vbp vdd gnd r1_cmp4
XCMPNA topap topan clkna clknab oanp oann vbn vdd gnd r1_cmp5n
XTHB cosp cosn isbp isbn trkb0 trkb1 topbp topbn cpb12 cpb11 cpb10 cpb9 cpb8 cpb7 cpb6 cpb5 cpb4 cpb3 cpb2 cpb1 cpb0 cnb12 cnb11 cnb10 cnb9 cnb8 cnb7 cnb6 cnb5 cnb4 cnb3 cnb2 cnb1 cnb0 vdd vrefb vreflb gnd r1_th4_fast_mc
XCMPB topbp topbn clkb clkbb obp obn vbp vdd gnd r1_cmp4
XCMPNB topbp topbn clknb clknbb obnp obnn vbn vdd gnd r1_cmp5n
XSAR oap oan obp obn oanp obnp mclk wina winb trka0 trka1 trkb0 trkb1 lata latb stba0 stba1 stba2 stba3 stba4 stba5 stba6 stba7 stba8 stba9 stba10 stba11 stba12 stba13 stbb0 stbb1 stbb2 stbb3 stbb4 stbb5 stbb6 stbb7 stbb8 stbb9 stbb10 stbb11 stbb12 stbb13 clka clkab clkb clkbb clkna clknab clknb clknbb cpa12 cpa11 cpa10 cpa9 cpa8 cpa7 cpa6 cpa5 cpa4 cpa3 cpa2 cpa1 cpa0 cna12 cna11 cna10 cna9 cna8 cna7 cna6 cna5 cna4 cna3 cna2 cna1 cna0 cpb12 cpb11 cpb10 cpb9 cpb8 cpb7 cpb6 cpb5 cpb4 cpb3 cpb2 cpb1 cpb0 cnb12 cnb11 cnb10 cnb9 cnb8 cnb7 cnb6 cnb5 cnb4 cnb3 cnb2 cnb1 cnb0 rawa rawb vdd gnd r1_sar5_logic
.ends r1_adc5_core_fast_mc

* r1_refbuf5h: revision-4 r1_refbuf4h (r1_refbuf4 without the input divider; error-amplifier gate on vbg,
* vref = vbg). Accepted baseline (coordinator 2026-10-21). Same devices as r1_refbuf4 otherwise.
.subckt r1_refbuf5h vbg vref vdda gnd msf=32 mib=160 ndec=6 ncg=1 mt=1 lt=8u
Ibias vdda nb 5u
XMB0 nb nb gnd gnd sg13_hv_nmos w=2u l=1u ng=1 m=1
XMT  ntl nb gnd gnd sg13_hv_nmos w=2u l={lt} ng=1 m={mt}
XM1  na  vbg ntl gnd sg13_hv_nmos w=10u l=1u ng=2 m=1
XM2  ng  vref ntl gnd sg13_hv_nmos w=10u l=1u ng=2 m=1
XM3  na  na  vdda vdda sg13_hv_pmos w=4u l=1u ng=1 m=1
XM4  ng  na  vdda vdda sg13_hv_pmos w=4u l=1u ng=1 m=1
XCG  ng  gnd cap_cmim w=50u l=50u m={ncg}
XMSF vdda ng vref gnd sg13_hv_nmos w=10u l=0.45u ng=4 m={msf}
XMIB vref nb gnd gnd sg13_hv_nmos w=2u l=1u ng=1 m={mib}
XCD  vref gnd cap_cmim w=70u l=70u m={ndec}
.ends r1_refbuf5h

* r1_refbuf5 (R2-4 option 3): r1_refbuf5h with a separate LSB-array reference vrefl from the same buffer.
* The LSB array (C7..C0, lsb-node reset) draws its switching charge from vrefl and its own decoupling;
* the main follower and the error amplifier see only the MSB array (C12..C8).
* Pin nb (T2 2026-10-21): bias current input (r1_bias ib_adc_ref, 5.07 uA at tt) into the diode XMB0.
.subckt r1_refbuf5 vbg vref vrefl nb vdda gnd msf=32 mib=160 ndec=6 ncg=1 mt=1 lt=8u msfl=8 mibl=40 ndecl=1
* nb: bias input, current sourced into the diode XMB0 by r1_bias (ib_adc_ref)
XMB0 nb nb gnd gnd sg13_hv_nmos w=2u l=1u ng=1 m=1
XMT  ntl nb gnd gnd sg13_hv_nmos w=2u l={lt} ng=1 m={mt}
XM1  na  vbg ntl gnd sg13_hv_nmos w=10u l=1u ng=2 m=1
XM2  ng  vref ntl gnd sg13_hv_nmos w=10u l=1u ng=2 m=1
XM3  na  na  vdda vdda sg13_hv_pmos w=4u l=1u ng=1 m=1
XM4  ng  na  vdda vdda sg13_hv_pmos w=4u l=1u ng=1 m=1
XCG  ng  gnd cap_cmim w=50u l=50u m={ncg}
XMSF vdda ng vref gnd sg13_hv_nmos w=10u l=0.45u ng=4 m={msf}
XMIB vref nb gnd gnd sg13_hv_nmos w=2u l=1u ng=1 m={mib}
XCD  vref gnd cap_cmim w=70u l=70u m={ndec}
* option 3: LSB-array sub-reference, a second source follower on the same gate node ng (no second
* loop: vrefl = ng - Vgs at the same current density as the main follower, msfl/mibl = msf/mib)
XMSFL vdda ng vrefl gnd sg13_hv_nmos w=10u l=0.45u ng=4 m={msfl}
XMIBL vrefl nb gnd gnd sg13_hv_nmos w=2u l=1u ng=1 m={mibl}
XCDL vrefl gnd cap_cmim w=70u l=70u m={ndecl}
.ends r1_refbuf5

* r1_refps5 (R2-4 option 2): per-slice decoupling capacitor. PMOS switch from the buffer output vin to the slice
* reference vout, closed while the slice tracks (trk0 OR trk1), open during its conversion; Cres = nres MIM
* cells of 70 x 70 um (7.36 pF each) on vout. Gate = NOR(trk0, trk1) (1.2 V domain).
.subckt r1_refps5 vin vout trk0 trk1 vdd gnd wsw=40u nres=3
XNP1 nx trk0 vdd vdd sg13_lv_pmos w=2u l=0.13u ng=1 m=1
XNP2 g trk1 nx vdd sg13_lv_pmos w=2u l=0.13u ng=1 m=1
XNN1 g trk0 gnd gnd sg13_lv_nmos w=1u l=0.13u ng=1 m=1
XNN2 g trk1 gnd gnd sg13_lv_nmos w=1u l=0.13u ng=1 m=1
XSW vout g vin vdd sg13_lv_pmos w={wsw} l=0.13u ng=8 m=1
XCR vout gnd cap_cmim w=70u l=70u m={nres}
.ends r1_refps5

* r1_reffilt5: reference input filter, MIM w x w from vbg to ground (with the r1_bgr source resistance).
.subckt r1_reffilt5 vbg gnd w=82u
XCF vbg gnd cap_cmim w={w} l={w} m=1
.ends r1_reffilt5

* =============================================================================================
* Revision 6 cells (PLAN.md D28, T2o 2026-10-28)
* =============================================================================================
* r1_cmp6_clkgen: r1_cmp4_clkgen with the delay-chain input on gnd (x = 1): mclk = NOT clk30. Reset (mclk = 0)
* from the rising clk30 edge to the falling edge, evaluate from the falling edge to the next rising edge.
.subckt r1_cmp6_clkgen clk30 mclk mclkb vdd gnd
XPD0 d0 gnd vdd vdd sg13_lv_pmos w=1u l=0.5u ng=1 m=1
XND0 d0 gnd gnd gnd sg13_lv_nmos w=0.5u l=0.5u ng=1 m=1
CD0 d0 gnd 10f
XPD1 d1 d0 vdd vdd sg13_lv_pmos w=1u l=0.5u ng=1 m=1
XND1 d1 d0 gnd gnd sg13_lv_nmos w=0.5u l=0.5u ng=1 m=1
CD1 d1 gnd 10f
XPD2 d2 d1 vdd vdd sg13_lv_pmos w=1u l=0.5u ng=1 m=1
XND2 d2 d1 gnd gnd sg13_lv_nmos w=0.5u l=0.5u ng=1 m=1
CD2 d2 gnd 10f
XPD3 d3 d2 vdd vdd sg13_lv_pmos w=1u l=0.5u ng=1 m=1
XND3 d3 d2 gnd gnd sg13_lv_nmos w=0.5u l=0.5u ng=1 m=1
CD3 d3 gnd 10f
XPD4 x d3 vdd vdd sg13_lv_pmos w=1u l=0.5u ng=1 m=1
XND4 x d3 gnd gnd sg13_lv_nmos w=0.5u l=0.5u ng=1 m=1
CD4 x gnd 10f
XPA mclk clk30 vdd vdd sg13_lv_pmos w=2u l=0.13u ng=1 m=1
XPB mclk x vdd vdd sg13_lv_pmos w=2u l=0.13u ng=1 m=1
XNA mclk clk30 nn gnd sg13_lv_nmos w=2u l=0.13u ng=1 m=1
XNB nn x gnd gnd sg13_lv_nmos w=2u l=0.13u ng=1 m=1
XPI mclkb mclk vdd vdd sg13_lv_pmos w=2u l=0.13u ng=1 m=1
XNI mclkb mclk gnd gnd sg13_lv_nmos w=1u l=0.13u ng=1 m=1
.ends r1_cmp6_clkgen

* r1_refbuf6: r1_refbuf5 with msfl 24 / mibl 120 (LSB-array follower and sink x3, same density; vrefl branch
* 600 uA at 5 uA bias). Same pins as r1_refbuf5. Layout: ndec 4, ndecl 2 as for r1_refbuf5.
.subckt r1_refbuf6 vbg vref vrefl nb vdda gnd msf=32 mib=160 ndec=6 ncg=1 mt=1 lt=8u msfl=24 mibl=120 ndecl=1
* nb: bias input, current sourced into the diode XMB0 by r1_bias (ib_adc_ref)
XMB0 nb nb gnd gnd sg13_hv_nmos w=2u l=1u ng=1 m=1
XMT  ntl nb gnd gnd sg13_hv_nmos w=2u l={lt} ng=1 m={mt}
XM1  na  vbg ntl gnd sg13_hv_nmos w=10u l=1u ng=2 m=1
XM2  ng  vref ntl gnd sg13_hv_nmos w=10u l=1u ng=2 m=1
XM3  na  na  vdda vdda sg13_hv_pmos w=4u l=1u ng=1 m=1
XM4  ng  na  vdda vdda sg13_hv_pmos w=4u l=1u ng=1 m=1
XCG  ng  gnd cap_cmim w=50u l=50u m={ncg}
XMSF vdda ng vref gnd sg13_hv_nmos w=10u l=0.45u ng=4 m={msf}
XMIB vref nb gnd gnd sg13_hv_nmos w=2u l=1u ng=1 m={mib}
XCD  vref gnd cap_cmim w=70u l=70u m={ndec}
* option 3: LSB-array sub-reference, a second source follower on the same gate node ng (no second
* loop: vrefl = ng - Vgs at the same current density as the main follower, msfl/mibl = msf/mib)
XMSFL vdda ng vrefl gnd sg13_hv_nmos w=10u l=0.45u ng=4 m={msfl}
XMIBL vrefl nb gnd gnd sg13_hv_nmos w=2u l=1u ng=1 m={mibl}
XCDL vrefl gnd cap_cmim w=70u l=70u m={ndecl}
.ends r1_refbuf6

* r1_adc6_core*: the revision-5 cores with r1_cmp6_clkgen (falling-edge strobe).
.subckt r1_adc6_core sinp sinn cosp cosn isap isan isbp isbn trka0 trka1 trkb0 trkb1 clk30 wina winb lata latb stba0 stba1 stba2 stba3 stba4 stba5 stba6 stba7 stba8 stba9 stba10 stba11 stba12 stba13 stbb0 stbb1 stbb2 stbb3 stbb4 stbb5 stbb6 stbb7 stbb8 stbb9 stbb10 stbb11 stbb12 stbb13 rawa rawb topap topan topbp topbn vdd vrefa vrefb vrefla vreflb gnd
XCKG clk30 mclk mclkb vdd gnd r1_cmp6_clkgen
XTHA sinp sinn isap isan trka0 trka1 topap topan cpa12 cpa11 cpa10 cpa9 cpa8 cpa7 cpa6 cpa5 cpa4 cpa3 cpa2 cpa1 cpa0 cna12 cna11 cna10 cna9 cna8 cna7 cna6 cna5 cna4 cna3 cna2 cna1 cna0 vdd vrefa vrefla gnd r1_th4
XCBIAS vbp vdd gnd r1_cmp4_bias
XCBIASN vbn vdd gnd r1_cmp5n_bias
XCMPA topap topan clka clkab oap oan vbp vdd gnd r1_cmp4
XCMPNA topap topan clkna clknab oanp oann vbn vdd gnd r1_cmp5n
XTHB cosp cosn isbp isbn trkb0 trkb1 topbp topbn cpb12 cpb11 cpb10 cpb9 cpb8 cpb7 cpb6 cpb5 cpb4 cpb3 cpb2 cpb1 cpb0 cnb12 cnb11 cnb10 cnb9 cnb8 cnb7 cnb6 cnb5 cnb4 cnb3 cnb2 cnb1 cnb0 vdd vrefb vreflb gnd r1_th4
XCMPB topbp topbn clkb clkbb obp obn vbp vdd gnd r1_cmp4
XCMPNB topbp topbn clknb clknbb obnp obnn vbn vdd gnd r1_cmp5n
XSAR oap oan obp obn oanp obnp mclk wina winb trka0 trka1 trkb0 trkb1 lata latb stba0 stba1 stba2 stba3 stba4 stba5 stba6 stba7 stba8 stba9 stba10 stba11 stba12 stba13 stbb0 stbb1 stbb2 stbb3 stbb4 stbb5 stbb6 stbb7 stbb8 stbb9 stbb10 stbb11 stbb12 stbb13 clka clkab clkb clkbb clkna clknab clknb clknbb cpa12 cpa11 cpa10 cpa9 cpa8 cpa7 cpa6 cpa5 cpa4 cpa3 cpa2 cpa1 cpa0 cna12 cna11 cna10 cna9 cna8 cna7 cna6 cna5 cna4 cna3 cna2 cna1 cna0 cpb12 cpb11 cpb10 cpb9 cpb8 cpb7 cpb6 cpb5 cpb4 cpb3 cpb2 cpb1 cpb0 cnb12 cnb11 cnb10 cnb9 cnb8 cnb7 cnb6 cnb5 cnb4 cnb3 cnb2 cnb1 cnb0 rawa rawb vdd gnd r1_sar5_logic
.ends r1_adc6_core

.subckt r1_adc6_core_fast sinp sinn cosp cosn isap isan isbp isbn trka0 trka1 trkb0 trkb1 clk30 wina winb lata latb stba0 stba1 stba2 stba3 stba4 stba5 stba6 stba7 stba8 stba9 stba10 stba11 stba12 stba13 stbb0 stbb1 stbb2 stbb3 stbb4 stbb5 stbb6 stbb7 stbb8 stbb9 stbb10 stbb11 stbb12 stbb13 rawa rawb topap topan topbp topbn vdd vrefa vrefb vrefla vreflb gnd
XCKG clk30 mclk mclkb vdd gnd r1_cmp6_clkgen
XTHA sinp sinn isap isan trka0 trka1 topap topan cpa12 cpa11 cpa10 cpa9 cpa8 cpa7 cpa6 cpa5 cpa4 cpa3 cpa2 cpa1 cpa0 cna12 cna11 cna10 cna9 cna8 cna7 cna6 cna5 cna4 cna3 cna2 cna1 cna0 vdd vrefa vrefla gnd r1_th4_fast
XCBIAS vbp vdd gnd r1_cmp4_bias
XCBIASN vbn vdd gnd r1_cmp5n_bias
XCMPA topap topan clka clkab oap oan vbp vdd gnd r1_cmp4
XCMPNA topap topan clkna clknab oanp oann vbn vdd gnd r1_cmp5n
XTHB cosp cosn isbp isbn trkb0 trkb1 topbp topbn cpb12 cpb11 cpb10 cpb9 cpb8 cpb7 cpb6 cpb5 cpb4 cpb3 cpb2 cpb1 cpb0 cnb12 cnb11 cnb10 cnb9 cnb8 cnb7 cnb6 cnb5 cnb4 cnb3 cnb2 cnb1 cnb0 vdd vrefb vreflb gnd r1_th4_fast
XCMPB topbp topbn clkb clkbb obp obn vbp vdd gnd r1_cmp4
XCMPNB topbp topbn clknb clknbb obnp obnn vbn vdd gnd r1_cmp5n
XSAR oap oan obp obn oanp obnp mclk wina winb trka0 trka1 trkb0 trkb1 lata latb stba0 stba1 stba2 stba3 stba4 stba5 stba6 stba7 stba8 stba9 stba10 stba11 stba12 stba13 stbb0 stbb1 stbb2 stbb3 stbb4 stbb5 stbb6 stbb7 stbb8 stbb9 stbb10 stbb11 stbb12 stbb13 clka clkab clkb clkbb clkna clknab clknb clknbb cpa12 cpa11 cpa10 cpa9 cpa8 cpa7 cpa6 cpa5 cpa4 cpa3 cpa2 cpa1 cpa0 cna12 cna11 cna10 cna9 cna8 cna7 cna6 cna5 cna4 cna3 cna2 cna1 cna0 cpb12 cpb11 cpb10 cpb9 cpb8 cpb7 cpb6 cpb5 cpb4 cpb3 cpb2 cpb1 cpb0 cnb12 cnb11 cnb10 cnb9 cnb8 cnb7 cnb6 cnb5 cnb4 cnb3 cnb2 cnb1 cnb0 rawa rawb vdd gnd r1_sar5_logic
.ends r1_adc6_core_fast

.subckt r1_adc6_core_fast_mc sinp sinn cosp cosn isap isan isbp isbn trka0 trka1 trkb0 trkb1 clk30 wina winb lata latb stba0 stba1 stba2 stba3 stba4 stba5 stba6 stba7 stba8 stba9 stba10 stba11 stba12 stba13 stbb0 stbb1 stbb2 stbb3 stbb4 stbb5 stbb6 stbb7 stbb8 stbb9 stbb10 stbb11 stbb12 stbb13 rawa rawb topap topan topbp topbn vdd vrefa vrefb vrefla vreflb gnd
XCKG clk30 mclk mclkb vdd gnd r1_cmp6_clkgen
XTHA sinp sinn isap isan trka0 trka1 topap topan cpa12 cpa11 cpa10 cpa9 cpa8 cpa7 cpa6 cpa5 cpa4 cpa3 cpa2 cpa1 cpa0 cna12 cna11 cna10 cna9 cna8 cna7 cna6 cna5 cna4 cna3 cna2 cna1 cna0 vdd vrefa vrefla gnd r1_th4_fast_mc
XCBIAS vbp vdd gnd r1_cmp4_bias
XCBIASN vbn vdd gnd r1_cmp5n_bias
XCMPA topap topan clka clkab oap oan vbp vdd gnd r1_cmp4
XCMPNA topap topan clkna clknab oanp oann vbn vdd gnd r1_cmp5n
XTHB cosp cosn isbp isbn trkb0 trkb1 topbp topbn cpb12 cpb11 cpb10 cpb9 cpb8 cpb7 cpb6 cpb5 cpb4 cpb3 cpb2 cpb1 cpb0 cnb12 cnb11 cnb10 cnb9 cnb8 cnb7 cnb6 cnb5 cnb4 cnb3 cnb2 cnb1 cnb0 vdd vrefb vreflb gnd r1_th4_fast_mc
XCMPB topbp topbn clkb clkbb obp obn vbp vdd gnd r1_cmp4
XCMPNB topbp topbn clknb clknbb obnp obnn vbn vdd gnd r1_cmp5n
XSAR oap oan obp obn oanp obnp mclk wina winb trka0 trka1 trkb0 trkb1 lata latb stba0 stba1 stba2 stba3 stba4 stba5 stba6 stba7 stba8 stba9 stba10 stba11 stba12 stba13 stbb0 stbb1 stbb2 stbb3 stbb4 stbb5 stbb6 stbb7 stbb8 stbb9 stbb10 stbb11 stbb12 stbb13 clka clkab clkb clkbb clkna clknab clknb clknbb cpa12 cpa11 cpa10 cpa9 cpa8 cpa7 cpa6 cpa5 cpa4 cpa3 cpa2 cpa1 cpa0 cna12 cna11 cna10 cna9 cna8 cna7 cna6 cna5 cna4 cna3 cna2 cna1 cna0 cpb12 cpb11 cpb10 cpb9 cpb8 cpb7 cpb6 cpb5 cpb4 cpb3 cpb2 cpb1 cpb0 cnb12 cnb11 cnb10 cnb9 cnb8 cnb7 cnb6 cnb5 cnb4 cnb3 cnb2 cnb1 cnb0 rawa rawb vdd gnd r1_sar5_logic
.ends r1_adc6_core_fast_mc
