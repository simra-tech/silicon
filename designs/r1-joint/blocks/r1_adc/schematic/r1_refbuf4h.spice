* r1_refbuf4h.spice -- r1_refbuf4 with a high-impedance input (generated by gen_r1_refbuf4h.py; do not edit)
* Include after r1_adc_r4.spice. Input filter: instantiate r1_reffilt4 (Cf = MIM w x w) on vbg.
.subckt r1_refbuf4h vbg vref vdda gnd msf=32 mib=160 ndec=6 ncg=1 mt=1 lt=8u
Ibias vdda nb 5u
XMB0 nb nb gnd gnd sg13_hv_nmos w=2u l=1u ng=1 m=1
XMT  ntl nb gnd gnd sg13_hv_nmos w=2u l={lt} ng=1 m={mt}
XM1  na  vbg ntl gnd sg13_hv_nmos w=10u l=1u ng=2 m=1
XM2  ng  vref ntl gnd sg13_hv_nmos w=10u l=1u ng=2 m=1
XM3  na  na  vdda vdda sg13_hv_pmos w=4u l=1u ng=1 m=1
XM4  ng  na  vdda vdda sg13_hv_pmos w=4u l=1u ng=1 m=1
XCG  ng  gnd cap_cmim w=50u l=50u m={ncg}
XMSF vdda ng vref gnd sg13_hv_nmos w=10u l=0.45u ng=4 m={msf}
XMIB vref nb gnd gnd sg13_hv_nmos w=2u l=1u ng=1 m={mib}
XCD  vref gnd cap_cmim w=70u l=70u m={ndec}
.ends r1_refbuf4h
.subckt r1_reffilt4 vbg gnd w=58u
XCF vbg gnd cap_cmim w={w} l={w} m=1
.ends r1_reffilt4
