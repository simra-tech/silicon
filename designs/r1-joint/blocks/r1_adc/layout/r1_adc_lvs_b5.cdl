* r1_adc layout B5 LVS reference: analog part (netlist of record, layout/r1_adc_lvs.cdl) + r1_adc_sar
* (release t2j-ll-h2312-h, PDK standard cells). Built by layout/b5/make_cdl_b5.py; format change only.
* schematic netlist for KLayout LVS, generated by pnl2cdl.py from <G1_RESULTS_ROOT>/r1_adc_sar/release-t2j-h/r1_adc_sar.pnl.v
************************************************************************
*
* Copyright 2023 IHP PDK Authors
*
* Licensed under the Apache License, Version 2.0 (the "License");
* you may not use this file except in compliance with the License.
* You may obtain a copy of the License at
*
*    https://www.apache.org/licenses/LICENSE-2.0
*
* Unless required by applicable law or agreed to in writing, software
* distributed under the License is distributed on an "AS IS" BASIS,
* WITHOUT WARRANTIES OR CONDITIONS OF ANY KIND, either express or implied.
* See the License for the specific language governing permissions and
* limitations under the License.
*
************************************************************************

************************************************************************
* Library Name: sg13g2_stdcell
* Cell Name:    sg13g2_a21o_1
* View Name:    schematic
************************************************************************

.SUBCKT sg13g2_a21o_1 X A1 A2 B1 VDD VSS
*.PININFO A1:I A2:I B1:I X:O VDD:B VSS:B
MN0 net1 A1 net2 VSS sg13_lv_nmos m=1 w=640.00n l=130.00n ng=1
MN1 net2 A2 VSS VSS sg13_lv_nmos m=1 w=640.00n l=130.00n ng=1
MN2 net1 B1 VSS VSS sg13_lv_nmos m=1 w=640.00n l=130.00n ng=1
MN3 X net1 VSS VSS sg13_lv_nmos m=1 w=740.00n l=130.00n ng=1
MP2 net1 B1 net3 VDD sg13_lv_pmos m=1 w=1.000u l=130.00n ng=1
MP0 net3 A1 VDD VDD sg13_lv_pmos m=1 w=1.000u l=130.00n ng=1
MP1 net3 A2 VDD VDD sg13_lv_pmos m=1 w=1.000u l=130.00n ng=1
MP3 X net1 VDD VDD sg13_lv_pmos m=1 w=1.12u l=130.00n ng=1
.ENDS

************************************************************************
* Library Name: sg13g2_stdcell
* Cell Name:    sg13g2_a21o_2
* View Name:    schematic
************************************************************************

.SUBCKT sg13g2_a21o_2 X A1 A2 B1 VDD VSS
*.PININFO A1:I A2:I B1:I X:O VDD:B VSS:B
MN0 net1 A1 net2 VSS sg13_lv_nmos m=1 w=740.00n l=130.00n ng=1
MN1 net2 A2 VSS VSS sg13_lv_nmos m=1 w=740.00n l=130.00n ng=1
MN2 net1 B1 VSS VSS sg13_lv_nmos m=1 w=740.00n l=130.00n ng=1
MN3 X net1 VSS VSS sg13_lv_nmos m=1 w=1.48u l=130.00n ng=2
MP2 net1 B1 net3 VDD sg13_lv_pmos m=1 w=1.000u l=130.00n ng=1
MP0 net3 A1 VDD VDD sg13_lv_pmos m=1 w=1.000u l=130.00n ng=1
MP1 net3 A2 VDD VDD sg13_lv_pmos m=1 w=1.000u l=130.00n ng=1
MP3 X net1 VDD VDD sg13_lv_pmos m=1 w=2.24u l=130.00n ng=2
.ENDS

************************************************************************
* Library Name: sg13g2_stdcell
* Cell Name:    sg13g2_a21oi_1
* View Name:    schematic
************************************************************************

.SUBCKT sg13g2_a21oi_1 Y A1 A2 B1 VDD VSS
*.PININFO A1:I A2:I B1:I Y:O VDD:B VSS:B
MN0 Y B1 VSS VSS sg13_lv_nmos m=1 w=740.00n l=130.00n ng=1
MN2 net1 A2 VSS VSS sg13_lv_nmos m=1 w=740.00n l=130.00n ng=1
MN1 Y A1 net1 VSS sg13_lv_nmos m=1 w=740.00n l=130.00n ng=1
MP2 Y B1 net2 VDD sg13_lv_pmos m=1 w=1.12u l=130.00n ng=1
MP1 net2 A2 VDD VDD sg13_lv_pmos m=1 w=1.12u l=130.00n ng=1
MP0 net2 A1 VDD VDD sg13_lv_pmos m=1 w=1.12u l=130.00n ng=1
.ENDS

************************************************************************
* Library Name: sg13g2_stdcell
* Cell Name:    sg13g2_a21oi_2
* View Name:    schematic
************************************************************************

.SUBCKT sg13g2_a21oi_2 Y A1 A2 B1 VDD VSS
*.PININFO A1:I A2:I B1:I Y:O VDD:B VSS:B
MN0 Y B1 VSS VSS sg13_lv_nmos m=1 w=1.48u l=130.00n ng=2
MN2 net2 A2 VSS VSS sg13_lv_nmos m=1 w=1.48u l=130.00n ng=2
MN1 Y A1 net2 VSS sg13_lv_nmos m=1 w=1.48u l=130.00n ng=2
MP2 Y B1 net1 VDD sg13_lv_pmos m=1 w=2.24u l=130.00n ng=2
MP1 net1 A2 VDD VDD sg13_lv_pmos m=1 w=2.24u l=130.00n ng=2
MP0 net1 A1 VDD VDD sg13_lv_pmos m=1 w=2.24u l=130.00n ng=2
.ENDS

************************************************************************
* Library Name: sg13g2_stdcell
* Cell Name:    sg13g2_a221oi_1
* View Name:    schematic
************************************************************************

.SUBCKT sg13g2_a221oi_1 Y A1 A2 B1 B2 C1 VDD VSS
*.PININFO A1:I A2:I B1:I B2:I C1:I Y:O VDD:B VSS:B
MP2 Y C1 net3 VDD sg13_lv_pmos m=1 w=1.12u l=130.00n ng=1
MP4 net3 B2 net1 VDD sg13_lv_pmos m=1 w=1.12u l=130.00n ng=1
MP1 net3 B1 net1 VDD sg13_lv_pmos m=1 w=1.12u l=130.00n ng=1
MP3 net1 A2 VDD VDD sg13_lv_pmos m=1 w=1.12u l=130.00n ng=1
MP0 net1 A1 VDD VDD sg13_lv_pmos m=1 w=1.12u l=130.00n ng=1
MN4 Y C1 VSS VSS sg13_lv_nmos m=1 w=740.00n l=130.00n ng=1
MN3 net4 B2 VSS VSS sg13_lv_nmos m=1 w=740.00n l=130.00n ng=1
MN2 Y B1 net4 VSS sg13_lv_nmos m=1 w=740.00n l=130.00n ng=1
MN1 net2 A2 VSS VSS sg13_lv_nmos m=1 w=740.00n l=130.00n ng=1
MN0 Y A1 net2 VSS sg13_lv_nmos m=1 w=740.00n l=130.00n ng=1
.ENDS

************************************************************************
* Library Name: sg13g2_stdcell
* Cell Name:    sg13g2_and2_1
* View Name:    schematic
************************************************************************

.SUBCKT sg13g2_and2_1 X A B VDD VSS
*.PININFO A:I B:I X:O VDD:B VSS:B
MN0 net4 A net2 VSS sg13_lv_nmos m=1 w=640.00n l=130.00n ng=1
MN2 X net4 VSS VSS sg13_lv_nmos m=1 w=740.00n l=130.00n ng=1
MN1 net2 B VSS VSS sg13_lv_nmos m=1 w=640.00n l=130.00n ng=1
MP0 net4 B VDD VDD sg13_lv_pmos m=1 w=840.00n l=130.00n ng=1
MP2 X net4 VDD VDD sg13_lv_pmos m=1 w=1.12u l=130.00n ng=1
MP1 net4 A VDD VDD sg13_lv_pmos m=1 w=840.00n l=130.00n ng=1
.ENDS

************************************************************************
* Library Name: sg13g2_stdcell
* Cell Name:    sg13g2_and2_2
* View Name:    schematic
************************************************************************

.SUBCKT sg13g2_and2_2 X A B VDD VSS
*.PININFO A:I B:I X:O VDD:B VSS:B
MN0 net1 A net2 VSS sg13_lv_nmos m=1 w=640.00n l=130.00n ng=1
MN2 X net1 VSS VSS sg13_lv_nmos m=1 w=1.48u l=130.00n ng=2
MN1 net2 B VSS VSS sg13_lv_nmos m=1 w=640.00n l=130.00n ng=1
MP0 net1 B VDD VDD sg13_lv_pmos m=1 w=840.00n l=130.00n ng=1
MP2 X net1 VDD VDD sg13_lv_pmos m=1 w=2.24u l=130.00n ng=2
MP1 net1 A VDD VDD sg13_lv_pmos m=1 w=840.00n l=130.00n ng=1
.ENDS

************************************************************************
* Library Name: sg13g2_stdcell
* Cell Name:    sg13g2_and3_1
* View Name:    schematic
************************************************************************

.SUBCKT sg13g2_and3_1 X A B C VDD VSS
*.PININFO A:I B:I C:I X:O VDD:B VSS:B
MN2 net3 C VSS VSS sg13_lv_nmos m=1 w=640.00n l=130.00n ng=1
MN3 X net2 VSS VSS sg13_lv_nmos m=1 w=740.00n l=130.00n ng=1
MN0 net2 A net1 VSS sg13_lv_nmos m=1 w=640.00n l=130.00n ng=1
MN1 net1 B net3 VSS sg13_lv_nmos m=1 w=640.00n l=130.00n ng=1
MP3 X net2 VDD VDD sg13_lv_pmos m=1 w=1.12u l=130.00n ng=1
MP1 net2 B VDD VDD sg13_lv_pmos m=1 w=840.00n l=130.00n ng=1
MP2 net2 A VDD VDD sg13_lv_pmos m=1 w=840.00n l=130.00n ng=1
MP0 net2 C VDD VDD sg13_lv_pmos m=1 w=840.00n l=130.00n ng=1
.ENDS

************************************************************************
* Library Name: sg13g2_stdcell
* Cell Name:    sg13g2_and3_2
* View Name:    schematic
************************************************************************

.SUBCKT sg13g2_and3_2 X A B C VDD VSS
*.PININFO A:I B:I C:I X:O VDD:B VSS:B
MN2 net3 C VSS VSS sg13_lv_nmos m=1 w=640.00n l=130.00n ng=1
MN3 X net2 VSS VSS sg13_lv_nmos m=1 w=1.48u l=130.00n ng=2
MN0 net2 A net1 VSS sg13_lv_nmos m=1 w=640.00n l=130.00n ng=1
MN1 net1 B net3 VSS sg13_lv_nmos m=1 w=640.00n l=130.00n ng=1
MP3 X net2 VDD VDD sg13_lv_pmos m=1 w=2.24u l=130.00n ng=2
MP1 net2 B VDD VDD sg13_lv_pmos m=1 w=840.00n l=130.00n ng=1
MP2 net2 A VDD VDD sg13_lv_pmos m=1 w=840.00n l=130.00n ng=1
MP0 net2 C VDD VDD sg13_lv_pmos m=1 w=840.00n l=130.00n ng=1
.ENDS

************************************************************************
* Library Name: sg13g2_stdcell
* Cell Name:    sg13g2_and4_1
* View Name:    schematic
************************************************************************

.SUBCKT sg13g2_and4_1 X A B C D VDD VSS
*.PININFO A:I B:I C:I D:I X:O VDD:B VSS:B
MN3 net17 D VSS VSS sg13_lv_nmos m=1 w=640.00n l=130.00n ng=1
MN2 net16 C net17 VSS sg13_lv_nmos m=1 w=640.00n l=130.00n ng=1
MN1 net15 B net16 VSS sg13_lv_nmos m=1 w=640.00n l=130.00n ng=1
MN0 net1 A net15 VSS sg13_lv_nmos m=1 w=640.00n l=130.00n ng=1
MN4 X net1 VSS VSS sg13_lv_nmos m=1 w=740.00n l=130.00n ng=1
MP3 net1 A VDD VDD sg13_lv_pmos m=1 w=840.00n l=130.00n ng=1
MP4 X net1 VDD VDD sg13_lv_pmos m=1 w=1.12u l=130.00n ng=1
MP0 net1 D VDD VDD sg13_lv_pmos m=1 w=840.00n l=130.00n ng=1
MP1 net1 C VDD VDD sg13_lv_pmos m=1 w=840.00n l=130.00n ng=1
MP2 net1 B VDD VDD sg13_lv_pmos m=1 w=840.00n l=130.00n ng=1
.ENDS

************************************************************************
* Library Name: sg13g2_stdcell
* Cell Name:    sg13g2_and4_2
* View Name:    schematic
************************************************************************

.SUBCKT sg13g2_and4_2 X A B C D VDD VSS
*.PININFO A:I B:I C:I D:I X:O VDD:B VSS:B
MN3 net17 D VSS VSS sg13_lv_nmos m=1 w=640.00n l=130.00n ng=1
MN2 net16 C net17 VSS sg13_lv_nmos m=1 w=640.00n l=130.00n ng=1
MN1 net15 B net16 VSS sg13_lv_nmos m=1 w=640.00n l=130.00n ng=1
MN0 net1 A net15 VSS sg13_lv_nmos m=1 w=640.00n l=130.00n ng=1
MN4 X net1 VSS VSS sg13_lv_nmos m=1 w=1.48u l=130.00n ng=2
MP3 net1 A VDD VDD sg13_lv_pmos m=1 w=840.00n l=130.00n ng=1
MP4 X net1 VDD VDD sg13_lv_pmos m=1 w=2.24u l=130.00n ng=2
MP0 net1 D VDD VDD sg13_lv_pmos m=1 w=840.00n l=130.00n ng=1
MP1 net1 C VDD VDD sg13_lv_pmos m=1 w=840.00n l=130.00n ng=1
MP2 net1 B VDD VDD sg13_lv_pmos m=1 w=840.00n l=130.00n ng=1
.ENDS

************************************************************************
* Library Name: sg13g2_stdcell
* Cell Name:    sg13g2_antennanp
* View Name:    schematic
************************************************************************

.SUBCKT sg13g2_antennanp A VDD VSS
*.PININFO A:I VDD:B VSS:B
DD1 VSS A dantenna m=1 w=780n l=780n a=608.4f p=3.12u
DD0 A VDD dpantenna m=1 w=1.05u l=1.34u a=1.407p p=4.78u
.ENDS

************************************************************************
* Library Name: sg13g2_stdcell
* Cell Name:    sg13g2_buf_1
* View Name:    schematic
************************************************************************

.SUBCKT sg13g2_buf_1 X A VDD VSS
*.PININFO A:I X:O VDD:B VSS:B
MN0 net1 A VSS VSS sg13_lv_nmos m=1 w=550.00n l=130.00n ng=1
MN1 X net1 VSS VSS sg13_lv_nmos m=1 w=740.00n l=130.00n ng=1
MP1 X net1 VDD VDD sg13_lv_pmos m=1 w=1.12u l=130.00n ng=1
MP0 net1 A VDD VDD sg13_lv_pmos m=1 w=840.00n l=130.00n ng=1
.ENDS

************************************************************************
* Library Name: sg13g2_stdcell
* Cell Name:    sg13g2_buf_16
* View Name:    schematic
************************************************************************

.SUBCKT sg13g2_buf_16 X A VDD VSS
*.PININFO A:I X:O VDD:B VSS:B
MN0 net1 A VSS VSS sg13_lv_nmos m=1 w=4.44u l=130.00n ng=6
MN1 X net1 VSS VSS sg13_lv_nmos m=1 w=11.84u l=130.00n ng=16
MP1 X net1 VDD VDD sg13_lv_pmos m=1 w=17.92u l=130.00n ng=16
MP0 net1 A VDD VDD sg13_lv_pmos m=1 w=6.72u l=130.00n ng=6
.ENDS

************************************************************************
* Library Name: sg13g2_stdcell
* Cell Name:    sg13g2_buf_2
* View Name:    schematic
************************************************************************

.SUBCKT sg13g2_buf_2 X A VDD VSS
*.PININFO A:I X:O VDD:B VSS:B
MN0 net1 A VSS VSS sg13_lv_nmos m=1 w=640.00n l=130.00n ng=1
MN1 X net1 VSS VSS sg13_lv_nmos m=1 w=1.48u l=130.00n ng=2
MP1 X net1 VDD VDD sg13_lv_pmos m=1 w=2.24u l=130.00n ng=2
MP0 net1 A VDD VDD sg13_lv_pmos m=1 w=1.000u l=130.00n ng=1
.ENDS

************************************************************************
* Library Name: sg13g2_stdcell
* Cell Name:    sg13g2_buf_4
* View Name:    schematic
************************************************************************

.SUBCKT sg13g2_buf_4 X A VDD VSS
*.PININFO A:I X:O VDD:B VSS:B
MN0 net1 A VSS VSS sg13_lv_nmos m=1 w=740.00n l=130.00n ng=1
MN1 X net1 VSS VSS sg13_lv_nmos m=1 w=2.96u l=130.00n ng=4
MP1 X net1 VDD VDD sg13_lv_pmos m=1 w=4.48u l=130.00n ng=4
MP0 net1 A VDD VDD sg13_lv_pmos m=1 w=1.68u l=130.00n ng=2
.ENDS

************************************************************************
* Library Name: sg13g2_stdcell
* Cell Name:    sg13g2_buf_8
* View Name:    schematic
************************************************************************

.SUBCKT sg13g2_buf_8 X A VDD VSS
*.PININFO A:I X:O VDD:B VSS:B
MN0 net1 A VSS VSS sg13_lv_nmos m=1 w=2.22u l=130.00n ng=3
MN1 X net1 VSS VSS sg13_lv_nmos m=1 w=5.92u l=130.00n ng=8
MP1 X net1 VDD VDD sg13_lv_pmos m=1 w=8.96u l=130.00n ng=8
MP0 net1 A VDD VDD sg13_lv_pmos m=1 w=3.36u l=130.00n ng=3
.ENDS

************************************************************************
* Library Name: sg13g2_stdcell
* Cell Name:    sg13g2_decap_4
* View Name:    schematic
************************************************************************

.SUBCKT sg13g2_decap_4 VDD VSS
*.PININFO VDD:B VSS:B
MN0 VSS VDD VSS VSS sg13_lv_nmos m=1 w=420.00n l=1.000u ng=1
MP0 VDD VSS VDD VDD sg13_lv_pmos m=1 w=1.000u l=1.000u ng=1
.ENDS

************************************************************************
* Library Name: sg13g2_stdcell
* Cell Name:    sg13g2_decap_8
* View Name:    schematic
************************************************************************

.SUBCKT sg13g2_decap_8 VDD VSS
*.PININFO VDD:B VSS:B
MN0 VSS VDD VSS VSS sg13_lv_nmos m=1 w=840.00n l=1.000u ng=2
MP0 VDD VSS VDD VDD sg13_lv_pmos m=1 w=2.000u l=1.000u ng=2
.ENDS

************************************************************************
* Library Name: sg13g2_stdcell
* Cell Name:    sg13g2_dfrbp_1
* View Name:    schematic
************************************************************************

.SUBCKT sg13g2_dfrbp_1 Q Q_N CLK D RESET_B VDD VSS
*.PININFO CLK:I D:I RESET_B:I Q:O Q_N:O VDD:B VSS:B
MN11 net12 net2 VSS VSS sg13_lv_nmos m=1 w=420.00n l=130.00n ng=1
MN10 net5 clkneg net12 VSS sg13_lv_nmos m=1 w=420.00n l=130.00n ng=1
MN12 net2 net5 net11 VSS sg13_lv_nmos m=1 w=420.00n l=130.00n ng=1
MN13 net11 RESET_B VSS VSS sg13_lv_nmos m=1 w=420.00n l=130.00n ng=1
MN14 Q_N net5 VSS VSS sg13_lv_nmos m=1 w=740.00n l=130.00n ng=1
MN0 Db D net10 VSS sg13_lv_nmos m=1 w=420.00n l=130.00n ng=1
MN1 net10 RESET_B VSS VSS sg13_lv_nmos m=1 w=420.00n l=130.00n ng=1
MN4 Db clkneg net6 VSS sg13_lv_nmos m=1 w=420.00n l=130.00n ng=1
MN5 net6 clkpos net9 VSS sg13_lv_nmos m=1 w=420.00n l=130.00n ng=1
MN6 net9 net4 net8 VSS sg13_lv_nmos m=1 w=420.00n l=130.00n ng=1
MN7 net8 RESET_B VSS VSS sg13_lv_nmos m=1 w=420.00n l=130.00n ng=1
MN8 net4 net6 VSS VSS sg13_lv_nmos m=1 w=740.00n l=130.00n ng=1
MN2 clkneg CLK VSS VSS sg13_lv_nmos m=1 w=740.00n l=130.00n ng=1
MN9 net4 clkpos net5 VSS sg13_lv_nmos m=1 w=740.00n l=130.00n ng=1
MN3 clkpos clkneg VSS VSS sg13_lv_nmos m=1 w=740.00n l=130.00n ng=1
MN16 Q net1 VSS VSS sg13_lv_nmos m=1 w=740.00n l=130.00n ng=1
MN15 net1 net5 VSS VSS sg13_lv_nmos m=1 w=740.00n l=130.00n ng=1
MP11 net5 clkpos net3 VDD sg13_lv_pmos m=1 w=420.00n l=130.00n ng=1
MP12 net2 net5 VDD VDD sg13_lv_pmos m=1 w=420.00n l=130.00n ng=1
MP13 net2 RESET_B VDD VDD sg13_lv_pmos m=1 w=420.00n l=130.00n ng=1
MP14 Q_N net5 VDD VDD sg13_lv_pmos m=1 w=1.12u l=130.00n ng=1
MP4 Db clkpos net6 VDD sg13_lv_pmos m=1 w=420.00n l=130.00n ng=1
MP0 Db RESET_B VDD VDD sg13_lv_pmos m=1 w=420.00n l=130.00n ng=1
MP1 Db D VDD VDD sg13_lv_pmos m=1 w=420.00n l=130.00n ng=1
MP5 net7 net4 VDD VDD sg13_lv_pmos m=1 w=420.00n l=130.00n ng=1
MP6 net6 clkneg net7 VDD sg13_lv_pmos m=1 w=420.00n l=130.00n ng=1
MP7 net6 RESET_B VDD VDD sg13_lv_pmos m=1 w=420.00n l=130.00n ng=1
MP2 clkneg CLK VDD VDD sg13_lv_pmos m=1 w=1.12u l=130.00n ng=1
MP3 clkpos clkneg VDD VDD sg13_lv_pmos m=1 w=1.12u l=130.00n ng=1
MP8 net4 net6 VDD VDD sg13_lv_pmos m=1 w=1.000u l=130.00n ng=1
MP9 net4 clkneg net5 VDD sg13_lv_pmos m=1 w=1.000u l=130.00n ng=1
MP16 Q net1 VDD VDD sg13_lv_pmos m=1 w=1.12u l=130.00n ng=1
MP10 net3 net2 VDD VDD sg13_lv_pmos m=1 w=420.00n l=130.00n ng=1
MP15 net1 net5 VDD VDD sg13_lv_pmos m=1 w=1.12u l=130.00n ng=1
.ENDS

************************************************************************
* Library Name: sg13g2_stdcell
* Cell Name:    sg13g2_dfrbp_2
* View Name:    schematic
************************************************************************

.SUBCKT sg13g2_dfrbp_2 Q Q_N CLK D RESET_B VDD VSS
*.PININFO CLK:I D:I RESET_B:I Q:O Q_N:O VDD:B VSS:B
MN11 net12 net2 VSS VSS sg13_lv_nmos m=1 w=420.00n l=130.00n ng=1
MN10 net5 clkneg net12 VSS sg13_lv_nmos m=1 w=420.00n l=130.00n ng=1
MN12 net2 net5 net11 VSS sg13_lv_nmos m=1 w=420.00n l=130.00n ng=1
MN13 net11 RESET_B VSS VSS sg13_lv_nmos m=1 w=420.00n l=130.00n ng=1
MN14 Q_N net5 VSS VSS sg13_lv_nmos m=1 w=1.48u l=130.00n ng=2
MN0 Db D net10 VSS sg13_lv_nmos m=1 w=420.00n l=130.00n ng=1
MN1 net10 RESET_B VSS VSS sg13_lv_nmos m=1 w=420.00n l=130.00n ng=1
MN4 Db clkneg net6 VSS sg13_lv_nmos m=1 w=420.00n l=130.00n ng=1
MN5 net6 clkpos net9 VSS sg13_lv_nmos m=1 w=420.00n l=130.00n ng=1
MN6 net9 net4 net8 VSS sg13_lv_nmos m=1 w=420.00n l=130.00n ng=1
MN7 net8 RESET_B VSS VSS sg13_lv_nmos m=1 w=420.00n l=130.00n ng=1
MN8 net4 net6 VSS VSS sg13_lv_nmos m=1 w=740.00n l=130.00n ng=1
MN2 clkneg CLK VSS VSS sg13_lv_nmos m=1 w=740.00n l=130.00n ng=1
MN9 net4 clkpos net5 VSS sg13_lv_nmos m=1 w=740.00n l=130.00n ng=1
MN3 clkpos clkneg VSS VSS sg13_lv_nmos m=1 w=740.00n l=130.00n ng=1
MN16 Q net1 VSS VSS sg13_lv_nmos m=1 w=1.48u l=130.00n ng=2
MN15 net1 net5 VSS VSS sg13_lv_nmos m=1 w=640.00n l=130.00n ng=1
MP11 net5 clkpos net3 VDD sg13_lv_pmos m=1 w=420.00n l=130.00n ng=1
MP12 net2 net5 VDD VDD sg13_lv_pmos m=1 w=420.00n l=130.00n ng=1
MP13 net2 RESET_B VDD VDD sg13_lv_pmos m=1 w=420.00n l=130.00n ng=1
MP14 Q_N net5 VDD VDD sg13_lv_pmos m=1 w=2.24u l=130.00n ng=2
MP4 Db clkpos net6 VDD sg13_lv_pmos m=1 w=420.00n l=130.00n ng=1
MP0 Db RESET_B VDD VDD sg13_lv_pmos m=1 w=420.00n l=130.00n ng=1
MP1 Db D VDD VDD sg13_lv_pmos m=1 w=420.00n l=130.00n ng=1
MP5 net7 net4 VDD VDD sg13_lv_pmos m=1 w=420.00n l=130.00n ng=1
MP6 net6 clkneg net7 VDD sg13_lv_pmos m=1 w=420.00n l=130.00n ng=1
MP7 net6 RESET_B VDD VDD sg13_lv_pmos m=1 w=420.00n l=130.00n ng=1
MP2 clkneg CLK VDD VDD sg13_lv_pmos m=1 w=1.12u l=130.00n ng=1
MP3 clkpos clkneg VDD VDD sg13_lv_pmos m=1 w=1.12u l=130.00n ng=1
MP8 net4 net6 VDD VDD sg13_lv_pmos m=1 w=1.000u l=130.00n ng=1
MP9 net4 clkneg net5 VDD sg13_lv_pmos m=1 w=1.000u l=130.00n ng=1
MP16 Q net1 VDD VDD sg13_lv_pmos m=1 w=2.24u l=130.00n ng=2
MP10 net3 net2 VDD VDD sg13_lv_pmos m=1 w=420.00n l=130.00n ng=1
MP15 net1 net5 VDD VDD sg13_lv_pmos m=1 w=1.000u l=130.00n ng=1
.ENDS

************************************************************************
* Library Name: sg13g2_stdcell
* Cell Name:    sg13g2_dlhq_1
* View Name:    schematic
************************************************************************

.SUBCKT sg13g2_dlhq_1 Q D GATE VDD VSS
*.PININFO D:I GATE:I Q:O VDD:B VSS:B
MP8 Q qint_b VDD VDD sg13_lv_pmos m=1 w=1.12u l=130.00n ng=1
MP6 qint GATE_BB net8 VDD sg13_lv_pmos m=1 w=420.00n l=130.00n ng=1
MP7 qint_b qint VDD VDD sg13_lv_pmos m=1 w=1.12u l=130.00n ng=1
MP2 Db D VDD VDD sg13_lv_pmos m=1 w=840.00n l=130.00n ng=1
MP0 GATE_B GATE VDD VDD sg13_lv_pmos m=1 w=840.00n l=130.00n ng=1
MP1 GATE_BB GATE_B VDD VDD sg13_lv_pmos m=1 w=840.00n l=130.00n ng=1
MP5 net8 qint_b VDD VDD sg13_lv_pmos m=1 w=420.00n l=130.00n ng=1
MP4 net4 GATE_B qint VDD sg13_lv_pmos m=1 w=1.000u l=130.00n ng=1
MP3 net4 Db VDD VDD sg13_lv_pmos m=1 w=1.000u l=130.00n ng=1
MN0 GATE_B GATE VSS VSS sg13_lv_nmos m=1 w=740.00n l=130.00n ng=1
MN1 GATE_BB GATE_B VSS VSS sg13_lv_nmos m=1 w=740.00n l=130.00n ng=1
MN5 qint GATE_B net9 VSS sg13_lv_nmos m=1 w=420.00n l=130.00n ng=1
MN8 Q qint_b VSS VSS sg13_lv_nmos m=1 w=740.00n l=130.00n ng=1
MN4 net7 Db VSS VSS sg13_lv_nmos m=1 w=740.00n l=130.00n ng=1
MN6 net9 qint_b VSS VSS sg13_lv_nmos m=1 w=420.00n l=130.00n ng=1
MN7 qint_b qint VSS VSS sg13_lv_nmos m=1 w=740.00n l=130.00n ng=1
MN3 qint GATE_BB net7 VSS sg13_lv_nmos m=1 w=740.00n l=130.00n ng=1
MN2 Db D VSS VSS sg13_lv_nmos m=1 w=550.00n l=130.00n ng=1
.ENDS

************************************************************************
* Library Name: sg13g2_stdcell
* Cell Name:    sg13g2_dlhr_1
* View Name:    schematic
************************************************************************

.SUBCKT sg13g2_dlhr_1 Q Q_N D GATE RESET_B VDD VSS
*.PININFO D:I GATE:I RESET_B:I Q:O Q_N:O VDD:B VSS:B
MP8 qint_b RESET_B VDD VDD sg13_lv_pmos m=1 w=1.12u l=130.00n ng=1
MP9 Q qint_b VDD VDD sg13_lv_pmos m=1 w=1.12u l=130.00n ng=1
MP6 qint GATE_BB net11 VDD sg13_lv_pmos m=1 w=420.00n l=130.00n ng=1
MP5 net11 qint_b VDD VDD sg13_lv_pmos m=1 w=420.00n l=130.00n ng=1
MP4 qint GATE_B net2 VDD sg13_lv_pmos m=1 w=1.000u l=130.00n ng=1
MP3 net2 Db VDD VDD sg13_lv_pmos m=1 w=1.000u l=130.00n ng=1
MP2 Db D VDD VDD sg13_lv_pmos m=1 w=840.00n l=130.00n ng=1
MP0 GATE_B GATE VDD VDD sg13_lv_pmos m=1 w=840.00n l=130.00n ng=1
MP11 Q_N qintn_b VDD VDD sg13_lv_pmos m=1 w=1.12u l=130.00n ng=1
MP7 qint_b qint VDD VDD sg13_lv_pmos m=1 w=1.12u l=130.00n ng=1
MP1 GATE_BB GATE_B VDD VDD sg13_lv_pmos m=1 w=840.00n l=130.00n ng=1
MP10 qintn_b qint_b VDD VDD sg13_lv_pmos m=1 w=840.00n l=130.00n ng=1
MN7 qint_b qint net9 VSS sg13_lv_nmos m=1 w=740.00n l=130.00n ng=1
MN8 net9 RESET_B VSS VSS sg13_lv_nmos m=1 w=740.00n l=130.00n ng=1
MN5 qint GATE_B net7 VSS sg13_lv_nmos m=1 w=420.00n l=130.00n ng=1
MN6 net7 qint_b VSS VSS sg13_lv_nmos m=1 w=420.00n l=130.00n ng=1
MN9 Q qint_b VSS VSS sg13_lv_nmos m=1 w=740.00n l=130.00n ng=1
MN3 qint GATE_BB net1 VSS sg13_lv_nmos m=1 w=640.00n l=130.00n ng=1
MN4 net1 Db VSS VSS sg13_lv_nmos m=1 w=640.00n l=130.00n ng=1
MN2 Db D VSS VSS sg13_lv_nmos m=1 w=550.00n l=130.00n ng=1
MN0 GATE_B GATE VSS VSS sg13_lv_nmos m=1 w=740.00n l=130.00n ng=1
MN11 Q_N qintn_b VSS VSS sg13_lv_nmos m=1 w=740.00n l=130.00n ng=1
MN1 GATE_BB GATE_B VSS VSS sg13_lv_nmos m=1 w=740.00n l=130.00n ng=1
MN10 qintn_b qint_b VSS VSS sg13_lv_nmos m=1 w=550.00n l=130.00n ng=1
.ENDS

************************************************************************
* Library Name: sg13g2_stdcell
* Cell Name:    sg13g2_dlhrq_1
* View Name:    schematic
************************************************************************

.SUBCKT sg13g2_dlhrq_1 Q D GATE RESET_B VDD VSS
*.PININFO D:I GATE:I RESET_B:I Q:O VDD:B VSS:B
MN8 net116 RESET_B VSS VSS sg13_lv_nmos m=1 w=740.00n l=130.00n ng=1
MN9 Q qint_b VSS VSS sg13_lv_nmos m=1 w=740.00n l=130.00n ng=1
MN1 GATE_BB GATE_B VSS VSS sg13_lv_nmos m=1 w=740.00n l=130.00n ng=1
MN5 qint GATE_B net89 VSS sg13_lv_nmos m=1 w=420.00n l=130.00n ng=1
MN7 qint_b qint net116 VSS sg13_lv_nmos m=1 w=740.00n l=130.00n ng=1
MN2 Db D VSS VSS sg13_lv_nmos m=1 w=550.00n l=130.00n ng=1
MN4 net61 Db VSS VSS sg13_lv_nmos m=1 w=640.00n l=130.00n ng=1
MN3 qint GATE_BB net61 VSS sg13_lv_nmos m=1 w=640.00n l=130.00n ng=1
MN6 net89 qint_b VSS VSS sg13_lv_nmos m=1 w=420.00n l=130.00n ng=1
MN0 GATE_B GATE VSS VSS sg13_lv_nmos m=1 w=740.00n l=130.00n ng=1
MP3 net60 Db VDD VDD sg13_lv_pmos m=1 w=1.000u l=130.00n ng=1
MP8 qint_b RESET_B VDD VDD sg13_lv_pmos m=1 w=1.000u l=130.00n ng=1
MP6 qint GATE_BB net92 VDD sg13_lv_pmos m=1 w=420.00n l=130.00n ng=1
MP9 Q qint_b VDD VDD sg13_lv_pmos m=1 w=1.12u l=130.00n ng=1
MP5 net92 qint_b VDD VDD sg13_lv_pmos m=1 w=420.00n l=130.00n ng=1
MP0 GATE_B GATE VDD VDD sg13_lv_pmos m=1 w=840.00n l=130.00n ng=1
MP2 Db D VDD VDD sg13_lv_pmos m=1 w=840.00n l=130.00n ng=1
MP4 qint GATE_B net60 VDD sg13_lv_pmos m=1 w=1.000u l=130.00n ng=1
MP1 GATE_BB GATE_B VDD VDD sg13_lv_pmos m=1 w=840.00n l=130.00n ng=1
MP7 qint_b qint VDD VDD sg13_lv_pmos m=1 w=1.000u l=130.00n ng=1
.ENDS

************************************************************************
* Library Name: sg13g2_stdcell
* Cell Name:    sg13g2_dllr_1
* View Name:    schematic
************************************************************************

.SUBCKT sg13g2_dllr_1 Q Q_N D GATE_N RESET_B VDD VSS
*.PININFO D:I GATE_N:I RESET_B:I Q:O Q_N:O VDD:B VSS:B
MN2 Db D VSS VSS sg13_lv_nmos m=1 w=550.00n l=130.00n ng=1
MN0 gnb GATE_N VSS VSS sg13_lv_nmos m=1 w=740.00n l=130.00n ng=1
MN1 gnbb gnb VSS VSS sg13_lv_nmos m=1 w=740.00n l=130.00n ng=1
MN6 net89 qint_b VSS VSS sg13_lv_nmos m=1 w=420.00n l=130.00n ng=1
MN7 qint_b qint net116 VSS sg13_lv_nmos m=1 w=740.00n l=130.00n ng=1
MN8 net116 RESET_B VSS VSS sg13_lv_nmos m=1 w=740.00n l=130.00n ng=1
MN5 qint gnbb net89 VSS sg13_lv_nmos m=1 w=420.00n l=130.00n ng=1
MN11 Q_N qintn_b VSS VSS sg13_lv_nmos m=1 w=740.00n l=130.00n ng=1
MN3 qint gnb net61 VSS sg13_lv_nmos m=1 w=640.00n l=130.00n ng=1
MN10 qintn_b qint_b VSS VSS sg13_lv_nmos m=1 w=550.00n l=130.00n ng=1
MN4 net61 Db VSS VSS sg13_lv_nmos m=1 w=640.00n l=130.00n ng=1
MN9 Q qint_b VSS VSS sg13_lv_nmos m=1 w=740.00n l=130.00n ng=1
MP1 gnbb gnb VDD VDD sg13_lv_pmos m=1 w=840.00n l=130.00n ng=1
MP4 qint gnbb net60 VDD sg13_lv_pmos m=1 w=1.000u l=130.00n ng=1
MP10 qintn_b qint_b VDD VDD sg13_lv_pmos m=1 w=840.00n l=130.00n ng=1
MP11 Q_N qintn_b VDD VDD sg13_lv_pmos m=1 w=1.12u l=130.00n ng=1
MP3 net60 Db VDD VDD sg13_lv_pmos m=1 w=1.000u l=130.00n ng=1
MP5 net92 qint_b VDD VDD sg13_lv_pmos m=1 w=420.00n l=130.00n ng=1
MP8 qint_b RESET_B VDD VDD sg13_lv_pmos m=1 w=1.12u l=130.00n ng=1
MP2 Db D VDD VDD sg13_lv_pmos m=1 w=840.00n l=130.00n ng=1
MP0 gnb GATE_N VDD VDD sg13_lv_pmos m=1 w=840.00n l=130.00n ng=1
MP9 Q qint_b VDD VDD sg13_lv_pmos m=1 w=1.12u l=130.00n ng=1
MP6 qint gnb net92 VDD sg13_lv_pmos m=1 w=420.00n l=130.00n ng=1
MP7 qint_b qint VDD VDD sg13_lv_pmos m=1 w=1.12u l=130.00n ng=1
.ENDS

************************************************************************
* Library Name: sg13g2_stdcell
* Cell Name:    sg13g2_dllrq_1
* View Name:    schematic
************************************************************************

.SUBCKT sg13g2_dllrq_1 Q D GATE_N RESET_B VDD VSS
*.PININFO D:I GATE_N:I RESET_B:I Q:O VDD:B VSS:B
MN5 qint gnbb net89 VSS sg13_lv_nmos m=1 w=420.00n l=130.00n ng=1
MN3 qint gnb net61 VSS sg13_lv_nmos m=1 w=640.00n l=130.00n ng=1
MN8 net116 RESET_B VSS VSS sg13_lv_nmos m=1 w=740.00n l=130.00n ng=1
MN9 Q qint_b VSS VSS sg13_lv_nmos m=1 w=740.00n l=130.00n ng=1
MN4 net61 Db VSS VSS sg13_lv_nmos m=1 w=640.00n l=130.00n ng=1
MN6 net89 qint_b VSS VSS sg13_lv_nmos m=1 w=420.00n l=130.00n ng=1
MN7 qint_b qint net116 VSS sg13_lv_nmos m=1 w=740.00n l=130.00n ng=1
MN2 Db D VSS VSS sg13_lv_nmos m=1 w=550.00n l=130.00n ng=1
MN0 gnb GATE_N VSS VSS sg13_lv_nmos m=1 w=740.00n l=130.00n ng=1
MN1 gnbb gnb VSS VSS sg13_lv_nmos m=1 w=740.00n l=130.00n ng=1
MP3 net59 Db VDD VDD sg13_lv_pmos m=1 w=1.000u l=130.00n ng=1
MP8 qint_b RESET_B VDD VDD sg13_lv_pmos m=1 w=1.000u l=130.00n ng=1
MP0 gnb GATE_N VDD VDD sg13_lv_pmos m=1 w=840.00n l=130.00n ng=1
MP5 net92 qint_b VDD VDD sg13_lv_pmos m=1 w=420.00n l=130.00n ng=1
MP7 qint_b qint VDD VDD sg13_lv_pmos m=1 w=1.000u l=130.00n ng=1
MP9 Q qint_b VDD VDD sg13_lv_pmos m=1 w=1.12u l=130.00n ng=1
MP4 qint gnbb net59 VDD sg13_lv_pmos m=1 w=1.000u l=130.00n ng=1
MP2 Db D VDD VDD sg13_lv_pmos m=1 w=840.00n l=130.00n ng=1
MP1 gnbb gnb VDD VDD sg13_lv_pmos m=1 w=840.00n l=130.00n ng=1
MP6 qint gnb net92 VDD sg13_lv_pmos m=1 w=420.00n l=130.00n ng=1
.ENDS

************************************************************************
* Library Name: sg13g2_stdcell
* Cell Name:    sg13g2_dlygate4sd1_1
* View Name:    schematic
************************************************************************

.SUBCKT sg13g2_dlygate4sd1_1 X A VDD VSS
*.PININFO A:I X:O VDD:B VSS:B
MP3 X net3 VDD VDD sg13_lv_pmos m=1 w=1.12u l=130.00n ng=1
MP2 net3 net2 VDD VDD sg13_lv_pmos m=1 w=1.000u l=130.00n ng=1
MP1 net2 net1 VDD VDD sg13_lv_pmos m=1 w=1.000u l=130.00n ng=1
MP0 net1 A VDD VDD sg13_lv_pmos m=1 w=420.00n l=130.00n ng=1
MN3 X net3 VSS VSS sg13_lv_nmos m=1 w=740.00n l=130.00n ng=1
MN2 net3 net2 VSS VSS sg13_lv_nmos m=1 w=420.00n l=130.00n ng=1
MN1 net2 net1 VSS VSS sg13_lv_nmos m=1 w=420.00n l=130.00n ng=1
MN0 net1 A VSS VSS sg13_lv_nmos m=1 w=420.00n l=130.00n ng=1
.ENDS

************************************************************************
* Library Name: sg13g2_stdcell
* Cell Name:    sg13g2_dlygate4sd2_1
* View Name:    schematic
************************************************************************

.SUBCKT sg13g2_dlygate4sd2_1 X A VDD VSS
*.PININFO A:I X:O VDD:B VSS:B
MP3 X net3 VDD VDD sg13_lv_pmos m=1 w=1.12u l=130.00n ng=1
MP2 net3 net2 VDD VDD sg13_lv_pmos m=1 w=1.000u l=250.00n ng=1
MP1 net2 net1 VDD VDD sg13_lv_pmos m=1 w=1.000u l=250.00n ng=1
MP0 net1 A VDD VDD sg13_lv_pmos m=1 w=420.00n l=130.00n ng=1
MN3 X net3 VSS VSS sg13_lv_nmos m=1 w=740.00n l=130.00n ng=1
MN2 net3 net2 VSS VSS sg13_lv_nmos m=1 w=420.00n l=180.00n ng=1
MN1 net2 net1 VSS VSS sg13_lv_nmos m=1 w=420.00n l=180.00n ng=1
MN0 net1 A VSS VSS sg13_lv_nmos m=1 w=420.00n l=130.00n ng=1
.ENDS

************************************************************************
* Library Name: sg13g2_stdcell
* Cell Name:    sg13g2_dlygate4sd3_1
* View Name:    schematic
************************************************************************

.SUBCKT sg13g2_dlygate4sd3_1 X A VDD VSS
*.PININFO A:I X:O VDD:B VSS:B
MP3 X net3 VDD VDD sg13_lv_pmos m=1 w=1.12u l=130.00n ng=1
MP2 net3 net2 VDD VDD sg13_lv_pmos m=1 w=1.000u l=500.0n ng=1
MP1 net2 net1 VDD VDD sg13_lv_pmos m=1 w=1.000u l=500.0n ng=1
MP0 net1 A VDD VDD sg13_lv_pmos m=1 w=420.00n l=130.00n ng=1
MN3 X net3 VSS VSS sg13_lv_nmos m=1 w=740.00n l=130.00n ng=1
MN2 net3 net2 VSS VSS sg13_lv_nmos m=1 w=420.00n l=500.0n ng=1
MN1 net2 net1 VSS VSS sg13_lv_nmos m=1 w=420.00n l=500.0n ng=1
MN0 net1 A VSS VSS sg13_lv_nmos m=1 w=420.00n l=130.00n ng=1
.ENDS

************************************************************************
* Library Name: sg13g2_stdcell
* Cell Name:    sg13g2_ebufn_2
* View Name:    schematic
************************************************************************

.SUBCKT sg13g2_ebufn_2 Z A TE_B VDD VSS
*.PININFO A:I TE_B:I Z:O VDD:B VSS:B
MN3 net4 net3 VSS VSS sg13_lv_nmos m=1 w=1.48u l=130.00n ng=2
MN2 Z net1 net4 VSS sg13_lv_nmos m=1 w=1.48u l=130.00n ng=2
MN1 net3 TE_B VSS VSS sg13_lv_nmos m=1 w=640.00n l=130.00n ng=1
MN0 net1 A VSS VSS sg13_lv_nmos m=1 w=640.00n l=130.00n ng=1
MP2 net2 TE_B VDD VDD sg13_lv_pmos m=1 w=2.24u l=130.00n ng=2
MP3 Z net1 net2 VDD sg13_lv_pmos m=1 w=2.24u l=130.00n ng=2
MP1 net3 TE_B VDD VDD sg13_lv_pmos m=1 w=1.000u l=130.00n ng=1
MP0 net1 A VDD VDD sg13_lv_pmos m=1 w=1.000u l=130.00n ng=1
.ENDS

************************************************************************
* Library Name: sg13g2_stdcell
* Cell Name:    sg13g2_ebufn_4
* View Name:    schematic
************************************************************************

.SUBCKT sg13g2_ebufn_4 Z A TE_B VDD VSS
*.PININFO A:I TE_B:I Z:O VDD:B VSS:B
MN0 net23 A VSS VSS sg13_lv_nmos m=1 w=740.00n l=130.00n ng=1
MN1 net21 TE_B VSS VSS sg13_lv_nmos m=1 w=740.00n l=130.00n ng=1
MN2 Z net23 net22 VSS sg13_lv_nmos m=1 w=2.96u l=130.00n ng=4
MN3 net22 net21 VSS VSS sg13_lv_nmos m=1 w=2.96u l=130.00n ng=4
MP0 net23 A VDD VDD sg13_lv_pmos m=1 w=1.12u l=130.00n ng=1
MP1 net21 TE_B VDD VDD sg13_lv_pmos m=1 w=1.12u l=130.00n ng=1
MP3 Z net23 net24 VDD sg13_lv_pmos m=1 w=4.48u l=130.00n ng=4
MP2 net24 TE_B VDD VDD sg13_lv_pmos m=1 w=4.48u l=130.00n ng=4
.ENDS

************************************************************************
* Library Name: sg13g2_stdcell
* Cell Name:    sg13g2_ebufn_8
* View Name:    schematic
************************************************************************

.SUBCKT sg13g2_ebufn_8 Z A TE_B VDD VSS
*.PININFO A:I TE_B:I Z:O VDD:B VSS:B
MN3 net23 net22 VSS VSS sg13_lv_nmos m=1 w=5.92u l=130.00n ng=8
MN2 Z net21 net23 VSS sg13_lv_nmos m=1 w=5.92u l=130.00n ng=8
MN1 net22 TE_B VSS VSS sg13_lv_nmos m=1 w=740.00n l=130.00n ng=1
MN0 net21 A VSS VSS sg13_lv_nmos m=1 w=1.48u l=130.00n ng=2
MP2 net24 TE_B VDD VDD sg13_lv_pmos m=1 w=8.96u l=130.00n ng=8
MP3 Z net21 net24 VDD sg13_lv_pmos m=1 w=8.96u l=130.00n ng=8
MP1 net22 TE_B VDD VDD sg13_lv_pmos m=1 w=1.12u l=130.00n ng=1
MP0 net21 A VDD VDD sg13_lv_pmos m=1 w=2.24u l=130.00n ng=2
.ENDS

************************************************************************
* Library Name: sg13g2_stdcell
* Cell Name:    sg13g2_einvn_2
* View Name:    schematic
************************************************************************

.SUBCKT sg13g2_einvn_2 Z A TE_B VDD VSS
*.PININFO A:I TE_B:I Z:O VDD:B VSS:B
MN0 TE TE_B VSS VSS sg13_lv_nmos m=1 w=420.00n l=130.00n ng=1
MN2 net1 TE VSS VSS sg13_lv_nmos m=1 w=1.48u l=130.00n ng=2
MN1 Z A net1 VSS sg13_lv_nmos m=1 w=1.48u l=130.00n ng=2
MP0 TE TE_B VDD VDD sg13_lv_pmos m=1 w=640.00n l=130.00n ng=1
MP1 net2 TE_B VDD VDD sg13_lv_pmos m=1 w=2.24u l=130.00n ng=2
MP2 Z A net2 VDD sg13_lv_pmos m=1 w=2.24u l=130.00n ng=2
.ENDS

************************************************************************
* Library Name: sg13g2_stdcell
* Cell Name:    sg13g2_einvn_4
* View Name:    schematic
************************************************************************

.SUBCKT sg13g2_einvn_4 Z A TE_B VDD VSS
*.PININFO A:I TE_B:I Z:O VDD:B VSS:B
MN2 net16 TE VSS VSS sg13_lv_nmos m=1 w=2.96u l=130.00n ng=4
MN0 TE TE_B VSS VSS sg13_lv_nmos m=1 w=740.00n l=130.00n ng=1
MN1 Z A net16 VSS sg13_lv_nmos m=1 w=2.96u l=130.00n ng=4
MP0 TE TE_B VDD VDD sg13_lv_pmos m=1 w=1.12u l=130.00n ng=1
MP1 net17 TE_B VDD VDD sg13_lv_pmos m=1 w=4.48u l=130.00n ng=4
MP2 Z A net17 VDD sg13_lv_pmos m=1 w=4.48u l=130.00n ng=4
.ENDS

************************************************************************
* Library Name: sg13g2_stdcell
* Cell Name:    sg13g2_einvn_8
* View Name:    schematic
************************************************************************

.SUBCKT sg13g2_einvn_8 Z A TE_B VDD VSS
*.PININFO A:I TE_B:I Z:O VDD:B VSS:B
MN1 Z A net29 VSS sg13_lv_nmos m=1 w=5.92u l=130.00n ng=8
MN0 TE TE_B VSS VSS sg13_lv_nmos m=1 w=740.00n l=130.00n ng=1
MN2 net29 TE VSS VSS sg13_lv_nmos m=1 w=5.92u l=130.00n ng=8
MP1 net28 TE_B VDD VDD sg13_lv_pmos m=1 w=8.96u l=130.00n ng=8
MP2 Z A net28 VDD sg13_lv_pmos m=1 w=8.96u l=130.00n ng=8
MP0 TE TE_B VDD VDD sg13_lv_pmos m=1 w=1.12u l=130.00n ng=1
.ENDS

************************************************************************
* Library Name: sg13g2_stdcell
* Cell Name:    sg13g2_inv_1
* View Name:    schematic
************************************************************************

.SUBCKT sg13g2_inv_1 Y A VDD VSS
*.PININFO A:I Y:O VDD:B VSS:B
MN0 Y A VSS VSS sg13_lv_nmos m=1 w=740.00n l=130.00n ng=1
MP0 Y A VDD VDD sg13_lv_pmos m=1 w=1.12u l=130.00n ng=1
.ENDS

************************************************************************
* Library Name: sg13g2_stdcell
* Cell Name:    sg13g2_inv_16
* View Name:    schematic
************************************************************************

.SUBCKT sg13g2_inv_16 Y A VDD VSS
*.PININFO A:I Y:O VDD:B VSS:B
MN0 Y A VSS VSS sg13_lv_nmos m=1 w=11.84u l=130.00n ng=16
MP0 Y A VDD VDD sg13_lv_pmos m=1 w=17.92u l=130.00n ng=16
.ENDS

************************************************************************
* Library Name: sg13g2_stdcell
* Cell Name:    sg13g2_inv_2
* View Name:    schematic
************************************************************************

.SUBCKT sg13g2_inv_2 Y A VDD VSS
*.PININFO A:I Y:O VDD:B VSS:B
MN0 Y A VSS VSS sg13_lv_nmos m=1 w=1.48u l=130.00n ng=2
MP0 Y A VDD VDD sg13_lv_pmos m=1 w=2.24u l=130.00n ng=2
.ENDS

************************************************************************
* Library Name: sg13g2_stdcell
* Cell Name:    sg13g2_inv_4
* View Name:    schematic
************************************************************************

.SUBCKT sg13g2_inv_4 Y A VDD VSS
*.PININFO A:I Y:O VDD:B VSS:B
MP0 Y A VDD VDD sg13_lv_pmos m=1 w=4.48u l=130.00n ng=4
MN0 Y A VSS VSS sg13_lv_nmos m=1 w=2.96u l=130.00n ng=4
.ENDS

************************************************************************
* Library Name: sg13g2_stdcell
* Cell Name:    sg13g2_inv_8
* View Name:    schematic
************************************************************************

.SUBCKT sg13g2_inv_8 Y A VDD VSS
*.PININFO A:I Y:O VDD:B VSS:B
MN0 Y A VSS VSS sg13_lv_nmos m=1 w=5.92u l=130.00n ng=8
MP0 Y A VDD VDD sg13_lv_pmos m=1 w=8.96u l=130.00n ng=8
.ENDS

************************************************************************
* Library Name: sg13g2_stdcell
* Cell Name:    sg13g2_lgcp_1
* View Name:    schematic
************************************************************************

.SUBCKT sg13g2_lgcp_1 GCLK CLK GATE VDD VSS
*.PININFO CLK:I GATE:I GCLK:O VDD:B VSS:B
MP1 CLKBB CLKB VDD VDD sg13_lv_pmos m=1 w=840.00n l=130.00n ng=1
MP3 net1 CLKBB net4 VDD sg13_lv_pmos m=1 w=1.000u l=130.00n ng=1
MP4 int_GATE net1 VDD VDD sg13_lv_pmos m=1 w=1.12u l=130.00n ng=1
MP2 net4 GATE VDD VDD sg13_lv_pmos m=1 w=1.000u l=130.00n ng=1
MP8 net3 int_GATE VDD VDD sg13_lv_pmos m=1 w=840.00n l=130.00n ng=1
MP9 GCLK net3 VDD VDD sg13_lv_pmos m=1 w=1.12u l=130.00n ng=1
MP6 net1 CLKB net6 VDD sg13_lv_pmos m=1 w=420.00n l=130.00n ng=1
MP0 CLKB CLK VDD VDD sg13_lv_pmos m=1 w=840.00n l=130.00n ng=1
MP7 net3 CLK VDD VDD sg13_lv_pmos m=1 w=840.00n l=130.00n ng=1
MP5 net6 int_GATE VDD VDD sg13_lv_pmos m=1 w=420.00n l=130.00n ng=1
MN9 GCLK net3 VSS VSS sg13_lv_nmos m=1 w=740.00n l=130.00n ng=1
MN7 net3 int_GATE net5 VSS sg13_lv_nmos m=1 w=640.00n l=130.00n ng=1
MN4 int_GATE net1 VSS VSS sg13_lv_nmos m=1 w=740.00n l=130.00n ng=1
MN1 CLKBB CLKB VSS VSS sg13_lv_nmos m=1 w=740.00n l=130.00n ng=1
MN6 net7 int_GATE VSS VSS sg13_lv_nmos m=1 w=420.00n l=130.00n ng=1
MN3 net2 GATE VSS VSS sg13_lv_nmos m=1 w=640.00n l=130.00n ng=1
MN5 net1 CLKBB net7 VSS sg13_lv_nmos m=1 w=420.00n l=130.00n ng=1
MN0 CLKB CLK VSS VSS sg13_lv_nmos m=1 w=740.00n l=130.00n ng=1
MN8 net5 CLK VSS VSS sg13_lv_nmos m=1 w=640.00n l=130.00n ng=1
MN2 net1 CLKB net2 VSS sg13_lv_nmos m=1 w=640.00n l=130.00n ng=1
.ENDS

************************************************************************
* Library Name: sg13g2_stdcell
* Cell Name:    sg13g2_mux2_1
* View Name:    schematic
************************************************************************

.SUBCKT sg13g2_mux2_1 X A0 A1 S VDD VSS
*.PININFO A0:I A1:I S:I X:O VDD:B VSS:B
MP1 net4 S VDD VDD sg13_lv_pmos m=1 w=1.000u l=130.00n ng=1
MP5 X net6 VDD VDD sg13_lv_pmos m=1 w=1.12u l=130.00n ng=1
MP4 net6 A1 net5 VDD sg13_lv_pmos m=1 w=1.000u l=130.00n ng=1
MP0 Sb S VDD VDD sg13_lv_pmos m=1 w=840.00n l=130.00n ng=1
MP3 net5 Sb VDD VDD sg13_lv_pmos m=1 w=1.000u l=130.00n ng=1
MP2 net6 A0 net4 VDD sg13_lv_pmos m=1 w=1.000u l=130.00n ng=1
MN4 net3 S VSS VSS sg13_lv_nmos m=1 w=740.00n l=130.00n ng=1
MN2 net1 Sb VSS VSS sg13_lv_nmos m=1 w=740.00n l=130.00n ng=1
MN5 X net6 VSS VSS sg13_lv_nmos m=1 w=740.00n l=130.00n ng=1
MN0 Sb S VSS VSS sg13_lv_nmos m=1 w=550.00n l=130.00n ng=1
MN3 net6 A1 net3 VSS sg13_lv_nmos m=1 w=740.00n l=130.00n ng=1
MN1 net6 A0 net1 VSS sg13_lv_nmos m=1 w=740.00n l=130.00n ng=1
.ENDS

************************************************************************
* Library Name: sg13g2_stdcell
* Cell Name:    sg13g2_mux2_2
* View Name:    schematic
************************************************************************

.SUBCKT sg13g2_mux2_2 X A0 A1 S VDD VSS
*.PININFO A0:I A1:I S:I X:O VDD:B VSS:B
MP1 net4 S VDD VDD sg13_lv_pmos m=1 w=1.000u l=130.00n ng=1
MP5 X net6 VDD VDD sg13_lv_pmos m=1 w=2.24u l=130.00n ng=2
MP4 net6 A1 net5 VDD sg13_lv_pmos m=1 w=1.000u l=130.00n ng=1
MP0 Sb S VDD VDD sg13_lv_pmos m=1 w=840.00n l=130.00n ng=1
MP3 net5 Sb VDD VDD sg13_lv_pmos m=1 w=1.000u l=130.00n ng=1
MP2 net6 A0 net4 VDD sg13_lv_pmos m=1 w=1.000u l=130.00n ng=1
MN4 net3 S VSS VSS sg13_lv_nmos m=1 w=740.00n l=130.00n ng=1
MN2 net1 Sb VSS VSS sg13_lv_nmos m=1 w=740.00n l=130.00n ng=1
MN5 X net6 VSS VSS sg13_lv_nmos m=1 w=1.48u l=130.00n ng=2
MN0 Sb S VSS VSS sg13_lv_nmos m=1 w=550.00n l=130.00n ng=1
MN3 net6 A1 net3 VSS sg13_lv_nmos m=1 w=740.00n l=130.00n ng=1
MN1 net6 A0 net1 VSS sg13_lv_nmos m=1 w=740.00n l=130.00n ng=1
.ENDS

************************************************************************
* Library Name: sg13g2_stdcell
* Cell Name:    sg13g2_mux4_1
* View Name:    schematic
************************************************************************

.SUBCKT sg13g2_mux4_1 X A0 A1 A2 A3 S0 S1 VDD VSS
*.PININFO A0:I A1:I A2:I A3:I S0:I S1:I X:O VDD:B VSS:B
MN12 X Xb VSS VSS sg13_lv_nmos m=1 w=740.00n l=130.00n ng=1
MN2 low S0b net7 VSS sg13_lv_nmos m=1 w=640.00n l=130.00n ng=1
MN3 net7 A0 VSS VSS sg13_lv_nmos m=1 w=640.00n l=130.00n ng=1
MN6 low S1b Xb VSS sg13_lv_nmos m=1 w=640.00n l=130.00n ng=1
MN11 high S1 Xb VSS sg13_lv_nmos m=1 w=640.00n l=130.00n ng=1
MN10 net4 A3 VSS VSS sg13_lv_nmos m=1 w=640.00n l=130.00n ng=1
MN9 high S0 net4 VSS sg13_lv_nmos m=1 w=640.00n l=130.00n ng=1
MN8 net6 A2 VSS VSS sg13_lv_nmos m=1 w=640.00n l=130.00n ng=1
MN7 high S0b net6 VSS sg13_lv_nmos m=1 w=640.00n l=130.00n ng=1
MN5 net2 A1 VSS VSS sg13_lv_nmos m=1 w=640.00n l=130.00n ng=1
MN4 low S0 net2 VSS sg13_lv_nmos m=1 w=640.00n l=130.00n ng=1
MN1 S1b S1 VSS VSS sg13_lv_nmos m=1 w=640.00n l=130.00n ng=1
MN0 S0b S0 VSS VSS sg13_lv_nmos m=1 w=640.00n l=130.00n ng=1
MP6 low S1 Xb VDD sg13_lv_pmos m=1 w=1.000u l=130.00n ng=1
MP11 high S1b Xb VDD sg13_lv_pmos m=1 w=1.000u l=130.00n ng=1
MP12 X Xb VDD VDD sg13_lv_pmos m=1 w=1.12u l=130.00n ng=1
MP10 high S0b net3 VDD sg13_lv_pmos m=1 w=1.000u l=130.00n ng=1
MP9 net3 A3 VDD VDD sg13_lv_pmos m=1 w=1.000u l=130.00n ng=1
MP8 high S0 net5 VDD sg13_lv_pmos m=1 w=1.000u l=130.00n ng=1
MP7 net5 A2 VDD VDD sg13_lv_pmos m=1 w=1.000u l=130.00n ng=1
MP2 net8 A0 VDD VDD sg13_lv_pmos m=1 w=1.000u l=130.00n ng=1
MP3 low S0 net8 VDD sg13_lv_pmos m=1 w=1.000u l=130.00n ng=1
MP1 S1b S1 VDD VDD sg13_lv_pmos m=1 w=1.000u l=130.00n ng=1
MP0 S0b S0 VDD VDD sg13_lv_pmos m=1 w=1.000u l=130.00n ng=1
MP5 low S0b net1 VDD sg13_lv_pmos m=1 w=1.000u l=130.00n ng=1
MP4 net1 A1 VDD VDD sg13_lv_pmos m=1 w=1.000u l=130.00n ng=1
.ENDS

************************************************************************
* Library Name: sg13g2_stdcell
* Cell Name:    sg13g2_nand2_1
* View Name:    schematic
************************************************************************

.SUBCKT sg13g2_nand2_1 Y A B VDD VSS
*.PININFO A:I B:I Y:O VDD:B VSS:B
MP1 Y B VDD VDD sg13_lv_pmos m=1 w=1.12u l=130.00n ng=1
MP0 Y A VDD VDD sg13_lv_pmos m=1 w=1.12u l=130.00n ng=1
MN1 net1 B VSS VSS sg13_lv_nmos m=1 w=740.00n l=130.00n ng=1
MN0 Y A net1 VSS sg13_lv_nmos m=1 w=740.00n l=130.00n ng=1
.ENDS

************************************************************************
* Library Name: sg13g2_stdcell
* Cell Name:    sg13g2_nand2_2
* View Name:    schematic
************************************************************************

.SUBCKT sg13g2_nand2_2 Y A B VDD VSS
*.PININFO A:I B:I Y:O VDD:B VSS:B
MP1 Y B VDD VDD sg13_lv_pmos m=1 w=2.24u l=130.00n ng=2
MP0 Y A VDD VDD sg13_lv_pmos m=1 w=2.24u l=130.00n ng=2
MN1 net1 B VSS VSS sg13_lv_nmos m=1 w=1.44u l=130.00n ng=2
MN0 Y A net1 VSS sg13_lv_nmos m=1 w=1.44u l=130.00n ng=2
.ENDS

************************************************************************
* Library Name: sg13g2_stdcell
* Cell Name:    sg13g2_nand2b_1
* View Name:    schematic
************************************************************************

.SUBCKT sg13g2_nand2b_1 Y A_N B VDD VSS
*.PININFO A_N:I B:I Y:O VDD:B VSS:B
MP2 Y net2 VDD VDD sg13_lv_pmos m=1 w=1.12u l=130.00n ng=1
MP1 net2 A_N VDD VDD sg13_lv_pmos m=1 w=840.00n l=130.00n ng=1
MP0 Y B VDD VDD sg13_lv_pmos m=1 w=1.12u l=130.00n ng=1
MN1 Y net2 net1 VSS sg13_lv_nmos m=1 w=740.00n l=130.00n ng=1
MN0 net2 A_N VSS VSS sg13_lv_nmos m=1 w=550.00n l=130.00n ng=1
MN2 net1 B VSS VSS sg13_lv_nmos m=1 w=740.00n l=130.00n ng=1
.ENDS

************************************************************************
* Library Name: sg13g2_stdcell
* Cell Name:    sg13g2_nand2b_2
* View Name:    schematic
************************************************************************

.SUBCKT sg13g2_nand2b_2 Y A_N B VDD VSS
*.PININFO A_N:I B:I Y:O VDD:B VSS:B
MP2 Y A VDD VDD sg13_lv_pmos m=1 w=2.24u l=130.00n ng=2
MP0 A A_N VDD VDD sg13_lv_pmos m=1 w=840.00n l=130.00n ng=1
MP1 Y B VDD VDD sg13_lv_pmos m=1 w=2.24u l=130.00n ng=2
MN1 Y B net1 VSS sg13_lv_nmos m=1 w=1.44u l=130.00n ng=2
MN0 A A_N VSS VSS sg13_lv_nmos m=1 w=550.00n l=130.00n ng=1
MN2 net1 A VSS VSS sg13_lv_nmos m=1 w=1.44u l=130.00n ng=2
.ENDS

************************************************************************
* Library Name: sg13g2_stdcell
* Cell Name:    sg13g2_nand3_1
* View Name:    schematic
************************************************************************

.SUBCKT sg13g2_nand3_1 Y A B C VDD VSS
*.PININFO A:I B:I C:I Y:O VDD:B VSS:B
MP0 Y A VDD VDD sg13_lv_pmos m=1 w=1.12u l=130.00n ng=1
MP1 Y B VDD VDD sg13_lv_pmos m=1 w=1.12u l=130.00n ng=1
MP2 Y C VDD VDD sg13_lv_pmos m=1 w=1.12u l=130.00n ng=1
MN1 net2 B net3 VSS sg13_lv_nmos m=1 w=740.00n l=130.00n ng=1
MN2 net3 C VSS VSS sg13_lv_nmos m=1 w=740.00n l=130.00n ng=1
MN0 Y A net2 VSS sg13_lv_nmos m=1 w=740.00n l=130.00n ng=1
.ENDS

************************************************************************
* Library Name: sg13g2_stdcell
* Cell Name:    sg13g2_nand3b_1
* View Name:    schematic
************************************************************************

.SUBCKT sg13g2_nand3b_1 Y A_N B C VDD VSS
*.PININFO A_N:I B:I C:I Y:O VDD:B VSS:B
MP0 net1 A_N VDD VDD sg13_lv_pmos m=1 w=840.00n l=130.00n ng=1
MP1 Y net1 VDD VDD sg13_lv_pmos m=1 w=1.12u l=130.00n ng=1
MP2 Y B VDD VDD sg13_lv_pmos m=1 w=1.12u l=130.00n ng=1
MP3 Y C VDD VDD sg13_lv_pmos m=1 w=1.12u l=130.00n ng=1
MN2 net2 B net3 VSS sg13_lv_nmos m=1 w=740.00n l=130.00n ng=1
MN3 net3 C VSS VSS sg13_lv_nmos m=1 w=740.00n l=130.00n ng=1
MN0 net1 A_N VSS VSS sg13_lv_nmos m=1 w=550.00n l=130.00n ng=1
MN1 Y net1 net2 VSS sg13_lv_nmos m=1 w=740.00n l=130.00n ng=1
.ENDS

************************************************************************
* Library Name: sg13g2_stdcell
* Cell Name:    sg13g2_nand4_1
* View Name:    schematic
************************************************************************

.SUBCKT sg13g2_nand4_1 Y A B C D VDD VSS
*.PININFO A:I B:I C:I D:I Y:O VDD:B VSS:B
MP3 Y D VDD VDD sg13_lv_pmos m=1 w=1.12u l=130.00n ng=1
MP0 Y A VDD VDD sg13_lv_pmos m=1 w=1.12u l=130.00n ng=1
MP1 Y B VDD VDD sg13_lv_pmos m=1 w=1.12u l=130.00n ng=1
MP2 Y C VDD VDD sg13_lv_pmos m=1 w=1.12u l=130.00n ng=1
MN1 net2 B net3 VSS sg13_lv_nmos m=1 w=740.00n l=130.00n ng=1
MN2 net3 C net5 VSS sg13_lv_nmos m=1 w=740.00n l=130.00n ng=1
MN0 Y A net2 VSS sg13_lv_nmos m=1 w=740.00n l=130.00n ng=1
MN3 net5 D VSS VSS sg13_lv_nmos m=1 w=740.00n l=130.00n ng=1
.ENDS

************************************************************************
* Library Name: sg13g2_stdcell
* Cell Name:    sg13g2_nor2_1
* View Name:    schematic
************************************************************************

.SUBCKT sg13g2_nor2_1 Y A B VDD VSS
*.PININFO A:I B:I Y:O VDD:B VSS:B
MN0 Y A VSS VSS sg13_lv_nmos m=1 w=740.00n l=130.00n ng=1
MN1 Y B VSS VSS sg13_lv_nmos m=1 w=740.00n l=130.00n ng=1
MP0 net1 A VDD VDD sg13_lv_pmos m=1 w=1.12u l=130.00n ng=1
MP1 Y B net1 VDD sg13_lv_pmos m=1 w=1.12u l=130.00n ng=1
.ENDS

************************************************************************
* Library Name: sg13g2_stdcell
* Cell Name:    sg13g2_nor2_2
* View Name:    schematic
************************************************************************

.SUBCKT sg13g2_nor2_2 Y A B VDD VSS
*.PININFO A:I B:I Y:O VDD:B VSS:B
MN0 Y A VSS VSS sg13_lv_nmos m=1 w=1.48u l=130.00n ng=2
MN1 Y B VSS VSS sg13_lv_nmos m=1 w=1.48u l=130.00n ng=2
MP0 net1 A VDD VDD sg13_lv_pmos m=1 w=2.24u l=130.00n ng=2
MP1 Y B net1 VDD sg13_lv_pmos m=1 w=2.24u l=130.00n ng=2
.ENDS

************************************************************************
* Library Name: sg13g2_stdcell
* Cell Name:    sg13g2_nor2b_1
* View Name:    schematic
************************************************************************

.SUBCKT sg13g2_nor2b_1 Y A B_N VDD VSS
*.PININFO A:I B_N:I Y:O VDD:B VSS:B
MN0 B B_N VSS VSS sg13_lv_nmos m=1 w=550.00n l=130.00n ng=1
MN1 Y A VSS VSS sg13_lv_nmos m=1 w=740.00n l=130.00n ng=1
MN2 Y B VSS VSS sg13_lv_nmos m=1 w=740.00n l=130.00n ng=1
MP0 B B_N VDD VDD sg13_lv_pmos m=1 w=840.00n l=130.00n ng=1
MP1 net1 B VDD VDD sg13_lv_pmos m=1 w=1.12u l=130.00n ng=1
MP2 Y A net1 VDD sg13_lv_pmos m=1 w=1.12u l=130.00n ng=1
.ENDS

************************************************************************
* Library Name: sg13g2_stdcell
* Cell Name:    sg13g2_nor2b_2
* View Name:    schematic
************************************************************************

.SUBCKT sg13g2_nor2b_2 Y A B_N VDD VSS
*.PININFO A:I B_N:I Y:O VDD:B VSS:B
MN0 B B_N VSS VSS sg13_lv_nmos m=1 w=640.00n l=130.00n ng=1
MN1 Y A VSS VSS sg13_lv_nmos m=1 w=1.44u l=130.00n ng=2
MN2 Y B VSS VSS sg13_lv_nmos m=1 w=1.44u l=130.00n ng=2
MP0 B B_N VDD VDD sg13_lv_pmos m=1 w=1.000u l=130.00n ng=1
MP1 net1 B VDD VDD sg13_lv_pmos m=1 w=2.24u l=130.00n ng=2
MP2 Y A net1 VDD sg13_lv_pmos m=1 w=2.24u l=130.00n ng=2
.ENDS

************************************************************************
* Library Name: sg13g2_stdcell
* Cell Name:    sg13g2_nor3_1
* View Name:    schematic
************************************************************************

.SUBCKT sg13g2_nor3_1 Y A B C VDD VSS
*.PININFO A:I B:I C:I Y:O VDD:B VSS:B
MP2 Y C net2 VDD sg13_lv_pmos m=1 w=1.12u l=130.00n ng=1
MP1 net2 B net3 VDD sg13_lv_pmos m=1 w=1.12u l=130.00n ng=1
MP0 net3 A VDD VDD sg13_lv_pmos m=1 w=1.12u l=130.00n ng=1
MN0 Y A VSS VSS sg13_lv_nmos m=1 w=770.00n l=130.00n ng=1
MN1 Y B VSS VSS sg13_lv_nmos m=1 w=770.00n l=130.00n ng=1
MN2 Y C VSS VSS sg13_lv_nmos m=1 w=770.00n l=130.00n ng=1
.ENDS

************************************************************************
* Library Name: sg13g2_stdcell
* Cell Name:    sg13g2_nor3_2
* View Name:    schematic
************************************************************************

.SUBCKT sg13g2_nor3_2 Y A B C VDD VSS
*.PININFO A:I B:I C:I Y:O VDD:B VSS:B
MP2 Y C net2 VDD sg13_lv_pmos m=1 w=2.24u l=130.00n ng=2
MP1 net2 B net3 VDD sg13_lv_pmos m=1 w=2.24u l=130.00n ng=2
MP0 net3 A VDD VDD sg13_lv_pmos m=1 w=2.24u l=130.00n ng=2
MN0 Y A VSS VSS sg13_lv_nmos m=1 w=1.48u l=130.00n ng=2
MN1 Y B VSS VSS sg13_lv_nmos m=1 w=1.48u l=130.00n ng=2
MN2 Y C VSS VSS sg13_lv_nmos m=1 w=1.48u l=130.00n ng=2
.ENDS

************************************************************************
* Library Name: sg13g2_stdcell
* Cell Name:    sg13g2_nor4_1
* View Name:    schematic
************************************************************************

.SUBCKT sg13g2_nor4_1 Y A B C D VDD VSS
*.PININFO A:I B:I C:I D:I Y:O VDD:B VSS:B
MP0 net3 A VDD VDD sg13_lv_pmos m=1 w=1.12u l=130.00n ng=1
MP1 net2 B net3 VDD sg13_lv_pmos m=1 w=1.12u l=130.00n ng=1
MP2 net1 C net2 VDD sg13_lv_pmos m=1 w=1.12u l=130.00n ng=1
MP3 Y D net1 VDD sg13_lv_pmos m=1 w=1.12u l=130.00n ng=1
MN0 Y A VSS VSS sg13_lv_nmos m=1 w=740.00n l=130.00n ng=1
MN3 Y D VSS VSS sg13_lv_nmos m=1 w=740.00n l=130.00n ng=1
MN1 Y B VSS VSS sg13_lv_nmos m=1 w=740.00n l=130.00n ng=1
MN2 Y C VSS VSS sg13_lv_nmos m=1 w=740.00n l=130.00n ng=1
.ENDS

************************************************************************
* Library Name: sg13g2_stdcell
* Cell Name:    sg13g2_nor4_2
* View Name:    schematic
************************************************************************

.SUBCKT sg13g2_nor4_2 Y A B C D VDD VSS
*.PININFO A:I B:I C:I D:I Y:O VDD:B VSS:B
MP0 net3 A VDD VDD sg13_lv_pmos m=1 w=2.24u l=130.00n ng=2
MP1 net2 B net3 VDD sg13_lv_pmos m=1 w=2.24u l=130.00n ng=2
MP2 net1 C net2 VDD sg13_lv_pmos m=1 w=2.24u l=130.00n ng=2
MP3 Y D net1 VDD sg13_lv_pmos m=1 w=2.24u l=130.00n ng=2
MN0 Y A VSS VSS sg13_lv_nmos m=1 w=1.48u l=130.00n ng=2
MN3 Y D VSS VSS sg13_lv_nmos m=1 w=1.48u l=130.00n ng=2
MN1 Y B VSS VSS sg13_lv_nmos m=1 w=1.48u l=130.00n ng=2
MN2 Y C VSS VSS sg13_lv_nmos m=1 w=1.48u l=130.00n ng=2
.ENDS

************************************************************************
* Library Name: sg13g2_stdcell
* Cell Name:    sg13g2_o21ai_1
* View Name:    schematic
************************************************************************

.SUBCKT sg13g2_o21ai_1 Y A1 A2 B1 VDD VSS
*.PININFO A1:I A2:I B1:I Y:O VDD:B VSS:B
MP0 net14 A1 VDD VDD sg13_lv_pmos m=1 w=1.12u l=150.00n ng=1
MP1 Y A2 net14 VDD sg13_lv_pmos m=1 w=1.12u l=150.00n ng=1
MP2 Y B1 VDD VDD sg13_lv_pmos m=1 w=1.12u l=150.00n ng=1
MN0 net1 A2 VSS VSS sg13_lv_nmos m=1 w=740.00n l=150.00n ng=1
MN2 net1 A1 VSS VSS sg13_lv_nmos m=1 w=740.00n l=150.00n ng=1
MN1 Y B1 net1 VSS sg13_lv_nmos m=1 w=740.00n l=150.00n ng=1
.ENDS

************************************************************************
* Library Name: sg13g2_stdcell
* Cell Name:    sg13g2_or2_1
* View Name:    schematic
************************************************************************

.SUBCKT sg13g2_or2_1 X A B VDD VSS
*.PININFO A:I B:I X:O VDD:B VSS:B
MP1 net2 B net3 VDD sg13_lv_pmos m=1 w=840.00n l=130.00n ng=1
MP0 net3 A VDD VDD sg13_lv_pmos m=1 w=840.00n l=130.00n ng=1
MP2 X net2 VDD VDD sg13_lv_pmos m=1 w=1.12u l=130.00n ng=1
MN1 net2 A VSS VSS sg13_lv_nmos m=1 w=550.00n l=130.00n ng=1
MN0 net2 B VSS VSS sg13_lv_nmos m=1 w=550.00n l=130.00n ng=1
MN2 X net2 VSS VSS sg13_lv_nmos m=1 w=740.00n l=130.00n ng=1
.ENDS

************************************************************************
* Library Name: sg13g2_stdcell
* Cell Name:    sg13g2_or2_2
* View Name:    schematic
************************************************************************

.SUBCKT sg13g2_or2_2 X A B VDD VSS
*.PININFO A:I B:I X:O VDD:B VSS:B
MP1 net2 B net3 VDD sg13_lv_pmos m=1 w=840.00n l=130.00n ng=1
MP0 net3 A VDD VDD sg13_lv_pmos m=1 w=840.00n l=130.00n ng=1
MP2 X net2 VDD VDD sg13_lv_pmos m=1 w=2.24u l=130.00n ng=2
MN1 net2 A VSS VSS sg13_lv_nmos m=1 w=550.00n l=130.00n ng=1
MN0 net2 B VSS VSS sg13_lv_nmos m=1 w=550.00n l=130.00n ng=1
MN2 X net2 VSS VSS sg13_lv_nmos m=1 w=1.48u l=130.00n ng=2
.ENDS

************************************************************************
* Library Name: sg13g2_stdcell
* Cell Name:    sg13g2_or3_1
* View Name:    schematic
************************************************************************

.SUBCKT sg13g2_or3_1 X A B C VDD VSS
*.PININFO A:I B:I C:I X:O VDD:B VSS:B
MN2 net1 C VSS VSS sg13_lv_nmos m=1 w=550.00n l=130.00n ng=1
MN3 X net1 VSS VSS sg13_lv_nmos m=1 w=740.00n l=130.00n ng=1
MN1 net1 B VSS VSS sg13_lv_nmos m=1 w=550.00n l=130.00n ng=1
MN0 net1 A VSS VSS sg13_lv_nmos m=1 w=550.00n l=130.00n ng=1
MP3 X net1 VDD VDD sg13_lv_pmos m=1 w=1.12u l=130.00n ng=1
MP1 net9 B net12 VDD sg13_lv_pmos m=1 w=1.000u l=130.00n ng=1
MP0 net12 A VDD VDD sg13_lv_pmos m=1 w=1.000u l=130.00n ng=1
MP2 net1 C net9 VDD sg13_lv_pmos m=1 w=1.000u l=130.00n ng=1
.ENDS

************************************************************************
* Library Name: sg13g2_stdcell
* Cell Name:    sg13g2_or3_2
* View Name:    schematic
************************************************************************

.SUBCKT sg13g2_or3_2 X A B C VDD VSS
*.PININFO A:I B:I C:I X:O VDD:B VSS:B
MN2 net1 C VSS VSS sg13_lv_nmos m=1 w=550.00n l=130.00n ng=1
MN3 X net1 VSS VSS sg13_lv_nmos m=1 w=1.48u l=130.00n ng=2
MN1 net1 B VSS VSS sg13_lv_nmos m=1 w=550.00n l=130.00n ng=1
MN0 net1 A VSS VSS sg13_lv_nmos m=1 w=550.00n l=130.00n ng=1
MP3 X net1 VDD VDD sg13_lv_pmos m=1 w=2.24u l=130.00n ng=2
MP1 net9 B net12 VDD sg13_lv_pmos m=1 w=1.000u l=130.00n ng=1
MP0 net12 A VDD VDD sg13_lv_pmos m=1 w=1.000u l=130.00n ng=1
MP2 net1 C net9 VDD sg13_lv_pmos m=1 w=1.000u l=130.00n ng=1
.ENDS

************************************************************************
* Library Name: sg13g2_stdcell
* Cell Name:    sg13g2_or4_1
* View Name:    schematic
************************************************************************

.SUBCKT sg13g2_or4_1 X A B C D VDD VSS
*.PININFO A:I B:I C:I D:I X:O VDD:B VSS:B
MN4 X net1 VSS VSS sg13_lv_nmos m=1 w=740.00n l=130.00n ng=1
MN3 net1 D VSS VSS sg13_lv_nmos m=1 w=550.00n l=130.00n ng=1
MN2 net1 C VSS VSS sg13_lv_nmos m=1 w=550.00n l=130.00n ng=1
MN1 net1 B VSS VSS sg13_lv_nmos m=1 w=550.00n l=130.00n ng=1
MN0 net1 A VSS VSS sg13_lv_nmos m=1 w=550.00n l=130.00n ng=1
MP0 net4 A VDD VDD sg13_lv_pmos m=1 w=1.000u l=130.00n ng=1
MP1 net3 B net4 VDD sg13_lv_pmos m=1 w=1.000u l=130.00n ng=1
MP2 net2 C net3 VDD sg13_lv_pmos m=1 w=1.000u l=130.00n ng=1
MP3 net1 D net2 VDD sg13_lv_pmos m=1 w=1.000u l=130.00n ng=1
MP4 X net1 VDD VDD sg13_lv_pmos m=1 w=1.12u l=130.00n ng=1
.ENDS

************************************************************************
* Library Name: sg13g2_stdcell
* Cell Name:    sg13g2_or4_2
* View Name:    schematic
************************************************************************

.SUBCKT sg13g2_or4_2 X A B C D VDD VSS
*.PININFO A:I B:I C:I D:I X:O VDD:B VSS:B
MN4 X net1 VSS VSS sg13_lv_nmos m=1 w=1.48u l=130.00n ng=2
MN3 net1 D VSS VSS sg13_lv_nmos m=1 w=550.00n l=130.00n ng=1
MN2 net1 C VSS VSS sg13_lv_nmos m=1 w=550.00n l=130.00n ng=1
MN1 net1 B VSS VSS sg13_lv_nmos m=1 w=550.00n l=130.00n ng=1
MN0 net1 A VSS VSS sg13_lv_nmos m=1 w=550.00n l=130.00n ng=1
MP0 net4 A VDD VDD sg13_lv_pmos m=1 w=1.000u l=130.00n ng=1
MP1 net3 B net4 VDD sg13_lv_pmos m=1 w=1.000u l=130.00n ng=1
MP2 net2 C net3 VDD sg13_lv_pmos m=1 w=1.000u l=130.00n ng=1
MP3 net1 D net2 VDD sg13_lv_pmos m=1 w=1.000u l=130.00n ng=1
MP4 X net1 VDD VDD sg13_lv_pmos m=1 w=2.24u l=130.00n ng=2
.ENDS

************************************************************************
* Library Name: sg13g2_stdcell
* Cell Name:    sg13g2_sdfbbp_1
* View Name:    schematic
************************************************************************

.SUBCKT sg13g2_sdfbbp_1 Q Q_N CLK D RESET_B SCD SCE SET_B VDD VSS
*.PININFO CLK:I D:I RESET_B:I SCD:I SCE:I SET_B:I Q:O Q_N:O VDD:B VSS:B
MP1 resetbb RESET_B VDD VDD sg13_lv_pmos m=1 w=640.00n l=130.00n ng=1
MP19 pre_q DbbLatch2 net8 VDD sg13_lv_pmos m=1 w=1.000u l=130.00n ng=1
MP20 pre_q SET_B VDD VDD sg13_lv_pmos m=1 w=1.000u l=130.00n ng=1
MP3 CLKbb CLKb VDD VDD sg13_lv_pmos m=1 w=1.12u l=130.00n ng=1
MP0 SCEb SCE VDD VDD sg13_lv_pmos m=1 w=640.00n l=130.00n ng=1
MP7 Db D net3 VDD sg13_lv_pmos m=1 w=640.00n l=130.00n ng=1
MP13 DbbTG CLKb net10 VDD sg13_lv_pmos m=1 w=420.00n l=130.00n ng=1
MP12 net10 DbLatchM VDD VDD sg13_lv_pmos m=1 w=420.00n l=130.00n ng=1
MP6 net3 SCE VDD VDD sg13_lv_pmos m=1 w=640.00n l=130.00n ng=1
MP21 Q_N pre_q VDD VDD sg13_lv_pmos m=1 w=1.12u l=130.00n ng=1
MP14 net1 DbLatchM VDD VDD sg13_lv_pmos m=1 w=840.00n l=130.00n ng=1
MP18 net8 resetbb VDD VDD sg13_lv_pmos m=1 w=1.000u l=130.00n ng=1
MP11 DbLatchM SET_B VDD VDD sg13_lv_pmos m=1 w=840.00n l=130.00n ng=1
MP4 net2 SCD VDD VDD sg13_lv_pmos m=1 w=640.00n l=130.00n ng=1
MP2 CLKb CLK VDD VDD sg13_lv_pmos m=1 w=1.12u l=130.00n ng=1
MP10 DbLatchM DbbTG net7 VDD sg13_lv_pmos m=1 w=840.00n l=130.00n ng=1
MP8 Db CLKbb DbbTG VDD sg13_lv_pmos m=1 w=640.00n l=130.00n ng=1
MP5 Db SCEb net2 VDD sg13_lv_pmos m=1 w=640.00n l=130.00n ng=1
MP22 pre_qb pre_q VDD VDD sg13_lv_pmos m=1 w=840.00n l=130.00n ng=1
MP9 net7 resetbb VDD VDD sg13_lv_pmos m=1 w=840.00n l=130.00n ng=1
MP16 net6 pre_q VDD VDD sg13_lv_pmos m=1 w=420.00n l=130.00n ng=1
MP17 DbbLatch2 CLKbb net6 VDD sg13_lv_pmos m=1 w=420.00n l=130.00n ng=1
MP15 DbbLatch2 CLKb net1 VDD sg13_lv_pmos m=1 w=840.00n l=130.00n ng=1
MP23 Q pre_qb VDD VDD sg13_lv_pmos m=1 w=1.12u l=130.00n ng=1
MN4 Db SCE net5 VSS sg13_lv_nmos m=1 w=420.00n l=130.00n ng=1
MN5 net5 SCD VSS VSS sg13_lv_nmos m=1 w=420.00n l=130.00n ng=1
MN18 pre_q DbbLatch2 net11 VSS sg13_lv_nmos m=1 w=740.00n l=130.00n ng=1
MN8 Db CLKb DbbTG VSS sg13_lv_nmos m=1 w=420.00n l=130.00n ng=1
MN7 net4 SCEb VSS VSS sg13_lv_nmos m=1 w=420.00n l=130.00n ng=1
MN3 CLKbb CLKb VSS VSS sg13_lv_nmos m=1 w=740.00n l=130.00n ng=1
MN1 resetbb RESET_B VSS VSS sg13_lv_nmos m=1 w=420.00n l=130.00n ng=1
MN17 net14 pre_q VSS VSS sg13_lv_nmos m=1 w=420.00n l=130.00n ng=1
MN9 DbLatchM DbbTG net12 VSS sg13_lv_nmos m=1 w=550.00n l=130.00n ng=1
MN0 SCEb SCE VSS VSS sg13_lv_nmos m=1 w=420.00n l=130.00n ng=1
MN10 net12 SET_B VSS VSS sg13_lv_nmos m=1 w=550.00n l=130.00n ng=1
MN13 net15 DbLatchM VSS VSS sg13_lv_nmos m=1 w=420.00n l=130.00n ng=1
MN19 net11 SET_B VSS VSS sg13_lv_nmos m=1 w=740.00n l=130.00n ng=1
MN12 DbbTG CLKbb net15 VSS sg13_lv_nmos m=1 w=420.00n l=130.00n ng=1
MN6 Db D net4 VSS sg13_lv_nmos m=1 w=420.00n l=130.00n ng=1
MN22 pre_qb pre_q VSS VSS sg13_lv_nmos m=1 w=550.00n l=130.00n ng=1
MN16 DbbLatch2 CLKb net14 VSS sg13_lv_nmos m=1 w=420.00n l=130.00n ng=1
MN23 Q pre_qb VSS VSS sg13_lv_nmos m=1 w=740.00n l=130.00n ng=1
MN15 net13 DbLatchM VSS VSS sg13_lv_nmos m=1 w=550.00n l=130.00n ng=1
MN2 CLKb CLK VSS VSS sg13_lv_nmos m=1 w=740.00n l=130.00n ng=1
MN14 DbbLatch2 CLKbb net13 VSS sg13_lv_nmos m=1 w=550.00n l=130.00n ng=1
MN11 DbLatchM resetbb net12 VSS sg13_lv_nmos m=1 w=550.00n l=130.00n ng=1
MN21 Q_N pre_q VSS VSS sg13_lv_nmos m=1 w=740.00n l=130.00n ng=1
MN20 pre_q resetbb net11 VSS sg13_lv_nmos m=1 w=740.00n l=130.00n ng=1
.ENDS

************************************************************************
* Library Name: sg13g2_stdcell
* Cell Name:    sg13g2_sighold
* View Name:    schematic
************************************************************************

.SUBCKT sg13g2_sighold SH VDD VSS
*.PININFO SH:B VDD:B VSS:B
MN1 net1 SH VSS VSS sg13_lv_nmos m=1 w=300.0n l=130.00n ng=1
MN0 SH net1 VSS VSS sg13_lv_nmos m=1 w=300.0n l=700.0n ng=1
MP1 net1 SH VDD VDD sg13_lv_pmos m=1 w=450.00n l=130.00n ng=1
MP0 SH net1 VDD VDD sg13_lv_pmos m=1 w=300.0n l=700.0n ng=1
.ENDS

************************************************************************
* Library Name: sg13g2_stdcell
* Cell Name:    sg13g2_slgcp_1
* View Name:    schematic
************************************************************************

.SUBCKT sg13g2_slgcp_1 GCLK CLK GATE SCE VDD VSS
*.PININFO CLK:I GATE:I SCE:I GCLK:O VDD:B VSS:B
MP10 GCLK net5 VDD VDD sg13_lv_pmos m=1 w=1.12u l=130.00n ng=1
MP4 net1 CLKbb net6 VDD sg13_lv_pmos m=1 w=840.00n l=130.00n ng=1
MP1 CLKbb CLKb VDD VDD sg13_lv_pmos m=1 w=840.00n l=130.00n ng=1
MP8 net5 int_GATE VDD VDD sg13_lv_pmos m=1 w=840.00n l=130.00n ng=1
MP2 net3 SCE VDD VDD sg13_lv_pmos m=1 w=840.00n l=130.00n ng=1
MP7 net6 CLKb net4 VDD sg13_lv_pmos m=1 w=420.00n l=130.00n ng=1
MP5 int_GATE net6 VDD VDD sg13_lv_pmos m=1 w=1.12u l=130.00n ng=1
MP0 CLKb CLK VDD VDD sg13_lv_pmos m=1 w=840.00n l=130.00n ng=1
MP9 net5 CLK VDD VDD sg13_lv_pmos m=1 w=840.00n l=130.00n ng=1
MP6 net4 int_GATE VDD VDD sg13_lv_pmos m=1 w=420.00n l=130.00n ng=1
MP3 net1 GATE net3 VDD sg13_lv_pmos m=1 w=840.00n l=130.00n ng=1
MN5 int_GATE net6 VSS VSS sg13_lv_nmos m=1 w=740.00n l=130.00n ng=1
MN9 net2 CLK VSS VSS sg13_lv_nmos m=1 w=640.00n l=130.00n ng=1
MN2 net1 SCE VSS VSS sg13_lv_nmos m=1 w=550.00n l=130.00n ng=1
MN4 net6 CLKb net1 VSS sg13_lv_nmos m=1 w=550.00n l=130.00n ng=1
MN7 net7 int_GATE VSS VSS sg13_lv_nmos m=1 w=420.00n l=130.00n ng=1
MN8 net5 int_GATE net2 VSS sg13_lv_nmos m=1 w=640.00n l=130.00n ng=1
MN10 GCLK net5 VSS VSS sg13_lv_nmos m=1 w=740.00n l=130.00n ng=1
MN1 CLKbb CLKb VSS VSS sg13_lv_nmos m=1 w=740.00n l=130.00n ng=1
MN3 net1 GATE VSS VSS sg13_lv_nmos m=1 w=550.00n l=130.00n ng=1
MN0 CLKb CLK VSS VSS sg13_lv_nmos m=1 w=740.00n l=130.00n ng=1
MN6 net6 CLKbb net7 VSS sg13_lv_nmos m=1 w=420.00n l=130.00n ng=1
.ENDS

************************************************************************
* Library Name: sg13g2_stdcell
* Cell Name:    sg13g2_tiehi
* View Name:    schematic
************************************************************************

.SUBCKT sg13g2_tiehi L_HI VDD VSS
*.PININFO L_HI:O VDD:B VSS:B
MN1 net3 net2 VSS VSS sg13_lv_nmos m=1 w=795.00n l=130.00n ng=1
MN0 net1 net1 VSS VSS sg13_lv_nmos m=1 w=300n l=130.00n ng=1
MP1 L_HI net3 VDD VDD sg13_lv_pmos m=1 w=1.155u l=130.00n ng=1
MP0 net2 net1 VDD VDD sg13_lv_pmos m=1 w=660.0n l=130.00n ng=1
.ENDS

************************************************************************
* Library Name: sg13g2_stdcell
* Cell Name:    sg13g2_tielo
* View Name:    schematic
************************************************************************

.SUBCKT sg13g2_tielo L_LO VDD VSS
*.PININFO L_LO:O VDD:B VSS:B
MN0 net3 net2 VSS VSS sg13_lv_nmos m=1 w=385.00n l=130.00n ng=1
MN1 L_LO net1 VSS VSS sg13_lv_nmos m=1 w=880.0n l=130.00n ng=1
MP0 net2 net2 VDD VDD sg13_lv_pmos m=1 w=300n l=130.00n ng=1
MP1 net1 net3 VDD VDD sg13_lv_pmos m=1 w=1.045u l=130.00n ng=1
.ENDS

************************************************************************
* Library Name: sg13g2_stdcell
* Cell Name:    sg13g2_xnor2_1
* View Name:    schematic
************************************************************************

.SUBCKT sg13g2_xnor2_1 Y A B VDD VSS
*.PININFO A:I B:I Y:O VDD:B VSS:B
MP4 Y net1 VDD VDD sg13_lv_pmos m=1 w=1.12u l=130.00n ng=1
MP3 Y B net4 VDD sg13_lv_pmos m=1 w=1.12u l=130.00n ng=1
MP2 net4 A VDD VDD sg13_lv_pmos m=1 w=1.12u l=130.00n ng=1
MP1 net1 B VDD VDD sg13_lv_pmos m=1 w=840.00n l=130.00n ng=1
MP0 net1 A VDD VDD sg13_lv_pmos m=1 w=840.00n l=130.00n ng=1
MN3 Y net1 net3 VSS sg13_lv_nmos m=1 w=740.00n l=130.00n ng=1
MN1 net2 A VSS VSS sg13_lv_nmos m=1 w=640.00n l=130.00n ng=1
MN0 net1 B net2 VSS sg13_lv_nmos m=1 w=640.00n l=130.00n ng=1
MN4 net3 B VSS VSS sg13_lv_nmos m=1 w=740.00n l=130.00n ng=1
MN2 net3 A VSS VSS sg13_lv_nmos m=1 w=740.00n l=130.00n ng=1
.ENDS

************************************************************************
* Library Name: sg13g2_stdcell
* Cell Name:    sg13g2_xor2_1
* View Name:    schematic
************************************************************************

.SUBCKT sg13g2_xor2_1 X A B VDD VSS
*.PININFO A:I B:I X:O VDD:B VSS:B
MN0 net1 A VSS VSS sg13_lv_nmos m=1 w=550.00n l=130.00n ng=1
MN3 X B net3 VSS sg13_lv_nmos m=1 w=740.00n l=130.00n ng=1
MN2 X net1 VSS VSS sg13_lv_nmos m=1 w=740.00n l=130.00n ng=1
MN4 net3 A VSS VSS sg13_lv_nmos m=1 w=740.00n l=130.00n ng=1
MN1 net1 B VSS VSS sg13_lv_nmos m=1 w=550.00n l=130.00n ng=1
MP0 net6 A VDD VDD sg13_lv_pmos m=1 w=1.000u l=130.00n ng=1
MP1 net1 B net6 VDD sg13_lv_pmos m=1 w=1.000u l=130.00n ng=1
MP2 net5 A VDD VDD sg13_lv_pmos m=1 w=1.12u l=130.00n ng=1
MP4 net5 B VDD VDD sg13_lv_pmos m=1 w=1.12u l=130.00n ng=1
MP3 X net1 net5 VDD sg13_lv_pmos m=1 w=1.12u l=130.00n ng=1
.ENDS

************************************************************************
* Library Name: sg13g2_stdcell
* Cell Name:    sg13g2_a22oi_1
* View Name:    schematic
************************************************************************

.SUBCKT sg13g2_a22oi_1 Y A1 A2 B1 B2 VDD VSS
*.PININFO A1:I A2:I B1:I B2:I Y:O VDD:B VSS:B
MN1 net1 B1 VSS VSS sg13_lv_nmos m=1 w=740.00n l=130.00n ng=1
MN0 Y B2 net1 VSS sg13_lv_nmos m=1 w=740.00n l=130.00n ng=1
MN3 net2 A2 VSS VSS sg13_lv_nmos m=1 w=740.00n l=130.00n ng=1
MN2 Y A1 net2 VSS sg13_lv_nmos m=1 w=740.00n l=130.00n ng=1
MP1 Y B1 net3 VDD sg13_lv_pmos m=1 w=1.12u l=130.00n ng=1
MP3 Y B2 net3 VDD sg13_lv_pmos m=1 w=1.12u l=130.00n ng=1
MP2 net3 A2 VDD VDD sg13_lv_pmos m=1 w=1.12u l=130.00n ng=1
MP0 net3 A1 VDD VDD sg13_lv_pmos m=1 w=1.12u l=130.00n ng=1
.ENDS

************************************************************************
* Library Name: sg13g2_stdcell
* Cell Name:    sg13g2_sdfrbpq_1
* View Name:    schematic
************************************************************************

.SUBCKT sg13g2_sdfrbpq_1 Q CLK D RESET_B SCD SCE VDD VSS
*.PININFO CLK:I D:I RESET_B:I SCD:I SCE:I Q:O VDD:B VSS:B
MN3 Db SCD net63 VSS sg13_lv_nmos m=1 w=740.00n l=130.00n ng=1
MN1 Db D net65 VSS sg13_lv_nmos m=1 w=740.00n l=130.00n ng=1
MN0 SCEb SCE VSS VSS sg13_lv_nmos m=1 w=550.00n l=130.00n ng=1
MN4 net63 SCE VSS VSS sg13_lv_nmos m=1 w=740.00n l=130.00n ng=1
MN2 net65 SCEb VSS VSS sg13_lv_nmos m=1 w=740.00n l=130.00n ng=1
MN17 net12 net2 VSS VSS sg13_lv_nmos m=1 w=420.00n l=130.00n ng=1
MN16 net5 clkneg net12 VSS sg13_lv_nmos m=1 w=420.00n l=130.00n ng=1
MN18 net2 net5 net11 VSS sg13_lv_nmos m=1 w=420.00n l=130.00n ng=1
MN19 net11 RESET_B VSS VSS sg13_lv_nmos m=1 w=420.00n l=130.00n ng=1
MN20 Q net2 VSS VSS sg13_lv_nmos m=1 w=740.00n l=130.00n ng=1
MN6 Dbbb Dbb net10 VSS sg13_lv_nmos m=1 w=420.00n l=130.00n ng=1
MN7 net10 RESET_B VSS VSS sg13_lv_nmos m=1 w=420.00n l=130.00n ng=1
MN10 Dbbb clkneg net6 VSS sg13_lv_nmos m=1 w=420.00n l=130.00n ng=1
MN11 net6 clkpos net9 VSS sg13_lv_nmos m=1 w=420.00n l=130.00n ng=1
MN12 net9 net4 net8 VSS sg13_lv_nmos m=1 w=420.00n l=130.00n ng=1
MN13 net8 RESET_B VSS VSS sg13_lv_nmos m=1 w=420.00n l=130.00n ng=1
MN14 net4 net6 VSS VSS sg13_lv_nmos m=1 w=740.00n l=130.00n ng=1
MN8 clkneg CLK VSS VSS sg13_lv_nmos m=1 w=740.00n l=130.00n ng=1
MN15 net4 clkpos net5 VSS sg13_lv_nmos m=1 w=740.00n l=130.00n ng=1
MN9 clkpos clkneg VSS VSS sg13_lv_nmos m=1 w=740.00n l=130.00n ng=1
MN5 Dbb Db VSS VSS sg13_lv_nmos m=1 w=740.00n l=130.00n ng=1
MP1 net64 SCE VDD VDD sg13_lv_pmos m=1 w=1.000u l=130.00n ng=1
MP3 net62 SCEb VDD VDD sg13_lv_pmos m=1 w=1.000u l=130.00n ng=1
MP0 SCEb SCE VDD VDD sg13_lv_pmos m=1 w=840.00n l=130.00n ng=1
MP4 Db SCD net62 VDD sg13_lv_pmos m=1 w=1.000u l=130.00n ng=1
MP2 Db D net64 VDD sg13_lv_pmos m=1 w=1.000u l=130.00n ng=1
MP17 net5 clkpos net3 VDD sg13_lv_pmos m=1 w=420.00n l=130.00n ng=1
MP18 net2 net5 VDD VDD sg13_lv_pmos m=1 w=420.00n l=130.00n ng=1
MP19 net2 RESET_B VDD VDD sg13_lv_pmos m=1 w=420.00n l=130.00n ng=1
MP20 Q net2 VDD VDD sg13_lv_pmos m=1 w=1.12u l=130.00n ng=1
MP10 Dbbb clkpos net6 VDD sg13_lv_pmos m=1 w=420.00n l=130.00n ng=1
MP6 Dbbb RESET_B VDD VDD sg13_lv_pmos m=1 w=420.00n l=130.00n ng=1
MP7 Dbbb Dbb VDD VDD sg13_lv_pmos m=1 w=420.00n l=130.00n ng=1
MP11 net7 net4 VDD VDD sg13_lv_pmos m=1 w=420.00n l=130.00n ng=1
MP12 net6 clkneg net7 VDD sg13_lv_pmos m=1 w=420.00n l=130.00n ng=1
MP13 net6 RESET_B VDD VDD sg13_lv_pmos m=1 w=420.00n l=130.00n ng=1
MP8 clkneg CLK VDD VDD sg13_lv_pmos m=1 w=1.12u l=130.00n ng=1
MP9 clkpos clkneg VDD VDD sg13_lv_pmos m=1 w=1.12u l=130.00n ng=1
MP14 net4 net6 VDD VDD sg13_lv_pmos m=1 w=1.000u l=130.00n ng=1
MP15 net4 clkneg net5 VDD sg13_lv_pmos m=1 w=1.000u l=130.00n ng=1
MP5 Dbb Db VDD VDD sg13_lv_pmos m=1 w=1.12u l=130.00n ng=1
MP16 net3 net2 VDD VDD sg13_lv_pmos m=1 w=420.00n l=130.00n ng=1
.ENDS

************************************************************************
* Library Name: sg13g2_stdcell
* Cell Name:    sg13g2_sdfrbpq_2
* View Name:    schematic
************************************************************************

.SUBCKT sg13g2_sdfrbpq_2 Q CLK D RESET_B SCD SCE VDD VSS
*.PININFO CLK:I D:I RESET_B:I SCD:I SCE:I Q:O VDD:B VSS:B
MN3 Db SCD net63 VSS sg13_lv_nmos m=1 w=740.00n l=130.00n ng=1
MN1 Db D net65 VSS sg13_lv_nmos m=1 w=740.00n l=130.00n ng=1
MN0 SCEb SCE VSS VSS sg13_lv_nmos m=1 w=550.00n l=130.00n ng=1
MN4 net63 SCE VSS VSS sg13_lv_nmos m=1 w=740.00n l=130.00n ng=1
MN2 net65 SCEb VSS VSS sg13_lv_nmos m=1 w=740.00n l=130.00n ng=1
MN5 Dbb Db VSS VSS sg13_lv_nmos m=1 w=740.00n l=130.00n ng=1
MN17 net12 net2 VSS VSS sg13_lv_nmos m=1 w=420.00n l=130.00n ng=1
MN16 net5 clkneg net12 VSS sg13_lv_nmos m=1 w=420.00n l=130.00n ng=1
MN18 net2 net5 net11 VSS sg13_lv_nmos m=1 w=420.00n l=130.00n ng=1
MN19 net11 RESET_B VSS VSS sg13_lv_nmos m=1 w=420.00n l=130.00n ng=1
MN20 Q net2 VSS VSS sg13_lv_nmos m=1 w=1.48u l=130.00n ng=2
MN6 Dbbb Dbb net10 VSS sg13_lv_nmos m=1 w=420.00n l=130.00n ng=1
MN7 net10 RESET_B VSS VSS sg13_lv_nmos m=1 w=420.00n l=130.00n ng=1
MN10 Dbbb clkneg net6 VSS sg13_lv_nmos m=1 w=420.00n l=130.00n ng=1
MN11 net6 clkpos net9 VSS sg13_lv_nmos m=1 w=420.00n l=130.00n ng=1
MN12 net9 net4 net8 VSS sg13_lv_nmos m=1 w=420.00n l=130.00n ng=1
MN13 net8 RESET_B VSS VSS sg13_lv_nmos m=1 w=420.00n l=130.00n ng=1
MN14 net4 net6 VSS VSS sg13_lv_nmos m=1 w=740.00n l=130.00n ng=1
MN8 clkneg CLK VSS VSS sg13_lv_nmos m=1 w=740.00n l=130.00n ng=1
MN15 net4 clkpos net5 VSS sg13_lv_nmos m=1 w=740.00n l=130.00n ng=1
MN9 clkpos clkneg VSS VSS sg13_lv_nmos m=1 w=740.00n l=130.00n ng=1
MP1 net64 SCE VDD VDD sg13_lv_pmos m=1 w=1.000u l=130.00n ng=1
MP3 net62 SCEb VDD VDD sg13_lv_pmos m=1 w=1.000u l=130.00n ng=1
MP0 SCEb SCE VDD VDD sg13_lv_pmos m=1 w=840.00n l=130.00n ng=1
MP4 Db SCD net62 VDD sg13_lv_pmos m=1 w=1.000u l=130.00n ng=1
MP2 Db D net64 VDD sg13_lv_pmos m=1 w=1.000u l=130.00n ng=1
MP5 Dbb Db VDD VDD sg13_lv_pmos m=1 w=1.12u l=130.00n ng=1
MP17 net5 clkpos net3 VDD sg13_lv_pmos m=1 w=420.00n l=130.00n ng=1
MP18 net2 net5 VDD VDD sg13_lv_pmos m=1 w=420.00n l=130.00n ng=1
MP19 net2 RESET_B VDD VDD sg13_lv_pmos m=1 w=420.00n l=130.00n ng=1
MP20 Q net2 VDD VDD sg13_lv_pmos m=1 w=2.24u l=130.00n ng=2
MP10 Dbbb clkpos net6 VDD sg13_lv_pmos m=1 w=420.00n l=130.00n ng=1
MP6 Dbbb RESET_B VDD VDD sg13_lv_pmos m=1 w=420.00n l=130.00n ng=1
MP7 Dbbb Dbb VDD VDD sg13_lv_pmos m=1 w=420.00n l=130.00n ng=1
MP11 net7 net4 VDD VDD sg13_lv_pmos m=1 w=420.00n l=130.00n ng=1
MP12 net6 clkneg net7 VDD sg13_lv_pmos m=1 w=420.00n l=130.00n ng=1
MP13 net6 RESET_B VDD VDD sg13_lv_pmos m=1 w=420.00n l=130.00n ng=1
MP8 clkneg CLK VDD VDD sg13_lv_pmos m=1 w=1.12u l=130.00n ng=1
MP9 clkpos clkneg VDD VDD sg13_lv_pmos m=1 w=1.12u l=130.00n ng=1
MP14 net4 net6 VDD VDD sg13_lv_pmos m=1 w=1.000u l=130.00n ng=1
MP15 net4 clkneg net5 VDD sg13_lv_pmos m=1 w=1.000u l=130.00n ng=1
MP16 net3 net2 VDD VDD sg13_lv_pmos m=1 w=420.00n l=130.00n ng=1
.ENDS

************************************************************************
* Library Name: sg13g2_stdcell
* Cell Name:    sg13g2_sdfrbp_2
* View Name:    schematic
************************************************************************

.SUBCKT sg13g2_sdfrbp_2 Q Q_N CLK D RESET_B SCD SCE VDD VSS
*.PININFO CLK:I D:I RESET_B:I SCD:I SCE:I Q:O Q_N:O VDD:B VSS:B
MN3 Db SCD net63 VSS sg13_lv_nmos m=1 w=740.00n l=130.00n ng=1
MN1 Db D net65 VSS sg13_lv_nmos m=1 w=740.00n l=130.00n ng=1
MN0 SCEb SCE VSS VSS sg13_lv_nmos m=1 w=550.00n l=130.00n ng=1
MN4 net63 SCE VSS VSS sg13_lv_nmos m=1 w=740.00n l=130.00n ng=1
MN2 net65 SCEb VSS VSS sg13_lv_nmos m=1 w=740.00n l=130.00n ng=1
MN5 Dbb Db VSS VSS sg13_lv_nmos m=1 w=740.00n l=130.00n ng=1
MN17 net12 net2 VSS VSS sg13_lv_nmos m=1 w=420.00n l=130.00n ng=1
MN16 net5 clkneg net12 VSS sg13_lv_nmos m=1 w=420.00n l=130.00n ng=1
MN18 net2 net5 net11 VSS sg13_lv_nmos m=1 w=420.00n l=130.00n ng=1
MN19 net11 RESET_B VSS VSS sg13_lv_nmos m=1 w=420.00n l=130.00n ng=1
MN20 Q_N net5 VSS VSS sg13_lv_nmos m=1 w=1.48u l=130.00n ng=2
MN6 Dbbb Dbb net10 VSS sg13_lv_nmos m=1 w=420.00n l=130.00n ng=1
MN7 net10 RESET_B VSS VSS sg13_lv_nmos m=1 w=420.00n l=130.00n ng=1
MN10 Dbbb clkneg net6 VSS sg13_lv_nmos m=1 w=420.00n l=130.00n ng=1
MN11 net6 clkpos net9 VSS sg13_lv_nmos m=1 w=420.00n l=130.00n ng=1
MN12 net9 net4 net8 VSS sg13_lv_nmos m=1 w=420.00n l=130.00n ng=1
MN13 net8 RESET_B VSS VSS sg13_lv_nmos m=1 w=420.00n l=130.00n ng=1
MN14 net4 net6 VSS VSS sg13_lv_nmos m=1 w=740.00n l=130.00n ng=1
MN8 clkneg CLK VSS VSS sg13_lv_nmos m=1 w=740.00n l=130.00n ng=1
MN15 net4 clkpos net5 VSS sg13_lv_nmos m=1 w=740.00n l=130.00n ng=1
MN9 clkpos clkneg VSS VSS sg13_lv_nmos m=1 w=740.00n l=130.00n ng=1
MN22 Q net1 VSS VSS sg13_lv_nmos m=1 w=1.48u l=130.00n ng=2
MN21 net1 net5 VSS VSS sg13_lv_nmos m=1 w=640.00n l=130.00n ng=1
MP1 net64 SCE VDD VDD sg13_lv_pmos m=1 w=1.000u l=130.00n ng=1
MP3 net62 SCEb VDD VDD sg13_lv_pmos m=1 w=1.000u l=130.00n ng=1
MP0 SCEb SCE VDD VDD sg13_lv_pmos m=1 w=840.00n l=130.00n ng=1
MP4 Db SCD net62 VDD sg13_lv_pmos m=1 w=1.000u l=130.00n ng=1
MP2 Db D net64 VDD sg13_lv_pmos m=1 w=1.000u l=130.00n ng=1
MP5 Dbb Db VDD VDD sg13_lv_pmos m=1 w=1.12u l=130.00n ng=1
MP17 net5 clkpos net3 VDD sg13_lv_pmos m=1 w=420.00n l=130.00n ng=1
MP18 net2 net5 VDD VDD sg13_lv_pmos m=1 w=420.00n l=130.00n ng=1
MP19 net2 RESET_B VDD VDD sg13_lv_pmos m=1 w=420.00n l=130.00n ng=1
MP20 Q_N net5 VDD VDD sg13_lv_pmos m=1 w=2.24u l=130.00n ng=2
MP10 Dbbb clkpos net6 VDD sg13_lv_pmos m=1 w=420.00n l=130.00n ng=1
MP6 Dbbb RESET_B VDD VDD sg13_lv_pmos m=1 w=420.00n l=130.00n ng=1
MP7 Dbbb Dbb VDD VDD sg13_lv_pmos m=1 w=420.00n l=130.00n ng=1
MP11 net7 net4 VDD VDD sg13_lv_pmos m=1 w=420.00n l=130.00n ng=1
MP12 net6 clkneg net7 VDD sg13_lv_pmos m=1 w=420.00n l=130.00n ng=1
MP13 net6 RESET_B VDD VDD sg13_lv_pmos m=1 w=420.00n l=130.00n ng=1
MP8 clkneg CLK VDD VDD sg13_lv_pmos m=1 w=1.12u l=130.00n ng=1
MP9 clkpos clkneg VDD VDD sg13_lv_pmos m=1 w=1.12u l=130.00n ng=1
MP14 net4 net6 VDD VDD sg13_lv_pmos m=1 w=1.000u l=130.00n ng=1
MP15 net4 clkneg net5 VDD sg13_lv_pmos m=1 w=1.000u l=130.00n ng=1
MP22 Q net1 VDD VDD sg13_lv_pmos m=1 w=2.24u l=130.00n ng=2
MP16 net3 net2 VDD VDD sg13_lv_pmos m=1 w=420.00n l=130.00n ng=1
MP21 net1 net5 VDD VDD sg13_lv_pmos m=1 w=1.000u l=130.00n ng=1
.ENDS

************************************************************************
* Library Name: sg13g2_stdcell
* Cell Name:    sg13g2_sdfrbp_1
* View Name:    schematic
************************************************************************

.SUBCKT sg13g2_sdfrbp_1 Q Q_N CLK D RESET_B SCD SCE VDD VSS
*.PININFO CLK:I D:I RESET_B:I SCD:I SCE:I Q:O Q_N:O VDD:B VSS:B
MN3 Db SCD net63 VSS sg13_lv_nmos m=1 w=740.00n l=130.00n ng=1
MN1 Db D net65 VSS sg13_lv_nmos m=1 w=740.00n l=130.00n ng=1
MN0 SCEb SCE VSS VSS sg13_lv_nmos m=1 w=550.00n l=130.00n ng=1
MN4 net63 SCE VSS VSS sg13_lv_nmos m=1 w=740.00n l=130.00n ng=1
MN2 net65 SCEb VSS VSS sg13_lv_nmos m=1 w=740.00n l=130.00n ng=1
MN5 net13 Db VSS VSS sg13_lv_nmos m=1 w=740.00n l=130.00n ng=1
MN17 net12 net2 VSS VSS sg13_lv_nmos m=1 w=420.00n l=130.00n ng=1
MN16 net5 clkneg net12 VSS sg13_lv_nmos m=1 w=420.00n l=130.00n ng=1
MN18 net2 net5 net11 VSS sg13_lv_nmos m=1 w=420.00n l=130.00n ng=1
MN19 net11 RESET_B VSS VSS sg13_lv_nmos m=1 w=420.00n l=130.00n ng=1
MN20 Q_N net5 VSS VSS sg13_lv_nmos m=1 w=740.00n l=130.00n ng=1
MN6 Dbb net13 net10 VSS sg13_lv_nmos m=1 w=420.00n l=130.00n ng=1
MN7 net10 RESET_B VSS VSS sg13_lv_nmos m=1 w=420.00n l=130.00n ng=1
MN10 Dbb clkneg net6 VSS sg13_lv_nmos m=1 w=420.00n l=130.00n ng=1
MN11 net6 clkpos net9 VSS sg13_lv_nmos m=1 w=420.00n l=130.00n ng=1
MN12 net9 net4 net8 VSS sg13_lv_nmos m=1 w=420.00n l=130.00n ng=1
MN13 net8 RESET_B VSS VSS sg13_lv_nmos m=1 w=420.00n l=130.00n ng=1
MN14 net4 net6 VSS VSS sg13_lv_nmos m=1 w=740.00n l=130.00n ng=1
MN8 clkneg CLK VSS VSS sg13_lv_nmos m=1 w=740.00n l=130.00n ng=1
MN15 net4 clkpos net5 VSS sg13_lv_nmos m=1 w=740.00n l=130.00n ng=1
MN9 clkpos clkneg VSS VSS sg13_lv_nmos m=1 w=740.00n l=130.00n ng=1
MN22 Q net1 VSS VSS sg13_lv_nmos m=1 w=740.00n l=130.00n ng=1
MN21 net1 net5 VSS VSS sg13_lv_nmos m=1 w=640.00n l=130.00n ng=1
MP1 net64 SCE VDD VDD sg13_lv_pmos m=1 w=1.000u l=130.00n ng=1
MP3 net62 SCEb VDD VDD sg13_lv_pmos m=1 w=1.000u l=130.00n ng=1
MP0 SCEb SCE VDD VDD sg13_lv_pmos m=1 w=840.00n l=130.00n ng=1
MP4 Db SCD net62 VDD sg13_lv_pmos m=1 w=1.000u l=130.00n ng=1
MP2 Db D net64 VDD sg13_lv_pmos m=1 w=1.000u l=130.00n ng=1
MP5 net13 Db VDD VDD sg13_lv_pmos m=1 w=1.12u l=130.00n ng=1
MP17 net5 clkpos net3 VDD sg13_lv_pmos m=1 w=420.00n l=130.00n ng=1
MP18 net2 net5 VDD VDD sg13_lv_pmos m=1 w=420.00n l=130.00n ng=1
MP19 net2 RESET_B VDD VDD sg13_lv_pmos m=1 w=420.00n l=130.00n ng=1
MP20 Q_N net5 VDD VDD sg13_lv_pmos m=1 w=1.12u l=130.00n ng=1
MP10 Dbb clkpos net6 VDD sg13_lv_pmos m=1 w=420.00n l=130.00n ng=1
MP6 Dbb RESET_B VDD VDD sg13_lv_pmos m=1 w=420.00n l=130.00n ng=1
MP7 Dbb net13 VDD VDD sg13_lv_pmos m=1 w=420.00n l=130.00n ng=1
MP11 net7 net4 VDD VDD sg13_lv_pmos m=1 w=420.00n l=130.00n ng=1
MP12 net6 clkneg net7 VDD sg13_lv_pmos m=1 w=420.00n l=130.00n ng=1
MP13 net6 RESET_B VDD VDD sg13_lv_pmos m=1 w=420.00n l=130.00n ng=1
MP8 clkneg CLK VDD VDD sg13_lv_pmos m=1 w=1.12u l=130.00n ng=1
MP9 clkpos clkneg VDD VDD sg13_lv_pmos m=1 w=1.12u l=130.00n ng=1
MP14 net4 net6 VDD VDD sg13_lv_pmos m=1 w=1.000u l=130.00n ng=1
MP15 net4 clkneg net5 VDD sg13_lv_pmos m=1 w=1.000u l=130.00n ng=1
MP22 Q net1 VDD VDD sg13_lv_pmos m=1 w=1.12u l=130.00n ng=1
MP16 net3 net2 VDD VDD sg13_lv_pmos m=1 w=420.00n l=130.00n ng=1
MP21 net1 net5 VDD VDD sg13_lv_pmos m=1 w=1.000u l=130.00n ng=1
.ENDS

************************************************************************
* Library Name: sg13g2_stdcell
* Cell Name:    sg13g2_dfrbpq_2
* View Name:    schematic
************************************************************************

.SUBCKT sg13g2_dfrbpq_2 Q CLK D RESET_B VDD VSS
*.PININFO CLK:I D:I RESET_B:I Q:O VDD:B VSS:B
MN11 net12 net2 VSS VSS sg13_lv_nmos m=1 w=420.00n l=130.00n ng=1
MN10 net5 clkneg net12 VSS sg13_lv_nmos m=1 w=420.00n l=130.00n ng=1
MN12 net2 net5 net11 VSS sg13_lv_nmos m=1 w=420.00n l=130.00n ng=1
MN13 net11 RESET_B VSS VSS sg13_lv_nmos m=1 w=420.00n l=130.00n ng=1
MN0 Db D net10 VSS sg13_lv_nmos m=1 w=420.00n l=130.00n ng=1
MN1 net10 RESET_B VSS VSS sg13_lv_nmos m=1 w=420.00n l=130.00n ng=1
MN4 Db clkneg net6 VSS sg13_lv_nmos m=1 w=420.00n l=130.00n ng=1
MN5 net6 clkpos net9 VSS sg13_lv_nmos m=1 w=420.00n l=130.00n ng=1
MN6 net9 net4 net8 VSS sg13_lv_nmos m=1 w=420.00n l=130.00n ng=1
MN7 net8 RESET_B VSS VSS sg13_lv_nmos m=1 w=420.00n l=130.00n ng=1
MN8 net4 net6 VSS VSS sg13_lv_nmos m=1 w=740.00n l=130.00n ng=1
MN2 clkneg CLK VSS VSS sg13_lv_nmos m=1 w=740.00n l=130.00n ng=1
MN9 net4 clkpos net5 VSS sg13_lv_nmos m=1 w=740.00n l=130.00n ng=1
MN3 clkpos clkneg VSS VSS sg13_lv_nmos m=1 w=740.00n l=130.00n ng=1
MN15 Q net1 VSS VSS sg13_lv_nmos m=1 w=1.48u l=130.00n ng=2
MN14 net1 net5 VSS VSS sg13_lv_nmos m=1 w=640.00n l=130.00n ng=1
MP11 net5 clkpos net3 VDD sg13_lv_pmos m=1 w=420.00n l=130.00n ng=1
MP12 net2 net5 VDD VDD sg13_lv_pmos m=1 w=420.00n l=130.00n ng=1
MP13 net2 RESET_B VDD VDD sg13_lv_pmos m=1 w=420.00n l=130.00n ng=1
MP4 Db clkpos net6 VDD sg13_lv_pmos m=1 w=420.00n l=130.00n ng=1
MP0 Db RESET_B VDD VDD sg13_lv_pmos m=1 w=420.00n l=130.00n ng=1
MP1 Db D VDD VDD sg13_lv_pmos m=1 w=420.00n l=130.00n ng=1
MP5 net7 net4 VDD VDD sg13_lv_pmos m=1 w=420.00n l=130.00n ng=1
MP6 net6 clkneg net7 VDD sg13_lv_pmos m=1 w=420.00n l=130.00n ng=1
MP7 net6 RESET_B VDD VDD sg13_lv_pmos m=1 w=420.00n l=130.00n ng=1
MP2 clkneg CLK VDD VDD sg13_lv_pmos m=1 w=1.12u l=130.00n ng=1
MP3 clkpos clkneg VDD VDD sg13_lv_pmos m=1 w=1.12u l=130.00n ng=1
MP8 net4 net6 VDD VDD sg13_lv_pmos m=1 w=1.000u l=130.00n ng=1
MP9 net4 clkneg net5 VDD sg13_lv_pmos m=1 w=1.000u l=130.00n ng=1
MP15 Q net1 VDD VDD sg13_lv_pmos m=1 w=2.24u l=130.00n ng=2
MP10 net3 net2 VDD VDD sg13_lv_pmos m=1 w=420.00n l=130.00n ng=1
MP14 net1 net5 VDD VDD sg13_lv_pmos m=1 w=1.000u l=130.00n ng=1
.ENDS

************************************************************************
* Library Name: sg13g2_stdcell
* Cell Name:    sg13g2_dfrbpq_1
* View Name:    schematic
************************************************************************

.SUBCKT sg13g2_dfrbpq_1 Q CLK D RESET_B VDD VSS
*.PININFO CLK:I D:I RESET_B:I Q:O VDD:B VSS:B
MN11 net12 net2 VSS VSS sg13_lv_nmos m=1 w=420.00n l=130.00n ng=1
MN10 net5 clkneg net12 VSS sg13_lv_nmos m=1 w=420.00n l=130.00n ng=1
MN12 net2 net5 net11 VSS sg13_lv_nmos m=1 w=420.00n l=130.00n ng=1
MN13 net11 RESET_B VSS VSS sg13_lv_nmos m=1 w=420.00n l=130.00n ng=1
MN0 Db D net10 VSS sg13_lv_nmos m=1 w=420.00n l=130.00n ng=1
MN1 net10 RESET_B VSS VSS sg13_lv_nmos m=1 w=420.00n l=130.00n ng=1
MN4 Db clkneg net6 VSS sg13_lv_nmos m=1 w=420.00n l=130.00n ng=1
MN5 net6 clkpos net9 VSS sg13_lv_nmos m=1 w=420.00n l=130.00n ng=1
MN6 net9 net4 net8 VSS sg13_lv_nmos m=1 w=420.00n l=130.00n ng=1
MN7 net8 RESET_B VSS VSS sg13_lv_nmos m=1 w=420.00n l=130.00n ng=1
MN8 net4 net6 VSS VSS sg13_lv_nmos m=1 w=740.00n l=130.00n ng=1
MN2 clkneg CLK VSS VSS sg13_lv_nmos m=1 w=740.00n l=130.00n ng=1
MN9 net4 clkpos net5 VSS sg13_lv_nmos m=1 w=740.00n l=130.00n ng=1
MN3 clkpos clkneg VSS VSS sg13_lv_nmos m=1 w=740.00n l=130.00n ng=1
MN15 Q net1 VSS VSS sg13_lv_nmos m=1 w=740.00n l=130.00n ng=1
MN14 net1 net5 VSS VSS sg13_lv_nmos m=1 w=740.00n l=130.00n ng=1
MP11 net5 clkpos net3 VDD sg13_lv_pmos m=1 w=420.00n l=130.00n ng=1
MP12 net2 net5 VDD VDD sg13_lv_pmos m=1 w=420.00n l=130.00n ng=1
MP13 net2 RESET_B VDD VDD sg13_lv_pmos m=1 w=420.00n l=130.00n ng=1
MP4 Db clkpos net6 VDD sg13_lv_pmos m=1 w=420.00n l=130.00n ng=1
MP0 Db RESET_B VDD VDD sg13_lv_pmos m=1 w=420.00n l=130.00n ng=1
MP1 Db D VDD VDD sg13_lv_pmos m=1 w=420.00n l=130.00n ng=1
MP5 net7 net4 VDD VDD sg13_lv_pmos m=1 w=420.00n l=130.00n ng=1
MP6 net6 clkneg net7 VDD sg13_lv_pmos m=1 w=420.00n l=130.00n ng=1
MP7 net6 RESET_B VDD VDD sg13_lv_pmos m=1 w=420.00n l=130.00n ng=1
MP2 clkneg CLK VDD VDD sg13_lv_pmos m=1 w=1.12u l=130.00n ng=1
MP3 clkpos clkneg VDD VDD sg13_lv_pmos m=1 w=1.12u l=130.00n ng=1
MP8 net4 net6 VDD VDD sg13_lv_pmos m=1 w=1.000u l=130.00n ng=1
MP9 net4 clkneg net5 VDD sg13_lv_pmos m=1 w=1.000u l=130.00n ng=1
MP15 Q net1 VDD VDD sg13_lv_pmos m=1 w=1.12u l=130.00n ng=1
MP10 net3 net2 VDD VDD sg13_lv_pmos m=1 w=420.00n l=130.00n ng=1
MP14 net1 net5 VDD VDD sg13_lv_pmos m=1 w=1.12u l=130.00n ng=1
.ENDS

************************************************************************
* Library Name: sg13g2_stdcell
* Cell Name:    sg13g2_fill_1
* View Name:    schematic
************************************************************************

.SUBCKT sg13g2_fill_1 VDD VSS
*.PININFO VDD:B VSS:B
.ENDS

************************************************************************
* Library Name: sg13g2_stdcell
* Cell Name:    sg13g2_fill_2
* View Name:    schematic
************************************************************************

.SUBCKT sg13g2_fill_2 VDD VSS
*.PININFO VDD:B VSS:B
.ENDS

************************************************************************
* Library Name: sg13g2_stdcell
* Cell Name:    sg13g2_fill_4
* View Name:    schematic
************************************************************************

.SUBCKT sg13g2_fill_4 VDD VSS
*.PININFO VDD:B VSS:B
.ENDS

************************************************************************
* Library Name: sg13g2_stdcell
* Cell Name:    sg13g2_fill_8
* View Name:    schematic
************************************************************************

.SUBCKT sg13g2_fill_8 VDD VSS
*.PININFO VDD:B VSS:B
.ENDS

.SUBCKT bondpad_70x70_tm1 pad
*.PININFO pad:B
* metal-only bond pad, no devices
.ENDS

.SUBCKT r1_adc_sar adc_hold adc_sel adc_start adc_valid_a adc_valid_b clk clka clkab clkb clkbb clkna clknab clknb clknbb cur_trk is_smp mclk oan oann oanp oap obn obnn obnp obp por_n trka0 trka1 trkb0 trkb1 VDD VSS adc_raw_a_13_ adc_raw_a_12_ adc_raw_a_11_ adc_raw_a_10_ adc_raw_a_9_ adc_raw_a_8_ adc_raw_a_7_ adc_raw_a_6_ adc_raw_a_5_ adc_raw_a_4_ adc_raw_a_3_ adc_raw_a_2_ adc_raw_a_1_ adc_raw_a_0_ adc_raw_b_13_ adc_raw_b_12_ adc_raw_b_11_ adc_raw_b_10_ adc_raw_b_9_ adc_raw_b_8_ adc_raw_b_7_ adc_raw_b_6_ adc_raw_b_5_ adc_raw_b_4_ adc_raw_b_3_ adc_raw_b_2_ adc_raw_b_1_ adc_raw_b_0_ cna_12_ cna_11_ cna_10_ cna_9_ cna_8_ cna_7_ cna_6_ cna_5_ cna_4_ cna_3_ cna_2_ cna_1_ cna_0_ cnb_12_ cnb_11_ cnb_10_ cnb_9_ cnb_8_ cnb_7_ cnb_6_ cnb_5_ cnb_4_ cnb_3_ cnb_2_ cnb_1_ cnb_0_ cpa_12_ cpa_11_ cpa_10_ cpa_9_ cpa_8_ cpa_7_ cpa_6_ cpa_5_ cpa_4_ cpa_3_ cpa_2_ cpa_1_ cpa_0_ cpb_12_ cpb_11_ cpb_10_ cpb_9_ cpb_8_ cpb_7_ cpb_6_ cpb_5_ cpb_4_ cpb_3_ cpb_2_ cpb_1_ cpb_0_
XANTENNA_1 clk VDD VSS / sg13g2_antennanp
XFILLER_0_0 VDD VSS / sg13g2_decap_8
XFILLER_0_110 VDD VSS / sg13g2_fill_1
XFILLER_0_132 VDD VSS / sg13g2_fill_2
XFILLER_0_134 VDD VSS / sg13g2_fill_1
XFILLER_0_14 VDD VSS / sg13g2_decap_8
XFILLER_0_152 VDD VSS / sg13g2_fill_2
XFILLER_0_203 VDD VSS / sg13g2_fill_1
XFILLER_0_210 VDD VSS / sg13g2_fill_1
XFILLER_0_222 VDD VSS / sg13g2_fill_2
XFILLER_0_224 VDD VSS / sg13g2_fill_1
XFILLER_0_231 VDD VSS / sg13g2_fill_2
XFILLER_0_233 VDD VSS / sg13g2_fill_1
XFILLER_0_275 VDD VSS / sg13g2_decap_4
XFILLER_0_316 VDD VSS / sg13g2_decap_4
XFILLER_0_370 VDD VSS / sg13g2_decap_4
XFILLER_0_382 VDD VSS / sg13g2_fill_2
XFILLER_0_391 VDD VSS / sg13g2_fill_2
XFILLER_0_398 VDD VSS / sg13g2_decap_8
XFILLER_0_405 VDD VSS / sg13g2_fill_1
XFILLER_0_422 VDD VSS / sg13g2_fill_2
XFILLER_0_424 VDD VSS / sg13g2_fill_1
XFILLER_0_452 VDD VSS / sg13g2_fill_1
XFILLER_0_475 VDD VSS / sg13g2_fill_2
XFILLER_0_477 VDD VSS / sg13g2_fill_1
XFILLER_0_510 VDD VSS / sg13g2_decap_4
XFILLER_0_521 VDD VSS / sg13g2_fill_1
XFILLER_0_557 VDD VSS / sg13g2_fill_1
XFILLER_0_618 VDD VSS / sg13g2_fill_1
XFILLER_0_634 VDD VSS / sg13g2_fill_2
XFILLER_0_657 VDD VSS / sg13g2_decap_4
XFILLER_0_661 VDD VSS / sg13g2_fill_1
XFILLER_0_67 VDD VSS / sg13g2_fill_1
XFILLER_0_674 VDD VSS / sg13g2_decap_4
XFILLER_0_689 VDD VSS / sg13g2_fill_1
XFILLER_0_7 VDD VSS / sg13g2_decap_8
XFILLER_0_728 VDD VSS / sg13g2_decap_4
XFILLER_0_742 VDD VSS / sg13g2_fill_1
XFILLER_0_761 VDD VSS / sg13g2_fill_2
XFILLER_0_792 VDD VSS / sg13g2_fill_2
XFILLER_0_794 VDD VSS / sg13g2_fill_1
XFILLER_0_83 VDD VSS / sg13g2_decap_4
XFILLER_0_839 VDD VSS / sg13g2_fill_2
XFILLER_0_888 VDD VSS / sg13g2_decap_8
XFILLER_0_895 VDD VSS / sg13g2_decap_8
XFILLER_0_902 VDD VSS / sg13g2_fill_1
XFILLER_1_0 VDD VSS / sg13g2_decap_8
XFILLER_1_101 VDD VSS / sg13g2_fill_1
XFILLER_1_14 VDD VSS / sg13g2_fill_2
XFILLER_1_246 VDD VSS / sg13g2_fill_1
XFILLER_1_280 VDD VSS / sg13g2_fill_2
XFILLER_1_282 VDD VSS / sg13g2_fill_1
XFILLER_1_295 VDD VSS / sg13g2_fill_2
XFILLER_1_312 VDD VSS / sg13g2_fill_1
XFILLER_1_341 VDD VSS / sg13g2_fill_2
XFILLER_1_354 VDD VSS / sg13g2_decap_4
XFILLER_1_414 VDD VSS / sg13g2_fill_1
XFILLER_1_435 VDD VSS / sg13g2_decap_4
XFILLER_1_443 VDD VSS / sg13g2_decap_8
XFILLER_1_450 VDD VSS / sg13g2_decap_4
XFILLER_1_477 VDD VSS / sg13g2_fill_1
XFILLER_1_506 VDD VSS / sg13g2_fill_2
XFILLER_1_508 VDD VSS / sg13g2_fill_1
XFILLER_1_537 VDD VSS / sg13g2_fill_2
XFILLER_1_539 VDD VSS / sg13g2_fill_1
XFILLER_1_545 VDD VSS / sg13g2_decap_8
XFILLER_1_552 VDD VSS / sg13g2_fill_1
XFILLER_1_585 VDD VSS / sg13g2_fill_2
XFILLER_1_587 VDD VSS / sg13g2_fill_1
XFILLER_1_61 VDD VSS / sg13g2_fill_2
XFILLER_1_63 VDD VSS / sg13g2_fill_1
XFILLER_1_7 VDD VSS / sg13g2_decap_8
XFILLER_1_710 VDD VSS / sg13g2_fill_1
XFILLER_1_762 VDD VSS / sg13g2_fill_2
XFILLER_1_764 VDD VSS / sg13g2_fill_1
XFILLER_1_810 VDD VSS / sg13g2_decap_4
XFILLER_1_854 VDD VSS / sg13g2_fill_1
XFILLER_1_882 VDD VSS / sg13g2_decap_8
XFILLER_1_889 VDD VSS / sg13g2_decap_8
XFILLER_1_896 VDD VSS / sg13g2_decap_8
XFILLER_2_0 VDD VSS / sg13g2_decap_8
XFILLER_2_108 VDD VSS / sg13g2_fill_2
XFILLER_2_14 VDD VSS / sg13g2_decap_4
XFILLER_2_142 VDD VSS / sg13g2_fill_2
XFILLER_2_154 VDD VSS / sg13g2_fill_1
XFILLER_2_169 VDD VSS / sg13g2_fill_1
XFILLER_2_18 VDD VSS / sg13g2_fill_2
XFILLER_2_184 VDD VSS / sg13g2_decap_8
XFILLER_2_191 VDD VSS / sg13g2_decap_4
XFILLER_2_200 VDD VSS / sg13g2_decap_8
XFILLER_2_211 VDD VSS / sg13g2_fill_2
XFILLER_2_213 VDD VSS / sg13g2_fill_1
XFILLER_2_232 VDD VSS / sg13g2_fill_2
XFILLER_2_239 VDD VSS / sg13g2_fill_1
XFILLER_2_259 VDD VSS / sg13g2_decap_8
XFILLER_2_266 VDD VSS / sg13g2_decap_8
XFILLER_2_273 VDD VSS / sg13g2_fill_2
XFILLER_2_275 VDD VSS / sg13g2_fill_1
XFILLER_2_301 VDD VSS / sg13g2_decap_8
XFILLER_2_308 VDD VSS / sg13g2_fill_2
XFILLER_2_310 VDD VSS / sg13g2_fill_1
XFILLER_2_321 VDD VSS / sg13g2_fill_1
XFILLER_2_360 VDD VSS / sg13g2_decap_4
XFILLER_2_388 VDD VSS / sg13g2_fill_1
XFILLER_2_398 VDD VSS / sg13g2_decap_4
XFILLER_2_402 VDD VSS / sg13g2_fill_2
XFILLER_2_422 VDD VSS / sg13g2_decap_8
XFILLER_2_429 VDD VSS / sg13g2_fill_1
XFILLER_2_499 VDD VSS / sg13g2_decap_4
XFILLER_2_56 VDD VSS / sg13g2_decap_4
XFILLER_2_562 VDD VSS / sg13g2_fill_2
XFILLER_2_60 VDD VSS / sg13g2_fill_2
XFILLER_2_602 VDD VSS / sg13g2_decap_4
XFILLER_2_638 VDD VSS / sg13g2_decap_4
XFILLER_2_642 VDD VSS / sg13g2_fill_1
XFILLER_2_658 VDD VSS / sg13g2_decap_8
XFILLER_2_685 VDD VSS / sg13g2_decap_8
XFILLER_2_692 VDD VSS / sg13g2_fill_2
XFILLER_2_694 VDD VSS / sg13g2_fill_1
XFILLER_2_7 VDD VSS / sg13g2_decap_8
XFILLER_2_705 VDD VSS / sg13g2_fill_1
XFILLER_2_721 VDD VSS / sg13g2_decap_8
XFILLER_2_728 VDD VSS / sg13g2_decap_8
XFILLER_2_735 VDD VSS / sg13g2_fill_1
XFILLER_2_788 VDD VSS / sg13g2_decap_8
XFILLER_2_795 VDD VSS / sg13g2_fill_2
XFILLER_2_797 VDD VSS / sg13g2_fill_1
XFILLER_2_808 VDD VSS / sg13g2_decap_4
XFILLER_2_828 VDD VSS / sg13g2_decap_4
XFILLER_2_832 VDD VSS / sg13g2_fill_2
XFILLER_3_0 VDD VSS / sg13g2_fill_1
XFILLER_3_106 VDD VSS / sg13g2_decap_4
XFILLER_3_110 VDD VSS / sg13g2_fill_1
XFILLER_3_188 VDD VSS / sg13g2_decap_4
XFILLER_3_235 VDD VSS / sg13g2_fill_2
XFILLER_3_237 VDD VSS / sg13g2_fill_1
XFILLER_3_247 VDD VSS / sg13g2_fill_1
XFILLER_3_267 VDD VSS / sg13g2_decap_4
XFILLER_3_271 VDD VSS / sg13g2_fill_1
XFILLER_3_28 VDD VSS / sg13g2_fill_2
XFILLER_3_316 VDD VSS / sg13g2_fill_1
XFILLER_3_370 VDD VSS / sg13g2_decap_4
XFILLER_3_419 VDD VSS / sg13g2_decap_8
XFILLER_3_426 VDD VSS / sg13g2_fill_1
XFILLER_3_454 VDD VSS / sg13g2_fill_2
XFILLER_3_487 VDD VSS / sg13g2_fill_2
XFILLER_3_521 VDD VSS / sg13g2_decap_8
XFILLER_3_528 VDD VSS / sg13g2_decap_8
XFILLER_3_535 VDD VSS / sg13g2_fill_2
XFILLER_3_54 VDD VSS / sg13g2_decap_8
XFILLER_3_547 VDD VSS / sg13g2_fill_1
XFILLER_3_561 VDD VSS / sg13g2_fill_1
XFILLER_3_590 VDD VSS / sg13g2_fill_1
XFILLER_3_61 VDD VSS / sg13g2_decap_8
XFILLER_3_624 VDD VSS / sg13g2_fill_2
XFILLER_3_626 VDD VSS / sg13g2_fill_1
XFILLER_3_637 VDD VSS / sg13g2_fill_2
XFILLER_3_68 VDD VSS / sg13g2_decap_4
XFILLER_3_695 VDD VSS / sg13g2_decap_4
XFILLER_3_699 VDD VSS / sg13g2_fill_2
XFILLER_3_716 VDD VSS / sg13g2_decap_8
XFILLER_3_72 VDD VSS / sg13g2_fill_1
XFILLER_3_723 VDD VSS / sg13g2_fill_2
XFILLER_3_725 VDD VSS / sg13g2_fill_1
XFILLER_3_741 VDD VSS / sg13g2_decap_4
XFILLER_3_784 VDD VSS / sg13g2_decap_4
XFILLER_3_803 VDD VSS / sg13g2_decap_4
XFILLER_3_813 VDD VSS / sg13g2_decap_4
XFILLER_3_817 VDD VSS / sg13g2_fill_1
XFILLER_3_828 VDD VSS / sg13g2_decap_8
XFILLER_3_835 VDD VSS / sg13g2_fill_2
XFILLER_3_852 VDD VSS / sg13g2_fill_2
XFILLER_3_882 VDD VSS / sg13g2_decap_8
XFILLER_3_889 VDD VSS / sg13g2_fill_1
XFILLER_4_0 VDD VSS / sg13g2_fill_2
XFILLER_4_126 VDD VSS / sg13g2_fill_2
XFILLER_4_128 VDD VSS / sg13g2_fill_1
XFILLER_4_143 VDD VSS / sg13g2_fill_2
XFILLER_4_145 VDD VSS / sg13g2_fill_1
XFILLER_4_151 VDD VSS / sg13g2_fill_2
XFILLER_4_153 VDD VSS / sg13g2_fill_1
XFILLER_4_213 VDD VSS / sg13g2_decap_8
XFILLER_4_220 VDD VSS / sg13g2_fill_2
XFILLER_4_222 VDD VSS / sg13g2_fill_1
XFILLER_4_283 VDD VSS / sg13g2_decap_4
XFILLER_4_298 VDD VSS / sg13g2_fill_1
XFILLER_4_336 VDD VSS / sg13g2_fill_1
XFILLER_4_347 VDD VSS / sg13g2_decap_8
XFILLER_4_354 VDD VSS / sg13g2_fill_2
XFILLER_4_356 VDD VSS / sg13g2_fill_1
XFILLER_4_401 VDD VSS / sg13g2_fill_2
XFILLER_4_435 VDD VSS / sg13g2_fill_2
XFILLER_4_450 VDD VSS / sg13g2_decap_8
XFILLER_4_500 VDD VSS / sg13g2_decap_8
XFILLER_4_507 VDD VSS / sg13g2_decap_4
XFILLER_4_511 VDD VSS / sg13g2_fill_2
XFILLER_4_540 VDD VSS / sg13g2_fill_2
XFILLER_4_55 VDD VSS / sg13g2_fill_2
XFILLER_4_57 VDD VSS / sg13g2_fill_1
XFILLER_4_573 VDD VSS / sg13g2_fill_2
XFILLER_4_584 VDD VSS / sg13g2_fill_1
XFILLER_4_592 VDD VSS / sg13g2_decap_4
XFILLER_4_596 VDD VSS / sg13g2_fill_1
XFILLER_4_606 VDD VSS / sg13g2_fill_1
XFILLER_4_635 VDD VSS / sg13g2_decap_8
XFILLER_4_642 VDD VSS / sg13g2_fill_2
XFILLER_4_648 VDD VSS / sg13g2_fill_1
XFILLER_4_659 VDD VSS / sg13g2_decap_8
XFILLER_4_666 VDD VSS / sg13g2_decap_8
XFILLER_4_673 VDD VSS / sg13g2_decap_4
XFILLER_4_770 VDD VSS / sg13g2_fill_2
XFILLER_4_828 VDD VSS / sg13g2_fill_2
XFILLER_4_85 VDD VSS / sg13g2_fill_2
XFILLER_4_858 VDD VSS / sg13g2_fill_1
XFILLER_4_867 VDD VSS / sg13g2_decap_4
XFILLER_4_871 VDD VSS / sg13g2_fill_1
XFILLER_4_92 VDD VSS / sg13g2_fill_2
XFILLER_4_97 VDD VSS / sg13g2_fill_1
X_160_ _063_ done_q VDD VSS / sg13g2_inv_1
X_161_ _064_ net46 VDD VSS / sg13g2_inv_1
X_162_ _065_ net47 VDD VSS / sg13g2_inv_1
X_163_ _066_ net30 VDD VSS / sg13g2_inv_1
X_164_ _067_ net11 VDD VSS / sg13g2_inv_1
X_165_ _068_ net9 VDD VSS / sg13g2_inv_1
X_166_ _057_ sel1 net57 VDD VSS / sg13g2_or2_1
X_167_ hs net4 net1 VDD VSS / sg13g2_or2_1
X_168_ _054_ net57 _056_ VDD VSS / sg13g2_and2_1
X_169_ _069_ net36 net4 net1 VDD VSS / sg13g2_nor3_1
X_170_ _070_ _063_ hs net36 VDD VSS / sg13g2_a21o_1
X_171_ trka0 _056_ _070_ VDD VSS / sg13g2_nor2_1
X_172_ trka1 _070_ sel1 VDD VSS / sg13g2_nor2b_1
X_173_ _071_ step_2_ net45 VDD VSS / sg13g2_nand2_1
X_174_ _072_ net46 net47 VDD VSS / sg13g2_nand2b_1
X_175_ _073_ _071_ _072_ net40 VDD VSS / sg13g2_o21ai_1
X_176_ wq_d net48 _073_ VDD VSS / sg13g2_nand2b_1
X_177_ fv0_d fv0 _066_ net48 VDD VSS / sg13g2_a21o_1
X_178_ _074_ net2 net52 VDD VSS / sg13g2_or2_1
X_179_ net14 net5 hsd _074_ VDD VSS / sg13g2_nand3_1
X_180_ clka net51 VDD VSS / sg13g2_inv_2
X_181_ net13 fv0 net51 VDD VSS / sg13g2_nor2_1
X_182_ clknab net51 fv0 VDD VSS / sg13g2_or2_2
X_183_ _075_ net48 net30 VDD VSS / sg13g2_nor2_1
X_184_ _076_ net48 lna adc_raw_a_13_ _075_ VDD VSS / sg13g2_a22oi_1
X_185_ _026_ _076_ VDD VSS / sg13g2_inv_1
X_186_ _077_ step_2_ net40 VDD VSS / sg13g2_nand2b_1
X_187_ _078_ net45 _072_ _077_ VDD VSS / sg13g2_nor3_1
X_188_ _079_ net29 adc_raw_a_12_ VDD VSS / sg13g2_nor2b_1
X_189_ _031_ _079_ net11 _078_ VDD VSS / sg13g2_mux2_1
X_190_ _080_ _064_ net47 net45 _077_ VDD VSS / sg13g2_nor4_1
X_191_ _081_ net29 adc_raw_a_11_ VDD VSS / sg13g2_nor2b_1
X_192_ _032_ _081_ net11 _080_ VDD VSS / sg13g2_mux2_1
X_193_ _082_ _064_ _065_ net45 _077_ VDD VSS / sg13g2_nor4_1
X_194_ _083_ net29 adc_raw_a_10_ VDD VSS / sg13g2_nor2b_1
X_195_ _033_ _083_ net12 _082_ VDD VSS / sg13g2_mux2_1
X_196_ _084_ net47 net40 VDD VSS / sg13g2_nand2b_1
X_197_ _085_ net45 step_2_ VDD VSS / sg13g2_nand2b_1
X_198_ _086_ net46 _084_ _085_ VDD VSS / sg13g2_nor3_1
X_199_ _087_ net29 adc_raw_a_9_ VDD VSS / sg13g2_nor2b_1
X_200_ _034_ _087_ net12 _086_ VDD VSS / sg13g2_mux2_1
X_201_ _088_ net46 net47 net40 VDD VSS / sg13g2_nand3b_1
X_202_ _089_ _085_ _088_ VDD VSS / sg13g2_or2_1
X_203_ _090_ net29 adc_raw_a_8_ VDD VSS / sg13g2_nor2b_1
X_204_ _035_ net12 _090_ _089_ VDD VSS / sg13g2_mux2_1
X_205_ _091_ net47 net46 net40 VDD VSS / sg13g2_nand3b_1
X_206_ _092_ _085_ _091_ VDD VSS / sg13g2_nor2_1
X_207_ _093_ net34 adc_raw_a_7_ VDD VSS / sg13g2_nor2b_1
X_208_ _036_ _093_ net12 _092_ VDD VSS / sg13g2_mux2_1
X_209_ _094_ net39 net46 net47 VDD VSS / sg13g2_and3_1
X_210_ _095_ net40 net46 step_0_ step_2_ VDD VSS / sg13g2_nand4_1
X_211_ _096_ step_3_ _095_ VDD VSS / sg13g2_or2_1
X_212_ _097_ net45 net12 _095_ VDD VSS / sg13g2_nor3_1
X_213_ _098_ _066_ adc_raw_a_6_ VDD VSS / sg13g2_nand2_1
X_214_ _037_ _096_ _098_ _097_ VDD VSS / sg13g2_a21oi_1
X_215_ _099_ step_2_ net45 VDD VSS / sg13g2_nand2b_1
X_216_ _100_ step_1_ _084_ _099_ VDD VSS / sg13g2_nor3_1
X_217_ _101_ net28 adc_raw_a_5_ VDD VSS / sg13g2_nor2b_1
X_218_ _038_ _101_ net12 net64 VDD VSS / sg13g2_mux2_1
X_219_ _102_ _088_ _099_ VDD VSS / sg13g2_or2_1
X_220_ _103_ net28 adc_raw_a_4_ VDD VSS / sg13g2_nor2b_1
X_221_ _039_ net11 _103_ _102_ VDD VSS / sg13g2_mux2_1
X_222_ _104_ _091_ _099_ VDD VSS / sg13g2_nor2_1
X_223_ _105_ net28 adc_raw_a_3_ VDD VSS / sg13g2_nor2b_1
X_224_ _027_ _105_ net11 _104_ VDD VSS / sg13g2_mux2_1
X_225_ _106_ step_2_ net45 _094_ VDD VSS / sg13g2_nand3b_1
X_226_ _107_ net27 adc_raw_a_2_ VDD VSS / sg13g2_nor2b_1
X_227_ _028_ net11 _107_ _106_ VDD VSS / sg13g2_mux2_1
X_228_ _108_ step_1_ _071_ _084_ VDD VSS / sg13g2_nor3_1
X_229_ _109_ net27 adc_raw_a_1_ VDD VSS / sg13g2_nor2b_1
X_230_ _029_ _109_ net11 net63 VDD VSS / sg13g2_mux2_1
X_231_ _110_ _071_ _088_ VDD VSS / sg13g2_nor2_1
X_232_ _111_ net27 adc_raw_a_0_ VDD VSS / sg13g2_nor2b_1
X_233_ _030_ _111_ net11 _110_ VDD VSS / sg13g2_mux2_1
X_234_ _112_ net48 lnb adc_raw_b_13_ _075_ VDD VSS / sg13g2_a22oi_1
X_235_ _040_ _112_ VDD VSS / sg13g2_inv_1
X_236_ _113_ net31 adc_raw_b_12_ VDD VSS / sg13g2_nor2b_1
X_237_ _045_ _113_ net9 net66 VDD VSS / sg13g2_mux2_1
X_238_ _114_ net31 adc_raw_b_11_ VDD VSS / sg13g2_nor2b_1
X_239_ _046_ _114_ net10 net16 VDD VSS / sg13g2_mux2_1
X_240_ _115_ net31 adc_raw_b_10_ VDD VSS / sg13g2_nor2b_1
X_241_ _047_ _115_ net10 net15 VDD VSS / sg13g2_mux2_1
X_242_ _116_ net31 adc_raw_b_9_ VDD VSS / sg13g2_nor2b_1
X_243_ _048_ _116_ net10 net65 VDD VSS / sg13g2_mux2_1
X_244_ _117_ net31 adc_raw_b_8_ VDD VSS / sg13g2_nor2b_1
X_245_ _049_ net10 _117_ _089_ VDD VSS / sg13g2_mux2_1
X_246_ _118_ net32 adc_raw_b_7_ VDD VSS / sg13g2_nor2b_1
X_247_ _050_ _118_ net10 _092_ VDD VSS / sg13g2_mux2_1
X_248_ _119_ step_3_ net9 _095_ VDD VSS / sg13g2_nor3_1
X_249_ _120_ _066_ adc_raw_b_6_ VDD VSS / sg13g2_nand2_1
X_250_ _051_ _096_ _120_ _119_ VDD VSS / sg13g2_a21oi_1
X_251_ _121_ net32 adc_raw_b_5_ VDD VSS / sg13g2_nor2b_1
X_252_ _052_ _121_ net10 _100_ VDD VSS / sg13g2_mux2_1
X_253_ _122_ net32 adc_raw_b_4_ VDD VSS / sg13g2_nor2b_1
X_254_ _053_ net9 _122_ _102_ VDD VSS / sg13g2_mux2_1
X_255_ _123_ net30 adc_raw_b_3_ VDD VSS / sg13g2_nor2b_1
X_256_ _041_ _123_ net9 _104_ VDD VSS / sg13g2_mux2_1
X_257_ _124_ net30 adc_raw_b_2_ VDD VSS / sg13g2_nor2b_1
X_258_ _042_ net9 _124_ _106_ VDD VSS / sg13g2_mux2_1
X_259_ _125_ net30 adc_raw_b_1_ VDD VSS / sg13g2_nor2b_1
X_260_ _043_ _125_ net9 _108_ VDD VSS / sg13g2_mux2_1
X_261_ _126_ net30 adc_raw_b_0_ VDD VSS / sg13g2_nor2b_1
X_262_ _044_ _126_ net9 _110_ VDD VSS / sg13g2_mux2_1
X_263_ _127_ _066_ fna_0_ net49 VDD VSS / sg13g2_a21oi_1
X_264_ _000_ net49 lna _127_ VDD VSS / sg13g2_a21oi_1
X_265_ _128_ net28 net54 VDD VSS / sg13g2_nor2b_1
X_266_ _004_ _128_ net8 _078_ VDD VSS / sg13g2_mux2_1
X_267_ _129_ net28 fna_2_ VDD VSS / sg13g2_nor2b_1
X_268_ _005_ _129_ net8 _080_ VDD VSS / sg13g2_mux2_1
X_269_ _130_ net29 fna_3_ VDD VSS / sg13g2_nor2b_1
X_270_ _006_ _130_ net8 _082_ VDD VSS / sg13g2_mux2_1
X_271_ _131_ net29 net55 VDD VSS / sg13g2_nor2b_1
X_272_ _007_ _131_ _067_ _086_ VDD VSS / sg13g2_mux2_1
X_273_ _132_ net27 fna_5_ VDD VSS / sg13g2_nor2b_1
X_274_ _008_ _067_ _132_ _089_ VDD VSS / sg13g2_mux2_1
X_275_ _133_ net28 fna_6_ VDD VSS / sg13g2_nor2b_1
X_276_ _009_ _133_ _067_ _092_ VDD VSS / sg13g2_mux2_1
X_277_ _134_ net34 fna_7_ VDD VSS / sg13g2_nor2b_1
X_278_ _010_ _096_ _134_ _097_ VDD VSS / sg13g2_a21o_1
X_279_ _135_ net28 fna_8_ VDD VSS / sg13g2_nor2b_1
X_280_ _011_ _135_ net8 net64 VDD VSS / sg13g2_mux2_1
X_281_ _136_ net27 fna_9_ VDD VSS / sg13g2_nor2b_1
X_282_ _012_ net8 _136_ _102_ VDD VSS / sg13g2_mux2_1
X_283_ _137_ net27 fna_10_ VDD VSS / sg13g2_nor2b_1
X_284_ _001_ _137_ net8 _104_ VDD VSS / sg13g2_mux2_1
X_285_ _138_ net27 fna_11_ VDD VSS / sg13g2_nor2b_1
X_286_ _002_ net8 _138_ _106_ VDD VSS / sg13g2_mux2_1
X_287_ _139_ net27 net53 VDD VSS / sg13g2_nor2b_1
X_288_ _003_ _139_ net8 net63 VDD VSS / sg13g2_mux2_1
X_289_ _140_ _066_ fnb_0_ net48 VDD VSS / sg13g2_a21oi_1
X_290_ _013_ net48 lnb _140_ VDD VSS / sg13g2_a21oi_1
X_291_ _141_ net31 fnb_1_ VDD VSS / sg13g2_nor2b_1
X_292_ _017_ _141_ net7 net66 VDD VSS / sg13g2_mux2_1
X_293_ _142_ net33 fnb_2_ VDD VSS / sg13g2_nor2b_1
X_294_ _018_ _142_ net7 net16 VDD VSS / sg13g2_mux2_1
X_295_ _143_ net32 fnb_3_ VDD VSS / sg13g2_nor2b_1
X_296_ _019_ _143_ _068_ net15 VDD VSS / sg13g2_mux2_1
X_297_ _144_ net31 fnb_4_ VDD VSS / sg13g2_nor2b_1
X_298_ _020_ _144_ _068_ net65 VDD VSS / sg13g2_mux2_1
X_299_ _145_ net31 fnb_5_ VDD VSS / sg13g2_nor2b_1
X_300_ _021_ _068_ _145_ _089_ VDD VSS / sg13g2_mux2_1
X_301_ _146_ net32 fnb_6_ VDD VSS / sg13g2_nor2b_1
X_302_ _022_ _146_ net7 _092_ VDD VSS / sg13g2_mux2_1
X_303_ _147_ net30 fnb_7_ VDD VSS / sg13g2_nor2b_1
X_304_ _023_ _096_ _147_ _119_ VDD VSS / sg13g2_a21o_1
X_305_ _148_ net32 fnb_8_ VDD VSS / sg13g2_nor2b_1
X_306_ _024_ _148_ net7 _100_ VDD VSS / sg13g2_mux2_1
X_307_ _149_ net32 fnb_9_ VDD VSS / sg13g2_nor2b_1
X_308_ _025_ net7 _149_ _102_ VDD VSS / sg13g2_mux2_1
X_309_ _150_ net30 fnb_10_ VDD VSS / sg13g2_nor2b_1
X_310_ _014_ _150_ net7 _104_ VDD VSS / sg13g2_mux2_1
X_311_ _151_ net33 fnb_11_ VDD VSS / sg13g2_nor2b_1
X_312_ _015_ net7 _151_ _106_ VDD VSS / sg13g2_mux2_1
X_313_ _152_ net33 fnb_12_ VDD VSS / sg13g2_nor2b_1
X_314_ _016_ _152_ net7 _108_ VDD VSS / sg13g2_mux2_1
X_315_ cpa_12_ adc_raw_a_13_ wq VDD VSS / sg13g2_and2_2
X_316_ cna_12_ fna_0_ wq VDD VSS / sg13g2_and2_2
X_317_ cpb_12_ adc_raw_b_13_ wq VDD VSS / sg13g2_and2_2
X_318_ cnb_12_ wq fnb_0_ VDD VSS / sg13g2_and2_2
X_319_ cpa_11_ adc_raw_a_12_ net37 VDD VSS / sg13g2_and2_2
X_320_ cna_11_ net38 fna_1_ VDD VSS / sg13g2_and2_2
X_321_ cpb_11_ adc_raw_b_12_ net41 VDD VSS / sg13g2_and2_2
X_322_ cnb_11_ net41 fnb_1_ VDD VSS / sg13g2_and2_2
X_323_ cpa_10_ adc_raw_a_11_ net37 VDD VSS / sg13g2_and2_2
X_324_ cna_10_ net35 fna_2_ VDD VSS / sg13g2_and2_2
X_325_ cpb_10_ adc_raw_b_11_ net41 VDD VSS / sg13g2_and2_2
X_326_ cnb_10_ net41 fnb_2_ VDD VSS / sg13g2_and2_2
X_327_ cpa_9_ adc_raw_a_10_ net39 VDD VSS / sg13g2_and2_2
X_328_ cna_9_ net35 fna_3_ VDD VSS / sg13g2_and2_2
X_329_ cpb_9_ net43 adc_raw_b_10_ VDD VSS / sg13g2_and2_2
X_330_ cnb_9_ net43 fnb_3_ VDD VSS / sg13g2_and2_2
X_331_ cpa_8_ adc_raw_a_9_ net39 VDD VSS / sg13g2_and2_2
X_332_ cna_8_ net35 fna_4_ VDD VSS / sg13g2_and2_2
X_333_ cpb_8_ adc_raw_b_9_ net42 VDD VSS / sg13g2_and2_2
X_334_ cnb_8_ net41 fnb_4_ VDD VSS / sg13g2_and2_2
X_335_ cpa_7_ adc_raw_a_8_ net37 VDD VSS / sg13g2_and2_2
X_336_ cna_7_ net36 fna_5_ VDD VSS / sg13g2_and2_2
X_337_ cpb_7_ adc_raw_b_8_ net41 VDD VSS / sg13g2_and2_2
X_338_ cnb_7_ net42 fnb_5_ VDD VSS / sg13g2_and2_2
X_339_ cpa_6_ adc_raw_a_7_ net37 VDD VSS / sg13g2_and2_2
X_340_ cna_6_ net35 fna_6_ VDD VSS / sg13g2_and2_2
X_341_ cpb_6_ adc_raw_b_7_ net42 VDD VSS / sg13g2_and2_2
X_342_ cnb_6_ net43 fnb_6_ VDD VSS / sg13g2_and2_2
X_343_ cpa_5_ adc_raw_a_6_ net37 VDD VSS / sg13g2_and2_2
X_344_ cna_5_ net35 fna_7_ VDD VSS / sg13g2_and2_2
X_345_ cpb_5_ adc_raw_b_6_ net42 VDD VSS / sg13g2_and2_2
X_346_ cnb_5_ net44 fnb_7_ VDD VSS / sg13g2_and2_2
X_347_ cpa_4_ adc_raw_a_5_ net37 VDD VSS / sg13g2_and2_2
X_348_ cna_4_ net35 fna_8_ VDD VSS / sg13g2_and2_2
X_349_ cpb_4_ adc_raw_b_5_ net42 VDD VSS / sg13g2_and2_2
X_350_ cnb_4_ net43 fnb_8_ VDD VSS / sg13g2_and2_2
X_351_ cpa_3_ adc_raw_a_4_ net37 VDD VSS / sg13g2_and2_2
X_352_ cna_3_ net35 fna_9_ VDD VSS / sg13g2_and2_2
X_353_ cpb_3_ adc_raw_b_4_ net42 VDD VSS / sg13g2_and2_2
X_354_ cnb_3_ net43 fnb_9_ VDD VSS / sg13g2_and2_2
X_355_ cpa_2_ adc_raw_a_3_ net37 VDD VSS / sg13g2_and2_2
X_356_ cna_2_ net35 fna_10_ VDD VSS / sg13g2_and2_2
X_357_ cpb_2_ adc_raw_b_3_ net42 VDD VSS / sg13g2_and2_2
X_358_ cnb_2_ net43 fnb_10_ VDD VSS / sg13g2_and2_2
X_359_ cpa_1_ adc_raw_a_2_ net38 VDD VSS / sg13g2_and2_2
X_360_ cna_1_ net36 fna_11_ VDD VSS / sg13g2_and2_2
X_361_ cpb_1_ adc_raw_b_2_ net41 VDD VSS / sg13g2_and2_2
X_362_ cnb_1_ net43 fnb_11_ VDD VSS / sg13g2_and2_2
X_363_ cpa_0_ adc_raw_a_1_ net38 VDD VSS / sg13g2_and2_2
X_364_ cna_0_ net36 fna_12_ VDD VSS / sg13g2_and2_2
X_365_ cpb_0_ adc_raw_b_1_ net41 VDD VSS / sg13g2_and2_2
X_366_ cnb_0_ net44 fnb_12_ VDD VSS / sg13g2_and2_2
X_367_ _055_ net49 _071_ _088_ VDD VSS / sg13g2_nor3_1
X_368_ _153_ net48 _084_ VDD VSS / sg13g2_nor2b_1
X_369_ _058_ net40 _065_ _153_ VDD VSS / sg13g2_o21ai_1
X_370_ _154_ net40 net47 net46 VDD VSS / sg13g2_a21oi_1
X_371_ _059_ net49 _094_ _154_ VDD VSS / sg13g2_nor3_1
X_372_ _155_ step_2_ _094_ VDD VSS / sg13g2_xnor2_1
X_373_ _060_ net49 _155_ VDD VSS / sg13g2_nor2_1
X_374_ _156_ step_3_ _095_ VDD VSS / sg13g2_nand2_1
X_375_ _061_ _096_ _156_ net49 VDD VSS / sg13g2_a21oi_1
X_376_ _157_ _071_ _088_ _063_ VDD VSS / sg13g2_o21ai_1
X_377_ _158_ net2 _069_ VDD VSS / sg13g2_nor2_1
X_378_ _062_ _157_ net59 VDD VSS / sg13g2_and2_1
X_379_ step_0_ clknet_4_7__leaf_clk _058_ net23 VDD VSS / sg13g2_dfrbpq_1
X_380_ step_1_ clknet_4_7__leaf_clk _059_ net19 VDD VSS / sg13g2_dfrbpq_1
X_381_ step_2_ clknet_4_5__leaf_clk _060_ net20 VDD VSS / sg13g2_dfrbpq_1
X_382_ step_3_ clknet_4_9__leaf_clk _061_ net23 VDD VSS / sg13g2_dfrbpq_1
X_383_ done_q clknet_4_3__leaf_clk _062_ net17 VDD VSS / sg13g2_dfrbpq_1
X_384_ adc_raw_a_13_ clknet_4_13__leaf_clk _026_ net23 VDD VSS / sg13g2_dfrbpq_2
X_385_ adc_raw_a_12_ clknet_4_4__leaf_clk _031_ net19 VDD VSS / sg13g2_dfrbpq_2
X_386_ adc_raw_a_11_ clknet_4_7__leaf_clk _032_ net20 VDD VSS / sg13g2_dfrbpq_2
X_387_ adc_raw_a_10_ clknet_4_4__leaf_clk _033_ net20 VDD VSS / sg13g2_dfrbpq_2
X_388_ adc_raw_a_9_ clknet_4_4__leaf_clk _034_ net19 VDD VSS / sg13g2_dfrbpq_2
X_389_ adc_raw_a_8_ clknet_4_6__leaf_clk _035_ net19 VDD VSS / sg13g2_dfrbpq_2
X_390_ adc_raw_a_7_ clknet_4_6__leaf_clk _036_ net19 VDD VSS / sg13g2_dfrbpq_2
X_391_ adc_raw_a_6_ clknet_4_5__leaf_clk _037_ net20 VDD VSS / sg13g2_dfrbpq_2
X_392_ adc_raw_a_5_ clknet_4_6__leaf_clk _038_ net19 VDD VSS / sg13g2_dfrbpq_2
X_393_ adc_raw_a_4_ clknet_4_2__leaf_clk _039_ net18 VDD VSS / sg13g2_dfrbpq_2
X_394_ adc_raw_a_3_ clknet_4_2__leaf_clk _027_ net18 VDD VSS / sg13g2_dfrbpq_2
X_395_ adc_raw_a_2_ clknet_4_2__leaf_clk _028_ net18 VDD VSS / sg13g2_dfrbpq_2
X_396_ adc_raw_a_1_ clknet_4_3__leaf_clk _029_ net17 VDD VSS / sg13g2_dfrbpq_2
X_397_ adc_raw_a_0_ clknet_4_3__leaf_clk _030_ net17 VDD VSS / sg13g2_dfrbpq_1
X_398_ adc_raw_b_13_ clknet_4_13__leaf_clk _040_ net22 VDD VSS / sg13g2_dfrbpq_2
X_399_ adc_raw_b_12_ clknet_4_11__leaf_clk _045_ net24 VDD VSS / sg13g2_dfrbpq_2
X_400_ adc_raw_b_11_ clknet_4_14__leaf_clk _046_ net24 VDD VSS / sg13g2_dfrbpq_2
X_401_ adc_raw_b_10_ clknet_4_14__leaf_clk _047_ net24 VDD VSS / sg13g2_dfrbpq_2
X_402_ adc_raw_b_9_ clknet_4_14__leaf_clk _048_ net24 VDD VSS / sg13g2_dfrbpq_2
X_403_ adc_raw_b_8_ clknet_4_15__leaf_clk _049_ net24 VDD VSS / sg13g2_dfrbpq_2
X_404_ adc_raw_b_7_ clknet_4_15__leaf_clk _050_ net25 VDD VSS / sg13g2_dfrbpq_2
X_405_ adc_raw_b_6_ clknet_4_8__leaf_clk _051_ net22 VDD VSS / sg13g2_dfrbpq_2
X_406_ adc_raw_b_5_ clknet_4_15__leaf_clk _052_ net25 VDD VSS / sg13g2_dfrbpq_2
X_407_ adc_raw_b_4_ clknet_4_15__leaf_clk _053_ net25 VDD VSS / sg13g2_dfrbpq_2
X_408_ adc_raw_b_3_ clknet_4_12__leaf_clk _041_ net25 VDD VSS / sg13g2_dfrbpq_2
X_409_ adc_raw_b_2_ clknet_4_12__leaf_clk _042_ net22 VDD VSS / sg13g2_dfrbpq_2
X_410_ adc_raw_b_1_ clknet_4_12__leaf_clk _043_ net22 VDD VSS / sg13g2_dfrbpq_2
X_411_ adc_raw_b_0_ clknet_4_13__leaf_clk _044_ net23 VDD VSS / sg13g2_dfrbpq_1
X_412_ fna_0_ clknet_4_5__leaf_clk _000_ net20 VDD VSS / sg13g2_dfrbpq_1
X_413_ fna_1_ clknet_4_4__leaf_clk _004_ net19 VDD VSS / sg13g2_dfrbpq_1
X_414_ fna_2_ clknet_4_4__leaf_clk _005_ net19 VDD VSS / sg13g2_dfrbpq_1
X_415_ fna_3_ clknet_4_0__leaf_clk _006_ net18 VDD VSS / sg13g2_dfrbpq_1
X_416_ fna_4_ clknet_4_0__leaf_clk _007_ net18 VDD VSS / sg13g2_dfrbpq_1
X_417_ fna_5_ clknet_4_2__leaf_clk _008_ net21 VDD VSS / sg13g2_dfrbpq_1
X_418_ fna_6_ clknet_4_0__leaf_clk _009_ net21 VDD VSS / sg13g2_dfrbpq_1
X_419_ fna_7_ clknet_4_6__leaf_clk _010_ net20 VDD VSS / sg13g2_dfrbpq_2
X_420_ fna_8_ clknet_4_3__leaf_clk _011_ net17 VDD VSS / sg13g2_dfrbpq_1
X_421_ fna_9_ clknet_4_0__leaf_clk _012_ net18 VDD VSS / sg13g2_dfrbpq_1
X_422_ fna_10_ clknet_4_0__leaf_clk _001_ net18 VDD VSS / sg13g2_dfrbpq_1
X_423_ fna_11_ clknet_4_1__leaf_clk _002_ net17 VDD VSS / sg13g2_dfrbpq_1
X_424_ fna_12_ clknet_4_1__leaf_clk _003_ net17 VDD VSS / sg13g2_dfrbpq_1
X_425_ fnb_0_ clknet_4_9__leaf_clk _013_ net22 VDD VSS / sg13g2_dfrbpq_1
X_426_ fnb_1_ clknet_4_10__leaf_clk _017_ net24 VDD VSS / sg13g2_dfrbpq_1
X_427_ fnb_2_ clknet_4_10__leaf_clk _018_ net26 VDD VSS / sg13g2_dfrbpq_1
X_428_ fnb_3_ clknet_4_10__leaf_clk _019_ net24 VDD VSS / sg13g2_dfrbpq_1
X_429_ fnb_4_ clknet_4_11__leaf_clk _020_ net24 VDD VSS / sg13g2_dfrbpq_1
X_430_ fnb_5_ clknet_4_11__leaf_clk _021_ net25 VDD VSS / sg13g2_dfrbpq_1
X_431_ fnb_6_ clknet_4_10__leaf_clk _022_ net25 VDD VSS / sg13g2_dfrbpq_1
X_432_ fnb_7_ clknet_4_8__leaf_clk _023_ net22 VDD VSS / sg13g2_dfrbpq_1
X_433_ fnb_8_ clknet_4_8__leaf_clk _024_ net25 VDD VSS / sg13g2_dfrbpq_1
X_434_ fnb_9_ clknet_4_12__leaf_clk _025_ net25 VDD VSS / sg13g2_dfrbpq_1
X_435_ fnb_10_ clknet_4_12__leaf_clk _014_ net22 VDD VSS / sg13g2_dfrbpq_1
X_436_ fnb_11_ clknet_4_8__leaf_clk _015_ net22 VDD VSS / sg13g2_dfrbpq_1
X_437_ fnb_12_ clknet_4_8__leaf_clk _016_ net26 VDD VSS / sg13g2_dfrbpq_1
X_438_ _056_ clknet_4_1__leaf_clk _057_ net17 VDD VSS / sg13g2_dfrbpq_1
X_439_ sel1 clknet_4_1__leaf_clk _054_ net17 VDD VSS / sg13g2_dfrbpq_1
X_440_ busy clknet_4_9__leaf_clk wq_d net23 VDD VSS / sg13g2_dfrbpq_1
X_441_ net60 clknet_4_7__leaf_clk _055_ net20 VDD VSS / sg13g2_dfrbpq_1
X_442_ vd clknet_4_13__leaf_clk net61 net23 VDD VSS / sg13g2_dfrbpq_1
X_443_ rs_0_ clknet_4_11__leaf_clk net net6 VDD VSS / sg13g2_dfrbpq_1
X_443__50 net VDD VSS / sg13g2_tiehi
X_444_ rs_1_ clknet_4_14__leaf_clk net62 net6 VDD VSS / sg13g2_dfrbpq_1
X_446_ adc_valid_b adc_valid_a VDD VSS / sg13g2_buf_1
X_447_ clkb clka VDD VSS / sg13g2_buf_2
X_448_ clkbb net51 VDD VSS / sg13g2_buf_1
X_449_ clknb net13 VDD VSS / sg13g2_buf_2
X_450_ clknbb clknab VDD VSS / sg13g2_buf_2
X_451_ trkb0 trka0 VDD VSS / sg13g2_buf_1
X_452_ trkb1 trka1 VDD VSS / sg13g2_buf_1
Xclkbuf_0_clk clknet_0_clk clk VDD VSS / sg13g2_buf_2
Xclkbuf_3_0_0_clk clknet_3_0_0_clk clknet_0_clk VDD VSS / sg13g2_buf_4
Xclkbuf_3_1_0_clk clknet_3_1_0_clk clknet_0_clk VDD VSS / sg13g2_buf_4
Xclkbuf_3_2_0_clk clknet_3_2_0_clk clknet_0_clk VDD VSS / sg13g2_buf_4
Xclkbuf_3_3_0_clk clknet_3_3_0_clk clknet_0_clk VDD VSS / sg13g2_buf_4
Xclkbuf_3_4_0_clk clknet_3_4_0_clk clknet_0_clk VDD VSS / sg13g2_buf_4
Xclkbuf_3_5_0_clk clknet_3_5_0_clk clknet_0_clk VDD VSS / sg13g2_buf_4
Xclkbuf_3_6_0_clk clknet_3_6_0_clk clknet_0_clk VDD VSS / sg13g2_buf_4
Xclkbuf_3_7_0_clk clknet_3_7_0_clk clknet_0_clk VDD VSS / sg13g2_buf_4
Xclkbuf_4_0__f_clk clknet_4_0__leaf_clk clknet_3_0_0_clk VDD VSS / sg13g2_buf_2
Xclkbuf_4_10__f_clk clknet_4_10__leaf_clk clknet_3_5_0_clk VDD VSS / sg13g2_buf_2
Xclkbuf_4_11__f_clk clknet_4_11__leaf_clk clknet_3_5_0_clk VDD VSS / sg13g2_buf_2
Xclkbuf_4_12__f_clk clknet_4_12__leaf_clk clknet_3_6_0_clk VDD VSS / sg13g2_buf_2
Xclkbuf_4_13__f_clk clknet_4_13__leaf_clk clknet_3_6_0_clk VDD VSS / sg13g2_buf_2
Xclkbuf_4_14__f_clk clknet_4_14__leaf_clk clknet_3_7_0_clk VDD VSS / sg13g2_buf_2
Xclkbuf_4_15__f_clk clknet_4_15__leaf_clk clknet_3_7_0_clk VDD VSS / sg13g2_buf_2
Xclkbuf_4_1__f_clk clknet_4_1__leaf_clk clknet_3_0_0_clk VDD VSS / sg13g2_buf_2
Xclkbuf_4_2__f_clk clknet_4_2__leaf_clk clknet_3_1_0_clk VDD VSS / sg13g2_buf_2
Xclkbuf_4_3__f_clk clknet_4_3__leaf_clk clknet_3_1_0_clk VDD VSS / sg13g2_buf_2
Xclkbuf_4_4__f_clk clknet_4_4__leaf_clk clknet_3_2_0_clk VDD VSS / sg13g2_buf_2
Xclkbuf_4_5__f_clk clknet_4_5__leaf_clk clknet_3_2_0_clk VDD VSS / sg13g2_buf_2
Xclkbuf_4_6__f_clk clknet_4_6__leaf_clk clknet_3_3_0_clk VDD VSS / sg13g2_buf_2
Xclkbuf_4_7__f_clk clknet_4_7__leaf_clk clknet_3_3_0_clk VDD VSS / sg13g2_buf_2
Xclkbuf_4_8__f_clk clknet_4_8__leaf_clk clknet_3_4_0_clk VDD VSS / sg13g2_buf_2
Xclkbuf_4_9__f_clk clknet_4_9__leaf_clk clknet_3_4_0_clk VDD VSS / sg13g2_buf_2
Xclkload0 _nc1 clknet_4_1__leaf_clk VDD VSS / sg13g2_inv_1
Xclkload1 _nc2 clknet_4_5__leaf_clk VDD VSS / sg13g2_inv_1
Xclkload2 _nc3 clknet_4_9__leaf_clk VDD VSS / sg13g2_inv_1
Xclkload3 _nc4 clknet_4_13__leaf_clk VDD VSS / sg13g2_inv_1
Xfanout10 net10 lpb VDD VSS / sg13g2_buf_1
Xfanout11 net11 lpa VDD VSS / sg13g2_buf_1
Xfanout12 net12 lpa VDD VSS / sg13g2_buf_1
Xfanout17 net17 net18 VDD VSS / sg13g2_buf_1
Xfanout18 net18 net21 VDD VSS / sg13g2_buf_1
Xfanout19 net19 net21 VDD VSS / sg13g2_buf_1
Xfanout20 net20 net21 VDD VSS / sg13g2_buf_1
Xfanout21 net21 rs_1_ VDD VSS / sg13g2_buf_1
Xfanout22 net22 net26 VDD VSS / sg13g2_buf_1
Xfanout23 net23 net26 VDD VSS / sg13g2_buf_1
Xfanout24 net24 net26 VDD VSS / sg13g2_buf_1
Xfanout25 net25 net26 VDD VSS / sg13g2_buf_1
Xfanout26 net26 rs_1_ VDD VSS / sg13g2_buf_1
Xfanout27 net27 net28 VDD VSS / sg13g2_buf_1
Xfanout28 net28 net29 VDD VSS / sg13g2_buf_1
Xfanout29 net29 net34 VDD VSS / sg13g2_buf_1
Xfanout30 net30 net33 VDD VSS / sg13g2_buf_1
Xfanout31 net31 net32 VDD VSS / sg13g2_buf_1
Xfanout32 net32 net33 VDD VSS / sg13g2_buf_1
Xfanout33 net33 net34 VDD VSS / sg13g2_buf_1
Xfanout34 net34 vd VDD VSS / sg13g2_buf_1
Xfanout35 net35 net36 VDD VSS / sg13g2_buf_1
Xfanout36 net36 busy VDD VSS / sg13g2_buf_1
Xfanout37 net37 net38 VDD VSS / sg13g2_buf_1
Xfanout38 net38 net39 VDD VSS / sg13g2_buf_1
Xfanout39 net39 busy VDD VSS / sg13g2_buf_1
Xfanout40 net40 net44 VDD VSS / sg13g2_buf_1
Xfanout41 net41 net42 VDD VSS / sg13g2_buf_1
Xfanout42 net42 net43 VDD VSS / sg13g2_buf_1
Xfanout43 net43 net44 VDD VSS / sg13g2_buf_1
Xfanout44 net44 busy VDD VSS / sg13g2_buf_1
Xfanout45 net45 step_3_ VDD VSS / sg13g2_buf_1
Xfanout46 net46 step_1_ VDD VSS / sg13g2_buf_1
Xfanout47 net47 step_0_ VDD VSS / sg13g2_buf_1
Xfanout48 net48 net49 VDD VSS / sg13g2_buf_1
Xfanout49 net49 net2 VDD VSS / sg13g2_buf_1
Xfanout7 net7 _068_ VDD VSS / sg13g2_buf_1
Xfanout8 net8 _067_ VDD VSS / sg13g2_buf_1
Xfanout9 net9 lpb VDD VSS / sg13g2_buf_1
Xhold57 net56 cur_trk VDD VSS / sg13g2_dlygate4sd3_1
Xhold58 net57 net3 VDD VSS / sg13g2_dlygate4sd3_1
Xhold59 net58 adc_start VDD VSS / sg13g2_dlygate4sd3_1
Xhold60 net59 _158_ VDD VSS / sg13g2_dlygate4sd3_1
Xhold61 adc_valid_a net60 VDD VSS / sg13g2_dlygate4sd3_1
Xhold62 net61 net60 VDD VSS / sg13g2_dlygate4sd3_1
Xhold63 net62 rs_0_ VDD VSS / sg13g2_dlygate4sd3_1
Xinput1 net1 adc_hold VDD VSS / sg13g2_buf_1
Xinput2 net2 net58 VDD VSS / sg13g2_buf_1
Xinput3 net3 net56 VDD VSS / sg13g2_buf_1
Xinput4 net4 is_smp VDD VSS / sg13g2_buf_1
Xinput5 net5 mclk VDD VSS / sg13g2_buf_1
Xinput6 net6 por_n VDD VSS / sg13g2_buf_1
Xmax_cap15 net15 _082_ VDD VSS / sg13g2_buf_2
Xmax_cap16 net16 _080_ VDD VSS / sg13g2_buf_2
Xmax_cap64 net63 _108_ VDD VSS / sg13g2_buf_4
Xmax_cap65 net64 _100_ VDD VSS / sg13g2_buf_4
Xmax_cap66 net65 _086_ VDD VSS / sg13g2_buf_4
Xmax_cap67 net66 _078_ VDD VSS / sg13g2_buf_4
Xrebuffer51 net50 net51 VDD VSS / sg13g2_buf_1
Xrebuffer52 net51 net14 VDD VSS / sg13g2_buf_2
Xrebuffer53 net52 wq VDD VSS / sg13g2_buf_1
Xrebuffer54 net53 fna_12_ VDD VSS / sg13g2_buf_1
Xrebuffer55 net54 fna_1_ VDD VSS / sg13g2_buf_1
Xrebuffer56 net55 fna_4_ VDD VSS / sg13g2_buf_1
Xu_dly_hs1 hsd1 hs VDD VSS / sg13g2_dlygate4sd3_1
Xu_dly_hs2 hsd hsd1 VDD VSS / sg13g2_dlygate4sd3_1
Xu_fv0 fv0 clknet_4_9__leaf_clk fv0_d net23 VDD VSS / sg13g2_dfrbpq_2
Xu_lat_na lna oanp net13 VDD VSS / sg13g2_dlhq_1
Xu_lat_nb lnb obnp net13 VDD VSS / sg13g2_dlhq_1
Xu_lat_pa lpa oap clka VDD VSS / sg13g2_dlhq_1
Xu_lat_pb lpb obp clka VDD VSS / sg13g2_dlhq_1
Xu_ld_oan nc_oan oan VDD VSS / sg13g2_buf_1
Xu_ld_oann nc_oann oann VDD VSS / sg13g2_buf_1
Xu_ld_obn nc_obn obn VDD VSS / sg13g2_buf_1
Xu_ld_obnn nc_obnn obnn VDD VSS / sg13g2_buf_1
Xu_ld_sel nc_sel adc_sel VDD VSS / sg13g2_buf_1
Xu_wq wq clknet_4_5__leaf_clk wq_d net23 VDD VSS / sg13g2_dfrbpq_2
Xwire13 clkna net13 VDD VSS / sg13g2_buf_8
Xwire14 clkab net50 VDD VSS / sg13g2_buf_8
.ENDS

* LVS reference CDL for r1_adc (revision 5 netlist of record), written by layout/r1_adc_netlist.py from schematic/r1_adc_r5.spice
* mapping: see the module docstring (CDAC units + dummies, Cboot / clkgen caps as MIM, multiplier and decoupling split); r1_sar5_logic (behavioural) not laid out: its nets are sar_* ports
.subckt r1_adc_slice in0p in0n in1p in1n trk0 trk1 cp0 cp1 cp2 cp3 cp4 cp5 cp6 cp7 cp8 cp9 cp10 cp11 cp12 cn0 cn1 cn2 cn3 cn4 cn5 cn6 cn7 cn8 cn9 cn10 cn11 cn12 clk clkb clkn clknb op on onp onn vbp vbn vref vrefl top_p top_n vdd gnd
Mxpt0a t0b trk0 vdd vdd sg13_lv_pmos w=2u l=0.13u m=1
Mxnt0a t0b trk0 gnd gnd sg13_lv_nmos w=1u l=0.13u m=1
Mxpt0b t0 t0b vdd vdd sg13_lv_pmos w=4u l=0.13u m=1
Mxnt0b t0 t0b gnd gnd sg13_lv_nmos w=2u l=0.13u m=1
Mxpt1a t1b trk1 vdd vdd sg13_lv_pmos w=2u l=0.13u m=1
Mxnt1a t1b trk1 gnd gnd sg13_lv_nmos w=1u l=0.13u m=1
Mxpt1b t1 t1b vdd vdd sg13_lv_pmos w=4u l=0.13u m=1
Mxnt1b t1 t1b gnd gnd sg13_lv_nmos w=2u l=0.13u m=1
Mxs0p_xms in0p xs0p_g top_p gnd sg13_lv_nmos w=6u l=0.13u m=1
Cxs0p_cboot xs0p_cbp xs0p_cbn cap_cmim w=11.49u l=11.49u m=1
Mxs0p_xm1 xs0p_cbn t0b gnd gnd sg13_lv_nmos w=1u l=0.13u m=1
Mxs0p_xm3 xs0p_cbp xs0p_g vdd xs0p_cbp sg13_lv_pmos w=1u l=0.13u m=1
Mxs0p_xm8 xs0p_g xs0p_x xs0p_cbp xs0p_cbp sg13_lv_pmos w=2u l=0.13u m=1
Mxs0p_xm4 xs0p_x t0 vdd vdd sg13_lv_pmos w=0.5u l=0.13u m=1
Mxs0p_xm5 xs0p_x t0 xs0p_cbn gnd sg13_lv_nmos w=1u l=0.13u m=1
Mxs0p_xm7 xs0p_x xs0p_g xs0p_cbn gnd sg13_lv_nmos w=0.5u l=0.13u m=1
Mxs0p_xm9 xs0p_cbn xs0p_g in0p gnd sg13_lv_nmos w=2u l=0.13u m=1
Mxs0p_xm10 xs0p_g vdd xs0p_n10 gnd sg13_lv_nmos w=2u l=0.13u m=1
Mxs0p_xm11 xs0p_n10 t0b gnd gnd sg13_lv_nmos w=2u l=0.13u m=1
Mxs0n_xms in0n xs0n_g top_n gnd sg13_lv_nmos w=6u l=0.13u m=1
Cxs0n_cboot xs0n_cbp xs0n_cbn cap_cmim w=11.49u l=11.49u m=1
Mxs0n_xm1 xs0n_cbn t0b gnd gnd sg13_lv_nmos w=1u l=0.13u m=1
Mxs0n_xm3 xs0n_cbp xs0n_g vdd xs0n_cbp sg13_lv_pmos w=1u l=0.13u m=1
Mxs0n_xm8 xs0n_g xs0n_x xs0n_cbp xs0n_cbp sg13_lv_pmos w=2u l=0.13u m=1
Mxs0n_xm4 xs0n_x t0 vdd vdd sg13_lv_pmos w=0.5u l=0.13u m=1
Mxs0n_xm5 xs0n_x t0 xs0n_cbn gnd sg13_lv_nmos w=1u l=0.13u m=1
Mxs0n_xm7 xs0n_x xs0n_g xs0n_cbn gnd sg13_lv_nmos w=0.5u l=0.13u m=1
Mxs0n_xm9 xs0n_cbn xs0n_g in0n gnd sg13_lv_nmos w=2u l=0.13u m=1
Mxs0n_xm10 xs0n_g vdd xs0n_n10 gnd sg13_lv_nmos w=2u l=0.13u m=1
Mxs0n_xm11 xs0n_n10 t0b gnd gnd sg13_lv_nmos w=2u l=0.13u m=1
Mxs1p_xms in1p xs1p_g top_p gnd sg13_lv_nmos w=6u l=0.13u m=1
Cxs1p_cboot xs1p_cbp xs1p_cbn cap_cmim w=11.49u l=11.49u m=1
Mxs1p_xm1 xs1p_cbn t1b gnd gnd sg13_lv_nmos w=1u l=0.13u m=1
Mxs1p_xm3 xs1p_cbp xs1p_g vdd xs1p_cbp sg13_lv_pmos w=1u l=0.13u m=1
Mxs1p_xm8 xs1p_g xs1p_x xs1p_cbp xs1p_cbp sg13_lv_pmos w=2u l=0.13u m=1
Mxs1p_xm4 xs1p_x t1 vdd vdd sg13_lv_pmos w=0.5u l=0.13u m=1
Mxs1p_xm5 xs1p_x t1 xs1p_cbn gnd sg13_lv_nmos w=1u l=0.13u m=1
Mxs1p_xm7 xs1p_x xs1p_g xs1p_cbn gnd sg13_lv_nmos w=0.5u l=0.13u m=1
Mxs1p_xm9 xs1p_cbn xs1p_g in1p gnd sg13_lv_nmos w=2u l=0.13u m=1
Mxs1p_xm10 xs1p_g vdd xs1p_n10 gnd sg13_lv_nmos w=2u l=0.13u m=1
Mxs1p_xm11 xs1p_n10 t1b gnd gnd sg13_lv_nmos w=2u l=0.13u m=1
Mxs1n_xms in1n xs1n_g top_n gnd sg13_lv_nmos w=6u l=0.13u m=1
Cxs1n_cboot xs1n_cbp xs1n_cbn cap_cmim w=11.49u l=11.49u m=1
Mxs1n_xm1 xs1n_cbn t1b gnd gnd sg13_lv_nmos w=1u l=0.13u m=1
Mxs1n_xm3 xs1n_cbp xs1n_g vdd xs1n_cbp sg13_lv_pmos w=1u l=0.13u m=1
Mxs1n_xm8 xs1n_g xs1n_x xs1n_cbp xs1n_cbp sg13_lv_pmos w=2u l=0.13u m=1
Mxs1n_xm4 xs1n_x t1 vdd vdd sg13_lv_pmos w=0.5u l=0.13u m=1
Mxs1n_xm5 xs1n_x t1 xs1n_cbn gnd sg13_lv_nmos w=1u l=0.13u m=1
Mxs1n_xm7 xs1n_x xs1n_g xs1n_cbn gnd sg13_lv_nmos w=0.5u l=0.13u m=1
Mxs1n_xm9 xs1n_cbn xs1n_g in1n gnd sg13_lv_nmos w=2u l=0.13u m=1
Mxs1n_xm10 xs1n_g vdd xs1n_n10 gnd sg13_lv_nmos w=2u l=0.13u m=1
Mxs1n_xm11 xs1n_n10 t1b gnd gnd sg13_lv_nmos w=2u l=0.13u m=1
Mxpr1 rstb_n t0b vdd vdd sg13_lv_pmos w=1u l=0.13u m=1
Mxpr2 rstb_n t1b vdd vdd sg13_lv_pmos w=1u l=0.13u m=1
Mxnr1 rstb_n t0b nr gnd sg13_lv_nmos w=1u l=0.13u m=1
Mxnr2 nr t1b gnd gnd sg13_lv_nmos w=1u l=0.13u m=1
Mxpr3 rstb rstb_n vdd vdd sg13_lv_pmos w=1u l=0.13u m=1
Mxnr3 rstb rstb_n gnd gnd sg13_lv_nmos w=0.5u l=0.13u m=1
Mxlrp lsb_p rstb vrefl vrefl sg13_lv_pmos w=1u l=0.13u m=1
Mxlrn lsb_n rstb vrefl vrefl sg13_lv_pmos w=1u l=0.13u m=1
Mxdp12_xmp bp12 cp12 vref vref sg13_lv_pmos w=2u l=0.13u m=1
Mxdp12_xmn bp12 cp12 gnd gnd sg13_lv_nmos w=1u l=0.13u m=1
Mxdp11_xmp bp11 cp11 vref vref sg13_lv_pmos w=2u l=0.13u m=1
Mxdp11_xmn bp11 cp11 gnd gnd sg13_lv_nmos w=1u l=0.13u m=1
Mxdp10_xmp bp10 cp10 vref vref sg13_lv_pmos w=2u l=0.13u m=1
Mxdp10_xmn bp10 cp10 gnd gnd sg13_lv_nmos w=1u l=0.13u m=1
Mxdp9_xmp bp9 cp9 vref vref sg13_lv_pmos w=1u l=0.13u m=1
Mxdp9_xmn bp9 cp9 gnd gnd sg13_lv_nmos w=0.5u l=0.13u m=1
Mxdp8_xmp bp8 cp8 vref vref sg13_lv_pmos w=1u l=0.13u m=1
Mxdp8_xmn bp8 cp8 gnd gnd sg13_lv_nmos w=0.5u l=0.13u m=1
Mxdp7_xmp bp7 cp7 vrefl vrefl sg13_lv_pmos w=1u l=0.13u m=1
Mxdp7_xmn bp7 cp7 gnd gnd sg13_lv_nmos w=0.5u l=0.13u m=1
Mxdp6_xmp bp6 cp6 vrefl vrefl sg13_lv_pmos w=1u l=0.13u m=1
Mxdp6_xmn bp6 cp6 gnd gnd sg13_lv_nmos w=0.5u l=0.13u m=1
Mxdp5_xmp bp5 cp5 vrefl vrefl sg13_lv_pmos w=1u l=0.13u m=1
Mxdp5_xmn bp5 cp5 gnd gnd sg13_lv_nmos w=0.5u l=0.13u m=1
Mxdp4_xmp bp4 cp4 vrefl vrefl sg13_lv_pmos w=1u l=0.13u m=1
Mxdp4_xmn bp4 cp4 gnd gnd sg13_lv_nmos w=0.5u l=0.13u m=1
Mxdp3_xmp bp3 cp3 vrefl vrefl sg13_lv_pmos w=1u l=0.13u m=1
Mxdp3_xmn bp3 cp3 gnd gnd sg13_lv_nmos w=0.5u l=0.13u m=1
Mxdp2_xmp bp2 cp2 vrefl vrefl sg13_lv_pmos w=1u l=0.13u m=1
Mxdp2_xmn bp2 cp2 gnd gnd sg13_lv_nmos w=0.5u l=0.13u m=1
Mxdp1_xmp bp1 cp1 vrefl vrefl sg13_lv_pmos w=1u l=0.13u m=1
Mxdp1_xmn bp1 cp1 gnd gnd sg13_lv_nmos w=0.5u l=0.13u m=1
Mxdp0_xmp bp0 cp0 vrefl vrefl sg13_lv_pmos w=1u l=0.13u m=1
Mxdp0_xmn bp0 cp0 gnd gnd sg13_lv_nmos w=0.5u l=0.13u m=1
Mxdn12_xmp bn12 cn12 vref vref sg13_lv_pmos w=2u l=0.13u m=1
Mxdn12_xmn bn12 cn12 gnd gnd sg13_lv_nmos w=1u l=0.13u m=1
Mxdn11_xmp bn11 cn11 vref vref sg13_lv_pmos w=2u l=0.13u m=1
Mxdn11_xmn bn11 cn11 gnd gnd sg13_lv_nmos w=1u l=0.13u m=1
Mxdn10_xmp bn10 cn10 vref vref sg13_lv_pmos w=2u l=0.13u m=1
Mxdn10_xmn bn10 cn10 gnd gnd sg13_lv_nmos w=1u l=0.13u m=1
Mxdn9_xmp bn9 cn9 vref vref sg13_lv_pmos w=1u l=0.13u m=1
Mxdn9_xmn bn9 cn9 gnd gnd sg13_lv_nmos w=0.5u l=0.13u m=1
Mxdn8_xmp bn8 cn8 vref vref sg13_lv_pmos w=1u l=0.13u m=1
Mxdn8_xmn bn8 cn8 gnd gnd sg13_lv_nmos w=0.5u l=0.13u m=1
Mxdn7_xmp bn7 cn7 vrefl vrefl sg13_lv_pmos w=1u l=0.13u m=1
Mxdn7_xmn bn7 cn7 gnd gnd sg13_lv_nmos w=0.5u l=0.13u m=1
Mxdn6_xmp bn6 cn6 vrefl vrefl sg13_lv_pmos w=1u l=0.13u m=1
Mxdn6_xmn bn6 cn6 gnd gnd sg13_lv_nmos w=0.5u l=0.13u m=1
Mxdn5_xmp bn5 cn5 vrefl vrefl sg13_lv_pmos w=1u l=0.13u m=1
Mxdn5_xmn bn5 cn5 gnd gnd sg13_lv_nmos w=0.5u l=0.13u m=1
Mxdn4_xmp bn4 cn4 vrefl vrefl sg13_lv_pmos w=1u l=0.13u m=1
Mxdn4_xmn bn4 cn4 gnd gnd sg13_lv_nmos w=0.5u l=0.13u m=1
Mxdn3_xmp bn3 cn3 vrefl vrefl sg13_lv_pmos w=1u l=0.13u m=1
Mxdn3_xmn bn3 cn3 gnd gnd sg13_lv_nmos w=0.5u l=0.13u m=1
Mxdn2_xmp bn2 cn2 vrefl vrefl sg13_lv_pmos w=1u l=0.13u m=1
Mxdn2_xmn bn2 cn2 gnd gnd sg13_lv_nmos w=0.5u l=0.13u m=1
Mxdn1_xmp bn1 cn1 vrefl vrefl sg13_lv_pmos w=1u l=0.13u m=1
Mxdn1_xmn bn1 cn1 gnd gnd sg13_lv_nmos w=0.5u l=0.13u m=1
Mxdn0_xmp bn0 cn0 vrefl vrefl sg13_lv_pmos w=1u l=0.13u m=1
Mxdn0_xmn bn0 cn0 gnd gnd sg13_lv_nmos w=0.5u l=0.13u m=1
Mxc4_xs1_xmt1 xc4_xs1_tail0 clkb vdd vdd sg13_lv_pmos w=16u l=0.13u m=1
Mxc4_xs1_xmtc xc4_xs1_tail vbp xc4_xs1_tail0 vdd sg13_lv_pmos w=16u l=0.5u m=1
Mxc4_xs1_xm1 xc4_dip top_p xc4_xs1_tail vdd sg13_lv_pmos w=48u l=0.3u m=1
Mxc4_xs1_xm2 xc4_din top_n xc4_xs1_tail vdd sg13_lv_pmos w=48u l=0.3u m=1
Mxc4_xci1 vdd xc4_dip vdd vdd sg13_lv_pmos w=80u l=4u m=1
Mxc4_xci2 vdd xc4_din vdd vdd sg13_lv_pmos w=80u l=4u m=1
Mxc4_xmr1 xc4_dip clkb gnd gnd sg13_lv_nmos w=20u l=0.13u m=1
Mxc4_xmr2 xc4_din clkb gnd gnd sg13_lv_nmos w=20u l=0.13u m=1
Mxc4_xmt2 xc4_lt clk gnd gnd sg13_lv_nmos w=4u l=0.13u m=1
Mxc4_xmn1 op on xc4_lt gnd sg13_lv_nmos w=2u l=0.13u m=1
Mxc4_xmn2 on op xc4_lt gnd sg13_lv_nmos w=2u l=0.13u m=1
Mxc4_xmp1 op on vdd vdd sg13_lv_pmos w=2u l=0.13u m=1
Mxc4_xmp2 on op vdd vdd sg13_lv_pmos w=2u l=0.13u m=1
Mxc4_xmh1 op xc4_dip vdd vdd sg13_lv_pmos w=8u l=0.13u m=1
Mxc4_xmh2 on xc4_din vdd vdd sg13_lv_pmos w=8u l=0.13u m=1
Mxc4_xbp1 xc4_outpb op vdd vdd sg13_lv_pmos w=1u l=0.13u m=1
Mxc4_xbn1 xc4_outpb op gnd gnd sg13_lv_nmos w=0.5u l=0.13u m=1
Mxc4_xbp2 xc4_outnb on vdd vdd sg13_lv_pmos w=1u l=0.13u m=1
Mxc4_xbn2 xc4_outnb on gnd gnd sg13_lv_nmos w=0.5u l=0.13u m=1
Mxc5_xs1_xmt1 xc5_xs1_tail0 clkn gnd gnd sg13_lv_nmos w=8u l=0.13u m=1
Mxc5_xs1_xmtc xc5_xs1_tail vbn xc5_xs1_tail0 gnd sg13_lv_nmos w=4u l=0.5u m=1
Mxc5_xs1_xm1 xc5_dip top_p xc5_xs1_tail gnd sg13_lv_nmos w=16u l=0.5u m=1
Mxc5_xs1_xm2 xc5_din top_n xc5_xs1_tail gnd sg13_lv_nmos w=16u l=0.5u m=1
Mxc5_xci1 gnd xc5_dip gnd gnd sg13_lv_nmos w=30u l=4u m=1
Mxc5_xci2 gnd xc5_din gnd gnd sg13_lv_nmos w=30u l=4u m=1
Mxc5_xmr1 xc5_dip clkn vdd vdd sg13_lv_pmos w=16u l=0.13u m=1
Mxc5_xmr2 xc5_din clkn vdd vdd sg13_lv_pmos w=16u l=0.13u m=1
Mxc5_xmt2 xc5_lt clknb vdd vdd sg13_lv_pmos w=8u l=0.13u m=1
Mxc5_xmp1 onp onn xc5_lt vdd sg13_lv_pmos w=4u l=0.13u m=1
Mxc5_xmp2 onn onp xc5_lt vdd sg13_lv_pmos w=4u l=0.13u m=1
Mxc5_xmn1 onp onn gnd gnd sg13_lv_nmos w=1u l=0.13u m=1
Mxc5_xmn2 onn onp gnd gnd sg13_lv_nmos w=1u l=0.13u m=1
Mxc5_xmh1 onp xc5_dip gnd gnd sg13_lv_nmos w=8u l=0.13u m=1
Mxc5_xmh2 onn xc5_din gnd gnd sg13_lv_nmos w=8u l=0.13u m=1
Mxc5_xbp1 xc5_outpb onp vdd vdd sg13_lv_pmos w=1u l=0.13u m=1
Mxc5_xbn1 xc5_outpb onp gnd gnd sg13_lv_nmos w=0.5u l=0.13u m=1
Mxc5_xbp2 xc5_outnb onn vdd vdd sg13_lv_pmos w=1u l=0.13u m=1
Mxc5_xbn2 xc5_outnb onn gnd gnd sg13_lv_nmos w=0.5u l=0.13u m=1
Cxdacp_xc12_u0 top_p bp12 cap_cmim w=3.78u l=3.78u m=1
Cxdacp_xc12_u1 top_p bp12 cap_cmim w=3.78u l=3.78u m=1
Cxdacp_xc12_u2 top_p bp12 cap_cmim w=3.78u l=3.78u m=1
Cxdacp_xc12_u3 top_p bp12 cap_cmim w=3.78u l=3.78u m=1
Cxdacp_xc12_u4 top_p bp12 cap_cmim w=3.78u l=3.78u m=1
Cxdacp_xc12_u5 top_p bp12 cap_cmim w=3.78u l=3.78u m=1
Cxdacp_xc12_u6 top_p bp12 cap_cmim w=3.78u l=3.78u m=1
Cxdacp_xc12_u7 top_p bp12 cap_cmim w=3.78u l=3.78u m=1
Cxdacp_xc12_u8 top_p bp12 cap_cmim w=3.78u l=3.78u m=1
Cxdacp_xc12_u9 top_p bp12 cap_cmim w=3.78u l=3.78u m=1
Cxdacp_xc12_u10 top_p bp12 cap_cmim w=3.78u l=3.78u m=1
Cxdacp_xc12_u11 top_p bp12 cap_cmim w=3.78u l=3.78u m=1
Cxdacp_xc12_u12 top_p bp12 cap_cmim w=3.78u l=3.78u m=1
Cxdacp_xc12_u13 top_p bp12 cap_cmim w=3.78u l=3.78u m=1
Cxdacp_xc12_u14 top_p bp12 cap_cmim w=3.78u l=3.78u m=1
Cxdacp_xc12_u15 top_p bp12 cap_cmim w=3.78u l=3.78u m=1
Cxdacp_xc11_u0 top_p bp11 cap_cmim w=3.78u l=3.78u m=1
Cxdacp_xc11_u1 top_p bp11 cap_cmim w=3.78u l=3.78u m=1
Cxdacp_xc11_u2 top_p bp11 cap_cmim w=3.78u l=3.78u m=1
Cxdacp_xc11_u3 top_p bp11 cap_cmim w=3.78u l=3.78u m=1
Cxdacp_xc11_u4 top_p bp11 cap_cmim w=3.78u l=3.78u m=1
Cxdacp_xc11_u5 top_p bp11 cap_cmim w=3.78u l=3.78u m=1
Cxdacp_xc11_u6 top_p bp11 cap_cmim w=3.78u l=3.78u m=1
Cxdacp_xc11_u7 top_p bp11 cap_cmim w=3.78u l=3.78u m=1
Cxdacp_xc10_u0 top_p bp10 cap_cmim w=3.78u l=3.78u m=1
Cxdacp_xc10_u1 top_p bp10 cap_cmim w=3.78u l=3.78u m=1
Cxdacp_xc10_u2 top_p bp10 cap_cmim w=3.78u l=3.78u m=1
Cxdacp_xc10_u3 top_p bp10 cap_cmim w=3.78u l=3.78u m=1
Cxdacp_xc9_u0 top_p bp9 cap_cmim w=3.78u l=3.78u m=1
Cxdacp_xc9_u1 top_p bp9 cap_cmim w=3.78u l=3.78u m=1
Cxdacp_xc8_u0 top_p bp8 cap_cmim w=3.78u l=3.78u m=1
Cxdacp_xcb top_p lsb_p cap_cmim w=4.23u l=4.23u m=1
Cxdacp_xc7_u0 lsb_p bp7 cap_cmim w=3.78u l=3.78u m=1
Cxdacp_xc7_u1 lsb_p bp7 cap_cmim w=3.78u l=3.78u m=1
Cxdacp_xc7_u2 lsb_p bp7 cap_cmim w=3.78u l=3.78u m=1
Cxdacp_xc7_u3 lsb_p bp7 cap_cmim w=3.78u l=3.78u m=1
Cxdacp_xc7_u4 lsb_p bp7 cap_cmim w=3.78u l=3.78u m=1
Cxdacp_xc7_u5 lsb_p bp7 cap_cmim w=3.78u l=3.78u m=1
Cxdacp_xc7_u6 lsb_p bp7 cap_cmim w=3.78u l=3.78u m=1
Cxdacp_xc7_u7 lsb_p bp7 cap_cmim w=3.78u l=3.78u m=1
Cxdacp_xc7_u8 lsb_p bp7 cap_cmim w=3.78u l=3.78u m=1
Cxdacp_xc7_u9 lsb_p bp7 cap_cmim w=3.78u l=3.78u m=1
Cxdacp_xc7_u10 lsb_p bp7 cap_cmim w=3.78u l=3.78u m=1
Cxdacp_xc7_u11 lsb_p bp7 cap_cmim w=3.78u l=3.78u m=1
Cxdacp_xc7_u12 lsb_p bp7 cap_cmim w=3.78u l=3.78u m=1
Cxdacp_xc7_u13 lsb_p bp7 cap_cmim w=3.78u l=3.78u m=1
Cxdacp_xc7_u14 lsb_p bp7 cap_cmim w=3.78u l=3.78u m=1
Cxdacp_xc7_u15 lsb_p bp7 cap_cmim w=3.78u l=3.78u m=1
Cxdacp_xc7_u16 lsb_p bp7 cap_cmim w=3.78u l=3.78u m=1
Cxdacp_xc7_u17 lsb_p bp7 cap_cmim w=3.78u l=3.78u m=1
Cxdacp_xc7_u18 lsb_p bp7 cap_cmim w=3.78u l=3.78u m=1
Cxdacp_xc7_u19 lsb_p bp7 cap_cmim w=3.78u l=3.78u m=1
Cxdacp_xc7_u20 lsb_p bp7 cap_cmim w=3.78u l=3.78u m=1
Cxdacp_xc7_u21 lsb_p bp7 cap_cmim w=3.78u l=3.78u m=1
Cxdacp_xc7_u22 lsb_p bp7 cap_cmim w=3.78u l=3.78u m=1
Cxdacp_xc7_u23 lsb_p bp7 cap_cmim w=3.78u l=3.78u m=1
Cxdacp_xc7_u24 lsb_p bp7 cap_cmim w=3.78u l=3.78u m=1
Cxdacp_xc7_u25 lsb_p bp7 cap_cmim w=3.78u l=3.78u m=1
Cxdacp_xc7_u26 lsb_p bp7 cap_cmim w=3.78u l=3.78u m=1
Cxdacp_xc7_u27 lsb_p bp7 cap_cmim w=3.78u l=3.78u m=1
Cxdacp_xc7_u28 lsb_p bp7 cap_cmim w=3.78u l=3.78u m=1
Cxdacp_xc7_u29 lsb_p bp7 cap_cmim w=3.78u l=3.78u m=1
Cxdacp_xc7_u30 lsb_p bp7 cap_cmim w=3.78u l=3.78u m=1
Cxdacp_xc7_u31 lsb_p bp7 cap_cmim w=3.78u l=3.78u m=1
Cxdacp_xc7_u32 lsb_p bp7 cap_cmim w=3.78u l=3.78u m=1
Cxdacp_xc7_u33 lsb_p bp7 cap_cmim w=3.78u l=3.78u m=1
Cxdacp_xc7_u34 lsb_p bp7 cap_cmim w=3.78u l=3.78u m=1
Cxdacp_xc7_u35 lsb_p bp7 cap_cmim w=3.78u l=3.78u m=1
Cxdacp_xc7_u36 lsb_p bp7 cap_cmim w=3.78u l=3.78u m=1
Cxdacp_xc7_u37 lsb_p bp7 cap_cmim w=3.78u l=3.78u m=1
Cxdacp_xc7_u38 lsb_p bp7 cap_cmim w=3.78u l=3.78u m=1
Cxdacp_xc7_u39 lsb_p bp7 cap_cmim w=3.78u l=3.78u m=1
Cxdacp_xc7_u40 lsb_p bp7 cap_cmim w=3.78u l=3.78u m=1
Cxdacp_xc7_u41 lsb_p bp7 cap_cmim w=3.78u l=3.78u m=1
Cxdacp_xc7_u42 lsb_p bp7 cap_cmim w=3.78u l=3.78u m=1
Cxdacp_xc7_u43 lsb_p bp7 cap_cmim w=3.78u l=3.78u m=1
Cxdacp_xc7_u44 lsb_p bp7 cap_cmim w=3.78u l=3.78u m=1
Cxdacp_xc7_u45 lsb_p bp7 cap_cmim w=3.78u l=3.78u m=1
Cxdacp_xc7_u46 lsb_p bp7 cap_cmim w=3.78u l=3.78u m=1
Cxdacp_xc7_u47 lsb_p bp7 cap_cmim w=3.78u l=3.78u m=1
Cxdacp_xc7_u48 lsb_p bp7 cap_cmim w=3.78u l=3.78u m=1
Cxdacp_xc7_u49 lsb_p bp7 cap_cmim w=3.78u l=3.78u m=1
Cxdacp_xc7_u50 lsb_p bp7 cap_cmim w=3.78u l=3.78u m=1
Cxdacp_xc7_u51 lsb_p bp7 cap_cmim w=3.78u l=3.78u m=1
Cxdacp_xc7_u52 lsb_p bp7 cap_cmim w=3.78u l=3.78u m=1
Cxdacp_xc7_u53 lsb_p bp7 cap_cmim w=3.78u l=3.78u m=1
Cxdacp_xc7_u54 lsb_p bp7 cap_cmim w=3.78u l=3.78u m=1
Cxdacp_xc7_u55 lsb_p bp7 cap_cmim w=3.78u l=3.78u m=1
Cxdacp_xc7_u56 lsb_p bp7 cap_cmim w=3.78u l=3.78u m=1
Cxdacp_xc7_u57 lsb_p bp7 cap_cmim w=3.78u l=3.78u m=1
Cxdacp_xc7_u58 lsb_p bp7 cap_cmim w=3.78u l=3.78u m=1
Cxdacp_xc7_u59 lsb_p bp7 cap_cmim w=3.78u l=3.78u m=1
Cxdacp_xc7_u60 lsb_p bp7 cap_cmim w=3.78u l=3.78u m=1
Cxdacp_xc7_u61 lsb_p bp7 cap_cmim w=3.78u l=3.78u m=1
Cxdacp_xc7_u62 lsb_p bp7 cap_cmim w=3.78u l=3.78u m=1
Cxdacp_xc7_u63 lsb_p bp7 cap_cmim w=3.78u l=3.78u m=1
Cxdacp_xc6_u0 lsb_p bp6 cap_cmim w=3.78u l=3.78u m=1
Cxdacp_xc6_u1 lsb_p bp6 cap_cmim w=3.78u l=3.78u m=1
Cxdacp_xc6_u2 lsb_p bp6 cap_cmim w=3.78u l=3.78u m=1
Cxdacp_xc6_u3 lsb_p bp6 cap_cmim w=3.78u l=3.78u m=1
Cxdacp_xc6_u4 lsb_p bp6 cap_cmim w=3.78u l=3.78u m=1
Cxdacp_xc6_u5 lsb_p bp6 cap_cmim w=3.78u l=3.78u m=1
Cxdacp_xc6_u6 lsb_p bp6 cap_cmim w=3.78u l=3.78u m=1
Cxdacp_xc6_u7 lsb_p bp6 cap_cmim w=3.78u l=3.78u m=1
Cxdacp_xc6_u8 lsb_p bp6 cap_cmim w=3.78u l=3.78u m=1
Cxdacp_xc6_u9 lsb_p bp6 cap_cmim w=3.78u l=3.78u m=1
Cxdacp_xc6_u10 lsb_p bp6 cap_cmim w=3.78u l=3.78u m=1
Cxdacp_xc6_u11 lsb_p bp6 cap_cmim w=3.78u l=3.78u m=1
Cxdacp_xc6_u12 lsb_p bp6 cap_cmim w=3.78u l=3.78u m=1
Cxdacp_xc6_u13 lsb_p bp6 cap_cmim w=3.78u l=3.78u m=1
Cxdacp_xc6_u14 lsb_p bp6 cap_cmim w=3.78u l=3.78u m=1
Cxdacp_xc6_u15 lsb_p bp6 cap_cmim w=3.78u l=3.78u m=1
Cxdacp_xc6_u16 lsb_p bp6 cap_cmim w=3.78u l=3.78u m=1
Cxdacp_xc6_u17 lsb_p bp6 cap_cmim w=3.78u l=3.78u m=1
Cxdacp_xc6_u18 lsb_p bp6 cap_cmim w=3.78u l=3.78u m=1
Cxdacp_xc6_u19 lsb_p bp6 cap_cmim w=3.78u l=3.78u m=1
Cxdacp_xc6_u20 lsb_p bp6 cap_cmim w=3.78u l=3.78u m=1
Cxdacp_xc6_u21 lsb_p bp6 cap_cmim w=3.78u l=3.78u m=1
Cxdacp_xc6_u22 lsb_p bp6 cap_cmim w=3.78u l=3.78u m=1
Cxdacp_xc6_u23 lsb_p bp6 cap_cmim w=3.78u l=3.78u m=1
Cxdacp_xc6_u24 lsb_p bp6 cap_cmim w=3.78u l=3.78u m=1
Cxdacp_xc6_u25 lsb_p bp6 cap_cmim w=3.78u l=3.78u m=1
Cxdacp_xc6_u26 lsb_p bp6 cap_cmim w=3.78u l=3.78u m=1
Cxdacp_xc6_u27 lsb_p bp6 cap_cmim w=3.78u l=3.78u m=1
Cxdacp_xc6_u28 lsb_p bp6 cap_cmim w=3.78u l=3.78u m=1
Cxdacp_xc6_u29 lsb_p bp6 cap_cmim w=3.78u l=3.78u m=1
Cxdacp_xc6_u30 lsb_p bp6 cap_cmim w=3.78u l=3.78u m=1
Cxdacp_xc6_u31 lsb_p bp6 cap_cmim w=3.78u l=3.78u m=1
Cxdacp_xc5_u0 lsb_p bp5 cap_cmim w=3.78u l=3.78u m=1
Cxdacp_xc5_u1 lsb_p bp5 cap_cmim w=3.78u l=3.78u m=1
Cxdacp_xc5_u2 lsb_p bp5 cap_cmim w=3.78u l=3.78u m=1
Cxdacp_xc5_u3 lsb_p bp5 cap_cmim w=3.78u l=3.78u m=1
Cxdacp_xc5_u4 lsb_p bp5 cap_cmim w=3.78u l=3.78u m=1
Cxdacp_xc5_u5 lsb_p bp5 cap_cmim w=3.78u l=3.78u m=1
Cxdacp_xc5_u6 lsb_p bp5 cap_cmim w=3.78u l=3.78u m=1
Cxdacp_xc5_u7 lsb_p bp5 cap_cmim w=3.78u l=3.78u m=1
Cxdacp_xc5_u8 lsb_p bp5 cap_cmim w=3.78u l=3.78u m=1
Cxdacp_xc5_u9 lsb_p bp5 cap_cmim w=3.78u l=3.78u m=1
Cxdacp_xc5_u10 lsb_p bp5 cap_cmim w=3.78u l=3.78u m=1
Cxdacp_xc5_u11 lsb_p bp5 cap_cmim w=3.78u l=3.78u m=1
Cxdacp_xc5_u12 lsb_p bp5 cap_cmim w=3.78u l=3.78u m=1
Cxdacp_xc5_u13 lsb_p bp5 cap_cmim w=3.78u l=3.78u m=1
Cxdacp_xc5_u14 lsb_p bp5 cap_cmim w=3.78u l=3.78u m=1
Cxdacp_xc5_u15 lsb_p bp5 cap_cmim w=3.78u l=3.78u m=1
Cxdacp_xc4_u0 lsb_p bp4 cap_cmim w=3.78u l=3.78u m=1
Cxdacp_xc4_u1 lsb_p bp4 cap_cmim w=3.78u l=3.78u m=1
Cxdacp_xc4_u2 lsb_p bp4 cap_cmim w=3.78u l=3.78u m=1
Cxdacp_xc4_u3 lsb_p bp4 cap_cmim w=3.78u l=3.78u m=1
Cxdacp_xc4_u4 lsb_p bp4 cap_cmim w=3.78u l=3.78u m=1
Cxdacp_xc4_u5 lsb_p bp4 cap_cmim w=3.78u l=3.78u m=1
Cxdacp_xc4_u6 lsb_p bp4 cap_cmim w=3.78u l=3.78u m=1
Cxdacp_xc4_u7 lsb_p bp4 cap_cmim w=3.78u l=3.78u m=1
Cxdacp_xc3_u0 lsb_p bp3 cap_cmim w=3.78u l=3.78u m=1
Cxdacp_xc3_u1 lsb_p bp3 cap_cmim w=3.78u l=3.78u m=1
Cxdacp_xc3_u2 lsb_p bp3 cap_cmim w=3.78u l=3.78u m=1
Cxdacp_xc3_u3 lsb_p bp3 cap_cmim w=3.78u l=3.78u m=1
Cxdacp_xc2_u0 lsb_p bp2 cap_cmim w=3.78u l=3.78u m=1
Cxdacp_xc2_u1 lsb_p bp2 cap_cmim w=3.78u l=3.78u m=1
Cxdacp_xc1_u0 lsb_p bp1 cap_cmim w=3.78u l=3.78u m=1
Cxdacp_xc0 lsb_p bp0 cap_cmim w=2.67u l=2.67u m=1
Cxdacn_xc12_u0 top_n bn12 cap_cmim w=3.78u l=3.78u m=1
Cxdacn_xc12_u1 top_n bn12 cap_cmim w=3.78u l=3.78u m=1
Cxdacn_xc12_u2 top_n bn12 cap_cmim w=3.78u l=3.78u m=1
Cxdacn_xc12_u3 top_n bn12 cap_cmim w=3.78u l=3.78u m=1
Cxdacn_xc12_u4 top_n bn12 cap_cmim w=3.78u l=3.78u m=1
Cxdacn_xc12_u5 top_n bn12 cap_cmim w=3.78u l=3.78u m=1
Cxdacn_xc12_u6 top_n bn12 cap_cmim w=3.78u l=3.78u m=1
Cxdacn_xc12_u7 top_n bn12 cap_cmim w=3.78u l=3.78u m=1
Cxdacn_xc12_u8 top_n bn12 cap_cmim w=3.78u l=3.78u m=1
Cxdacn_xc12_u9 top_n bn12 cap_cmim w=3.78u l=3.78u m=1
Cxdacn_xc12_u10 top_n bn12 cap_cmim w=3.78u l=3.78u m=1
Cxdacn_xc12_u11 top_n bn12 cap_cmim w=3.78u l=3.78u m=1
Cxdacn_xc12_u12 top_n bn12 cap_cmim w=3.78u l=3.78u m=1
Cxdacn_xc12_u13 top_n bn12 cap_cmim w=3.78u l=3.78u m=1
Cxdacn_xc12_u14 top_n bn12 cap_cmim w=3.78u l=3.78u m=1
Cxdacn_xc12_u15 top_n bn12 cap_cmim w=3.78u l=3.78u m=1
Cxdacn_xc11_u0 top_n bn11 cap_cmim w=3.78u l=3.78u m=1
Cxdacn_xc11_u1 top_n bn11 cap_cmim w=3.78u l=3.78u m=1
Cxdacn_xc11_u2 top_n bn11 cap_cmim w=3.78u l=3.78u m=1
Cxdacn_xc11_u3 top_n bn11 cap_cmim w=3.78u l=3.78u m=1
Cxdacn_xc11_u4 top_n bn11 cap_cmim w=3.78u l=3.78u m=1
Cxdacn_xc11_u5 top_n bn11 cap_cmim w=3.78u l=3.78u m=1
Cxdacn_xc11_u6 top_n bn11 cap_cmim w=3.78u l=3.78u m=1
Cxdacn_xc11_u7 top_n bn11 cap_cmim w=3.78u l=3.78u m=1
Cxdacn_xc10_u0 top_n bn10 cap_cmim w=3.78u l=3.78u m=1
Cxdacn_xc10_u1 top_n bn10 cap_cmim w=3.78u l=3.78u m=1
Cxdacn_xc10_u2 top_n bn10 cap_cmim w=3.78u l=3.78u m=1
Cxdacn_xc10_u3 top_n bn10 cap_cmim w=3.78u l=3.78u m=1
Cxdacn_xc9_u0 top_n bn9 cap_cmim w=3.78u l=3.78u m=1
Cxdacn_xc9_u1 top_n bn9 cap_cmim w=3.78u l=3.78u m=1
Cxdacn_xc8_u0 top_n bn8 cap_cmim w=3.78u l=3.78u m=1
Cxdacn_xcb top_n lsb_n cap_cmim w=4.23u l=4.23u m=1
Cxdacn_xc7_u0 lsb_n bn7 cap_cmim w=3.78u l=3.78u m=1
Cxdacn_xc7_u1 lsb_n bn7 cap_cmim w=3.78u l=3.78u m=1
Cxdacn_xc7_u2 lsb_n bn7 cap_cmim w=3.78u l=3.78u m=1
Cxdacn_xc7_u3 lsb_n bn7 cap_cmim w=3.78u l=3.78u m=1
Cxdacn_xc7_u4 lsb_n bn7 cap_cmim w=3.78u l=3.78u m=1
Cxdacn_xc7_u5 lsb_n bn7 cap_cmim w=3.78u l=3.78u m=1
Cxdacn_xc7_u6 lsb_n bn7 cap_cmim w=3.78u l=3.78u m=1
Cxdacn_xc7_u7 lsb_n bn7 cap_cmim w=3.78u l=3.78u m=1
Cxdacn_xc7_u8 lsb_n bn7 cap_cmim w=3.78u l=3.78u m=1
Cxdacn_xc7_u9 lsb_n bn7 cap_cmim w=3.78u l=3.78u m=1
Cxdacn_xc7_u10 lsb_n bn7 cap_cmim w=3.78u l=3.78u m=1
Cxdacn_xc7_u11 lsb_n bn7 cap_cmim w=3.78u l=3.78u m=1
Cxdacn_xc7_u12 lsb_n bn7 cap_cmim w=3.78u l=3.78u m=1
Cxdacn_xc7_u13 lsb_n bn7 cap_cmim w=3.78u l=3.78u m=1
Cxdacn_xc7_u14 lsb_n bn7 cap_cmim w=3.78u l=3.78u m=1
Cxdacn_xc7_u15 lsb_n bn7 cap_cmim w=3.78u l=3.78u m=1
Cxdacn_xc7_u16 lsb_n bn7 cap_cmim w=3.78u l=3.78u m=1
Cxdacn_xc7_u17 lsb_n bn7 cap_cmim w=3.78u l=3.78u m=1
Cxdacn_xc7_u18 lsb_n bn7 cap_cmim w=3.78u l=3.78u m=1
Cxdacn_xc7_u19 lsb_n bn7 cap_cmim w=3.78u l=3.78u m=1
Cxdacn_xc7_u20 lsb_n bn7 cap_cmim w=3.78u l=3.78u m=1
Cxdacn_xc7_u21 lsb_n bn7 cap_cmim w=3.78u l=3.78u m=1
Cxdacn_xc7_u22 lsb_n bn7 cap_cmim w=3.78u l=3.78u m=1
Cxdacn_xc7_u23 lsb_n bn7 cap_cmim w=3.78u l=3.78u m=1
Cxdacn_xc7_u24 lsb_n bn7 cap_cmim w=3.78u l=3.78u m=1
Cxdacn_xc7_u25 lsb_n bn7 cap_cmim w=3.78u l=3.78u m=1
Cxdacn_xc7_u26 lsb_n bn7 cap_cmim w=3.78u l=3.78u m=1
Cxdacn_xc7_u27 lsb_n bn7 cap_cmim w=3.78u l=3.78u m=1
Cxdacn_xc7_u28 lsb_n bn7 cap_cmim w=3.78u l=3.78u m=1
Cxdacn_xc7_u29 lsb_n bn7 cap_cmim w=3.78u l=3.78u m=1
Cxdacn_xc7_u30 lsb_n bn7 cap_cmim w=3.78u l=3.78u m=1
Cxdacn_xc7_u31 lsb_n bn7 cap_cmim w=3.78u l=3.78u m=1
Cxdacn_xc7_u32 lsb_n bn7 cap_cmim w=3.78u l=3.78u m=1
Cxdacn_xc7_u33 lsb_n bn7 cap_cmim w=3.78u l=3.78u m=1
Cxdacn_xc7_u34 lsb_n bn7 cap_cmim w=3.78u l=3.78u m=1
Cxdacn_xc7_u35 lsb_n bn7 cap_cmim w=3.78u l=3.78u m=1
Cxdacn_xc7_u36 lsb_n bn7 cap_cmim w=3.78u l=3.78u m=1
Cxdacn_xc7_u37 lsb_n bn7 cap_cmim w=3.78u l=3.78u m=1
Cxdacn_xc7_u38 lsb_n bn7 cap_cmim w=3.78u l=3.78u m=1
Cxdacn_xc7_u39 lsb_n bn7 cap_cmim w=3.78u l=3.78u m=1
Cxdacn_xc7_u40 lsb_n bn7 cap_cmim w=3.78u l=3.78u m=1
Cxdacn_xc7_u41 lsb_n bn7 cap_cmim w=3.78u l=3.78u m=1
Cxdacn_xc7_u42 lsb_n bn7 cap_cmim w=3.78u l=3.78u m=1
Cxdacn_xc7_u43 lsb_n bn7 cap_cmim w=3.78u l=3.78u m=1
Cxdacn_xc7_u44 lsb_n bn7 cap_cmim w=3.78u l=3.78u m=1
Cxdacn_xc7_u45 lsb_n bn7 cap_cmim w=3.78u l=3.78u m=1
Cxdacn_xc7_u46 lsb_n bn7 cap_cmim w=3.78u l=3.78u m=1
Cxdacn_xc7_u47 lsb_n bn7 cap_cmim w=3.78u l=3.78u m=1
Cxdacn_xc7_u48 lsb_n bn7 cap_cmim w=3.78u l=3.78u m=1
Cxdacn_xc7_u49 lsb_n bn7 cap_cmim w=3.78u l=3.78u m=1
Cxdacn_xc7_u50 lsb_n bn7 cap_cmim w=3.78u l=3.78u m=1
Cxdacn_xc7_u51 lsb_n bn7 cap_cmim w=3.78u l=3.78u m=1
Cxdacn_xc7_u52 lsb_n bn7 cap_cmim w=3.78u l=3.78u m=1
Cxdacn_xc7_u53 lsb_n bn7 cap_cmim w=3.78u l=3.78u m=1
Cxdacn_xc7_u54 lsb_n bn7 cap_cmim w=3.78u l=3.78u m=1
Cxdacn_xc7_u55 lsb_n bn7 cap_cmim w=3.78u l=3.78u m=1
Cxdacn_xc7_u56 lsb_n bn7 cap_cmim w=3.78u l=3.78u m=1
Cxdacn_xc7_u57 lsb_n bn7 cap_cmim w=3.78u l=3.78u m=1
Cxdacn_xc7_u58 lsb_n bn7 cap_cmim w=3.78u l=3.78u m=1
Cxdacn_xc7_u59 lsb_n bn7 cap_cmim w=3.78u l=3.78u m=1
Cxdacn_xc7_u60 lsb_n bn7 cap_cmim w=3.78u l=3.78u m=1
Cxdacn_xc7_u61 lsb_n bn7 cap_cmim w=3.78u l=3.78u m=1
Cxdacn_xc7_u62 lsb_n bn7 cap_cmim w=3.78u l=3.78u m=1
Cxdacn_xc7_u63 lsb_n bn7 cap_cmim w=3.78u l=3.78u m=1
Cxdacn_xc6_u0 lsb_n bn6 cap_cmim w=3.78u l=3.78u m=1
Cxdacn_xc6_u1 lsb_n bn6 cap_cmim w=3.78u l=3.78u m=1
Cxdacn_xc6_u2 lsb_n bn6 cap_cmim w=3.78u l=3.78u m=1
Cxdacn_xc6_u3 lsb_n bn6 cap_cmim w=3.78u l=3.78u m=1
Cxdacn_xc6_u4 lsb_n bn6 cap_cmim w=3.78u l=3.78u m=1
Cxdacn_xc6_u5 lsb_n bn6 cap_cmim w=3.78u l=3.78u m=1
Cxdacn_xc6_u6 lsb_n bn6 cap_cmim w=3.78u l=3.78u m=1
Cxdacn_xc6_u7 lsb_n bn6 cap_cmim w=3.78u l=3.78u m=1
Cxdacn_xc6_u8 lsb_n bn6 cap_cmim w=3.78u l=3.78u m=1
Cxdacn_xc6_u9 lsb_n bn6 cap_cmim w=3.78u l=3.78u m=1
Cxdacn_xc6_u10 lsb_n bn6 cap_cmim w=3.78u l=3.78u m=1
Cxdacn_xc6_u11 lsb_n bn6 cap_cmim w=3.78u l=3.78u m=1
Cxdacn_xc6_u12 lsb_n bn6 cap_cmim w=3.78u l=3.78u m=1
Cxdacn_xc6_u13 lsb_n bn6 cap_cmim w=3.78u l=3.78u m=1
Cxdacn_xc6_u14 lsb_n bn6 cap_cmim w=3.78u l=3.78u m=1
Cxdacn_xc6_u15 lsb_n bn6 cap_cmim w=3.78u l=3.78u m=1
Cxdacn_xc6_u16 lsb_n bn6 cap_cmim w=3.78u l=3.78u m=1
Cxdacn_xc6_u17 lsb_n bn6 cap_cmim w=3.78u l=3.78u m=1
Cxdacn_xc6_u18 lsb_n bn6 cap_cmim w=3.78u l=3.78u m=1
Cxdacn_xc6_u19 lsb_n bn6 cap_cmim w=3.78u l=3.78u m=1
Cxdacn_xc6_u20 lsb_n bn6 cap_cmim w=3.78u l=3.78u m=1
Cxdacn_xc6_u21 lsb_n bn6 cap_cmim w=3.78u l=3.78u m=1
Cxdacn_xc6_u22 lsb_n bn6 cap_cmim w=3.78u l=3.78u m=1
Cxdacn_xc6_u23 lsb_n bn6 cap_cmim w=3.78u l=3.78u m=1
Cxdacn_xc6_u24 lsb_n bn6 cap_cmim w=3.78u l=3.78u m=1
Cxdacn_xc6_u25 lsb_n bn6 cap_cmim w=3.78u l=3.78u m=1
Cxdacn_xc6_u26 lsb_n bn6 cap_cmim w=3.78u l=3.78u m=1
Cxdacn_xc6_u27 lsb_n bn6 cap_cmim w=3.78u l=3.78u m=1
Cxdacn_xc6_u28 lsb_n bn6 cap_cmim w=3.78u l=3.78u m=1
Cxdacn_xc6_u29 lsb_n bn6 cap_cmim w=3.78u l=3.78u m=1
Cxdacn_xc6_u30 lsb_n bn6 cap_cmim w=3.78u l=3.78u m=1
Cxdacn_xc6_u31 lsb_n bn6 cap_cmim w=3.78u l=3.78u m=1
Cxdacn_xc5_u0 lsb_n bn5 cap_cmim w=3.78u l=3.78u m=1
Cxdacn_xc5_u1 lsb_n bn5 cap_cmim w=3.78u l=3.78u m=1
Cxdacn_xc5_u2 lsb_n bn5 cap_cmim w=3.78u l=3.78u m=1
Cxdacn_xc5_u3 lsb_n bn5 cap_cmim w=3.78u l=3.78u m=1
Cxdacn_xc5_u4 lsb_n bn5 cap_cmim w=3.78u l=3.78u m=1
Cxdacn_xc5_u5 lsb_n bn5 cap_cmim w=3.78u l=3.78u m=1
Cxdacn_xc5_u6 lsb_n bn5 cap_cmim w=3.78u l=3.78u m=1
Cxdacn_xc5_u7 lsb_n bn5 cap_cmim w=3.78u l=3.78u m=1
Cxdacn_xc5_u8 lsb_n bn5 cap_cmim w=3.78u l=3.78u m=1
Cxdacn_xc5_u9 lsb_n bn5 cap_cmim w=3.78u l=3.78u m=1
Cxdacn_xc5_u10 lsb_n bn5 cap_cmim w=3.78u l=3.78u m=1
Cxdacn_xc5_u11 lsb_n bn5 cap_cmim w=3.78u l=3.78u m=1
Cxdacn_xc5_u12 lsb_n bn5 cap_cmim w=3.78u l=3.78u m=1
Cxdacn_xc5_u13 lsb_n bn5 cap_cmim w=3.78u l=3.78u m=1
Cxdacn_xc5_u14 lsb_n bn5 cap_cmim w=3.78u l=3.78u m=1
Cxdacn_xc5_u15 lsb_n bn5 cap_cmim w=3.78u l=3.78u m=1
Cxdacn_xc4_u0 lsb_n bn4 cap_cmim w=3.78u l=3.78u m=1
Cxdacn_xc4_u1 lsb_n bn4 cap_cmim w=3.78u l=3.78u m=1
Cxdacn_xc4_u2 lsb_n bn4 cap_cmim w=3.78u l=3.78u m=1
Cxdacn_xc4_u3 lsb_n bn4 cap_cmim w=3.78u l=3.78u m=1
Cxdacn_xc4_u4 lsb_n bn4 cap_cmim w=3.78u l=3.78u m=1
Cxdacn_xc4_u5 lsb_n bn4 cap_cmim w=3.78u l=3.78u m=1
Cxdacn_xc4_u6 lsb_n bn4 cap_cmim w=3.78u l=3.78u m=1
Cxdacn_xc4_u7 lsb_n bn4 cap_cmim w=3.78u l=3.78u m=1
Cxdacn_xc3_u0 lsb_n bn3 cap_cmim w=3.78u l=3.78u m=1
Cxdacn_xc3_u1 lsb_n bn3 cap_cmim w=3.78u l=3.78u m=1
Cxdacn_xc3_u2 lsb_n bn3 cap_cmim w=3.78u l=3.78u m=1
Cxdacn_xc3_u3 lsb_n bn3 cap_cmim w=3.78u l=3.78u m=1
Cxdacn_xc2_u0 lsb_n bn2 cap_cmim w=3.78u l=3.78u m=1
Cxdacn_xc2_u1 lsb_n bn2 cap_cmim w=3.78u l=3.78u m=1
Cxdacn_xc1_u0 lsb_n bn1 cap_cmim w=3.78u l=3.78u m=1
Cxdacn_xc0 lsb_n bn0 cap_cmim w=2.67u l=2.67u m=1
Cxdmy_u0 gnd gnd cap_cmim w=3.78u l=3.78u m=1
Cxdmy_u1 gnd gnd cap_cmim w=3.78u l=3.78u m=1
Cxdmy_u2 gnd gnd cap_cmim w=3.78u l=3.78u m=1
Cxdmy_u3 gnd gnd cap_cmim w=3.78u l=3.78u m=1
Cxdmy_u4 gnd gnd cap_cmim w=3.78u l=3.78u m=1
Cxdmy_u5 gnd gnd cap_cmim w=3.78u l=3.78u m=1
Cxdmy_u6 gnd gnd cap_cmim w=3.78u l=3.78u m=1
Cxdmy_u7 gnd gnd cap_cmim w=3.78u l=3.78u m=1
Cxdmy_u8 gnd gnd cap_cmim w=3.78u l=3.78u m=1
Cxdmy_u9 gnd gnd cap_cmim w=3.78u l=3.78u m=1
Cxdmy_u10 gnd gnd cap_cmim w=3.78u l=3.78u m=1
Cxdmy_u11 gnd gnd cap_cmim w=3.78u l=3.78u m=1
Cxdmy_u12 gnd gnd cap_cmim w=3.78u l=3.78u m=1
Cxdmy_u13 gnd gnd cap_cmim w=3.78u l=3.78u m=1
Cxdmy_u14 gnd gnd cap_cmim w=3.78u l=3.78u m=1
Cxdmy_u15 gnd gnd cap_cmim w=3.78u l=3.78u m=1
Cxdmy_u16 gnd gnd cap_cmim w=3.78u l=3.78u m=1
Cxdmy_u17 gnd gnd cap_cmim w=3.78u l=3.78u m=1
Cxdmy_u18 gnd gnd cap_cmim w=3.78u l=3.78u m=1
Cxdmy_u19 gnd gnd cap_cmim w=3.78u l=3.78u m=1
Cxdmy_u20 gnd gnd cap_cmim w=3.78u l=3.78u m=1
Cxdmy_u21 gnd gnd cap_cmim w=3.78u l=3.78u m=1
Cxdmy_u22 gnd gnd cap_cmim w=3.78u l=3.78u m=1
Cxdmy_u23 gnd gnd cap_cmim w=3.78u l=3.78u m=1
Cxdmy_u24 gnd gnd cap_cmim w=3.78u l=3.78u m=1
Cxdmy_u25 gnd gnd cap_cmim w=3.78u l=3.78u m=1
Cxdmy_u26 gnd gnd cap_cmim w=3.78u l=3.78u m=1
Cxdmy_u27 gnd gnd cap_cmim w=3.78u l=3.78u m=1
Cxdmy_u28 gnd gnd cap_cmim w=3.78u l=3.78u m=1
Cxdmy_u29 gnd gnd cap_cmim w=3.78u l=3.78u m=1
Cxdmy_u30 gnd gnd cap_cmim w=3.78u l=3.78u m=1
Cxdmy_u31 gnd gnd cap_cmim w=3.78u l=3.78u m=1
Cxdmy_u32 gnd gnd cap_cmim w=3.78u l=3.78u m=1
Cxdmy_u33 gnd gnd cap_cmim w=3.78u l=3.78u m=1
Cxdmy_u34 gnd gnd cap_cmim w=3.78u l=3.78u m=1
Cxdmy_u35 gnd gnd cap_cmim w=3.78u l=3.78u m=1
Cxdmy_u36 gnd gnd cap_cmim w=3.78u l=3.78u m=1
Cxdmy_u37 gnd gnd cap_cmim w=3.78u l=3.78u m=1
Cxdmy_u38 gnd gnd cap_cmim w=3.78u l=3.78u m=1
Cxdmy_u39 gnd gnd cap_cmim w=3.78u l=3.78u m=1
Cxdmy_u40 gnd gnd cap_cmim w=3.78u l=3.78u m=1
Cxdmy_u41 gnd gnd cap_cmim w=3.78u l=3.78u m=1
Cxdmy_u42 gnd gnd cap_cmim w=3.78u l=3.78u m=1
Cxdmy_u43 gnd gnd cap_cmim w=3.78u l=3.78u m=1
Cxdmy_u44 gnd gnd cap_cmim w=3.78u l=3.78u m=1
Cxdmy_u45 gnd gnd cap_cmim w=3.78u l=3.78u m=1
Cxdmy_u46 gnd gnd cap_cmim w=3.78u l=3.78u m=1
Cxdmy_u47 gnd gnd cap_cmim w=3.78u l=3.78u m=1
Cxdmy_u48 gnd gnd cap_cmim w=3.78u l=3.78u m=1
Cxdmy_u49 gnd gnd cap_cmim w=3.78u l=3.78u m=1
Cxdmy_u50 gnd gnd cap_cmim w=3.78u l=3.78u m=1
Cxdmy_u51 gnd gnd cap_cmim w=3.78u l=3.78u m=1
Cxdmy_u52 gnd gnd cap_cmim w=3.78u l=3.78u m=1
Cxdmy_u53 gnd gnd cap_cmim w=3.78u l=3.78u m=1
Cxdmy_u54 gnd gnd cap_cmim w=3.78u l=3.78u m=1
Cxdmy_u55 gnd gnd cap_cmim w=3.78u l=3.78u m=1
Cxdmy_u56 gnd gnd cap_cmim w=3.78u l=3.78u m=1
Cxdmy_u57 gnd gnd cap_cmim w=3.78u l=3.78u m=1
Cxdmy_u58 gnd gnd cap_cmim w=3.78u l=3.78u m=1
Cxdmy_u59 gnd gnd cap_cmim w=3.78u l=3.78u m=1
Cxdmy_u60 gnd gnd cap_cmim w=3.78u l=3.78u m=1
Cxdmy_u61 gnd gnd cap_cmim w=3.78u l=3.78u m=1
Cxdmy_u62 gnd gnd cap_cmim w=3.78u l=3.78u m=1
Cxdmy_u63 gnd gnd cap_cmim w=3.78u l=3.78u m=1
Cxdmy_u64 gnd gnd cap_cmim w=3.78u l=3.78u m=1
Cxdmy_u65 gnd gnd cap_cmim w=3.78u l=3.78u m=1
Cxdmy_u66 gnd gnd cap_cmim w=3.78u l=3.78u m=1
Cxdmy_u67 gnd gnd cap_cmim w=3.78u l=3.78u m=1
Cxdmy_u68 gnd gnd cap_cmim w=3.78u l=3.78u m=1
Cxdmy_u69 gnd gnd cap_cmim w=3.78u l=3.78u m=1
Cxdmy_u70 gnd gnd cap_cmim w=3.78u l=3.78u m=1
Cxdmy_u71 gnd gnd cap_cmim w=3.78u l=3.78u m=1
Cxdmy_u72 gnd gnd cap_cmim w=3.78u l=3.78u m=1
Cxdmy_u73 gnd gnd cap_cmim w=3.78u l=3.78u m=1
Cxdmy_u74 gnd gnd cap_cmim w=3.78u l=3.78u m=1
Cxdmy_u75 gnd gnd cap_cmim w=3.78u l=3.78u m=1
Cxdmy_u76 gnd gnd cap_cmim w=3.78u l=3.78u m=1
Cxdmy_u77 gnd gnd cap_cmim w=3.78u l=3.78u m=1
Cxdmy_u78 gnd gnd cap_cmim w=3.78u l=3.78u m=1
Cxdmy_u79 gnd gnd cap_cmim w=3.78u l=3.78u m=1
Cxdmy_u80 gnd gnd cap_cmim w=3.78u l=3.78u m=1
Cxdmy_u81 gnd gnd cap_cmim w=3.78u l=3.78u m=1
.ends
.subckt r1_adc adc_hold is_smp clk adc_start adc_sel adc_valid_a adc_raw_a<0> adc_raw_a<1> adc_raw_a<2> adc_raw_a<3> adc_raw_a<4> adc_raw_a<5> adc_raw_a<6> adc_raw_a<7> adc_raw_a<8> adc_raw_a<9> adc_raw_a<10> adc_raw_a<11> adc_raw_a<12> adc_raw_a<13> adc_valid_b adc_raw_b<0> adc_raw_b<1> adc_raw_b<2> adc_raw_b<3> adc_raw_b<4> adc_raw_b<5> adc_raw_b<6> adc_raw_b<7> adc_raw_b<8> adc_raw_b<9> adc_raw_b<10> adc_raw_b<11> adc_raw_b<12> adc_raw_b<13> por_n ain_sin_p ain_sin_n ain_cos_p ain_cos_n vcm2 ibias ain_isa_p ain_isa_n ain_isb_p ain_isb_n vcm vdda vdd vss vref_in topap topan topbp topbn cur_trk
Mxckg_xpd0 xckg_d0 clk vdd vdd sg13_lv_pmos w=1u l=0.5u m=1
Mxckg_xnd0 xckg_d0 clk vss vss sg13_lv_nmos w=0.5u l=0.5u m=1
Cxckg_cd0 xckg_d0 vss cap_cmim w=2.53u l=2.53u m=1
Mxckg_xpd1 xckg_d1 xckg_d0 vdd vdd sg13_lv_pmos w=1u l=0.5u m=1
Mxckg_xnd1 xckg_d1 xckg_d0 vss vss sg13_lv_nmos w=0.5u l=0.5u m=1
Cxckg_cd1 xckg_d1 vss cap_cmim w=2.53u l=2.53u m=1
Mxckg_xpd2 xckg_d2 xckg_d1 vdd vdd sg13_lv_pmos w=1u l=0.5u m=1
Mxckg_xnd2 xckg_d2 xckg_d1 vss vss sg13_lv_nmos w=0.5u l=0.5u m=1
Cxckg_cd2 xckg_d2 vss cap_cmim w=2.53u l=2.53u m=1
Mxckg_xpd3 xckg_d3 xckg_d2 vdd vdd sg13_lv_pmos w=1u l=0.5u m=1
Mxckg_xnd3 xckg_d3 xckg_d2 vss vss sg13_lv_nmos w=0.5u l=0.5u m=1
Cxckg_cd3 xckg_d3 vss cap_cmim w=2.53u l=2.53u m=1
Mxckg_xpd4 xckg_x xckg_d3 vdd vdd sg13_lv_pmos w=1u l=0.5u m=1
Mxckg_xnd4 xckg_x xckg_d3 vss vss sg13_lv_nmos w=0.5u l=0.5u m=1
Cxckg_cd4 xckg_x vss cap_cmim w=2.53u l=2.53u m=1
Mxckg_xpa sar_mclk clk vdd vdd sg13_lv_pmos w=2u l=0.13u m=1
Mxckg_xpb sar_mclk xckg_x vdd vdd sg13_lv_pmos w=2u l=0.13u m=1
Mxckg_xna sar_mclk clk xckg_nn vss sg13_lv_nmos w=2u l=0.13u m=1
Mxckg_xnb xckg_nn xckg_x vss vss sg13_lv_nmos w=2u l=0.13u m=1
Mxckg_xpi mclkb sar_mclk vdd vdd sg13_lv_pmos w=2u l=0.13u m=1
Mxckg_xni mclkb sar_mclk vss vss sg13_lv_nmos w=1u l=0.13u m=1
Mxcbias_xmbd vbp vbp vdd vdd sg13_lv_pmos w=0.8u l=0.5u m=1
Rxcbias_xrb_g0 vbp xcbias_xrb_s1 vss rppd w=1u l=40u m=1 b=0
Rxcbias_xrb_g1 xcbias_xrb_s1 xcbias_xrb_s2 vss rppd w=1u l=40u m=1 b=0
Rxcbias_xrb_g2 xcbias_xrb_s2 xcbias_xrb_s3 vss rppd w=1u l=40u m=1 b=0
Rxcbias_xrb_g3 xcbias_xrb_s3 vss vss rppd w=1u l=40u m=1 b=0
Mxcbiasn_xmbd vbn vbn vss vss sg13_lv_nmos w=0.2u l=0.5u m=1
Rxcbiasn_xrb_g0 vdd xcbiasn_xrb_s1 vss rppd w=1u l=40u m=1 b=0
Rxcbiasn_xrb_g1 xcbiasn_xrb_s1 xcbiasn_xrb_s2 vss rppd w=1u l=40u m=1 b=0
Rxcbiasn_xrb_g2 xcbiasn_xrb_s2 xcbiasn_xrb_s3 vss rppd w=1u l=40u m=1 b=0
Rxcbiasn_xrb_g3 xcbiasn_xrb_s3 vbn vss rppd w=1u l=40u m=1 b=0
Mxref_xmb0 ibias ibias vss vss sg13_hv_nmos w=2u l=1u m=1
Mxref_xmt xref_ntl ibias vss vss sg13_hv_nmos w=2u l=8u m=1
Mxref_xm1 xref_na vref_in xref_ntl vss sg13_hv_nmos w=10u l=1u m=1
Mxref_xm2 xref_ng vref xref_ntl vss sg13_hv_nmos w=10u l=1u m=1
Mxref_xm3 xref_na xref_na vdda vdda sg13_hv_pmos w=4u l=1u m=1
Mxref_xm4 xref_ng xref_na vdda vdda sg13_hv_pmos w=4u l=1u m=1
Cxref_xcg_u0 vss xref_ng cap_cmim w=26.32u l=95u m=1
Mxref_xmsf_s0 vdda xref_ng vref vss sg13_hv_nmos w=80u l=0.45u m=1
Mxref_xmsf_s1 vdda xref_ng vref vss sg13_hv_nmos w=80u l=0.45u m=1
Mxref_xmsf_s2 vdda xref_ng vref vss sg13_hv_nmos w=80u l=0.45u m=1
Mxref_xmsf_s3 vdda xref_ng vref vss sg13_hv_nmos w=80u l=0.45u m=1
Mxref_xmib_s0 vref ibias vss vss sg13_hv_nmos w=80u l=1u m=1
Mxref_xmib_s1 vref ibias vss vss sg13_hv_nmos w=80u l=1u m=1
Mxref_xmib_s2 vref ibias vss vss sg13_hv_nmos w=80u l=1u m=1
Mxref_xmib_s3 vref ibias vss vss sg13_hv_nmos w=80u l=1u m=1
Cxref_xcd_u0 vss vref cap_cmim w=51.58u l=95u m=1
Cxref_xcd_u1 vss vref cap_cmim w=51.58u l=95u m=1
Cxref_xcd_u2 vss vref cap_cmim w=51.58u l=95u m=1
Cxref_xcd_u3 vss vref cap_cmim w=51.58u l=95u m=1
Mxref_xmsfl_s0 vdda xref_ng vrefl vss sg13_hv_nmos w=80u l=0.45u m=1
Mxref_xmibl_s0 vrefl ibias vss vss sg13_hv_nmos w=80u l=1u m=1
Cxref_xcdl_u0 vss vrefl cap_cmim w=51.58u l=95u m=1
Cxref_xcdl_u1 vss vrefl cap_cmim w=51.58u l=95u m=1
Cxfilt_xcf_u0 vss vref_in cap_cmim w=37.36u l=90u m=1
Cxfilt_xcf_u1 vss vref_in cap_cmim w=37.36u l=90u m=1
Xslice_a ain_sin_p ain_sin_n ain_isa_p ain_isa_n sar_trka0 sar_trka1 sar_cpa0 sar_cpa1 sar_cpa2 sar_cpa3 sar_cpa4 sar_cpa5 sar_cpa6 sar_cpa7 sar_cpa8 sar_cpa9 sar_cpa10 sar_cpa11 sar_cpa12 sar_cna0 sar_cna1 sar_cna2 sar_cna3 sar_cna4 sar_cna5 sar_cna6 sar_cna7 sar_cna8 sar_cna9 sar_cna10 sar_cna11 sar_cna12 sar_clka sar_clkab sar_clkna sar_clknab sar_oap sar_oan sar_oanp sar_oann vbp vbn vref vrefl topap topan vdd vss r1_adc_slice
Xslice_b ain_cos_p ain_cos_n ain_isb_p ain_isb_n sar_trkb0 sar_trkb1 sar_cpb0 sar_cpb1 sar_cpb2 sar_cpb3 sar_cpb4 sar_cpb5 sar_cpb6 sar_cpb7 sar_cpb8 sar_cpb9 sar_cpb10 sar_cpb11 sar_cpb12 sar_cnb0 sar_cnb1 sar_cnb2 sar_cnb3 sar_cnb4 sar_cnb5 sar_cnb6 sar_cnb7 sar_cnb8 sar_cnb9 sar_cnb10 sar_cnb11 sar_cnb12 sar_clkb sar_clkbb sar_clknb sar_clknbb sar_obp sar_obn sar_obnp sar_obnn vbp vbn vref vrefl topbp topbn vdd vss r1_adc_slice
Xsar adc_hold adc_sel adc_start adc_valid_a adc_valid_b clk sar_clka sar_clkab sar_clkb sar_clkbb sar_clkna sar_clknab sar_clknb sar_clknbb cur_trk is_smp sar_mclk sar_oan sar_oann sar_oanp sar_oap sar_obn sar_obnn sar_obnp sar_obp por_n sar_trka0 sar_trka1 sar_trkb0 sar_trkb1 vdd vss adc_raw_a<13> adc_raw_a<12> adc_raw_a<11> adc_raw_a<10> adc_raw_a<9> adc_raw_a<8> adc_raw_a<7> adc_raw_a<6> adc_raw_a<5> adc_raw_a<4> adc_raw_a<3> adc_raw_a<2> adc_raw_a<1> adc_raw_a<0> adc_raw_b<13> adc_raw_b<12> adc_raw_b<11> adc_raw_b<10> adc_raw_b<9> adc_raw_b<8> adc_raw_b<7> adc_raw_b<6> adc_raw_b<5> adc_raw_b<4> adc_raw_b<3> adc_raw_b<2> adc_raw_b<1> adc_raw_b<0> sar_cna12 sar_cna11 sar_cna10 sar_cna9 sar_cna8 sar_cna7 sar_cna6 sar_cna5 sar_cna4 sar_cna3 sar_cna2 sar_cna1 sar_cna0 sar_cnb12 sar_cnb11 sar_cnb10 sar_cnb9 sar_cnb8 sar_cnb7 sar_cnb6 sar_cnb5 sar_cnb4 sar_cnb3 sar_cnb2 sar_cnb1 sar_cnb0 sar_cpa12 sar_cpa11 sar_cpa10 sar_cpa9 sar_cpa8 sar_cpa7 sar_cpa6 sar_cpa5 sar_cpa4 sar_cpa3 sar_cpa2 sar_cpa1 sar_cpa0 sar_cpb12 sar_cpb11 sar_cpb10 sar_cpb9 sar_cpb8 sar_cpb7 sar_cpb6 sar_cpb5 sar_cpb4 sar_cpb3 sar_cpb2 sar_cpb1 sar_cpb0 r1_adc_sar
.ends
