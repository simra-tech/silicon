* tb_adc5_dyn.cir -- R1 ADC revision 5 dynamic test (D18 frame, T2 2026-10-21): sine on SIN (slice A), cosine on COS
* (slice B), continuous, coherent with the frame rate 1/(22 T). One chunk of an N-point record; the sine phase of the
* chunk is set by PH (sim/r5/post_dyn5.py maps local frames to global frames). Local frame 0 is the start-up frame.
* Inputs: linear E sources around CM (R2-7). Fast core r1_adc5_core_fast (as every revision-5 conversion deck).
* Substitutions: CORNER TEMP VDD CM TIMING OPTS TSTOP TMAX AMP FIN PH PHB REFLINES SAVE RAW
.lib /foss/pdks/ihp-sg13g2/libs.tech/ngspice/models/cornerMOSlv.lib @CORNER@
.lib /foss/pdks/ihp-sg13g2/libs.tech/ngspice/models/cornerCAP.lib cap_typ
.lib /foss/pdks/ihp-sg13g2/libs.tech/ngspice/models/cornerMOShv.lib @CORNER@
.lib /foss/pdks/ihp-sg13g2/libs.tech/ngspice/models/cornerRES.lib res_typ
.include schematic/r1_adc_r5.spice
.include sim/r5/@TIMING@
.temp @TEMP@
.option @OPTS@
Vdd vdd 0 @VDD@
@REFLINES@
Vcm vcm 0 @CM@
Vda vda 0 SIN(0 @AMP@ @FIN@ 0 0 @PH@)
Vdb vdb 0 SIN(0 @AMP@ @FIN@ 0 0 @PHB@)
Esp sinp vcm vda 0 0.5
Esn sinn vcm vda 0 -0.5
Ecp cosp vcm vdb 0 0.5
Ecn cosn vcm vdb 0 -0.5
Vip isap 0 0.6
Vin isan 0 0.6
XADC sinp sinn cosp cosn isap isan isap isan trka0 trka1 trkb0 trkb1 clk30 wina winb lata latb
+ stba0 stba1 stba2 stba3 stba4 stba5 stba6 stba7 stba8 stba9 stba10 stba11 stba12 stba13
+ stbb0 stbb1 stbb2 stbb3 stbb4 stbb5 stbb6 stbb7 stbb8 stbb9 stbb10 stbb11 stbb12 stbb13
+ rawa rawb topap topan topbp topbn vdd vrefa vrefb vrefla vreflb 0 r1_adc5_core_fast
.control
set num_threads=1
save v(rawa) v(rawb)
tran 1n @TSTOP@ 0 @TMAX@
write @RAW@/codes.raw
.endc
.end
