* tb_adc3_points.cir -- R1 ADC revision 3: both slices in parallel, one held differential input per slot and slice.
* Slot s (sampling edge 0.6 us + s * 0.6 us): slice A samples vda (SIN path), slice B samples vdb (COS path).
* vda/vdb are PWL sources written by sim/r3/run_points3.py (value of slot s applied 550 ns before its edge).
* Inputs are linear E sources around the common mode CM (revision 3, R2-7: no B sources on the input path).
* Reference: REFLINES (ideal source, or r1_refbuf3 from an ideal 1.045 V bandgap node).
* Substitutions: CORNER TEMP VDD CM CORE TIMING OPTS TMAX TSTOP PWLA PWLB REFLINES SAVE RAW
.lib /foss/pdks/ihp-sg13g2/libs.tech/ngspice/models/cornerMOSlv.lib @CORNER@
.lib /foss/pdks/ihp-sg13g2/libs.tech/ngspice/models/cornerCAP.lib cap_typ
.lib /foss/pdks/ihp-sg13g2/libs.tech/ngspice/models/cornerMOShv.lib @CORNER@
.lib /foss/pdks/ihp-sg13g2/libs.tech/ngspice/models/cornerRES.lib res_typ
.include schematic/r1_adc_r3.spice
.include sim/r3/@TIMING@
.temp @TEMP@
.option @OPTS@

Vdd vdd 0 @VDD@
@REFLINES@
Vcm vcm 0 @CM@
Vda vda 0 PWL(@PWLA@)
Vdb vdb 0 PWL(@PWLB@)
Esp sinp vcm vda 0 0.5
Esn sinn vcm vda 0 -0.5
Ecp cosp vcm vdb 0 0.5
Ecn cosn vcm vdb 0 -0.5
Vip isap 0 0.6
Vin isan 0 0.6

XADC sinp sinn cosp cosn isap isan isap isan trka0 trka1 trkb0 trkb1 mclk wina winb lata latb
+ stb0 stb1 stb2 stb3 stb4 stb5 stb6 stb7 stb8 stb9 stb10 stb11 stb12 stb13
+ rawa rawb topap topan topbp topbn vdd vref 0 @CORE@

.control
set num_threads=1
save @SAVE@
tran 1n @TSTOP@ 0 @TMAX@
meas tran idd avg i(vdd) from=0.7u to=@TSTOP@
write @RAW@/codes.raw
.endc
.end
