* r1_adc.spice -- R1 12-bit SAR ADC, schematic-level library (generated by gen_r1_adc.py; do not edit)
* Requires: cornerMOSlv.lib (mos_*), cornerCAP.lib (cap_*), XSPICE digital code models, PSP OSDI.

* ---------------------------------------------------------------------------------------------
* r1_bootsw: bootstrapped NMOS sampling switch. trk=1 (trkb=0): out follows vin, gate g = vin + VDD.
* Boost capacitor ideal 200 fF in this step (to be a MIM or MOS capacitor in layout).
* Thin-oxide stress: every device sees <= VDD between any two terminals (MN10 splits the g discharge).
* ---------------------------------------------------------------------------------------------
.subckt r1_bootsw vin out trk trkb vdd gnd wsw=6u cboot=200f
XMS   vin  g    out  gnd  sg13_lv_nmos w={wsw} l=0.13u ng=2 m=1
Cboot cbp  cbn  {cboot}
XM1   cbn  trkb gnd  gnd  sg13_lv_nmos w=1u l=0.13u ng=1 m=1
XM3   cbp  g    vdd  cbp  sg13_lv_pmos w=1u l=0.13u ng=1 m=1
XM8   g    x    cbp  cbp  sg13_lv_pmos w=2u l=0.13u ng=1 m=1
XM4   x    trk  vdd  vdd  sg13_lv_pmos w=0.5u l=0.13u ng=1 m=1
XM5   x    trk  cbn  gnd  sg13_lv_nmos w=1u l=0.13u ng=1 m=1
XM7   x    g    cbn  gnd  sg13_lv_nmos w=0.5u l=0.13u ng=1 m=1
XM9   cbn  g    vin  gnd  sg13_lv_nmos w=2u l=0.13u ng=1 m=1
XM10  g    vdd  n10  gnd  sg13_lv_nmos w=2u l=0.13u ng=1 m=1
XM11  n10  trkb gnd  gnd  sg13_lv_nmos w=2u l=0.13u ng=1 m=1
.ends r1_bootsw

* r1_offsw: main device of a deselected bootstrapped switch (gate held at gnd), load and feed-through model
.subckt r1_offsw vin out gnd wsw=6u
XMS   vin  gnd  out  gnd  sg13_lv_nmos w={wsw} l=0.13u ng=2 m=1
.ends r1_offsw

* ---------------------------------------------------------------------------------------------
* Bottom-plate drivers. in=0 -> out=VREF (reset / sampling state); in=1 -> out=GND (monotonic step).
* ---------------------------------------------------------------------------------------------
.subckt r1_drv in out vref gnd wp=1u wn=0.5u
XMP out in vref vref sg13_lv_pmos w={wp} l=0.13u ng=1 m=1
XMN out in gnd  gnd  sg13_lv_nmos w={wn} l=0.13u ng=1 m=1
.ends r1_drv

* fast-deck driver: ideal smooth conductance pair, Ron 400 ohm, Roff 1e12 (marked ideal in run records).
* s = 0.5*(1+tanh(20*(v(in)-0.6))): in=0 -> out tied to VREF, in=1.2 -> out tied to GND. Current is drawn from VREF.
.subckt r1_drv_sw in out vref gnd
BU vref out i=(v(vref)-v(out))*(1e-12+2.5e-3*(0.5-0.5*tanh(20*(v(in)-0.6))))
BD out gnd i=(v(out)-v(gnd))*(1e-12+2.5e-3*(0.5+0.5*tanh(20*(v(in)-0.6))))
.ends r1_drv_sw

* ---------------------------------------------------------------------------------------------
* r1_cdac_side: one side of the split 6+6 bridge array. Unit Cu = cap_cmim 3.78u x 3.78u (22.04 fF).
* MSB array on top: C10..C6 = 16,8,4,2,1 Cu; bridge Cb = 1 Cu (top-lsb); LSB array on lsb: C5..C0 = 32..1 Cu
* (63 Cu, no dummy, so Cb/(63+Cb) = 1/64 exactly). Bottom plates b10..b0. Nominal: multipliers m=.
* ---------------------------------------------------------------------------------------------
.subckt r1_cdac_side top lsb b10 b9 b8 b7 b6 b5 b4 b3 b2 b1 b0
XC10 top b10 cap_cmim w=3.78u l=3.78u m=16
XC9 top b9 cap_cmim w=3.78u l=3.78u m=8
XC8 top b8 cap_cmim w=3.78u l=3.78u m=4
XC7 top b7 cap_cmim w=3.78u l=3.78u m=2
XC6 top b6 cap_cmim w=3.78u l=3.78u m=1
XC5 lsb b5 cap_cmim w=3.78u l=3.78u m=32
XC4 lsb b4 cap_cmim w=3.78u l=3.78u m=16
XC3 lsb b3 cap_cmim w=3.78u l=3.78u m=8
XC2 lsb b2 cap_cmim w=3.78u l=3.78u m=4
XC1 lsb b1 cap_cmim w=3.78u l=3.78u m=2
XC0 lsb b0 cap_cmim w=3.78u l=3.78u m=1
XCB top lsb cap_cmim w=3.78u l=3.78u m=1
.ends r1_cdac_side

* r1_cdac_side_mc: same array, one cap_cmim instance per unit so that each unit draws its own
* mismatch value (cap_*_mismatch section, mm_ok=1).
.subckt r1_cdac_side_mc top lsb b10 b9 b8 b7 b6 b5 b4 b3 b2 b1 b0 mm=1
XC10_0 top b10 cap_cmim w=3.78u l=3.78u mm_ok={mm}
XC10_1 top b10 cap_cmim w=3.78u l=3.78u mm_ok={mm}
XC10_2 top b10 cap_cmim w=3.78u l=3.78u mm_ok={mm}
XC10_3 top b10 cap_cmim w=3.78u l=3.78u mm_ok={mm}
XC10_4 top b10 cap_cmim w=3.78u l=3.78u mm_ok={mm}
XC10_5 top b10 cap_cmim w=3.78u l=3.78u mm_ok={mm}
XC10_6 top b10 cap_cmim w=3.78u l=3.78u mm_ok={mm}
XC10_7 top b10 cap_cmim w=3.78u l=3.78u mm_ok={mm}
XC10_8 top b10 cap_cmim w=3.78u l=3.78u mm_ok={mm}
XC10_9 top b10 cap_cmim w=3.78u l=3.78u mm_ok={mm}
XC10_10 top b10 cap_cmim w=3.78u l=3.78u mm_ok={mm}
XC10_11 top b10 cap_cmim w=3.78u l=3.78u mm_ok={mm}
XC10_12 top b10 cap_cmim w=3.78u l=3.78u mm_ok={mm}
XC10_13 top b10 cap_cmim w=3.78u l=3.78u mm_ok={mm}
XC10_14 top b10 cap_cmim w=3.78u l=3.78u mm_ok={mm}
XC10_15 top b10 cap_cmim w=3.78u l=3.78u mm_ok={mm}
XC9_0 top b9 cap_cmim w=3.78u l=3.78u mm_ok={mm}
XC9_1 top b9 cap_cmim w=3.78u l=3.78u mm_ok={mm}
XC9_2 top b9 cap_cmim w=3.78u l=3.78u mm_ok={mm}
XC9_3 top b9 cap_cmim w=3.78u l=3.78u mm_ok={mm}
XC9_4 top b9 cap_cmim w=3.78u l=3.78u mm_ok={mm}
XC9_5 top b9 cap_cmim w=3.78u l=3.78u mm_ok={mm}
XC9_6 top b9 cap_cmim w=3.78u l=3.78u mm_ok={mm}
XC9_7 top b9 cap_cmim w=3.78u l=3.78u mm_ok={mm}
XC8_0 top b8 cap_cmim w=3.78u l=3.78u mm_ok={mm}
XC8_1 top b8 cap_cmim w=3.78u l=3.78u mm_ok={mm}
XC8_2 top b8 cap_cmim w=3.78u l=3.78u mm_ok={mm}
XC8_3 top b8 cap_cmim w=3.78u l=3.78u mm_ok={mm}
XC7_0 top b7 cap_cmim w=3.78u l=3.78u mm_ok={mm}
XC7_1 top b7 cap_cmim w=3.78u l=3.78u mm_ok={mm}
XC6_0 top b6 cap_cmim w=3.78u l=3.78u mm_ok={mm}
XC5_0 lsb b5 cap_cmim w=3.78u l=3.78u mm_ok={mm}
XC5_1 lsb b5 cap_cmim w=3.78u l=3.78u mm_ok={mm}
XC5_2 lsb b5 cap_cmim w=3.78u l=3.78u mm_ok={mm}
XC5_3 lsb b5 cap_cmim w=3.78u l=3.78u mm_ok={mm}
XC5_4 lsb b5 cap_cmim w=3.78u l=3.78u mm_ok={mm}
XC5_5 lsb b5 cap_cmim w=3.78u l=3.78u mm_ok={mm}
XC5_6 lsb b5 cap_cmim w=3.78u l=3.78u mm_ok={mm}
XC5_7 lsb b5 cap_cmim w=3.78u l=3.78u mm_ok={mm}
XC5_8 lsb b5 cap_cmim w=3.78u l=3.78u mm_ok={mm}
XC5_9 lsb b5 cap_cmim w=3.78u l=3.78u mm_ok={mm}
XC5_10 lsb b5 cap_cmim w=3.78u l=3.78u mm_ok={mm}
XC5_11 lsb b5 cap_cmim w=3.78u l=3.78u mm_ok={mm}
XC5_12 lsb b5 cap_cmim w=3.78u l=3.78u mm_ok={mm}
XC5_13 lsb b5 cap_cmim w=3.78u l=3.78u mm_ok={mm}
XC5_14 lsb b5 cap_cmim w=3.78u l=3.78u mm_ok={mm}
XC5_15 lsb b5 cap_cmim w=3.78u l=3.78u mm_ok={mm}
XC5_16 lsb b5 cap_cmim w=3.78u l=3.78u mm_ok={mm}
XC5_17 lsb b5 cap_cmim w=3.78u l=3.78u mm_ok={mm}
XC5_18 lsb b5 cap_cmim w=3.78u l=3.78u mm_ok={mm}
XC5_19 lsb b5 cap_cmim w=3.78u l=3.78u mm_ok={mm}
XC5_20 lsb b5 cap_cmim w=3.78u l=3.78u mm_ok={mm}
XC5_21 lsb b5 cap_cmim w=3.78u l=3.78u mm_ok={mm}
XC5_22 lsb b5 cap_cmim w=3.78u l=3.78u mm_ok={mm}
XC5_23 lsb b5 cap_cmim w=3.78u l=3.78u mm_ok={mm}
XC5_24 lsb b5 cap_cmim w=3.78u l=3.78u mm_ok={mm}
XC5_25 lsb b5 cap_cmim w=3.78u l=3.78u mm_ok={mm}
XC5_26 lsb b5 cap_cmim w=3.78u l=3.78u mm_ok={mm}
XC5_27 lsb b5 cap_cmim w=3.78u l=3.78u mm_ok={mm}
XC5_28 lsb b5 cap_cmim w=3.78u l=3.78u mm_ok={mm}
XC5_29 lsb b5 cap_cmim w=3.78u l=3.78u mm_ok={mm}
XC5_30 lsb b5 cap_cmim w=3.78u l=3.78u mm_ok={mm}
XC5_31 lsb b5 cap_cmim w=3.78u l=3.78u mm_ok={mm}
XC4_0 lsb b4 cap_cmim w=3.78u l=3.78u mm_ok={mm}
XC4_1 lsb b4 cap_cmim w=3.78u l=3.78u mm_ok={mm}
XC4_2 lsb b4 cap_cmim w=3.78u l=3.78u mm_ok={mm}
XC4_3 lsb b4 cap_cmim w=3.78u l=3.78u mm_ok={mm}
XC4_4 lsb b4 cap_cmim w=3.78u l=3.78u mm_ok={mm}
XC4_5 lsb b4 cap_cmim w=3.78u l=3.78u mm_ok={mm}
XC4_6 lsb b4 cap_cmim w=3.78u l=3.78u mm_ok={mm}
XC4_7 lsb b4 cap_cmim w=3.78u l=3.78u mm_ok={mm}
XC4_8 lsb b4 cap_cmim w=3.78u l=3.78u mm_ok={mm}
XC4_9 lsb b4 cap_cmim w=3.78u l=3.78u mm_ok={mm}
XC4_10 lsb b4 cap_cmim w=3.78u l=3.78u mm_ok={mm}
XC4_11 lsb b4 cap_cmim w=3.78u l=3.78u mm_ok={mm}
XC4_12 lsb b4 cap_cmim w=3.78u l=3.78u mm_ok={mm}
XC4_13 lsb b4 cap_cmim w=3.78u l=3.78u mm_ok={mm}
XC4_14 lsb b4 cap_cmim w=3.78u l=3.78u mm_ok={mm}
XC4_15 lsb b4 cap_cmim w=3.78u l=3.78u mm_ok={mm}
XC3_0 lsb b3 cap_cmim w=3.78u l=3.78u mm_ok={mm}
XC3_1 lsb b3 cap_cmim w=3.78u l=3.78u mm_ok={mm}
XC3_2 lsb b3 cap_cmim w=3.78u l=3.78u mm_ok={mm}
XC3_3 lsb b3 cap_cmim w=3.78u l=3.78u mm_ok={mm}
XC3_4 lsb b3 cap_cmim w=3.78u l=3.78u mm_ok={mm}
XC3_5 lsb b3 cap_cmim w=3.78u l=3.78u mm_ok={mm}
XC3_6 lsb b3 cap_cmim w=3.78u l=3.78u mm_ok={mm}
XC3_7 lsb b3 cap_cmim w=3.78u l=3.78u mm_ok={mm}
XC2_0 lsb b2 cap_cmim w=3.78u l=3.78u mm_ok={mm}
XC2_1 lsb b2 cap_cmim w=3.78u l=3.78u mm_ok={mm}
XC2_2 lsb b2 cap_cmim w=3.78u l=3.78u mm_ok={mm}
XC2_3 lsb b2 cap_cmim w=3.78u l=3.78u mm_ok={mm}
XC1_0 lsb b1 cap_cmim w=3.78u l=3.78u mm_ok={mm}
XC1_1 lsb b1 cap_cmim w=3.78u l=3.78u mm_ok={mm}
XC0_0 lsb b0 cap_cmim w=3.78u l=3.78u mm_ok={mm}
XCB top lsb cap_cmim w=3.78u l=3.78u mm_ok={mm}
.ends r1_cdac_side_mc

* ---------------------------------------------------------------------------------------------
* r1_cmp: double-tail dynamic comparator (AnalogAcademy module 3 / Lin 2010 lineage, Schinkel stage 2).
* PMOS input pair so that the input common mode may fall from 0.6 V to ~0 V (monotonic switching).
* clk=1, clkb=0: evaluate. clk=0: reset, outp = outn = VDD. Decision: inp > inn -> outp stays high.
* ---------------------------------------------------------------------------------------------
.subckt r1_cmp inp inn clk clkb outp outn vdd gnd
XMT1 tail clkb vdd  vdd sg13_lv_pmos w=8u l=0.13u ng=2 m=1
XM1  dip  inp  tail vdd sg13_lv_pmos w=16u l=0.2u ng=4 m=1
XM2  din  inn  tail vdd sg13_lv_pmos w=16u l=0.2u ng=4 m=1
XMR1 dip  clkb gnd  gnd sg13_lv_nmos w=1u l=0.13u ng=1 m=1
XMR2 din  clkb gnd  gnd sg13_lv_nmos w=1u l=0.13u ng=1 m=1
XMT2 lt   clk  gnd  gnd sg13_lv_nmos w=4u l=0.13u ng=1 m=1
XMN1 outp outn lt   gnd sg13_lv_nmos w=2u l=0.13u ng=1 m=1
XMN2 outn outp lt   gnd sg13_lv_nmos w=2u l=0.13u ng=1 m=1
XMP1 outp outn vdd  vdd sg13_lv_pmos w=2u l=0.13u ng=1 m=1
XMP2 outn outp vdd  vdd sg13_lv_pmos w=2u l=0.13u ng=1 m=1
XMH1 outp dip  vdd  vdd sg13_lv_pmos w=2u l=0.13u ng=1 m=1
XMH2 outn din  vdd  vdd sg13_lv_pmos w=2u l=0.13u ng=1 m=1
* output buffers (load of the SAR register inputs)
XBP1 outpb outp vdd vdd sg13_lv_pmos w=1u l=0.13u ng=1 m=1
XBN1 outpb outp gnd gnd sg13_lv_nmos w=0.5u l=0.13u ng=1 m=1
XBP2 outnb outn vdd vdd sg13_lv_pmos w=1u l=0.13u ng=1 m=1
XBN2 outnb outn gnd gnd sg13_lv_nmos w=0.5u l=0.13u ng=1 m=1
Cbp outpb gnd 3f
Cbn outnb gnd 3f
.ends r1_cmp

* ---------------------------------------------------------------------------------------------
* r1_th: one track-and-hold slice = CDAC P and N with top-plate sampling.
* in0 (encoder SIN or COS) sampled when trk0=1, in1 (current channel) when trk1=1. The sample is
* taken on the falling edge of trk0/trk1 (common for both slices). lsb nodes reset to VREF in track.
* cpK/cnK = 1: bottom plate of capacitor K on side P/N goes VREF -> GND.
* top_p/top_n are the comparator inputs.
* Full variant: both input pairs with complete bootstrapped switches; transistor drivers.
* ---------------------------------------------------------------------------------------------
.subckt r1_th in0p in0n in1p in1n trk0 trk1 top_p top_n cp10 cp9 cp8 cp7 cp6 cp5 cp4 cp3 cp2 cp1 cp0 cn10 cn9 cn8 cn7 cn6 cn5 cn4 cn3 cn2 cn1 cn0 vdd vref gnd
XPT0a t0b trk0 vdd vdd sg13_lv_pmos w=2u l=0.13u ng=1 m=1
XNT0a t0b trk0 gnd gnd sg13_lv_nmos w=1u l=0.13u ng=1 m=1
XPT0b t0 t0b vdd vdd sg13_lv_pmos w=4u l=0.13u ng=1 m=1
XNT0b t0 t0b gnd gnd sg13_lv_nmos w=2u l=0.13u ng=1 m=1
XPT1a t1b trk1 vdd vdd sg13_lv_pmos w=2u l=0.13u ng=1 m=1
XNT1a t1b trk1 gnd gnd sg13_lv_nmos w=1u l=0.13u ng=1 m=1
XPT1b t1 t1b vdd vdd sg13_lv_pmos w=4u l=0.13u ng=1 m=1
XNT1b t1 t1b gnd gnd sg13_lv_nmos w=2u l=0.13u ng=1 m=1
XS0P in0p top_p t0 t0b vdd gnd r1_bootsw
XS0N in0n top_n t0 t0b vdd gnd r1_bootsw
XS1P in1p top_p t1 t1b vdd gnd r1_bootsw
XS1N in1n top_n t1 t1b vdd gnd r1_bootsw
* lsb reset gate rstb = NOT(t0 OR t1) = AND(t0b, t1b) (static CMOS)
XPR1 rstb_n t0b vdd vdd sg13_lv_pmos w=1u l=0.13u ng=1 m=1
XPR2 rstb_n t1b vdd vdd sg13_lv_pmos w=1u l=0.13u ng=1 m=1
XNR1 rstb_n t0b nr gnd sg13_lv_nmos w=1u l=0.13u ng=1 m=1
XNR2 nr t1b gnd gnd sg13_lv_nmos w=1u l=0.13u ng=1 m=1
XPR3 rstb rstb_n vdd vdd sg13_lv_pmos w=1u l=0.13u ng=1 m=1
XNR3 rstb rstb_n gnd gnd sg13_lv_nmos w=0.5u l=0.13u ng=1 m=1
* lsb-node reset to VREF during track (PMOS, gate low in track)
XLRP lsb_p rstb vref vref sg13_lv_pmos w=1u l=0.13u ng=1 m=1
XLRN lsb_n rstb vref vref sg13_lv_pmos w=1u l=0.13u ng=1 m=1
XDACP top_p lsb_p bp10 bp9 bp8 bp7 bp6 bp5 bp4 bp3 bp2 bp1 bp0 r1_cdac_side
XDACN top_n lsb_n bn10 bn9 bn8 bn7 bn6 bn5 bn4 bn3 bn2 bn1 bn0 r1_cdac_side
XDp10 cp10 bp10 vref gnd r1_drv wp=2u wn=1u
XDp9 cp9 bp9 vref gnd r1_drv wp=2u wn=1u
XDp8 cp8 bp8 vref gnd r1_drv wp=2u wn=1u
XDp7 cp7 bp7 vref gnd r1_drv wp=1u wn=0.5u
XDp6 cp6 bp6 vref gnd r1_drv wp=1u wn=0.5u
XDp5 cp5 bp5 vref gnd r1_drv wp=1u wn=0.5u
XDp4 cp4 bp4 vref gnd r1_drv wp=1u wn=0.5u
XDp3 cp3 bp3 vref gnd r1_drv wp=1u wn=0.5u
XDp2 cp2 bp2 vref gnd r1_drv wp=1u wn=0.5u
XDp1 cp1 bp1 vref gnd r1_drv wp=1u wn=0.5u
XDp0 cp0 bp0 vref gnd r1_drv wp=1u wn=0.5u
XDn10 cn10 bn10 vref gnd r1_drv wp=2u wn=1u
XDn9 cn9 bn9 vref gnd r1_drv wp=2u wn=1u
XDn8 cn8 bn8 vref gnd r1_drv wp=2u wn=1u
XDn7 cn7 bn7 vref gnd r1_drv wp=1u wn=0.5u
XDn6 cn6 bn6 vref gnd r1_drv wp=1u wn=0.5u
XDn5 cn5 bn5 vref gnd r1_drv wp=1u wn=0.5u
XDn4 cn4 bn4 vref gnd r1_drv wp=1u wn=0.5u
XDn3 cn3 bn3 vref gnd r1_drv wp=1u wn=0.5u
XDn2 cn2 bn2 vref gnd r1_drv wp=1u wn=0.5u
XDn1 cn1 bn1 vref gnd r1_drv wp=1u wn=0.5u
XDn0 cn0 bn0 vref gnd r1_drv wp=1u wn=0.5u
.ends r1_th

* ---------------------------------------------------------------------------------------------
* r1_th_fast: one track-and-hold slice = CDAC P and N with top-plate sampling.
* in0 (encoder SIN or COS) sampled when trk0=1, in1 (current channel) when trk1=1. The sample is
* taken on the falling edge of trk0/trk1 (common for both slices). lsb nodes reset to VREF in track.
* cpK/cnK = 1: bottom plate of capacitor K on side P/N goes VREF -> GND.
* top_p/top_n are the comparator inputs.
* Fast variant: deselected input pair = r1_offsw only; drivers r1_drv_sw (ideal switches).
* ---------------------------------------------------------------------------------------------
.subckt r1_th_fast in0p in0n in1p in1n trk0 trk1 top_p top_n cp10 cp9 cp8 cp7 cp6 cp5 cp4 cp3 cp2 cp1 cp0 cn10 cn9 cn8 cn7 cn6 cn5 cn4 cn3 cn2 cn1 cn0 vdd vref gnd
XPT0a t0b trk0 vdd vdd sg13_lv_pmos w=2u l=0.13u ng=1 m=1
XNT0a t0b trk0 gnd gnd sg13_lv_nmos w=1u l=0.13u ng=1 m=1
XPT0b t0 t0b vdd vdd sg13_lv_pmos w=4u l=0.13u ng=1 m=1
XNT0b t0 t0b gnd gnd sg13_lv_nmos w=2u l=0.13u ng=1 m=1
XS0P in0p top_p t0 t0b vdd gnd r1_bootsw
XS0N in0n top_n t0 t0b vdd gnd r1_bootsw
XS1P in1p top_p gnd r1_offsw
XS1N in1n top_n gnd r1_offsw
* trk1 unused in the fast variant (deselected path)
Rtrk1 trk1 gnd 1e9
* lsb-node reset to VREF during track (PMOS, gate low in track)
XLRP lsb_p t0b vref vref sg13_lv_pmos w=1u l=0.13u ng=1 m=1
XLRN lsb_n t0b vref vref sg13_lv_pmos w=1u l=0.13u ng=1 m=1
XDACP top_p lsb_p bp10 bp9 bp8 bp7 bp6 bp5 bp4 bp3 bp2 bp1 bp0 r1_cdac_side
XDACN top_n lsb_n bn10 bn9 bn8 bn7 bn6 bn5 bn4 bn3 bn2 bn1 bn0 r1_cdac_side
XDp10 cp10 bp10 vref gnd r1_drv_sw
XDp9 cp9 bp9 vref gnd r1_drv_sw
XDp8 cp8 bp8 vref gnd r1_drv_sw
XDp7 cp7 bp7 vref gnd r1_drv_sw
XDp6 cp6 bp6 vref gnd r1_drv_sw
XDp5 cp5 bp5 vref gnd r1_drv_sw
XDp4 cp4 bp4 vref gnd r1_drv_sw
XDp3 cp3 bp3 vref gnd r1_drv_sw
XDp2 cp2 bp2 vref gnd r1_drv_sw
XDp1 cp1 bp1 vref gnd r1_drv_sw
XDp0 cp0 bp0 vref gnd r1_drv_sw
XDn10 cn10 bn10 vref gnd r1_drv_sw
XDn9 cn9 bn9 vref gnd r1_drv_sw
XDn8 cn8 bn8 vref gnd r1_drv_sw
XDn7 cn7 bn7 vref gnd r1_drv_sw
XDn6 cn6 bn6 vref gnd r1_drv_sw
XDn5 cn5 bn5 vref gnd r1_drv_sw
XDn4 cn4 bn4 vref gnd r1_drv_sw
XDn3 cn3 bn3 vref gnd r1_drv_sw
XDn2 cn2 bn2 vref gnd r1_drv_sw
XDn1 cn1 bn1 vref gnd r1_drv_sw
XDn0 cn0 bn0 vref gnd r1_drv_sw
.ends r1_th_fast

* ---------------------------------------------------------------------------------------------
* r1_sar_logic: XSPICE digital SAR register (behavioural-structural, B/BN flags as in
* AnalogAcademy sar_logic.v). Timing inputs (mclk, winA, winB, rst, lat, stb0..stb23) come from the
* controller (r1_ctrl); in this step from ideal sources in the test bench.
* Outputs: clkA/clkAb, clkB/clkBb comparator clocks; cpaK/cnaK, cpbK/cnbK bottom-plate controls;
* codeA/codeB analog image of the latched 12-bit codes (0..4095) for the decks.
* ---------------------------------------------------------------------------------------------
.subckt r1_sar_logic oap oan obp obn mclk wina winb rst lat stb0 stb1 stb2 stb3 stb4 stb5 stb6 stb7 stb8 stb9 stb10 stb11 stb12 stb13 stb14 stb15 stb16 stb17 stb18 stb19 stb20 stb21 stb22 stb23 clka clkab clkb clkbb cpa10 cpa9 cpa8 cpa7 cpa6 cpa5 cpa4 cpa3 cpa2 cpa1 cpa0 cna10 cna9 cna8 cna7 cna6 cna5 cna4 cna3 cna2 cna1 cna0 cpb10 cpb9 cpb8 cpb7 cpb6 cpb5 cpb4 cpb3 cpb2 cpb1 cpb0 cnb10 cnb9 cnb8 cnb7 cnb6 cnb5 cnb4 cnb3 cnb2 cnb1 cnb0 codea codeb vdd gnd
.model r1_adcb adc_bridge(in_low=0.6 in_high=0.6 rise_delay=20p fall_delay=20p)
.model r1_adcbh adc_bridge(in_low=0.2 in_high=1.0 rise_delay=20p fall_delay=20p)
.model r1_dacb dac_bridge(out_low=0 out_high=1.2 out_undef=0.6 input_load=1e-15 t_rise=80p t_fall=80p)
.model r1_dff d_dff(clk_delay=80p set_delay=80p reset_delay=80p ic=0 rise_delay=20p fall_delay=20p)
.model r1_and d_and(rise_delay=30p fall_delay=30p)
.model r1_nand d_nand(rise_delay=30p fall_delay=30p)
ABRC [oap oan obp obn] [d_oap d_oan d_obp d_obn] r1_adcbh
ABR [mclk wina winb rst lat stb0 stb1 stb2 stb3 stb4 stb5 stb6 stb7 stb8 stb9 stb10 stb11 stb12 stb13 stb14 stb15 stb16 stb17 stb18 stb19 stb20 stb21 stb22 stb23] [d_mclk d_wina d_winb d_rst d_lat d_stb0 d_stb1 d_stb2 d_stb3 d_stb4 d_stb5 d_stb6 d_stb7 d_stb8 d_stb9 d_stb10 d_stb11 d_stb12 d_stb13 d_stb14 d_stb15 d_stb16 d_stb17 d_stb18 d_stb19 d_stb20 d_stb21 d_stb22 d_stb23] r1_adcb
AGA1 [d_mclk d_wina] g_clka r1_and
AGA2 [d_mclk d_wina] g_clkab r1_nand
AGB1 [d_mclk d_winb] g_clkb r1_and
AGB2 [d_mclk d_winb] g_clkbb r1_nand
AFPa0 d_oap d_stb0 NULL d_rst fpa0 nfpa0 r1_dff
AFNa0 d_oan d_stb0 NULL d_rst fna0 nfna0 r1_dff
AQa11 fpa0 d_lat NULL NULL qa11 nqa11 r1_dff
AFPa1 d_oap d_stb1 NULL d_rst fpa1 nfpa1 r1_dff
AFNa1 d_oan d_stb1 NULL d_rst fna1 nfna1 r1_dff
AQa10 fpa1 d_lat NULL NULL qa10 nqa10 r1_dff
AFPa2 d_oap d_stb2 NULL d_rst fpa2 nfpa2 r1_dff
AFNa2 d_oan d_stb2 NULL d_rst fna2 nfna2 r1_dff
AQa9 fpa2 d_lat NULL NULL qa9 nqa9 r1_dff
AFPa3 d_oap d_stb3 NULL d_rst fpa3 nfpa3 r1_dff
AFNa3 d_oan d_stb3 NULL d_rst fna3 nfna3 r1_dff
AQa8 fpa3 d_lat NULL NULL qa8 nqa8 r1_dff
AFPa4 d_oap d_stb4 NULL d_rst fpa4 nfpa4 r1_dff
AFNa4 d_oan d_stb4 NULL d_rst fna4 nfna4 r1_dff
AQa7 fpa4 d_lat NULL NULL qa7 nqa7 r1_dff
AFPa5 d_oap d_stb5 NULL d_rst fpa5 nfpa5 r1_dff
AFNa5 d_oan d_stb5 NULL d_rst fna5 nfna5 r1_dff
AQa6 fpa5 d_lat NULL NULL qa6 nqa6 r1_dff
AFPa6 d_oap d_stb6 NULL d_rst fpa6 nfpa6 r1_dff
AFNa6 d_oan d_stb6 NULL d_rst fna6 nfna6 r1_dff
AQa5 fpa6 d_lat NULL NULL qa5 nqa5 r1_dff
AFPa7 d_oap d_stb7 NULL d_rst fpa7 nfpa7 r1_dff
AFNa7 d_oan d_stb7 NULL d_rst fna7 nfna7 r1_dff
AQa4 fpa7 d_lat NULL NULL qa4 nqa4 r1_dff
AFPa8 d_oap d_stb8 NULL d_rst fpa8 nfpa8 r1_dff
AFNa8 d_oan d_stb8 NULL d_rst fna8 nfna8 r1_dff
AQa3 fpa8 d_lat NULL NULL qa3 nqa3 r1_dff
AFPa9 d_oap d_stb9 NULL d_rst fpa9 nfpa9 r1_dff
AFNa9 d_oan d_stb9 NULL d_rst fna9 nfna9 r1_dff
AQa2 fpa9 d_lat NULL NULL qa2 nqa2 r1_dff
AFPa10 d_oap d_stb10 NULL d_rst fpa10 nfpa10 r1_dff
AFNa10 d_oan d_stb10 NULL d_rst fna10 nfna10 r1_dff
AQa1 fpa10 d_lat NULL NULL qa1 nqa1 r1_dff
AFPa11 d_oap d_stb11 NULL d_rst fpa11 nfpa11 r1_dff
AQa0 fpa11 d_lat NULL NULL qa0 nqa0 r1_dff
AFPb0 d_obp d_stb12 NULL d_rst fpb0 nfpb0 r1_dff
AFNb0 d_obn d_stb12 NULL d_rst fnb0 nfnb0 r1_dff
AQb11 fpb0 d_lat NULL NULL qb11 nqb11 r1_dff
AFPb1 d_obp d_stb13 NULL d_rst fpb1 nfpb1 r1_dff
AFNb1 d_obn d_stb13 NULL d_rst fnb1 nfnb1 r1_dff
AQb10 fpb1 d_lat NULL NULL qb10 nqb10 r1_dff
AFPb2 d_obp d_stb14 NULL d_rst fpb2 nfpb2 r1_dff
AFNb2 d_obn d_stb14 NULL d_rst fnb2 nfnb2 r1_dff
AQb9 fpb2 d_lat NULL NULL qb9 nqb9 r1_dff
AFPb3 d_obp d_stb15 NULL d_rst fpb3 nfpb3 r1_dff
AFNb3 d_obn d_stb15 NULL d_rst fnb3 nfnb3 r1_dff
AQb8 fpb3 d_lat NULL NULL qb8 nqb8 r1_dff
AFPb4 d_obp d_stb16 NULL d_rst fpb4 nfpb4 r1_dff
AFNb4 d_obn d_stb16 NULL d_rst fnb4 nfnb4 r1_dff
AQb7 fpb4 d_lat NULL NULL qb7 nqb7 r1_dff
AFPb5 d_obp d_stb17 NULL d_rst fpb5 nfpb5 r1_dff
AFNb5 d_obn d_stb17 NULL d_rst fnb5 nfnb5 r1_dff
AQb6 fpb5 d_lat NULL NULL qb6 nqb6 r1_dff
AFPb6 d_obp d_stb18 NULL d_rst fpb6 nfpb6 r1_dff
AFNb6 d_obn d_stb18 NULL d_rst fnb6 nfnb6 r1_dff
AQb5 fpb6 d_lat NULL NULL qb5 nqb5 r1_dff
AFPb7 d_obp d_stb19 NULL d_rst fpb7 nfpb7 r1_dff
AFNb7 d_obn d_stb19 NULL d_rst fnb7 nfnb7 r1_dff
AQb4 fpb7 d_lat NULL NULL qb4 nqb4 r1_dff
AFPb8 d_obp d_stb20 NULL d_rst fpb8 nfpb8 r1_dff
AFNb8 d_obn d_stb20 NULL d_rst fnb8 nfnb8 r1_dff
AQb3 fpb8 d_lat NULL NULL qb3 nqb3 r1_dff
AFPb9 d_obp d_stb21 NULL d_rst fpb9 nfpb9 r1_dff
AFNb9 d_obn d_stb21 NULL d_rst fnb9 nfnb9 r1_dff
AQb2 fpb9 d_lat NULL NULL qb2 nqb2 r1_dff
AFPb10 d_obp d_stb22 NULL d_rst fpb10 nfpb10 r1_dff
AFNb10 d_obn d_stb22 NULL d_rst fnb10 nfnb10 r1_dff
AQb1 fpb10 d_lat NULL NULL qb1 nqb1 r1_dff
AFPb11 d_obp d_stb23 NULL d_rst fpb11 nfpb11 r1_dff
AQb0 fpb11 d_lat NULL NULL qb0 nqb0 r1_dff
ADB [g_clka g_clkab g_clkb g_clkbb fpa0 fna0 fpa1 fna1 fpa2 fna2 fpa3 fna3 fpa4 fna4 fpa5 fna5 fpa6 fna6 fpa7 fna7 fpa8 fna8 fpa9 fna9 fpa10 fna10 qa0 qa1 qa2 qa3 qa4 qa5 qa6 qa7 qa8 qa9 qa10 qa11 fpb0 fnb0 fpb1 fnb1 fpb2 fnb2 fpb3 fnb3 fpb4 fnb4 fpb5 fnb5 fpb6 fnb6 fpb7 fnb7 fpb8 fnb8 fpb9 fnb9 fpb10 fnb10 qb0 qb1 qb2 qb3 qb4 qb5 qb6 qb7 qb8 qb9 qb10 qb11] [clka clkab clkb clkbb cpa10 cna10 cpa9 cna9 cpa8 cna8 cpa7 cna7 cpa6 cna6 cpa5 cna5 cpa4 cna4 cpa3 cna3 cpa2 cna2 cpa1 cna1 cpa0 cna0 qa_a0 qa_a1 qa_a2 qa_a3 qa_a4 qa_a5 qa_a6 qa_a7 qa_a8 qa_a9 qa_a10 qa_a11 cpb10 cnb10 cpb9 cnb9 cpb8 cnb8 cpb7 cnb7 cpb6 cnb6 cpb5 cnb5 cpb4 cnb4 cpb3 cnb3 cpb2 cnb2 cpb1 cnb1 cpb0 cnb0 qa_b0 qa_b1 qa_b2 qa_b3 qa_b4 qa_b5 qa_b6 qa_b7 qa_b8 qa_b9 qa_b10 qa_b11] r1_dacb
Bcodea codea gnd v=(1*v(qa_a0)+2*v(qa_a1)+4*v(qa_a2)+8*v(qa_a3)+16*v(qa_a4)+32*v(qa_a5)+64*v(qa_a6)+128*v(qa_a7)+256*v(qa_a8)+512*v(qa_a9)+1024*v(qa_a10)+2048*v(qa_a11))/1.2
Bcodeb codeb gnd v=(1*v(qa_b0)+2*v(qa_b1)+4*v(qa_b2)+8*v(qa_b3)+16*v(qa_b4)+32*v(qa_b5)+64*v(qa_b6)+128*v(qa_b7)+256*v(qa_b8)+512*v(qa_b9)+1024*v(qa_b10)+2048*v(qa_b11))/1.2
.ends r1_sar_logic

* ---------------------------------------------------------------------------------------------
* r1_adc_core: R1 ADC core. Slice A: in0 = SIN, in1 = ISA. Slice B: in0 = COS, in1 = ISB.
* trk_enc samples SIN and COS together, trk_cur samples ISA and ISB together (one edge each).
* Conversion order per 1 us frame (30 MHz, 30 cycles): A in cycles 0-11, B in 12-23, track 24-29.
* ---------------------------------------------------------------------------------------------
.subckt r1_adc_core sinp sinn cosp cosn isap isan isbp isbn trk_enc trk_cur mclk wina winb rst lat stb0 stb1 stb2 stb3 stb4 stb5 stb6 stb7 stb8 stb9 stb10 stb11 stb12 stb13 stb14 stb15 stb16 stb17 stb18 stb19 stb20 stb21 stb22 stb23 codea codeb topap topan topbp topbn vdd vref gnd
XTHA sinp sinn isap isan trk_enc trk_cur topap topan cpa10 cpa9 cpa8 cpa7 cpa6 cpa5 cpa4 cpa3 cpa2 cpa1 cpa0 cna10 cna9 cna8 cna7 cna6 cna5 cna4 cna3 cna2 cna1 cna0 vdd vref gnd r1_th
XTHB cosp cosn isbp isbn trk_enc trk_cur topbp topbn cpb10 cpb9 cpb8 cpb7 cpb6 cpb5 cpb4 cpb3 cpb2 cpb1 cpb0 cnb10 cnb9 cnb8 cnb7 cnb6 cnb5 cnb4 cnb3 cnb2 cnb1 cnb0 vdd vref gnd r1_th
XCMPA topap topan clka clkab oap oan vdd gnd r1_cmp
XCMPB topbp topbn clkb clkbb obp obn vdd gnd r1_cmp
XSAR oap oan obp obn mclk wina winb rst lat stb0 stb1 stb2 stb3 stb4 stb5 stb6 stb7 stb8 stb9 stb10 stb11 stb12 stb13 stb14 stb15 stb16 stb17 stb18 stb19 stb20 stb21 stb22 stb23 clka clkab clkb clkbb cpa10 cpa9 cpa8 cpa7 cpa6 cpa5 cpa4 cpa3 cpa2 cpa1 cpa0 cna10 cna9 cna8 cna7 cna6 cna5 cna4 cna3 cna2 cna1 cna0 cpb10 cpb9 cpb8 cpb7 cpb6 cpb5 cpb4 cpb3 cpb2 cpb1 cpb0 cnb10 cnb9 cnb8 cnb7 cnb6 cnb5 cnb4 cnb3 cnb2 cnb1 cnb0 codea codeb vdd gnd r1_sar_logic
.ends r1_adc_core

* ---------------------------------------------------------------------------------------------
* r1_adc_core_fast: R1 ADC core. Slice A: in0 = SIN, in1 = ISA. Slice B: in0 = COS, in1 = ISB.
* trk_enc samples SIN and COS together, trk_cur samples ISA and ISB together (one edge each).
* Conversion order per 1 us frame (30 MHz, 30 cycles): A in cycles 0-11, B in 12-23, track 24-29.
* ---------------------------------------------------------------------------------------------
.subckt r1_adc_core_fast sinp sinn cosp cosn isap isan isbp isbn trk_enc trk_cur mclk wina winb rst lat stb0 stb1 stb2 stb3 stb4 stb5 stb6 stb7 stb8 stb9 stb10 stb11 stb12 stb13 stb14 stb15 stb16 stb17 stb18 stb19 stb20 stb21 stb22 stb23 codea codeb topap topan topbp topbn vdd vref gnd
XTHA sinp sinn isap isan trk_enc trk_cur topap topan cpa10 cpa9 cpa8 cpa7 cpa6 cpa5 cpa4 cpa3 cpa2 cpa1 cpa0 cna10 cna9 cna8 cna7 cna6 cna5 cna4 cna3 cna2 cna1 cna0 vdd vref gnd r1_th_fast
XTHB cosp cosn isbp isbn trk_enc trk_cur topbp topbn cpb10 cpb9 cpb8 cpb7 cpb6 cpb5 cpb4 cpb3 cpb2 cpb1 cpb0 cnb10 cnb9 cnb8 cnb7 cnb6 cnb5 cnb4 cnb3 cnb2 cnb1 cnb0 vdd vref gnd r1_th_fast
XCMPA topap topan clka clkab oap oan vdd gnd r1_cmp
XCMPB topbp topbn clkb clkbb obp obn vdd gnd r1_cmp
XSAR oap oan obp obn mclk wina winb rst lat stb0 stb1 stb2 stb3 stb4 stb5 stb6 stb7 stb8 stb9 stb10 stb11 stb12 stb13 stb14 stb15 stb16 stb17 stb18 stb19 stb20 stb21 stb22 stb23 clka clkab clkb clkbb cpa10 cpa9 cpa8 cpa7 cpa6 cpa5 cpa4 cpa3 cpa2 cpa1 cpa0 cna10 cna9 cna8 cna7 cna6 cna5 cna4 cna3 cna2 cna1 cna0 cpb10 cpb9 cpb8 cpb7 cpb6 cpb5 cpb4 cpb3 cpb2 cpb1 cpb0 cnb10 cnb9 cnb8 cnb7 cnb6 cnb5 cnb4 cnb3 cnb2 cnb1 cnb0 codea codeb vdd gnd r1_sar_logic
.ends r1_adc_core_fast

* r1_adc_core_fast_a: r1_adc_core_fast with slice B and comparator B removed (comparator B inputs of
* the SAR logic tied). Same port list as r1_adc_core_fast. For static-linearity decks only.
.subckt r1_adc_core_fast_a sinp sinn cosp cosn isap isan isbp isbn trk_enc trk_cur mclk wina winb rst lat stb0 stb1 stb2 stb3 stb4 stb5 stb6 stb7 stb8 stb9 stb10 stb11 stb12 stb13 stb14 stb15 stb16 stb17 stb18 stb19 stb20 stb21 stb22 stb23 codea codeb topap topan topbp topbn vdd vref gnd
XTHA sinp sinn isap isan trk_enc trk_cur topap topan cpa10 cpa9 cpa8 cpa7 cpa6 cpa5 cpa4 cpa3 cpa2 cpa1 cpa0 cna10 cna9 cna8 cna7 cna6 cna5 cna4 cna3 cna2 cna1 cna0 vdd vref gnd r1_th_fast
XCMPA topap topan clka clkab oap oan vdd gnd r1_cmp
Vtieb1 obp gnd 1.2
Vtieb2 obn gnd 0
Rtb1 topbp gnd 1e9
Rtb2 topbn gnd 1e9
XSAR oap oan obp obn mclk wina winb rst lat stb0 stb1 stb2 stb3 stb4 stb5 stb6 stb7 stb8 stb9 stb10 stb11 stb12 stb13 stb14 stb15 stb16 stb17 stb18 stb19 stb20 stb21 stb22 stb23 clka clkab clkb clkbb cpa10 cpa9 cpa8 cpa7 cpa6 cpa5 cpa4 cpa3 cpa2 cpa1 cpa0 cna10 cna9 cna8 cna7 cna6 cna5 cna4 cna3 cna2 cna1 cna0 cpb10 cpb9 cpb8 cpb7 cpb6 cpb5 cpb4 cpb3 cpb2 cpb1 cpb0 cnb10 cnb9 cnb8 cnb7 cnb6 cnb5 cnb4 cnb3 cnb2 cnb1 cnb0 codea codeb vdd gnd r1_sar_logic
.ends r1_adc_core_fast_a
