* tb_cmp5n_noise.cir (generated by sim/r5/gen_cmp5_decks.py) -- r1_cmp5n first stage, quasi-static noise
.lib /foss/pdks/ihp-sg13g2/libs.tech/ngspice/models/cornerMOSlv.lib mos_ff
.lib /foss/pdks/ihp-sg13g2/libs.tech/ngspice/models/cornerCAP.lib cap_typ
.lib /foss/pdks/ihp-sg13g2/libs.tech/ngspice/models/cornerRES.lib res_typ
.include schematic/r1_adc_r5.spice
.temp -40
Vdd vdd 0 1.32
Vclk clk 0 1.32
Vx vx 0 0.8
XBn8 vbnn8 vdd 0 r1_cmp5n_bias
Vinpn8 inpn8 0 DC 0.6 AC 1
Vinnn8 innn8 0 DC 0.6
Xn8 inpn8 innn8 dpn8 dnn8 clk vbnn8 vdd 0 r1_cmp5n_s1
Vdpn8 vx dpn8 0
Vdnn8 vx dnn8 0
Hn8 outn8 0 poly(2) Vdpn8 Vdnn8 0 1 -1
Vbnn8s vbnn8s 0 1.32
Vinpn8s inpn8s 0 DC 0.6 AC 1
Vinnn8s innn8s 0 DC 0.6
Xn8s inpn8s innn8s dpn8s dnn8s clk vbnn8s vdd 0 r1_cmp5n_s1
Vdpn8s vx dpn8s 0
Vdnn8s vx dnn8s 0
Hn8s outn8s 0 poly(2) Vdpn8s Vdnn8s 0 1 -1
XBn8c vbnn8c vdd 0 r1_cmp5n_bias
Vinpn8c inpn8c 0 DC 0.6 AC 1
Vinnn8c innn8c 0 DC 0.6
Xn8c inpn8c innn8c dpn8c dnn8c clk vbnn8c vdd 0 r1_cmp5n_s1
Vdpn8c vx dpn8c 0
Vdnn8c vx dnn8c 0
Hn8c outn8c 0 poly(2) Vdpn8c Vdnn8c 0 1 -1
XBn16 vbnn16 vdd 0 r1_cmp5n_bias
Vinpn16 inpn16 0 DC 0.6 AC 1
Vinnn16 innn16 0 DC 0.6
Xn16 inpn16 innn16 dpn16 dnn16 clk vbnn16 vdd 0 r1_cmp5n_s1 wi=16u ngi=4 wt=8u wtc=8u
Vdpn16 vx dpn16 0
Vdnn16 vx dnn16 0
Hn16 outn16 0 poly(2) Vdpn16 Vdnn16 0 1 -1
.control
set num_threads=1
set wr_singlescale
set wr_vecnames
op
noise v(outn8) vinpn8 dec 20 1e3 1e11
setplot noise1
wrdata <G1_RESULTS_ROOT>/r1_adc/r5-cmpn-noise-ffm40-b/noise_n8.txt inoise_spectrum onoise_spectrum
destroy all
reset
op
noise v(outn8s) vinpn8s dec 20 1e3 1e11
setplot noise1
wrdata <G1_RESULTS_ROOT>/r1_adc/r5-cmpn-noise-ffm40-b/noise_n8s.txt inoise_spectrum onoise_spectrum
destroy all
reset
op
noise v(outn8c) vinpn8c dec 20 1e3 1e11
setplot noise1
wrdata <G1_RESULTS_ROOT>/r1_adc/r5-cmpn-noise-ffm40-b/noise_n8c.txt inoise_spectrum onoise_spectrum
destroy all
reset
op
noise v(outn16) vinpn16 dec 20 1e3 1e11
setplot noise1
wrdata <G1_RESULTS_ROOT>/r1_adc/r5-cmpn-noise-ffm40-b/noise_n16.txt inoise_spectrum onoise_spectrum
destroy all
reset
.endc
.end
