* tb_cmp4_noise.cir (generated by sim/r4/gen_cmp4_decks.py) -- r1_cmp4 first stage, quasi-static noise
.lib /foss/pdks/ihp-sg13g2/libs.tech/ngspice/models/cornerMOSlv.lib mos_tt
.lib /foss/pdks/ihp-sg13g2/libs.tech/ngspice/models/cornerCAP.lib cap_typ
.lib /foss/pdks/ihp-sg13g2/libs.tech/ngspice/models/cornerRES.lib res_typ
.include schematic/r1_adc_r4.spice
.temp 27
Vdd vdd 0 1.2
Vclkb clkb 0 0
Vx vx 0 0.3
XBv32 vbpv32 vdd 0 r1_cmp4_bias rbl=160u
Vinpv32 inpv32 0 DC 0.1 AC 1
Vinnv32 innv32 0 DC 0.1
Xv32 inpv32 innv32 dpv32 dnv32 clkb vbpv32 vdd 0 r1_cmp4_s1
Vdpv32 dpv32 vx 0
Vdnv32 dnv32 vx 0
Hv32 outv32 0 poly(2) Vdpv32 Vdnv32 0 1 -1
XBv48 vbpv48 vdd 0 r1_cmp4_bias rbl=160u
Vinpv48 inpv48 0 DC 0.1 AC 1
Vinnv48 innv48 0 DC 0.1
Xv48 inpv48 innv48 dpv48 dnv48 clkb vbpv48 vdd 0 r1_cmp4_s1
Vdpv48 dpv48 vx 0
Vdnv48 dnv48 vx 0
Hv48 outv48 0 poly(2) Vdpv48 Vdnv48 0 1 -1
XBv64 vbpv64 vdd 0 r1_cmp4_bias rbl=160u
Vinpv64 inpv64 0 DC 0.1 AC 1
Vinnv64 innv64 0 DC 0.1
Xv64 inpv64 innv64 dpv64 dnv64 clkb vbpv64 vdd 0 r1_cmp4_s1
Vdpv64 dpv64 vx 0
Vdnv64 dnv64 vx 0
Hv64 outv64 0 poly(2) Vdpv64 Vdnv64 0 1 -1
XBv64r vbpv64r vdd 0 r1_cmp4_bias rbl=200u
Vinpv64r inpv64r 0 DC 0.1 AC 1
Vinnv64r innv64r 0 DC 0.1
Xv64r inpv64r innv64r dpv64r dnv64r clkb vbpv64r vdd 0 r1_cmp4_s1
Vdpv64r dpv64r vx 0
Vdnv64r dnv64r vx 0
Hv64r outv64r 0 poly(2) Vdpv64r Vdnv64r 0 1 -1
XBv80 vbpv80 vdd 0 r1_cmp4_bias rbl=160u
Vinpv80 inpv80 0 DC 0.1 AC 1
Vinnv80 innv80 0 DC 0.1
Xv80 inpv80 innv80 dpv80 dnv80 clkb vbpv80 vdd 0 r1_cmp4_s1
Vdpv80 dpv80 vx 0
Vdnv80 dnv80 vx 0
Hv80 outv80 0 poly(2) Vdpv80 Vdnv80 0 1 -1
XBv96 vbpv96 vdd 0 r1_cmp4_bias rbl=160u
Vinpv96 inpv96 0 DC 0.1 AC 1
Vinnv96 innv96 0 DC 0.1
Xv96 inpv96 innv96 dpv96 dnv96 clkb vbpv96 vdd 0 r1_cmp4_s1
Vdpv96 dpv96 vx 0
Vdnv96 dnv96 vx 0
Hv96 outv96 0 poly(2) Vdpv96 Vdnv96 0 1 -1
.control
set num_threads=1
set wr_singlescale
set wr_vecnames
op
noise v(outv32) vinpv32 dec 20 1e3 1e11
setplot noise1
wrdata <G1_RESULTS_ROOT>/r1_adc/r4-cmp-noise-tt27-a/noise_v32.txt inoise_spectrum onoise_spectrum
destroy all
reset
op
noise v(outv48) vinpv48 dec 20 1e3 1e11
setplot noise1
wrdata <G1_RESULTS_ROOT>/r1_adc/r4-cmp-noise-tt27-a/noise_v48.txt inoise_spectrum onoise_spectrum
destroy all
reset
op
noise v(outv64) vinpv64 dec 20 1e3 1e11
setplot noise1
wrdata <G1_RESULTS_ROOT>/r1_adc/r4-cmp-noise-tt27-a/noise_v64.txt inoise_spectrum onoise_spectrum
destroy all
reset
op
noise v(outv64r) vinpv64r dec 20 1e3 1e11
setplot noise1
wrdata <G1_RESULTS_ROOT>/r1_adc/r4-cmp-noise-tt27-a/noise_v64r.txt inoise_spectrum onoise_spectrum
destroy all
reset
op
noise v(outv80) vinpv80 dec 20 1e3 1e11
setplot noise1
wrdata <G1_RESULTS_ROOT>/r1_adc/r4-cmp-noise-tt27-a/noise_v80.txt inoise_spectrum onoise_spectrum
destroy all
reset
op
noise v(outv96) vinpv96 dec 20 1e3 1e11
setplot noise1
wrdata <G1_RESULTS_ROOT>/r1_adc/r4-cmp-noise-tt27-a/noise_v96.txt inoise_spectrum onoise_spectrum
destroy all
reset
.endc
.end
