* tb_cmp5n_mem.cir (generated by sim/r5/gen_cmp5_decks.py) -- r1_cmp5n variants, one decision per tick, clock from r1_cmp4_clkgen, alternating +30 mV / -ASM input
.lib /foss/pdks/ihp-sg13g2/libs.tech/ngspice/models/cornerMOSlv.lib mos_ff
.lib /foss/pdks/ihp-sg13g2/libs.tech/ngspice/models/cornerCAP.lib cap_typ
.lib /foss/pdks/ihp-sg13g2/libs.tech/ngspice/models/cornerRES.lib res_typ
.include schematic/r1_adc_r5.spice
.temp -40
.option reltol=1e-4 vntol=1e-7 abstol=1e-13 method=gear
Vdd vdd 0 1.32
Vclk30 clk30 0 PULSE(0 1.32 2n 50p 50p 16.6167n 33.3333n)
XCKG clk30 mclk mclkb vdd 0 r1_cmp4_clkgen
Bclk clk 0 v=1.32*0.5*(1+tanh(25*(v(mclk)-0.6)))
Bclkb clkb 0 v=1.32*0.5*(1-tanh(25*(v(mclk)-0.6)))
Vd vd 0 PULSE(0.03 -0.0002 34.1333n 0.2n 0.2n 33.1333n 66.6667n)
V_n8 vdd_n8 vdd 0
XBn8 vbnn8 vdd_n8 0 r1_cmp5n_bias
Bpn8h ipn8h 0 v=0.7+v(vd)/2
Bnn8h inn8h 0 v=0.7-v(vd)/2
Xn8h ipn8h inn8h clk clkb opn8h onn8h vbnn8 vdd_n8 0 r1_cmp5n
Bpn8m ipn8m 0 v=0.6+v(vd)/2
Bnn8m inn8m 0 v=0.6-v(vd)/2
Xn8m ipn8m inn8m clk clkb opn8m onn8m vbnn8 vdd_n8 0 r1_cmp5n
Bpn8l ipn8l 0 v=0.5+v(vd)/2
Bnn8l inn8l 0 v=0.5-v(vd)/2
Xn8l ipn8l inn8l clk clkb opn8l onn8l vbnn8 vdd_n8 0 r1_cmp5n
V_n8s vdd_n8s vdd 0
Vbnn8s vbnn8s 0 1.32
Bpn8sh ipn8sh 0 v=0.7+v(vd)/2
Bnn8sh inn8sh 0 v=0.7-v(vd)/2
Xn8sh ipn8sh inn8sh clk clkb opn8sh onn8sh vbnn8s vdd_n8s 0 r1_cmp5n
Bpn8sm ipn8sm 0 v=0.6+v(vd)/2
Bnn8sm inn8sm 0 v=0.6-v(vd)/2
Xn8sm ipn8sm inn8sm clk clkb opn8sm onn8sm vbnn8s vdd_n8s 0 r1_cmp5n
Bpn8sl ipn8sl 0 v=0.5+v(vd)/2
Bnn8sl inn8sl 0 v=0.5-v(vd)/2
Xn8sl ipn8sl inn8sl clk clkb opn8sl onn8sl vbnn8s vdd_n8s 0 r1_cmp5n
V_n8c vdd_n8c vdd 0
XBn8c vbnn8c vdd_n8c 0 r1_cmp5n_bias
Bpn8ch ipn8ch 0 v=0.7+v(vd)/2
Bnn8ch inn8ch 0 v=0.7-v(vd)/2
Xn8ch ipn8ch inn8ch clk clkb opn8ch onn8ch vbnn8c vdd_n8c 0 r1_cmp5n wcap=10u
Bpn8cm ipn8cm 0 v=0.6+v(vd)/2
Bnn8cm inn8cm 0 v=0.6-v(vd)/2
Xn8cm ipn8cm inn8cm clk clkb opn8cm onn8cm vbnn8c vdd_n8c 0 r1_cmp5n wcap=10u
Bpn8cl ipn8cl 0 v=0.5+v(vd)/2
Bnn8cl inn8cl 0 v=0.5-v(vd)/2
Xn8cl ipn8cl inn8cl clk clkb opn8cl onn8cl vbnn8c vdd_n8c 0 r1_cmp5n wcap=10u
V_n16 vdd_n16 vdd 0
XBn16 vbnn16 vdd_n16 0 r1_cmp5n_bias
Bpn16h ipn16h 0 v=0.7+v(vd)/2
Bnn16h inn16h 0 v=0.7-v(vd)/2
Xn16h ipn16h inn16h clk clkb opn16h onn16h vbnn16 vdd_n16 0 r1_cmp5n wi=16u ngi=4 wt=8u wtc=8u wcap=40u wr=8u wh=8u
Bpn16m ipn16m 0 v=0.6+v(vd)/2
Bnn16m inn16m 0 v=0.6-v(vd)/2
Xn16m ipn16m inn16m clk clkb opn16m onn16m vbnn16 vdd_n16 0 r1_cmp5n wi=16u ngi=4 wt=8u wtc=8u wcap=40u wr=8u wh=8u
Bpn16l ipn16l 0 v=0.5+v(vd)/2
Bnn16l inn16l 0 v=0.5-v(vd)/2
Xn16l ipn16l inn16l clk clkb opn16l onn16l vbnn16 vdd_n16 0 r1_cmp5n wi=16u ngi=4 wt=8u wtc=8u wcap=40u wr=8u wh=8u
.control
set num_threads=1
save v(clk30) v(mclk) v(vd) i(vdd) v(opn8h) v(onn8h) v(opn8m) v(onn8m) v(opn8l) v(onn8l) i(v_n8) v(opn8sh) v(onn8sh) v(opn8sm) v(onn8sm) v(opn8sl) v(onn8sl) i(v_n8s) v(opn8ch) v(onn8ch) v(opn8cm) v(onn8cm) v(opn8cl) v(onn8cl) i(v_n8c) v(opn16h) v(onn16h) v(opn16m) v(onn16m) v(opn16l) v(onn16l) i(v_n16)
tran 5p 335.333n 0 20p
write <G1_RESULTS_ROOT>/r1_adc/r5-cmpn-mem-ffm40-b/mem.raw
.endc
.end
