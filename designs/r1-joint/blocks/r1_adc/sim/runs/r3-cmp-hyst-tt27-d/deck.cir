* tb_cmp3_hyst.cir (generated by sim/r3/gen_cmp3_hyst.py) -- r1_cmp3 (wcap 80u, rbl 85u) memory test
.lib /foss/pdks/ihp-sg13g2/libs.tech/ngspice/models/cornerMOSlv.lib mos_tt
.lib /foss/pdks/ihp-sg13g2/libs.tech/ngspice/models/cornerCAP.lib cap_typ
.lib /foss/pdks/ihp-sg13g2/libs.tech/ngspice/models/cornerRES.lib res_typ
.include schematic/r1_adc_r3.spice
.temp 27
.option reltol=1e-4 vntol=1e-7 abstol=1e-13 method=gear
Vdd vdd 0 1.2
Vclk clk 0 PULSE(0 1.2 1n 50p 50p 13.45n 16.6667n)
Vclkb clkb 0 PULSE(1.2 0 1n 50p 50p 13.45n 16.6667n)
Vd vd 0 PULSE(0.03 -0.0002 15.1667n 0.2n 0.2n 16.2667n 33.3333n)
XBc16 vbpc16 vdd 0 r1_cmp3_bias rbl=120u
Bwc16hp inpwc16h 0 v=0.6+v(vd)/2
Bwc16hn innwc16h 0 v=0.6-v(vd)/2
Xwc16h inpwc16h innwc16h clk clkb opwc16h onwc16h vbpc16 vdd 0 r1_cmp3 wr=4u wcap=16u
Bwc16mp inpwc16m 0 v=0.35+v(vd)/2
Bwc16mn innwc16m 0 v=0.35-v(vd)/2
Xwc16m inpwc16m innwc16m clk clkb opwc16m onwc16m vbpc16 vdd 0 r1_cmp3 wr=4u wcap=16u
Bwc16lp inpwc16l 0 v=0.1+v(vd)/2
Bwc16ln innwc16l 0 v=0.1-v(vd)/2
Xwc16l inpwc16l innwc16l clk clkb opwc16l onwc16l vbpc16 vdd 0 r1_cmp3 wr=4u wcap=16u
XBc24 vbpc24 vdd 0 r1_cmp3_bias rbl=120u
Bwc24hp inpwc24h 0 v=0.6+v(vd)/2
Bwc24hn innwc24h 0 v=0.6-v(vd)/2
Xwc24h inpwc24h innwc24h clk clkb opwc24h onwc24h vbpc24 vdd 0 r1_cmp3 wr=6u wcap=24u
Bwc24mp inpwc24m 0 v=0.35+v(vd)/2
Bwc24mn innwc24m 0 v=0.35-v(vd)/2
Xwc24m inpwc24m innwc24m clk clkb opwc24m onwc24m vbpc24 vdd 0 r1_cmp3 wr=6u wcap=24u
Bwc24lp inpwc24l 0 v=0.1+v(vd)/2
Bwc24ln innwc24l 0 v=0.1-v(vd)/2
Xwc24l inpwc24l innwc24l clk clkb opwc24l onwc24l vbpc24 vdd 0 r1_cmp3 wr=6u wcap=24u
XBc32 vbpc32 vdd 0 r1_cmp3_bias rbl=120u
Bwc32hp inpwc32h 0 v=0.6+v(vd)/2
Bwc32hn innwc32h 0 v=0.6-v(vd)/2
Xwc32h inpwc32h innwc32h clk clkb opwc32h onwc32h vbpc32 vdd 0 r1_cmp3 wr=8u wcap=32u
Bwc32mp inpwc32m 0 v=0.35+v(vd)/2
Bwc32mn innwc32m 0 v=0.35-v(vd)/2
Xwc32m inpwc32m innwc32m clk clkb opwc32m onwc32m vbpc32 vdd 0 r1_cmp3 wr=8u wcap=32u
Bwc32lp inpwc32l 0 v=0.1+v(vd)/2
Bwc32ln innwc32l 0 v=0.1-v(vd)/2
Xwc32l inpwc32l innwc32l clk clkb opwc32l onwc32l vbpc32 vdd 0 r1_cmp3 wr=8u wcap=32u
XBc32c vbpc32c vdd 0 r1_cmp3_bias rbl=160u
Bwc32chp inpwc32ch 0 v=0.6+v(vd)/2
Bwc32chn innwc32ch 0 v=0.6-v(vd)/2
Xwc32ch inpwc32ch innwc32ch clk clkb opwc32ch onwc32ch vbpc32c vdd 0 r1_cmp3 wr=8u wcap=32u
Bwc32cmp inpwc32cm 0 v=0.35+v(vd)/2
Bwc32cmn innwc32cm 0 v=0.35-v(vd)/2
Xwc32cm inpwc32cm innwc32cm clk clkb opwc32cm onwc32cm vbpc32c vdd 0 r1_cmp3 wr=8u wcap=32u
Bwc32clp inpwc32cl 0 v=0.1+v(vd)/2
Bwc32cln innwc32cl 0 v=0.1-v(vd)/2
Xwc32cl inpwc32cl innwc32cl clk clkb opwc32cl onwc32cl vbpc32c vdd 0 r1_cmp3 wr=8u wcap=32u
XBc40b vbpc40b vdd 0 r1_cmp3_bias rbl=120u
Bwc40bhp inpwc40bh 0 v=0.6+v(vd)/2
Bwc40bhn innwc40bh 0 v=0.6-v(vd)/2
Xwc40bh inpwc40bh innwc40bh clk clkb opwc40bh onwc40bh vbpc40b vdd 0 r1_cmp3 wr=8u wcap=40u
Bwc40bmp inpwc40bm 0 v=0.35+v(vd)/2
Bwc40bmn innwc40bm 0 v=0.35-v(vd)/2
Xwc40bm inpwc40bm innwc40bm clk clkb opwc40bm onwc40bm vbpc40b vdd 0 r1_cmp3 wr=8u wcap=40u
Bwc40blp inpwc40bl 0 v=0.1+v(vd)/2
Bwc40bln innwc40bl 0 v=0.1-v(vd)/2
Xwc40bl inpwc40bl innwc40bl clk clkb opwc40bl onwc40bl vbpc40b vdd 0 r1_cmp3 wr=8u wcap=40u
XBc40c vbpc40c vdd 0 r1_cmp3_bias rbl=160u
Bwc40chp inpwc40ch 0 v=0.6+v(vd)/2
Bwc40chn innwc40ch 0 v=0.6-v(vd)/2
Xwc40ch inpwc40ch innwc40ch clk clkb opwc40ch onwc40ch vbpc40c vdd 0 r1_cmp3 wr=8u wcap=40u
Bwc40cmp inpwc40cm 0 v=0.35+v(vd)/2
Bwc40cmn innwc40cm 0 v=0.35-v(vd)/2
Xwc40cm inpwc40cm innwc40cm clk clkb opwc40cm onwc40cm vbpc40c vdd 0 r1_cmp3 wr=8u wcap=40u
Bwc40clp inpwc40cl 0 v=0.1+v(vd)/2
Bwc40cln innwc40cl 0 v=0.1-v(vd)/2
Xwc40cl inpwc40cl innwc40cl clk clkb opwc40cl onwc40cl vbpc40c vdd 0 r1_cmp3 wr=8u wcap=40u
.control
set num_threads=1
save v(clk) v(vd) v(opwc16h) v(onwc16h) v(opwc16m) v(onwc16m) v(opwc16l) v(onwc16l) v(opwc24h) v(onwc24h) v(opwc24m) v(onwc24m) v(opwc24l) v(onwc24l) v(opwc32h) v(onwc32h) v(opwc32m) v(onwc32m) v(opwc32l) v(onwc32l) v(opwc32ch) v(onwc32ch) v(opwc32cm) v(onwc32cm) v(opwc32cl) v(onwc32cl) v(opwc40bh) v(onwc40bh) v(opwc40bm) v(onwc40bm) v(opwc40bl) v(onwc40bl) v(opwc40ch) v(onwc40ch) v(opwc40cm) v(onwc40cm) v(opwc40cl) v(onwc40cl)
tran 5p 200n 0 20p
write <G1_RESULTS_ROOT>/r1_adc/r3-cmp-hyst-tt27-d/hyst.raw
.endc
.end
