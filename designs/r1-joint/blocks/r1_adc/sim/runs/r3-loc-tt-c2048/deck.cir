* tb_adc3_points.cir -- R1 ADC revision 3: both slices in parallel, one held differential input per slot and slice.
* Slot s (sampling edge 0.6 us + s * 0.6 us): slice A samples vda (SIN path), slice B samples vdb (COS path).
* vda/vdb are PWL sources written by sim/r3/run_points3.py (value of slot s applied 550 ns before its edge).
* Inputs are linear E sources around the common mode CM (revision 3, R2-7: no B sources on the input path).
* Reference: REFLINES (ideal source, or r1_refbuf3 from an ideal 1.045 V bandgap node).
* Substitutions: CORNER TEMP VDD CM CORE TIMING OPTS TMAX TSTOP PWLA PWLB REFLINES SAVE RAW
.lib /foss/pdks/ihp-sg13g2/libs.tech/ngspice/models/cornerMOSlv.lib mos_tt
.lib /foss/pdks/ihp-sg13g2/libs.tech/ngspice/models/cornerCAP.lib cap_typ
.lib /foss/pdks/ihp-sg13g2/libs.tech/ngspice/models/cornerMOShv.lib mos_tt
.lib /foss/pdks/ihp-sg13g2/libs.tech/ngspice/models/cornerRES.lib res_typ
.include schematic/r1_adc_r3.spice
.include sim/r3/r1_adc_timing_r3.inc
.temp 27
.option reltol=1e-4 vntol=1e-6 abstol=1e-12 method=trap klu rshunt=1e12 interp

Vdd vdd 0 1.2
Vref vref 0 1.0
Vcm vcm 0 0.6
Vda vda 0 PWL(0 -0.0160000 6.500000e-07 -0.0160000 6.600000e-07 -0.0156000 1.250000e-06 -0.0156000 1.260000e-06 -0.0152000 1.850000e-06 -0.0152000 1.860000e-06 -0.0148000 2.450000e-06 -0.0148000
+ 2.460000e-06 -0.0144000 3.050000e-06 -0.0144000 3.060000e-06 -0.0140000 3.650000e-06 -0.0140000 3.660000e-06 -0.0136000 4.250000e-06 -0.0136000 4.260000e-06 -0.0132000 4.850000e-06 -0.0132000
+ 4.860000e-06 -0.0128000 5.450000e-06 -0.0128000 5.460000e-06 -0.0124000 6.050000e-06 -0.0124000 6.060000e-06 -0.0120000 6.650000e-06 -0.0120000 6.660000e-06 -0.0116000 7.250000e-06 -0.0116000
+ 7.260000e-06 -0.0112000 7.850000e-06 -0.0112000 7.860000e-06 -0.0108000 8.450000e-06 -0.0108000 8.460000e-06 -0.0104000 9.050000e-06 -0.0104000 9.060000e-06 -0.0100000 9.650000e-06 -0.0100000
+ 9.660000e-06 -0.0096000 1.025000e-05 -0.0096000 1.026000e-05 -0.0092000 1.085000e-05 -0.0092000 1.086000e-05 -0.0088000 1.145000e-05 -0.0088000 1.146000e-05 -0.0084000 1.205000e-05 -0.0084000
+ 1.206000e-05 -0.0080000 1.265000e-05 -0.0080000 1.266000e-05 -0.0076000 1.325000e-05 -0.0076000 1.326000e-05 -0.0072000 1.385000e-05 -0.0072000 1.386000e-05 -0.0068000 1.445000e-05 -0.0068000
+ 1.446000e-05 -0.0064000 1.505000e-05 -0.0064000 1.506000e-05 -0.0060000 1.565000e-05 -0.0060000 1.566000e-05 -0.0056000 1.625000e-05 -0.0056000 1.626000e-05 -0.0052000 1.685000e-05 -0.0052000
+ 1.686000e-05 -0.0048000 1.745000e-05 -0.0048000 1.746000e-05 -0.0044000 1.805000e-05 -0.0044000 1.806000e-05 -0.0040000 1.865000e-05 -0.0040000 1.866000e-05 -0.0036000 1.925000e-05 -0.0036000
+ 1.926000e-05 -0.0032000 1.985000e-05 -0.0032000 1.986000e-05 -0.0028000 2.045000e-05 -0.0028000 2.046000e-05 -0.0024000 2.105000e-05 -0.0024000 2.106000e-05 -0.0020000 2.165000e-05 -0.0020000
+ 2.166000e-05 -0.0016000 2.225000e-05 -0.0016000 2.226000e-05 -0.0012000 2.285000e-05 -0.0012000 2.286000e-05 -0.0008000 2.345000e-05 -0.0008000 2.346000e-05 -0.0004000 2.405000e-05 -0.0004000
+ 2.406000e-05 0.0000000 2.465000e-05 0.0000000 2.466000e-05 0.0004000 2.525000e-05 0.0004000 2.526000e-05 0.0008000 2.585000e-05 0.0008000 2.586000e-05 0.0012000 2.645000e-05 0.0012000
+ 2.646000e-05 0.0016000 2.705000e-05 0.0016000 2.706000e-05 0.0020000 2.765000e-05 0.0020000 2.766000e-05 0.0024000 2.825000e-05 0.0024000 2.826000e-05 0.0028000 2.885000e-05 0.0028000
+ 2.886000e-05 0.0032000 2.945000e-05 0.0032000 2.946000e-05 0.0036000)
Vdb vdb 0 PWL(0 -0.0160000 6.500000e-07 -0.0160000 6.600000e-07 -0.0156000 1.250000e-06 -0.0156000 1.260000e-06 -0.0152000 1.850000e-06 -0.0152000 1.860000e-06 -0.0148000 2.450000e-06 -0.0148000
+ 2.460000e-06 -0.0144000 3.050000e-06 -0.0144000 3.060000e-06 -0.0140000 3.650000e-06 -0.0140000 3.660000e-06 -0.0136000 4.250000e-06 -0.0136000 4.260000e-06 -0.0132000 4.850000e-06 -0.0132000
+ 4.860000e-06 -0.0128000 5.450000e-06 -0.0128000 5.460000e-06 -0.0124000 6.050000e-06 -0.0124000 6.060000e-06 -0.0120000 6.650000e-06 -0.0120000 6.660000e-06 -0.0116000 7.250000e-06 -0.0116000
+ 7.260000e-06 -0.0112000 7.850000e-06 -0.0112000 7.860000e-06 -0.0108000 8.450000e-06 -0.0108000 8.460000e-06 -0.0104000 9.050000e-06 -0.0104000 9.060000e-06 -0.0100000 9.650000e-06 -0.0100000
+ 9.660000e-06 -0.0096000 1.025000e-05 -0.0096000 1.026000e-05 -0.0092000 1.085000e-05 -0.0092000 1.086000e-05 -0.0088000 1.145000e-05 -0.0088000 1.146000e-05 -0.0084000 1.205000e-05 -0.0084000
+ 1.206000e-05 -0.0080000 1.265000e-05 -0.0080000 1.266000e-05 -0.0076000 1.325000e-05 -0.0076000 1.326000e-05 -0.0072000 1.385000e-05 -0.0072000 1.386000e-05 -0.0068000 1.445000e-05 -0.0068000
+ 1.446000e-05 -0.0064000 1.505000e-05 -0.0064000 1.506000e-05 -0.0060000 1.565000e-05 -0.0060000 1.566000e-05 -0.0056000 1.625000e-05 -0.0056000 1.626000e-05 -0.0052000 1.685000e-05 -0.0052000
+ 1.686000e-05 -0.0048000 1.745000e-05 -0.0048000 1.746000e-05 -0.0044000 1.805000e-05 -0.0044000 1.806000e-05 -0.0040000 1.865000e-05 -0.0040000 1.866000e-05 -0.0036000 1.925000e-05 -0.0036000
+ 1.926000e-05 -0.0032000 1.985000e-05 -0.0032000 1.986000e-05 -0.0028000 2.045000e-05 -0.0028000 2.046000e-05 -0.0024000 2.105000e-05 -0.0024000 2.106000e-05 -0.0020000 2.165000e-05 -0.0020000
+ 2.166000e-05 -0.0016000 2.225000e-05 -0.0016000 2.226000e-05 -0.0012000 2.285000e-05 -0.0012000 2.286000e-05 -0.0008000 2.345000e-05 -0.0008000 2.346000e-05 -0.0004000 2.405000e-05 -0.0004000
+ 2.406000e-05 0.0000000 2.465000e-05 0.0000000 2.466000e-05 0.0004000 2.525000e-05 0.0004000 2.526000e-05 0.0008000 2.585000e-05 0.0008000 2.586000e-05 0.0012000 2.645000e-05 0.0012000
+ 2.646000e-05 0.0016000 2.705000e-05 0.0016000 2.706000e-05 0.0020000 2.765000e-05 0.0020000 2.766000e-05 0.0024000 2.825000e-05 0.0024000 2.826000e-05 0.0028000 2.885000e-05 0.0028000
+ 2.886000e-05 0.0032000 2.945000e-05 0.0032000 2.946000e-05 0.0036000)
Esp sinp vcm vda 0 0.5
Esn sinn vcm vda 0 -0.5
Ecp cosp vcm vdb 0 0.5
Ecn cosn vcm vdb 0 -0.5
Vip isap 0 0.6
Vin isan 0 0.6

XADC sinp sinn cosp cosn isap isan isap isan trka0 trka1 trkb0 trkb1 mclk wina winb lata latb
+ stb0 stb1 stb2 stb3 stb4 stb5 stb6 stb7 stb8 stb9 stb10 stb11 stb12 stb13
+ rawa rawb topap topan topbp topbn vdd vref 0 r1_adc3_core_fast

.control
set num_threads=1
save v(rawa) v(rawb)
tran 1n 30.3000u 0 0.2n
meas tran idd avg i(vdd) from=0.7u to=30.3000u
write <G1_RESULTS_ROOT>/r1_adc/r3-loc-tt-c2048/codes.raw
.endc
.end
