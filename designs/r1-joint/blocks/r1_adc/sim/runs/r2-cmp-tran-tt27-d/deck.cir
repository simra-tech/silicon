* tb_cmp2_tran.cir (generated by sim/r2/gen_cmp_decks.py) -- r1_cmp2 variants, decision dynamics
.lib /foss/pdks/ihp-sg13g2/libs.tech/ngspice/models/cornerMOSlv.lib mos_tt
.lib /foss/pdks/ihp-sg13g2/libs.tech/ngspice/models/cornerCAP.lib cap_typ
.lib /foss/pdks/ihp-sg13g2/libs.tech/ngspice/models/cornerMOShv.lib mos_tt
.lib /foss/pdks/ihp-sg13g2/libs.tech/ngspice/models/cornerRES.lib res_typ
.include schematic/r1_adc_r2.spice
.temp 27
.option reltol=1e-4 vntol=1e-7 abstol=1e-13 method=gear
Vdd vdd 0 1.2
Vclk clk 0 PULSE(0 1.2 2n 50p 50p 16.6167n 33.3333n)
Vclkb clkb 0 PULSE(1.2 0 2n 50p 50p 16.6167n 33.3333n)
XB vbp vdd 0 r1_cmp2_bias ib=14u
VpBh ipBh 0 0.6001
VnBh inBh 0 0.5999
XBh ipBh inBh clk clkb opBh onBh vbp vdd 0 r1_cmp2 wi=48u li=0.3u ngi=12 wt=16u wtc=8u ltc=0.5u wcap=8u lcap=4u wr=2u wh=8u
VpBm ipBm 0 0.3501
VnBm inBm 0 0.3499
XBm ipBm inBm clk clkb opBm onBm vbp vdd 0 r1_cmp2 wi=48u li=0.3u ngi=12 wt=16u wtc=8u ltc=0.5u wcap=8u lcap=4u wr=2u wh=8u
VpBl ipBl 0 0.1001
VnBl inBl 0 0.0999
XBl ipBl inBl clk clkb opBl onBl vbp vdd 0 r1_cmp2 wi=48u li=0.3u ngi=12 wt=16u wtc=8u ltc=0.5u wcap=8u lcap=4u wr=2u wh=8u
VpB12h ipB12h 0 0.6001
VnB12h inB12h 0 0.5999
XB12h ipB12h inB12h clk clkb opB12h onB12h vbp vdd 0 r1_cmp2 wi=48u li=0.3u ngi=12 wt=16u wtc=12u ltc=0.5u wcap=12u lcap=4u wr=2u wh=8u
VpB12m ipB12m 0 0.3501
VnB12m inB12m 0 0.3499
XB12m ipB12m inB12m clk clkb opB12m onB12m vbp vdd 0 r1_cmp2 wi=48u li=0.3u ngi=12 wt=16u wtc=12u ltc=0.5u wcap=12u lcap=4u wr=2u wh=8u
VpB12l ipB12l 0 0.1001
VnB12l inB12l 0 0.0999
XB12l ipB12l inB12l clk clkb opB12l onB12l vbp vdd 0 r1_cmp2 wi=48u li=0.3u ngi=12 wt=16u wtc=12u ltc=0.5u wcap=12u lcap=4u wr=2u wh=8u
VpB16h ipB16h 0 0.6001
VnB16h inB16h 0 0.5999
XB16h ipB16h inB16h clk clkb opB16h onB16h vbp vdd 0 r1_cmp2 wi=48u li=0.3u ngi=12 wt=16u wtc=16u ltc=0.5u wcap=16u lcap=4u wr=2u wh=8u
VpB16m ipB16m 0 0.3501
VnB16m inB16m 0 0.3499
XB16m ipB16m inB16m clk clkb opB16m onB16m vbp vdd 0 r1_cmp2 wi=48u li=0.3u ngi=12 wt=16u wtc=16u ltc=0.5u wcap=16u lcap=4u wr=2u wh=8u
VpB16l ipB16l 0 0.1001
VnB16l inB16l 0 0.0999
XB16l ipB16l inB16l clk clkb opB16l onB16l vbp vdd 0 r1_cmp2 wi=48u li=0.3u ngi=12 wt=16u wtc=16u ltc=0.5u wcap=16u lcap=4u wr=2u wh=8u
.control
set num_threads=1
save v(opBh) v(onBh) v(xBh.dip) v(xBh.din) v(opBm) v(onBm) v(xBm.dip) v(xBm.din) v(opBl) v(onBl) v(xBl.dip) v(xBl.din) v(opB12h) v(onB12h) v(xB12h.dip) v(xB12h.din) v(opB12m) v(onB12m) v(xB12m.dip) v(xB12m.din) v(opB12l) v(onB12l) v(xB12l.dip) v(xB12l.din) v(opB16h) v(onB16h) v(xB16h.dip) v(xB16h.din) v(opB16m) v(onB16m) v(xB16m.dip) v(xB16m.din) v(opB16l) v(onB16l) v(xB16l.dip) v(xB16l.din) v(clk) i(vdd)
tran 5p 100n 0 20p
write <G1_RESULTS_ROOT>/r1_adc/r2-cmp-tran-tt27-d/cmp_tran.raw
.endc
.end
