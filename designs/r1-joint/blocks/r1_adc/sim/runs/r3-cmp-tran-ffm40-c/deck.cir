* tb_cmp3_tran.cir (generated by sim/r3/gen_cmp3_decks.py) -- r1_cmp3 variants, decision dynamics, rev-3 clock
.lib /foss/pdks/ihp-sg13g2/libs.tech/ngspice/models/cornerMOSlv.lib mos_ff
.lib /foss/pdks/ihp-sg13g2/libs.tech/ngspice/models/cornerCAP.lib cap_typ
.lib /foss/pdks/ihp-sg13g2/libs.tech/ngspice/models/cornerRES.lib res_typ
.include schematic/r1_adc_r3.spice
.temp -40
.option reltol=1e-4 vntol=1e-7 abstol=1e-13 method=gear
Vdd vdd 0 1.32
Vclk clk 0 PULSE(0 1.32 1n 50p 50p 13.45n 16.6667n)
Vclkb clkb 0 PULSE(1.32 0 1n 50p 50p 13.45n 16.6667n)
V_r80a vdd_r80a vdd 0
XBr80a vbpr80a vdd_r80a 0 r1_cmp3_bias rbw=1u rbl=75u
Vpr80ah ipr80ah 0 0.6001
Vnr80ah inr80ah 0 0.5999
Xr80ah ipr80ah inr80ah clk clkb opr80ah onr80ah vbpr80a vdd_r80a 0 r1_cmp3 wcap=80u
Vpr80am ipr80am 0 0.3501
Vnr80am inr80am 0 0.3499
Xr80am ipr80am inr80am clk clkb opr80am onr80am vbpr80a vdd_r80a 0 r1_cmp3 wcap=80u
Vpr80al ipr80al 0 0.1001
Vnr80al inr80al 0 0.0999
Xr80al ipr80al inr80al clk clkb opr80al onr80al vbpr80a vdd_r80a 0 r1_cmp3 wcap=80u
V_r80b vdd_r80b vdd 0
XBr80b vbpr80b vdd_r80b 0 r1_cmp3_bias rbw=1u rbl=85u
Vpr80bh ipr80bh 0 0.6001
Vnr80bh inr80bh 0 0.5999
Xr80bh ipr80bh inr80bh clk clkb opr80bh onr80bh vbpr80b vdd_r80b 0 r1_cmp3 wcap=80u
Vpr80bm ipr80bm 0 0.3501
Vnr80bm inr80bm 0 0.3499
Xr80bm ipr80bm inr80bm clk clkb opr80bm onr80bm vbpr80b vdd_r80b 0 r1_cmp3 wcap=80u
Vpr80bl ipr80bl 0 0.1001
Vnr80bl inr80bl 0 0.0999
Xr80bl ipr80bl inr80bl clk clkb opr80bl onr80bl vbpr80b vdd_r80b 0 r1_cmp3 wcap=80u
V_r96a vdd_r96a vdd 0
XBr96a vbpr96a vdd_r96a 0 r1_cmp3_bias rbw=1u rbl=65u
Vpr96ah ipr96ah 0 0.6001
Vnr96ah inr96ah 0 0.5999
Xr96ah ipr96ah inr96ah clk clkb opr96ah onr96ah vbpr96a vdd_r96a 0 r1_cmp3 wcap=96u
Vpr96am ipr96am 0 0.3501
Vnr96am inr96am 0 0.3499
Xr96am ipr96am inr96am clk clkb opr96am onr96am vbpr96a vdd_r96a 0 r1_cmp3 wcap=96u
Vpr96al ipr96al 0 0.1001
Vnr96al inr96al 0 0.0999
Xr96al ipr96al inr96al clk clkb opr96al onr96al vbpr96a vdd_r96a 0 r1_cmp3 wcap=96u
V_r96b vdd_r96b vdd 0
XBr96b vbpr96b vdd_r96b 0 r1_cmp3_bias rbw=1u rbl=75u
Vpr96bh ipr96bh 0 0.6001
Vnr96bh inr96bh 0 0.5999
Xr96bh ipr96bh inr96bh clk clkb opr96bh onr96bh vbpr96b vdd_r96b 0 r1_cmp3 wcap=96u
Vpr96bm ipr96bm 0 0.3501
Vnr96bm inr96bm 0 0.3499
Xr96bm ipr96bm inr96bm clk clkb opr96bm onr96bm vbpr96b vdd_r96b 0 r1_cmp3 wcap=96u
Vpr96bl ipr96bl 0 0.1001
Vnr96bl inr96bl 0 0.0999
Xr96bl ipr96bl inr96bl clk clkb opr96bl onr96bl vbpr96b vdd_r96b 0 r1_cmp3 wcap=96u
V_w64a vdd_w64a vdd 0
XBw64a vbpw64a vdd_w64a 0 r1_cmp3_bias rbw=1u rbl=85u
Vpw64ah ipw64ah 0 0.6001
Vnw64ah inw64ah 0 0.5999
Xw64ah ipw64ah inw64ah clk clkb opw64ah onw64ah vbpw64a vdd_w64a 0 r1_cmp3 wcap=64u wi=64u ngi=16
Vpw64am ipw64am 0 0.3501
Vnw64am inw64am 0 0.3499
Xw64am ipw64am inw64am clk clkb opw64am onw64am vbpw64a vdd_w64a 0 r1_cmp3 wcap=64u wi=64u ngi=16
Vpw64al ipw64al 0 0.1001
Vnw64al inw64al 0 0.0999
Xw64al ipw64al inw64al clk clkb opw64al onw64al vbpw64a vdd_w64a 0 r1_cmp3 wcap=64u wi=64u ngi=16
V_w64b vdd_w64b vdd 0
XBw64b vbpw64b vdd_w64b 0 r1_cmp3_bias rbw=1u rbl=75u
Vpw64bh ipw64bh 0 0.6001
Vnw64bh inw64bh 0 0.5999
Xw64bh ipw64bh inw64bh clk clkb opw64bh onw64bh vbpw64b vdd_w64b 0 r1_cmp3 wcap=80u wi=64u ngi=16
Vpw64bm ipw64bm 0 0.3501
Vnw64bm inw64bm 0 0.3499
Xw64bm ipw64bm inw64bm clk clkb opw64bm onw64bm vbpw64b vdd_w64b 0 r1_cmp3 wcap=80u wi=64u ngi=16
Vpw64bl ipw64bl 0 0.1001
Vnw64bl inw64bl 0 0.0999
Xw64bl ipw64bl inw64bl clk clkb opw64bl onw64bl vbpw64b vdd_w64b 0 r1_cmp3 wcap=80u wi=64u ngi=16
.control
set num_threads=1
save v(vbpr80a) v(opr80ah) v(onr80ah) v(xr80ah.dip) v(xr80ah.din) v(opr80am) v(onr80am) v(xr80am.dip) v(xr80am.din) v(opr80al) v(onr80al) v(xr80al.dip) v(xr80al.din) i(v_r80a) v(vbpr80b) v(opr80bh) v(onr80bh) v(xr80bh.dip) v(xr80bh.din) v(opr80bm) v(onr80bm) v(xr80bm.dip) v(xr80bm.din) v(opr80bl) v(onr80bl) v(xr80bl.dip) v(xr80bl.din) i(v_r80b) v(vbpr96a) v(opr96ah) v(onr96ah) v(xr96ah.dip) v(xr96ah.din) v(opr96am) v(onr96am) v(xr96am.dip) v(xr96am.din) v(opr96al) v(onr96al) v(xr96al.dip) v(xr96al.din) i(v_r96a) v(vbpr96b) v(opr96bh) v(onr96bh) v(xr96bh.dip) v(xr96bh.din) v(opr96bm) v(onr96bm) v(xr96bm.dip) v(xr96bm.din) v(opr96bl) v(onr96bl) v(xr96bl.dip) v(xr96bl.din) i(v_r96b) v(vbpw64a) v(opw64ah) v(onw64ah) v(xw64ah.dip) v(xw64ah.din) v(opw64am) v(onw64am) v(xw64am.dip) v(xw64am.din) v(opw64al) v(onw64al) v(xw64al.dip) v(xw64al.din) i(v_w64a) v(vbpw64b) v(opw64bh) v(onw64bh) v(xw64bh.dip) v(xw64bh.din) v(opw64bm) v(onw64bm) v(xw64bm.dip) v(xw64bm.din) v(opw64bl) v(onw64bl) v(xw64bl.dip) v(xw64bl.din) i(v_w64b) v(clk) i(vdd)
tran 5p 70n 0 20p
write <G1_RESULTS_ROOT>/r1_adc/r3-cmp-tran-ffm40-c/cmp_tran.raw
.endc
.end
