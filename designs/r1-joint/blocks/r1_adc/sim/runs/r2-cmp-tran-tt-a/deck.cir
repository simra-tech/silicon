* tb_cmp2_tran.cir (generated by sim/r2/gen_cmp_decks.py) -- r1_cmp2 variants, decision dynamics
.lib /foss/pdks/ihp-sg13g2/libs.tech/ngspice/models/cornerMOSlv.lib mos_tt
.lib /foss/pdks/ihp-sg13g2/libs.tech/ngspice/models/cornerCAP.lib cap_typ
.lib /foss/pdks/ihp-sg13g2/libs.tech/ngspice/models/cornerMOShv.lib mos_tt
.lib /foss/pdks/ihp-sg13g2/libs.tech/ngspice/models/cornerRES.lib res_typ
.include schematic/r1_adc_r2.spice
.temp 27
.option reltol=1e-4 vntol=1e-7 abstol=1e-13 method=gear
Vdd vdd 0 1.2
Vclk clk 0 PULSE(0 1.2 2n 50p 50p 16.6167n 33.3333n)
Vclkb clkb 0 PULSE(1.2 0 2n 50p 50p 16.6167n 33.3333n)
VpV0h ipV0h 0 0.6001
VnV0h inV0h 0 0.5999
XV0h ipV0h inV0h clk clkb opV0h onV0h vdd 0 r1_cmp2 wi=16u li=0.2u ngi=4 wt=8u wcap=0.15u lcap=0.13u wr=1u
VpV0l ipV0l 0 0.1001
VnV0l inV0l 0 0.0999
XV0l ipV0l inV0l clk clkb opV0l onV0l vdd 0 r1_cmp2 wi=16u li=0.2u ngi=4 wt=8u wcap=0.15u lcap=0.13u wr=1u
VpV1h ipV1h 0 0.6001
VnV1h inV1h 0 0.5999
XV1h ipV1h inV1h clk clkb opV1h onV1h vdd 0 r1_cmp2 wi=48u li=0.3u ngi=12 wt=16u wcap=12u lcap=4u wr=2u
VpV1l ipV1l 0 0.1001
VnV1l inV1l 0 0.0999
XV1l ipV1l inV1l clk clkb opV1l onV1l vdd 0 r1_cmp2 wi=48u li=0.3u ngi=12 wt=16u wcap=12u lcap=4u wr=2u
VpV2h ipV2h 0 0.6001
VnV2h inV2h 0 0.5999
XV2h ipV2h inV2h clk clkb opV2h onV2h vdd 0 r1_cmp2 wi=48u li=0.3u ngi=12 wt=16u wcap=6u lcap=4u wr=2u
VpV2l ipV2l 0 0.1001
VnV2l inV2l 0 0.0999
XV2l ipV2l inV2l clk clkb opV2l onV2l vdd 0 r1_cmp2 wi=48u li=0.3u ngi=12 wt=16u wcap=6u lcap=4u wr=2u
VpV3h ipV3h 0 0.6001
VnV3h inV3h 0 0.5999
XV3h ipV3h inV3h clk clkb opV3h onV3h vdd 0 r1_cmp2 wi=32u li=0.3u ngi=8 wt=16u wcap=8u lcap=4u wr=2u
VpV3l ipV3l 0 0.1001
VnV3l inV3l 0 0.0999
XV3l ipV3l inV3l clk clkb opV3l onV3l vdd 0 r1_cmp2 wi=32u li=0.3u ngi=8 wt=16u wcap=8u lcap=4u wr=2u
.control
set num_threads=1
save v(opV0h) v(onV0h) v(xV0h.dip) v(xV0h.din) v(opV0l) v(onV0l) v(xV0l.dip) v(xV0l.din) v(opV1h) v(onV1h) v(xV1h.dip) v(xV1h.din) v(opV1l) v(onV1l) v(xV1l.dip) v(xV1l.din) v(opV2h) v(onV2h) v(xV2h.dip) v(xV2h.din) v(opV2l) v(onV2l) v(xV2l.dip) v(xV2l.din) v(opV3h) v(onV3h) v(xV3h.dip) v(xV3h.din) v(opV3l) v(onV3l) v(xV3l.dip) v(xV3l.din) v(clk) i(vdd)
tran 5p 100n 0 20p
write <G1_RESULTS_ROOT>/r1_adc/r2-cmp-tran-tt-a/cmp_tran.raw
.endc
.end
