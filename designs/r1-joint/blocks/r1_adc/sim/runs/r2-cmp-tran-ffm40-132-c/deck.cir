* tb_cmp2_tran.cir (generated by sim/r2/gen_cmp_decks.py) -- r1_cmp2 variants, decision dynamics
.lib /foss/pdks/ihp-sg13g2/libs.tech/ngspice/models/cornerMOSlv.lib mos_ff
.lib /foss/pdks/ihp-sg13g2/libs.tech/ngspice/models/cornerCAP.lib cap_typ
.lib /foss/pdks/ihp-sg13g2/libs.tech/ngspice/models/cornerMOShv.lib mos_ff
.lib /foss/pdks/ihp-sg13g2/libs.tech/ngspice/models/cornerRES.lib res_typ
.include schematic/r1_adc_r2.spice
.temp -40
.option reltol=1e-4 vntol=1e-7 abstol=1e-13 method=gear
Vdd vdd 0 1.32
Vclk clk 0 PULSE(0 1.32 2n 50p 50p 16.6167n 33.3333n)
Vclkb clkb 0 PULSE(1.32 0 2n 50p 50p 16.6167n 33.3333n)
XB vbp vdd 0 r1_cmp2_bias ib=14u
VpBh ipBh 0 0.6001
VnBh inBh 0 0.5999
XBh ipBh inBh clk clkb opBh onBh vbp vdd 0 r1_cmp2 wi=48u li=0.3u ngi=12 wt=16u wtc=8u ltc=0.5u wcap=8u lcap=4u wr=2u wh=8u
VpBm ipBm 0 0.3501
VnBm inBm 0 0.3499
XBm ipBm inBm clk clkb opBm onBm vbp vdd 0 r1_cmp2 wi=48u li=0.3u ngi=12 wt=16u wtc=8u ltc=0.5u wcap=8u lcap=4u wr=2u wh=8u
VpBl ipBl 0 0.1001
VnBl inBl 0 0.0999
XBl ipBl inBl clk clkb opBl onBl vbp vdd 0 r1_cmp2 wi=48u li=0.3u ngi=12 wt=16u wtc=8u ltc=0.5u wcap=8u lcap=4u wr=2u wh=8u
VpEh ipEh 0 0.6001
VnEh inEh 0 0.5999
XEh ipEh inEh clk clkb opEh onEh vbp vdd 0 r1_cmp2 wi=96u li=0.25u ngi=16 wt=16u wtc=8u ltc=0.5u wcap=8u lcap=4u wr=2u wh=8u
VpEm ipEm 0 0.3501
VnEm inEm 0 0.3499
XEm ipEm inEm clk clkb opEm onEm vbp vdd 0 r1_cmp2 wi=96u li=0.25u ngi=16 wt=16u wtc=8u ltc=0.5u wcap=8u lcap=4u wr=2u wh=8u
VpEl ipEl 0 0.1001
VnEl inEl 0 0.0999
XEl ipEl inEl clk clkb opEl onEl vbp vdd 0 r1_cmp2 wi=96u li=0.25u ngi=16 wt=16u wtc=8u ltc=0.5u wcap=8u lcap=4u wr=2u wh=8u
VpFh ipFh 0 0.6001
VnFh inFh 0 0.5999
XFh ipFh inFh clk clkb opFh onFh vbp vdd 0 r1_cmp2 wi=128u li=0.25u ngi=16 wt=16u wtc=8u ltc=0.5u wcap=8u lcap=4u wr=2u wh=8u
VpFm ipFm 0 0.3501
VnFm inFm 0 0.3499
XFm ipFm inFm clk clkb opFm onFm vbp vdd 0 r1_cmp2 wi=128u li=0.25u ngi=16 wt=16u wtc=8u ltc=0.5u wcap=8u lcap=4u wr=2u wh=8u
VpFl ipFl 0 0.1001
VnFl inFl 0 0.0999
XFl ipFl inFl clk clkb opFl onFl vbp vdd 0 r1_cmp2 wi=128u li=0.25u ngi=16 wt=16u wtc=8u ltc=0.5u wcap=8u lcap=4u wr=2u wh=8u
VpGh ipGh 0 0.6001
VnGh inGh 0 0.5999
XGh ipGh inGh clk clkb opGh onGh vbp vdd 0 r1_cmp2 wi=64u li=0.3u ngi=16 wt=16u wtc=8u ltc=0.5u wcap=8u lcap=4u wr=2u wh=8u
VpGm ipGm 0 0.3501
VnGm inGm 0 0.3499
XGm ipGm inGm clk clkb opGm onGm vbp vdd 0 r1_cmp2 wi=64u li=0.3u ngi=16 wt=16u wtc=8u ltc=0.5u wcap=8u lcap=4u wr=2u wh=8u
VpGl ipGl 0 0.1001
VnGl inGl 0 0.0999
XGl ipGl inGl clk clkb opGl onGl vbp vdd 0 r1_cmp2 wi=64u li=0.3u ngi=16 wt=16u wtc=8u ltc=0.5u wcap=8u lcap=4u wr=2u wh=8u
VpHh ipHh 0 0.6001
VnHh inHh 0 0.5999
XHh ipHh inHh clk clkb opHh onHh vbp vdd 0 r1_cmp2 wi=96u li=0.25u ngi=16 wt=16u wtc=8u ltc=0.5u wcap=12u lcap=4u wr=2u wh=8u
VpHm ipHm 0 0.3501
VnHm inHm 0 0.3499
XHm ipHm inHm clk clkb opHm onHm vbp vdd 0 r1_cmp2 wi=96u li=0.25u ngi=16 wt=16u wtc=8u ltc=0.5u wcap=12u lcap=4u wr=2u wh=8u
VpHl ipHl 0 0.1001
VnHl inHl 0 0.0999
XHl ipHl inHl clk clkb opHl onHl vbp vdd 0 r1_cmp2 wi=96u li=0.25u ngi=16 wt=16u wtc=8u ltc=0.5u wcap=12u lcap=4u wr=2u wh=8u
.control
set num_threads=1
save v(opBh) v(onBh) v(xBh.dip) v(xBh.din) v(opBm) v(onBm) v(xBm.dip) v(xBm.din) v(opBl) v(onBl) v(xBl.dip) v(xBl.din) v(opEh) v(onEh) v(xEh.dip) v(xEh.din) v(opEm) v(onEm) v(xEm.dip) v(xEm.din) v(opEl) v(onEl) v(xEl.dip) v(xEl.din) v(opFh) v(onFh) v(xFh.dip) v(xFh.din) v(opFm) v(onFm) v(xFm.dip) v(xFm.din) v(opFl) v(onFl) v(xFl.dip) v(xFl.din) v(opGh) v(onGh) v(xGh.dip) v(xGh.din) v(opGm) v(onGm) v(xGm.dip) v(xGm.din) v(opGl) v(onGl) v(xGl.dip) v(xGl.din) v(opHh) v(onHh) v(xHh.dip) v(xHh.din) v(opHm) v(onHm) v(xHm.dip) v(xHm.din) v(opHl) v(onHl) v(xHl.dip) v(xHl.din) v(clk) i(vdd)
tran 5p 100n 0 20p
write <G1_RESULTS_ROOT>/r1_adc/r2-cmp-tran-ffm40-132-c/cmp_tran.raw
.endc
.end
