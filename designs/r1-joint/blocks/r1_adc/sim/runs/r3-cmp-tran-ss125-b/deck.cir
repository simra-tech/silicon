* tb_cmp3_tran.cir (generated by sim/r3/gen_cmp3_decks.py) -- r1_cmp3 variants, decision dynamics, rev-3 clock
.lib /foss/pdks/ihp-sg13g2/libs.tech/ngspice/models/cornerMOSlv.lib mos_ss
.lib /foss/pdks/ihp-sg13g2/libs.tech/ngspice/models/cornerCAP.lib cap_typ
.lib /foss/pdks/ihp-sg13g2/libs.tech/ngspice/models/cornerRES.lib res_typ
.include schematic/r1_adc_r3.spice
.temp 125
.option reltol=1e-4 vntol=1e-7 abstol=1e-13 method=gear
Vdd vdd 0 1.08
Vclk clk 0 PULSE(0 1.08 1n 50p 50p 13.45n 16.6667n)
Vclkb clkb 0 PULSE(1.08 0 1n 50p 50p 13.45n 16.6667n)
V_r56a vdd_r56a vdd 0
XBr56a vbpr56a vdd_r56a 0 r1_cmp3_bias rbw=1u rbl=100u
Vpr56ah ipr56ah 0 0.6001
Vnr56ah inr56ah 0 0.5999
Xr56ah ipr56ah inr56ah clk clkb opr56ah onr56ah vbpr56a vdd_r56a 0 r1_cmp3 wcap=56u
Vpr56am ipr56am 0 0.3501
Vnr56am inr56am 0 0.3499
Xr56am ipr56am inr56am clk clkb opr56am onr56am vbpr56a vdd_r56a 0 r1_cmp3 wcap=56u
Vpr56al ipr56al 0 0.1001
Vnr56al inr56al 0 0.0999
Xr56al ipr56al inr56al clk clkb opr56al onr56al vbpr56a vdd_r56a 0 r1_cmp3 wcap=56u
V_r56b vdd_r56b vdd 0
XBr56b vbpr56b vdd_r56b 0 r1_cmp3_bias rbw=1u rbl=115u
Vpr56bh ipr56bh 0 0.6001
Vnr56bh inr56bh 0 0.5999
Xr56bh ipr56bh inr56bh clk clkb opr56bh onr56bh vbpr56b vdd_r56b 0 r1_cmp3 wcap=56u
Vpr56bm ipr56bm 0 0.3501
Vnr56bm inr56bm 0 0.3499
Xr56bm ipr56bm inr56bm clk clkb opr56bm onr56bm vbpr56b vdd_r56b 0 r1_cmp3 wcap=56u
Vpr56bl ipr56bl 0 0.1001
Vnr56bl inr56bl 0 0.0999
Xr56bl ipr56bl inr56bl clk clkb opr56bl onr56bl vbpr56b vdd_r56b 0 r1_cmp3 wcap=56u
V_r56c vdd_r56c vdd 0
XBr56c vbpr56c vdd_r56c 0 r1_cmp3_bias rbw=1u rbl=130u
Vpr56ch ipr56ch 0 0.6001
Vnr56ch inr56ch 0 0.5999
Xr56ch ipr56ch inr56ch clk clkb opr56ch onr56ch vbpr56c vdd_r56c 0 r1_cmp3 wcap=56u
Vpr56cm ipr56cm 0 0.3501
Vnr56cm inr56cm 0 0.3499
Xr56cm ipr56cm inr56cm clk clkb opr56cm onr56cm vbpr56c vdd_r56c 0 r1_cmp3 wcap=56u
Vpr56cl ipr56cl 0 0.1001
Vnr56cl inr56cl 0 0.0999
Xr56cl ipr56cl inr56cl clk clkb opr56cl onr56cl vbpr56c vdd_r56c 0 r1_cmp3 wcap=56u
V_r64a vdd_r64a vdd 0
XBr64a vbpr64a vdd_r64a 0 r1_cmp3_bias rbw=1u rbl=100u
Vpr64ah ipr64ah 0 0.6001
Vnr64ah inr64ah 0 0.5999
Xr64ah ipr64ah inr64ah clk clkb opr64ah onr64ah vbpr64a vdd_r64a 0 r1_cmp3 wcap=64u
Vpr64am ipr64am 0 0.3501
Vnr64am inr64am 0 0.3499
Xr64am ipr64am inr64am clk clkb opr64am onr64am vbpr64a vdd_r64a 0 r1_cmp3 wcap=64u
Vpr64al ipr64al 0 0.1001
Vnr64al inr64al 0 0.0999
Xr64al ipr64al inr64al clk clkb opr64al onr64al vbpr64a vdd_r64a 0 r1_cmp3 wcap=64u
V_r64b vdd_r64b vdd 0
XBr64b vbpr64b vdd_r64b 0 r1_cmp3_bias rbw=1u rbl=115u
Vpr64bh ipr64bh 0 0.6001
Vnr64bh inr64bh 0 0.5999
Xr64bh ipr64bh inr64bh clk clkb opr64bh onr64bh vbpr64b vdd_r64b 0 r1_cmp3 wcap=64u
Vpr64bm ipr64bm 0 0.3501
Vnr64bm inr64bm 0 0.3499
Xr64bm ipr64bm inr64bm clk clkb opr64bm onr64bm vbpr64b vdd_r64b 0 r1_cmp3 wcap=64u
Vpr64bl ipr64bl 0 0.1001
Vnr64bl inr64bl 0 0.0999
Xr64bl ipr64bl inr64bl clk clkb opr64bl onr64bl vbpr64b vdd_r64b 0 r1_cmp3 wcap=64u
V_r64c vdd_r64c vdd 0
XBr64c vbpr64c vdd_r64c 0 r1_cmp3_bias rbw=1u rbl=130u
Vpr64ch ipr64ch 0 0.6001
Vnr64ch inr64ch 0 0.5999
Xr64ch ipr64ch inr64ch clk clkb opr64ch onr64ch vbpr64c vdd_r64c 0 r1_cmp3 wcap=64u
Vpr64cm ipr64cm 0 0.3501
Vnr64cm inr64cm 0 0.3499
Xr64cm ipr64cm inr64cm clk clkb opr64cm onr64cm vbpr64c vdd_r64c 0 r1_cmp3 wcap=64u
Vpr64cl ipr64cl 0 0.1001
Vnr64cl inr64cl 0 0.0999
Xr64cl ipr64cl inr64cl clk clkb opr64cl onr64cl vbpr64c vdd_r64c 0 r1_cmp3 wcap=64u
.control
set num_threads=1
save v(vbpr56a) v(opr56ah) v(onr56ah) v(xr56ah.dip) v(xr56ah.din) v(opr56am) v(onr56am) v(xr56am.dip) v(xr56am.din) v(opr56al) v(onr56al) v(xr56al.dip) v(xr56al.din) i(v_r56a) v(vbpr56b) v(opr56bh) v(onr56bh) v(xr56bh.dip) v(xr56bh.din) v(opr56bm) v(onr56bm) v(xr56bm.dip) v(xr56bm.din) v(opr56bl) v(onr56bl) v(xr56bl.dip) v(xr56bl.din) i(v_r56b) v(vbpr56c) v(opr56ch) v(onr56ch) v(xr56ch.dip) v(xr56ch.din) v(opr56cm) v(onr56cm) v(xr56cm.dip) v(xr56cm.din) v(opr56cl) v(onr56cl) v(xr56cl.dip) v(xr56cl.din) i(v_r56c) v(vbpr64a) v(opr64ah) v(onr64ah) v(xr64ah.dip) v(xr64ah.din) v(opr64am) v(onr64am) v(xr64am.dip) v(xr64am.din) v(opr64al) v(onr64al) v(xr64al.dip) v(xr64al.din) i(v_r64a) v(vbpr64b) v(opr64bh) v(onr64bh) v(xr64bh.dip) v(xr64bh.din) v(opr64bm) v(onr64bm) v(xr64bm.dip) v(xr64bm.din) v(opr64bl) v(onr64bl) v(xr64bl.dip) v(xr64bl.din) i(v_r64b) v(vbpr64c) v(opr64ch) v(onr64ch) v(xr64ch.dip) v(xr64ch.din) v(opr64cm) v(onr64cm) v(xr64cm.dip) v(xr64cm.din) v(opr64cl) v(onr64cl) v(xr64cl.dip) v(xr64cl.din) i(v_r64c) v(clk) i(vdd)
tran 5p 70n 0 20p
write <G1_RESULTS_ROOT>/r1_adc/r3-cmp-tran-ss125-b/cmp_tran.raw
.endc
.end
