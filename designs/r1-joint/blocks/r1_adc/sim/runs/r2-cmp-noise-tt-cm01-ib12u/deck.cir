* tb_cmp2_noise.cir (generated by sim/r2/gen_cmp_decks.py) -- r1_cmp2 first stage, quasi-static noise
.lib /foss/pdks/ihp-sg13g2/libs.tech/ngspice/models/cornerMOSlv.lib mos_tt
.lib /foss/pdks/ihp-sg13g2/libs.tech/ngspice/models/cornerCAP.lib cap_typ
.lib /foss/pdks/ihp-sg13g2/libs.tech/ngspice/models/cornerMOShv.lib mos_tt
.lib /foss/pdks/ihp-sg13g2/libs.tech/ngspice/models/cornerRES.lib res_typ
.include schematic/r1_adc_r2.spice
.temp 27
Vdd vdd 0 1.2
Vclkb clkb 0 0
Vx vx 0 0.3
Vinp inp 0 DC 0.1 AC 1
Vinn inn 0 DC 0.1
XB vbp vdd 0 r1_cmp2_bias ib=12u
XA inp inn dpA dnA clkb vbp vdd 0 r1_cmp2_s1 wi=48u li=0.3u ngi=12 wt=16u wtc=8u ltc=0.5u
VdpA dpA vx 0
VdnA dnA vx 0
HA outA 0 poly(2) VdpA VdnA 0 1 -1
XB inp inn dpB dnB clkb vbp vdd 0 r1_cmp2_s1 wi=48u li=0.3u ngi=12 wt=16u wtc=8u ltc=0.5u
VdpB dpB vx 0
VdnB dnB vx 0
HB outB 0 poly(2) VdpB VdnB 0 1 -1
XC inp inn dpC dnC clkb vbp vdd 0 r1_cmp2_s1 wi=48u li=0.3u ngi=12 wt=16u wtc=8u ltc=0.5u
VdpC dpC vx 0
VdnC dnC vx 0
HC outC 0 poly(2) VdpC VdnC 0 1 -1
XD inp inn dpD dnD clkb vbp vdd 0 r1_cmp2_s1 wi=64u li=0.3u ngi=16 wt=16u wtc=8u ltc=0.5u
VdpD dpD vx 0
VdnD dnD vx 0
HD outD 0 poly(2) VdpD VdnD 0 1 -1
.control
set num_threads=1
set wr_singlescale
set wr_vecnames
op
print i(vdpA) i(vdnA)
noise v(outA) vinp dec 20 1e3 1e11
setplot noise1
wrdata <G1_RESULTS_ROOT>/r1_adc/r2-cmp-noise-tt-cm01-ib12u/noise_A.txt inoise_spectrum onoise_spectrum
destroy all
reset
op
print i(vdpB) i(vdnB)
noise v(outB) vinp dec 20 1e3 1e11
setplot noise1
wrdata <G1_RESULTS_ROOT>/r1_adc/r2-cmp-noise-tt-cm01-ib12u/noise_B.txt inoise_spectrum onoise_spectrum
destroy all
reset
op
print i(vdpC) i(vdnC)
noise v(outC) vinp dec 20 1e3 1e11
setplot noise1
wrdata <G1_RESULTS_ROOT>/r1_adc/r2-cmp-noise-tt-cm01-ib12u/noise_C.txt inoise_spectrum onoise_spectrum
destroy all
reset
op
print i(vdpD) i(vdnD)
noise v(outD) vinp dec 20 1e3 1e11
setplot noise1
wrdata <G1_RESULTS_ROOT>/r1_adc/r2-cmp-noise-tt-cm01-ib12u/noise_D.txt inoise_spectrum onoise_spectrum
destroy all
reset
.endc
.end
