* tb_cmp3_noise.cir (generated by sim/r3/gen_cmp3_decks.py) -- r1_cmp3 first stage, quasi-static noise
.lib /foss/pdks/ihp-sg13g2/libs.tech/ngspice/models/cornerMOSlv.lib mos_ff
.lib /foss/pdks/ihp-sg13g2/libs.tech/ngspice/models/cornerCAP.lib cap_typ
.lib /foss/pdks/ihp-sg13g2/libs.tech/ngspice/models/cornerRES.lib res_typ
.include schematic/r1_adc_r3.spice
.temp -40
Vdd vdd 0 1.32
Vclkb clkb 0 0
Vx vx 0 0.3
XBr80a vbpr80a vdd 0 r1_cmp3_bias rbw=1u rbl=75u
Vinpr80a inpr80a 0 DC 0.1 AC 1
Vinnr80a innr80a 0 DC 0.1
Xr80a inpr80a innr80a dpr80a dnr80a clkb vbpr80a vdd 0 r1_cmp3_s1
Vdpr80a dpr80a vx 0
Vdnr80a dnr80a vx 0
Hr80a outr80a 0 poly(2) Vdpr80a Vdnr80a 0 1 -1
XBr80b vbpr80b vdd 0 r1_cmp3_bias rbw=1u rbl=85u
Vinpr80b inpr80b 0 DC 0.1 AC 1
Vinnr80b innr80b 0 DC 0.1
Xr80b inpr80b innr80b dpr80b dnr80b clkb vbpr80b vdd 0 r1_cmp3_s1
Vdpr80b dpr80b vx 0
Vdnr80b dnr80b vx 0
Hr80b outr80b 0 poly(2) Vdpr80b Vdnr80b 0 1 -1
XBr96a vbpr96a vdd 0 r1_cmp3_bias rbw=1u rbl=65u
Vinpr96a inpr96a 0 DC 0.1 AC 1
Vinnr96a innr96a 0 DC 0.1
Xr96a inpr96a innr96a dpr96a dnr96a clkb vbpr96a vdd 0 r1_cmp3_s1
Vdpr96a dpr96a vx 0
Vdnr96a dnr96a vx 0
Hr96a outr96a 0 poly(2) Vdpr96a Vdnr96a 0 1 -1
XBr96b vbpr96b vdd 0 r1_cmp3_bias rbw=1u rbl=75u
Vinpr96b inpr96b 0 DC 0.1 AC 1
Vinnr96b innr96b 0 DC 0.1
Xr96b inpr96b innr96b dpr96b dnr96b clkb vbpr96b vdd 0 r1_cmp3_s1
Vdpr96b dpr96b vx 0
Vdnr96b dnr96b vx 0
Hr96b outr96b 0 poly(2) Vdpr96b Vdnr96b 0 1 -1
XBw64a vbpw64a vdd 0 r1_cmp3_bias rbw=1u rbl=85u
Vinpw64a inpw64a 0 DC 0.1 AC 1
Vinnw64a innw64a 0 DC 0.1
Xw64a inpw64a innw64a dpw64a dnw64a clkb vbpw64a vdd 0 r1_cmp3_s1 wi=64u ngi=16
Vdpw64a dpw64a vx 0
Vdnw64a dnw64a vx 0
Hw64a outw64a 0 poly(2) Vdpw64a Vdnw64a 0 1 -1
XBw64b vbpw64b vdd 0 r1_cmp3_bias rbw=1u rbl=75u
Vinpw64b inpw64b 0 DC 0.1 AC 1
Vinnw64b innw64b 0 DC 0.1
Xw64b inpw64b innw64b dpw64b dnw64b clkb vbpw64b vdd 0 r1_cmp3_s1 wi=64u ngi=16
Vdpw64b dpw64b vx 0
Vdnw64b dnw64b vx 0
Hw64b outw64b 0 poly(2) Vdpw64b Vdnw64b 0 1 -1
.control
set num_threads=1
set wr_singlescale
set wr_vecnames
op
print i(vdpr80a) i(vdnr80a) v(vbpr80a)
noise v(outr80a) vinpr80a dec 20 1e3 1e11
setplot noise1
wrdata <G1_RESULTS_ROOT>/r1_adc/r3-cmp-noise-ffm40-cm01-c/noise_r80a.txt inoise_spectrum onoise_spectrum
destroy all
reset
op
print i(vdpr80b) i(vdnr80b) v(vbpr80b)
noise v(outr80b) vinpr80b dec 20 1e3 1e11
setplot noise1
wrdata <G1_RESULTS_ROOT>/r1_adc/r3-cmp-noise-ffm40-cm01-c/noise_r80b.txt inoise_spectrum onoise_spectrum
destroy all
reset
op
print i(vdpr96a) i(vdnr96a) v(vbpr96a)
noise v(outr96a) vinpr96a dec 20 1e3 1e11
setplot noise1
wrdata <G1_RESULTS_ROOT>/r1_adc/r3-cmp-noise-ffm40-cm01-c/noise_r96a.txt inoise_spectrum onoise_spectrum
destroy all
reset
op
print i(vdpr96b) i(vdnr96b) v(vbpr96b)
noise v(outr96b) vinpr96b dec 20 1e3 1e11
setplot noise1
wrdata <G1_RESULTS_ROOT>/r1_adc/r3-cmp-noise-ffm40-cm01-c/noise_r96b.txt inoise_spectrum onoise_spectrum
destroy all
reset
op
print i(vdpw64a) i(vdnw64a) v(vbpw64a)
noise v(outw64a) vinpw64a dec 20 1e3 1e11
setplot noise1
wrdata <G1_RESULTS_ROOT>/r1_adc/r3-cmp-noise-ffm40-cm01-c/noise_w64a.txt inoise_spectrum onoise_spectrum
destroy all
reset
op
print i(vdpw64b) i(vdnw64b) v(vbpw64b)
noise v(outw64b) vinpw64b dec 20 1e3 1e11
setplot noise1
wrdata <G1_RESULTS_ROOT>/r1_adc/r3-cmp-noise-ffm40-cm01-c/noise_w64b.txt inoise_spectrum onoise_spectrum
destroy all
reset
.endc
.end
