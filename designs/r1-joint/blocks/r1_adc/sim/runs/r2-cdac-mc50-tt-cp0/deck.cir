* tb_cdac2_mc.cir (generated by sim/r2/gen_tb_cdac2_mc.py) -- revision-2 CDAC mismatch MC, 50 samples x 2 sides
.lib /foss/pdks/ihp-sg13g2/libs.tech/ngspice/models/cornerCAP.lib cap_typ_mismatch
.include schematic/r1_adc_r2.spice
Vb11 b11 0 DC 0 AC 0
Vb10 b10 0 DC 0 AC 0
Vb9 b9 0 DC 0 AC 0
Vb8 b8 0 DC 0 AC 0
Vb7 b7 0 DC 0 AC 0
Vb6 b6 0 DC 0 AC 0
Vb5 b5 0 DC 0 AC 0
Vb4 b4 0 DC 0 AC 0
Vb3 b3 0 DC 0 AC 0
Vb2 b2 0 DC 0 AC 0
Vb1 b1 0 DC 0 AC 0
Vb0 b0 0 DC 0 AC 0
Xp0 tp0 lp0 b11 b10 b9 b8 b7 b6 b5 b4 b3 b2 b1 b0 r1_cdac2_side_mc mm=1
Rpt0 tp0 0 1e15
Rpl0 lp0 0 1e15
Cppar0 tp0 0 0.001f
Cpplsb0 lp0 0 0.001f
Xn0 tn0 ln0 b11 b10 b9 b8 b7 b6 b5 b4 b3 b2 b1 b0 r1_cdac2_side_mc mm=1
Rnt0 tn0 0 1e15
Rnl0 ln0 0 1e15
Cnpar0 tn0 0 0.001f
Cnplsb0 ln0 0 0.001f
Xp1 tp1 lp1 b11 b10 b9 b8 b7 b6 b5 b4 b3 b2 b1 b0 r1_cdac2_side_mc mm=1
Rpt1 tp1 0 1e15
Rpl1 lp1 0 1e15
Cppar1 tp1 0 0.001f
Cpplsb1 lp1 0 0.001f
Xn1 tn1 ln1 b11 b10 b9 b8 b7 b6 b5 b4 b3 b2 b1 b0 r1_cdac2_side_mc mm=1
Rnt1 tn1 0 1e15
Rnl1 ln1 0 1e15
Cnpar1 tn1 0 0.001f
Cnplsb1 ln1 0 0.001f
Xp2 tp2 lp2 b11 b10 b9 b8 b7 b6 b5 b4 b3 b2 b1 b0 r1_cdac2_side_mc mm=1
Rpt2 tp2 0 1e15
Rpl2 lp2 0 1e15
Cppar2 tp2 0 0.001f
Cpplsb2 lp2 0 0.001f
Xn2 tn2 ln2 b11 b10 b9 b8 b7 b6 b5 b4 b3 b2 b1 b0 r1_cdac2_side_mc mm=1
Rnt2 tn2 0 1e15
Rnl2 ln2 0 1e15
Cnpar2 tn2 0 0.001f
Cnplsb2 ln2 0 0.001f
Xp3 tp3 lp3 b11 b10 b9 b8 b7 b6 b5 b4 b3 b2 b1 b0 r1_cdac2_side_mc mm=1
Rpt3 tp3 0 1e15
Rpl3 lp3 0 1e15
Cppar3 tp3 0 0.001f
Cpplsb3 lp3 0 0.001f
Xn3 tn3 ln3 b11 b10 b9 b8 b7 b6 b5 b4 b3 b2 b1 b0 r1_cdac2_side_mc mm=1
Rnt3 tn3 0 1e15
Rnl3 ln3 0 1e15
Cnpar3 tn3 0 0.001f
Cnplsb3 ln3 0 0.001f
Xp4 tp4 lp4 b11 b10 b9 b8 b7 b6 b5 b4 b3 b2 b1 b0 r1_cdac2_side_mc mm=1
Rpt4 tp4 0 1e15
Rpl4 lp4 0 1e15
Cppar4 tp4 0 0.001f
Cpplsb4 lp4 0 0.001f
Xn4 tn4 ln4 b11 b10 b9 b8 b7 b6 b5 b4 b3 b2 b1 b0 r1_cdac2_side_mc mm=1
Rnt4 tn4 0 1e15
Rnl4 ln4 0 1e15
Cnpar4 tn4 0 0.001f
Cnplsb4 ln4 0 0.001f
Xp5 tp5 lp5 b11 b10 b9 b8 b7 b6 b5 b4 b3 b2 b1 b0 r1_cdac2_side_mc mm=1
Rpt5 tp5 0 1e15
Rpl5 lp5 0 1e15
Cppar5 tp5 0 0.001f
Cpplsb5 lp5 0 0.001f
Xn5 tn5 ln5 b11 b10 b9 b8 b7 b6 b5 b4 b3 b2 b1 b0 r1_cdac2_side_mc mm=1
Rnt5 tn5 0 1e15
Rnl5 ln5 0 1e15
Cnpar5 tn5 0 0.001f
Cnplsb5 ln5 0 0.001f
Xp6 tp6 lp6 b11 b10 b9 b8 b7 b6 b5 b4 b3 b2 b1 b0 r1_cdac2_side_mc mm=1
Rpt6 tp6 0 1e15
Rpl6 lp6 0 1e15
Cppar6 tp6 0 0.001f
Cpplsb6 lp6 0 0.001f
Xn6 tn6 ln6 b11 b10 b9 b8 b7 b6 b5 b4 b3 b2 b1 b0 r1_cdac2_side_mc mm=1
Rnt6 tn6 0 1e15
Rnl6 ln6 0 1e15
Cnpar6 tn6 0 0.001f
Cnplsb6 ln6 0 0.001f
Xp7 tp7 lp7 b11 b10 b9 b8 b7 b6 b5 b4 b3 b2 b1 b0 r1_cdac2_side_mc mm=1
Rpt7 tp7 0 1e15
Rpl7 lp7 0 1e15
Cppar7 tp7 0 0.001f
Cpplsb7 lp7 0 0.001f
Xn7 tn7 ln7 b11 b10 b9 b8 b7 b6 b5 b4 b3 b2 b1 b0 r1_cdac2_side_mc mm=1
Rnt7 tn7 0 1e15
Rnl7 ln7 0 1e15
Cnpar7 tn7 0 0.001f
Cnplsb7 ln7 0 0.001f
Xp8 tp8 lp8 b11 b10 b9 b8 b7 b6 b5 b4 b3 b2 b1 b0 r1_cdac2_side_mc mm=1
Rpt8 tp8 0 1e15
Rpl8 lp8 0 1e15
Cppar8 tp8 0 0.001f
Cpplsb8 lp8 0 0.001f
Xn8 tn8 ln8 b11 b10 b9 b8 b7 b6 b5 b4 b3 b2 b1 b0 r1_cdac2_side_mc mm=1
Rnt8 tn8 0 1e15
Rnl8 ln8 0 1e15
Cnpar8 tn8 0 0.001f
Cnplsb8 ln8 0 0.001f
Xp9 tp9 lp9 b11 b10 b9 b8 b7 b6 b5 b4 b3 b2 b1 b0 r1_cdac2_side_mc mm=1
Rpt9 tp9 0 1e15
Rpl9 lp9 0 1e15
Cppar9 tp9 0 0.001f
Cpplsb9 lp9 0 0.001f
Xn9 tn9 ln9 b11 b10 b9 b8 b7 b6 b5 b4 b3 b2 b1 b0 r1_cdac2_side_mc mm=1
Rnt9 tn9 0 1e15
Rnl9 ln9 0 1e15
Cnpar9 tn9 0 0.001f
Cnplsb9 ln9 0 0.001f
Xp10 tp10 lp10 b11 b10 b9 b8 b7 b6 b5 b4 b3 b2 b1 b0 r1_cdac2_side_mc mm=1
Rpt10 tp10 0 1e15
Rpl10 lp10 0 1e15
Cppar10 tp10 0 0.001f
Cpplsb10 lp10 0 0.001f
Xn10 tn10 ln10 b11 b10 b9 b8 b7 b6 b5 b4 b3 b2 b1 b0 r1_cdac2_side_mc mm=1
Rnt10 tn10 0 1e15
Rnl10 ln10 0 1e15
Cnpar10 tn10 0 0.001f
Cnplsb10 ln10 0 0.001f
Xp11 tp11 lp11 b11 b10 b9 b8 b7 b6 b5 b4 b3 b2 b1 b0 r1_cdac2_side_mc mm=1
Rpt11 tp11 0 1e15
Rpl11 lp11 0 1e15
Cppar11 tp11 0 0.001f
Cpplsb11 lp11 0 0.001f
Xn11 tn11 ln11 b11 b10 b9 b8 b7 b6 b5 b4 b3 b2 b1 b0 r1_cdac2_side_mc mm=1
Rnt11 tn11 0 1e15
Rnl11 ln11 0 1e15
Cnpar11 tn11 0 0.001f
Cnplsb11 ln11 0 0.001f
Xp12 tp12 lp12 b11 b10 b9 b8 b7 b6 b5 b4 b3 b2 b1 b0 r1_cdac2_side_mc mm=1
Rpt12 tp12 0 1e15
Rpl12 lp12 0 1e15
Cppar12 tp12 0 0.001f
Cpplsb12 lp12 0 0.001f
Xn12 tn12 ln12 b11 b10 b9 b8 b7 b6 b5 b4 b3 b2 b1 b0 r1_cdac2_side_mc mm=1
Rnt12 tn12 0 1e15
Rnl12 ln12 0 1e15
Cnpar12 tn12 0 0.001f
Cnplsb12 ln12 0 0.001f
Xp13 tp13 lp13 b11 b10 b9 b8 b7 b6 b5 b4 b3 b2 b1 b0 r1_cdac2_side_mc mm=1
Rpt13 tp13 0 1e15
Rpl13 lp13 0 1e15
Cppar13 tp13 0 0.001f
Cpplsb13 lp13 0 0.001f
Xn13 tn13 ln13 b11 b10 b9 b8 b7 b6 b5 b4 b3 b2 b1 b0 r1_cdac2_side_mc mm=1
Rnt13 tn13 0 1e15
Rnl13 ln13 0 1e15
Cnpar13 tn13 0 0.001f
Cnplsb13 ln13 0 0.001f
Xp14 tp14 lp14 b11 b10 b9 b8 b7 b6 b5 b4 b3 b2 b1 b0 r1_cdac2_side_mc mm=1
Rpt14 tp14 0 1e15
Rpl14 lp14 0 1e15
Cppar14 tp14 0 0.001f
Cpplsb14 lp14 0 0.001f
Xn14 tn14 ln14 b11 b10 b9 b8 b7 b6 b5 b4 b3 b2 b1 b0 r1_cdac2_side_mc mm=1
Rnt14 tn14 0 1e15
Rnl14 ln14 0 1e15
Cnpar14 tn14 0 0.001f
Cnplsb14 ln14 0 0.001f
Xp15 tp15 lp15 b11 b10 b9 b8 b7 b6 b5 b4 b3 b2 b1 b0 r1_cdac2_side_mc mm=1
Rpt15 tp15 0 1e15
Rpl15 lp15 0 1e15
Cppar15 tp15 0 0.001f
Cpplsb15 lp15 0 0.001f
Xn15 tn15 ln15 b11 b10 b9 b8 b7 b6 b5 b4 b3 b2 b1 b0 r1_cdac2_side_mc mm=1
Rnt15 tn15 0 1e15
Rnl15 ln15 0 1e15
Cnpar15 tn15 0 0.001f
Cnplsb15 ln15 0 0.001f
Xp16 tp16 lp16 b11 b10 b9 b8 b7 b6 b5 b4 b3 b2 b1 b0 r1_cdac2_side_mc mm=1
Rpt16 tp16 0 1e15
Rpl16 lp16 0 1e15
Cppar16 tp16 0 0.001f
Cpplsb16 lp16 0 0.001f
Xn16 tn16 ln16 b11 b10 b9 b8 b7 b6 b5 b4 b3 b2 b1 b0 r1_cdac2_side_mc mm=1
Rnt16 tn16 0 1e15
Rnl16 ln16 0 1e15
Cnpar16 tn16 0 0.001f
Cnplsb16 ln16 0 0.001f
Xp17 tp17 lp17 b11 b10 b9 b8 b7 b6 b5 b4 b3 b2 b1 b0 r1_cdac2_side_mc mm=1
Rpt17 tp17 0 1e15
Rpl17 lp17 0 1e15
Cppar17 tp17 0 0.001f
Cpplsb17 lp17 0 0.001f
Xn17 tn17 ln17 b11 b10 b9 b8 b7 b6 b5 b4 b3 b2 b1 b0 r1_cdac2_side_mc mm=1
Rnt17 tn17 0 1e15
Rnl17 ln17 0 1e15
Cnpar17 tn17 0 0.001f
Cnplsb17 ln17 0 0.001f
Xp18 tp18 lp18 b11 b10 b9 b8 b7 b6 b5 b4 b3 b2 b1 b0 r1_cdac2_side_mc mm=1
Rpt18 tp18 0 1e15
Rpl18 lp18 0 1e15
Cppar18 tp18 0 0.001f
Cpplsb18 lp18 0 0.001f
Xn18 tn18 ln18 b11 b10 b9 b8 b7 b6 b5 b4 b3 b2 b1 b0 r1_cdac2_side_mc mm=1
Rnt18 tn18 0 1e15
Rnl18 ln18 0 1e15
Cnpar18 tn18 0 0.001f
Cnplsb18 ln18 0 0.001f
Xp19 tp19 lp19 b11 b10 b9 b8 b7 b6 b5 b4 b3 b2 b1 b0 r1_cdac2_side_mc mm=1
Rpt19 tp19 0 1e15
Rpl19 lp19 0 1e15
Cppar19 tp19 0 0.001f
Cpplsb19 lp19 0 0.001f
Xn19 tn19 ln19 b11 b10 b9 b8 b7 b6 b5 b4 b3 b2 b1 b0 r1_cdac2_side_mc mm=1
Rnt19 tn19 0 1e15
Rnl19 ln19 0 1e15
Cnpar19 tn19 0 0.001f
Cnplsb19 ln19 0 0.001f
Xp20 tp20 lp20 b11 b10 b9 b8 b7 b6 b5 b4 b3 b2 b1 b0 r1_cdac2_side_mc mm=1
Rpt20 tp20 0 1e15
Rpl20 lp20 0 1e15
Cppar20 tp20 0 0.001f
Cpplsb20 lp20 0 0.001f
Xn20 tn20 ln20 b11 b10 b9 b8 b7 b6 b5 b4 b3 b2 b1 b0 r1_cdac2_side_mc mm=1
Rnt20 tn20 0 1e15
Rnl20 ln20 0 1e15
Cnpar20 tn20 0 0.001f
Cnplsb20 ln20 0 0.001f
Xp21 tp21 lp21 b11 b10 b9 b8 b7 b6 b5 b4 b3 b2 b1 b0 r1_cdac2_side_mc mm=1
Rpt21 tp21 0 1e15
Rpl21 lp21 0 1e15
Cppar21 tp21 0 0.001f
Cpplsb21 lp21 0 0.001f
Xn21 tn21 ln21 b11 b10 b9 b8 b7 b6 b5 b4 b3 b2 b1 b0 r1_cdac2_side_mc mm=1
Rnt21 tn21 0 1e15
Rnl21 ln21 0 1e15
Cnpar21 tn21 0 0.001f
Cnplsb21 ln21 0 0.001f
Xp22 tp22 lp22 b11 b10 b9 b8 b7 b6 b5 b4 b3 b2 b1 b0 r1_cdac2_side_mc mm=1
Rpt22 tp22 0 1e15
Rpl22 lp22 0 1e15
Cppar22 tp22 0 0.001f
Cpplsb22 lp22 0 0.001f
Xn22 tn22 ln22 b11 b10 b9 b8 b7 b6 b5 b4 b3 b2 b1 b0 r1_cdac2_side_mc mm=1
Rnt22 tn22 0 1e15
Rnl22 ln22 0 1e15
Cnpar22 tn22 0 0.001f
Cnplsb22 ln22 0 0.001f
Xp23 tp23 lp23 b11 b10 b9 b8 b7 b6 b5 b4 b3 b2 b1 b0 r1_cdac2_side_mc mm=1
Rpt23 tp23 0 1e15
Rpl23 lp23 0 1e15
Cppar23 tp23 0 0.001f
Cpplsb23 lp23 0 0.001f
Xn23 tn23 ln23 b11 b10 b9 b8 b7 b6 b5 b4 b3 b2 b1 b0 r1_cdac2_side_mc mm=1
Rnt23 tn23 0 1e15
Rnl23 ln23 0 1e15
Cnpar23 tn23 0 0.001f
Cnplsb23 ln23 0 0.001f
Xp24 tp24 lp24 b11 b10 b9 b8 b7 b6 b5 b4 b3 b2 b1 b0 r1_cdac2_side_mc mm=1
Rpt24 tp24 0 1e15
Rpl24 lp24 0 1e15
Cppar24 tp24 0 0.001f
Cpplsb24 lp24 0 0.001f
Xn24 tn24 ln24 b11 b10 b9 b8 b7 b6 b5 b4 b3 b2 b1 b0 r1_cdac2_side_mc mm=1
Rnt24 tn24 0 1e15
Rnl24 ln24 0 1e15
Cnpar24 tn24 0 0.001f
Cnplsb24 ln24 0 0.001f
Xp25 tp25 lp25 b11 b10 b9 b8 b7 b6 b5 b4 b3 b2 b1 b0 r1_cdac2_side_mc mm=1
Rpt25 tp25 0 1e15
Rpl25 lp25 0 1e15
Cppar25 tp25 0 0.001f
Cpplsb25 lp25 0 0.001f
Xn25 tn25 ln25 b11 b10 b9 b8 b7 b6 b5 b4 b3 b2 b1 b0 r1_cdac2_side_mc mm=1
Rnt25 tn25 0 1e15
Rnl25 ln25 0 1e15
Cnpar25 tn25 0 0.001f
Cnplsb25 ln25 0 0.001f
Xp26 tp26 lp26 b11 b10 b9 b8 b7 b6 b5 b4 b3 b2 b1 b0 r1_cdac2_side_mc mm=1
Rpt26 tp26 0 1e15
Rpl26 lp26 0 1e15
Cppar26 tp26 0 0.001f
Cpplsb26 lp26 0 0.001f
Xn26 tn26 ln26 b11 b10 b9 b8 b7 b6 b5 b4 b3 b2 b1 b0 r1_cdac2_side_mc mm=1
Rnt26 tn26 0 1e15
Rnl26 ln26 0 1e15
Cnpar26 tn26 0 0.001f
Cnplsb26 ln26 0 0.001f
Xp27 tp27 lp27 b11 b10 b9 b8 b7 b6 b5 b4 b3 b2 b1 b0 r1_cdac2_side_mc mm=1
Rpt27 tp27 0 1e15
Rpl27 lp27 0 1e15
Cppar27 tp27 0 0.001f
Cpplsb27 lp27 0 0.001f
Xn27 tn27 ln27 b11 b10 b9 b8 b7 b6 b5 b4 b3 b2 b1 b0 r1_cdac2_side_mc mm=1
Rnt27 tn27 0 1e15
Rnl27 ln27 0 1e15
Cnpar27 tn27 0 0.001f
Cnplsb27 ln27 0 0.001f
Xp28 tp28 lp28 b11 b10 b9 b8 b7 b6 b5 b4 b3 b2 b1 b0 r1_cdac2_side_mc mm=1
Rpt28 tp28 0 1e15
Rpl28 lp28 0 1e15
Cppar28 tp28 0 0.001f
Cpplsb28 lp28 0 0.001f
Xn28 tn28 ln28 b11 b10 b9 b8 b7 b6 b5 b4 b3 b2 b1 b0 r1_cdac2_side_mc mm=1
Rnt28 tn28 0 1e15
Rnl28 ln28 0 1e15
Cnpar28 tn28 0 0.001f
Cnplsb28 ln28 0 0.001f
Xp29 tp29 lp29 b11 b10 b9 b8 b7 b6 b5 b4 b3 b2 b1 b0 r1_cdac2_side_mc mm=1
Rpt29 tp29 0 1e15
Rpl29 lp29 0 1e15
Cppar29 tp29 0 0.001f
Cpplsb29 lp29 0 0.001f
Xn29 tn29 ln29 b11 b10 b9 b8 b7 b6 b5 b4 b3 b2 b1 b0 r1_cdac2_side_mc mm=1
Rnt29 tn29 0 1e15
Rnl29 ln29 0 1e15
Cnpar29 tn29 0 0.001f
Cnplsb29 ln29 0 0.001f
Xp30 tp30 lp30 b11 b10 b9 b8 b7 b6 b5 b4 b3 b2 b1 b0 r1_cdac2_side_mc mm=1
Rpt30 tp30 0 1e15
Rpl30 lp30 0 1e15
Cppar30 tp30 0 0.001f
Cpplsb30 lp30 0 0.001f
Xn30 tn30 ln30 b11 b10 b9 b8 b7 b6 b5 b4 b3 b2 b1 b0 r1_cdac2_side_mc mm=1
Rnt30 tn30 0 1e15
Rnl30 ln30 0 1e15
Cnpar30 tn30 0 0.001f
Cnplsb30 ln30 0 0.001f
Xp31 tp31 lp31 b11 b10 b9 b8 b7 b6 b5 b4 b3 b2 b1 b0 r1_cdac2_side_mc mm=1
Rpt31 tp31 0 1e15
Rpl31 lp31 0 1e15
Cppar31 tp31 0 0.001f
Cpplsb31 lp31 0 0.001f
Xn31 tn31 ln31 b11 b10 b9 b8 b7 b6 b5 b4 b3 b2 b1 b0 r1_cdac2_side_mc mm=1
Rnt31 tn31 0 1e15
Rnl31 ln31 0 1e15
Cnpar31 tn31 0 0.001f
Cnplsb31 ln31 0 0.001f
Xp32 tp32 lp32 b11 b10 b9 b8 b7 b6 b5 b4 b3 b2 b1 b0 r1_cdac2_side_mc mm=1
Rpt32 tp32 0 1e15
Rpl32 lp32 0 1e15
Cppar32 tp32 0 0.001f
Cpplsb32 lp32 0 0.001f
Xn32 tn32 ln32 b11 b10 b9 b8 b7 b6 b5 b4 b3 b2 b1 b0 r1_cdac2_side_mc mm=1
Rnt32 tn32 0 1e15
Rnl32 ln32 0 1e15
Cnpar32 tn32 0 0.001f
Cnplsb32 ln32 0 0.001f
Xp33 tp33 lp33 b11 b10 b9 b8 b7 b6 b5 b4 b3 b2 b1 b0 r1_cdac2_side_mc mm=1
Rpt33 tp33 0 1e15
Rpl33 lp33 0 1e15
Cppar33 tp33 0 0.001f
Cpplsb33 lp33 0 0.001f
Xn33 tn33 ln33 b11 b10 b9 b8 b7 b6 b5 b4 b3 b2 b1 b0 r1_cdac2_side_mc mm=1
Rnt33 tn33 0 1e15
Rnl33 ln33 0 1e15
Cnpar33 tn33 0 0.001f
Cnplsb33 ln33 0 0.001f
Xp34 tp34 lp34 b11 b10 b9 b8 b7 b6 b5 b4 b3 b2 b1 b0 r1_cdac2_side_mc mm=1
Rpt34 tp34 0 1e15
Rpl34 lp34 0 1e15
Cppar34 tp34 0 0.001f
Cpplsb34 lp34 0 0.001f
Xn34 tn34 ln34 b11 b10 b9 b8 b7 b6 b5 b4 b3 b2 b1 b0 r1_cdac2_side_mc mm=1
Rnt34 tn34 0 1e15
Rnl34 ln34 0 1e15
Cnpar34 tn34 0 0.001f
Cnplsb34 ln34 0 0.001f
Xp35 tp35 lp35 b11 b10 b9 b8 b7 b6 b5 b4 b3 b2 b1 b0 r1_cdac2_side_mc mm=1
Rpt35 tp35 0 1e15
Rpl35 lp35 0 1e15
Cppar35 tp35 0 0.001f
Cpplsb35 lp35 0 0.001f
Xn35 tn35 ln35 b11 b10 b9 b8 b7 b6 b5 b4 b3 b2 b1 b0 r1_cdac2_side_mc mm=1
Rnt35 tn35 0 1e15
Rnl35 ln35 0 1e15
Cnpar35 tn35 0 0.001f
Cnplsb35 ln35 0 0.001f
Xp36 tp36 lp36 b11 b10 b9 b8 b7 b6 b5 b4 b3 b2 b1 b0 r1_cdac2_side_mc mm=1
Rpt36 tp36 0 1e15
Rpl36 lp36 0 1e15
Cppar36 tp36 0 0.001f
Cpplsb36 lp36 0 0.001f
Xn36 tn36 ln36 b11 b10 b9 b8 b7 b6 b5 b4 b3 b2 b1 b0 r1_cdac2_side_mc mm=1
Rnt36 tn36 0 1e15
Rnl36 ln36 0 1e15
Cnpar36 tn36 0 0.001f
Cnplsb36 ln36 0 0.001f
Xp37 tp37 lp37 b11 b10 b9 b8 b7 b6 b5 b4 b3 b2 b1 b0 r1_cdac2_side_mc mm=1
Rpt37 tp37 0 1e15
Rpl37 lp37 0 1e15
Cppar37 tp37 0 0.001f
Cpplsb37 lp37 0 0.001f
Xn37 tn37 ln37 b11 b10 b9 b8 b7 b6 b5 b4 b3 b2 b1 b0 r1_cdac2_side_mc mm=1
Rnt37 tn37 0 1e15
Rnl37 ln37 0 1e15
Cnpar37 tn37 0 0.001f
Cnplsb37 ln37 0 0.001f
Xp38 tp38 lp38 b11 b10 b9 b8 b7 b6 b5 b4 b3 b2 b1 b0 r1_cdac2_side_mc mm=1
Rpt38 tp38 0 1e15
Rpl38 lp38 0 1e15
Cppar38 tp38 0 0.001f
Cpplsb38 lp38 0 0.001f
Xn38 tn38 ln38 b11 b10 b9 b8 b7 b6 b5 b4 b3 b2 b1 b0 r1_cdac2_side_mc mm=1
Rnt38 tn38 0 1e15
Rnl38 ln38 0 1e15
Cnpar38 tn38 0 0.001f
Cnplsb38 ln38 0 0.001f
Xp39 tp39 lp39 b11 b10 b9 b8 b7 b6 b5 b4 b3 b2 b1 b0 r1_cdac2_side_mc mm=1
Rpt39 tp39 0 1e15
Rpl39 lp39 0 1e15
Cppar39 tp39 0 0.001f
Cpplsb39 lp39 0 0.001f
Xn39 tn39 ln39 b11 b10 b9 b8 b7 b6 b5 b4 b3 b2 b1 b0 r1_cdac2_side_mc mm=1
Rnt39 tn39 0 1e15
Rnl39 ln39 0 1e15
Cnpar39 tn39 0 0.001f
Cnplsb39 ln39 0 0.001f
Xp40 tp40 lp40 b11 b10 b9 b8 b7 b6 b5 b4 b3 b2 b1 b0 r1_cdac2_side_mc mm=1
Rpt40 tp40 0 1e15
Rpl40 lp40 0 1e15
Cppar40 tp40 0 0.001f
Cpplsb40 lp40 0 0.001f
Xn40 tn40 ln40 b11 b10 b9 b8 b7 b6 b5 b4 b3 b2 b1 b0 r1_cdac2_side_mc mm=1
Rnt40 tn40 0 1e15
Rnl40 ln40 0 1e15
Cnpar40 tn40 0 0.001f
Cnplsb40 ln40 0 0.001f
Xp41 tp41 lp41 b11 b10 b9 b8 b7 b6 b5 b4 b3 b2 b1 b0 r1_cdac2_side_mc mm=1
Rpt41 tp41 0 1e15
Rpl41 lp41 0 1e15
Cppar41 tp41 0 0.001f
Cpplsb41 lp41 0 0.001f
Xn41 tn41 ln41 b11 b10 b9 b8 b7 b6 b5 b4 b3 b2 b1 b0 r1_cdac2_side_mc mm=1
Rnt41 tn41 0 1e15
Rnl41 ln41 0 1e15
Cnpar41 tn41 0 0.001f
Cnplsb41 ln41 0 0.001f
Xp42 tp42 lp42 b11 b10 b9 b8 b7 b6 b5 b4 b3 b2 b1 b0 r1_cdac2_side_mc mm=1
Rpt42 tp42 0 1e15
Rpl42 lp42 0 1e15
Cppar42 tp42 0 0.001f
Cpplsb42 lp42 0 0.001f
Xn42 tn42 ln42 b11 b10 b9 b8 b7 b6 b5 b4 b3 b2 b1 b0 r1_cdac2_side_mc mm=1
Rnt42 tn42 0 1e15
Rnl42 ln42 0 1e15
Cnpar42 tn42 0 0.001f
Cnplsb42 ln42 0 0.001f
Xp43 tp43 lp43 b11 b10 b9 b8 b7 b6 b5 b4 b3 b2 b1 b0 r1_cdac2_side_mc mm=1
Rpt43 tp43 0 1e15
Rpl43 lp43 0 1e15
Cppar43 tp43 0 0.001f
Cpplsb43 lp43 0 0.001f
Xn43 tn43 ln43 b11 b10 b9 b8 b7 b6 b5 b4 b3 b2 b1 b0 r1_cdac2_side_mc mm=1
Rnt43 tn43 0 1e15
Rnl43 ln43 0 1e15
Cnpar43 tn43 0 0.001f
Cnplsb43 ln43 0 0.001f
Xp44 tp44 lp44 b11 b10 b9 b8 b7 b6 b5 b4 b3 b2 b1 b0 r1_cdac2_side_mc mm=1
Rpt44 tp44 0 1e15
Rpl44 lp44 0 1e15
Cppar44 tp44 0 0.001f
Cpplsb44 lp44 0 0.001f
Xn44 tn44 ln44 b11 b10 b9 b8 b7 b6 b5 b4 b3 b2 b1 b0 r1_cdac2_side_mc mm=1
Rnt44 tn44 0 1e15
Rnl44 ln44 0 1e15
Cnpar44 tn44 0 0.001f
Cnplsb44 ln44 0 0.001f
Xp45 tp45 lp45 b11 b10 b9 b8 b7 b6 b5 b4 b3 b2 b1 b0 r1_cdac2_side_mc mm=1
Rpt45 tp45 0 1e15
Rpl45 lp45 0 1e15
Cppar45 tp45 0 0.001f
Cpplsb45 lp45 0 0.001f
Xn45 tn45 ln45 b11 b10 b9 b8 b7 b6 b5 b4 b3 b2 b1 b0 r1_cdac2_side_mc mm=1
Rnt45 tn45 0 1e15
Rnl45 ln45 0 1e15
Cnpar45 tn45 0 0.001f
Cnplsb45 ln45 0 0.001f
Xp46 tp46 lp46 b11 b10 b9 b8 b7 b6 b5 b4 b3 b2 b1 b0 r1_cdac2_side_mc mm=1
Rpt46 tp46 0 1e15
Rpl46 lp46 0 1e15
Cppar46 tp46 0 0.001f
Cpplsb46 lp46 0 0.001f
Xn46 tn46 ln46 b11 b10 b9 b8 b7 b6 b5 b4 b3 b2 b1 b0 r1_cdac2_side_mc mm=1
Rnt46 tn46 0 1e15
Rnl46 ln46 0 1e15
Cnpar46 tn46 0 0.001f
Cnplsb46 ln46 0 0.001f
Xp47 tp47 lp47 b11 b10 b9 b8 b7 b6 b5 b4 b3 b2 b1 b0 r1_cdac2_side_mc mm=1
Rpt47 tp47 0 1e15
Rpl47 lp47 0 1e15
Cppar47 tp47 0 0.001f
Cpplsb47 lp47 0 0.001f
Xn47 tn47 ln47 b11 b10 b9 b8 b7 b6 b5 b4 b3 b2 b1 b0 r1_cdac2_side_mc mm=1
Rnt47 tn47 0 1e15
Rnl47 ln47 0 1e15
Cnpar47 tn47 0 0.001f
Cnplsb47 ln47 0 0.001f
Xp48 tp48 lp48 b11 b10 b9 b8 b7 b6 b5 b4 b3 b2 b1 b0 r1_cdac2_side_mc mm=1
Rpt48 tp48 0 1e15
Rpl48 lp48 0 1e15
Cppar48 tp48 0 0.001f
Cpplsb48 lp48 0 0.001f
Xn48 tn48 ln48 b11 b10 b9 b8 b7 b6 b5 b4 b3 b2 b1 b0 r1_cdac2_side_mc mm=1
Rnt48 tn48 0 1e15
Rnl48 ln48 0 1e15
Cnpar48 tn48 0 0.001f
Cnplsb48 ln48 0 0.001f
Xp49 tp49 lp49 b11 b10 b9 b8 b7 b6 b5 b4 b3 b2 b1 b0 r1_cdac2_side_mc mm=1
Rpt49 tp49 0 1e15
Rpl49 lp49 0 1e15
Cppar49 tp49 0 0.001f
Cpplsb49 lp49 0 0.001f
Xn49 tn49 ln49 b11 b10 b9 b8 b7 b6 b5 b4 b3 b2 b1 b0 r1_cdac2_side_mc mm=1
Rnt49 tn49 0 1e15
Rnl49 ln49 0 1e15
Cnpar49 tn49 0 0.001f
Cnplsb49 ln49 0 0.001f
.control
set wr_singlescale
alter vb11 acmag=1
ac lin 1 1k 1k
wrdata <G1_RESULTS_ROOT>/r1_adc/r2-cdac-mc50-tt-cp0/w_b11.txt v(tp0) v(tn0) v(tp1) v(tn1) v(tp2) v(tn2) v(tp3) v(tn3) v(tp4) v(tn4) v(tp5) v(tn5) v(tp6) v(tn6) v(tp7) v(tn7) v(tp8) v(tn8) v(tp9) v(tn9) v(tp10) v(tn10) v(tp11) v(tn11) v(tp12) v(tn12) v(tp13) v(tn13) v(tp14) v(tn14) v(tp15) v(tn15) v(tp16) v(tn16) v(tp17) v(tn17) v(tp18) v(tn18) v(tp19) v(tn19) v(tp20) v(tn20) v(tp21) v(tn21) v(tp22) v(tn22) v(tp23) v(tn23) v(tp24) v(tn24) v(tp25) v(tn25) v(tp26) v(tn26) v(tp27) v(tn27) v(tp28) v(tn28) v(tp29) v(tn29) v(tp30) v(tn30) v(tp31) v(tn31) v(tp32) v(tn32) v(tp33) v(tn33) v(tp34) v(tn34) v(tp35) v(tn35) v(tp36) v(tn36) v(tp37) v(tn37) v(tp38) v(tn38) v(tp39) v(tn39) v(tp40) v(tn40) v(tp41) v(tn41) v(tp42) v(tn42) v(tp43) v(tn43) v(tp44) v(tn44) v(tp45) v(tn45) v(tp46) v(tn46) v(tp47) v(tn47) v(tp48) v(tn48) v(tp49) v(tn49)
alter vb11 acmag=0
alter vb10 acmag=1
ac lin 1 1k 1k
wrdata <G1_RESULTS_ROOT>/r1_adc/r2-cdac-mc50-tt-cp0/w_b10.txt v(tp0) v(tn0) v(tp1) v(tn1) v(tp2) v(tn2) v(tp3) v(tn3) v(tp4) v(tn4) v(tp5) v(tn5) v(tp6) v(tn6) v(tp7) v(tn7) v(tp8) v(tn8) v(tp9) v(tn9) v(tp10) v(tn10) v(tp11) v(tn11) v(tp12) v(tn12) v(tp13) v(tn13) v(tp14) v(tn14) v(tp15) v(tn15) v(tp16) v(tn16) v(tp17) v(tn17) v(tp18) v(tn18) v(tp19) v(tn19) v(tp20) v(tn20) v(tp21) v(tn21) v(tp22) v(tn22) v(tp23) v(tn23) v(tp24) v(tn24) v(tp25) v(tn25) v(tp26) v(tn26) v(tp27) v(tn27) v(tp28) v(tn28) v(tp29) v(tn29) v(tp30) v(tn30) v(tp31) v(tn31) v(tp32) v(tn32) v(tp33) v(tn33) v(tp34) v(tn34) v(tp35) v(tn35) v(tp36) v(tn36) v(tp37) v(tn37) v(tp38) v(tn38) v(tp39) v(tn39) v(tp40) v(tn40) v(tp41) v(tn41) v(tp42) v(tn42) v(tp43) v(tn43) v(tp44) v(tn44) v(tp45) v(tn45) v(tp46) v(tn46) v(tp47) v(tn47) v(tp48) v(tn48) v(tp49) v(tn49)
alter vb10 acmag=0
alter vb9 acmag=1
ac lin 1 1k 1k
wrdata <G1_RESULTS_ROOT>/r1_adc/r2-cdac-mc50-tt-cp0/w_b9.txt v(tp0) v(tn0) v(tp1) v(tn1) v(tp2) v(tn2) v(tp3) v(tn3) v(tp4) v(tn4) v(tp5) v(tn5) v(tp6) v(tn6) v(tp7) v(tn7) v(tp8) v(tn8) v(tp9) v(tn9) v(tp10) v(tn10) v(tp11) v(tn11) v(tp12) v(tn12) v(tp13) v(tn13) v(tp14) v(tn14) v(tp15) v(tn15) v(tp16) v(tn16) v(tp17) v(tn17) v(tp18) v(tn18) v(tp19) v(tn19) v(tp20) v(tn20) v(tp21) v(tn21) v(tp22) v(tn22) v(tp23) v(tn23) v(tp24) v(tn24) v(tp25) v(tn25) v(tp26) v(tn26) v(tp27) v(tn27) v(tp28) v(tn28) v(tp29) v(tn29) v(tp30) v(tn30) v(tp31) v(tn31) v(tp32) v(tn32) v(tp33) v(tn33) v(tp34) v(tn34) v(tp35) v(tn35) v(tp36) v(tn36) v(tp37) v(tn37) v(tp38) v(tn38) v(tp39) v(tn39) v(tp40) v(tn40) v(tp41) v(tn41) v(tp42) v(tn42) v(tp43) v(tn43) v(tp44) v(tn44) v(tp45) v(tn45) v(tp46) v(tn46) v(tp47) v(tn47) v(tp48) v(tn48) v(tp49) v(tn49)
alter vb9 acmag=0
alter vb8 acmag=1
ac lin 1 1k 1k
wrdata <G1_RESULTS_ROOT>/r1_adc/r2-cdac-mc50-tt-cp0/w_b8.txt v(tp0) v(tn0) v(tp1) v(tn1) v(tp2) v(tn2) v(tp3) v(tn3) v(tp4) v(tn4) v(tp5) v(tn5) v(tp6) v(tn6) v(tp7) v(tn7) v(tp8) v(tn8) v(tp9) v(tn9) v(tp10) v(tn10) v(tp11) v(tn11) v(tp12) v(tn12) v(tp13) v(tn13) v(tp14) v(tn14) v(tp15) v(tn15) v(tp16) v(tn16) v(tp17) v(tn17) v(tp18) v(tn18) v(tp19) v(tn19) v(tp20) v(tn20) v(tp21) v(tn21) v(tp22) v(tn22) v(tp23) v(tn23) v(tp24) v(tn24) v(tp25) v(tn25) v(tp26) v(tn26) v(tp27) v(tn27) v(tp28) v(tn28) v(tp29) v(tn29) v(tp30) v(tn30) v(tp31) v(tn31) v(tp32) v(tn32) v(tp33) v(tn33) v(tp34) v(tn34) v(tp35) v(tn35) v(tp36) v(tn36) v(tp37) v(tn37) v(tp38) v(tn38) v(tp39) v(tn39) v(tp40) v(tn40) v(tp41) v(tn41) v(tp42) v(tn42) v(tp43) v(tn43) v(tp44) v(tn44) v(tp45) v(tn45) v(tp46) v(tn46) v(tp47) v(tn47) v(tp48) v(tn48) v(tp49) v(tn49)
alter vb8 acmag=0
alter vb7 acmag=1
ac lin 1 1k 1k
wrdata <G1_RESULTS_ROOT>/r1_adc/r2-cdac-mc50-tt-cp0/w_b7.txt v(tp0) v(tn0) v(tp1) v(tn1) v(tp2) v(tn2) v(tp3) v(tn3) v(tp4) v(tn4) v(tp5) v(tn5) v(tp6) v(tn6) v(tp7) v(tn7) v(tp8) v(tn8) v(tp9) v(tn9) v(tp10) v(tn10) v(tp11) v(tn11) v(tp12) v(tn12) v(tp13) v(tn13) v(tp14) v(tn14) v(tp15) v(tn15) v(tp16) v(tn16) v(tp17) v(tn17) v(tp18) v(tn18) v(tp19) v(tn19) v(tp20) v(tn20) v(tp21) v(tn21) v(tp22) v(tn22) v(tp23) v(tn23) v(tp24) v(tn24) v(tp25) v(tn25) v(tp26) v(tn26) v(tp27) v(tn27) v(tp28) v(tn28) v(tp29) v(tn29) v(tp30) v(tn30) v(tp31) v(tn31) v(tp32) v(tn32) v(tp33) v(tn33) v(tp34) v(tn34) v(tp35) v(tn35) v(tp36) v(tn36) v(tp37) v(tn37) v(tp38) v(tn38) v(tp39) v(tn39) v(tp40) v(tn40) v(tp41) v(tn41) v(tp42) v(tn42) v(tp43) v(tn43) v(tp44) v(tn44) v(tp45) v(tn45) v(tp46) v(tn46) v(tp47) v(tn47) v(tp48) v(tn48) v(tp49) v(tn49)
alter vb7 acmag=0
alter vb6 acmag=1
ac lin 1 1k 1k
wrdata <G1_RESULTS_ROOT>/r1_adc/r2-cdac-mc50-tt-cp0/w_b6.txt v(tp0) v(tn0) v(tp1) v(tn1) v(tp2) v(tn2) v(tp3) v(tn3) v(tp4) v(tn4) v(tp5) v(tn5) v(tp6) v(tn6) v(tp7) v(tn7) v(tp8) v(tn8) v(tp9) v(tn9) v(tp10) v(tn10) v(tp11) v(tn11) v(tp12) v(tn12) v(tp13) v(tn13) v(tp14) v(tn14) v(tp15) v(tn15) v(tp16) v(tn16) v(tp17) v(tn17) v(tp18) v(tn18) v(tp19) v(tn19) v(tp20) v(tn20) v(tp21) v(tn21) v(tp22) v(tn22) v(tp23) v(tn23) v(tp24) v(tn24) v(tp25) v(tn25) v(tp26) v(tn26) v(tp27) v(tn27) v(tp28) v(tn28) v(tp29) v(tn29) v(tp30) v(tn30) v(tp31) v(tn31) v(tp32) v(tn32) v(tp33) v(tn33) v(tp34) v(tn34) v(tp35) v(tn35) v(tp36) v(tn36) v(tp37) v(tn37) v(tp38) v(tn38) v(tp39) v(tn39) v(tp40) v(tn40) v(tp41) v(tn41) v(tp42) v(tn42) v(tp43) v(tn43) v(tp44) v(tn44) v(tp45) v(tn45) v(tp46) v(tn46) v(tp47) v(tn47) v(tp48) v(tn48) v(tp49) v(tn49)
alter vb6 acmag=0
alter vb5 acmag=1
ac lin 1 1k 1k
wrdata <G1_RESULTS_ROOT>/r1_adc/r2-cdac-mc50-tt-cp0/w_b5.txt v(tp0) v(tn0) v(tp1) v(tn1) v(tp2) v(tn2) v(tp3) v(tn3) v(tp4) v(tn4) v(tp5) v(tn5) v(tp6) v(tn6) v(tp7) v(tn7) v(tp8) v(tn8) v(tp9) v(tn9) v(tp10) v(tn10) v(tp11) v(tn11) v(tp12) v(tn12) v(tp13) v(tn13) v(tp14) v(tn14) v(tp15) v(tn15) v(tp16) v(tn16) v(tp17) v(tn17) v(tp18) v(tn18) v(tp19) v(tn19) v(tp20) v(tn20) v(tp21) v(tn21) v(tp22) v(tn22) v(tp23) v(tn23) v(tp24) v(tn24) v(tp25) v(tn25) v(tp26) v(tn26) v(tp27) v(tn27) v(tp28) v(tn28) v(tp29) v(tn29) v(tp30) v(tn30) v(tp31) v(tn31) v(tp32) v(tn32) v(tp33) v(tn33) v(tp34) v(tn34) v(tp35) v(tn35) v(tp36) v(tn36) v(tp37) v(tn37) v(tp38) v(tn38) v(tp39) v(tn39) v(tp40) v(tn40) v(tp41) v(tn41) v(tp42) v(tn42) v(tp43) v(tn43) v(tp44) v(tn44) v(tp45) v(tn45) v(tp46) v(tn46) v(tp47) v(tn47) v(tp48) v(tn48) v(tp49) v(tn49)
alter vb5 acmag=0
alter vb4 acmag=1
ac lin 1 1k 1k
wrdata <G1_RESULTS_ROOT>/r1_adc/r2-cdac-mc50-tt-cp0/w_b4.txt v(tp0) v(tn0) v(tp1) v(tn1) v(tp2) v(tn2) v(tp3) v(tn3) v(tp4) v(tn4) v(tp5) v(tn5) v(tp6) v(tn6) v(tp7) v(tn7) v(tp8) v(tn8) v(tp9) v(tn9) v(tp10) v(tn10) v(tp11) v(tn11) v(tp12) v(tn12) v(tp13) v(tn13) v(tp14) v(tn14) v(tp15) v(tn15) v(tp16) v(tn16) v(tp17) v(tn17) v(tp18) v(tn18) v(tp19) v(tn19) v(tp20) v(tn20) v(tp21) v(tn21) v(tp22) v(tn22) v(tp23) v(tn23) v(tp24) v(tn24) v(tp25) v(tn25) v(tp26) v(tn26) v(tp27) v(tn27) v(tp28) v(tn28) v(tp29) v(tn29) v(tp30) v(tn30) v(tp31) v(tn31) v(tp32) v(tn32) v(tp33) v(tn33) v(tp34) v(tn34) v(tp35) v(tn35) v(tp36) v(tn36) v(tp37) v(tn37) v(tp38) v(tn38) v(tp39) v(tn39) v(tp40) v(tn40) v(tp41) v(tn41) v(tp42) v(tn42) v(tp43) v(tn43) v(tp44) v(tn44) v(tp45) v(tn45) v(tp46) v(tn46) v(tp47) v(tn47) v(tp48) v(tn48) v(tp49) v(tn49)
alter vb4 acmag=0
alter vb3 acmag=1
ac lin 1 1k 1k
wrdata <G1_RESULTS_ROOT>/r1_adc/r2-cdac-mc50-tt-cp0/w_b3.txt v(tp0) v(tn0) v(tp1) v(tn1) v(tp2) v(tn2) v(tp3) v(tn3) v(tp4) v(tn4) v(tp5) v(tn5) v(tp6) v(tn6) v(tp7) v(tn7) v(tp8) v(tn8) v(tp9) v(tn9) v(tp10) v(tn10) v(tp11) v(tn11) v(tp12) v(tn12) v(tp13) v(tn13) v(tp14) v(tn14) v(tp15) v(tn15) v(tp16) v(tn16) v(tp17) v(tn17) v(tp18) v(tn18) v(tp19) v(tn19) v(tp20) v(tn20) v(tp21) v(tn21) v(tp22) v(tn22) v(tp23) v(tn23) v(tp24) v(tn24) v(tp25) v(tn25) v(tp26) v(tn26) v(tp27) v(tn27) v(tp28) v(tn28) v(tp29) v(tn29) v(tp30) v(tn30) v(tp31) v(tn31) v(tp32) v(tn32) v(tp33) v(tn33) v(tp34) v(tn34) v(tp35) v(tn35) v(tp36) v(tn36) v(tp37) v(tn37) v(tp38) v(tn38) v(tp39) v(tn39) v(tp40) v(tn40) v(tp41) v(tn41) v(tp42) v(tn42) v(tp43) v(tn43) v(tp44) v(tn44) v(tp45) v(tn45) v(tp46) v(tn46) v(tp47) v(tn47) v(tp48) v(tn48) v(tp49) v(tn49)
alter vb3 acmag=0
alter vb2 acmag=1
ac lin 1 1k 1k
wrdata <G1_RESULTS_ROOT>/r1_adc/r2-cdac-mc50-tt-cp0/w_b2.txt v(tp0) v(tn0) v(tp1) v(tn1) v(tp2) v(tn2) v(tp3) v(tn3) v(tp4) v(tn4) v(tp5) v(tn5) v(tp6) v(tn6) v(tp7) v(tn7) v(tp8) v(tn8) v(tp9) v(tn9) v(tp10) v(tn10) v(tp11) v(tn11) v(tp12) v(tn12) v(tp13) v(tn13) v(tp14) v(tn14) v(tp15) v(tn15) v(tp16) v(tn16) v(tp17) v(tn17) v(tp18) v(tn18) v(tp19) v(tn19) v(tp20) v(tn20) v(tp21) v(tn21) v(tp22) v(tn22) v(tp23) v(tn23) v(tp24) v(tn24) v(tp25) v(tn25) v(tp26) v(tn26) v(tp27) v(tn27) v(tp28) v(tn28) v(tp29) v(tn29) v(tp30) v(tn30) v(tp31) v(tn31) v(tp32) v(tn32) v(tp33) v(tn33) v(tp34) v(tn34) v(tp35) v(tn35) v(tp36) v(tn36) v(tp37) v(tn37) v(tp38) v(tn38) v(tp39) v(tn39) v(tp40) v(tn40) v(tp41) v(tn41) v(tp42) v(tn42) v(tp43) v(tn43) v(tp44) v(tn44) v(tp45) v(tn45) v(tp46) v(tn46) v(tp47) v(tn47) v(tp48) v(tn48) v(tp49) v(tn49)
alter vb2 acmag=0
alter vb1 acmag=1
ac lin 1 1k 1k
wrdata <G1_RESULTS_ROOT>/r1_adc/r2-cdac-mc50-tt-cp0/w_b1.txt v(tp0) v(tn0) v(tp1) v(tn1) v(tp2) v(tn2) v(tp3) v(tn3) v(tp4) v(tn4) v(tp5) v(tn5) v(tp6) v(tn6) v(tp7) v(tn7) v(tp8) v(tn8) v(tp9) v(tn9) v(tp10) v(tn10) v(tp11) v(tn11) v(tp12) v(tn12) v(tp13) v(tn13) v(tp14) v(tn14) v(tp15) v(tn15) v(tp16) v(tn16) v(tp17) v(tn17) v(tp18) v(tn18) v(tp19) v(tn19) v(tp20) v(tn20) v(tp21) v(tn21) v(tp22) v(tn22) v(tp23) v(tn23) v(tp24) v(tn24) v(tp25) v(tn25) v(tp26) v(tn26) v(tp27) v(tn27) v(tp28) v(tn28) v(tp29) v(tn29) v(tp30) v(tn30) v(tp31) v(tn31) v(tp32) v(tn32) v(tp33) v(tn33) v(tp34) v(tn34) v(tp35) v(tn35) v(tp36) v(tn36) v(tp37) v(tn37) v(tp38) v(tn38) v(tp39) v(tn39) v(tp40) v(tn40) v(tp41) v(tn41) v(tp42) v(tn42) v(tp43) v(tn43) v(tp44) v(tn44) v(tp45) v(tn45) v(tp46) v(tn46) v(tp47) v(tn47) v(tp48) v(tn48) v(tp49) v(tn49)
alter vb1 acmag=0
alter vb0 acmag=1
ac lin 1 1k 1k
wrdata <G1_RESULTS_ROOT>/r1_adc/r2-cdac-mc50-tt-cp0/w_b0.txt v(tp0) v(tn0) v(tp1) v(tn1) v(tp2) v(tn2) v(tp3) v(tn3) v(tp4) v(tn4) v(tp5) v(tn5) v(tp6) v(tn6) v(tp7) v(tn7) v(tp8) v(tn8) v(tp9) v(tn9) v(tp10) v(tn10) v(tp11) v(tn11) v(tp12) v(tn12) v(tp13) v(tn13) v(tp14) v(tn14) v(tp15) v(tn15) v(tp16) v(tn16) v(tp17) v(tn17) v(tp18) v(tn18) v(tp19) v(tn19) v(tp20) v(tn20) v(tp21) v(tn21) v(tp22) v(tn22) v(tp23) v(tn23) v(tp24) v(tn24) v(tp25) v(tn25) v(tp26) v(tn26) v(tp27) v(tn27) v(tp28) v(tn28) v(tp29) v(tn29) v(tp30) v(tn30) v(tp31) v(tn31) v(tp32) v(tn32) v(tp33) v(tn33) v(tp34) v(tn34) v(tp35) v(tn35) v(tp36) v(tn36) v(tp37) v(tn37) v(tp38) v(tn38) v(tp39) v(tn39) v(tp40) v(tn40) v(tp41) v(tn41) v(tp42) v(tn42) v(tp43) v(tn43) v(tp44) v(tn44) v(tp45) v(tn45) v(tp46) v(tn46) v(tp47) v(tn47) v(tp48) v(tn48) v(tp49) v(tn49)
alter vb0 acmag=0
.endc
.end
