* tb_cmp2_tran.cir (generated by sim/r2/gen_cmp_decks.py) -- r1_cmp2 variants, decision dynamics
.lib /foss/pdks/ihp-sg13g2/libs.tech/ngspice/models/cornerMOSlv.lib mos_tt
.lib /foss/pdks/ihp-sg13g2/libs.tech/ngspice/models/cornerCAP.lib cap_typ
.lib /foss/pdks/ihp-sg13g2/libs.tech/ngspice/models/cornerMOShv.lib mos_tt
.lib /foss/pdks/ihp-sg13g2/libs.tech/ngspice/models/cornerRES.lib res_typ
.include schematic/r1_adc_r2.spice
.temp 27
.option reltol=1e-4 vntol=1e-7 abstol=1e-13 method=gear
Vdd vdd 0 1.2
Vclk clk 0 PULSE(0 1.2 2n 50p 50p 16.6167n 33.3333n)
Vclkb clkb 0 PULSE(1.2 0 2n 50p 50p 16.6167n 33.3333n)
XB vbp vdd 0 r1_cmp2_bias ib=8u
VpAh ipAh 0 0.6001
VnAh inAh 0 0.5999
XAh ipAh inAh clk clkb opAh onAh vbp vdd 0 r1_cmp2 wi=48u li=0.3u ngi=12 wt=16u wtc=8u ltc=0.5u wcap=12u lcap=4u wr=2u wh=8u
VpAm ipAm 0 0.3501
VnAm inAm 0 0.3499
XAm ipAm inAm clk clkb opAm onAm vbp vdd 0 r1_cmp2 wi=48u li=0.3u ngi=12 wt=16u wtc=8u ltc=0.5u wcap=12u lcap=4u wr=2u wh=8u
VpAl ipAl 0 0.1001
VnAl inAl 0 0.0999
XAl ipAl inAl clk clkb opAl onAl vbp vdd 0 r1_cmp2 wi=48u li=0.3u ngi=12 wt=16u wtc=8u ltc=0.5u wcap=12u lcap=4u wr=2u wh=8u
VpBh ipBh 0 0.6001
VnBh inBh 0 0.5999
XBh ipBh inBh clk clkb opBh onBh vbp vdd 0 r1_cmp2 wi=48u li=0.3u ngi=12 wt=16u wtc=8u ltc=0.5u wcap=8u lcap=4u wr=2u wh=8u
VpBm ipBm 0 0.3501
VnBm inBm 0 0.3499
XBm ipBm inBm clk clkb opBm onBm vbp vdd 0 r1_cmp2 wi=48u li=0.3u ngi=12 wt=16u wtc=8u ltc=0.5u wcap=8u lcap=4u wr=2u wh=8u
VpBl ipBl 0 0.1001
VnBl inBl 0 0.0999
XBl ipBl inBl clk clkb opBl onBl vbp vdd 0 r1_cmp2 wi=48u li=0.3u ngi=12 wt=16u wtc=8u ltc=0.5u wcap=8u lcap=4u wr=2u wh=8u
VpCh ipCh 0 0.6001
VnCh inCh 0 0.5999
XCh ipCh inCh clk clkb opCh onCh vbp vdd 0 r1_cmp2 wi=48u li=0.3u ngi=12 wt=16u wtc=8u ltc=0.5u wcap=16u lcap=4u wr=2u wh=8u
VpCm ipCm 0 0.3501
VnCm inCm 0 0.3499
XCm ipCm inCm clk clkb opCm onCm vbp vdd 0 r1_cmp2 wi=48u li=0.3u ngi=12 wt=16u wtc=8u ltc=0.5u wcap=16u lcap=4u wr=2u wh=8u
VpCl ipCl 0 0.1001
VnCl inCl 0 0.0999
XCl ipCl inCl clk clkb opCl onCl vbp vdd 0 r1_cmp2 wi=48u li=0.3u ngi=12 wt=16u wtc=8u ltc=0.5u wcap=16u lcap=4u wr=2u wh=8u
VpDh ipDh 0 0.6001
VnDh inDh 0 0.5999
XDh ipDh inDh clk clkb opDh onDh vbp vdd 0 r1_cmp2 wi=64u li=0.3u ngi=16 wt=16u wtc=8u ltc=0.5u wcap=12u lcap=4u wr=2u wh=8u
VpDm ipDm 0 0.3501
VnDm inDm 0 0.3499
XDm ipDm inDm clk clkb opDm onDm vbp vdd 0 r1_cmp2 wi=64u li=0.3u ngi=16 wt=16u wtc=8u ltc=0.5u wcap=12u lcap=4u wr=2u wh=8u
VpDl ipDl 0 0.1001
VnDl inDl 0 0.0999
XDl ipDl inDl clk clkb opDl onDl vbp vdd 0 r1_cmp2 wi=64u li=0.3u ngi=16 wt=16u wtc=8u ltc=0.5u wcap=12u lcap=4u wr=2u wh=8u
.control
set num_threads=1
save v(opAh) v(onAh) v(xAh.dip) v(xAh.din) v(opAm) v(onAm) v(xAm.dip) v(xAm.din) v(opAl) v(onAl) v(xAl.dip) v(xAl.din) v(opBh) v(onBh) v(xBh.dip) v(xBh.din) v(opBm) v(onBm) v(xBm.dip) v(xBm.din) v(opBl) v(onBl) v(xBl.dip) v(xBl.din) v(opCh) v(onCh) v(xCh.dip) v(xCh.din) v(opCm) v(onCm) v(xCm.dip) v(xCm.din) v(opCl) v(onCl) v(xCl.dip) v(xCl.din) v(opDh) v(onDh) v(xDh.dip) v(xDh.din) v(opDm) v(onDm) v(xDm.dip) v(xDm.din) v(opDl) v(onDl) v(xDl.dip) v(xDl.din) v(clk) i(vdd)
tran 5p 100n 0 20p
write <G1_RESULTS_ROOT>/r1_adc/r2-cmp-tran-tt-ib8u/cmp_tran.raw
.endc
.end
