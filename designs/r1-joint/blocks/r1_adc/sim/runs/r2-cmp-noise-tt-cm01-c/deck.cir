* tb_cmp2_noise.cir (generated by sim/r2/gen_cmp_decks.py) -- r1_cmp2 first stage, quasi-static noise
.lib /foss/pdks/ihp-sg13g2/libs.tech/ngspice/models/cornerMOSlv.lib mos_tt
.lib /foss/pdks/ihp-sg13g2/libs.tech/ngspice/models/cornerCAP.lib cap_typ
.lib /foss/pdks/ihp-sg13g2/libs.tech/ngspice/models/cornerMOShv.lib mos_tt
.lib /foss/pdks/ihp-sg13g2/libs.tech/ngspice/models/cornerRES.lib res_typ
.include schematic/r1_adc_r2.spice
.temp 27
Vdd vdd 0 1.2
Vclkb clkb 0 0
Vx vx 0 0.3
XB vbp vdd 0 r1_cmp2_bias ib=14u
VinpB inpB 0 DC 0.1 AC 1
VinnB innB 0 DC 0.1
XB inpB innB dpB dnB clkb vbp vdd 0 r1_cmp2_s1 wi=48u li=0.3u ngi=12 wt=16u wtc=8u ltc=0.5u
VdpB dpB vx 0
VdnB dnB vx 0
HB outB 0 poly(2) VdpB VdnB 0 1 -1
VinpE inpE 0 DC 0.1 AC 1
VinnE innE 0 DC 0.1
XE inpE innE dpE dnE clkb vbp vdd 0 r1_cmp2_s1 wi=96u li=0.25u ngi=16 wt=16u wtc=8u ltc=0.5u
VdpE dpE vx 0
VdnE dnE vx 0
HE outE 0 poly(2) VdpE VdnE 0 1 -1
VinpF inpF 0 DC 0.1 AC 1
VinnF innF 0 DC 0.1
XF inpF innF dpF dnF clkb vbp vdd 0 r1_cmp2_s1 wi=128u li=0.25u ngi=16 wt=16u wtc=8u ltc=0.5u
VdpF dpF vx 0
VdnF dnF vx 0
HF outF 0 poly(2) VdpF VdnF 0 1 -1
VinpG inpG 0 DC 0.1 AC 1
VinnG innG 0 DC 0.1
XG inpG innG dpG dnG clkb vbp vdd 0 r1_cmp2_s1 wi=64u li=0.3u ngi=16 wt=16u wtc=8u ltc=0.5u
VdpG dpG vx 0
VdnG dnG vx 0
HG outG 0 poly(2) VdpG VdnG 0 1 -1
VinpH inpH 0 DC 0.1 AC 1
VinnH innH 0 DC 0.1
XH inpH innH dpH dnH clkb vbp vdd 0 r1_cmp2_s1 wi=96u li=0.25u ngi=16 wt=16u wtc=8u ltc=0.5u
VdpH dpH vx 0
VdnH dnH vx 0
HH outH 0 poly(2) VdpH VdnH 0 1 -1
.control
set num_threads=1
set wr_singlescale
set wr_vecnames
op
print i(vdpB) i(vdnB)
ac lin 1 100e6 100e6
let cin_B = abs(imag(i(vinpB)))/(2*3.14159265*100e6)
let gm_B = abs(real(v(outB)))
print cin_B gm_B
noise v(outB) vinpB dec 20 1e3 1e11
setplot noise1
wrdata <G1_RESULTS_ROOT>/r1_adc/r2-cmp-noise-tt-cm01-c/noise_B.txt inoise_spectrum onoise_spectrum
destroy all
reset
op
print i(vdpE) i(vdnE)
ac lin 1 100e6 100e6
let cin_E = abs(imag(i(vinpE)))/(2*3.14159265*100e6)
let gm_E = abs(real(v(outE)))
print cin_E gm_E
noise v(outE) vinpE dec 20 1e3 1e11
setplot noise1
wrdata <G1_RESULTS_ROOT>/r1_adc/r2-cmp-noise-tt-cm01-c/noise_E.txt inoise_spectrum onoise_spectrum
destroy all
reset
op
print i(vdpF) i(vdnF)
ac lin 1 100e6 100e6
let cin_F = abs(imag(i(vinpF)))/(2*3.14159265*100e6)
let gm_F = abs(real(v(outF)))
print cin_F gm_F
noise v(outF) vinpF dec 20 1e3 1e11
setplot noise1
wrdata <G1_RESULTS_ROOT>/r1_adc/r2-cmp-noise-tt-cm01-c/noise_F.txt inoise_spectrum onoise_spectrum
destroy all
reset
op
print i(vdpG) i(vdnG)
ac lin 1 100e6 100e6
let cin_G = abs(imag(i(vinpG)))/(2*3.14159265*100e6)
let gm_G = abs(real(v(outG)))
print cin_G gm_G
noise v(outG) vinpG dec 20 1e3 1e11
setplot noise1
wrdata <G1_RESULTS_ROOT>/r1_adc/r2-cmp-noise-tt-cm01-c/noise_G.txt inoise_spectrum onoise_spectrum
destroy all
reset
op
print i(vdpH) i(vdnH)
ac lin 1 100e6 100e6
let cin_H = abs(imag(i(vinpH)))/(2*3.14159265*100e6)
let gm_H = abs(real(v(outH)))
print cin_H gm_H
noise v(outH) vinpH dec 20 1e3 1e11
setplot noise1
wrdata <G1_RESULTS_ROOT>/r1_adc/r2-cmp-noise-tt-cm01-c/noise_H.txt inoise_spectrum onoise_spectrum
destroy all
reset
.endc
.end
