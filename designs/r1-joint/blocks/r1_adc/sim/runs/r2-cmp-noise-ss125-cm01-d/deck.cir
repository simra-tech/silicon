* tb_cmp2_noise.cir (generated by sim/r2/gen_cmp_decks.py) -- r1_cmp2 first stage, quasi-static noise
.lib /foss/pdks/ihp-sg13g2/libs.tech/ngspice/models/cornerMOSlv.lib mos_ss
.lib /foss/pdks/ihp-sg13g2/libs.tech/ngspice/models/cornerCAP.lib cap_typ
.lib /foss/pdks/ihp-sg13g2/libs.tech/ngspice/models/cornerMOShv.lib mos_ss
.lib /foss/pdks/ihp-sg13g2/libs.tech/ngspice/models/cornerRES.lib res_typ
.include schematic/r1_adc_r2.spice
.temp 125
Vdd vdd 0 1.08
Vclkb clkb 0 0
Vx vx 0 0.3
XB vbp vdd 0 r1_cmp2_bias ib=14u
VinpB inpB 0 DC 0.1 AC 1
VinnB innB 0 DC 0.1
XB inpB innB dpB dnB clkb vbp vdd 0 r1_cmp2_s1 wi=48u li=0.3u ngi=12 wt=16u wtc=8u ltc=0.5u
VdpB dpB vx 0
VdnB dnB vx 0
HB outB 0 poly(2) VdpB VdnB 0 1 -1
VinpB12 inpB12 0 DC 0.1 AC 1
VinnB12 innB12 0 DC 0.1
XB12 inpB12 innB12 dpB12 dnB12 clkb vbp vdd 0 r1_cmp2_s1 wi=48u li=0.3u ngi=12 wt=16u wtc=12u ltc=0.5u
VdpB12 dpB12 vx 0
VdnB12 dnB12 vx 0
HB12 outB12 0 poly(2) VdpB12 VdnB12 0 1 -1
VinpB16 inpB16 0 DC 0.1 AC 1
VinnB16 innB16 0 DC 0.1
XB16 inpB16 innB16 dpB16 dnB16 clkb vbp vdd 0 r1_cmp2_s1 wi=48u li=0.3u ngi=12 wt=16u wtc=16u ltc=0.5u
VdpB16 dpB16 vx 0
VdnB16 dnB16 vx 0
HB16 outB16 0 poly(2) VdpB16 VdnB16 0 1 -1
.control
set num_threads=1
set wr_singlescale
set wr_vecnames
op
print i(vdpB) i(vdnB)
ac lin 1 100e6 100e6
let cin_B = abs(imag(i(vinpB)))/(2*3.14159265*100e6)
let gm_B = abs(real(v(outB)))
print cin_B gm_B
noise v(outB) vinpB dec 20 1e3 1e11
setplot noise1
wrdata <G1_RESULTS_ROOT>/r1_adc/r2-cmp-noise-ss125-cm01-d/noise_B.txt inoise_spectrum onoise_spectrum
destroy all
reset
op
print i(vdpB12) i(vdnB12)
ac lin 1 100e6 100e6
let cin_B12 = abs(imag(i(vinpB12)))/(2*3.14159265*100e6)
let gm_B12 = abs(real(v(outB12)))
print cin_B12 gm_B12
noise v(outB12) vinpB12 dec 20 1e3 1e11
setplot noise1
wrdata <G1_RESULTS_ROOT>/r1_adc/r2-cmp-noise-ss125-cm01-d/noise_B12.txt inoise_spectrum onoise_spectrum
destroy all
reset
op
print i(vdpB16) i(vdnB16)
ac lin 1 100e6 100e6
let cin_B16 = abs(imag(i(vinpB16)))/(2*3.14159265*100e6)
let gm_B16 = abs(real(v(outB16)))
print cin_B16 gm_B16
noise v(outB16) vinpB16 dec 20 1e3 1e11
setplot noise1
wrdata <G1_RESULTS_ROOT>/r1_adc/r2-cmp-noise-ss125-cm01-d/noise_B16.txt inoise_spectrum onoise_spectrum
destroy all
reset
.endc
.end
