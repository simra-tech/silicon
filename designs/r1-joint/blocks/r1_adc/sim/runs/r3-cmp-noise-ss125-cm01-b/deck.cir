* tb_cmp3_noise.cir (generated by sim/r3/gen_cmp3_decks.py) -- r1_cmp3 first stage, quasi-static noise
.lib /foss/pdks/ihp-sg13g2/libs.tech/ngspice/models/cornerMOSlv.lib mos_ss
.lib /foss/pdks/ihp-sg13g2/libs.tech/ngspice/models/cornerCAP.lib cap_typ
.lib /foss/pdks/ihp-sg13g2/libs.tech/ngspice/models/cornerRES.lib res_typ
.include schematic/r1_adc_r3.spice
.temp 125
Vdd vdd 0 1.08
Vclkb clkb 0 0
Vx vx 0 0.3
XBr56a vbpr56a vdd 0 r1_cmp3_bias rbw=1u rbl=100u
Vinpr56a inpr56a 0 DC 0.1 AC 1
Vinnr56a innr56a 0 DC 0.1
Xr56a inpr56a innr56a dpr56a dnr56a clkb vbpr56a vdd 0 r1_cmp3_s1
Vdpr56a dpr56a vx 0
Vdnr56a dnr56a vx 0
Hr56a outr56a 0 poly(2) Vdpr56a Vdnr56a 0 1 -1
XBr56b vbpr56b vdd 0 r1_cmp3_bias rbw=1u rbl=115u
Vinpr56b inpr56b 0 DC 0.1 AC 1
Vinnr56b innr56b 0 DC 0.1
Xr56b inpr56b innr56b dpr56b dnr56b clkb vbpr56b vdd 0 r1_cmp3_s1
Vdpr56b dpr56b vx 0
Vdnr56b dnr56b vx 0
Hr56b outr56b 0 poly(2) Vdpr56b Vdnr56b 0 1 -1
XBr56c vbpr56c vdd 0 r1_cmp3_bias rbw=1u rbl=130u
Vinpr56c inpr56c 0 DC 0.1 AC 1
Vinnr56c innr56c 0 DC 0.1
Xr56c inpr56c innr56c dpr56c dnr56c clkb vbpr56c vdd 0 r1_cmp3_s1
Vdpr56c dpr56c vx 0
Vdnr56c dnr56c vx 0
Hr56c outr56c 0 poly(2) Vdpr56c Vdnr56c 0 1 -1
XBr64a vbpr64a vdd 0 r1_cmp3_bias rbw=1u rbl=100u
Vinpr64a inpr64a 0 DC 0.1 AC 1
Vinnr64a innr64a 0 DC 0.1
Xr64a inpr64a innr64a dpr64a dnr64a clkb vbpr64a vdd 0 r1_cmp3_s1
Vdpr64a dpr64a vx 0
Vdnr64a dnr64a vx 0
Hr64a outr64a 0 poly(2) Vdpr64a Vdnr64a 0 1 -1
XBr64b vbpr64b vdd 0 r1_cmp3_bias rbw=1u rbl=115u
Vinpr64b inpr64b 0 DC 0.1 AC 1
Vinnr64b innr64b 0 DC 0.1
Xr64b inpr64b innr64b dpr64b dnr64b clkb vbpr64b vdd 0 r1_cmp3_s1
Vdpr64b dpr64b vx 0
Vdnr64b dnr64b vx 0
Hr64b outr64b 0 poly(2) Vdpr64b Vdnr64b 0 1 -1
XBr64c vbpr64c vdd 0 r1_cmp3_bias rbw=1u rbl=130u
Vinpr64c inpr64c 0 DC 0.1 AC 1
Vinnr64c innr64c 0 DC 0.1
Xr64c inpr64c innr64c dpr64c dnr64c clkb vbpr64c vdd 0 r1_cmp3_s1
Vdpr64c dpr64c vx 0
Vdnr64c dnr64c vx 0
Hr64c outr64c 0 poly(2) Vdpr64c Vdnr64c 0 1 -1
.control
set num_threads=1
set wr_singlescale
set wr_vecnames
op
print i(vdpr56a) i(vdnr56a) v(vbpr56a)
noise v(outr56a) vinpr56a dec 20 1e3 1e11
setplot noise1
wrdata <G1_RESULTS_ROOT>/r1_adc/r3-cmp-noise-ss125-cm01-b/noise_r56a.txt inoise_spectrum onoise_spectrum
destroy all
reset
op
print i(vdpr56b) i(vdnr56b) v(vbpr56b)
noise v(outr56b) vinpr56b dec 20 1e3 1e11
setplot noise1
wrdata <G1_RESULTS_ROOT>/r1_adc/r3-cmp-noise-ss125-cm01-b/noise_r56b.txt inoise_spectrum onoise_spectrum
destroy all
reset
op
print i(vdpr56c) i(vdnr56c) v(vbpr56c)
noise v(outr56c) vinpr56c dec 20 1e3 1e11
setplot noise1
wrdata <G1_RESULTS_ROOT>/r1_adc/r3-cmp-noise-ss125-cm01-b/noise_r56c.txt inoise_spectrum onoise_spectrum
destroy all
reset
op
print i(vdpr64a) i(vdnr64a) v(vbpr64a)
noise v(outr64a) vinpr64a dec 20 1e3 1e11
setplot noise1
wrdata <G1_RESULTS_ROOT>/r1_adc/r3-cmp-noise-ss125-cm01-b/noise_r64a.txt inoise_spectrum onoise_spectrum
destroy all
reset
op
print i(vdpr64b) i(vdnr64b) v(vbpr64b)
noise v(outr64b) vinpr64b dec 20 1e3 1e11
setplot noise1
wrdata <G1_RESULTS_ROOT>/r1_adc/r3-cmp-noise-ss125-cm01-b/noise_r64b.txt inoise_spectrum onoise_spectrum
destroy all
reset
op
print i(vdpr64c) i(vdnr64c) v(vbpr64c)
noise v(outr64c) vinpr64c dec 20 1e3 1e11
setplot noise1
wrdata <G1_RESULTS_ROOT>/r1_adc/r3-cmp-noise-ss125-cm01-b/noise_r64c.txt inoise_spectrum onoise_spectrum
destroy all
reset
.endc
.end
