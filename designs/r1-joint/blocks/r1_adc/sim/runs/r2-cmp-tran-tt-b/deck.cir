* tb_cmp2_tran.cir (generated by sim/r2/gen_cmp_decks.py) -- r1_cmp2 variants, decision dynamics
.lib /foss/pdks/ihp-sg13g2/libs.tech/ngspice/models/cornerMOSlv.lib mos_tt
.lib /foss/pdks/ihp-sg13g2/libs.tech/ngspice/models/cornerCAP.lib cap_typ
.lib /foss/pdks/ihp-sg13g2/libs.tech/ngspice/models/cornerMOShv.lib mos_tt
.lib /foss/pdks/ihp-sg13g2/libs.tech/ngspice/models/cornerRES.lib res_typ
.include schematic/r1_adc_r2.spice
.temp 27
.option reltol=1e-4 vntol=1e-7 abstol=1e-13 method=gear
Vdd vdd 0 1.2
Vclk clk 0 PULSE(0 1.2 2n 50p 50p 16.6167n 33.3333n)
Vclkb clkb 0 PULSE(1.2 0 2n 50p 50p 16.6167n 33.3333n)
VpV0h ipV0h 0 0.6001
VnV0h inV0h 0 0.5999
XV0h ipV0h inV0h clk clkb opV0h onV0h vdd 0 r1_cmp2 wi=16u li=0.2u ngi=4 wt=8u wcap=0.15u lcap=0.13u wr=1u wh=2u
VpV0l ipV0l 0 0.1001
VnV0l inV0l 0 0.0999
XV0l ipV0l inV0l clk clkb opV0l onV0l vdd 0 r1_cmp2 wi=16u li=0.2u ngi=4 wt=8u wcap=0.15u lcap=0.13u wr=1u wh=2u
VpV1h ipV1h 0 0.6001
VnV1h inV1h 0 0.5999
XV1h ipV1h inV1h clk clkb opV1h onV1h vdd 0 r1_cmp2 wi=48u li=0.3u ngi=12 wt=16u wcap=12u lcap=4u wr=2u wh=2u
VpV1l ipV1l 0 0.1001
VnV1l inV1l 0 0.0999
XV1l ipV1l inV1l clk clkb opV1l onV1l vdd 0 r1_cmp2 wi=48u li=0.3u ngi=12 wt=16u wcap=12u lcap=4u wr=2u wh=2u
VpV1h8h ipV1h8h 0 0.6001
VnV1h8h inV1h8h 0 0.5999
XV1h8h ipV1h8h inV1h8h clk clkb opV1h8h onV1h8h vdd 0 r1_cmp2 wi=48u li=0.3u ngi=12 wt=16u wcap=12u lcap=4u wr=2u wh=8u
VpV1h8l ipV1h8l 0 0.1001
VnV1h8l inV1h8l 0 0.0999
XV1h8l ipV1h8l inV1h8l clk clkb opV1h8l onV1h8l vdd 0 r1_cmp2 wi=48u li=0.3u ngi=12 wt=16u wcap=12u lcap=4u wr=2u wh=8u
VpV1h16h ipV1h16h 0 0.6001
VnV1h16h inV1h16h 0 0.5999
XV1h16h ipV1h16h inV1h16h clk clkb opV1h16h onV1h16h vdd 0 r1_cmp2 wi=48u li=0.3u ngi=12 wt=16u wcap=12u lcap=4u wr=2u wh=16u
VpV1h16l ipV1h16l 0 0.1001
VnV1h16l inV1h16l 0 0.0999
XV1h16l ipV1h16l inV1h16l clk clkb opV1h16l onV1h16l vdd 0 r1_cmp2 wi=48u li=0.3u ngi=12 wt=16u wcap=12u lcap=4u wr=2u wh=16u
VpV2h8h ipV2h8h 0 0.6001
VnV2h8h inV2h8h 0 0.5999
XV2h8h ipV2h8h inV2h8h clk clkb opV2h8h onV2h8h vdd 0 r1_cmp2 wi=48u li=0.3u ngi=12 wt=16u wcap=6u lcap=4u wr=2u wh=8u
VpV2h8l ipV2h8l 0 0.1001
VnV2h8l inV2h8l 0 0.0999
XV2h8l ipV2h8l inV2h8l clk clkb opV2h8l onV2h8l vdd 0 r1_cmp2 wi=48u li=0.3u ngi=12 wt=16u wcap=6u lcap=4u wr=2u wh=8u
VpV3h8h ipV3h8h 0 0.6001
VnV3h8h inV3h8h 0 0.5999
XV3h8h ipV3h8h inV3h8h clk clkb opV3h8h onV3h8h vdd 0 r1_cmp2 wi=32u li=0.3u ngi=8 wt=16u wcap=8u lcap=4u wr=2u wh=8u
VpV3h8l ipV3h8l 0 0.1001
VnV3h8l inV3h8l 0 0.0999
XV3h8l ipV3h8l inV3h8l clk clkb opV3h8l onV3h8l vdd 0 r1_cmp2 wi=32u li=0.3u ngi=8 wt=16u wcap=8u lcap=4u wr=2u wh=8u
.control
set num_threads=1
save v(opV0h) v(onV0h) v(xV0h.dip) v(xV0h.din) v(opV0l) v(onV0l) v(xV0l.dip) v(xV0l.din) v(opV1h) v(onV1h) v(xV1h.dip) v(xV1h.din) v(opV1l) v(onV1l) v(xV1l.dip) v(xV1l.din) v(opV1h8h) v(onV1h8h) v(xV1h8h.dip) v(xV1h8h.din) v(opV1h8l) v(onV1h8l) v(xV1h8l.dip) v(xV1h8l.din) v(opV1h16h) v(onV1h16h) v(xV1h16h.dip) v(xV1h16h.din) v(opV1h16l) v(onV1h16l) v(xV1h16l.dip) v(xV1h16l.din) v(opV2h8h) v(onV2h8h) v(xV2h8h.dip) v(xV2h8h.din) v(opV2h8l) v(onV2h8l) v(xV2h8l.dip) v(xV2h8l.din) v(opV3h8h) v(onV3h8h) v(xV3h8h.dip) v(xV3h8h.din) v(opV3h8l) v(onV3h8l) v(xV3h8l.dip) v(xV3h8l.din) v(clk) i(vdd)
tran 5p 70n 0 10p
write <G1_RESULTS_ROOT>/r1_adc/r2-cmp-tran-tt-b/cmp_tran.raw
.endc
.end
