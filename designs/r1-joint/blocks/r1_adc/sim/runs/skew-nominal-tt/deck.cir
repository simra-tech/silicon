* tb_th_skew_nominal.cir (generated by gen_tb_th_skew.py) -- T/H sampling skew, 10 copies
.lib /foss/pdks/ihp-sg13g2/libs.tech/ngspice/models/cornerMOSlv.lib mos_tt
.lib /foss/pdks/ihp-sg13g2/libs.tech/ngspice/models/cornerCAP.lib cap_typ
.include schematic/r1_adc.spice
.temp 27
.option reltol=1e-4 vntol=1e-7 abstol=1e-13 method=trap
Vdd vdd 0 1.2
Vref vref 0 1.2
* common track signal: high until t_edge (50 ps fall), as distributed from one r1_ctrl output
Vtrk trk 0 PWL(0 1.2 9.9975e-08 1.2 1.00025e-07 0)
Vz z 0 0
Vcm cm 0 0.6
* copy 0: V0 = -0.9 V, S = 2e+07 V/s
Bp0 ip0 0 v=0.6+(-0.9+2e+07*(time-1e-07))/2
Bn0 in0 0 v=0.6-(-0.9+2e+07*(time-1e-07))/2
XTHa0 ip0 in0 cm cm trk z tap0 tan0 z z z z z z z z z z z z z z z z z z z z z z vdd vref 0 r1_th
Ccap0 tap0 0 30f
Ccan0 tan0 0 30f
XTHb0 ip0 in0 cm cm trk z tbp0 tbn0 z z z z z z z z z z z z z z z z z z z z z z vdd vref 0 r1_th
Ccbp0 tbp0 0 30f
Ccbn0 tbn0 0 30f
* copy 1: V0 = -0.9 V, S = -2e+07 V/s
Bp1 ip1 0 v=0.6+(-0.9+-2e+07*(time-1e-07))/2
Bn1 in1 0 v=0.6-(-0.9+-2e+07*(time-1e-07))/2
XTHa1 ip1 in1 cm cm trk z tap1 tan1 z z z z z z z z z z z z z z z z z z z z z z vdd vref 0 r1_th
Ccap1 tap1 0 30f
Ccan1 tan1 0 30f
XTHb1 ip1 in1 cm cm trk z tbp1 tbn1 z z z z z z z z z z z z z z z z z z z z z z vdd vref 0 r1_th
Ccbp1 tbp1 0 30f
Ccbn1 tbn1 0 30f
* copy 2: V0 = -0.45 V, S = 2e+07 V/s
Bp2 ip2 0 v=0.6+(-0.45+2e+07*(time-1e-07))/2
Bn2 in2 0 v=0.6-(-0.45+2e+07*(time-1e-07))/2
XTHa2 ip2 in2 cm cm trk z tap2 tan2 z z z z z z z z z z z z z z z z z z z z z z vdd vref 0 r1_th
Ccap2 tap2 0 30f
Ccan2 tan2 0 30f
XTHb2 ip2 in2 cm cm trk z tbp2 tbn2 z z z z z z z z z z z z z z z z z z z z z z vdd vref 0 r1_th
Ccbp2 tbp2 0 30f
Ccbn2 tbn2 0 30f
* copy 3: V0 = -0.45 V, S = -2e+07 V/s
Bp3 ip3 0 v=0.6+(-0.45+-2e+07*(time-1e-07))/2
Bn3 in3 0 v=0.6-(-0.45+-2e+07*(time-1e-07))/2
XTHa3 ip3 in3 cm cm trk z tap3 tan3 z z z z z z z z z z z z z z z z z z z z z z vdd vref 0 r1_th
Ccap3 tap3 0 30f
Ccan3 tan3 0 30f
XTHb3 ip3 in3 cm cm trk z tbp3 tbn3 z z z z z z z z z z z z z z z z z z z z z z vdd vref 0 r1_th
Ccbp3 tbp3 0 30f
Ccbn3 tbn3 0 30f
* copy 4: V0 = 0 V, S = 2e+07 V/s
Bp4 ip4 0 v=0.6+(0+2e+07*(time-1e-07))/2
Bn4 in4 0 v=0.6-(0+2e+07*(time-1e-07))/2
XTHa4 ip4 in4 cm cm trk z tap4 tan4 z z z z z z z z z z z z z z z z z z z z z z vdd vref 0 r1_th
Ccap4 tap4 0 30f
Ccan4 tan4 0 30f
XTHb4 ip4 in4 cm cm trk z tbp4 tbn4 z z z z z z z z z z z z z z z z z z z z z z vdd vref 0 r1_th
Ccbp4 tbp4 0 30f
Ccbn4 tbn4 0 30f
* copy 5: V0 = 0 V, S = -2e+07 V/s
Bp5 ip5 0 v=0.6+(0+-2e+07*(time-1e-07))/2
Bn5 in5 0 v=0.6-(0+-2e+07*(time-1e-07))/2
XTHa5 ip5 in5 cm cm trk z tap5 tan5 z z z z z z z z z z z z z z z z z z z z z z vdd vref 0 r1_th
Ccap5 tap5 0 30f
Ccan5 tan5 0 30f
XTHb5 ip5 in5 cm cm trk z tbp5 tbn5 z z z z z z z z z z z z z z z z z z z z z z vdd vref 0 r1_th
Ccbp5 tbp5 0 30f
Ccbn5 tbn5 0 30f
* copy 6: V0 = 0.45 V, S = 2e+07 V/s
Bp6 ip6 0 v=0.6+(0.45+2e+07*(time-1e-07))/2
Bn6 in6 0 v=0.6-(0.45+2e+07*(time-1e-07))/2
XTHa6 ip6 in6 cm cm trk z tap6 tan6 z z z z z z z z z z z z z z z z z z z z z z vdd vref 0 r1_th
Ccap6 tap6 0 30f
Ccan6 tan6 0 30f
XTHb6 ip6 in6 cm cm trk z tbp6 tbn6 z z z z z z z z z z z z z z z z z z z z z z vdd vref 0 r1_th
Ccbp6 tbp6 0 30f
Ccbn6 tbn6 0 30f
* copy 7: V0 = 0.45 V, S = -2e+07 V/s
Bp7 ip7 0 v=0.6+(0.45+-2e+07*(time-1e-07))/2
Bn7 in7 0 v=0.6-(0.45+-2e+07*(time-1e-07))/2
XTHa7 ip7 in7 cm cm trk z tap7 tan7 z z z z z z z z z z z z z z z z z z z z z z vdd vref 0 r1_th
Ccap7 tap7 0 30f
Ccan7 tan7 0 30f
XTHb7 ip7 in7 cm cm trk z tbp7 tbn7 z z z z z z z z z z z z z z z z z z z z z z vdd vref 0 r1_th
Ccbp7 tbp7 0 30f
Ccbn7 tbn7 0 30f
* copy 8: V0 = 0.9 V, S = 2e+07 V/s
Bp8 ip8 0 v=0.6+(0.9+2e+07*(time-1e-07))/2
Bn8 in8 0 v=0.6-(0.9+2e+07*(time-1e-07))/2
XTHa8 ip8 in8 cm cm trk z tap8 tan8 z z z z z z z z z z z z z z z z z z z z z z vdd vref 0 r1_th
Ccap8 tap8 0 30f
Ccan8 tan8 0 30f
XTHb8 ip8 in8 cm cm trk z tbp8 tbn8 z z z z z z z z z z z z z z z z z z z z z z vdd vref 0 r1_th
Ccbp8 tbp8 0 30f
Ccbn8 tbn8 0 30f
* copy 9: V0 = 0.9 V, S = -2e+07 V/s
Bp9 ip9 0 v=0.6+(0.9+-2e+07*(time-1e-07))/2
Bn9 in9 0 v=0.6-(0.9+-2e+07*(time-1e-07))/2
XTHa9 ip9 in9 cm cm trk z tap9 tan9 z z z z z z z z z z z z z z z z z z z z z z vdd vref 0 r1_th
Ccap9 tap9 0 30f
Ccan9 tan9 0 30f
XTHb9 ip9 in9 cm cm trk z tbp9 tbn9 z z z z z z z z z z z z z z z z z z z z z z vdd vref 0 r1_th
Ccbp9 tbp9 0 30f
Ccbn9 tbn9 0 30f
* 30 fF per top node: comparator input load (r1_cmp input pair gate, estimated)
.control
set num_threads=1
tran 10p 1.12e-07 0 20p
meas tran ha0 find v(tap0,tan0) at=1.1e-07
meas tran da0 find v(tap0,tan0) at=1.105e-07
meas tran hb0 find v(tbp0,tbn0) at=1.1e-07
meas tran db0 find v(tbp0,tbn0) at=1.105e-07
meas tran ha1 find v(tap1,tan1) at=1.1e-07
meas tran da1 find v(tap1,tan1) at=1.105e-07
meas tran hb1 find v(tbp1,tbn1) at=1.1e-07
meas tran db1 find v(tbp1,tbn1) at=1.105e-07
meas tran ha2 find v(tap2,tan2) at=1.1e-07
meas tran da2 find v(tap2,tan2) at=1.105e-07
meas tran hb2 find v(tbp2,tbn2) at=1.1e-07
meas tran db2 find v(tbp2,tbn2) at=1.105e-07
meas tran ha3 find v(tap3,tan3) at=1.1e-07
meas tran da3 find v(tap3,tan3) at=1.105e-07
meas tran hb3 find v(tbp3,tbn3) at=1.1e-07
meas tran db3 find v(tbp3,tbn3) at=1.105e-07
meas tran ha4 find v(tap4,tan4) at=1.1e-07
meas tran da4 find v(tap4,tan4) at=1.105e-07
meas tran hb4 find v(tbp4,tbn4) at=1.1e-07
meas tran db4 find v(tbp4,tbn4) at=1.105e-07
meas tran ha5 find v(tap5,tan5) at=1.1e-07
meas tran da5 find v(tap5,tan5) at=1.105e-07
meas tran hb5 find v(tbp5,tbn5) at=1.1e-07
meas tran db5 find v(tbp5,tbn5) at=1.105e-07
meas tran ha6 find v(tap6,tan6) at=1.1e-07
meas tran da6 find v(tap6,tan6) at=1.105e-07
meas tran hb6 find v(tbp6,tbn6) at=1.1e-07
meas tran db6 find v(tbp6,tbn6) at=1.105e-07
meas tran ha7 find v(tap7,tan7) at=1.1e-07
meas tran da7 find v(tap7,tan7) at=1.105e-07
meas tran hb7 find v(tbp7,tbn7) at=1.1e-07
meas tran db7 find v(tbp7,tbn7) at=1.105e-07
meas tran ha8 find v(tap8,tan8) at=1.1e-07
meas tran da8 find v(tap8,tan8) at=1.105e-07
meas tran hb8 find v(tbp8,tbn8) at=1.1e-07
meas tran db8 find v(tbp8,tbn8) at=1.105e-07
meas tran ha9 find v(tap9,tan9) at=1.1e-07
meas tran da9 find v(tap9,tan9) at=1.105e-07
meas tran hb9 find v(tbp9,tbn9) at=1.1e-07
meas tran db9 find v(tbp9,tbn9) at=1.105e-07
write <G1_RESULTS_ROOT>/r1_adc/skew-nominal-tt/tb.raw
.endc
.end
