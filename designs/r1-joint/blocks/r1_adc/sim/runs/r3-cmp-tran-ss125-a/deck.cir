* tb_cmp3_tran.cir (generated by sim/r3/gen_cmp3_decks.py) -- r1_cmp3 variants, decision dynamics, rev-3 clock
.lib /foss/pdks/ihp-sg13g2/libs.tech/ngspice/models/cornerMOSlv.lib mos_ss
.lib /foss/pdks/ihp-sg13g2/libs.tech/ngspice/models/cornerCAP.lib cap_typ
.lib /foss/pdks/ihp-sg13g2/libs.tech/ngspice/models/cornerRES.lib res_typ
.include schematic/r1_adc_r3.spice
.temp 125
.option reltol=1e-4 vntol=1e-7 abstol=1e-13 method=gear
Vdd vdd 0 1.08
Vclk clk 0 PULSE(0 1.08 1n 50p 50p 13.45n 16.6667n)
Vclkb clkb 0 PULSE(1.08 0 1n 50p 50p 13.45n 16.6667n)
V_i16 vdd_i16 vdd 0
XBi16 vbpi16 vdd_i16 0 r1_cmp3_ibias ib=14u
Vpi16h ipi16h 0 0.6001
Vni16h ini16h 0 0.5999
Xi16h ipi16h ini16h clk clkb opi16h oni16h vbpi16 vdd_i16 0 r1_cmp3 wcap=16u
Vpi16m ipi16m 0 0.3501
Vni16m ini16m 0 0.3499
Xi16m ipi16m ini16m clk clkb opi16m oni16m vbpi16 vdd_i16 0 r1_cmp3 wcap=16u
Vpi16l ipi16l 0 0.1001
Vni16l ini16l 0 0.0999
Xi16l ipi16l ini16l clk clkb opi16l oni16l vbpi16 vdd_i16 0 r1_cmp3 wcap=16u
V_i32 vdd_i32 vdd 0
XBi32 vbpi32 vdd_i32 0 r1_cmp3_ibias ib=14u
Vpi32h ipi32h 0 0.6001
Vni32h ini32h 0 0.5999
Xi32h ipi32h ini32h clk clkb opi32h oni32h vbpi32 vdd_i32 0 r1_cmp3 wcap=32u
Vpi32m ipi32m 0 0.3501
Vni32m ini32m 0 0.3499
Xi32m ipi32m ini32m clk clkb opi32m oni32m vbpi32 vdd_i32 0 r1_cmp3 wcap=32u
Vpi32l ipi32l 0 0.1001
Vni32l ini32l 0 0.0999
Xi32l ipi32l ini32l clk clkb opi32l oni32l vbpi32 vdd_i32 0 r1_cmp3 wcap=32u
V_r24a vdd_r24a vdd 0
XBr24a vbpr24a vdd_r24a 0 r1_cmp3_bias rbw=1u rbl=80u
Vpr24ah ipr24ah 0 0.6001
Vnr24ah inr24ah 0 0.5999
Xr24ah ipr24ah inr24ah clk clkb opr24ah onr24ah vbpr24a vdd_r24a 0 r1_cmp3 wcap=24u
Vpr24am ipr24am 0 0.3501
Vnr24am inr24am 0 0.3499
Xr24am ipr24am inr24am clk clkb opr24am onr24am vbpr24a vdd_r24a 0 r1_cmp3 wcap=24u
Vpr24al ipr24al 0 0.1001
Vnr24al inr24al 0 0.0999
Xr24al ipr24al inr24al clk clkb opr24al onr24al vbpr24a vdd_r24a 0 r1_cmp3 wcap=24u
V_r24b vdd_r24b vdd 0
XBr24b vbpr24b vdd_r24b 0 r1_cmp3_bias rbw=1u rbl=120u
Vpr24bh ipr24bh 0 0.6001
Vnr24bh inr24bh 0 0.5999
Xr24bh ipr24bh inr24bh clk clkb opr24bh onr24bh vbpr24b vdd_r24b 0 r1_cmp3 wcap=24u
Vpr24bm ipr24bm 0 0.3501
Vnr24bm inr24bm 0 0.3499
Xr24bm ipr24bm inr24bm clk clkb opr24bm onr24bm vbpr24b vdd_r24b 0 r1_cmp3 wcap=24u
Vpr24bl ipr24bl 0 0.1001
Vnr24bl inr24bl 0 0.0999
Xr24bl ipr24bl inr24bl clk clkb opr24bl onr24bl vbpr24b vdd_r24b 0 r1_cmp3 wcap=24u
V_r32a vdd_r32a vdd 0
XBr32a vbpr32a vdd_r32a 0 r1_cmp3_bias rbw=1u rbl=80u
Vpr32ah ipr32ah 0 0.6001
Vnr32ah inr32ah 0 0.5999
Xr32ah ipr32ah inr32ah clk clkb opr32ah onr32ah vbpr32a vdd_r32a 0 r1_cmp3 wcap=32u
Vpr32am ipr32am 0 0.3501
Vnr32am inr32am 0 0.3499
Xr32am ipr32am inr32am clk clkb opr32am onr32am vbpr32a vdd_r32a 0 r1_cmp3 wcap=32u
Vpr32al ipr32al 0 0.1001
Vnr32al inr32al 0 0.0999
Xr32al ipr32al inr32al clk clkb opr32al onr32al vbpr32a vdd_r32a 0 r1_cmp3 wcap=32u
V_r32b vdd_r32b vdd 0
XBr32b vbpr32b vdd_r32b 0 r1_cmp3_bias rbw=1u rbl=120u
Vpr32bh ipr32bh 0 0.6001
Vnr32bh inr32bh 0 0.5999
Xr32bh ipr32bh inr32bh clk clkb opr32bh onr32bh vbpr32b vdd_r32b 0 r1_cmp3 wcap=32u
Vpr32bm ipr32bm 0 0.3501
Vnr32bm inr32bm 0 0.3499
Xr32bm ipr32bm inr32bm clk clkb opr32bm onr32bm vbpr32b vdd_r32b 0 r1_cmp3 wcap=32u
Vpr32bl ipr32bl 0 0.1001
Vnr32bl inr32bl 0 0.0999
Xr32bl ipr32bl inr32bl clk clkb opr32bl onr32bl vbpr32b vdd_r32b 0 r1_cmp3 wcap=32u
V_r32c vdd_r32c vdd 0
XBr32c vbpr32c vdd_r32c 0 r1_cmp3_bias rbw=1u rbl=160u
Vpr32ch ipr32ch 0 0.6001
Vnr32ch inr32ch 0 0.5999
Xr32ch ipr32ch inr32ch clk clkb opr32ch onr32ch vbpr32c vdd_r32c 0 r1_cmp3 wcap=32u
Vpr32cm ipr32cm 0 0.3501
Vnr32cm inr32cm 0 0.3499
Xr32cm ipr32cm inr32cm clk clkb opr32cm onr32cm vbpr32c vdd_r32c 0 r1_cmp3 wcap=32u
Vpr32cl ipr32cl 0 0.1001
Vnr32cl inr32cl 0 0.0999
Xr32cl ipr32cl inr32cl clk clkb opr32cl onr32cl vbpr32c vdd_r32c 0 r1_cmp3 wcap=32u
V_r40a vdd_r40a vdd 0
XBr40a vbpr40a vdd_r40a 0 r1_cmp3_bias rbw=1u rbl=80u
Vpr40ah ipr40ah 0 0.6001
Vnr40ah inr40ah 0 0.5999
Xr40ah ipr40ah inr40ah clk clkb opr40ah onr40ah vbpr40a vdd_r40a 0 r1_cmp3 wcap=40u
Vpr40am ipr40am 0 0.3501
Vnr40am inr40am 0 0.3499
Xr40am ipr40am inr40am clk clkb opr40am onr40am vbpr40a vdd_r40a 0 r1_cmp3 wcap=40u
Vpr40al ipr40al 0 0.1001
Vnr40al inr40al 0 0.0999
Xr40al ipr40al inr40al clk clkb opr40al onr40al vbpr40a vdd_r40a 0 r1_cmp3 wcap=40u
V_r40b vdd_r40b vdd 0
XBr40b vbpr40b vdd_r40b 0 r1_cmp3_bias rbw=1u rbl=120u
Vpr40bh ipr40bh 0 0.6001
Vnr40bh inr40bh 0 0.5999
Xr40bh ipr40bh inr40bh clk clkb opr40bh onr40bh vbpr40b vdd_r40b 0 r1_cmp3 wcap=40u
Vpr40bm ipr40bm 0 0.3501
Vnr40bm inr40bm 0 0.3499
Xr40bm ipr40bm inr40bm clk clkb opr40bm onr40bm vbpr40b vdd_r40b 0 r1_cmp3 wcap=40u
Vpr40bl ipr40bl 0 0.1001
Vnr40bl inr40bl 0 0.0999
Xr40bl ipr40bl inr40bl clk clkb opr40bl onr40bl vbpr40b vdd_r40b 0 r1_cmp3 wcap=40u
V_r40c vdd_r40c vdd 0
XBr40c vbpr40c vdd_r40c 0 r1_cmp3_bias rbw=1u rbl=160u
Vpr40ch ipr40ch 0 0.6001
Vnr40ch inr40ch 0 0.5999
Xr40ch ipr40ch inr40ch clk clkb opr40ch onr40ch vbpr40c vdd_r40c 0 r1_cmp3 wcap=40u
Vpr40cm ipr40cm 0 0.3501
Vnr40cm inr40cm 0 0.3499
Xr40cm ipr40cm inr40cm clk clkb opr40cm onr40cm vbpr40c vdd_r40c 0 r1_cmp3 wcap=40u
Vpr40cl ipr40cl 0 0.1001
Vnr40cl inr40cl 0 0.0999
Xr40cl ipr40cl inr40cl clk clkb opr40cl onr40cl vbpr40c vdd_r40c 0 r1_cmp3 wcap=40u
.control
set num_threads=1
save v(vbpi16) v(opi16h) v(oni16h) v(xi16h.dip) v(xi16h.din) v(opi16m) v(oni16m) v(xi16m.dip) v(xi16m.din) v(opi16l) v(oni16l) v(xi16l.dip) v(xi16l.din) i(v_i16) v(vbpi32) v(opi32h) v(oni32h) v(xi32h.dip) v(xi32h.din) v(opi32m) v(oni32m) v(xi32m.dip) v(xi32m.din) v(opi32l) v(oni32l) v(xi32l.dip) v(xi32l.din) i(v_i32) v(vbpr24a) v(opr24ah) v(onr24ah) v(xr24ah.dip) v(xr24ah.din) v(opr24am) v(onr24am) v(xr24am.dip) v(xr24am.din) v(opr24al) v(onr24al) v(xr24al.dip) v(xr24al.din) i(v_r24a) v(vbpr24b) v(opr24bh) v(onr24bh) v(xr24bh.dip) v(xr24bh.din) v(opr24bm) v(onr24bm) v(xr24bm.dip) v(xr24bm.din) v(opr24bl) v(onr24bl) v(xr24bl.dip) v(xr24bl.din) i(v_r24b) v(vbpr32a) v(opr32ah) v(onr32ah) v(xr32ah.dip) v(xr32ah.din) v(opr32am) v(onr32am) v(xr32am.dip) v(xr32am.din) v(opr32al) v(onr32al) v(xr32al.dip) v(xr32al.din) i(v_r32a) v(vbpr32b) v(opr32bh) v(onr32bh) v(xr32bh.dip) v(xr32bh.din) v(opr32bm) v(onr32bm) v(xr32bm.dip) v(xr32bm.din) v(opr32bl) v(onr32bl) v(xr32bl.dip) v(xr32bl.din) i(v_r32b) v(vbpr32c) v(opr32ch) v(onr32ch) v(xr32ch.dip) v(xr32ch.din) v(opr32cm) v(onr32cm) v(xr32cm.dip) v(xr32cm.din) v(opr32cl) v(onr32cl) v(xr32cl.dip) v(xr32cl.din) i(v_r32c) v(vbpr40a) v(opr40ah) v(onr40ah) v(xr40ah.dip) v(xr40ah.din) v(opr40am) v(onr40am) v(xr40am.dip) v(xr40am.din) v(opr40al) v(onr40al) v(xr40al.dip) v(xr40al.din) i(v_r40a) v(vbpr40b) v(opr40bh) v(onr40bh) v(xr40bh.dip) v(xr40bh.din) v(opr40bm) v(onr40bm) v(xr40bm.dip) v(xr40bm.din) v(opr40bl) v(onr40bl) v(xr40bl.dip) v(xr40bl.din) i(v_r40b) v(vbpr40c) v(opr40ch) v(onr40ch) v(xr40ch.dip) v(xr40ch.din) v(opr40cm) v(onr40cm) v(xr40cm.dip) v(xr40cm.din) v(opr40cl) v(onr40cl) v(xr40cl.dip) v(xr40cl.din) i(v_r40c) v(clk) i(vdd)
tran 5p 70n 0 20p
write <G1_RESULTS_ROOT>/r1_adc/r3-cmp-tran-ss125-a/cmp_tran.raw
.endc
.end
