* tb_cmp3_noise.cir (generated by sim/r3/gen_cmp3_decks.py) -- r1_cmp3 first stage, quasi-static noise
.lib /foss/pdks/ihp-sg13g2/libs.tech/ngspice/models/cornerMOSlv.lib mos_ff
.lib /foss/pdks/ihp-sg13g2/libs.tech/ngspice/models/cornerCAP.lib cap_typ
.lib /foss/pdks/ihp-sg13g2/libs.tech/ngspice/models/cornerRES.lib res_typ
.include schematic/r1_adc_r3.spice
.temp -40
Vdd vdd 0 1.32
Vclkb clkb 0 0
Vx vx 0 0.3
XBi16 vbpi16 vdd 0 r1_cmp3_ibias ib=14u
Vinpi16 inpi16 0 DC 0.1 AC 1
Vinni16 inni16 0 DC 0.1
Xi16 inpi16 inni16 dpi16 dni16 clkb vbpi16 vdd 0 r1_cmp3_s1
Vdpi16 dpi16 vx 0
Vdni16 dni16 vx 0
Hi16 outi16 0 poly(2) Vdpi16 Vdni16 0 1 -1
XBi32 vbpi32 vdd 0 r1_cmp3_ibias ib=14u
Vinpi32 inpi32 0 DC 0.1 AC 1
Vinni32 inni32 0 DC 0.1
Xi32 inpi32 inni32 dpi32 dni32 clkb vbpi32 vdd 0 r1_cmp3_s1
Vdpi32 dpi32 vx 0
Vdni32 dni32 vx 0
Hi32 outi32 0 poly(2) Vdpi32 Vdni32 0 1 -1
XBr24a vbpr24a vdd 0 r1_cmp3_bias rbw=1u rbl=80u
Vinpr24a inpr24a 0 DC 0.1 AC 1
Vinnr24a innr24a 0 DC 0.1
Xr24a inpr24a innr24a dpr24a dnr24a clkb vbpr24a vdd 0 r1_cmp3_s1
Vdpr24a dpr24a vx 0
Vdnr24a dnr24a vx 0
Hr24a outr24a 0 poly(2) Vdpr24a Vdnr24a 0 1 -1
XBr24b vbpr24b vdd 0 r1_cmp3_bias rbw=1u rbl=120u
Vinpr24b inpr24b 0 DC 0.1 AC 1
Vinnr24b innr24b 0 DC 0.1
Xr24b inpr24b innr24b dpr24b dnr24b clkb vbpr24b vdd 0 r1_cmp3_s1
Vdpr24b dpr24b vx 0
Vdnr24b dnr24b vx 0
Hr24b outr24b 0 poly(2) Vdpr24b Vdnr24b 0 1 -1
XBr32a vbpr32a vdd 0 r1_cmp3_bias rbw=1u rbl=80u
Vinpr32a inpr32a 0 DC 0.1 AC 1
Vinnr32a innr32a 0 DC 0.1
Xr32a inpr32a innr32a dpr32a dnr32a clkb vbpr32a vdd 0 r1_cmp3_s1
Vdpr32a dpr32a vx 0
Vdnr32a dnr32a vx 0
Hr32a outr32a 0 poly(2) Vdpr32a Vdnr32a 0 1 -1
XBr32b vbpr32b vdd 0 r1_cmp3_bias rbw=1u rbl=120u
Vinpr32b inpr32b 0 DC 0.1 AC 1
Vinnr32b innr32b 0 DC 0.1
Xr32b inpr32b innr32b dpr32b dnr32b clkb vbpr32b vdd 0 r1_cmp3_s1
Vdpr32b dpr32b vx 0
Vdnr32b dnr32b vx 0
Hr32b outr32b 0 poly(2) Vdpr32b Vdnr32b 0 1 -1
XBr32c vbpr32c vdd 0 r1_cmp3_bias rbw=1u rbl=160u
Vinpr32c inpr32c 0 DC 0.1 AC 1
Vinnr32c innr32c 0 DC 0.1
Xr32c inpr32c innr32c dpr32c dnr32c clkb vbpr32c vdd 0 r1_cmp3_s1
Vdpr32c dpr32c vx 0
Vdnr32c dnr32c vx 0
Hr32c outr32c 0 poly(2) Vdpr32c Vdnr32c 0 1 -1
XBr40a vbpr40a vdd 0 r1_cmp3_bias rbw=1u rbl=80u
Vinpr40a inpr40a 0 DC 0.1 AC 1
Vinnr40a innr40a 0 DC 0.1
Xr40a inpr40a innr40a dpr40a dnr40a clkb vbpr40a vdd 0 r1_cmp3_s1
Vdpr40a dpr40a vx 0
Vdnr40a dnr40a vx 0
Hr40a outr40a 0 poly(2) Vdpr40a Vdnr40a 0 1 -1
XBr40b vbpr40b vdd 0 r1_cmp3_bias rbw=1u rbl=120u
Vinpr40b inpr40b 0 DC 0.1 AC 1
Vinnr40b innr40b 0 DC 0.1
Xr40b inpr40b innr40b dpr40b dnr40b clkb vbpr40b vdd 0 r1_cmp3_s1
Vdpr40b dpr40b vx 0
Vdnr40b dnr40b vx 0
Hr40b outr40b 0 poly(2) Vdpr40b Vdnr40b 0 1 -1
XBr40c vbpr40c vdd 0 r1_cmp3_bias rbw=1u rbl=160u
Vinpr40c inpr40c 0 DC 0.1 AC 1
Vinnr40c innr40c 0 DC 0.1
Xr40c inpr40c innr40c dpr40c dnr40c clkb vbpr40c vdd 0 r1_cmp3_s1
Vdpr40c dpr40c vx 0
Vdnr40c dnr40c vx 0
Hr40c outr40c 0 poly(2) Vdpr40c Vdnr40c 0 1 -1
.control
set num_threads=1
set wr_singlescale
set wr_vecnames
op
print i(vdpi16) i(vdni16) v(vbpi16)
noise v(outi16) vinpi16 dec 20 1e3 1e11
setplot noise1
wrdata <G1_RESULTS_ROOT>/r1_adc/r3-cmp-noise-ffm40-cm01-a/noise_i16.txt inoise_spectrum onoise_spectrum
destroy all
reset
op
print i(vdpi32) i(vdni32) v(vbpi32)
noise v(outi32) vinpi32 dec 20 1e3 1e11
setplot noise1
wrdata <G1_RESULTS_ROOT>/r1_adc/r3-cmp-noise-ffm40-cm01-a/noise_i32.txt inoise_spectrum onoise_spectrum
destroy all
reset
op
print i(vdpr24a) i(vdnr24a) v(vbpr24a)
noise v(outr24a) vinpr24a dec 20 1e3 1e11
setplot noise1
wrdata <G1_RESULTS_ROOT>/r1_adc/r3-cmp-noise-ffm40-cm01-a/noise_r24a.txt inoise_spectrum onoise_spectrum
destroy all
reset
op
print i(vdpr24b) i(vdnr24b) v(vbpr24b)
noise v(outr24b) vinpr24b dec 20 1e3 1e11
setplot noise1
wrdata <G1_RESULTS_ROOT>/r1_adc/r3-cmp-noise-ffm40-cm01-a/noise_r24b.txt inoise_spectrum onoise_spectrum
destroy all
reset
op
print i(vdpr32a) i(vdnr32a) v(vbpr32a)
noise v(outr32a) vinpr32a dec 20 1e3 1e11
setplot noise1
wrdata <G1_RESULTS_ROOT>/r1_adc/r3-cmp-noise-ffm40-cm01-a/noise_r32a.txt inoise_spectrum onoise_spectrum
destroy all
reset
op
print i(vdpr32b) i(vdnr32b) v(vbpr32b)
noise v(outr32b) vinpr32b dec 20 1e3 1e11
setplot noise1
wrdata <G1_RESULTS_ROOT>/r1_adc/r3-cmp-noise-ffm40-cm01-a/noise_r32b.txt inoise_spectrum onoise_spectrum
destroy all
reset
op
print i(vdpr32c) i(vdnr32c) v(vbpr32c)
noise v(outr32c) vinpr32c dec 20 1e3 1e11
setplot noise1
wrdata <G1_RESULTS_ROOT>/r1_adc/r3-cmp-noise-ffm40-cm01-a/noise_r32c.txt inoise_spectrum onoise_spectrum
destroy all
reset
op
print i(vdpr40a) i(vdnr40a) v(vbpr40a)
noise v(outr40a) vinpr40a dec 20 1e3 1e11
setplot noise1
wrdata <G1_RESULTS_ROOT>/r1_adc/r3-cmp-noise-ffm40-cm01-a/noise_r40a.txt inoise_spectrum onoise_spectrum
destroy all
reset
op
print i(vdpr40b) i(vdnr40b) v(vbpr40b)
noise v(outr40b) vinpr40b dec 20 1e3 1e11
setplot noise1
wrdata <G1_RESULTS_ROOT>/r1_adc/r3-cmp-noise-ffm40-cm01-a/noise_r40b.txt inoise_spectrum onoise_spectrum
destroy all
reset
op
print i(vdpr40c) i(vdnr40c) v(vbpr40c)
noise v(outr40c) vinpr40c dec 20 1e3 1e11
setplot noise1
wrdata <G1_RESULTS_ROOT>/r1_adc/r3-cmp-noise-ffm40-cm01-a/noise_r40c.txt inoise_spectrum onoise_spectrum
destroy all
reset
.endc
.end
