* tb_cmp2_noise.cir (generated by sim/r2/gen_cmp_decks.py) -- r1_cmp2 first stage, quasi-static noise
.lib /foss/pdks/ihp-sg13g2/libs.tech/ngspice/models/cornerMOSlv.lib mos_tt
.lib /foss/pdks/ihp-sg13g2/libs.tech/ngspice/models/cornerCAP.lib cap_typ
.lib /foss/pdks/ihp-sg13g2/libs.tech/ngspice/models/cornerMOShv.lib mos_tt
.lib /foss/pdks/ihp-sg13g2/libs.tech/ngspice/models/cornerRES.lib res_typ
.include schematic/r1_adc_r2.spice
.temp 27
Vdd vdd 0 1.2
Vclkb clkb 0 0
Vx vx 0 0.3
Vinp inp 0 DC 0.6 AC 1
Vinn inn 0 DC 0.6
XV0 inp inn dpV0 dnV0 clkb vdd 0 r1_cmp2_s1 wi=16u li=0.2u ngi=4 wt=8u
VdpV0 dpV0 vx 0
VdnV0 dnV0 vx 0
HV0 outV0 0 poly(2) VdpV0 VdnV0 0 1 -1
XV1 inp inn dpV1 dnV1 clkb vdd 0 r1_cmp2_s1 wi=48u li=0.3u ngi=12 wt=16u
VdpV1 dpV1 vx 0
VdnV1 dnV1 vx 0
HV1 outV1 0 poly(2) VdpV1 VdnV1 0 1 -1
XV2 inp inn dpV2 dnV2 clkb vdd 0 r1_cmp2_s1 wi=48u li=0.3u ngi=12 wt=16u
VdpV2 dpV2 vx 0
VdnV2 dnV2 vx 0
HV2 outV2 0 poly(2) VdpV2 VdnV2 0 1 -1
XV3 inp inn dpV3 dnV3 clkb vdd 0 r1_cmp2_s1 wi=32u li=0.3u ngi=8 wt=16u
VdpV3 dpV3 vx 0
VdnV3 dnV3 vx 0
HV3 outV3 0 poly(2) VdpV3 VdnV3 0 1 -1
.control
set num_threads=1
set wr_singlescale
set wr_vecnames
op
print i(vdpV0) i(vdnV0)
noise v(outV0) vinp dec 20 1e3 1e11
setplot noise1
wrdata <G1_RESULTS_ROOT>/r1_adc/r2-cmp-noise-tt-cm06-a/noise_V0.txt inoise_spectrum onoise_spectrum
destroy all
reset
op
print i(vdpV1) i(vdnV1)
noise v(outV1) vinp dec 20 1e3 1e11
setplot noise1
wrdata <G1_RESULTS_ROOT>/r1_adc/r2-cmp-noise-tt-cm06-a/noise_V1.txt inoise_spectrum onoise_spectrum
destroy all
reset
op
print i(vdpV2) i(vdnV2)
noise v(outV2) vinp dec 20 1e3 1e11
setplot noise1
wrdata <G1_RESULTS_ROOT>/r1_adc/r2-cmp-noise-tt-cm06-a/noise_V2.txt inoise_spectrum onoise_spectrum
destroy all
reset
op
print i(vdpV3) i(vdnV3)
noise v(outV3) vinp dec 20 1e3 1e11
setplot noise1
wrdata <G1_RESULTS_ROOT>/r1_adc/r2-cmp-noise-tt-cm06-a/noise_V3.txt inoise_spectrum onoise_spectrum
destroy all
reset
.endc
.end
