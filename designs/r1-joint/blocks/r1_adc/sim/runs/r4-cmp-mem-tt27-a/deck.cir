* tb_cmp4_mem.cir (generated by sim/r4/gen_cmp4_decks.py) -- r1_cmp4 variants, one decision per tick, clock from r1_cmp4_clkgen, alternating +30 mV / -ASM input
.lib /foss/pdks/ihp-sg13g2/libs.tech/ngspice/models/cornerMOSlv.lib mos_tt
.lib /foss/pdks/ihp-sg13g2/libs.tech/ngspice/models/cornerCAP.lib cap_typ
.lib /foss/pdks/ihp-sg13g2/libs.tech/ngspice/models/cornerRES.lib res_typ
.include schematic/r1_adc_r4.spice
.temp 27
.option reltol=1e-4 vntol=1e-7 abstol=1e-13 method=gear
Vdd vdd 0 1.2
Vclk30 clk30 0 PULSE(0 1.2 2n 50p 50p 16.6167n 33.3333n)
XCKG clk30 mclk mclkb vdd 0 r1_cmp4_clkgen
Bclk clk 0 v=1.2*0.5*(1+tanh(25*(v(mclk)-0.6)))
Bclkb clkb 0 v=1.2*0.5*(1-tanh(25*(v(mclk)-0.6)))
Vd vd 0 PULSE(0.03 -0.0002 34.1333n 0.2n 0.2n 33.1333n 66.6667n)
V_v32 vdd_v32 vdd 0
XBv32 vbpv32 vdd_v32 0 r1_cmp4_bias rbl=160u
Bpv32h ipv32h 0 v=0.6+v(vd)/2
Bnv32h inv32h 0 v=0.6-v(vd)/2
Xv32h ipv32h inv32h clk clkb opv32h onv32h vbpv32 vdd_v32 0 r1_cmp4 wcap=32u wr=8u
Bpv32m ipv32m 0 v=0.35+v(vd)/2
Bnv32m inv32m 0 v=0.35-v(vd)/2
Xv32m ipv32m inv32m clk clkb opv32m onv32m vbpv32 vdd_v32 0 r1_cmp4 wcap=32u wr=8u
Bpv32l ipv32l 0 v=0.1+v(vd)/2
Bnv32l inv32l 0 v=0.1-v(vd)/2
Xv32l ipv32l inv32l clk clkb opv32l onv32l vbpv32 vdd_v32 0 r1_cmp4 wcap=32u wr=8u
V_v48 vdd_v48 vdd 0
XBv48 vbpv48 vdd_v48 0 r1_cmp4_bias rbl=160u
Bpv48h ipv48h 0 v=0.6+v(vd)/2
Bnv48h inv48h 0 v=0.6-v(vd)/2
Xv48h ipv48h inv48h clk clkb opv48h onv48h vbpv48 vdd_v48 0 r1_cmp4 wcap=48u wr=12u
Bpv48m ipv48m 0 v=0.35+v(vd)/2
Bnv48m inv48m 0 v=0.35-v(vd)/2
Xv48m ipv48m inv48m clk clkb opv48m onv48m vbpv48 vdd_v48 0 r1_cmp4 wcap=48u wr=12u
Bpv48l ipv48l 0 v=0.1+v(vd)/2
Bnv48l inv48l 0 v=0.1-v(vd)/2
Xv48l ipv48l inv48l clk clkb opv48l onv48l vbpv48 vdd_v48 0 r1_cmp4 wcap=48u wr=12u
V_v64 vdd_v64 vdd 0
XBv64 vbpv64 vdd_v64 0 r1_cmp4_bias rbl=160u
Bpv64h ipv64h 0 v=0.6+v(vd)/2
Bnv64h inv64h 0 v=0.6-v(vd)/2
Xv64h ipv64h inv64h clk clkb opv64h onv64h vbpv64 vdd_v64 0 r1_cmp4 wcap=64u wr=16u
Bpv64m ipv64m 0 v=0.35+v(vd)/2
Bnv64m inv64m 0 v=0.35-v(vd)/2
Xv64m ipv64m inv64m clk clkb opv64m onv64m vbpv64 vdd_v64 0 r1_cmp4 wcap=64u wr=16u
Bpv64l ipv64l 0 v=0.1+v(vd)/2
Bnv64l inv64l 0 v=0.1-v(vd)/2
Xv64l ipv64l inv64l clk clkb opv64l onv64l vbpv64 vdd_v64 0 r1_cmp4 wcap=64u wr=16u
V_v64r vdd_v64r vdd 0
XBv64r vbpv64r vdd_v64r 0 r1_cmp4_bias rbl=200u
Bpv64rh ipv64rh 0 v=0.6+v(vd)/2
Bnv64rh inv64rh 0 v=0.6-v(vd)/2
Xv64rh ipv64rh inv64rh clk clkb opv64rh onv64rh vbpv64r vdd_v64r 0 r1_cmp4 wcap=64u wr=16u
Bpv64rm ipv64rm 0 v=0.35+v(vd)/2
Bnv64rm inv64rm 0 v=0.35-v(vd)/2
Xv64rm ipv64rm inv64rm clk clkb opv64rm onv64rm vbpv64r vdd_v64r 0 r1_cmp4 wcap=64u wr=16u
Bpv64rl ipv64rl 0 v=0.1+v(vd)/2
Bnv64rl inv64rl 0 v=0.1-v(vd)/2
Xv64rl ipv64rl inv64rl clk clkb opv64rl onv64rl vbpv64r vdd_v64r 0 r1_cmp4 wcap=64u wr=16u
V_v80 vdd_v80 vdd 0
XBv80 vbpv80 vdd_v80 0 r1_cmp4_bias rbl=160u
Bpv80h ipv80h 0 v=0.6+v(vd)/2
Bnv80h inv80h 0 v=0.6-v(vd)/2
Xv80h ipv80h inv80h clk clkb opv80h onv80h vbpv80 vdd_v80 0 r1_cmp4 wcap=80u wr=20u
Bpv80m ipv80m 0 v=0.35+v(vd)/2
Bnv80m inv80m 0 v=0.35-v(vd)/2
Xv80m ipv80m inv80m clk clkb opv80m onv80m vbpv80 vdd_v80 0 r1_cmp4 wcap=80u wr=20u
Bpv80l ipv80l 0 v=0.1+v(vd)/2
Bnv80l inv80l 0 v=0.1-v(vd)/2
Xv80l ipv80l inv80l clk clkb opv80l onv80l vbpv80 vdd_v80 0 r1_cmp4 wcap=80u wr=20u
V_v96 vdd_v96 vdd 0
XBv96 vbpv96 vdd_v96 0 r1_cmp4_bias rbl=160u
Bpv96h ipv96h 0 v=0.6+v(vd)/2
Bnv96h inv96h 0 v=0.6-v(vd)/2
Xv96h ipv96h inv96h clk clkb opv96h onv96h vbpv96 vdd_v96 0 r1_cmp4 wcap=96u wr=24u
Bpv96m ipv96m 0 v=0.35+v(vd)/2
Bnv96m inv96m 0 v=0.35-v(vd)/2
Xv96m ipv96m inv96m clk clkb opv96m onv96m vbpv96 vdd_v96 0 r1_cmp4 wcap=96u wr=24u
Bpv96l ipv96l 0 v=0.1+v(vd)/2
Bnv96l inv96l 0 v=0.1-v(vd)/2
Xv96l ipv96l inv96l clk clkb opv96l onv96l vbpv96 vdd_v96 0 r1_cmp4 wcap=96u wr=24u
.control
set num_threads=1
save v(clk30) v(mclk) v(vd) i(vdd) v(opv32h) v(onv32h) v(opv32m) v(onv32m) v(opv32l) v(onv32l) i(v_v32) v(opv48h) v(onv48h) v(opv48m) v(onv48m) v(opv48l) v(onv48l) i(v_v48) v(opv64h) v(onv64h) v(opv64m) v(onv64m) v(opv64l) v(onv64l) i(v_v64) v(opv64rh) v(onv64rh) v(opv64rm) v(onv64rm) v(opv64rl) v(onv64rl) i(v_v64r) v(opv80h) v(onv80h) v(opv80m) v(onv80m) v(opv80l) v(onv80l) i(v_v80) v(opv96h) v(onv96h) v(opv96m) v(onv96m) v(opv96l) v(onv96l) i(v_v96)
tran 5p 335.333n 0 20p
write <G1_RESULTS_ROOT>/r1_adc/r4-cmp-mem-tt27-a/mem.raw
.endc
.end
