* tb_adc4_points.cir -- R1 ADC revision 4 (D18): both slices, one held differential input per frame and slice.
* Frame s: slice A samples vda (SIN path) at tsA = 0.6 us + s * 22 T, slice B samples vdb (COS path) at tsA + N T.
* vda/vdb are PWL sources written by sim/r4/run_points4.py (value of frame s applied 550 ns before its edge).
* Inputs are linear E sources around the common mode CM (R2-7: no B sources on the input path).
* Reference: REFLINES (ideal sources, or r1_refbuf4 from an ideal 1.045 V bandgap node; vrefl = LSB-array reference).
* Substitutions: CORNER TEMP VDD CM CORE TIMING OPTS TMAX TSTOP PWLA PWLB REFLINES SAVE RAW
.lib /foss/pdks/ihp-sg13g2/libs.tech/ngspice/models/cornerMOSlv.lib mos_ss
.lib /foss/pdks/ihp-sg13g2/libs.tech/ngspice/models/cornerCAP.lib cap_typ
.lib /foss/pdks/ihp-sg13g2/libs.tech/ngspice/models/cornerMOShv.lib mos_ss
.lib /foss/pdks/ihp-sg13g2/libs.tech/ngspice/models/cornerRES.lib res_typ
.include schematic/r1_adc_r4.spice
.include sim/r4/r1_adc_timing_r4_n0_vdd108.inc
.temp 125
.option reltol=1e-4 vntol=1e-6 abstol=1e-12 gmin=1e-9 method=trap klu rshunt=1e12 interp

Vdd vdd 0 1.08
Vref vref 0 1.0
Vrl vrefl vref 0
Vcm vcm 0 0.45
Vda vda 0 PWL(0 -0.0640000 7.833333e-07 -0.0640000 7.933333e-07 -0.0600000 1.516667e-06 -0.0600000 1.526667e-06 -0.0560000 2.250000e-06 -0.0560000 2.260000e-06 -0.0520000 2.983333e-06 -0.0520000
+ 2.993333e-06 -0.0480000 3.716667e-06 -0.0480000 3.726667e-06 -0.0440000 4.450000e-06 -0.0440000 4.460000e-06 -0.0400000 5.183333e-06 -0.0400000 5.193333e-06 -0.0360000 5.916667e-06 -0.0360000
+ 5.926667e-06 -0.0320000 6.650000e-06 -0.0320000 6.660000e-06 -0.0280000 7.383333e-06 -0.0280000 7.393333e-06 -0.0240000 8.116667e-06 -0.0240000 8.126667e-06 -0.0200000 8.850000e-06 -0.0200000
+ 8.860000e-06 -0.0160000 9.583333e-06 -0.0160000 9.593333e-06 -0.0120000 1.031667e-05 -0.0120000 1.032667e-05 -0.0080000 1.105000e-05 -0.0080000 1.106000e-05 -0.0040000 1.178333e-05 -0.0040000
+ 1.179333e-05 0.0000000 1.251667e-05 0.0000000 1.252667e-05 -0.8800000 1.325000e-05 -0.8800000 1.326000e-05 -0.7542857 1.398333e-05 -0.7542857 1.399333e-05 -0.6285714 1.471667e-05 -0.6285714
+ 1.472667e-05 -0.5028571 1.545000e-05 -0.5028571 1.546000e-05 -0.3771429 1.618333e-05 -0.3771429 1.619333e-05 -0.2514286 1.691667e-05 -0.2514286 1.692667e-05 -0.1257143 1.765000e-05 -0.1257143
+ 1.766000e-05 0.0000000 1.838333e-05 0.0000000 1.839333e-05 0.1257143 1.911667e-05 0.1257143 1.912667e-05 0.2514286 1.985000e-05 0.2514286 1.986000e-05 0.3771429 2.058333e-05 0.3771429
+ 2.059333e-05 0.5028571 2.131667e-05 0.5028571 2.132667e-05 0.6285714 2.205000e-05 0.6285714 2.206000e-05 0.7542857 2.278333e-05 0.7542857 2.279333e-05 0.8800000)
Vdb vdb 0 PWL(0 -0.0660000 7.833333e-07 -0.0660000 7.933333e-07 -0.0620000 1.516667e-06 -0.0620000 1.526667e-06 -0.0580000 2.250000e-06 -0.0580000 2.260000e-06 -0.0540000 2.983333e-06 -0.0540000
+ 2.993333e-06 -0.0500000 3.716667e-06 -0.0500000 3.726667e-06 -0.0460000 4.450000e-06 -0.0460000 4.460000e-06 -0.0420000 5.183333e-06 -0.0420000 5.193333e-06 -0.0380000 5.916667e-06 -0.0380000
+ 5.926667e-06 -0.0340000 6.650000e-06 -0.0340000 6.660000e-06 -0.0300000 7.383333e-06 -0.0300000 7.393333e-06 -0.0260000 8.116667e-06 -0.0260000 8.126667e-06 -0.0220000 8.850000e-06 -0.0220000
+ 8.860000e-06 -0.0180000 9.583333e-06 -0.0180000 9.593333e-06 -0.0140000 1.031667e-05 -0.0140000 1.032667e-05 -0.0100000 1.105000e-05 -0.0100000 1.106000e-05 -0.0060000 1.178333e-05 -0.0060000
+ 1.179333e-05 -0.0020000 1.251667e-05 -0.0020000 1.252667e-05 -0.8500000 1.325000e-05 -0.8500000 1.326000e-05 -0.7242857 1.398333e-05 -0.7242857 1.399333e-05 -0.5985714 1.471667e-05 -0.5985714
+ 1.472667e-05 -0.4728571 1.545000e-05 -0.4728571 1.546000e-05 -0.3471429 1.618333e-05 -0.3471429 1.619333e-05 -0.2214286 1.691667e-05 -0.2214286 1.692667e-05 -0.0957143 1.765000e-05 -0.0957143
+ 1.766000e-05 0.0300000 1.838333e-05 0.0300000 1.839333e-05 0.1557143 1.911667e-05 0.1557143 1.912667e-05 0.2814286 1.985000e-05 0.2814286 1.986000e-05 0.4071429 2.058333e-05 0.4071429
+ 2.059333e-05 0.5328571 2.131667e-05 0.5328571 2.132667e-05 0.6585714 2.205000e-05 0.6585714 2.206000e-05 0.7842857 2.278333e-05 0.7842857 2.279333e-05 0.8500000)
Esp sinp vcm vda 0 0.5
Esn sinn vcm vda 0 -0.5
Ecp cosp vcm vdb 0 0.5
Ecn cosn vcm vdb 0 -0.5
Vip isap 0 0.6
Vin isan 0 0.6

XADC sinp sinn cosp cosn isap isan isap isan trka0 trka1 trkb0 trkb1 clk30 wina winb lata latb
+ stba0 stba1 stba2 stba3 stba4 stba5 stba6 stba7 stba8 stba9 stba10 stba11 stba12 stba13
+ stbb0 stbb1 stbb2 stbb3 stbb4 stbb5 stbb6 stbb7 stbb8 stbb9 stbb10 stbb11 stbb12 stbb13
+ rawa rawb topap topan topbp topbn vdd vref vrefl 0 r1_adc4_core_fast

.control
set num_threads=1
save v(rawa) v(rawb)
tran 1n 23.8600u 0 0.2n
meas tran idd avg i(vdd) from=0.7u to=23.8600u
write <G1_RESULTS_ROOT>/r1_adc/r4-sweep-ss125-cm045/codes.raw
.endc
.end
