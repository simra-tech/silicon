* tb_cmp3_hyst.cir (generated by sim/r3/gen_cmp3_hyst.py) -- r1_cmp3 (wcap 80u, rbl 85u) memory test
.lib /foss/pdks/ihp-sg13g2/libs.tech/ngspice/models/cornerMOSlv.lib mos_ss
.lib /foss/pdks/ihp-sg13g2/libs.tech/ngspice/models/cornerCAP.lib cap_typ
.lib /foss/pdks/ihp-sg13g2/libs.tech/ngspice/models/cornerRES.lib res_typ
.include schematic/r1_adc_r3.spice
.temp 125
.option reltol=1e-4 vntol=1e-7 abstol=1e-13 method=gear
Vdd vdd 0 1.08
Vclk clk 0 PULSE(0 1.08 1n 50p 50p 13.45n 16.6667n)
Vclkb clkb 0 PULSE(1.08 0 1n 50p 50p 13.45n 16.6667n)
Vd vd 0 PULSE(0.03 -0.0002 15.1667n 0.2n 0.2n 16.2667n 33.3333n)
XB2 vbp2 vdd 0 r1_cmp3_bias
Bw2hp inpw2h 0 v=0.6+v(vd)/2
Bw2hn innw2h 0 v=0.6-v(vd)/2
Xw2h inpw2h innw2h clk clkb opw2h onw2h vbp2 vdd 0 r1_cmp3 wr=2u
Bw2mp inpw2m 0 v=0.35+v(vd)/2
Bw2mn innw2m 0 v=0.35-v(vd)/2
Xw2m inpw2m innw2m clk clkb opw2m onw2m vbp2 vdd 0 r1_cmp3 wr=2u
Bw2lp inpw2l 0 v=0.1+v(vd)/2
Bw2ln innw2l 0 v=0.1-v(vd)/2
Xw2l inpw2l innw2l clk clkb opw2l onw2l vbp2 vdd 0 r1_cmp3 wr=2u
XB8 vbp8 vdd 0 r1_cmp3_bias
Bw8hp inpw8h 0 v=0.6+v(vd)/2
Bw8hn innw8h 0 v=0.6-v(vd)/2
Xw8h inpw8h innw8h clk clkb opw8h onw8h vbp8 vdd 0 r1_cmp3 wr=8u
Bw8mp inpw8m 0 v=0.35+v(vd)/2
Bw8mn innw8m 0 v=0.35-v(vd)/2
Xw8m inpw8m innw8m clk clkb opw8m onw8m vbp8 vdd 0 r1_cmp3 wr=8u
Bw8lp inpw8l 0 v=0.1+v(vd)/2
Bw8ln innw8l 0 v=0.1-v(vd)/2
Xw8l inpw8l innw8l clk clkb opw8l onw8l vbp8 vdd 0 r1_cmp3 wr=8u
XB16 vbp16 vdd 0 r1_cmp3_bias
Bw16hp inpw16h 0 v=0.6+v(vd)/2
Bw16hn innw16h 0 v=0.6-v(vd)/2
Xw16h inpw16h innw16h clk clkb opw16h onw16h vbp16 vdd 0 r1_cmp3 wr=16u
Bw16mp inpw16m 0 v=0.35+v(vd)/2
Bw16mn innw16m 0 v=0.35-v(vd)/2
Xw16m inpw16m innw16m clk clkb opw16m onw16m vbp16 vdd 0 r1_cmp3 wr=16u
Bw16lp inpw16l 0 v=0.1+v(vd)/2
Bw16ln innw16l 0 v=0.1-v(vd)/2
Xw16l inpw16l innw16l clk clkb opw16l onw16l vbp16 vdd 0 r1_cmp3 wr=16u
XB24 vbp24 vdd 0 r1_cmp3_bias
Bw24hp inpw24h 0 v=0.6+v(vd)/2
Bw24hn innw24h 0 v=0.6-v(vd)/2
Xw24h inpw24h innw24h clk clkb opw24h onw24h vbp24 vdd 0 r1_cmp3 wr=24u
Bw24mp inpw24m 0 v=0.35+v(vd)/2
Bw24mn innw24m 0 v=0.35-v(vd)/2
Xw24m inpw24m innw24m clk clkb opw24m onw24m vbp24 vdd 0 r1_cmp3 wr=24u
Bw24lp inpw24l 0 v=0.1+v(vd)/2
Bw24ln innw24l 0 v=0.1-v(vd)/2
Xw24l inpw24l innw24l clk clkb opw24l onw24l vbp24 vdd 0 r1_cmp3 wr=24u
.control
set num_threads=1
save v(clk) v(vd) v(opw2h) v(onw2h) v(opw2m) v(onw2m) v(opw2l) v(onw2l) v(opw8h) v(onw8h) v(opw8m) v(onw8m) v(opw8l) v(onw8l) v(opw16h) v(onw16h) v(opw16m) v(onw16m) v(opw16l) v(onw16l) v(opw24h) v(onw24h) v(opw24m) v(onw24m) v(opw24l) v(onw24l)
tran 5p 200n 0 20p
write <G1_RESULTS_ROOT>/r1_adc/r3-cmp-hyst-ss125-c/hyst.raw
.endc
.end
