* tb_cdac_mc.cir (generated by gen_tb_cdac_mc.py) -- CDAC mismatch MC, 50 samples x 2 sides
.lib /foss/pdks/ihp-sg13g2/libs.tech/ngspice/models/cornerCAP.lib cap_typ_mismatch
.include schematic/r1_adc.spice
.option reltol=1e-6 vntol=1e-9 abstol=1e-15 method=trap
Vref vref 0 1.2
Vcm vcm 0 0.6
* reset switch control: high until 1 ns
Vrst rst 0 PWL(0 1.2 1n 1.2 1.01n 0)
.model swr sw(vt=0.6 vh=0.01 ron=1 roff=1e15)
Vb10 b10 0 PWL(0 1.2 2e-09 1.2 2.01e-09 0)
Vb9 b9 0 PWL(0 1.2 4e-09 1.2 4.01e-09 0)
Vb8 b8 0 PWL(0 1.2 6e-09 1.2 6.01e-09 0)
Vb7 b7 0 PWL(0 1.2 8e-09 1.2 8.01e-09 0)
Vb6 b6 0 PWL(0 1.2 1e-08 1.2 1.001e-08 0)
Vb5 b5 0 PWL(0 1.2 1.2e-08 1.2 1.201e-08 0)
Vb4 b4 0 PWL(0 1.2 1.4e-08 1.2 1.401e-08 0)
Vb3 b3 0 PWL(0 1.2 1.6e-08 1.2 1.601e-08 0)
Vb2 b2 0 PWL(0 1.2 1.8e-08 1.2 1.801e-08 0)
Vb1 b1 0 PWL(0 1.2 2e-08 1.2 2.001e-08 0)
Vb0 b0 0 PWL(0 1.2 2.2e-08 1.2 2.201e-08 0)
Xp0 tp0 lp0 b10 b9 b8 b7 b6 b5 b4 b3 b2 b1 b0 r1_cdac_side_mc mm=1
Spt0 vcm tp0 rst 0 swr
Spl0 vref lp0 rst 0 swr
Xn0 tn0 ln0 b10 b9 b8 b7 b6 b5 b4 b3 b2 b1 b0 r1_cdac_side_mc mm=1
Snt0 vcm tn0 rst 0 swr
Snl0 vref ln0 rst 0 swr
Xp1 tp1 lp1 b10 b9 b8 b7 b6 b5 b4 b3 b2 b1 b0 r1_cdac_side_mc mm=1
Spt1 vcm tp1 rst 0 swr
Spl1 vref lp1 rst 0 swr
Xn1 tn1 ln1 b10 b9 b8 b7 b6 b5 b4 b3 b2 b1 b0 r1_cdac_side_mc mm=1
Snt1 vcm tn1 rst 0 swr
Snl1 vref ln1 rst 0 swr
Xp2 tp2 lp2 b10 b9 b8 b7 b6 b5 b4 b3 b2 b1 b0 r1_cdac_side_mc mm=1
Spt2 vcm tp2 rst 0 swr
Spl2 vref lp2 rst 0 swr
Xn2 tn2 ln2 b10 b9 b8 b7 b6 b5 b4 b3 b2 b1 b0 r1_cdac_side_mc mm=1
Snt2 vcm tn2 rst 0 swr
Snl2 vref ln2 rst 0 swr
Xp3 tp3 lp3 b10 b9 b8 b7 b6 b5 b4 b3 b2 b1 b0 r1_cdac_side_mc mm=1
Spt3 vcm tp3 rst 0 swr
Spl3 vref lp3 rst 0 swr
Xn3 tn3 ln3 b10 b9 b8 b7 b6 b5 b4 b3 b2 b1 b0 r1_cdac_side_mc mm=1
Snt3 vcm tn3 rst 0 swr
Snl3 vref ln3 rst 0 swr
Xp4 tp4 lp4 b10 b9 b8 b7 b6 b5 b4 b3 b2 b1 b0 r1_cdac_side_mc mm=1
Spt4 vcm tp4 rst 0 swr
Spl4 vref lp4 rst 0 swr
Xn4 tn4 ln4 b10 b9 b8 b7 b6 b5 b4 b3 b2 b1 b0 r1_cdac_side_mc mm=1
Snt4 vcm tn4 rst 0 swr
Snl4 vref ln4 rst 0 swr
Xp5 tp5 lp5 b10 b9 b8 b7 b6 b5 b4 b3 b2 b1 b0 r1_cdac_side_mc mm=1
Spt5 vcm tp5 rst 0 swr
Spl5 vref lp5 rst 0 swr
Xn5 tn5 ln5 b10 b9 b8 b7 b6 b5 b4 b3 b2 b1 b0 r1_cdac_side_mc mm=1
Snt5 vcm tn5 rst 0 swr
Snl5 vref ln5 rst 0 swr
Xp6 tp6 lp6 b10 b9 b8 b7 b6 b5 b4 b3 b2 b1 b0 r1_cdac_side_mc mm=1
Spt6 vcm tp6 rst 0 swr
Spl6 vref lp6 rst 0 swr
Xn6 tn6 ln6 b10 b9 b8 b7 b6 b5 b4 b3 b2 b1 b0 r1_cdac_side_mc mm=1
Snt6 vcm tn6 rst 0 swr
Snl6 vref ln6 rst 0 swr
Xp7 tp7 lp7 b10 b9 b8 b7 b6 b5 b4 b3 b2 b1 b0 r1_cdac_side_mc mm=1
Spt7 vcm tp7 rst 0 swr
Spl7 vref lp7 rst 0 swr
Xn7 tn7 ln7 b10 b9 b8 b7 b6 b5 b4 b3 b2 b1 b0 r1_cdac_side_mc mm=1
Snt7 vcm tn7 rst 0 swr
Snl7 vref ln7 rst 0 swr
Xp8 tp8 lp8 b10 b9 b8 b7 b6 b5 b4 b3 b2 b1 b0 r1_cdac_side_mc mm=1
Spt8 vcm tp8 rst 0 swr
Spl8 vref lp8 rst 0 swr
Xn8 tn8 ln8 b10 b9 b8 b7 b6 b5 b4 b3 b2 b1 b0 r1_cdac_side_mc mm=1
Snt8 vcm tn8 rst 0 swr
Snl8 vref ln8 rst 0 swr
Xp9 tp9 lp9 b10 b9 b8 b7 b6 b5 b4 b3 b2 b1 b0 r1_cdac_side_mc mm=1
Spt9 vcm tp9 rst 0 swr
Spl9 vref lp9 rst 0 swr
Xn9 tn9 ln9 b10 b9 b8 b7 b6 b5 b4 b3 b2 b1 b0 r1_cdac_side_mc mm=1
Snt9 vcm tn9 rst 0 swr
Snl9 vref ln9 rst 0 swr
Xp10 tp10 lp10 b10 b9 b8 b7 b6 b5 b4 b3 b2 b1 b0 r1_cdac_side_mc mm=1
Spt10 vcm tp10 rst 0 swr
Spl10 vref lp10 rst 0 swr
Xn10 tn10 ln10 b10 b9 b8 b7 b6 b5 b4 b3 b2 b1 b0 r1_cdac_side_mc mm=1
Snt10 vcm tn10 rst 0 swr
Snl10 vref ln10 rst 0 swr
Xp11 tp11 lp11 b10 b9 b8 b7 b6 b5 b4 b3 b2 b1 b0 r1_cdac_side_mc mm=1
Spt11 vcm tp11 rst 0 swr
Spl11 vref lp11 rst 0 swr
Xn11 tn11 ln11 b10 b9 b8 b7 b6 b5 b4 b3 b2 b1 b0 r1_cdac_side_mc mm=1
Snt11 vcm tn11 rst 0 swr
Snl11 vref ln11 rst 0 swr
Xp12 tp12 lp12 b10 b9 b8 b7 b6 b5 b4 b3 b2 b1 b0 r1_cdac_side_mc mm=1
Spt12 vcm tp12 rst 0 swr
Spl12 vref lp12 rst 0 swr
Xn12 tn12 ln12 b10 b9 b8 b7 b6 b5 b4 b3 b2 b1 b0 r1_cdac_side_mc mm=1
Snt12 vcm tn12 rst 0 swr
Snl12 vref ln12 rst 0 swr
Xp13 tp13 lp13 b10 b9 b8 b7 b6 b5 b4 b3 b2 b1 b0 r1_cdac_side_mc mm=1
Spt13 vcm tp13 rst 0 swr
Spl13 vref lp13 rst 0 swr
Xn13 tn13 ln13 b10 b9 b8 b7 b6 b5 b4 b3 b2 b1 b0 r1_cdac_side_mc mm=1
Snt13 vcm tn13 rst 0 swr
Snl13 vref ln13 rst 0 swr
Xp14 tp14 lp14 b10 b9 b8 b7 b6 b5 b4 b3 b2 b1 b0 r1_cdac_side_mc mm=1
Spt14 vcm tp14 rst 0 swr
Spl14 vref lp14 rst 0 swr
Xn14 tn14 ln14 b10 b9 b8 b7 b6 b5 b4 b3 b2 b1 b0 r1_cdac_side_mc mm=1
Snt14 vcm tn14 rst 0 swr
Snl14 vref ln14 rst 0 swr
Xp15 tp15 lp15 b10 b9 b8 b7 b6 b5 b4 b3 b2 b1 b0 r1_cdac_side_mc mm=1
Spt15 vcm tp15 rst 0 swr
Spl15 vref lp15 rst 0 swr
Xn15 tn15 ln15 b10 b9 b8 b7 b6 b5 b4 b3 b2 b1 b0 r1_cdac_side_mc mm=1
Snt15 vcm tn15 rst 0 swr
Snl15 vref ln15 rst 0 swr
Xp16 tp16 lp16 b10 b9 b8 b7 b6 b5 b4 b3 b2 b1 b0 r1_cdac_side_mc mm=1
Spt16 vcm tp16 rst 0 swr
Spl16 vref lp16 rst 0 swr
Xn16 tn16 ln16 b10 b9 b8 b7 b6 b5 b4 b3 b2 b1 b0 r1_cdac_side_mc mm=1
Snt16 vcm tn16 rst 0 swr
Snl16 vref ln16 rst 0 swr
Xp17 tp17 lp17 b10 b9 b8 b7 b6 b5 b4 b3 b2 b1 b0 r1_cdac_side_mc mm=1
Spt17 vcm tp17 rst 0 swr
Spl17 vref lp17 rst 0 swr
Xn17 tn17 ln17 b10 b9 b8 b7 b6 b5 b4 b3 b2 b1 b0 r1_cdac_side_mc mm=1
Snt17 vcm tn17 rst 0 swr
Snl17 vref ln17 rst 0 swr
Xp18 tp18 lp18 b10 b9 b8 b7 b6 b5 b4 b3 b2 b1 b0 r1_cdac_side_mc mm=1
Spt18 vcm tp18 rst 0 swr
Spl18 vref lp18 rst 0 swr
Xn18 tn18 ln18 b10 b9 b8 b7 b6 b5 b4 b3 b2 b1 b0 r1_cdac_side_mc mm=1
Snt18 vcm tn18 rst 0 swr
Snl18 vref ln18 rst 0 swr
Xp19 tp19 lp19 b10 b9 b8 b7 b6 b5 b4 b3 b2 b1 b0 r1_cdac_side_mc mm=1
Spt19 vcm tp19 rst 0 swr
Spl19 vref lp19 rst 0 swr
Xn19 tn19 ln19 b10 b9 b8 b7 b6 b5 b4 b3 b2 b1 b0 r1_cdac_side_mc mm=1
Snt19 vcm tn19 rst 0 swr
Snl19 vref ln19 rst 0 swr
Xp20 tp20 lp20 b10 b9 b8 b7 b6 b5 b4 b3 b2 b1 b0 r1_cdac_side_mc mm=1
Spt20 vcm tp20 rst 0 swr
Spl20 vref lp20 rst 0 swr
Xn20 tn20 ln20 b10 b9 b8 b7 b6 b5 b4 b3 b2 b1 b0 r1_cdac_side_mc mm=1
Snt20 vcm tn20 rst 0 swr
Snl20 vref ln20 rst 0 swr
Xp21 tp21 lp21 b10 b9 b8 b7 b6 b5 b4 b3 b2 b1 b0 r1_cdac_side_mc mm=1
Spt21 vcm tp21 rst 0 swr
Spl21 vref lp21 rst 0 swr
Xn21 tn21 ln21 b10 b9 b8 b7 b6 b5 b4 b3 b2 b1 b0 r1_cdac_side_mc mm=1
Snt21 vcm tn21 rst 0 swr
Snl21 vref ln21 rst 0 swr
Xp22 tp22 lp22 b10 b9 b8 b7 b6 b5 b4 b3 b2 b1 b0 r1_cdac_side_mc mm=1
Spt22 vcm tp22 rst 0 swr
Spl22 vref lp22 rst 0 swr
Xn22 tn22 ln22 b10 b9 b8 b7 b6 b5 b4 b3 b2 b1 b0 r1_cdac_side_mc mm=1
Snt22 vcm tn22 rst 0 swr
Snl22 vref ln22 rst 0 swr
Xp23 tp23 lp23 b10 b9 b8 b7 b6 b5 b4 b3 b2 b1 b0 r1_cdac_side_mc mm=1
Spt23 vcm tp23 rst 0 swr
Spl23 vref lp23 rst 0 swr
Xn23 tn23 ln23 b10 b9 b8 b7 b6 b5 b4 b3 b2 b1 b0 r1_cdac_side_mc mm=1
Snt23 vcm tn23 rst 0 swr
Snl23 vref ln23 rst 0 swr
Xp24 tp24 lp24 b10 b9 b8 b7 b6 b5 b4 b3 b2 b1 b0 r1_cdac_side_mc mm=1
Spt24 vcm tp24 rst 0 swr
Spl24 vref lp24 rst 0 swr
Xn24 tn24 ln24 b10 b9 b8 b7 b6 b5 b4 b3 b2 b1 b0 r1_cdac_side_mc mm=1
Snt24 vcm tn24 rst 0 swr
Snl24 vref ln24 rst 0 swr
Xp25 tp25 lp25 b10 b9 b8 b7 b6 b5 b4 b3 b2 b1 b0 r1_cdac_side_mc mm=1
Spt25 vcm tp25 rst 0 swr
Spl25 vref lp25 rst 0 swr
Xn25 tn25 ln25 b10 b9 b8 b7 b6 b5 b4 b3 b2 b1 b0 r1_cdac_side_mc mm=1
Snt25 vcm tn25 rst 0 swr
Snl25 vref ln25 rst 0 swr
Xp26 tp26 lp26 b10 b9 b8 b7 b6 b5 b4 b3 b2 b1 b0 r1_cdac_side_mc mm=1
Spt26 vcm tp26 rst 0 swr
Spl26 vref lp26 rst 0 swr
Xn26 tn26 ln26 b10 b9 b8 b7 b6 b5 b4 b3 b2 b1 b0 r1_cdac_side_mc mm=1
Snt26 vcm tn26 rst 0 swr
Snl26 vref ln26 rst 0 swr
Xp27 tp27 lp27 b10 b9 b8 b7 b6 b5 b4 b3 b2 b1 b0 r1_cdac_side_mc mm=1
Spt27 vcm tp27 rst 0 swr
Spl27 vref lp27 rst 0 swr
Xn27 tn27 ln27 b10 b9 b8 b7 b6 b5 b4 b3 b2 b1 b0 r1_cdac_side_mc mm=1
Snt27 vcm tn27 rst 0 swr
Snl27 vref ln27 rst 0 swr
Xp28 tp28 lp28 b10 b9 b8 b7 b6 b5 b4 b3 b2 b1 b0 r1_cdac_side_mc mm=1
Spt28 vcm tp28 rst 0 swr
Spl28 vref lp28 rst 0 swr
Xn28 tn28 ln28 b10 b9 b8 b7 b6 b5 b4 b3 b2 b1 b0 r1_cdac_side_mc mm=1
Snt28 vcm tn28 rst 0 swr
Snl28 vref ln28 rst 0 swr
Xp29 tp29 lp29 b10 b9 b8 b7 b6 b5 b4 b3 b2 b1 b0 r1_cdac_side_mc mm=1
Spt29 vcm tp29 rst 0 swr
Spl29 vref lp29 rst 0 swr
Xn29 tn29 ln29 b10 b9 b8 b7 b6 b5 b4 b3 b2 b1 b0 r1_cdac_side_mc mm=1
Snt29 vcm tn29 rst 0 swr
Snl29 vref ln29 rst 0 swr
Xp30 tp30 lp30 b10 b9 b8 b7 b6 b5 b4 b3 b2 b1 b0 r1_cdac_side_mc mm=1
Spt30 vcm tp30 rst 0 swr
Spl30 vref lp30 rst 0 swr
Xn30 tn30 ln30 b10 b9 b8 b7 b6 b5 b4 b3 b2 b1 b0 r1_cdac_side_mc mm=1
Snt30 vcm tn30 rst 0 swr
Snl30 vref ln30 rst 0 swr
Xp31 tp31 lp31 b10 b9 b8 b7 b6 b5 b4 b3 b2 b1 b0 r1_cdac_side_mc mm=1
Spt31 vcm tp31 rst 0 swr
Spl31 vref lp31 rst 0 swr
Xn31 tn31 ln31 b10 b9 b8 b7 b6 b5 b4 b3 b2 b1 b0 r1_cdac_side_mc mm=1
Snt31 vcm tn31 rst 0 swr
Snl31 vref ln31 rst 0 swr
Xp32 tp32 lp32 b10 b9 b8 b7 b6 b5 b4 b3 b2 b1 b0 r1_cdac_side_mc mm=1
Spt32 vcm tp32 rst 0 swr
Spl32 vref lp32 rst 0 swr
Xn32 tn32 ln32 b10 b9 b8 b7 b6 b5 b4 b3 b2 b1 b0 r1_cdac_side_mc mm=1
Snt32 vcm tn32 rst 0 swr
Snl32 vref ln32 rst 0 swr
Xp33 tp33 lp33 b10 b9 b8 b7 b6 b5 b4 b3 b2 b1 b0 r1_cdac_side_mc mm=1
Spt33 vcm tp33 rst 0 swr
Spl33 vref lp33 rst 0 swr
Xn33 tn33 ln33 b10 b9 b8 b7 b6 b5 b4 b3 b2 b1 b0 r1_cdac_side_mc mm=1
Snt33 vcm tn33 rst 0 swr
Snl33 vref ln33 rst 0 swr
Xp34 tp34 lp34 b10 b9 b8 b7 b6 b5 b4 b3 b2 b1 b0 r1_cdac_side_mc mm=1
Spt34 vcm tp34 rst 0 swr
Spl34 vref lp34 rst 0 swr
Xn34 tn34 ln34 b10 b9 b8 b7 b6 b5 b4 b3 b2 b1 b0 r1_cdac_side_mc mm=1
Snt34 vcm tn34 rst 0 swr
Snl34 vref ln34 rst 0 swr
Xp35 tp35 lp35 b10 b9 b8 b7 b6 b5 b4 b3 b2 b1 b0 r1_cdac_side_mc mm=1
Spt35 vcm tp35 rst 0 swr
Spl35 vref lp35 rst 0 swr
Xn35 tn35 ln35 b10 b9 b8 b7 b6 b5 b4 b3 b2 b1 b0 r1_cdac_side_mc mm=1
Snt35 vcm tn35 rst 0 swr
Snl35 vref ln35 rst 0 swr
Xp36 tp36 lp36 b10 b9 b8 b7 b6 b5 b4 b3 b2 b1 b0 r1_cdac_side_mc mm=1
Spt36 vcm tp36 rst 0 swr
Spl36 vref lp36 rst 0 swr
Xn36 tn36 ln36 b10 b9 b8 b7 b6 b5 b4 b3 b2 b1 b0 r1_cdac_side_mc mm=1
Snt36 vcm tn36 rst 0 swr
Snl36 vref ln36 rst 0 swr
Xp37 tp37 lp37 b10 b9 b8 b7 b6 b5 b4 b3 b2 b1 b0 r1_cdac_side_mc mm=1
Spt37 vcm tp37 rst 0 swr
Spl37 vref lp37 rst 0 swr
Xn37 tn37 ln37 b10 b9 b8 b7 b6 b5 b4 b3 b2 b1 b0 r1_cdac_side_mc mm=1
Snt37 vcm tn37 rst 0 swr
Snl37 vref ln37 rst 0 swr
Xp38 tp38 lp38 b10 b9 b8 b7 b6 b5 b4 b3 b2 b1 b0 r1_cdac_side_mc mm=1
Spt38 vcm tp38 rst 0 swr
Spl38 vref lp38 rst 0 swr
Xn38 tn38 ln38 b10 b9 b8 b7 b6 b5 b4 b3 b2 b1 b0 r1_cdac_side_mc mm=1
Snt38 vcm tn38 rst 0 swr
Snl38 vref ln38 rst 0 swr
Xp39 tp39 lp39 b10 b9 b8 b7 b6 b5 b4 b3 b2 b1 b0 r1_cdac_side_mc mm=1
Spt39 vcm tp39 rst 0 swr
Spl39 vref lp39 rst 0 swr
Xn39 tn39 ln39 b10 b9 b8 b7 b6 b5 b4 b3 b2 b1 b0 r1_cdac_side_mc mm=1
Snt39 vcm tn39 rst 0 swr
Snl39 vref ln39 rst 0 swr
Xp40 tp40 lp40 b10 b9 b8 b7 b6 b5 b4 b3 b2 b1 b0 r1_cdac_side_mc mm=1
Spt40 vcm tp40 rst 0 swr
Spl40 vref lp40 rst 0 swr
Xn40 tn40 ln40 b10 b9 b8 b7 b6 b5 b4 b3 b2 b1 b0 r1_cdac_side_mc mm=1
Snt40 vcm tn40 rst 0 swr
Snl40 vref ln40 rst 0 swr
Xp41 tp41 lp41 b10 b9 b8 b7 b6 b5 b4 b3 b2 b1 b0 r1_cdac_side_mc mm=1
Spt41 vcm tp41 rst 0 swr
Spl41 vref lp41 rst 0 swr
Xn41 tn41 ln41 b10 b9 b8 b7 b6 b5 b4 b3 b2 b1 b0 r1_cdac_side_mc mm=1
Snt41 vcm tn41 rst 0 swr
Snl41 vref ln41 rst 0 swr
Xp42 tp42 lp42 b10 b9 b8 b7 b6 b5 b4 b3 b2 b1 b0 r1_cdac_side_mc mm=1
Spt42 vcm tp42 rst 0 swr
Spl42 vref lp42 rst 0 swr
Xn42 tn42 ln42 b10 b9 b8 b7 b6 b5 b4 b3 b2 b1 b0 r1_cdac_side_mc mm=1
Snt42 vcm tn42 rst 0 swr
Snl42 vref ln42 rst 0 swr
Xp43 tp43 lp43 b10 b9 b8 b7 b6 b5 b4 b3 b2 b1 b0 r1_cdac_side_mc mm=1
Spt43 vcm tp43 rst 0 swr
Spl43 vref lp43 rst 0 swr
Xn43 tn43 ln43 b10 b9 b8 b7 b6 b5 b4 b3 b2 b1 b0 r1_cdac_side_mc mm=1
Snt43 vcm tn43 rst 0 swr
Snl43 vref ln43 rst 0 swr
Xp44 tp44 lp44 b10 b9 b8 b7 b6 b5 b4 b3 b2 b1 b0 r1_cdac_side_mc mm=1
Spt44 vcm tp44 rst 0 swr
Spl44 vref lp44 rst 0 swr
Xn44 tn44 ln44 b10 b9 b8 b7 b6 b5 b4 b3 b2 b1 b0 r1_cdac_side_mc mm=1
Snt44 vcm tn44 rst 0 swr
Snl44 vref ln44 rst 0 swr
Xp45 tp45 lp45 b10 b9 b8 b7 b6 b5 b4 b3 b2 b1 b0 r1_cdac_side_mc mm=1
Spt45 vcm tp45 rst 0 swr
Spl45 vref lp45 rst 0 swr
Xn45 tn45 ln45 b10 b9 b8 b7 b6 b5 b4 b3 b2 b1 b0 r1_cdac_side_mc mm=1
Snt45 vcm tn45 rst 0 swr
Snl45 vref ln45 rst 0 swr
Xp46 tp46 lp46 b10 b9 b8 b7 b6 b5 b4 b3 b2 b1 b0 r1_cdac_side_mc mm=1
Spt46 vcm tp46 rst 0 swr
Spl46 vref lp46 rst 0 swr
Xn46 tn46 ln46 b10 b9 b8 b7 b6 b5 b4 b3 b2 b1 b0 r1_cdac_side_mc mm=1
Snt46 vcm tn46 rst 0 swr
Snl46 vref ln46 rst 0 swr
Xp47 tp47 lp47 b10 b9 b8 b7 b6 b5 b4 b3 b2 b1 b0 r1_cdac_side_mc mm=1
Spt47 vcm tp47 rst 0 swr
Spl47 vref lp47 rst 0 swr
Xn47 tn47 ln47 b10 b9 b8 b7 b6 b5 b4 b3 b2 b1 b0 r1_cdac_side_mc mm=1
Snt47 vcm tn47 rst 0 swr
Snl47 vref ln47 rst 0 swr
Xp48 tp48 lp48 b10 b9 b8 b7 b6 b5 b4 b3 b2 b1 b0 r1_cdac_side_mc mm=1
Spt48 vcm tp48 rst 0 swr
Spl48 vref lp48 rst 0 swr
Xn48 tn48 ln48 b10 b9 b8 b7 b6 b5 b4 b3 b2 b1 b0 r1_cdac_side_mc mm=1
Snt48 vcm tn48 rst 0 swr
Snl48 vref ln48 rst 0 swr
Xp49 tp49 lp49 b10 b9 b8 b7 b6 b5 b4 b3 b2 b1 b0 r1_cdac_side_mc mm=1
Spt49 vcm tp49 rst 0 swr
Spl49 vref lp49 rst 0 swr
Xn49 tn49 ln49 b10 b9 b8 b7 b6 b5 b4 b3 b2 b1 b0 r1_cdac_side_mc mm=1
Snt49 vcm tn49 rst 0 swr
Snl49 vref ln49 rst 0 swr
.control
set num_threads=1
tran 10p 2.4e-08 0 50p
set wr_singlescale
set wr_vecnames
meas tran m_p0_0 find v(tp0) at=1.5e-09
meas tran m_n0_0 find v(tn0) at=1.5e-09
meas tran m_p1_0 find v(tp1) at=1.5e-09
meas tran m_n1_0 find v(tn1) at=1.5e-09
meas tran m_p2_0 find v(tp2) at=1.5e-09
meas tran m_n2_0 find v(tn2) at=1.5e-09
meas tran m_p3_0 find v(tp3) at=1.5e-09
meas tran m_n3_0 find v(tn3) at=1.5e-09
meas tran m_p4_0 find v(tp4) at=1.5e-09
meas tran m_n4_0 find v(tn4) at=1.5e-09
meas tran m_p5_0 find v(tp5) at=1.5e-09
meas tran m_n5_0 find v(tn5) at=1.5e-09
meas tran m_p6_0 find v(tp6) at=1.5e-09
meas tran m_n6_0 find v(tn6) at=1.5e-09
meas tran m_p7_0 find v(tp7) at=1.5e-09
meas tran m_n7_0 find v(tn7) at=1.5e-09
meas tran m_p8_0 find v(tp8) at=1.5e-09
meas tran m_n8_0 find v(tn8) at=1.5e-09
meas tran m_p9_0 find v(tp9) at=1.5e-09
meas tran m_n9_0 find v(tn9) at=1.5e-09
meas tran m_p10_0 find v(tp10) at=1.5e-09
meas tran m_n10_0 find v(tn10) at=1.5e-09
meas tran m_p11_0 find v(tp11) at=1.5e-09
meas tran m_n11_0 find v(tn11) at=1.5e-09
meas tran m_p12_0 find v(tp12) at=1.5e-09
meas tran m_n12_0 find v(tn12) at=1.5e-09
meas tran m_p13_0 find v(tp13) at=1.5e-09
meas tran m_n13_0 find v(tn13) at=1.5e-09
meas tran m_p14_0 find v(tp14) at=1.5e-09
meas tran m_n14_0 find v(tn14) at=1.5e-09
meas tran m_p15_0 find v(tp15) at=1.5e-09
meas tran m_n15_0 find v(tn15) at=1.5e-09
meas tran m_p16_0 find v(tp16) at=1.5e-09
meas tran m_n16_0 find v(tn16) at=1.5e-09
meas tran m_p17_0 find v(tp17) at=1.5e-09
meas tran m_n17_0 find v(tn17) at=1.5e-09
meas tran m_p18_0 find v(tp18) at=1.5e-09
meas tran m_n18_0 find v(tn18) at=1.5e-09
meas tran m_p19_0 find v(tp19) at=1.5e-09
meas tran m_n19_0 find v(tn19) at=1.5e-09
meas tran m_p20_0 find v(tp20) at=1.5e-09
meas tran m_n20_0 find v(tn20) at=1.5e-09
meas tran m_p21_0 find v(tp21) at=1.5e-09
meas tran m_n21_0 find v(tn21) at=1.5e-09
meas tran m_p22_0 find v(tp22) at=1.5e-09
meas tran m_n22_0 find v(tn22) at=1.5e-09
meas tran m_p23_0 find v(tp23) at=1.5e-09
meas tran m_n23_0 find v(tn23) at=1.5e-09
meas tran m_p24_0 find v(tp24) at=1.5e-09
meas tran m_n24_0 find v(tn24) at=1.5e-09
meas tran m_p25_0 find v(tp25) at=1.5e-09
meas tran m_n25_0 find v(tn25) at=1.5e-09
meas tran m_p26_0 find v(tp26) at=1.5e-09
meas tran m_n26_0 find v(tn26) at=1.5e-09
meas tran m_p27_0 find v(tp27) at=1.5e-09
meas tran m_n27_0 find v(tn27) at=1.5e-09
meas tran m_p28_0 find v(tp28) at=1.5e-09
meas tran m_n28_0 find v(tn28) at=1.5e-09
meas tran m_p29_0 find v(tp29) at=1.5e-09
meas tran m_n29_0 find v(tn29) at=1.5e-09
meas tran m_p30_0 find v(tp30) at=1.5e-09
meas tran m_n30_0 find v(tn30) at=1.5e-09
meas tran m_p31_0 find v(tp31) at=1.5e-09
meas tran m_n31_0 find v(tn31) at=1.5e-09
meas tran m_p32_0 find v(tp32) at=1.5e-09
meas tran m_n32_0 find v(tn32) at=1.5e-09
meas tran m_p33_0 find v(tp33) at=1.5e-09
meas tran m_n33_0 find v(tn33) at=1.5e-09
meas tran m_p34_0 find v(tp34) at=1.5e-09
meas tran m_n34_0 find v(tn34) at=1.5e-09
meas tran m_p35_0 find v(tp35) at=1.5e-09
meas tran m_n35_0 find v(tn35) at=1.5e-09
meas tran m_p36_0 find v(tp36) at=1.5e-09
meas tran m_n36_0 find v(tn36) at=1.5e-09
meas tran m_p37_0 find v(tp37) at=1.5e-09
meas tran m_n37_0 find v(tn37) at=1.5e-09
meas tran m_p38_0 find v(tp38) at=1.5e-09
meas tran m_n38_0 find v(tn38) at=1.5e-09
meas tran m_p39_0 find v(tp39) at=1.5e-09
meas tran m_n39_0 find v(tn39) at=1.5e-09
meas tran m_p40_0 find v(tp40) at=1.5e-09
meas tran m_n40_0 find v(tn40) at=1.5e-09
meas tran m_p41_0 find v(tp41) at=1.5e-09
meas tran m_n41_0 find v(tn41) at=1.5e-09
meas tran m_p42_0 find v(tp42) at=1.5e-09
meas tran m_n42_0 find v(tn42) at=1.5e-09
meas tran m_p43_0 find v(tp43) at=1.5e-09
meas tran m_n43_0 find v(tn43) at=1.5e-09
meas tran m_p44_0 find v(tp44) at=1.5e-09
meas tran m_n44_0 find v(tn44) at=1.5e-09
meas tran m_p45_0 find v(tp45) at=1.5e-09
meas tran m_n45_0 find v(tn45) at=1.5e-09
meas tran m_p46_0 find v(tp46) at=1.5e-09
meas tran m_n46_0 find v(tn46) at=1.5e-09
meas tran m_p47_0 find v(tp47) at=1.5e-09
meas tran m_n47_0 find v(tn47) at=1.5e-09
meas tran m_p48_0 find v(tp48) at=1.5e-09
meas tran m_n48_0 find v(tn48) at=1.5e-09
meas tran m_p49_0 find v(tp49) at=1.5e-09
meas tran m_n49_0 find v(tn49) at=1.5e-09
meas tran m_p0_1 find v(tp0) at=3e-09
meas tran m_n0_1 find v(tn0) at=3e-09
meas tran m_p1_1 find v(tp1) at=3e-09
meas tran m_n1_1 find v(tn1) at=3e-09
meas tran m_p2_1 find v(tp2) at=3e-09
meas tran m_n2_1 find v(tn2) at=3e-09
meas tran m_p3_1 find v(tp3) at=3e-09
meas tran m_n3_1 find v(tn3) at=3e-09
meas tran m_p4_1 find v(tp4) at=3e-09
meas tran m_n4_1 find v(tn4) at=3e-09
meas tran m_p5_1 find v(tp5) at=3e-09
meas tran m_n5_1 find v(tn5) at=3e-09
meas tran m_p6_1 find v(tp6) at=3e-09
meas tran m_n6_1 find v(tn6) at=3e-09
meas tran m_p7_1 find v(tp7) at=3e-09
meas tran m_n7_1 find v(tn7) at=3e-09
meas tran m_p8_1 find v(tp8) at=3e-09
meas tran m_n8_1 find v(tn8) at=3e-09
meas tran m_p9_1 find v(tp9) at=3e-09
meas tran m_n9_1 find v(tn9) at=3e-09
meas tran m_p10_1 find v(tp10) at=3e-09
meas tran m_n10_1 find v(tn10) at=3e-09
meas tran m_p11_1 find v(tp11) at=3e-09
meas tran m_n11_1 find v(tn11) at=3e-09
meas tran m_p12_1 find v(tp12) at=3e-09
meas tran m_n12_1 find v(tn12) at=3e-09
meas tran m_p13_1 find v(tp13) at=3e-09
meas tran m_n13_1 find v(tn13) at=3e-09
meas tran m_p14_1 find v(tp14) at=3e-09
meas tran m_n14_1 find v(tn14) at=3e-09
meas tran m_p15_1 find v(tp15) at=3e-09
meas tran m_n15_1 find v(tn15) at=3e-09
meas tran m_p16_1 find v(tp16) at=3e-09
meas tran m_n16_1 find v(tn16) at=3e-09
meas tran m_p17_1 find v(tp17) at=3e-09
meas tran m_n17_1 find v(tn17) at=3e-09
meas tran m_p18_1 find v(tp18) at=3e-09
meas tran m_n18_1 find v(tn18) at=3e-09
meas tran m_p19_1 find v(tp19) at=3e-09
meas tran m_n19_1 find v(tn19) at=3e-09
meas tran m_p20_1 find v(tp20) at=3e-09
meas tran m_n20_1 find v(tn20) at=3e-09
meas tran m_p21_1 find v(tp21) at=3e-09
meas tran m_n21_1 find v(tn21) at=3e-09
meas tran m_p22_1 find v(tp22) at=3e-09
meas tran m_n22_1 find v(tn22) at=3e-09
meas tran m_p23_1 find v(tp23) at=3e-09
meas tran m_n23_1 find v(tn23) at=3e-09
meas tran m_p24_1 find v(tp24) at=3e-09
meas tran m_n24_1 find v(tn24) at=3e-09
meas tran m_p25_1 find v(tp25) at=3e-09
meas tran m_n25_1 find v(tn25) at=3e-09
meas tran m_p26_1 find v(tp26) at=3e-09
meas tran m_n26_1 find v(tn26) at=3e-09
meas tran m_p27_1 find v(tp27) at=3e-09
meas tran m_n27_1 find v(tn27) at=3e-09
meas tran m_p28_1 find v(tp28) at=3e-09
meas tran m_n28_1 find v(tn28) at=3e-09
meas tran m_p29_1 find v(tp29) at=3e-09
meas tran m_n29_1 find v(tn29) at=3e-09
meas tran m_p30_1 find v(tp30) at=3e-09
meas tran m_n30_1 find v(tn30) at=3e-09
meas tran m_p31_1 find v(tp31) at=3e-09
meas tran m_n31_1 find v(tn31) at=3e-09
meas tran m_p32_1 find v(tp32) at=3e-09
meas tran m_n32_1 find v(tn32) at=3e-09
meas tran m_p33_1 find v(tp33) at=3e-09
meas tran m_n33_1 find v(tn33) at=3e-09
meas tran m_p34_1 find v(tp34) at=3e-09
meas tran m_n34_1 find v(tn34) at=3e-09
meas tran m_p35_1 find v(tp35) at=3e-09
meas tran m_n35_1 find v(tn35) at=3e-09
meas tran m_p36_1 find v(tp36) at=3e-09
meas tran m_n36_1 find v(tn36) at=3e-09
meas tran m_p37_1 find v(tp37) at=3e-09
meas tran m_n37_1 find v(tn37) at=3e-09
meas tran m_p38_1 find v(tp38) at=3e-09
meas tran m_n38_1 find v(tn38) at=3e-09
meas tran m_p39_1 find v(tp39) at=3e-09
meas tran m_n39_1 find v(tn39) at=3e-09
meas tran m_p40_1 find v(tp40) at=3e-09
meas tran m_n40_1 find v(tn40) at=3e-09
meas tran m_p41_1 find v(tp41) at=3e-09
meas tran m_n41_1 find v(tn41) at=3e-09
meas tran m_p42_1 find v(tp42) at=3e-09
meas tran m_n42_1 find v(tn42) at=3e-09
meas tran m_p43_1 find v(tp43) at=3e-09
meas tran m_n43_1 find v(tn43) at=3e-09
meas tran m_p44_1 find v(tp44) at=3e-09
meas tran m_n44_1 find v(tn44) at=3e-09
meas tran m_p45_1 find v(tp45) at=3e-09
meas tran m_n45_1 find v(tn45) at=3e-09
meas tran m_p46_1 find v(tp46) at=3e-09
meas tran m_n46_1 find v(tn46) at=3e-09
meas tran m_p47_1 find v(tp47) at=3e-09
meas tran m_n47_1 find v(tn47) at=3e-09
meas tran m_p48_1 find v(tp48) at=3e-09
meas tran m_n48_1 find v(tn48) at=3e-09
meas tran m_p49_1 find v(tp49) at=3e-09
meas tran m_n49_1 find v(tn49) at=3e-09
meas tran m_p0_2 find v(tp0) at=5e-09
meas tran m_n0_2 find v(tn0) at=5e-09
meas tran m_p1_2 find v(tp1) at=5e-09
meas tran m_n1_2 find v(tn1) at=5e-09
meas tran m_p2_2 find v(tp2) at=5e-09
meas tran m_n2_2 find v(tn2) at=5e-09
meas tran m_p3_2 find v(tp3) at=5e-09
meas tran m_n3_2 find v(tn3) at=5e-09
meas tran m_p4_2 find v(tp4) at=5e-09
meas tran m_n4_2 find v(tn4) at=5e-09
meas tran m_p5_2 find v(tp5) at=5e-09
meas tran m_n5_2 find v(tn5) at=5e-09
meas tran m_p6_2 find v(tp6) at=5e-09
meas tran m_n6_2 find v(tn6) at=5e-09
meas tran m_p7_2 find v(tp7) at=5e-09
meas tran m_n7_2 find v(tn7) at=5e-09
meas tran m_p8_2 find v(tp8) at=5e-09
meas tran m_n8_2 find v(tn8) at=5e-09
meas tran m_p9_2 find v(tp9) at=5e-09
meas tran m_n9_2 find v(tn9) at=5e-09
meas tran m_p10_2 find v(tp10) at=5e-09
meas tran m_n10_2 find v(tn10) at=5e-09
meas tran m_p11_2 find v(tp11) at=5e-09
meas tran m_n11_2 find v(tn11) at=5e-09
meas tran m_p12_2 find v(tp12) at=5e-09
meas tran m_n12_2 find v(tn12) at=5e-09
meas tran m_p13_2 find v(tp13) at=5e-09
meas tran m_n13_2 find v(tn13) at=5e-09
meas tran m_p14_2 find v(tp14) at=5e-09
meas tran m_n14_2 find v(tn14) at=5e-09
meas tran m_p15_2 find v(tp15) at=5e-09
meas tran m_n15_2 find v(tn15) at=5e-09
meas tran m_p16_2 find v(tp16) at=5e-09
meas tran m_n16_2 find v(tn16) at=5e-09
meas tran m_p17_2 find v(tp17) at=5e-09
meas tran m_n17_2 find v(tn17) at=5e-09
meas tran m_p18_2 find v(tp18) at=5e-09
meas tran m_n18_2 find v(tn18) at=5e-09
meas tran m_p19_2 find v(tp19) at=5e-09
meas tran m_n19_2 find v(tn19) at=5e-09
meas tran m_p20_2 find v(tp20) at=5e-09
meas tran m_n20_2 find v(tn20) at=5e-09
meas tran m_p21_2 find v(tp21) at=5e-09
meas tran m_n21_2 find v(tn21) at=5e-09
meas tran m_p22_2 find v(tp22) at=5e-09
meas tran m_n22_2 find v(tn22) at=5e-09
meas tran m_p23_2 find v(tp23) at=5e-09
meas tran m_n23_2 find v(tn23) at=5e-09
meas tran m_p24_2 find v(tp24) at=5e-09
meas tran m_n24_2 find v(tn24) at=5e-09
meas tran m_p25_2 find v(tp25) at=5e-09
meas tran m_n25_2 find v(tn25) at=5e-09
meas tran m_p26_2 find v(tp26) at=5e-09
meas tran m_n26_2 find v(tn26) at=5e-09
meas tran m_p27_2 find v(tp27) at=5e-09
meas tran m_n27_2 find v(tn27) at=5e-09
meas tran m_p28_2 find v(tp28) at=5e-09
meas tran m_n28_2 find v(tn28) at=5e-09
meas tran m_p29_2 find v(tp29) at=5e-09
meas tran m_n29_2 find v(tn29) at=5e-09
meas tran m_p30_2 find v(tp30) at=5e-09
meas tran m_n30_2 find v(tn30) at=5e-09
meas tran m_p31_2 find v(tp31) at=5e-09
meas tran m_n31_2 find v(tn31) at=5e-09
meas tran m_p32_2 find v(tp32) at=5e-09
meas tran m_n32_2 find v(tn32) at=5e-09
meas tran m_p33_2 find v(tp33) at=5e-09
meas tran m_n33_2 find v(tn33) at=5e-09
meas tran m_p34_2 find v(tp34) at=5e-09
meas tran m_n34_2 find v(tn34) at=5e-09
meas tran m_p35_2 find v(tp35) at=5e-09
meas tran m_n35_2 find v(tn35) at=5e-09
meas tran m_p36_2 find v(tp36) at=5e-09
meas tran m_n36_2 find v(tn36) at=5e-09
meas tran m_p37_2 find v(tp37) at=5e-09
meas tran m_n37_2 find v(tn37) at=5e-09
meas tran m_p38_2 find v(tp38) at=5e-09
meas tran m_n38_2 find v(tn38) at=5e-09
meas tran m_p39_2 find v(tp39) at=5e-09
meas tran m_n39_2 find v(tn39) at=5e-09
meas tran m_p40_2 find v(tp40) at=5e-09
meas tran m_n40_2 find v(tn40) at=5e-09
meas tran m_p41_2 find v(tp41) at=5e-09
meas tran m_n41_2 find v(tn41) at=5e-09
meas tran m_p42_2 find v(tp42) at=5e-09
meas tran m_n42_2 find v(tn42) at=5e-09
meas tran m_p43_2 find v(tp43) at=5e-09
meas tran m_n43_2 find v(tn43) at=5e-09
meas tran m_p44_2 find v(tp44) at=5e-09
meas tran m_n44_2 find v(tn44) at=5e-09
meas tran m_p45_2 find v(tp45) at=5e-09
meas tran m_n45_2 find v(tn45) at=5e-09
meas tran m_p46_2 find v(tp46) at=5e-09
meas tran m_n46_2 find v(tn46) at=5e-09
meas tran m_p47_2 find v(tp47) at=5e-09
meas tran m_n47_2 find v(tn47) at=5e-09
meas tran m_p48_2 find v(tp48) at=5e-09
meas tran m_n48_2 find v(tn48) at=5e-09
meas tran m_p49_2 find v(tp49) at=5e-09
meas tran m_n49_2 find v(tn49) at=5e-09
meas tran m_p0_3 find v(tp0) at=7e-09
meas tran m_n0_3 find v(tn0) at=7e-09
meas tran m_p1_3 find v(tp1) at=7e-09
meas tran m_n1_3 find v(tn1) at=7e-09
meas tran m_p2_3 find v(tp2) at=7e-09
meas tran m_n2_3 find v(tn2) at=7e-09
meas tran m_p3_3 find v(tp3) at=7e-09
meas tran m_n3_3 find v(tn3) at=7e-09
meas tran m_p4_3 find v(tp4) at=7e-09
meas tran m_n4_3 find v(tn4) at=7e-09
meas tran m_p5_3 find v(tp5) at=7e-09
meas tran m_n5_3 find v(tn5) at=7e-09
meas tran m_p6_3 find v(tp6) at=7e-09
meas tran m_n6_3 find v(tn6) at=7e-09
meas tran m_p7_3 find v(tp7) at=7e-09
meas tran m_n7_3 find v(tn7) at=7e-09
meas tran m_p8_3 find v(tp8) at=7e-09
meas tran m_n8_3 find v(tn8) at=7e-09
meas tran m_p9_3 find v(tp9) at=7e-09
meas tran m_n9_3 find v(tn9) at=7e-09
meas tran m_p10_3 find v(tp10) at=7e-09
meas tran m_n10_3 find v(tn10) at=7e-09
meas tran m_p11_3 find v(tp11) at=7e-09
meas tran m_n11_3 find v(tn11) at=7e-09
meas tran m_p12_3 find v(tp12) at=7e-09
meas tran m_n12_3 find v(tn12) at=7e-09
meas tran m_p13_3 find v(tp13) at=7e-09
meas tran m_n13_3 find v(tn13) at=7e-09
meas tran m_p14_3 find v(tp14) at=7e-09
meas tran m_n14_3 find v(tn14) at=7e-09
meas tran m_p15_3 find v(tp15) at=7e-09
meas tran m_n15_3 find v(tn15) at=7e-09
meas tran m_p16_3 find v(tp16) at=7e-09
meas tran m_n16_3 find v(tn16) at=7e-09
meas tran m_p17_3 find v(tp17) at=7e-09
meas tran m_n17_3 find v(tn17) at=7e-09
meas tran m_p18_3 find v(tp18) at=7e-09
meas tran m_n18_3 find v(tn18) at=7e-09
meas tran m_p19_3 find v(tp19) at=7e-09
meas tran m_n19_3 find v(tn19) at=7e-09
meas tran m_p20_3 find v(tp20) at=7e-09
meas tran m_n20_3 find v(tn20) at=7e-09
meas tran m_p21_3 find v(tp21) at=7e-09
meas tran m_n21_3 find v(tn21) at=7e-09
meas tran m_p22_3 find v(tp22) at=7e-09
meas tran m_n22_3 find v(tn22) at=7e-09
meas tran m_p23_3 find v(tp23) at=7e-09
meas tran m_n23_3 find v(tn23) at=7e-09
meas tran m_p24_3 find v(tp24) at=7e-09
meas tran m_n24_3 find v(tn24) at=7e-09
meas tran m_p25_3 find v(tp25) at=7e-09
meas tran m_n25_3 find v(tn25) at=7e-09
meas tran m_p26_3 find v(tp26) at=7e-09
meas tran m_n26_3 find v(tn26) at=7e-09
meas tran m_p27_3 find v(tp27) at=7e-09
meas tran m_n27_3 find v(tn27) at=7e-09
meas tran m_p28_3 find v(tp28) at=7e-09
meas tran m_n28_3 find v(tn28) at=7e-09
meas tran m_p29_3 find v(tp29) at=7e-09
meas tran m_n29_3 find v(tn29) at=7e-09
meas tran m_p30_3 find v(tp30) at=7e-09
meas tran m_n30_3 find v(tn30) at=7e-09
meas tran m_p31_3 find v(tp31) at=7e-09
meas tran m_n31_3 find v(tn31) at=7e-09
meas tran m_p32_3 find v(tp32) at=7e-09
meas tran m_n32_3 find v(tn32) at=7e-09
meas tran m_p33_3 find v(tp33) at=7e-09
meas tran m_n33_3 find v(tn33) at=7e-09
meas tran m_p34_3 find v(tp34) at=7e-09
meas tran m_n34_3 find v(tn34) at=7e-09
meas tran m_p35_3 find v(tp35) at=7e-09
meas tran m_n35_3 find v(tn35) at=7e-09
meas tran m_p36_3 find v(tp36) at=7e-09
meas tran m_n36_3 find v(tn36) at=7e-09
meas tran m_p37_3 find v(tp37) at=7e-09
meas tran m_n37_3 find v(tn37) at=7e-09
meas tran m_p38_3 find v(tp38) at=7e-09
meas tran m_n38_3 find v(tn38) at=7e-09
meas tran m_p39_3 find v(tp39) at=7e-09
meas tran m_n39_3 find v(tn39) at=7e-09
meas tran m_p40_3 find v(tp40) at=7e-09
meas tran m_n40_3 find v(tn40) at=7e-09
meas tran m_p41_3 find v(tp41) at=7e-09
meas tran m_n41_3 find v(tn41) at=7e-09
meas tran m_p42_3 find v(tp42) at=7e-09
meas tran m_n42_3 find v(tn42) at=7e-09
meas tran m_p43_3 find v(tp43) at=7e-09
meas tran m_n43_3 find v(tn43) at=7e-09
meas tran m_p44_3 find v(tp44) at=7e-09
meas tran m_n44_3 find v(tn44) at=7e-09
meas tran m_p45_3 find v(tp45) at=7e-09
meas tran m_n45_3 find v(tn45) at=7e-09
meas tran m_p46_3 find v(tp46) at=7e-09
meas tran m_n46_3 find v(tn46) at=7e-09
meas tran m_p47_3 find v(tp47) at=7e-09
meas tran m_n47_3 find v(tn47) at=7e-09
meas tran m_p48_3 find v(tp48) at=7e-09
meas tran m_n48_3 find v(tn48) at=7e-09
meas tran m_p49_3 find v(tp49) at=7e-09
meas tran m_n49_3 find v(tn49) at=7e-09
meas tran m_p0_4 find v(tp0) at=9e-09
meas tran m_n0_4 find v(tn0) at=9e-09
meas tran m_p1_4 find v(tp1) at=9e-09
meas tran m_n1_4 find v(tn1) at=9e-09
meas tran m_p2_4 find v(tp2) at=9e-09
meas tran m_n2_4 find v(tn2) at=9e-09
meas tran m_p3_4 find v(tp3) at=9e-09
meas tran m_n3_4 find v(tn3) at=9e-09
meas tran m_p4_4 find v(tp4) at=9e-09
meas tran m_n4_4 find v(tn4) at=9e-09
meas tran m_p5_4 find v(tp5) at=9e-09
meas tran m_n5_4 find v(tn5) at=9e-09
meas tran m_p6_4 find v(tp6) at=9e-09
meas tran m_n6_4 find v(tn6) at=9e-09
meas tran m_p7_4 find v(tp7) at=9e-09
meas tran m_n7_4 find v(tn7) at=9e-09
meas tran m_p8_4 find v(tp8) at=9e-09
meas tran m_n8_4 find v(tn8) at=9e-09
meas tran m_p9_4 find v(tp9) at=9e-09
meas tran m_n9_4 find v(tn9) at=9e-09
meas tran m_p10_4 find v(tp10) at=9e-09
meas tran m_n10_4 find v(tn10) at=9e-09
meas tran m_p11_4 find v(tp11) at=9e-09
meas tran m_n11_4 find v(tn11) at=9e-09
meas tran m_p12_4 find v(tp12) at=9e-09
meas tran m_n12_4 find v(tn12) at=9e-09
meas tran m_p13_4 find v(tp13) at=9e-09
meas tran m_n13_4 find v(tn13) at=9e-09
meas tran m_p14_4 find v(tp14) at=9e-09
meas tran m_n14_4 find v(tn14) at=9e-09
meas tran m_p15_4 find v(tp15) at=9e-09
meas tran m_n15_4 find v(tn15) at=9e-09
meas tran m_p16_4 find v(tp16) at=9e-09
meas tran m_n16_4 find v(tn16) at=9e-09
meas tran m_p17_4 find v(tp17) at=9e-09
meas tran m_n17_4 find v(tn17) at=9e-09
meas tran m_p18_4 find v(tp18) at=9e-09
meas tran m_n18_4 find v(tn18) at=9e-09
meas tran m_p19_4 find v(tp19) at=9e-09
meas tran m_n19_4 find v(tn19) at=9e-09
meas tran m_p20_4 find v(tp20) at=9e-09
meas tran m_n20_4 find v(tn20) at=9e-09
meas tran m_p21_4 find v(tp21) at=9e-09
meas tran m_n21_4 find v(tn21) at=9e-09
meas tran m_p22_4 find v(tp22) at=9e-09
meas tran m_n22_4 find v(tn22) at=9e-09
meas tran m_p23_4 find v(tp23) at=9e-09
meas tran m_n23_4 find v(tn23) at=9e-09
meas tran m_p24_4 find v(tp24) at=9e-09
meas tran m_n24_4 find v(tn24) at=9e-09
meas tran m_p25_4 find v(tp25) at=9e-09
meas tran m_n25_4 find v(tn25) at=9e-09
meas tran m_p26_4 find v(tp26) at=9e-09
meas tran m_n26_4 find v(tn26) at=9e-09
meas tran m_p27_4 find v(tp27) at=9e-09
meas tran m_n27_4 find v(tn27) at=9e-09
meas tran m_p28_4 find v(tp28) at=9e-09
meas tran m_n28_4 find v(tn28) at=9e-09
meas tran m_p29_4 find v(tp29) at=9e-09
meas tran m_n29_4 find v(tn29) at=9e-09
meas tran m_p30_4 find v(tp30) at=9e-09
meas tran m_n30_4 find v(tn30) at=9e-09
meas tran m_p31_4 find v(tp31) at=9e-09
meas tran m_n31_4 find v(tn31) at=9e-09
meas tran m_p32_4 find v(tp32) at=9e-09
meas tran m_n32_4 find v(tn32) at=9e-09
meas tran m_p33_4 find v(tp33) at=9e-09
meas tran m_n33_4 find v(tn33) at=9e-09
meas tran m_p34_4 find v(tp34) at=9e-09
meas tran m_n34_4 find v(tn34) at=9e-09
meas tran m_p35_4 find v(tp35) at=9e-09
meas tran m_n35_4 find v(tn35) at=9e-09
meas tran m_p36_4 find v(tp36) at=9e-09
meas tran m_n36_4 find v(tn36) at=9e-09
meas tran m_p37_4 find v(tp37) at=9e-09
meas tran m_n37_4 find v(tn37) at=9e-09
meas tran m_p38_4 find v(tp38) at=9e-09
meas tran m_n38_4 find v(tn38) at=9e-09
meas tran m_p39_4 find v(tp39) at=9e-09
meas tran m_n39_4 find v(tn39) at=9e-09
meas tran m_p40_4 find v(tp40) at=9e-09
meas tran m_n40_4 find v(tn40) at=9e-09
meas tran m_p41_4 find v(tp41) at=9e-09
meas tran m_n41_4 find v(tn41) at=9e-09
meas tran m_p42_4 find v(tp42) at=9e-09
meas tran m_n42_4 find v(tn42) at=9e-09
meas tran m_p43_4 find v(tp43) at=9e-09
meas tran m_n43_4 find v(tn43) at=9e-09
meas tran m_p44_4 find v(tp44) at=9e-09
meas tran m_n44_4 find v(tn44) at=9e-09
meas tran m_p45_4 find v(tp45) at=9e-09
meas tran m_n45_4 find v(tn45) at=9e-09
meas tran m_p46_4 find v(tp46) at=9e-09
meas tran m_n46_4 find v(tn46) at=9e-09
meas tran m_p47_4 find v(tp47) at=9e-09
meas tran m_n47_4 find v(tn47) at=9e-09
meas tran m_p48_4 find v(tp48) at=9e-09
meas tran m_n48_4 find v(tn48) at=9e-09
meas tran m_p49_4 find v(tp49) at=9e-09
meas tran m_n49_4 find v(tn49) at=9e-09
meas tran m_p0_5 find v(tp0) at=1.1e-08
meas tran m_n0_5 find v(tn0) at=1.1e-08
meas tran m_p1_5 find v(tp1) at=1.1e-08
meas tran m_n1_5 find v(tn1) at=1.1e-08
meas tran m_p2_5 find v(tp2) at=1.1e-08
meas tran m_n2_5 find v(tn2) at=1.1e-08
meas tran m_p3_5 find v(tp3) at=1.1e-08
meas tran m_n3_5 find v(tn3) at=1.1e-08
meas tran m_p4_5 find v(tp4) at=1.1e-08
meas tran m_n4_5 find v(tn4) at=1.1e-08
meas tran m_p5_5 find v(tp5) at=1.1e-08
meas tran m_n5_5 find v(tn5) at=1.1e-08
meas tran m_p6_5 find v(tp6) at=1.1e-08
meas tran m_n6_5 find v(tn6) at=1.1e-08
meas tran m_p7_5 find v(tp7) at=1.1e-08
meas tran m_n7_5 find v(tn7) at=1.1e-08
meas tran m_p8_5 find v(tp8) at=1.1e-08
meas tran m_n8_5 find v(tn8) at=1.1e-08
meas tran m_p9_5 find v(tp9) at=1.1e-08
meas tran m_n9_5 find v(tn9) at=1.1e-08
meas tran m_p10_5 find v(tp10) at=1.1e-08
meas tran m_n10_5 find v(tn10) at=1.1e-08
meas tran m_p11_5 find v(tp11) at=1.1e-08
meas tran m_n11_5 find v(tn11) at=1.1e-08
meas tran m_p12_5 find v(tp12) at=1.1e-08
meas tran m_n12_5 find v(tn12) at=1.1e-08
meas tran m_p13_5 find v(tp13) at=1.1e-08
meas tran m_n13_5 find v(tn13) at=1.1e-08
meas tran m_p14_5 find v(tp14) at=1.1e-08
meas tran m_n14_5 find v(tn14) at=1.1e-08
meas tran m_p15_5 find v(tp15) at=1.1e-08
meas tran m_n15_5 find v(tn15) at=1.1e-08
meas tran m_p16_5 find v(tp16) at=1.1e-08
meas tran m_n16_5 find v(tn16) at=1.1e-08
meas tran m_p17_5 find v(tp17) at=1.1e-08
meas tran m_n17_5 find v(tn17) at=1.1e-08
meas tran m_p18_5 find v(tp18) at=1.1e-08
meas tran m_n18_5 find v(tn18) at=1.1e-08
meas tran m_p19_5 find v(tp19) at=1.1e-08
meas tran m_n19_5 find v(tn19) at=1.1e-08
meas tran m_p20_5 find v(tp20) at=1.1e-08
meas tran m_n20_5 find v(tn20) at=1.1e-08
meas tran m_p21_5 find v(tp21) at=1.1e-08
meas tran m_n21_5 find v(tn21) at=1.1e-08
meas tran m_p22_5 find v(tp22) at=1.1e-08
meas tran m_n22_5 find v(tn22) at=1.1e-08
meas tran m_p23_5 find v(tp23) at=1.1e-08
meas tran m_n23_5 find v(tn23) at=1.1e-08
meas tran m_p24_5 find v(tp24) at=1.1e-08
meas tran m_n24_5 find v(tn24) at=1.1e-08
meas tran m_p25_5 find v(tp25) at=1.1e-08
meas tran m_n25_5 find v(tn25) at=1.1e-08
meas tran m_p26_5 find v(tp26) at=1.1e-08
meas tran m_n26_5 find v(tn26) at=1.1e-08
meas tran m_p27_5 find v(tp27) at=1.1e-08
meas tran m_n27_5 find v(tn27) at=1.1e-08
meas tran m_p28_5 find v(tp28) at=1.1e-08
meas tran m_n28_5 find v(tn28) at=1.1e-08
meas tran m_p29_5 find v(tp29) at=1.1e-08
meas tran m_n29_5 find v(tn29) at=1.1e-08
meas tran m_p30_5 find v(tp30) at=1.1e-08
meas tran m_n30_5 find v(tn30) at=1.1e-08
meas tran m_p31_5 find v(tp31) at=1.1e-08
meas tran m_n31_5 find v(tn31) at=1.1e-08
meas tran m_p32_5 find v(tp32) at=1.1e-08
meas tran m_n32_5 find v(tn32) at=1.1e-08
meas tran m_p33_5 find v(tp33) at=1.1e-08
meas tran m_n33_5 find v(tn33) at=1.1e-08
meas tran m_p34_5 find v(tp34) at=1.1e-08
meas tran m_n34_5 find v(tn34) at=1.1e-08
meas tran m_p35_5 find v(tp35) at=1.1e-08
meas tran m_n35_5 find v(tn35) at=1.1e-08
meas tran m_p36_5 find v(tp36) at=1.1e-08
meas tran m_n36_5 find v(tn36) at=1.1e-08
meas tran m_p37_5 find v(tp37) at=1.1e-08
meas tran m_n37_5 find v(tn37) at=1.1e-08
meas tran m_p38_5 find v(tp38) at=1.1e-08
meas tran m_n38_5 find v(tn38) at=1.1e-08
meas tran m_p39_5 find v(tp39) at=1.1e-08
meas tran m_n39_5 find v(tn39) at=1.1e-08
meas tran m_p40_5 find v(tp40) at=1.1e-08
meas tran m_n40_5 find v(tn40) at=1.1e-08
meas tran m_p41_5 find v(tp41) at=1.1e-08
meas tran m_n41_5 find v(tn41) at=1.1e-08
meas tran m_p42_5 find v(tp42) at=1.1e-08
meas tran m_n42_5 find v(tn42) at=1.1e-08
meas tran m_p43_5 find v(tp43) at=1.1e-08
meas tran m_n43_5 find v(tn43) at=1.1e-08
meas tran m_p44_5 find v(tp44) at=1.1e-08
meas tran m_n44_5 find v(tn44) at=1.1e-08
meas tran m_p45_5 find v(tp45) at=1.1e-08
meas tran m_n45_5 find v(tn45) at=1.1e-08
meas tran m_p46_5 find v(tp46) at=1.1e-08
meas tran m_n46_5 find v(tn46) at=1.1e-08
meas tran m_p47_5 find v(tp47) at=1.1e-08
meas tran m_n47_5 find v(tn47) at=1.1e-08
meas tran m_p48_5 find v(tp48) at=1.1e-08
meas tran m_n48_5 find v(tn48) at=1.1e-08
meas tran m_p49_5 find v(tp49) at=1.1e-08
meas tran m_n49_5 find v(tn49) at=1.1e-08
meas tran m_p0_6 find v(tp0) at=1.3e-08
meas tran m_n0_6 find v(tn0) at=1.3e-08
meas tran m_p1_6 find v(tp1) at=1.3e-08
meas tran m_n1_6 find v(tn1) at=1.3e-08
meas tran m_p2_6 find v(tp2) at=1.3e-08
meas tran m_n2_6 find v(tn2) at=1.3e-08
meas tran m_p3_6 find v(tp3) at=1.3e-08
meas tran m_n3_6 find v(tn3) at=1.3e-08
meas tran m_p4_6 find v(tp4) at=1.3e-08
meas tran m_n4_6 find v(tn4) at=1.3e-08
meas tran m_p5_6 find v(tp5) at=1.3e-08
meas tran m_n5_6 find v(tn5) at=1.3e-08
meas tran m_p6_6 find v(tp6) at=1.3e-08
meas tran m_n6_6 find v(tn6) at=1.3e-08
meas tran m_p7_6 find v(tp7) at=1.3e-08
meas tran m_n7_6 find v(tn7) at=1.3e-08
meas tran m_p8_6 find v(tp8) at=1.3e-08
meas tran m_n8_6 find v(tn8) at=1.3e-08
meas tran m_p9_6 find v(tp9) at=1.3e-08
meas tran m_n9_6 find v(tn9) at=1.3e-08
meas tran m_p10_6 find v(tp10) at=1.3e-08
meas tran m_n10_6 find v(tn10) at=1.3e-08
meas tran m_p11_6 find v(tp11) at=1.3e-08
meas tran m_n11_6 find v(tn11) at=1.3e-08
meas tran m_p12_6 find v(tp12) at=1.3e-08
meas tran m_n12_6 find v(tn12) at=1.3e-08
meas tran m_p13_6 find v(tp13) at=1.3e-08
meas tran m_n13_6 find v(tn13) at=1.3e-08
meas tran m_p14_6 find v(tp14) at=1.3e-08
meas tran m_n14_6 find v(tn14) at=1.3e-08
meas tran m_p15_6 find v(tp15) at=1.3e-08
meas tran m_n15_6 find v(tn15) at=1.3e-08
meas tran m_p16_6 find v(tp16) at=1.3e-08
meas tran m_n16_6 find v(tn16) at=1.3e-08
meas tran m_p17_6 find v(tp17) at=1.3e-08
meas tran m_n17_6 find v(tn17) at=1.3e-08
meas tran m_p18_6 find v(tp18) at=1.3e-08
meas tran m_n18_6 find v(tn18) at=1.3e-08
meas tran m_p19_6 find v(tp19) at=1.3e-08
meas tran m_n19_6 find v(tn19) at=1.3e-08
meas tran m_p20_6 find v(tp20) at=1.3e-08
meas tran m_n20_6 find v(tn20) at=1.3e-08
meas tran m_p21_6 find v(tp21) at=1.3e-08
meas tran m_n21_6 find v(tn21) at=1.3e-08
meas tran m_p22_6 find v(tp22) at=1.3e-08
meas tran m_n22_6 find v(tn22) at=1.3e-08
meas tran m_p23_6 find v(tp23) at=1.3e-08
meas tran m_n23_6 find v(tn23) at=1.3e-08
meas tran m_p24_6 find v(tp24) at=1.3e-08
meas tran m_n24_6 find v(tn24) at=1.3e-08
meas tran m_p25_6 find v(tp25) at=1.3e-08
meas tran m_n25_6 find v(tn25) at=1.3e-08
meas tran m_p26_6 find v(tp26) at=1.3e-08
meas tran m_n26_6 find v(tn26) at=1.3e-08
meas tran m_p27_6 find v(tp27) at=1.3e-08
meas tran m_n27_6 find v(tn27) at=1.3e-08
meas tran m_p28_6 find v(tp28) at=1.3e-08
meas tran m_n28_6 find v(tn28) at=1.3e-08
meas tran m_p29_6 find v(tp29) at=1.3e-08
meas tran m_n29_6 find v(tn29) at=1.3e-08
meas tran m_p30_6 find v(tp30) at=1.3e-08
meas tran m_n30_6 find v(tn30) at=1.3e-08
meas tran m_p31_6 find v(tp31) at=1.3e-08
meas tran m_n31_6 find v(tn31) at=1.3e-08
meas tran m_p32_6 find v(tp32) at=1.3e-08
meas tran m_n32_6 find v(tn32) at=1.3e-08
meas tran m_p33_6 find v(tp33) at=1.3e-08
meas tran m_n33_6 find v(tn33) at=1.3e-08
meas tran m_p34_6 find v(tp34) at=1.3e-08
meas tran m_n34_6 find v(tn34) at=1.3e-08
meas tran m_p35_6 find v(tp35) at=1.3e-08
meas tran m_n35_6 find v(tn35) at=1.3e-08
meas tran m_p36_6 find v(tp36) at=1.3e-08
meas tran m_n36_6 find v(tn36) at=1.3e-08
meas tran m_p37_6 find v(tp37) at=1.3e-08
meas tran m_n37_6 find v(tn37) at=1.3e-08
meas tran m_p38_6 find v(tp38) at=1.3e-08
meas tran m_n38_6 find v(tn38) at=1.3e-08
meas tran m_p39_6 find v(tp39) at=1.3e-08
meas tran m_n39_6 find v(tn39) at=1.3e-08
meas tran m_p40_6 find v(tp40) at=1.3e-08
meas tran m_n40_6 find v(tn40) at=1.3e-08
meas tran m_p41_6 find v(tp41) at=1.3e-08
meas tran m_n41_6 find v(tn41) at=1.3e-08
meas tran m_p42_6 find v(tp42) at=1.3e-08
meas tran m_n42_6 find v(tn42) at=1.3e-08
meas tran m_p43_6 find v(tp43) at=1.3e-08
meas tran m_n43_6 find v(tn43) at=1.3e-08
meas tran m_p44_6 find v(tp44) at=1.3e-08
meas tran m_n44_6 find v(tn44) at=1.3e-08
meas tran m_p45_6 find v(tp45) at=1.3e-08
meas tran m_n45_6 find v(tn45) at=1.3e-08
meas tran m_p46_6 find v(tp46) at=1.3e-08
meas tran m_n46_6 find v(tn46) at=1.3e-08
meas tran m_p47_6 find v(tp47) at=1.3e-08
meas tran m_n47_6 find v(tn47) at=1.3e-08
meas tran m_p48_6 find v(tp48) at=1.3e-08
meas tran m_n48_6 find v(tn48) at=1.3e-08
meas tran m_p49_6 find v(tp49) at=1.3e-08
meas tran m_n49_6 find v(tn49) at=1.3e-08
meas tran m_p0_7 find v(tp0) at=1.5e-08
meas tran m_n0_7 find v(tn0) at=1.5e-08
meas tran m_p1_7 find v(tp1) at=1.5e-08
meas tran m_n1_7 find v(tn1) at=1.5e-08
meas tran m_p2_7 find v(tp2) at=1.5e-08
meas tran m_n2_7 find v(tn2) at=1.5e-08
meas tran m_p3_7 find v(tp3) at=1.5e-08
meas tran m_n3_7 find v(tn3) at=1.5e-08
meas tran m_p4_7 find v(tp4) at=1.5e-08
meas tran m_n4_7 find v(tn4) at=1.5e-08
meas tran m_p5_7 find v(tp5) at=1.5e-08
meas tran m_n5_7 find v(tn5) at=1.5e-08
meas tran m_p6_7 find v(tp6) at=1.5e-08
meas tran m_n6_7 find v(tn6) at=1.5e-08
meas tran m_p7_7 find v(tp7) at=1.5e-08
meas tran m_n7_7 find v(tn7) at=1.5e-08
meas tran m_p8_7 find v(tp8) at=1.5e-08
meas tran m_n8_7 find v(tn8) at=1.5e-08
meas tran m_p9_7 find v(tp9) at=1.5e-08
meas tran m_n9_7 find v(tn9) at=1.5e-08
meas tran m_p10_7 find v(tp10) at=1.5e-08
meas tran m_n10_7 find v(tn10) at=1.5e-08
meas tran m_p11_7 find v(tp11) at=1.5e-08
meas tran m_n11_7 find v(tn11) at=1.5e-08
meas tran m_p12_7 find v(tp12) at=1.5e-08
meas tran m_n12_7 find v(tn12) at=1.5e-08
meas tran m_p13_7 find v(tp13) at=1.5e-08
meas tran m_n13_7 find v(tn13) at=1.5e-08
meas tran m_p14_7 find v(tp14) at=1.5e-08
meas tran m_n14_7 find v(tn14) at=1.5e-08
meas tran m_p15_7 find v(tp15) at=1.5e-08
meas tran m_n15_7 find v(tn15) at=1.5e-08
meas tran m_p16_7 find v(tp16) at=1.5e-08
meas tran m_n16_7 find v(tn16) at=1.5e-08
meas tran m_p17_7 find v(tp17) at=1.5e-08
meas tran m_n17_7 find v(tn17) at=1.5e-08
meas tran m_p18_7 find v(tp18) at=1.5e-08
meas tran m_n18_7 find v(tn18) at=1.5e-08
meas tran m_p19_7 find v(tp19) at=1.5e-08
meas tran m_n19_7 find v(tn19) at=1.5e-08
meas tran m_p20_7 find v(tp20) at=1.5e-08
meas tran m_n20_7 find v(tn20) at=1.5e-08
meas tran m_p21_7 find v(tp21) at=1.5e-08
meas tran m_n21_7 find v(tn21) at=1.5e-08
meas tran m_p22_7 find v(tp22) at=1.5e-08
meas tran m_n22_7 find v(tn22) at=1.5e-08
meas tran m_p23_7 find v(tp23) at=1.5e-08
meas tran m_n23_7 find v(tn23) at=1.5e-08
meas tran m_p24_7 find v(tp24) at=1.5e-08
meas tran m_n24_7 find v(tn24) at=1.5e-08
meas tran m_p25_7 find v(tp25) at=1.5e-08
meas tran m_n25_7 find v(tn25) at=1.5e-08
meas tran m_p26_7 find v(tp26) at=1.5e-08
meas tran m_n26_7 find v(tn26) at=1.5e-08
meas tran m_p27_7 find v(tp27) at=1.5e-08
meas tran m_n27_7 find v(tn27) at=1.5e-08
meas tran m_p28_7 find v(tp28) at=1.5e-08
meas tran m_n28_7 find v(tn28) at=1.5e-08
meas tran m_p29_7 find v(tp29) at=1.5e-08
meas tran m_n29_7 find v(tn29) at=1.5e-08
meas tran m_p30_7 find v(tp30) at=1.5e-08
meas tran m_n30_7 find v(tn30) at=1.5e-08
meas tran m_p31_7 find v(tp31) at=1.5e-08
meas tran m_n31_7 find v(tn31) at=1.5e-08
meas tran m_p32_7 find v(tp32) at=1.5e-08
meas tran m_n32_7 find v(tn32) at=1.5e-08
meas tran m_p33_7 find v(tp33) at=1.5e-08
meas tran m_n33_7 find v(tn33) at=1.5e-08
meas tran m_p34_7 find v(tp34) at=1.5e-08
meas tran m_n34_7 find v(tn34) at=1.5e-08
meas tran m_p35_7 find v(tp35) at=1.5e-08
meas tran m_n35_7 find v(tn35) at=1.5e-08
meas tran m_p36_7 find v(tp36) at=1.5e-08
meas tran m_n36_7 find v(tn36) at=1.5e-08
meas tran m_p37_7 find v(tp37) at=1.5e-08
meas tran m_n37_7 find v(tn37) at=1.5e-08
meas tran m_p38_7 find v(tp38) at=1.5e-08
meas tran m_n38_7 find v(tn38) at=1.5e-08
meas tran m_p39_7 find v(tp39) at=1.5e-08
meas tran m_n39_7 find v(tn39) at=1.5e-08
meas tran m_p40_7 find v(tp40) at=1.5e-08
meas tran m_n40_7 find v(tn40) at=1.5e-08
meas tran m_p41_7 find v(tp41) at=1.5e-08
meas tran m_n41_7 find v(tn41) at=1.5e-08
meas tran m_p42_7 find v(tp42) at=1.5e-08
meas tran m_n42_7 find v(tn42) at=1.5e-08
meas tran m_p43_7 find v(tp43) at=1.5e-08
meas tran m_n43_7 find v(tn43) at=1.5e-08
meas tran m_p44_7 find v(tp44) at=1.5e-08
meas tran m_n44_7 find v(tn44) at=1.5e-08
meas tran m_p45_7 find v(tp45) at=1.5e-08
meas tran m_n45_7 find v(tn45) at=1.5e-08
meas tran m_p46_7 find v(tp46) at=1.5e-08
meas tran m_n46_7 find v(tn46) at=1.5e-08
meas tran m_p47_7 find v(tp47) at=1.5e-08
meas tran m_n47_7 find v(tn47) at=1.5e-08
meas tran m_p48_7 find v(tp48) at=1.5e-08
meas tran m_n48_7 find v(tn48) at=1.5e-08
meas tran m_p49_7 find v(tp49) at=1.5e-08
meas tran m_n49_7 find v(tn49) at=1.5e-08
meas tran m_p0_8 find v(tp0) at=1.7e-08
meas tran m_n0_8 find v(tn0) at=1.7e-08
meas tran m_p1_8 find v(tp1) at=1.7e-08
meas tran m_n1_8 find v(tn1) at=1.7e-08
meas tran m_p2_8 find v(tp2) at=1.7e-08
meas tran m_n2_8 find v(tn2) at=1.7e-08
meas tran m_p3_8 find v(tp3) at=1.7e-08
meas tran m_n3_8 find v(tn3) at=1.7e-08
meas tran m_p4_8 find v(tp4) at=1.7e-08
meas tran m_n4_8 find v(tn4) at=1.7e-08
meas tran m_p5_8 find v(tp5) at=1.7e-08
meas tran m_n5_8 find v(tn5) at=1.7e-08
meas tran m_p6_8 find v(tp6) at=1.7e-08
meas tran m_n6_8 find v(tn6) at=1.7e-08
meas tran m_p7_8 find v(tp7) at=1.7e-08
meas tran m_n7_8 find v(tn7) at=1.7e-08
meas tran m_p8_8 find v(tp8) at=1.7e-08
meas tran m_n8_8 find v(tn8) at=1.7e-08
meas tran m_p9_8 find v(tp9) at=1.7e-08
meas tran m_n9_8 find v(tn9) at=1.7e-08
meas tran m_p10_8 find v(tp10) at=1.7e-08
meas tran m_n10_8 find v(tn10) at=1.7e-08
meas tran m_p11_8 find v(tp11) at=1.7e-08
meas tran m_n11_8 find v(tn11) at=1.7e-08
meas tran m_p12_8 find v(tp12) at=1.7e-08
meas tran m_n12_8 find v(tn12) at=1.7e-08
meas tran m_p13_8 find v(tp13) at=1.7e-08
meas tran m_n13_8 find v(tn13) at=1.7e-08
meas tran m_p14_8 find v(tp14) at=1.7e-08
meas tran m_n14_8 find v(tn14) at=1.7e-08
meas tran m_p15_8 find v(tp15) at=1.7e-08
meas tran m_n15_8 find v(tn15) at=1.7e-08
meas tran m_p16_8 find v(tp16) at=1.7e-08
meas tran m_n16_8 find v(tn16) at=1.7e-08
meas tran m_p17_8 find v(tp17) at=1.7e-08
meas tran m_n17_8 find v(tn17) at=1.7e-08
meas tran m_p18_8 find v(tp18) at=1.7e-08
meas tran m_n18_8 find v(tn18) at=1.7e-08
meas tran m_p19_8 find v(tp19) at=1.7e-08
meas tran m_n19_8 find v(tn19) at=1.7e-08
meas tran m_p20_8 find v(tp20) at=1.7e-08
meas tran m_n20_8 find v(tn20) at=1.7e-08
meas tran m_p21_8 find v(tp21) at=1.7e-08
meas tran m_n21_8 find v(tn21) at=1.7e-08
meas tran m_p22_8 find v(tp22) at=1.7e-08
meas tran m_n22_8 find v(tn22) at=1.7e-08
meas tran m_p23_8 find v(tp23) at=1.7e-08
meas tran m_n23_8 find v(tn23) at=1.7e-08
meas tran m_p24_8 find v(tp24) at=1.7e-08
meas tran m_n24_8 find v(tn24) at=1.7e-08
meas tran m_p25_8 find v(tp25) at=1.7e-08
meas tran m_n25_8 find v(tn25) at=1.7e-08
meas tran m_p26_8 find v(tp26) at=1.7e-08
meas tran m_n26_8 find v(tn26) at=1.7e-08
meas tran m_p27_8 find v(tp27) at=1.7e-08
meas tran m_n27_8 find v(tn27) at=1.7e-08
meas tran m_p28_8 find v(tp28) at=1.7e-08
meas tran m_n28_8 find v(tn28) at=1.7e-08
meas tran m_p29_8 find v(tp29) at=1.7e-08
meas tran m_n29_8 find v(tn29) at=1.7e-08
meas tran m_p30_8 find v(tp30) at=1.7e-08
meas tran m_n30_8 find v(tn30) at=1.7e-08
meas tran m_p31_8 find v(tp31) at=1.7e-08
meas tran m_n31_8 find v(tn31) at=1.7e-08
meas tran m_p32_8 find v(tp32) at=1.7e-08
meas tran m_n32_8 find v(tn32) at=1.7e-08
meas tran m_p33_8 find v(tp33) at=1.7e-08
meas tran m_n33_8 find v(tn33) at=1.7e-08
meas tran m_p34_8 find v(tp34) at=1.7e-08
meas tran m_n34_8 find v(tn34) at=1.7e-08
meas tran m_p35_8 find v(tp35) at=1.7e-08
meas tran m_n35_8 find v(tn35) at=1.7e-08
meas tran m_p36_8 find v(tp36) at=1.7e-08
meas tran m_n36_8 find v(tn36) at=1.7e-08
meas tran m_p37_8 find v(tp37) at=1.7e-08
meas tran m_n37_8 find v(tn37) at=1.7e-08
meas tran m_p38_8 find v(tp38) at=1.7e-08
meas tran m_n38_8 find v(tn38) at=1.7e-08
meas tran m_p39_8 find v(tp39) at=1.7e-08
meas tran m_n39_8 find v(tn39) at=1.7e-08
meas tran m_p40_8 find v(tp40) at=1.7e-08
meas tran m_n40_8 find v(tn40) at=1.7e-08
meas tran m_p41_8 find v(tp41) at=1.7e-08
meas tran m_n41_8 find v(tn41) at=1.7e-08
meas tran m_p42_8 find v(tp42) at=1.7e-08
meas tran m_n42_8 find v(tn42) at=1.7e-08
meas tran m_p43_8 find v(tp43) at=1.7e-08
meas tran m_n43_8 find v(tn43) at=1.7e-08
meas tran m_p44_8 find v(tp44) at=1.7e-08
meas tran m_n44_8 find v(tn44) at=1.7e-08
meas tran m_p45_8 find v(tp45) at=1.7e-08
meas tran m_n45_8 find v(tn45) at=1.7e-08
meas tran m_p46_8 find v(tp46) at=1.7e-08
meas tran m_n46_8 find v(tn46) at=1.7e-08
meas tran m_p47_8 find v(tp47) at=1.7e-08
meas tran m_n47_8 find v(tn47) at=1.7e-08
meas tran m_p48_8 find v(tp48) at=1.7e-08
meas tran m_n48_8 find v(tn48) at=1.7e-08
meas tran m_p49_8 find v(tp49) at=1.7e-08
meas tran m_n49_8 find v(tn49) at=1.7e-08
meas tran m_p0_9 find v(tp0) at=1.9e-08
meas tran m_n0_9 find v(tn0) at=1.9e-08
meas tran m_p1_9 find v(tp1) at=1.9e-08
meas tran m_n1_9 find v(tn1) at=1.9e-08
meas tran m_p2_9 find v(tp2) at=1.9e-08
meas tran m_n2_9 find v(tn2) at=1.9e-08
meas tran m_p3_9 find v(tp3) at=1.9e-08
meas tran m_n3_9 find v(tn3) at=1.9e-08
meas tran m_p4_9 find v(tp4) at=1.9e-08
meas tran m_n4_9 find v(tn4) at=1.9e-08
meas tran m_p5_9 find v(tp5) at=1.9e-08
meas tran m_n5_9 find v(tn5) at=1.9e-08
meas tran m_p6_9 find v(tp6) at=1.9e-08
meas tran m_n6_9 find v(tn6) at=1.9e-08
meas tran m_p7_9 find v(tp7) at=1.9e-08
meas tran m_n7_9 find v(tn7) at=1.9e-08
meas tran m_p8_9 find v(tp8) at=1.9e-08
meas tran m_n8_9 find v(tn8) at=1.9e-08
meas tran m_p9_9 find v(tp9) at=1.9e-08
meas tran m_n9_9 find v(tn9) at=1.9e-08
meas tran m_p10_9 find v(tp10) at=1.9e-08
meas tran m_n10_9 find v(tn10) at=1.9e-08
meas tran m_p11_9 find v(tp11) at=1.9e-08
meas tran m_n11_9 find v(tn11) at=1.9e-08
meas tran m_p12_9 find v(tp12) at=1.9e-08
meas tran m_n12_9 find v(tn12) at=1.9e-08
meas tran m_p13_9 find v(tp13) at=1.9e-08
meas tran m_n13_9 find v(tn13) at=1.9e-08
meas tran m_p14_9 find v(tp14) at=1.9e-08
meas tran m_n14_9 find v(tn14) at=1.9e-08
meas tran m_p15_9 find v(tp15) at=1.9e-08
meas tran m_n15_9 find v(tn15) at=1.9e-08
meas tran m_p16_9 find v(tp16) at=1.9e-08
meas tran m_n16_9 find v(tn16) at=1.9e-08
meas tran m_p17_9 find v(tp17) at=1.9e-08
meas tran m_n17_9 find v(tn17) at=1.9e-08
meas tran m_p18_9 find v(tp18) at=1.9e-08
meas tran m_n18_9 find v(tn18) at=1.9e-08
meas tran m_p19_9 find v(tp19) at=1.9e-08
meas tran m_n19_9 find v(tn19) at=1.9e-08
meas tran m_p20_9 find v(tp20) at=1.9e-08
meas tran m_n20_9 find v(tn20) at=1.9e-08
meas tran m_p21_9 find v(tp21) at=1.9e-08
meas tran m_n21_9 find v(tn21) at=1.9e-08
meas tran m_p22_9 find v(tp22) at=1.9e-08
meas tran m_n22_9 find v(tn22) at=1.9e-08
meas tran m_p23_9 find v(tp23) at=1.9e-08
meas tran m_n23_9 find v(tn23) at=1.9e-08
meas tran m_p24_9 find v(tp24) at=1.9e-08
meas tran m_n24_9 find v(tn24) at=1.9e-08
meas tran m_p25_9 find v(tp25) at=1.9e-08
meas tran m_n25_9 find v(tn25) at=1.9e-08
meas tran m_p26_9 find v(tp26) at=1.9e-08
meas tran m_n26_9 find v(tn26) at=1.9e-08
meas tran m_p27_9 find v(tp27) at=1.9e-08
meas tran m_n27_9 find v(tn27) at=1.9e-08
meas tran m_p28_9 find v(tp28) at=1.9e-08
meas tran m_n28_9 find v(tn28) at=1.9e-08
meas tran m_p29_9 find v(tp29) at=1.9e-08
meas tran m_n29_9 find v(tn29) at=1.9e-08
meas tran m_p30_9 find v(tp30) at=1.9e-08
meas tran m_n30_9 find v(tn30) at=1.9e-08
meas tran m_p31_9 find v(tp31) at=1.9e-08
meas tran m_n31_9 find v(tn31) at=1.9e-08
meas tran m_p32_9 find v(tp32) at=1.9e-08
meas tran m_n32_9 find v(tn32) at=1.9e-08
meas tran m_p33_9 find v(tp33) at=1.9e-08
meas tran m_n33_9 find v(tn33) at=1.9e-08
meas tran m_p34_9 find v(tp34) at=1.9e-08
meas tran m_n34_9 find v(tn34) at=1.9e-08
meas tran m_p35_9 find v(tp35) at=1.9e-08
meas tran m_n35_9 find v(tn35) at=1.9e-08
meas tran m_p36_9 find v(tp36) at=1.9e-08
meas tran m_n36_9 find v(tn36) at=1.9e-08
meas tran m_p37_9 find v(tp37) at=1.9e-08
meas tran m_n37_9 find v(tn37) at=1.9e-08
meas tran m_p38_9 find v(tp38) at=1.9e-08
meas tran m_n38_9 find v(tn38) at=1.9e-08
meas tran m_p39_9 find v(tp39) at=1.9e-08
meas tran m_n39_9 find v(tn39) at=1.9e-08
meas tran m_p40_9 find v(tp40) at=1.9e-08
meas tran m_n40_9 find v(tn40) at=1.9e-08
meas tran m_p41_9 find v(tp41) at=1.9e-08
meas tran m_n41_9 find v(tn41) at=1.9e-08
meas tran m_p42_9 find v(tp42) at=1.9e-08
meas tran m_n42_9 find v(tn42) at=1.9e-08
meas tran m_p43_9 find v(tp43) at=1.9e-08
meas tran m_n43_9 find v(tn43) at=1.9e-08
meas tran m_p44_9 find v(tp44) at=1.9e-08
meas tran m_n44_9 find v(tn44) at=1.9e-08
meas tran m_p45_9 find v(tp45) at=1.9e-08
meas tran m_n45_9 find v(tn45) at=1.9e-08
meas tran m_p46_9 find v(tp46) at=1.9e-08
meas tran m_n46_9 find v(tn46) at=1.9e-08
meas tran m_p47_9 find v(tp47) at=1.9e-08
meas tran m_n47_9 find v(tn47) at=1.9e-08
meas tran m_p48_9 find v(tp48) at=1.9e-08
meas tran m_n48_9 find v(tn48) at=1.9e-08
meas tran m_p49_9 find v(tp49) at=1.9e-08
meas tran m_n49_9 find v(tn49) at=1.9e-08
meas tran m_p0_10 find v(tp0) at=2.1e-08
meas tran m_n0_10 find v(tn0) at=2.1e-08
meas tran m_p1_10 find v(tp1) at=2.1e-08
meas tran m_n1_10 find v(tn1) at=2.1e-08
meas tran m_p2_10 find v(tp2) at=2.1e-08
meas tran m_n2_10 find v(tn2) at=2.1e-08
meas tran m_p3_10 find v(tp3) at=2.1e-08
meas tran m_n3_10 find v(tn3) at=2.1e-08
meas tran m_p4_10 find v(tp4) at=2.1e-08
meas tran m_n4_10 find v(tn4) at=2.1e-08
meas tran m_p5_10 find v(tp5) at=2.1e-08
meas tran m_n5_10 find v(tn5) at=2.1e-08
meas tran m_p6_10 find v(tp6) at=2.1e-08
meas tran m_n6_10 find v(tn6) at=2.1e-08
meas tran m_p7_10 find v(tp7) at=2.1e-08
meas tran m_n7_10 find v(tn7) at=2.1e-08
meas tran m_p8_10 find v(tp8) at=2.1e-08
meas tran m_n8_10 find v(tn8) at=2.1e-08
meas tran m_p9_10 find v(tp9) at=2.1e-08
meas tran m_n9_10 find v(tn9) at=2.1e-08
meas tran m_p10_10 find v(tp10) at=2.1e-08
meas tran m_n10_10 find v(tn10) at=2.1e-08
meas tran m_p11_10 find v(tp11) at=2.1e-08
meas tran m_n11_10 find v(tn11) at=2.1e-08
meas tran m_p12_10 find v(tp12) at=2.1e-08
meas tran m_n12_10 find v(tn12) at=2.1e-08
meas tran m_p13_10 find v(tp13) at=2.1e-08
meas tran m_n13_10 find v(tn13) at=2.1e-08
meas tran m_p14_10 find v(tp14) at=2.1e-08
meas tran m_n14_10 find v(tn14) at=2.1e-08
meas tran m_p15_10 find v(tp15) at=2.1e-08
meas tran m_n15_10 find v(tn15) at=2.1e-08
meas tran m_p16_10 find v(tp16) at=2.1e-08
meas tran m_n16_10 find v(tn16) at=2.1e-08
meas tran m_p17_10 find v(tp17) at=2.1e-08
meas tran m_n17_10 find v(tn17) at=2.1e-08
meas tran m_p18_10 find v(tp18) at=2.1e-08
meas tran m_n18_10 find v(tn18) at=2.1e-08
meas tran m_p19_10 find v(tp19) at=2.1e-08
meas tran m_n19_10 find v(tn19) at=2.1e-08
meas tran m_p20_10 find v(tp20) at=2.1e-08
meas tran m_n20_10 find v(tn20) at=2.1e-08
meas tran m_p21_10 find v(tp21) at=2.1e-08
meas tran m_n21_10 find v(tn21) at=2.1e-08
meas tran m_p22_10 find v(tp22) at=2.1e-08
meas tran m_n22_10 find v(tn22) at=2.1e-08
meas tran m_p23_10 find v(tp23) at=2.1e-08
meas tran m_n23_10 find v(tn23) at=2.1e-08
meas tran m_p24_10 find v(tp24) at=2.1e-08
meas tran m_n24_10 find v(tn24) at=2.1e-08
meas tran m_p25_10 find v(tp25) at=2.1e-08
meas tran m_n25_10 find v(tn25) at=2.1e-08
meas tran m_p26_10 find v(tp26) at=2.1e-08
meas tran m_n26_10 find v(tn26) at=2.1e-08
meas tran m_p27_10 find v(tp27) at=2.1e-08
meas tran m_n27_10 find v(tn27) at=2.1e-08
meas tran m_p28_10 find v(tp28) at=2.1e-08
meas tran m_n28_10 find v(tn28) at=2.1e-08
meas tran m_p29_10 find v(tp29) at=2.1e-08
meas tran m_n29_10 find v(tn29) at=2.1e-08
meas tran m_p30_10 find v(tp30) at=2.1e-08
meas tran m_n30_10 find v(tn30) at=2.1e-08
meas tran m_p31_10 find v(tp31) at=2.1e-08
meas tran m_n31_10 find v(tn31) at=2.1e-08
meas tran m_p32_10 find v(tp32) at=2.1e-08
meas tran m_n32_10 find v(tn32) at=2.1e-08
meas tran m_p33_10 find v(tp33) at=2.1e-08
meas tran m_n33_10 find v(tn33) at=2.1e-08
meas tran m_p34_10 find v(tp34) at=2.1e-08
meas tran m_n34_10 find v(tn34) at=2.1e-08
meas tran m_p35_10 find v(tp35) at=2.1e-08
meas tran m_n35_10 find v(tn35) at=2.1e-08
meas tran m_p36_10 find v(tp36) at=2.1e-08
meas tran m_n36_10 find v(tn36) at=2.1e-08
meas tran m_p37_10 find v(tp37) at=2.1e-08
meas tran m_n37_10 find v(tn37) at=2.1e-08
meas tran m_p38_10 find v(tp38) at=2.1e-08
meas tran m_n38_10 find v(tn38) at=2.1e-08
meas tran m_p39_10 find v(tp39) at=2.1e-08
meas tran m_n39_10 find v(tn39) at=2.1e-08
meas tran m_p40_10 find v(tp40) at=2.1e-08
meas tran m_n40_10 find v(tn40) at=2.1e-08
meas tran m_p41_10 find v(tp41) at=2.1e-08
meas tran m_n41_10 find v(tn41) at=2.1e-08
meas tran m_p42_10 find v(tp42) at=2.1e-08
meas tran m_n42_10 find v(tn42) at=2.1e-08
meas tran m_p43_10 find v(tp43) at=2.1e-08
meas tran m_n43_10 find v(tn43) at=2.1e-08
meas tran m_p44_10 find v(tp44) at=2.1e-08
meas tran m_n44_10 find v(tn44) at=2.1e-08
meas tran m_p45_10 find v(tp45) at=2.1e-08
meas tran m_n45_10 find v(tn45) at=2.1e-08
meas tran m_p46_10 find v(tp46) at=2.1e-08
meas tran m_n46_10 find v(tn46) at=2.1e-08
meas tran m_p47_10 find v(tp47) at=2.1e-08
meas tran m_n47_10 find v(tn47) at=2.1e-08
meas tran m_p48_10 find v(tp48) at=2.1e-08
meas tran m_n48_10 find v(tn48) at=2.1e-08
meas tran m_p49_10 find v(tp49) at=2.1e-08
meas tran m_n49_10 find v(tn49) at=2.1e-08
meas tran m_p0_11 find v(tp0) at=2.3e-08
meas tran m_n0_11 find v(tn0) at=2.3e-08
meas tran m_p1_11 find v(tp1) at=2.3e-08
meas tran m_n1_11 find v(tn1) at=2.3e-08
meas tran m_p2_11 find v(tp2) at=2.3e-08
meas tran m_n2_11 find v(tn2) at=2.3e-08
meas tran m_p3_11 find v(tp3) at=2.3e-08
meas tran m_n3_11 find v(tn3) at=2.3e-08
meas tran m_p4_11 find v(tp4) at=2.3e-08
meas tran m_n4_11 find v(tn4) at=2.3e-08
meas tran m_p5_11 find v(tp5) at=2.3e-08
meas tran m_n5_11 find v(tn5) at=2.3e-08
meas tran m_p6_11 find v(tp6) at=2.3e-08
meas tran m_n6_11 find v(tn6) at=2.3e-08
meas tran m_p7_11 find v(tp7) at=2.3e-08
meas tran m_n7_11 find v(tn7) at=2.3e-08
meas tran m_p8_11 find v(tp8) at=2.3e-08
meas tran m_n8_11 find v(tn8) at=2.3e-08
meas tran m_p9_11 find v(tp9) at=2.3e-08
meas tran m_n9_11 find v(tn9) at=2.3e-08
meas tran m_p10_11 find v(tp10) at=2.3e-08
meas tran m_n10_11 find v(tn10) at=2.3e-08
meas tran m_p11_11 find v(tp11) at=2.3e-08
meas tran m_n11_11 find v(tn11) at=2.3e-08
meas tran m_p12_11 find v(tp12) at=2.3e-08
meas tran m_n12_11 find v(tn12) at=2.3e-08
meas tran m_p13_11 find v(tp13) at=2.3e-08
meas tran m_n13_11 find v(tn13) at=2.3e-08
meas tran m_p14_11 find v(tp14) at=2.3e-08
meas tran m_n14_11 find v(tn14) at=2.3e-08
meas tran m_p15_11 find v(tp15) at=2.3e-08
meas tran m_n15_11 find v(tn15) at=2.3e-08
meas tran m_p16_11 find v(tp16) at=2.3e-08
meas tran m_n16_11 find v(tn16) at=2.3e-08
meas tran m_p17_11 find v(tp17) at=2.3e-08
meas tran m_n17_11 find v(tn17) at=2.3e-08
meas tran m_p18_11 find v(tp18) at=2.3e-08
meas tran m_n18_11 find v(tn18) at=2.3e-08
meas tran m_p19_11 find v(tp19) at=2.3e-08
meas tran m_n19_11 find v(tn19) at=2.3e-08
meas tran m_p20_11 find v(tp20) at=2.3e-08
meas tran m_n20_11 find v(tn20) at=2.3e-08
meas tran m_p21_11 find v(tp21) at=2.3e-08
meas tran m_n21_11 find v(tn21) at=2.3e-08
meas tran m_p22_11 find v(tp22) at=2.3e-08
meas tran m_n22_11 find v(tn22) at=2.3e-08
meas tran m_p23_11 find v(tp23) at=2.3e-08
meas tran m_n23_11 find v(tn23) at=2.3e-08
meas tran m_p24_11 find v(tp24) at=2.3e-08
meas tran m_n24_11 find v(tn24) at=2.3e-08
meas tran m_p25_11 find v(tp25) at=2.3e-08
meas tran m_n25_11 find v(tn25) at=2.3e-08
meas tran m_p26_11 find v(tp26) at=2.3e-08
meas tran m_n26_11 find v(tn26) at=2.3e-08
meas tran m_p27_11 find v(tp27) at=2.3e-08
meas tran m_n27_11 find v(tn27) at=2.3e-08
meas tran m_p28_11 find v(tp28) at=2.3e-08
meas tran m_n28_11 find v(tn28) at=2.3e-08
meas tran m_p29_11 find v(tp29) at=2.3e-08
meas tran m_n29_11 find v(tn29) at=2.3e-08
meas tran m_p30_11 find v(tp30) at=2.3e-08
meas tran m_n30_11 find v(tn30) at=2.3e-08
meas tran m_p31_11 find v(tp31) at=2.3e-08
meas tran m_n31_11 find v(tn31) at=2.3e-08
meas tran m_p32_11 find v(tp32) at=2.3e-08
meas tran m_n32_11 find v(tn32) at=2.3e-08
meas tran m_p33_11 find v(tp33) at=2.3e-08
meas tran m_n33_11 find v(tn33) at=2.3e-08
meas tran m_p34_11 find v(tp34) at=2.3e-08
meas tran m_n34_11 find v(tn34) at=2.3e-08
meas tran m_p35_11 find v(tp35) at=2.3e-08
meas tran m_n35_11 find v(tn35) at=2.3e-08
meas tran m_p36_11 find v(tp36) at=2.3e-08
meas tran m_n36_11 find v(tn36) at=2.3e-08
meas tran m_p37_11 find v(tp37) at=2.3e-08
meas tran m_n37_11 find v(tn37) at=2.3e-08
meas tran m_p38_11 find v(tp38) at=2.3e-08
meas tran m_n38_11 find v(tn38) at=2.3e-08
meas tran m_p39_11 find v(tp39) at=2.3e-08
meas tran m_n39_11 find v(tn39) at=2.3e-08
meas tran m_p40_11 find v(tp40) at=2.3e-08
meas tran m_n40_11 find v(tn40) at=2.3e-08
meas tran m_p41_11 find v(tp41) at=2.3e-08
meas tran m_n41_11 find v(tn41) at=2.3e-08
meas tran m_p42_11 find v(tp42) at=2.3e-08
meas tran m_n42_11 find v(tn42) at=2.3e-08
meas tran m_p43_11 find v(tp43) at=2.3e-08
meas tran m_n43_11 find v(tn43) at=2.3e-08
meas tran m_p44_11 find v(tp44) at=2.3e-08
meas tran m_n44_11 find v(tn44) at=2.3e-08
meas tran m_p45_11 find v(tp45) at=2.3e-08
meas tran m_n45_11 find v(tn45) at=2.3e-08
meas tran m_p46_11 find v(tp46) at=2.3e-08
meas tran m_n46_11 find v(tn46) at=2.3e-08
meas tran m_p47_11 find v(tp47) at=2.3e-08
meas tran m_n47_11 find v(tn47) at=2.3e-08
meas tran m_p48_11 find v(tp48) at=2.3e-08
meas tran m_n48_11 find v(tn48) at=2.3e-08
meas tran m_p49_11 find v(tp49) at=2.3e-08
meas tran m_n49_11 find v(tn49) at=2.3e-08
write <G1_RESULTS_ROOT>/r1_adc/cdac-mc50-tt/tb.raw
.endc
.end
