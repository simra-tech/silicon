* tb_cmp5n_noise.cir (generated by sim/r5/gen_cmp5_decks.py) -- r1_cmp5n first stage, quasi-static noise
.lib /foss/pdks/ihp-sg13g2/libs.tech/ngspice/models/cornerMOSlv.lib mos_tt
.lib /foss/pdks/ihp-sg13g2/libs.tech/ngspice/models/cornerCAP.lib cap_typ
.lib /foss/pdks/ihp-sg13g2/libs.tech/ngspice/models/cornerRES.lib res_typ
.include schematic/r1_adc_r5.spice
.temp 27
Vdd vdd 0 1.2
Vclk clk 0 1.2
Vx vx 0 0.8
XBn16r vbnn16r vdd 0 r1_cmp5n_bias
Vinpn16r inpn16r 0 DC 0.6 AC 1
Vinnn16r innn16r 0 DC 0.6
Xn16r inpn16r innn16r dpn16r dnn16r clk vbnn16r vdd 0 r1_cmp5n_s1 wi=16u ngi=4 wt=8u wtc=4u
Vdpn16r vx dpn16r 0
Vdnn16r vx dnn16r 0
Hn16r outn16r 0 poly(2) Vdpn16r Vdnn16r 0 1 -1
XBn16c vbnn16c vdd 0 r1_cmp5n_bias
Vinpn16c inpn16c 0 DC 0.6 AC 1
Vinnn16c innn16c 0 DC 0.6
Xn16c inpn16c innn16c dpn16c dnn16c clk vbnn16c vdd 0 r1_cmp5n_s1 wi=16u ngi=4 wt=8u wtc=8u
Vdpn16c vx dpn16c 0
Vdnn16c vx dnn16c 0
Hn16c outn16c 0 poly(2) Vdpn16c Vdnn16c 0 1 -1
XBn12r vbnn12r vdd 0 r1_cmp5n_bias
Vinpn12r inpn12r 0 DC 0.6 AC 1
Vinnn12r innn12r 0 DC 0.6
Xn12r inpn12r innn12r dpn12r dnn12r clk vbnn12r vdd 0 r1_cmp5n_s1 wi=12u ngi=3 wt=6u wtc=3u
Vdpn12r vx dpn12r 0
Vdnn12r vx dnn12r 0
Hn12r outn12r 0 poly(2) Vdpn12r Vdnn12r 0 1 -1
XBn16rl vbnn16rl vdd 0 r1_cmp5n_bias
Vinpn16rl inpn16rl 0 DC 0.6 AC 1
Vinnn16rl innn16rl 0 DC 0.6
Xn16rl inpn16rl innn16rl dpn16rl dnn16rl clk vbnn16rl vdd 0 r1_cmp5n_s1 wi=16u li=0.5u ngi=4 wt=8u wtc=4u
Vdpn16rl vx dpn16rl 0
Vdnn16rl vx dnn16rl 0
Hn16rl outn16rl 0 poly(2) Vdpn16rl Vdnn16rl 0 1 -1
.control
set num_threads=1
set wr_singlescale
set wr_vecnames
op
noise v(outn16r) vinpn16r dec 20 1e3 1e11
setplot noise1
wrdata <G1_RESULTS_ROOT>/r1_adc/r5-cmpn-noise-tt27-c/noise_n16r.txt inoise_spectrum onoise_spectrum
destroy all
reset
op
noise v(outn16c) vinpn16c dec 20 1e3 1e11
setplot noise1
wrdata <G1_RESULTS_ROOT>/r1_adc/r5-cmpn-noise-tt27-c/noise_n16c.txt inoise_spectrum onoise_spectrum
destroy all
reset
op
noise v(outn12r) vinpn12r dec 20 1e3 1e11
setplot noise1
wrdata <G1_RESULTS_ROOT>/r1_adc/r5-cmpn-noise-tt27-c/noise_n12r.txt inoise_spectrum onoise_spectrum
destroy all
reset
op
noise v(outn16rl) vinpn16rl dec 20 1e3 1e11
setplot noise1
wrdata <G1_RESULTS_ROOT>/r1_adc/r5-cmpn-noise-tt27-c/noise_n16rl.txt inoise_spectrum onoise_spectrum
destroy all
reset
.endc
.end
