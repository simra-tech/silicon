* tb_cmp5n_mem.cir (generated by sim/r5/gen_cmp5_decks.py) -- r1_cmp5n variants, one decision per tick, clock from r1_cmp4_clkgen, alternating +30 mV / -ASM input
.lib /foss/pdks/ihp-sg13g2/libs.tech/ngspice/models/cornerMOSlv.lib mos_ss
.lib /foss/pdks/ihp-sg13g2/libs.tech/ngspice/models/cornerCAP.lib cap_typ
.lib /foss/pdks/ihp-sg13g2/libs.tech/ngspice/models/cornerRES.lib res_typ
.include schematic/r1_adc_r5.spice
.temp 125
.option reltol=1e-4 vntol=1e-7 abstol=1e-13 method=gear
Vdd vdd 0 1.08
Vclk30 clk30 0 PULSE(0 1.08 2n 50p 50p 16.6167n 33.3333n)
XCKG clk30 mclk mclkb vdd 0 r1_cmp4_clkgen
Bclk clk 0 v=1.08*0.5*(1+tanh(25*(v(mclk)-0.6)))
Bclkb clkb 0 v=1.08*0.5*(1-tanh(25*(v(mclk)-0.6)))
Vd vd 0 PULSE(0.03 -0.0002 34.1333n 0.2n 0.2n 33.1333n 66.6667n)
V_n16r vdd_n16r vdd 0
XBn16r vbnn16r vdd_n16r 0 r1_cmp5n_bias
Bpn16rh ipn16rh 0 v=0.7+v(vd)/2
Bnn16rh inn16rh 0 v=0.7-v(vd)/2
Xn16rh ipn16rh inn16rh clk clkb opn16rh onn16rh vbnn16r vdd_n16r 0 r1_cmp5n wi=16u ngi=4 wt=8u wtc=4u wcap=40u wr=16u wh=8u
Bpn16rm ipn16rm 0 v=0.6+v(vd)/2
Bnn16rm inn16rm 0 v=0.6-v(vd)/2
Xn16rm ipn16rm inn16rm clk clkb opn16rm onn16rm vbnn16r vdd_n16r 0 r1_cmp5n wi=16u ngi=4 wt=8u wtc=4u wcap=40u wr=16u wh=8u
Bpn16rl ipn16rl 0 v=0.5+v(vd)/2
Bnn16rl inn16rl 0 v=0.5-v(vd)/2
Xn16rl ipn16rl inn16rl clk clkb opn16rl onn16rl vbnn16r vdd_n16r 0 r1_cmp5n wi=16u ngi=4 wt=8u wtc=4u wcap=40u wr=16u wh=8u
V_n16c vdd_n16c vdd 0
XBn16c vbnn16c vdd_n16c 0 r1_cmp5n_bias
Bpn16ch ipn16ch 0 v=0.7+v(vd)/2
Bnn16ch inn16ch 0 v=0.7-v(vd)/2
Xn16ch ipn16ch inn16ch clk clkb opn16ch onn16ch vbnn16c vdd_n16c 0 r1_cmp5n wi=16u ngi=4 wt=8u wtc=8u wcap=20u wr=8u wh=8u
Bpn16cm ipn16cm 0 v=0.6+v(vd)/2
Bnn16cm inn16cm 0 v=0.6-v(vd)/2
Xn16cm ipn16cm inn16cm clk clkb opn16cm onn16cm vbnn16c vdd_n16c 0 r1_cmp5n wi=16u ngi=4 wt=8u wtc=8u wcap=20u wr=8u wh=8u
Bpn16cl ipn16cl 0 v=0.5+v(vd)/2
Bnn16cl inn16cl 0 v=0.5-v(vd)/2
Xn16cl ipn16cl inn16cl clk clkb opn16cl onn16cl vbnn16c vdd_n16c 0 r1_cmp5n wi=16u ngi=4 wt=8u wtc=8u wcap=20u wr=8u wh=8u
V_n12r vdd_n12r vdd 0
XBn12r vbnn12r vdd_n12r 0 r1_cmp5n_bias
Bpn12rh ipn12rh 0 v=0.7+v(vd)/2
Bnn12rh inn12rh 0 v=0.7-v(vd)/2
Xn12rh ipn12rh inn12rh clk clkb opn12rh onn12rh vbnn12r vdd_n12r 0 r1_cmp5n wi=12u ngi=3 wt=6u wtc=3u wcap=30u wr=16u wh=8u
Bpn12rm ipn12rm 0 v=0.6+v(vd)/2
Bnn12rm inn12rm 0 v=0.6-v(vd)/2
Xn12rm ipn12rm inn12rm clk clkb opn12rm onn12rm vbnn12r vdd_n12r 0 r1_cmp5n wi=12u ngi=3 wt=6u wtc=3u wcap=30u wr=16u wh=8u
Bpn12rl ipn12rl 0 v=0.5+v(vd)/2
Bnn12rl inn12rl 0 v=0.5-v(vd)/2
Xn12rl ipn12rl inn12rl clk clkb opn12rl onn12rl vbnn12r vdd_n12r 0 r1_cmp5n wi=12u ngi=3 wt=6u wtc=3u wcap=30u wr=16u wh=8u
V_n16rl vdd_n16rl vdd 0
XBn16rl vbnn16rl vdd_n16rl 0 r1_cmp5n_bias
Bpn16rlh ipn16rlh 0 v=0.7+v(vd)/2
Bnn16rlh inn16rlh 0 v=0.7-v(vd)/2
Xn16rlh ipn16rlh inn16rlh clk clkb opn16rlh onn16rlh vbnn16rl vdd_n16rl 0 r1_cmp5n wi=16u li=0.5u ngi=4 wt=8u wtc=4u wcap=30u wr=16u wh=8u
Bpn16rlm ipn16rlm 0 v=0.6+v(vd)/2
Bnn16rlm inn16rlm 0 v=0.6-v(vd)/2
Xn16rlm ipn16rlm inn16rlm clk clkb opn16rlm onn16rlm vbnn16rl vdd_n16rl 0 r1_cmp5n wi=16u li=0.5u ngi=4 wt=8u wtc=4u wcap=30u wr=16u wh=8u
Bpn16rll ipn16rll 0 v=0.5+v(vd)/2
Bnn16rll inn16rll 0 v=0.5-v(vd)/2
Xn16rll ipn16rll inn16rll clk clkb opn16rll onn16rll vbnn16rl vdd_n16rl 0 r1_cmp5n wi=16u li=0.5u ngi=4 wt=8u wtc=4u wcap=30u wr=16u wh=8u
.control
set num_threads=1
save v(clk30) v(mclk) v(vd) i(vdd) v(opn16rh) v(onn16rh) v(opn16rm) v(onn16rm) v(opn16rl) v(onn16rl) i(v_n16r) v(opn16ch) v(onn16ch) v(opn16cm) v(onn16cm) v(opn16cl) v(onn16cl) i(v_n16c) v(opn12rh) v(onn12rh) v(opn12rm) v(onn12rm) v(opn12rl) v(onn12rl) i(v_n12r) v(opn16rlh) v(onn16rlh) v(opn16rlm) v(onn16rlm) v(opn16rll) v(onn16rll) i(v_n16rl)
tran 5p 335.333n 0 20p
write <G1_RESULTS_ROOT>/r1_adc/r5-cmpn-mem-ss125-c/mem.raw
.endc
.end
