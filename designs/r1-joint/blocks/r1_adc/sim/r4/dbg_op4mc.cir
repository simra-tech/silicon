* tb_adc4_points.cir -- R1 ADC revision 4 (D18): both slices, one held differential input per frame and slice.
* Frame s: slice A samples vda (SIN path) at tsA = 0.6 us + s * 22 T, slice B samples vdb (COS path) at tsA + N T.
* vda/vdb are PWL sources written by sim/r4/run_points4.py (value of frame s applied 550 ns before its edge).
* Inputs are linear E sources around the common mode CM (R2-7: no B sources on the input path).
* Reference: REFLINES (ideal sources, or r1_refbuf4 from an ideal 1.045 V bandgap node; vrefl = LSB-array reference).
* Substitutions: CORNER TEMP VDD CM CORE TIMING OPTS TMAX TSTOP PWLA PWLB REFLINES SAVE RAW
.lib /foss/pdks/ihp-sg13g2/libs.tech/ngspice/models/cornerMOSlv.lib mos_tt
.lib /foss/pdks/ihp-sg13g2/libs.tech/ngspice/models/cornerCAP.lib cap_typ_mismatch
.lib /foss/pdks/ihp-sg13g2/libs.tech/ngspice/models/cornerMOShv.lib mos_tt
.lib /foss/pdks/ihp-sg13g2/libs.tech/ngspice/models/cornerRES.lib res_typ
.include schematic/r1_adc_r4.spice
.include sim/r4/r1_adc_timing_r4_n0.inc
.temp 27
.option @XOPT@ reltol=1e-4 vntol=1e-6 abstol=1e-12 gmin=1e-10 method=trap klu rshunt=1e12 interp seed=12

Vdd vdd 0 1.2
Vref vref 0 1.0
Vrl vrefl vref 0
Vcm vcm 0 0.6
Vda vda 0 PWL(0 -0.0057624 7.833333e-07 -0.0057624 7.933333e-07 -0.0056508 1.516667e-06 -0.0056508 1.526667e-06 -0.0055392 2.250000e-06 -0.0055392 2.260000e-06 -0.0054276 2.983333e-06 -0.0054276
+ 2.993333e-06 -0.0053160 3.716667e-06 -0.0053160 3.726667e-06 -0.0052044 4.450000e-06 -0.0052044 4.460000e-06 -0.0050928 5.183333e-06 -0.0050928 5.193333e-06 -0.0049812 5.916667e-06 -0.0049812
+ 5.926667e-06 -0.0048696 6.650000e-06 -0.0048696 6.660000e-06 -0.0047580 7.383333e-06 -0.0047580 7.393333e-06 -0.0046464 8.116667e-06 -0.0046464 8.126667e-06 -0.0045348 8.850000e-06 -0.0045348
+ 8.860000e-06 -0.0044232 9.583333e-06 -0.0044232 9.593333e-06 -0.0043116 1.031667e-05 -0.0043116 1.032667e-05 -0.0042000 1.105000e-05 -0.0042000 1.106000e-05 -0.0040884 1.178333e-05 -0.0040884
+ 1.179333e-05 -0.0039768 1.251667e-05 -0.0039768 1.252667e-05 -0.0038652 1.325000e-05 -0.0038652 1.326000e-05 -0.0037536 1.398333e-05 -0.0037536 1.399333e-05 -0.0036420 1.471667e-05 -0.0036420
+ 1.472667e-05 -0.0035304 1.545000e-05 -0.0035304 1.546000e-05 -0.0034188 1.618333e-05 -0.0034188 1.619333e-05 -0.0033072 1.691667e-05 -0.0033072 1.692667e-05 -0.0031956 1.765000e-05 -0.0031956
+ 1.766000e-05 -0.0030840 1.838333e-05 -0.0030840 1.839333e-05 -0.0029724 1.911667e-05 -0.0029724 1.912667e-05 -0.0028608 1.985000e-05 -0.0028608 1.986000e-05 -0.0027492 2.058333e-05 -0.0027492
+ 2.059333e-05 -0.0026376 2.131667e-05 -0.0026376 2.132667e-05 0.4537376 2.205000e-05 0.4537376 2.206000e-05 0.4538492 2.278333e-05 0.4538492 2.279333e-05 0.4539608 2.351667e-05 0.4539608
+ 2.352667e-05 0.4540724 2.425000e-05 0.4540724 2.426000e-05 0.4541840 2.498333e-05 0.4541840 2.499333e-05 0.4542956 2.571667e-05 0.4542956 2.572667e-05 0.4544072 2.645000e-05 0.4544072
+ 2.646000e-05 0.4545188 2.718333e-05 0.4545188 2.719333e-05 0.4546304 2.791667e-05 0.4546304 2.792667e-05 0.4547420 2.865000e-05 0.4547420 2.866000e-05 0.4548536 2.938333e-05 0.4548536
+ 2.939333e-05 0.4549652 3.011667e-05 0.4549652 3.012667e-05 0.4550768 3.085000e-05 0.4550768 3.086000e-05 0.4551884 3.158333e-05 0.4551884 3.159333e-05 0.4553000 3.231667e-05 0.4553000
+ 3.232667e-05 0.4554116 3.305000e-05 0.4554116 3.306000e-05 0.4555232 3.378333e-05 0.4555232 3.379333e-05 0.4556348 3.451667e-05 0.4556348 3.452667e-05 0.4557464 3.525000e-05 0.4557464
+ 3.526000e-05 0.4558580 3.598333e-05 0.4558580 3.599333e-05 0.4559696 3.671667e-05 0.4559696 3.672667e-05 0.4560812 3.745000e-05 0.4560812 3.746000e-05 0.4561928 3.818333e-05 0.4561928
+ 3.819333e-05 0.4563044 3.891667e-05 0.4563044 3.892667e-05 0.4564160 3.965000e-05 0.4564160 3.966000e-05 0.4565276 4.038333e-05 0.4565276 4.039333e-05 0.4566392 4.111667e-05 0.4566392
+ 4.112667e-05 0.4567508 4.185000e-05 0.4567508 4.186000e-05 0.4568624 4.258333e-05 0.4568624 4.259333e-05 -0.4568624 4.331667e-05 -0.4568624 4.332667e-05 -0.4567508 4.405000e-05 -0.4567508
+ 4.406000e-05 -0.4566392 4.478333e-05 -0.4566392 4.479333e-05 -0.4565276 4.551667e-05 -0.4565276 4.552667e-05 -0.4564160 4.625000e-05 -0.4564160 4.626000e-05 -0.4563044 4.698333e-05 -0.4563044
+ 4.699333e-05 -0.4561928 4.771667e-05 -0.4561928 4.772667e-05 -0.4560812 4.845000e-05 -0.4560812 4.846000e-05 -0.4559696 4.918333e-05 -0.4559696 4.919333e-05 -0.4558580 4.991667e-05 -0.4558580
+ 4.992667e-05 -0.4557464 5.065000e-05 -0.4557464 5.066000e-05 -0.4556348 5.138333e-05 -0.4556348 5.139333e-05 -0.4555232 5.211667e-05 -0.4555232 5.212667e-05 -0.4554116 5.285000e-05 -0.4554116
+ 5.286000e-05 -0.4553000 5.358333e-05 -0.4553000 5.359333e-05 -0.4551884 5.431667e-05 -0.4551884 5.432667e-05 -0.4550768 5.505000e-05 -0.4550768 5.506000e-05 -0.4549652 5.578333e-05 -0.4549652
+ 5.579333e-05 -0.4548536 5.651667e-05 -0.4548536 5.652667e-05 -0.4547420 5.725000e-05 -0.4547420 5.726000e-05 -0.4546304 5.798333e-05 -0.4546304 5.799333e-05 -0.4545188 5.871667e-05 -0.4545188
+ 5.872667e-05 -0.4544072 5.945000e-05 -0.4544072 5.946000e-05 -0.4542956 6.018333e-05 -0.4542956 6.019333e-05 -0.4541840 6.091667e-05 -0.4541840 6.092667e-05 -0.4540724 6.165000e-05 -0.4540724
+ 6.166000e-05 -0.4539608 6.238333e-05 -0.4539608 6.239333e-05 -0.4538492 6.311667e-05 -0.4538492 6.312667e-05 -0.4537376)
Vdb vdb 0 PWL(0 -0.0057066 7.833333e-07 -0.0057066 7.933333e-07 -0.0055950 1.516667e-06 -0.0055950 1.526667e-06 -0.0054834 2.250000e-06 -0.0054834 2.260000e-06 -0.0053718 2.983333e-06 -0.0053718
+ 2.993333e-06 -0.0052602 3.716667e-06 -0.0052602 3.726667e-06 -0.0051486 4.450000e-06 -0.0051486 4.460000e-06 -0.0050370 5.183333e-06 -0.0050370 5.193333e-06 -0.0049254 5.916667e-06 -0.0049254
+ 5.926667e-06 -0.0048138 6.650000e-06 -0.0048138 6.660000e-06 -0.0047022 7.383333e-06 -0.0047022 7.393333e-06 -0.0045906 8.116667e-06 -0.0045906 8.126667e-06 -0.0044790 8.850000e-06 -0.0044790
+ 8.860000e-06 -0.0043674 9.583333e-06 -0.0043674 9.593333e-06 -0.0042558 1.031667e-05 -0.0042558 1.032667e-05 -0.0041442 1.105000e-05 -0.0041442 1.106000e-05 -0.0040326 1.178333e-05 -0.0040326
+ 1.179333e-05 -0.0039210 1.251667e-05 -0.0039210 1.252667e-05 -0.0038094 1.325000e-05 -0.0038094 1.326000e-05 -0.0036978 1.398333e-05 -0.0036978 1.399333e-05 -0.0035862 1.471667e-05 -0.0035862
+ 1.472667e-05 -0.0034746 1.545000e-05 -0.0034746 1.546000e-05 -0.0033630 1.618333e-05 -0.0033630 1.619333e-05 -0.0032514 1.691667e-05 -0.0032514 1.692667e-05 -0.0031398 1.765000e-05 -0.0031398
+ 1.766000e-05 -0.0030282 1.838333e-05 -0.0030282 1.839333e-05 -0.0029166 1.911667e-05 -0.0029166 1.912667e-05 -0.0028050 1.985000e-05 -0.0028050 1.986000e-05 -0.0026934 2.058333e-05 -0.0026934
+ 2.059333e-05 -0.0025818 2.131667e-05 -0.0025818 2.132667e-05 0.4537934 2.205000e-05 0.4537934 2.206000e-05 0.4539050 2.278333e-05 0.4539050 2.279333e-05 0.4540166 2.351667e-05 0.4540166
+ 2.352667e-05 0.4541282 2.425000e-05 0.4541282 2.426000e-05 0.4542398 2.498333e-05 0.4542398 2.499333e-05 0.4543514 2.571667e-05 0.4543514 2.572667e-05 0.4544630 2.645000e-05 0.4544630
+ 2.646000e-05 0.4545746 2.718333e-05 0.4545746 2.719333e-05 0.4546862 2.791667e-05 0.4546862 2.792667e-05 0.4547978 2.865000e-05 0.4547978 2.866000e-05 0.4549094 2.938333e-05 0.4549094
+ 2.939333e-05 0.4550210 3.011667e-05 0.4550210 3.012667e-05 0.4551326 3.085000e-05 0.4551326 3.086000e-05 0.4552442 3.158333e-05 0.4552442 3.159333e-05 0.4553558 3.231667e-05 0.4553558
+ 3.232667e-05 0.4554674 3.305000e-05 0.4554674 3.306000e-05 0.4555790 3.378333e-05 0.4555790 3.379333e-05 0.4556906 3.451667e-05 0.4556906 3.452667e-05 0.4558022 3.525000e-05 0.4558022
+ 3.526000e-05 0.4559138 3.598333e-05 0.4559138 3.599333e-05 0.4560254 3.671667e-05 0.4560254 3.672667e-05 0.4561370 3.745000e-05 0.4561370 3.746000e-05 0.4562486 3.818333e-05 0.4562486
+ 3.819333e-05 0.4563602 3.891667e-05 0.4563602 3.892667e-05 0.4564718 3.965000e-05 0.4564718 3.966000e-05 0.4565834 4.038333e-05 0.4565834 4.039333e-05 0.4566950 4.111667e-05 0.4566950
+ 4.112667e-05 0.4568066 4.185000e-05 0.4568066 4.186000e-05 0.4569182 4.258333e-05 0.4569182 4.259333e-05 -0.4568066 4.331667e-05 -0.4568066 4.332667e-05 -0.4566950 4.405000e-05 -0.4566950
+ 4.406000e-05 -0.4565834 4.478333e-05 -0.4565834 4.479333e-05 -0.4564718 4.551667e-05 -0.4564718 4.552667e-05 -0.4563602 4.625000e-05 -0.4563602 4.626000e-05 -0.4562486 4.698333e-05 -0.4562486
+ 4.699333e-05 -0.4561370 4.771667e-05 -0.4561370 4.772667e-05 -0.4560254 4.845000e-05 -0.4560254 4.846000e-05 -0.4559138 4.918333e-05 -0.4559138 4.919333e-05 -0.4558022 4.991667e-05 -0.4558022
+ 4.992667e-05 -0.4556906 5.065000e-05 -0.4556906 5.066000e-05 -0.4555790 5.138333e-05 -0.4555790 5.139333e-05 -0.4554674 5.211667e-05 -0.4554674 5.212667e-05 -0.4553558 5.285000e-05 -0.4553558
+ 5.286000e-05 -0.4552442 5.358333e-05 -0.4552442 5.359333e-05 -0.4551326 5.431667e-05 -0.4551326 5.432667e-05 -0.4550210 5.505000e-05 -0.4550210 5.506000e-05 -0.4549094 5.578333e-05 -0.4549094
+ 5.579333e-05 -0.4547978 5.651667e-05 -0.4547978 5.652667e-05 -0.4546862 5.725000e-05 -0.4546862 5.726000e-05 -0.4545746 5.798333e-05 -0.4545746 5.799333e-05 -0.4544630 5.871667e-05 -0.4544630
+ 5.872667e-05 -0.4543514 5.945000e-05 -0.4543514 5.946000e-05 -0.4542398 6.018333e-05 -0.4542398 6.019333e-05 -0.4541282 6.091667e-05 -0.4541282 6.092667e-05 -0.4540166 6.165000e-05 -0.4540166
+ 6.166000e-05 -0.4539050 6.238333e-05 -0.4539050 6.239333e-05 -0.4537934 6.311667e-05 -0.4537934 6.312667e-05 -0.4536818)
Esp sinp vcm vda 0 0.5
Esn sinn vcm vda 0 -0.5
Ecp cosp vcm vdb 0 0.5
Ecn cosn vcm vdb 0 -0.5
Vip isap 0 0.6
Vin isan 0 0.6

XM0 sinp sinn cosp cosn isap isan isap isan trka0 trka1 trkb0 trkb1 clk30 wina winb lata latb
+ stba0 stba1 stba2 stba3 stba4 stba5 stba6 stba7 stba8 stba9 stba10 stba11 stba12 stba13
+ stbb0 stbb1 stbb2 stbb3 stbb4 stbb5 stbb6 stbb7 stbb8 stbb9 stbb10 stbb11 stbb12 stbb13
+ m0rawa m0rawb m0tpa m0tna m0tpb m0tnb vdd vref vrefl 0 r1_adc4_core_fast_mc
XM1 sinp sinn cosp cosn isap isan isap isan trka0 trka1 trkb0 trkb1 clk30 wina winb lata latb
+ stba0 stba1 stba2 stba3 stba4 stba5 stba6 stba7 stba8 stba9 stba10 stba11 stba12 stba13
+ stbb0 stbb1 stbb2 stbb3 stbb4 stbb5 stbb6 stbb7 stbb8 stbb9 stbb10 stbb11 stbb12 stbb13
+ m1rawa m1rawb m1tpa m1tna m1tpb m1tnb vdd vref vrefl 0 r1_adc4_core_fast_mc

.control
set num_threads=1
op
print v(vref) v(m0tpa) v(m1tpb)
.endc
.end
