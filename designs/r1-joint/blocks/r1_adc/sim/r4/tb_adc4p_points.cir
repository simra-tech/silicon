* tb_adc4p_points.cir -- tb_adc4_points.cir plus the MSB pre-switch library (r1_adc_r4p.spice). R1 ADC revision 4 (D18): both slices, one held differential input per frame and slice.
* Frame s: slice A samples vda (SIN path) at tsA = 0.6 us + s * 22 T, slice B samples vdb (COS path) at tsA + N T.
* vda/vdb are PWL sources written by sim/r4/run_points4.py (value of frame s applied 550 ns before its edge).
* Inputs are linear E sources around the common mode CM (R2-7: no B sources on the input path).
* Reference: REFLINES (ideal sources, or r1_refbuf4 from an ideal 1.045 V bandgap node; vrefl = LSB-array reference).
* Substitutions: CORNER TEMP VDD CM CORE TIMING OPTS TMAX TSTOP PWLA PWLB REFLINES SAVE RAW
.lib /foss/pdks/ihp-sg13g2/libs.tech/ngspice/models/cornerMOSlv.lib @CORNER@
.lib /foss/pdks/ihp-sg13g2/libs.tech/ngspice/models/cornerCAP.lib @CAPLIB@
.lib /foss/pdks/ihp-sg13g2/libs.tech/ngspice/models/cornerMOShv.lib @CORNER@
.lib /foss/pdks/ihp-sg13g2/libs.tech/ngspice/models/cornerRES.lib res_typ
.include schematic/r1_adc_r4.spice
.include schematic/r1_adc_r4p.spice
.include sim/r4/@TIMING@
.temp @TEMP@
.option @OPTS@

Vdd vdd 0 @VDD@
@REFLINES@
Vcm vcm 0 @CM@
Vda vda 0 PWL(@PWLA@)
Vdb vdb 0 PWL(@PWLB@)
Esp sinp vcm vda 0 0.5
Esn sinn vcm vda 0 -0.5
Ecp cosp vcm vdb 0 0.5
Ecn cosn vcm vdb 0 -0.5
Vip isap 0 0.6
Vin isan 0 0.6

@INSTANCES@

.control
set num_threads=1
save @SAVE@
tran 1n @TSTOP@ 0 @TMAX@
meas tran idd avg i(vdd) from=0.7u to=@TSTOP@
write @RAW@/codes.raw
.endc
.end
