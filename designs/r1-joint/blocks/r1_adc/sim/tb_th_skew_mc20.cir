* tb_th_skew_mc20.cir (generated by gen_tb_th_skew.py) -- T/H sampling skew, 20 copies
.lib /foss/pdks/ihp-sg13g2/libs.tech/ngspice/models/cornerMOSlv.lib mos_tt_mismatch
.lib /foss/pdks/ihp-sg13g2/libs.tech/ngspice/models/cornerCAP.lib cap_typ
.param mmos=1
.include schematic/r1_adc_mm.spice
.temp 27
.option reltol=1e-4 vntol=1e-7 abstol=1e-13 method=trap
Vdd vdd 0 1.2
Vref vref 0 1.2
* common track signal: hold 0-30 ns (boost capacitors charge), track 30 ns - t_edge (170 ns, as in the
* ADC frame), 50 ps fall at t_edge; distributed from one r1_ctrl output
Vtrk trk 0 PWL(0 0 30n 0 30.05n 1.2 1.99975e-07 1.2 2.00025e-07 0)
Vz z 0 0
Vcm cm 0 0.6
* copy 0: V0 = 0 V, S = 2e+07 V/s
Bx0 x0 0 v=min(max(0+2e+07*max(time-2e-07,-20n),-1.15),1.15)
Bp0 ip0 0 v=0.6+v(x0)/2
Bn0 in0 0 v=0.6-v(x0)/2
XTHa0 ip0 in0 cm cm trk z tap0 tan0 z z z z z z z z z z z z z z z z z z z z z z vdd vref 0 r1_th
Ccap0 tap0 0 30f
Ccan0 tan0 0 30f
XTHb0 ip0 in0 cm cm trk z tbp0 tbn0 z z z z z z z z z z z z z z z z z z z z z z vdd vref 0 r1_th
Ccbp0 tbp0 0 30f
Ccbn0 tbn0 0 30f
* copy 1: V0 = 0.7 V, S = 2e+07 V/s
Bx1 x1 0 v=min(max(0.7+2e+07*max(time-2e-07,-20n),-1.15),1.15)
Bp1 ip1 0 v=0.6+v(x1)/2
Bn1 in1 0 v=0.6-v(x1)/2
XTHa1 ip1 in1 cm cm trk z tap1 tan1 z z z z z z z z z z z z z z z z z z z z z z vdd vref 0 r1_th
Ccap1 tap1 0 30f
Ccan1 tan1 0 30f
XTHb1 ip1 in1 cm cm trk z tbp1 tbn1 z z z z z z z z z z z z z z z z z z z z z z vdd vref 0 r1_th
Ccbp1 tbp1 0 30f
Ccbn1 tbn1 0 30f
* copy 2: V0 = 0 V, S = 2e+07 V/s
Bx2 x2 0 v=min(max(0+2e+07*max(time-2e-07,-20n),-1.15),1.15)
Bp2 ip2 0 v=0.6+v(x2)/2
Bn2 in2 0 v=0.6-v(x2)/2
XTHa2 ip2 in2 cm cm trk z tap2 tan2 z z z z z z z z z z z z z z z z z z z z z z vdd vref 0 r1_th
Ccap2 tap2 0 30f
Ccan2 tan2 0 30f
XTHb2 ip2 in2 cm cm trk z tbp2 tbn2 z z z z z z z z z z z z z z z z z z z z z z vdd vref 0 r1_th
Ccbp2 tbp2 0 30f
Ccbn2 tbn2 0 30f
* copy 3: V0 = 0.7 V, S = 2e+07 V/s
Bx3 x3 0 v=min(max(0.7+2e+07*max(time-2e-07,-20n),-1.15),1.15)
Bp3 ip3 0 v=0.6+v(x3)/2
Bn3 in3 0 v=0.6-v(x3)/2
XTHa3 ip3 in3 cm cm trk z tap3 tan3 z z z z z z z z z z z z z z z z z z z z z z vdd vref 0 r1_th
Ccap3 tap3 0 30f
Ccan3 tan3 0 30f
XTHb3 ip3 in3 cm cm trk z tbp3 tbn3 z z z z z z z z z z z z z z z z z z z z z z vdd vref 0 r1_th
Ccbp3 tbp3 0 30f
Ccbn3 tbn3 0 30f
* copy 4: V0 = 0 V, S = 2e+07 V/s
Bx4 x4 0 v=min(max(0+2e+07*max(time-2e-07,-20n),-1.15),1.15)
Bp4 ip4 0 v=0.6+v(x4)/2
Bn4 in4 0 v=0.6-v(x4)/2
XTHa4 ip4 in4 cm cm trk z tap4 tan4 z z z z z z z z z z z z z z z z z z z z z z vdd vref 0 r1_th
Ccap4 tap4 0 30f
Ccan4 tan4 0 30f
XTHb4 ip4 in4 cm cm trk z tbp4 tbn4 z z z z z z z z z z z z z z z z z z z z z z vdd vref 0 r1_th
Ccbp4 tbp4 0 30f
Ccbn4 tbn4 0 30f
* copy 5: V0 = 0.7 V, S = 2e+07 V/s
Bx5 x5 0 v=min(max(0.7+2e+07*max(time-2e-07,-20n),-1.15),1.15)
Bp5 ip5 0 v=0.6+v(x5)/2
Bn5 in5 0 v=0.6-v(x5)/2
XTHa5 ip5 in5 cm cm trk z tap5 tan5 z z z z z z z z z z z z z z z z z z z z z z vdd vref 0 r1_th
Ccap5 tap5 0 30f
Ccan5 tan5 0 30f
XTHb5 ip5 in5 cm cm trk z tbp5 tbn5 z z z z z z z z z z z z z z z z z z z z z z vdd vref 0 r1_th
Ccbp5 tbp5 0 30f
Ccbn5 tbn5 0 30f
* copy 6: V0 = 0 V, S = 2e+07 V/s
Bx6 x6 0 v=min(max(0+2e+07*max(time-2e-07,-20n),-1.15),1.15)
Bp6 ip6 0 v=0.6+v(x6)/2
Bn6 in6 0 v=0.6-v(x6)/2
XTHa6 ip6 in6 cm cm trk z tap6 tan6 z z z z z z z z z z z z z z z z z z z z z z vdd vref 0 r1_th
Ccap6 tap6 0 30f
Ccan6 tan6 0 30f
XTHb6 ip6 in6 cm cm trk z tbp6 tbn6 z z z z z z z z z z z z z z z z z z z z z z vdd vref 0 r1_th
Ccbp6 tbp6 0 30f
Ccbn6 tbn6 0 30f
* copy 7: V0 = 0.7 V, S = 2e+07 V/s
Bx7 x7 0 v=min(max(0.7+2e+07*max(time-2e-07,-20n),-1.15),1.15)
Bp7 ip7 0 v=0.6+v(x7)/2
Bn7 in7 0 v=0.6-v(x7)/2
XTHa7 ip7 in7 cm cm trk z tap7 tan7 z z z z z z z z z z z z z z z z z z z z z z vdd vref 0 r1_th
Ccap7 tap7 0 30f
Ccan7 tan7 0 30f
XTHb7 ip7 in7 cm cm trk z tbp7 tbn7 z z z z z z z z z z z z z z z z z z z z z z vdd vref 0 r1_th
Ccbp7 tbp7 0 30f
Ccbn7 tbn7 0 30f
* copy 8: V0 = 0 V, S = 2e+07 V/s
Bx8 x8 0 v=min(max(0+2e+07*max(time-2e-07,-20n),-1.15),1.15)
Bp8 ip8 0 v=0.6+v(x8)/2
Bn8 in8 0 v=0.6-v(x8)/2
XTHa8 ip8 in8 cm cm trk z tap8 tan8 z z z z z z z z z z z z z z z z z z z z z z vdd vref 0 r1_th
Ccap8 tap8 0 30f
Ccan8 tan8 0 30f
XTHb8 ip8 in8 cm cm trk z tbp8 tbn8 z z z z z z z z z z z z z z z z z z z z z z vdd vref 0 r1_th
Ccbp8 tbp8 0 30f
Ccbn8 tbn8 0 30f
* copy 9: V0 = 0.7 V, S = 2e+07 V/s
Bx9 x9 0 v=min(max(0.7+2e+07*max(time-2e-07,-20n),-1.15),1.15)
Bp9 ip9 0 v=0.6+v(x9)/2
Bn9 in9 0 v=0.6-v(x9)/2
XTHa9 ip9 in9 cm cm trk z tap9 tan9 z z z z z z z z z z z z z z z z z z z z z z vdd vref 0 r1_th
Ccap9 tap9 0 30f
Ccan9 tan9 0 30f
XTHb9 ip9 in9 cm cm trk z tbp9 tbn9 z z z z z z z z z z z z z z z z z z z z z z vdd vref 0 r1_th
Ccbp9 tbp9 0 30f
Ccbn9 tbn9 0 30f
* copy 10: V0 = 0 V, S = 2e+07 V/s
Bx10 x10 0 v=min(max(0+2e+07*max(time-2e-07,-20n),-1.15),1.15)
Bp10 ip10 0 v=0.6+v(x10)/2
Bn10 in10 0 v=0.6-v(x10)/2
XTHa10 ip10 in10 cm cm trk z tap10 tan10 z z z z z z z z z z z z z z z z z z z z z z vdd vref 0 r1_th
Ccap10 tap10 0 30f
Ccan10 tan10 0 30f
XTHb10 ip10 in10 cm cm trk z tbp10 tbn10 z z z z z z z z z z z z z z z z z z z z z z vdd vref 0 r1_th
Ccbp10 tbp10 0 30f
Ccbn10 tbn10 0 30f
* copy 11: V0 = 0.7 V, S = 2e+07 V/s
Bx11 x11 0 v=min(max(0.7+2e+07*max(time-2e-07,-20n),-1.15),1.15)
Bp11 ip11 0 v=0.6+v(x11)/2
Bn11 in11 0 v=0.6-v(x11)/2
XTHa11 ip11 in11 cm cm trk z tap11 tan11 z z z z z z z z z z z z z z z z z z z z z z vdd vref 0 r1_th
Ccap11 tap11 0 30f
Ccan11 tan11 0 30f
XTHb11 ip11 in11 cm cm trk z tbp11 tbn11 z z z z z z z z z z z z z z z z z z z z z z vdd vref 0 r1_th
Ccbp11 tbp11 0 30f
Ccbn11 tbn11 0 30f
* copy 12: V0 = 0 V, S = 2e+07 V/s
Bx12 x12 0 v=min(max(0+2e+07*max(time-2e-07,-20n),-1.15),1.15)
Bp12 ip12 0 v=0.6+v(x12)/2
Bn12 in12 0 v=0.6-v(x12)/2
XTHa12 ip12 in12 cm cm trk z tap12 tan12 z z z z z z z z z z z z z z z z z z z z z z vdd vref 0 r1_th
Ccap12 tap12 0 30f
Ccan12 tan12 0 30f
XTHb12 ip12 in12 cm cm trk z tbp12 tbn12 z z z z z z z z z z z z z z z z z z z z z z vdd vref 0 r1_th
Ccbp12 tbp12 0 30f
Ccbn12 tbn12 0 30f
* copy 13: V0 = 0.7 V, S = 2e+07 V/s
Bx13 x13 0 v=min(max(0.7+2e+07*max(time-2e-07,-20n),-1.15),1.15)
Bp13 ip13 0 v=0.6+v(x13)/2
Bn13 in13 0 v=0.6-v(x13)/2
XTHa13 ip13 in13 cm cm trk z tap13 tan13 z z z z z z z z z z z z z z z z z z z z z z vdd vref 0 r1_th
Ccap13 tap13 0 30f
Ccan13 tan13 0 30f
XTHb13 ip13 in13 cm cm trk z tbp13 tbn13 z z z z z z z z z z z z z z z z z z z z z z vdd vref 0 r1_th
Ccbp13 tbp13 0 30f
Ccbn13 tbn13 0 30f
* copy 14: V0 = 0 V, S = 2e+07 V/s
Bx14 x14 0 v=min(max(0+2e+07*max(time-2e-07,-20n),-1.15),1.15)
Bp14 ip14 0 v=0.6+v(x14)/2
Bn14 in14 0 v=0.6-v(x14)/2
XTHa14 ip14 in14 cm cm trk z tap14 tan14 z z z z z z z z z z z z z z z z z z z z z z vdd vref 0 r1_th
Ccap14 tap14 0 30f
Ccan14 tan14 0 30f
XTHb14 ip14 in14 cm cm trk z tbp14 tbn14 z z z z z z z z z z z z z z z z z z z z z z vdd vref 0 r1_th
Ccbp14 tbp14 0 30f
Ccbn14 tbn14 0 30f
* copy 15: V0 = 0.7 V, S = 2e+07 V/s
Bx15 x15 0 v=min(max(0.7+2e+07*max(time-2e-07,-20n),-1.15),1.15)
Bp15 ip15 0 v=0.6+v(x15)/2
Bn15 in15 0 v=0.6-v(x15)/2
XTHa15 ip15 in15 cm cm trk z tap15 tan15 z z z z z z z z z z z z z z z z z z z z z z vdd vref 0 r1_th
Ccap15 tap15 0 30f
Ccan15 tan15 0 30f
XTHb15 ip15 in15 cm cm trk z tbp15 tbn15 z z z z z z z z z z z z z z z z z z z z z z vdd vref 0 r1_th
Ccbp15 tbp15 0 30f
Ccbn15 tbn15 0 30f
* copy 16: V0 = 0 V, S = 2e+07 V/s
Bx16 x16 0 v=min(max(0+2e+07*max(time-2e-07,-20n),-1.15),1.15)
Bp16 ip16 0 v=0.6+v(x16)/2
Bn16 in16 0 v=0.6-v(x16)/2
XTHa16 ip16 in16 cm cm trk z tap16 tan16 z z z z z z z z z z z z z z z z z z z z z z vdd vref 0 r1_th
Ccap16 tap16 0 30f
Ccan16 tan16 0 30f
XTHb16 ip16 in16 cm cm trk z tbp16 tbn16 z z z z z z z z z z z z z z z z z z z z z z vdd vref 0 r1_th
Ccbp16 tbp16 0 30f
Ccbn16 tbn16 0 30f
* copy 17: V0 = 0.7 V, S = 2e+07 V/s
Bx17 x17 0 v=min(max(0.7+2e+07*max(time-2e-07,-20n),-1.15),1.15)
Bp17 ip17 0 v=0.6+v(x17)/2
Bn17 in17 0 v=0.6-v(x17)/2
XTHa17 ip17 in17 cm cm trk z tap17 tan17 z z z z z z z z z z z z z z z z z z z z z z vdd vref 0 r1_th
Ccap17 tap17 0 30f
Ccan17 tan17 0 30f
XTHb17 ip17 in17 cm cm trk z tbp17 tbn17 z z z z z z z z z z z z z z z z z z z z z z vdd vref 0 r1_th
Ccbp17 tbp17 0 30f
Ccbn17 tbn17 0 30f
* copy 18: V0 = 0 V, S = 2e+07 V/s
Bx18 x18 0 v=min(max(0+2e+07*max(time-2e-07,-20n),-1.15),1.15)
Bp18 ip18 0 v=0.6+v(x18)/2
Bn18 in18 0 v=0.6-v(x18)/2
XTHa18 ip18 in18 cm cm trk z tap18 tan18 z z z z z z z z z z z z z z z z z z z z z z vdd vref 0 r1_th
Ccap18 tap18 0 30f
Ccan18 tan18 0 30f
XTHb18 ip18 in18 cm cm trk z tbp18 tbn18 z z z z z z z z z z z z z z z z z z z z z z vdd vref 0 r1_th
Ccbp18 tbp18 0 30f
Ccbn18 tbn18 0 30f
* copy 19: V0 = 0.7 V, S = 2e+07 V/s
Bx19 x19 0 v=min(max(0.7+2e+07*max(time-2e-07,-20n),-1.15),1.15)
Bp19 ip19 0 v=0.6+v(x19)/2
Bn19 in19 0 v=0.6-v(x19)/2
XTHa19 ip19 in19 cm cm trk z tap19 tan19 z z z z z z z z z z z z z z z z z z z z z z vdd vref 0 r1_th
Ccap19 tap19 0 30f
Ccan19 tan19 0 30f
XTHb19 ip19 in19 cm cm trk z tbp19 tbn19 z z z z z z z z z z z z z z z z z z z z z z vdd vref 0 r1_th
Ccbp19 tbp19 0 30f
Ccbn19 tbn19 0 30f
* 30 fF per top node: comparator input load (r1_cmp input pair gate, estimated)
.control
set num_threads=1
tran 10p 2.12e-07 0 20p
let va0 = v(tap0) - v(tan0)
meas tran ha0 find va0 at=2.1e-07
meas tran da0 find va0 at=2.105e-07
let vb0 = v(tbp0) - v(tbn0)
meas tran hb0 find vb0 at=2.1e-07
meas tran db0 find vb0 at=2.105e-07
let va1 = v(tap1) - v(tan1)
meas tran ha1 find va1 at=2.1e-07
meas tran da1 find va1 at=2.105e-07
let vb1 = v(tbp1) - v(tbn1)
meas tran hb1 find vb1 at=2.1e-07
meas tran db1 find vb1 at=2.105e-07
let va2 = v(tap2) - v(tan2)
meas tran ha2 find va2 at=2.1e-07
meas tran da2 find va2 at=2.105e-07
let vb2 = v(tbp2) - v(tbn2)
meas tran hb2 find vb2 at=2.1e-07
meas tran db2 find vb2 at=2.105e-07
let va3 = v(tap3) - v(tan3)
meas tran ha3 find va3 at=2.1e-07
meas tran da3 find va3 at=2.105e-07
let vb3 = v(tbp3) - v(tbn3)
meas tran hb3 find vb3 at=2.1e-07
meas tran db3 find vb3 at=2.105e-07
let va4 = v(tap4) - v(tan4)
meas tran ha4 find va4 at=2.1e-07
meas tran da4 find va4 at=2.105e-07
let vb4 = v(tbp4) - v(tbn4)
meas tran hb4 find vb4 at=2.1e-07
meas tran db4 find vb4 at=2.105e-07
let va5 = v(tap5) - v(tan5)
meas tran ha5 find va5 at=2.1e-07
meas tran da5 find va5 at=2.105e-07
let vb5 = v(tbp5) - v(tbn5)
meas tran hb5 find vb5 at=2.1e-07
meas tran db5 find vb5 at=2.105e-07
let va6 = v(tap6) - v(tan6)
meas tran ha6 find va6 at=2.1e-07
meas tran da6 find va6 at=2.105e-07
let vb6 = v(tbp6) - v(tbn6)
meas tran hb6 find vb6 at=2.1e-07
meas tran db6 find vb6 at=2.105e-07
let va7 = v(tap7) - v(tan7)
meas tran ha7 find va7 at=2.1e-07
meas tran da7 find va7 at=2.105e-07
let vb7 = v(tbp7) - v(tbn7)
meas tran hb7 find vb7 at=2.1e-07
meas tran db7 find vb7 at=2.105e-07
let va8 = v(tap8) - v(tan8)
meas tran ha8 find va8 at=2.1e-07
meas tran da8 find va8 at=2.105e-07
let vb8 = v(tbp8) - v(tbn8)
meas tran hb8 find vb8 at=2.1e-07
meas tran db8 find vb8 at=2.105e-07
let va9 = v(tap9) - v(tan9)
meas tran ha9 find va9 at=2.1e-07
meas tran da9 find va9 at=2.105e-07
let vb9 = v(tbp9) - v(tbn9)
meas tran hb9 find vb9 at=2.1e-07
meas tran db9 find vb9 at=2.105e-07
let va10 = v(tap10) - v(tan10)
meas tran ha10 find va10 at=2.1e-07
meas tran da10 find va10 at=2.105e-07
let vb10 = v(tbp10) - v(tbn10)
meas tran hb10 find vb10 at=2.1e-07
meas tran db10 find vb10 at=2.105e-07
let va11 = v(tap11) - v(tan11)
meas tran ha11 find va11 at=2.1e-07
meas tran da11 find va11 at=2.105e-07
let vb11 = v(tbp11) - v(tbn11)
meas tran hb11 find vb11 at=2.1e-07
meas tran db11 find vb11 at=2.105e-07
let va12 = v(tap12) - v(tan12)
meas tran ha12 find va12 at=2.1e-07
meas tran da12 find va12 at=2.105e-07
let vb12 = v(tbp12) - v(tbn12)
meas tran hb12 find vb12 at=2.1e-07
meas tran db12 find vb12 at=2.105e-07
let va13 = v(tap13) - v(tan13)
meas tran ha13 find va13 at=2.1e-07
meas tran da13 find va13 at=2.105e-07
let vb13 = v(tbp13) - v(tbn13)
meas tran hb13 find vb13 at=2.1e-07
meas tran db13 find vb13 at=2.105e-07
let va14 = v(tap14) - v(tan14)
meas tran ha14 find va14 at=2.1e-07
meas tran da14 find va14 at=2.105e-07
let vb14 = v(tbp14) - v(tbn14)
meas tran hb14 find vb14 at=2.1e-07
meas tran db14 find vb14 at=2.105e-07
let va15 = v(tap15) - v(tan15)
meas tran ha15 find va15 at=2.1e-07
meas tran da15 find va15 at=2.105e-07
let vb15 = v(tbp15) - v(tbn15)
meas tran hb15 find vb15 at=2.1e-07
meas tran db15 find vb15 at=2.105e-07
let va16 = v(tap16) - v(tan16)
meas tran ha16 find va16 at=2.1e-07
meas tran da16 find va16 at=2.105e-07
let vb16 = v(tbp16) - v(tbn16)
meas tran hb16 find vb16 at=2.1e-07
meas tran db16 find vb16 at=2.105e-07
let va17 = v(tap17) - v(tan17)
meas tran ha17 find va17 at=2.1e-07
meas tran da17 find va17 at=2.105e-07
let vb17 = v(tbp17) - v(tbn17)
meas tran hb17 find vb17 at=2.1e-07
meas tran db17 find vb17 at=2.105e-07
let va18 = v(tap18) - v(tan18)
meas tran ha18 find va18 at=2.1e-07
meas tran da18 find va18 at=2.105e-07
let vb18 = v(tbp18) - v(tbn18)
meas tran hb18 find vb18 at=2.1e-07
meas tran db18 find vb18 at=2.105e-07
let va19 = v(tap19) - v(tan19)
meas tran ha19 find va19 at=2.1e-07
meas tran da19 find va19 at=2.105e-07
let vb19 = v(tbp19) - v(tbn19)
meas tran hb19 find vb19 at=2.1e-07
meas tran db19 find vb19 at=2.105e-07
write @RAW@/tb.raw
.endc
.end
