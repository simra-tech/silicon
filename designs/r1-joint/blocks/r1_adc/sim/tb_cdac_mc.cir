* tb_cdac_mc.cir (generated by gen_tb_cdac_mc.py) -- CDAC mismatch MC, 50 samples x 2 sides
.lib /foss/pdks/ihp-sg13g2/libs.tech/ngspice/models/cornerCAP.lib cap_typ_mismatch
.include schematic/r1_adc.spice
Vb10 b10 0 DC 0 AC 0
Vb9 b9 0 DC 0 AC 0
Vb8 b8 0 DC 0 AC 0
Vb7 b7 0 DC 0 AC 0
Vb6 b6 0 DC 0 AC 0
Vb5 b5 0 DC 0 AC 0
Vb4 b4 0 DC 0 AC 0
Vb3 b3 0 DC 0 AC 0
Vb2 b2 0 DC 0 AC 0
Vb1 b1 0 DC 0 AC 0
Vb0 b0 0 DC 0 AC 0
Xp0 tp0 lp0 b10 b9 b8 b7 b6 b5 b4 b3 b2 b1 b0 r1_cdac_side_mc mm=1
Rpt0 tp0 0 1e15
Rpl0 lp0 0 1e15
Xn0 tn0 ln0 b10 b9 b8 b7 b6 b5 b4 b3 b2 b1 b0 r1_cdac_side_mc mm=1
Rnt0 tn0 0 1e15
Rnl0 ln0 0 1e15
Xp1 tp1 lp1 b10 b9 b8 b7 b6 b5 b4 b3 b2 b1 b0 r1_cdac_side_mc mm=1
Rpt1 tp1 0 1e15
Rpl1 lp1 0 1e15
Xn1 tn1 ln1 b10 b9 b8 b7 b6 b5 b4 b3 b2 b1 b0 r1_cdac_side_mc mm=1
Rnt1 tn1 0 1e15
Rnl1 ln1 0 1e15
Xp2 tp2 lp2 b10 b9 b8 b7 b6 b5 b4 b3 b2 b1 b0 r1_cdac_side_mc mm=1
Rpt2 tp2 0 1e15
Rpl2 lp2 0 1e15
Xn2 tn2 ln2 b10 b9 b8 b7 b6 b5 b4 b3 b2 b1 b0 r1_cdac_side_mc mm=1
Rnt2 tn2 0 1e15
Rnl2 ln2 0 1e15
Xp3 tp3 lp3 b10 b9 b8 b7 b6 b5 b4 b3 b2 b1 b0 r1_cdac_side_mc mm=1
Rpt3 tp3 0 1e15
Rpl3 lp3 0 1e15
Xn3 tn3 ln3 b10 b9 b8 b7 b6 b5 b4 b3 b2 b1 b0 r1_cdac_side_mc mm=1
Rnt3 tn3 0 1e15
Rnl3 ln3 0 1e15
Xp4 tp4 lp4 b10 b9 b8 b7 b6 b5 b4 b3 b2 b1 b0 r1_cdac_side_mc mm=1
Rpt4 tp4 0 1e15
Rpl4 lp4 0 1e15
Xn4 tn4 ln4 b10 b9 b8 b7 b6 b5 b4 b3 b2 b1 b0 r1_cdac_side_mc mm=1
Rnt4 tn4 0 1e15
Rnl4 ln4 0 1e15
Xp5 tp5 lp5 b10 b9 b8 b7 b6 b5 b4 b3 b2 b1 b0 r1_cdac_side_mc mm=1
Rpt5 tp5 0 1e15
Rpl5 lp5 0 1e15
Xn5 tn5 ln5 b10 b9 b8 b7 b6 b5 b4 b3 b2 b1 b0 r1_cdac_side_mc mm=1
Rnt5 tn5 0 1e15
Rnl5 ln5 0 1e15
Xp6 tp6 lp6 b10 b9 b8 b7 b6 b5 b4 b3 b2 b1 b0 r1_cdac_side_mc mm=1
Rpt6 tp6 0 1e15
Rpl6 lp6 0 1e15
Xn6 tn6 ln6 b10 b9 b8 b7 b6 b5 b4 b3 b2 b1 b0 r1_cdac_side_mc mm=1
Rnt6 tn6 0 1e15
Rnl6 ln6 0 1e15
Xp7 tp7 lp7 b10 b9 b8 b7 b6 b5 b4 b3 b2 b1 b0 r1_cdac_side_mc mm=1
Rpt7 tp7 0 1e15
Rpl7 lp7 0 1e15
Xn7 tn7 ln7 b10 b9 b8 b7 b6 b5 b4 b3 b2 b1 b0 r1_cdac_side_mc mm=1
Rnt7 tn7 0 1e15
Rnl7 ln7 0 1e15
Xp8 tp8 lp8 b10 b9 b8 b7 b6 b5 b4 b3 b2 b1 b0 r1_cdac_side_mc mm=1
Rpt8 tp8 0 1e15
Rpl8 lp8 0 1e15
Xn8 tn8 ln8 b10 b9 b8 b7 b6 b5 b4 b3 b2 b1 b0 r1_cdac_side_mc mm=1
Rnt8 tn8 0 1e15
Rnl8 ln8 0 1e15
Xp9 tp9 lp9 b10 b9 b8 b7 b6 b5 b4 b3 b2 b1 b0 r1_cdac_side_mc mm=1
Rpt9 tp9 0 1e15
Rpl9 lp9 0 1e15
Xn9 tn9 ln9 b10 b9 b8 b7 b6 b5 b4 b3 b2 b1 b0 r1_cdac_side_mc mm=1
Rnt9 tn9 0 1e15
Rnl9 ln9 0 1e15
Xp10 tp10 lp10 b10 b9 b8 b7 b6 b5 b4 b3 b2 b1 b0 r1_cdac_side_mc mm=1
Rpt10 tp10 0 1e15
Rpl10 lp10 0 1e15
Xn10 tn10 ln10 b10 b9 b8 b7 b6 b5 b4 b3 b2 b1 b0 r1_cdac_side_mc mm=1
Rnt10 tn10 0 1e15
Rnl10 ln10 0 1e15
Xp11 tp11 lp11 b10 b9 b8 b7 b6 b5 b4 b3 b2 b1 b0 r1_cdac_side_mc mm=1
Rpt11 tp11 0 1e15
Rpl11 lp11 0 1e15
Xn11 tn11 ln11 b10 b9 b8 b7 b6 b5 b4 b3 b2 b1 b0 r1_cdac_side_mc mm=1
Rnt11 tn11 0 1e15
Rnl11 ln11 0 1e15
Xp12 tp12 lp12 b10 b9 b8 b7 b6 b5 b4 b3 b2 b1 b0 r1_cdac_side_mc mm=1
Rpt12 tp12 0 1e15
Rpl12 lp12 0 1e15
Xn12 tn12 ln12 b10 b9 b8 b7 b6 b5 b4 b3 b2 b1 b0 r1_cdac_side_mc mm=1
Rnt12 tn12 0 1e15
Rnl12 ln12 0 1e15
Xp13 tp13 lp13 b10 b9 b8 b7 b6 b5 b4 b3 b2 b1 b0 r1_cdac_side_mc mm=1
Rpt13 tp13 0 1e15
Rpl13 lp13 0 1e15
Xn13 tn13 ln13 b10 b9 b8 b7 b6 b5 b4 b3 b2 b1 b0 r1_cdac_side_mc mm=1
Rnt13 tn13 0 1e15
Rnl13 ln13 0 1e15
Xp14 tp14 lp14 b10 b9 b8 b7 b6 b5 b4 b3 b2 b1 b0 r1_cdac_side_mc mm=1
Rpt14 tp14 0 1e15
Rpl14 lp14 0 1e15
Xn14 tn14 ln14 b10 b9 b8 b7 b6 b5 b4 b3 b2 b1 b0 r1_cdac_side_mc mm=1
Rnt14 tn14 0 1e15
Rnl14 ln14 0 1e15
Xp15 tp15 lp15 b10 b9 b8 b7 b6 b5 b4 b3 b2 b1 b0 r1_cdac_side_mc mm=1
Rpt15 tp15 0 1e15
Rpl15 lp15 0 1e15
Xn15 tn15 ln15 b10 b9 b8 b7 b6 b5 b4 b3 b2 b1 b0 r1_cdac_side_mc mm=1
Rnt15 tn15 0 1e15
Rnl15 ln15 0 1e15
Xp16 tp16 lp16 b10 b9 b8 b7 b6 b5 b4 b3 b2 b1 b0 r1_cdac_side_mc mm=1
Rpt16 tp16 0 1e15
Rpl16 lp16 0 1e15
Xn16 tn16 ln16 b10 b9 b8 b7 b6 b5 b4 b3 b2 b1 b0 r1_cdac_side_mc mm=1
Rnt16 tn16 0 1e15
Rnl16 ln16 0 1e15
Xp17 tp17 lp17 b10 b9 b8 b7 b6 b5 b4 b3 b2 b1 b0 r1_cdac_side_mc mm=1
Rpt17 tp17 0 1e15
Rpl17 lp17 0 1e15
Xn17 tn17 ln17 b10 b9 b8 b7 b6 b5 b4 b3 b2 b1 b0 r1_cdac_side_mc mm=1
Rnt17 tn17 0 1e15
Rnl17 ln17 0 1e15
Xp18 tp18 lp18 b10 b9 b8 b7 b6 b5 b4 b3 b2 b1 b0 r1_cdac_side_mc mm=1
Rpt18 tp18 0 1e15
Rpl18 lp18 0 1e15
Xn18 tn18 ln18 b10 b9 b8 b7 b6 b5 b4 b3 b2 b1 b0 r1_cdac_side_mc mm=1
Rnt18 tn18 0 1e15
Rnl18 ln18 0 1e15
Xp19 tp19 lp19 b10 b9 b8 b7 b6 b5 b4 b3 b2 b1 b0 r1_cdac_side_mc mm=1
Rpt19 tp19 0 1e15
Rpl19 lp19 0 1e15
Xn19 tn19 ln19 b10 b9 b8 b7 b6 b5 b4 b3 b2 b1 b0 r1_cdac_side_mc mm=1
Rnt19 tn19 0 1e15
Rnl19 ln19 0 1e15
Xp20 tp20 lp20 b10 b9 b8 b7 b6 b5 b4 b3 b2 b1 b0 r1_cdac_side_mc mm=1
Rpt20 tp20 0 1e15
Rpl20 lp20 0 1e15
Xn20 tn20 ln20 b10 b9 b8 b7 b6 b5 b4 b3 b2 b1 b0 r1_cdac_side_mc mm=1
Rnt20 tn20 0 1e15
Rnl20 ln20 0 1e15
Xp21 tp21 lp21 b10 b9 b8 b7 b6 b5 b4 b3 b2 b1 b0 r1_cdac_side_mc mm=1
Rpt21 tp21 0 1e15
Rpl21 lp21 0 1e15
Xn21 tn21 ln21 b10 b9 b8 b7 b6 b5 b4 b3 b2 b1 b0 r1_cdac_side_mc mm=1
Rnt21 tn21 0 1e15
Rnl21 ln21 0 1e15
Xp22 tp22 lp22 b10 b9 b8 b7 b6 b5 b4 b3 b2 b1 b0 r1_cdac_side_mc mm=1
Rpt22 tp22 0 1e15
Rpl22 lp22 0 1e15
Xn22 tn22 ln22 b10 b9 b8 b7 b6 b5 b4 b3 b2 b1 b0 r1_cdac_side_mc mm=1
Rnt22 tn22 0 1e15
Rnl22 ln22 0 1e15
Xp23 tp23 lp23 b10 b9 b8 b7 b6 b5 b4 b3 b2 b1 b0 r1_cdac_side_mc mm=1
Rpt23 tp23 0 1e15
Rpl23 lp23 0 1e15
Xn23 tn23 ln23 b10 b9 b8 b7 b6 b5 b4 b3 b2 b1 b0 r1_cdac_side_mc mm=1
Rnt23 tn23 0 1e15
Rnl23 ln23 0 1e15
Xp24 tp24 lp24 b10 b9 b8 b7 b6 b5 b4 b3 b2 b1 b0 r1_cdac_side_mc mm=1
Rpt24 tp24 0 1e15
Rpl24 lp24 0 1e15
Xn24 tn24 ln24 b10 b9 b8 b7 b6 b5 b4 b3 b2 b1 b0 r1_cdac_side_mc mm=1
Rnt24 tn24 0 1e15
Rnl24 ln24 0 1e15
Xp25 tp25 lp25 b10 b9 b8 b7 b6 b5 b4 b3 b2 b1 b0 r1_cdac_side_mc mm=1
Rpt25 tp25 0 1e15
Rpl25 lp25 0 1e15
Xn25 tn25 ln25 b10 b9 b8 b7 b6 b5 b4 b3 b2 b1 b0 r1_cdac_side_mc mm=1
Rnt25 tn25 0 1e15
Rnl25 ln25 0 1e15
Xp26 tp26 lp26 b10 b9 b8 b7 b6 b5 b4 b3 b2 b1 b0 r1_cdac_side_mc mm=1
Rpt26 tp26 0 1e15
Rpl26 lp26 0 1e15
Xn26 tn26 ln26 b10 b9 b8 b7 b6 b5 b4 b3 b2 b1 b0 r1_cdac_side_mc mm=1
Rnt26 tn26 0 1e15
Rnl26 ln26 0 1e15
Xp27 tp27 lp27 b10 b9 b8 b7 b6 b5 b4 b3 b2 b1 b0 r1_cdac_side_mc mm=1
Rpt27 tp27 0 1e15
Rpl27 lp27 0 1e15
Xn27 tn27 ln27 b10 b9 b8 b7 b6 b5 b4 b3 b2 b1 b0 r1_cdac_side_mc mm=1
Rnt27 tn27 0 1e15
Rnl27 ln27 0 1e15
Xp28 tp28 lp28 b10 b9 b8 b7 b6 b5 b4 b3 b2 b1 b0 r1_cdac_side_mc mm=1
Rpt28 tp28 0 1e15
Rpl28 lp28 0 1e15
Xn28 tn28 ln28 b10 b9 b8 b7 b6 b5 b4 b3 b2 b1 b0 r1_cdac_side_mc mm=1
Rnt28 tn28 0 1e15
Rnl28 ln28 0 1e15
Xp29 tp29 lp29 b10 b9 b8 b7 b6 b5 b4 b3 b2 b1 b0 r1_cdac_side_mc mm=1
Rpt29 tp29 0 1e15
Rpl29 lp29 0 1e15
Xn29 tn29 ln29 b10 b9 b8 b7 b6 b5 b4 b3 b2 b1 b0 r1_cdac_side_mc mm=1
Rnt29 tn29 0 1e15
Rnl29 ln29 0 1e15
Xp30 tp30 lp30 b10 b9 b8 b7 b6 b5 b4 b3 b2 b1 b0 r1_cdac_side_mc mm=1
Rpt30 tp30 0 1e15
Rpl30 lp30 0 1e15
Xn30 tn30 ln30 b10 b9 b8 b7 b6 b5 b4 b3 b2 b1 b0 r1_cdac_side_mc mm=1
Rnt30 tn30 0 1e15
Rnl30 ln30 0 1e15
Xp31 tp31 lp31 b10 b9 b8 b7 b6 b5 b4 b3 b2 b1 b0 r1_cdac_side_mc mm=1
Rpt31 tp31 0 1e15
Rpl31 lp31 0 1e15
Xn31 tn31 ln31 b10 b9 b8 b7 b6 b5 b4 b3 b2 b1 b0 r1_cdac_side_mc mm=1
Rnt31 tn31 0 1e15
Rnl31 ln31 0 1e15
Xp32 tp32 lp32 b10 b9 b8 b7 b6 b5 b4 b3 b2 b1 b0 r1_cdac_side_mc mm=1
Rpt32 tp32 0 1e15
Rpl32 lp32 0 1e15
Xn32 tn32 ln32 b10 b9 b8 b7 b6 b5 b4 b3 b2 b1 b0 r1_cdac_side_mc mm=1
Rnt32 tn32 0 1e15
Rnl32 ln32 0 1e15
Xp33 tp33 lp33 b10 b9 b8 b7 b6 b5 b4 b3 b2 b1 b0 r1_cdac_side_mc mm=1
Rpt33 tp33 0 1e15
Rpl33 lp33 0 1e15
Xn33 tn33 ln33 b10 b9 b8 b7 b6 b5 b4 b3 b2 b1 b0 r1_cdac_side_mc mm=1
Rnt33 tn33 0 1e15
Rnl33 ln33 0 1e15
Xp34 tp34 lp34 b10 b9 b8 b7 b6 b5 b4 b3 b2 b1 b0 r1_cdac_side_mc mm=1
Rpt34 tp34 0 1e15
Rpl34 lp34 0 1e15
Xn34 tn34 ln34 b10 b9 b8 b7 b6 b5 b4 b3 b2 b1 b0 r1_cdac_side_mc mm=1
Rnt34 tn34 0 1e15
Rnl34 ln34 0 1e15
Xp35 tp35 lp35 b10 b9 b8 b7 b6 b5 b4 b3 b2 b1 b0 r1_cdac_side_mc mm=1
Rpt35 tp35 0 1e15
Rpl35 lp35 0 1e15
Xn35 tn35 ln35 b10 b9 b8 b7 b6 b5 b4 b3 b2 b1 b0 r1_cdac_side_mc mm=1
Rnt35 tn35 0 1e15
Rnl35 ln35 0 1e15
Xp36 tp36 lp36 b10 b9 b8 b7 b6 b5 b4 b3 b2 b1 b0 r1_cdac_side_mc mm=1
Rpt36 tp36 0 1e15
Rpl36 lp36 0 1e15
Xn36 tn36 ln36 b10 b9 b8 b7 b6 b5 b4 b3 b2 b1 b0 r1_cdac_side_mc mm=1
Rnt36 tn36 0 1e15
Rnl36 ln36 0 1e15
Xp37 tp37 lp37 b10 b9 b8 b7 b6 b5 b4 b3 b2 b1 b0 r1_cdac_side_mc mm=1
Rpt37 tp37 0 1e15
Rpl37 lp37 0 1e15
Xn37 tn37 ln37 b10 b9 b8 b7 b6 b5 b4 b3 b2 b1 b0 r1_cdac_side_mc mm=1
Rnt37 tn37 0 1e15
Rnl37 ln37 0 1e15
Xp38 tp38 lp38 b10 b9 b8 b7 b6 b5 b4 b3 b2 b1 b0 r1_cdac_side_mc mm=1
Rpt38 tp38 0 1e15
Rpl38 lp38 0 1e15
Xn38 tn38 ln38 b10 b9 b8 b7 b6 b5 b4 b3 b2 b1 b0 r1_cdac_side_mc mm=1
Rnt38 tn38 0 1e15
Rnl38 ln38 0 1e15
Xp39 tp39 lp39 b10 b9 b8 b7 b6 b5 b4 b3 b2 b1 b0 r1_cdac_side_mc mm=1
Rpt39 tp39 0 1e15
Rpl39 lp39 0 1e15
Xn39 tn39 ln39 b10 b9 b8 b7 b6 b5 b4 b3 b2 b1 b0 r1_cdac_side_mc mm=1
Rnt39 tn39 0 1e15
Rnl39 ln39 0 1e15
Xp40 tp40 lp40 b10 b9 b8 b7 b6 b5 b4 b3 b2 b1 b0 r1_cdac_side_mc mm=1
Rpt40 tp40 0 1e15
Rpl40 lp40 0 1e15
Xn40 tn40 ln40 b10 b9 b8 b7 b6 b5 b4 b3 b2 b1 b0 r1_cdac_side_mc mm=1
Rnt40 tn40 0 1e15
Rnl40 ln40 0 1e15
Xp41 tp41 lp41 b10 b9 b8 b7 b6 b5 b4 b3 b2 b1 b0 r1_cdac_side_mc mm=1
Rpt41 tp41 0 1e15
Rpl41 lp41 0 1e15
Xn41 tn41 ln41 b10 b9 b8 b7 b6 b5 b4 b3 b2 b1 b0 r1_cdac_side_mc mm=1
Rnt41 tn41 0 1e15
Rnl41 ln41 0 1e15
Xp42 tp42 lp42 b10 b9 b8 b7 b6 b5 b4 b3 b2 b1 b0 r1_cdac_side_mc mm=1
Rpt42 tp42 0 1e15
Rpl42 lp42 0 1e15
Xn42 tn42 ln42 b10 b9 b8 b7 b6 b5 b4 b3 b2 b1 b0 r1_cdac_side_mc mm=1
Rnt42 tn42 0 1e15
Rnl42 ln42 0 1e15
Xp43 tp43 lp43 b10 b9 b8 b7 b6 b5 b4 b3 b2 b1 b0 r1_cdac_side_mc mm=1
Rpt43 tp43 0 1e15
Rpl43 lp43 0 1e15
Xn43 tn43 ln43 b10 b9 b8 b7 b6 b5 b4 b3 b2 b1 b0 r1_cdac_side_mc mm=1
Rnt43 tn43 0 1e15
Rnl43 ln43 0 1e15
Xp44 tp44 lp44 b10 b9 b8 b7 b6 b5 b4 b3 b2 b1 b0 r1_cdac_side_mc mm=1
Rpt44 tp44 0 1e15
Rpl44 lp44 0 1e15
Xn44 tn44 ln44 b10 b9 b8 b7 b6 b5 b4 b3 b2 b1 b0 r1_cdac_side_mc mm=1
Rnt44 tn44 0 1e15
Rnl44 ln44 0 1e15
Xp45 tp45 lp45 b10 b9 b8 b7 b6 b5 b4 b3 b2 b1 b0 r1_cdac_side_mc mm=1
Rpt45 tp45 0 1e15
Rpl45 lp45 0 1e15
Xn45 tn45 ln45 b10 b9 b8 b7 b6 b5 b4 b3 b2 b1 b0 r1_cdac_side_mc mm=1
Rnt45 tn45 0 1e15
Rnl45 ln45 0 1e15
Xp46 tp46 lp46 b10 b9 b8 b7 b6 b5 b4 b3 b2 b1 b0 r1_cdac_side_mc mm=1
Rpt46 tp46 0 1e15
Rpl46 lp46 0 1e15
Xn46 tn46 ln46 b10 b9 b8 b7 b6 b5 b4 b3 b2 b1 b0 r1_cdac_side_mc mm=1
Rnt46 tn46 0 1e15
Rnl46 ln46 0 1e15
Xp47 tp47 lp47 b10 b9 b8 b7 b6 b5 b4 b3 b2 b1 b0 r1_cdac_side_mc mm=1
Rpt47 tp47 0 1e15
Rpl47 lp47 0 1e15
Xn47 tn47 ln47 b10 b9 b8 b7 b6 b5 b4 b3 b2 b1 b0 r1_cdac_side_mc mm=1
Rnt47 tn47 0 1e15
Rnl47 ln47 0 1e15
Xp48 tp48 lp48 b10 b9 b8 b7 b6 b5 b4 b3 b2 b1 b0 r1_cdac_side_mc mm=1
Rpt48 tp48 0 1e15
Rpl48 lp48 0 1e15
Xn48 tn48 ln48 b10 b9 b8 b7 b6 b5 b4 b3 b2 b1 b0 r1_cdac_side_mc mm=1
Rnt48 tn48 0 1e15
Rnl48 ln48 0 1e15
Xp49 tp49 lp49 b10 b9 b8 b7 b6 b5 b4 b3 b2 b1 b0 r1_cdac_side_mc mm=1
Rpt49 tp49 0 1e15
Rpl49 lp49 0 1e15
Xn49 tn49 ln49 b10 b9 b8 b7 b6 b5 b4 b3 b2 b1 b0 r1_cdac_side_mc mm=1
Rnt49 tn49 0 1e15
Rnl49 ln49 0 1e15
.control
set wr_singlescale
alter vb10 acmag=1
ac lin 1 1k 1k
wrdata @RAW@/w_b10.txt v(tp0) v(tn0) v(tp1) v(tn1) v(tp2) v(tn2) v(tp3) v(tn3) v(tp4) v(tn4) v(tp5) v(tn5) v(tp6) v(tn6) v(tp7) v(tn7) v(tp8) v(tn8) v(tp9) v(tn9) v(tp10) v(tn10) v(tp11) v(tn11) v(tp12) v(tn12) v(tp13) v(tn13) v(tp14) v(tn14) v(tp15) v(tn15) v(tp16) v(tn16) v(tp17) v(tn17) v(tp18) v(tn18) v(tp19) v(tn19) v(tp20) v(tn20) v(tp21) v(tn21) v(tp22) v(tn22) v(tp23) v(tn23) v(tp24) v(tn24) v(tp25) v(tn25) v(tp26) v(tn26) v(tp27) v(tn27) v(tp28) v(tn28) v(tp29) v(tn29) v(tp30) v(tn30) v(tp31) v(tn31) v(tp32) v(tn32) v(tp33) v(tn33) v(tp34) v(tn34) v(tp35) v(tn35) v(tp36) v(tn36) v(tp37) v(tn37) v(tp38) v(tn38) v(tp39) v(tn39) v(tp40) v(tn40) v(tp41) v(tn41) v(tp42) v(tn42) v(tp43) v(tn43) v(tp44) v(tn44) v(tp45) v(tn45) v(tp46) v(tn46) v(tp47) v(tn47) v(tp48) v(tn48) v(tp49) v(tn49)
alter vb10 acmag=0
alter vb9 acmag=1
ac lin 1 1k 1k
wrdata @RAW@/w_b9.txt v(tp0) v(tn0) v(tp1) v(tn1) v(tp2) v(tn2) v(tp3) v(tn3) v(tp4) v(tn4) v(tp5) v(tn5) v(tp6) v(tn6) v(tp7) v(tn7) v(tp8) v(tn8) v(tp9) v(tn9) v(tp10) v(tn10) v(tp11) v(tn11) v(tp12) v(tn12) v(tp13) v(tn13) v(tp14) v(tn14) v(tp15) v(tn15) v(tp16) v(tn16) v(tp17) v(tn17) v(tp18) v(tn18) v(tp19) v(tn19) v(tp20) v(tn20) v(tp21) v(tn21) v(tp22) v(tn22) v(tp23) v(tn23) v(tp24) v(tn24) v(tp25) v(tn25) v(tp26) v(tn26) v(tp27) v(tn27) v(tp28) v(tn28) v(tp29) v(tn29) v(tp30) v(tn30) v(tp31) v(tn31) v(tp32) v(tn32) v(tp33) v(tn33) v(tp34) v(tn34) v(tp35) v(tn35) v(tp36) v(tn36) v(tp37) v(tn37) v(tp38) v(tn38) v(tp39) v(tn39) v(tp40) v(tn40) v(tp41) v(tn41) v(tp42) v(tn42) v(tp43) v(tn43) v(tp44) v(tn44) v(tp45) v(tn45) v(tp46) v(tn46) v(tp47) v(tn47) v(tp48) v(tn48) v(tp49) v(tn49)
alter vb9 acmag=0
alter vb8 acmag=1
ac lin 1 1k 1k
wrdata @RAW@/w_b8.txt v(tp0) v(tn0) v(tp1) v(tn1) v(tp2) v(tn2) v(tp3) v(tn3) v(tp4) v(tn4) v(tp5) v(tn5) v(tp6) v(tn6) v(tp7) v(tn7) v(tp8) v(tn8) v(tp9) v(tn9) v(tp10) v(tn10) v(tp11) v(tn11) v(tp12) v(tn12) v(tp13) v(tn13) v(tp14) v(tn14) v(tp15) v(tn15) v(tp16) v(tn16) v(tp17) v(tn17) v(tp18) v(tn18) v(tp19) v(tn19) v(tp20) v(tn20) v(tp21) v(tn21) v(tp22) v(tn22) v(tp23) v(tn23) v(tp24) v(tn24) v(tp25) v(tn25) v(tp26) v(tn26) v(tp27) v(tn27) v(tp28) v(tn28) v(tp29) v(tn29) v(tp30) v(tn30) v(tp31) v(tn31) v(tp32) v(tn32) v(tp33) v(tn33) v(tp34) v(tn34) v(tp35) v(tn35) v(tp36) v(tn36) v(tp37) v(tn37) v(tp38) v(tn38) v(tp39) v(tn39) v(tp40) v(tn40) v(tp41) v(tn41) v(tp42) v(tn42) v(tp43) v(tn43) v(tp44) v(tn44) v(tp45) v(tn45) v(tp46) v(tn46) v(tp47) v(tn47) v(tp48) v(tn48) v(tp49) v(tn49)
alter vb8 acmag=0
alter vb7 acmag=1
ac lin 1 1k 1k
wrdata @RAW@/w_b7.txt v(tp0) v(tn0) v(tp1) v(tn1) v(tp2) v(tn2) v(tp3) v(tn3) v(tp4) v(tn4) v(tp5) v(tn5) v(tp6) v(tn6) v(tp7) v(tn7) v(tp8) v(tn8) v(tp9) v(tn9) v(tp10) v(tn10) v(tp11) v(tn11) v(tp12) v(tn12) v(tp13) v(tn13) v(tp14) v(tn14) v(tp15) v(tn15) v(tp16) v(tn16) v(tp17) v(tn17) v(tp18) v(tn18) v(tp19) v(tn19) v(tp20) v(tn20) v(tp21) v(tn21) v(tp22) v(tn22) v(tp23) v(tn23) v(tp24) v(tn24) v(tp25) v(tn25) v(tp26) v(tn26) v(tp27) v(tn27) v(tp28) v(tn28) v(tp29) v(tn29) v(tp30) v(tn30) v(tp31) v(tn31) v(tp32) v(tn32) v(tp33) v(tn33) v(tp34) v(tn34) v(tp35) v(tn35) v(tp36) v(tn36) v(tp37) v(tn37) v(tp38) v(tn38) v(tp39) v(tn39) v(tp40) v(tn40) v(tp41) v(tn41) v(tp42) v(tn42) v(tp43) v(tn43) v(tp44) v(tn44) v(tp45) v(tn45) v(tp46) v(tn46) v(tp47) v(tn47) v(tp48) v(tn48) v(tp49) v(tn49)
alter vb7 acmag=0
alter vb6 acmag=1
ac lin 1 1k 1k
wrdata @RAW@/w_b6.txt v(tp0) v(tn0) v(tp1) v(tn1) v(tp2) v(tn2) v(tp3) v(tn3) v(tp4) v(tn4) v(tp5) v(tn5) v(tp6) v(tn6) v(tp7) v(tn7) v(tp8) v(tn8) v(tp9) v(tn9) v(tp10) v(tn10) v(tp11) v(tn11) v(tp12) v(tn12) v(tp13) v(tn13) v(tp14) v(tn14) v(tp15) v(tn15) v(tp16) v(tn16) v(tp17) v(tn17) v(tp18) v(tn18) v(tp19) v(tn19) v(tp20) v(tn20) v(tp21) v(tn21) v(tp22) v(tn22) v(tp23) v(tn23) v(tp24) v(tn24) v(tp25) v(tn25) v(tp26) v(tn26) v(tp27) v(tn27) v(tp28) v(tn28) v(tp29) v(tn29) v(tp30) v(tn30) v(tp31) v(tn31) v(tp32) v(tn32) v(tp33) v(tn33) v(tp34) v(tn34) v(tp35) v(tn35) v(tp36) v(tn36) v(tp37) v(tn37) v(tp38) v(tn38) v(tp39) v(tn39) v(tp40) v(tn40) v(tp41) v(tn41) v(tp42) v(tn42) v(tp43) v(tn43) v(tp44) v(tn44) v(tp45) v(tn45) v(tp46) v(tn46) v(tp47) v(tn47) v(tp48) v(tn48) v(tp49) v(tn49)
alter vb6 acmag=0
alter vb5 acmag=1
ac lin 1 1k 1k
wrdata @RAW@/w_b5.txt v(tp0) v(tn0) v(tp1) v(tn1) v(tp2) v(tn2) v(tp3) v(tn3) v(tp4) v(tn4) v(tp5) v(tn5) v(tp6) v(tn6) v(tp7) v(tn7) v(tp8) v(tn8) v(tp9) v(tn9) v(tp10) v(tn10) v(tp11) v(tn11) v(tp12) v(tn12) v(tp13) v(tn13) v(tp14) v(tn14) v(tp15) v(tn15) v(tp16) v(tn16) v(tp17) v(tn17) v(tp18) v(tn18) v(tp19) v(tn19) v(tp20) v(tn20) v(tp21) v(tn21) v(tp22) v(tn22) v(tp23) v(tn23) v(tp24) v(tn24) v(tp25) v(tn25) v(tp26) v(tn26) v(tp27) v(tn27) v(tp28) v(tn28) v(tp29) v(tn29) v(tp30) v(tn30) v(tp31) v(tn31) v(tp32) v(tn32) v(tp33) v(tn33) v(tp34) v(tn34) v(tp35) v(tn35) v(tp36) v(tn36) v(tp37) v(tn37) v(tp38) v(tn38) v(tp39) v(tn39) v(tp40) v(tn40) v(tp41) v(tn41) v(tp42) v(tn42) v(tp43) v(tn43) v(tp44) v(tn44) v(tp45) v(tn45) v(tp46) v(tn46) v(tp47) v(tn47) v(tp48) v(tn48) v(tp49) v(tn49)
alter vb5 acmag=0
alter vb4 acmag=1
ac lin 1 1k 1k
wrdata @RAW@/w_b4.txt v(tp0) v(tn0) v(tp1) v(tn1) v(tp2) v(tn2) v(tp3) v(tn3) v(tp4) v(tn4) v(tp5) v(tn5) v(tp6) v(tn6) v(tp7) v(tn7) v(tp8) v(tn8) v(tp9) v(tn9) v(tp10) v(tn10) v(tp11) v(tn11) v(tp12) v(tn12) v(tp13) v(tn13) v(tp14) v(tn14) v(tp15) v(tn15) v(tp16) v(tn16) v(tp17) v(tn17) v(tp18) v(tn18) v(tp19) v(tn19) v(tp20) v(tn20) v(tp21) v(tn21) v(tp22) v(tn22) v(tp23) v(tn23) v(tp24) v(tn24) v(tp25) v(tn25) v(tp26) v(tn26) v(tp27) v(tn27) v(tp28) v(tn28) v(tp29) v(tn29) v(tp30) v(tn30) v(tp31) v(tn31) v(tp32) v(tn32) v(tp33) v(tn33) v(tp34) v(tn34) v(tp35) v(tn35) v(tp36) v(tn36) v(tp37) v(tn37) v(tp38) v(tn38) v(tp39) v(tn39) v(tp40) v(tn40) v(tp41) v(tn41) v(tp42) v(tn42) v(tp43) v(tn43) v(tp44) v(tn44) v(tp45) v(tn45) v(tp46) v(tn46) v(tp47) v(tn47) v(tp48) v(tn48) v(tp49) v(tn49)
alter vb4 acmag=0
alter vb3 acmag=1
ac lin 1 1k 1k
wrdata @RAW@/w_b3.txt v(tp0) v(tn0) v(tp1) v(tn1) v(tp2) v(tn2) v(tp3) v(tn3) v(tp4) v(tn4) v(tp5) v(tn5) v(tp6) v(tn6) v(tp7) v(tn7) v(tp8) v(tn8) v(tp9) v(tn9) v(tp10) v(tn10) v(tp11) v(tn11) v(tp12) v(tn12) v(tp13) v(tn13) v(tp14) v(tn14) v(tp15) v(tn15) v(tp16) v(tn16) v(tp17) v(tn17) v(tp18) v(tn18) v(tp19) v(tn19) v(tp20) v(tn20) v(tp21) v(tn21) v(tp22) v(tn22) v(tp23) v(tn23) v(tp24) v(tn24) v(tp25) v(tn25) v(tp26) v(tn26) v(tp27) v(tn27) v(tp28) v(tn28) v(tp29) v(tn29) v(tp30) v(tn30) v(tp31) v(tn31) v(tp32) v(tn32) v(tp33) v(tn33) v(tp34) v(tn34) v(tp35) v(tn35) v(tp36) v(tn36) v(tp37) v(tn37) v(tp38) v(tn38) v(tp39) v(tn39) v(tp40) v(tn40) v(tp41) v(tn41) v(tp42) v(tn42) v(tp43) v(tn43) v(tp44) v(tn44) v(tp45) v(tn45) v(tp46) v(tn46) v(tp47) v(tn47) v(tp48) v(tn48) v(tp49) v(tn49)
alter vb3 acmag=0
alter vb2 acmag=1
ac lin 1 1k 1k
wrdata @RAW@/w_b2.txt v(tp0) v(tn0) v(tp1) v(tn1) v(tp2) v(tn2) v(tp3) v(tn3) v(tp4) v(tn4) v(tp5) v(tn5) v(tp6) v(tn6) v(tp7) v(tn7) v(tp8) v(tn8) v(tp9) v(tn9) v(tp10) v(tn10) v(tp11) v(tn11) v(tp12) v(tn12) v(tp13) v(tn13) v(tp14) v(tn14) v(tp15) v(tn15) v(tp16) v(tn16) v(tp17) v(tn17) v(tp18) v(tn18) v(tp19) v(tn19) v(tp20) v(tn20) v(tp21) v(tn21) v(tp22) v(tn22) v(tp23) v(tn23) v(tp24) v(tn24) v(tp25) v(tn25) v(tp26) v(tn26) v(tp27) v(tn27) v(tp28) v(tn28) v(tp29) v(tn29) v(tp30) v(tn30) v(tp31) v(tn31) v(tp32) v(tn32) v(tp33) v(tn33) v(tp34) v(tn34) v(tp35) v(tn35) v(tp36) v(tn36) v(tp37) v(tn37) v(tp38) v(tn38) v(tp39) v(tn39) v(tp40) v(tn40) v(tp41) v(tn41) v(tp42) v(tn42) v(tp43) v(tn43) v(tp44) v(tn44) v(tp45) v(tn45) v(tp46) v(tn46) v(tp47) v(tn47) v(tp48) v(tn48) v(tp49) v(tn49)
alter vb2 acmag=0
alter vb1 acmag=1
ac lin 1 1k 1k
wrdata @RAW@/w_b1.txt v(tp0) v(tn0) v(tp1) v(tn1) v(tp2) v(tn2) v(tp3) v(tn3) v(tp4) v(tn4) v(tp5) v(tn5) v(tp6) v(tn6) v(tp7) v(tn7) v(tp8) v(tn8) v(tp9) v(tn9) v(tp10) v(tn10) v(tp11) v(tn11) v(tp12) v(tn12) v(tp13) v(tn13) v(tp14) v(tn14) v(tp15) v(tn15) v(tp16) v(tn16) v(tp17) v(tn17) v(tp18) v(tn18) v(tp19) v(tn19) v(tp20) v(tn20) v(tp21) v(tn21) v(tp22) v(tn22) v(tp23) v(tn23) v(tp24) v(tn24) v(tp25) v(tn25) v(tp26) v(tn26) v(tp27) v(tn27) v(tp28) v(tn28) v(tp29) v(tn29) v(tp30) v(tn30) v(tp31) v(tn31) v(tp32) v(tn32) v(tp33) v(tn33) v(tp34) v(tn34) v(tp35) v(tn35) v(tp36) v(tn36) v(tp37) v(tn37) v(tp38) v(tn38) v(tp39) v(tn39) v(tp40) v(tn40) v(tp41) v(tn41) v(tp42) v(tn42) v(tp43) v(tn43) v(tp44) v(tn44) v(tp45) v(tn45) v(tp46) v(tn46) v(tp47) v(tn47) v(tp48) v(tn48) v(tp49) v(tn49)
alter vb1 acmag=0
alter vb0 acmag=1
ac lin 1 1k 1k
wrdata @RAW@/w_b0.txt v(tp0) v(tn0) v(tp1) v(tn1) v(tp2) v(tn2) v(tp3) v(tn3) v(tp4) v(tn4) v(tp5) v(tn5) v(tp6) v(tn6) v(tp7) v(tn7) v(tp8) v(tn8) v(tp9) v(tn9) v(tp10) v(tn10) v(tp11) v(tn11) v(tp12) v(tn12) v(tp13) v(tn13) v(tp14) v(tn14) v(tp15) v(tn15) v(tp16) v(tn16) v(tp17) v(tn17) v(tp18) v(tn18) v(tp19) v(tn19) v(tp20) v(tn20) v(tp21) v(tn21) v(tp22) v(tn22) v(tp23) v(tn23) v(tp24) v(tn24) v(tp25) v(tn25) v(tp26) v(tn26) v(tp27) v(tn27) v(tp28) v(tn28) v(tp29) v(tn29) v(tp30) v(tn30) v(tp31) v(tn31) v(tp32) v(tn32) v(tp33) v(tn33) v(tp34) v(tn34) v(tp35) v(tn35) v(tp36) v(tn36) v(tp37) v(tn37) v(tp38) v(tn38) v(tp39) v(tn39) v(tp40) v(tn40) v(tp41) v(tn41) v(tp42) v(tn42) v(tp43) v(tn43) v(tp44) v(tn44) v(tp45) v(tn45) v(tp46) v(tn46) v(tp47) v(tn47) v(tp48) v(tn48) v(tp49) v(tn49)
alter vb0 acmag=0
.endc
.end
