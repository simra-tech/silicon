* sim/post/b5/decks/b5s4/fc_ss125.cir -- generated by sim/post/b5/gen_b5_decks.py (T2k); do not edit.
* first conversion at ss / 125 C / 1.08 V, A -0.80 V, B -0.781 V (as postb4-fc-ss125-rc)
* ADC netlist: sim/post/r1_adc_post_rc_mb5.spice (subckt r1_adc_lay_sar, sha256 7bf2b33fe2c6ddc544c4c754f8f37a9d4ee09bed36801e903b498b6360b949e9); SAR: r1_adc_sar_glc (SPEF lumped C); frames ee; corner mos_ss 125 C 1.08 V.
* Placeholders: RAW (bulk run directory), <G1_RESULTS_ROOT>/r1_adc_sar/release-t2j-h/r1_adc_sar_gl_sim.spice (release gate-level netlist, used with --sar-par none).
.lib /foss/pdks/ihp-sg13g2/libs.tech/ngspice/models/cornerMOSlv.lib mos_ss
.lib /foss/pdks/ihp-sg13g2/libs.tech/ngspice/models/cornerCAP.lib cap_typ
.lib /foss/pdks/ihp-sg13g2/libs.tech/ngspice/models/cornerMOShv.lib mos_ss
.lib /foss/pdks/ihp-sg13g2/libs.tech/ngspice/models/cornerRES.lib res_typ
.include sim/post/r1_adc_post_rc_mb5.spice
.include /foss/pdks/ihp-sg13g2/libs.ref/sg13g2_stdcell/spice/sg13g2_stdcell.spice
.include sim/post/b5/sar/r1_adc_sar_gl_lumpc.spice
.temp 125
* sparse + noopiter: as the B4 RC runs (KLU fails the OP on the RC netlist and with the cell netlists)
.option reltol=1e-4 vntol=1e-6 abstol=1e-12 method=trap sparse seed=1 noopiter
Vdd vdd 0 1.08
Vsarm vddsar vdd 0
Vdda vdda 0 3.3
Vbgi vbgi 0 DC 0.995000
Rbg vbgi vbg 190k
Ibref vdda nbr 5u
Vrefi vrefa 0 1.045
Vrefli vrefla 0 1.045
Vcm vcm 0 0.6
Vda vda 0 PWL(0 -0.8000000 7.883333e-07 -0.8000000 7.983333e-07 -0.8000000)
Vdb vdb 0 PWL(0 -0.7808511 7.883333e-07 -0.7808511 7.983333e-07 -0.7808511)
Esp sinp vcm vda 0 0.5
Esn sinn vcm vda 0 -0.5
Ecp cosp vcm vdb 0 0.5
Ecn cosn vcm vdb 0 -0.5
* in1 inputs idle at the common mode (as tb_post_points.cir: both slices on isap / isan = 0.6 V)
Vip isap 0 0.6
Vin isan 0 0.6
Vibp isbp 0 0.6
Vibn isbn 0 0.6
* ctrl side (r1_gate protocol, T2j sar/sim/gen_gl_deck.py; cur_trk per INTERFACES ctrl 0.7)
Vclk clk 0 PULSE(0 1.08 33.3333333n 50p 50p 16.6166667n 33.3333333n)
Vpor por_n 0 PWL(0 0 50n 0 50.05n 1.08)
Vadc_start adc_start 0 PWL(0 0 600.3000n 0 600.3500n 1.08 633.6333n 1.08 633.6833n 0 1333.6333n 0 1333.6833n 1.08 1366.9667n 1.08 1367.0167n 0)
Vadc_hold adc_hold 0 PWL(0 0 100.3000n 0 100.3500n 1.08 166.9667n 1.08 167.0167n 0 600.3000n 0 600.3500n 1.08 1100.3000n 1.08 1100.3500n 0 1333.6333n 0 1333.6833n 1.08 1833.6333n 1.08 1833.6833n 0)
Vis_smp is_smp 0 PWL(0 0)
Vcur_trk cur_trk 0 PWL(0 0)
Vsel adc_sel 0 0
Cl_adc_valid_a adc_valid_a 0 50f
Cl_adc_valid_b adc_valid_b 0 50f
Cl_adc_raw_a_0 adc_raw_a_0 0 50f
Cl_adc_raw_a_1 adc_raw_a_1 0 50f
Cl_adc_raw_a_2 adc_raw_a_2 0 50f
Cl_adc_raw_a_3 adc_raw_a_3 0 50f
Cl_adc_raw_a_4 adc_raw_a_4 0 50f
Cl_adc_raw_a_5 adc_raw_a_5 0 50f
Cl_adc_raw_a_6 adc_raw_a_6 0 50f
Cl_adc_raw_a_7 adc_raw_a_7 0 50f
Cl_adc_raw_a_8 adc_raw_a_8 0 50f
Cl_adc_raw_a_9 adc_raw_a_9 0 50f
Cl_adc_raw_a_10 adc_raw_a_10 0 50f
Cl_adc_raw_a_11 adc_raw_a_11 0 50f
Cl_adc_raw_a_12 adc_raw_a_12 0 50f
Cl_adc_raw_a_13 adc_raw_a_13 0 50f
Cl_adc_raw_b_0 adc_raw_b_0 0 50f
Cl_adc_raw_b_1 adc_raw_b_1 0 50f
Cl_adc_raw_b_2 adc_raw_b_2 0 50f
Cl_adc_raw_b_3 adc_raw_b_3 0 50f
Cl_adc_raw_b_4 adc_raw_b_4 0 50f
Cl_adc_raw_b_5 adc_raw_b_5 0 50f
Cl_adc_raw_b_6 adc_raw_b_6 0 50f
Cl_adc_raw_b_7 adc_raw_b_7 0 50f
Cl_adc_raw_b_8 adc_raw_b_8 0 50f
Cl_adc_raw_b_9 adc_raw_b_9 0 50f
Cl_adc_raw_b_10 adc_raw_b_10 0 50f
Cl_adc_raw_b_11 adc_raw_b_11 0 50f
Cl_adc_raw_b_12 adc_raw_b_12 0 50f
Cl_adc_raw_b_13 adc_raw_b_13 0 50f
* post-layout ADC (wrapper keeps the B4 node names xadc.xl.*)
.subckt r1_adc_b5w adc_hold adc_raw_a_0 adc_raw_a_1 adc_raw_a_10 adc_raw_a_11 adc_raw_a_12 adc_raw_a_13 adc_raw_a_2 adc_raw_a_3 adc_raw_a_4 adc_raw_a_5 adc_raw_a_6 adc_raw_a_7 adc_raw_a_8 adc_raw_a_9 adc_raw_b_0 adc_raw_b_1 adc_raw_b_10 adc_raw_b_11 adc_raw_b_12 adc_raw_b_13 adc_raw_b_2 adc_raw_b_3 adc_raw_b_4 adc_raw_b_5 adc_raw_b_6 adc_raw_b_7 adc_raw_b_8 adc_raw_b_9 adc_sel adc_start adc_valid_a adc_valid_b clk cosn cosp is_smp isan isap isbn isbp nbr nc_vcm nc_vcm2 por_n sar_clka sar_clkab sar_clkb sar_clkbb sar_clkna sar_clknab sar_clknb sar_clknbb sar_cna0 sar_cna1 sar_cna10 sar_cna11 sar_cna12 sar_cna2 sar_cna3 sar_cna4 sar_cna5 sar_cna6 sar_cna7 sar_cna8 sar_cna9 sar_cnb0 sar_cnb1 sar_cnb10 sar_cnb11 sar_cnb12 sar_cnb2 sar_cnb3 sar_cnb4 sar_cnb5 sar_cnb6 sar_cnb7 sar_cnb8 sar_cnb9 sar_cpa0 sar_cpa1 sar_cpa10 sar_cpa11 sar_cpa12 sar_cpa2 sar_cpa3 sar_cpa4 sar_cpa5 sar_cpa6 sar_cpa7 sar_cpa8 sar_cpa9 sar_cpb0 sar_cpb1 sar_cpb10 sar_cpb11 sar_cpb12 sar_cpb2 sar_cpb3 sar_cpb4 sar_cpb5 sar_cpb6 sar_cpb7 sar_cpb8 sar_cpb9 sar_mclk sar_oan sar_oann sar_oanp sar_oap sar_obn sar_obnn sar_obnp sar_obp sar_trka0 sar_trka1 sar_trkb0 sar_trkb1 sinn sinp topan topap topbn topbp vbg vdd vdd_sar vdda vrefa vrefla vss_sar
XL adc_hold is_smp clk adc_start adc_sel adc_valid_a adc_raw_a_0 adc_raw_a_1 adc_raw_a_2 adc_raw_a_3 adc_raw_a_4 adc_raw_a_5 adc_raw_a_6 adc_raw_a_7 adc_raw_a_8 adc_raw_a_9 adc_raw_a_10 adc_raw_a_11 adc_raw_a_12 adc_raw_a_13 adc_valid_b adc_raw_b_0 adc_raw_b_1 adc_raw_b_2 adc_raw_b_3 adc_raw_b_4 adc_raw_b_5 adc_raw_b_6 adc_raw_b_7 adc_raw_b_8 adc_raw_b_9 adc_raw_b_10 adc_raw_b_11 adc_raw_b_12 adc_raw_b_13 por_n sinp sinn cosp cosn nc_vcm2 nbr isap isan isbp isbn nc_vcm vdda vdd 0 vbg topap topan topbp topbn sar_clka sar_clkab sar_clkb sar_clkbb sar_clkna sar_clknab sar_clknb sar_clknbb sar_cna0 sar_cna1 sar_cna10 sar_cna11 sar_cna12 sar_cna2 sar_cna3 sar_cna4 sar_cna5 sar_cna6 sar_cna7 sar_cna8 sar_cna9 sar_cnb0 sar_cnb1 sar_cnb10 sar_cnb11 sar_cnb12 sar_cnb2 sar_cnb3 sar_cnb4 sar_cnb5 sar_cnb6 sar_cnb7 sar_cnb8 sar_cnb9 sar_cpa0 sar_cpa1 sar_cpa10 sar_cpa11 sar_cpa12 sar_cpa2 sar_cpa3 sar_cpa4 sar_cpa5 sar_cpa6 sar_cpa7 sar_cpa8 sar_cpa9 sar_cpb0 sar_cpb1 sar_cpb10 sar_cpb11 sar_cpb12 sar_cpb2 sar_cpb3 sar_cpb4 sar_cpb5 sar_cpb6 sar_cpb7 sar_cpb8 sar_cpb9 sar_oan sar_oann sar_oanp sar_oap sar_obn sar_obnn sar_obnp sar_obp sar_trka0 sar_trka1 sar_trkb0 sar_trkb1 sar_mclk vrefa vrefla vdd_sar vss_sar r1_adc_lay_sar
Rnc_vcm nc_vcm 0 1k
Rnc_vcm2 nc_vcm2 0 1k
.ends r1_adc_b5w
XADC adc_hold adc_raw_a_0 adc_raw_a_1 adc_raw_a_10 adc_raw_a_11 adc_raw_a_12 adc_raw_a_13 adc_raw_a_2 adc_raw_a_3 adc_raw_a_4 adc_raw_a_5 adc_raw_a_6 adc_raw_a_7 adc_raw_a_8 adc_raw_a_9 adc_raw_b_0 adc_raw_b_1 adc_raw_b_10 adc_raw_b_11 adc_raw_b_12 adc_raw_b_13 adc_raw_b_2 adc_raw_b_3 adc_raw_b_4 adc_raw_b_5 adc_raw_b_6 adc_raw_b_7 adc_raw_b_8 adc_raw_b_9 adc_sel adc_start adc_valid_a adc_valid_b clk cosn cosp is_smp isan isap isbn isbp nbr nc_vcm nc_vcm2 por_n sar_clka sar_clkab sar_clkb sar_clkbb sar_clkna sar_clknab sar_clknb sar_clknbb sar_cna0 sar_cna1 sar_cna10 sar_cna11 sar_cna12 sar_cna2 sar_cna3 sar_cna4 sar_cna5 sar_cna6 sar_cna7 sar_cna8 sar_cna9 sar_cnb0 sar_cnb1 sar_cnb10 sar_cnb11 sar_cnb12 sar_cnb2 sar_cnb3 sar_cnb4 sar_cnb5 sar_cnb6 sar_cnb7 sar_cnb8 sar_cnb9 sar_cpa0 sar_cpa1 sar_cpa10 sar_cpa11 sar_cpa12 sar_cpa2 sar_cpa3 sar_cpa4 sar_cpa5 sar_cpa6 sar_cpa7 sar_cpa8 sar_cpa9 sar_cpb0 sar_cpb1 sar_cpb10 sar_cpb11 sar_cpb12 sar_cpb2 sar_cpb3 sar_cpb4 sar_cpb5 sar_cpb6 sar_cpb7 sar_cpb8 sar_cpb9 sar_mclk sar_oan sar_oann sar_oanp sar_oap sar_obn sar_obnn sar_obnp sar_obp sar_trka0 sar_trka1 sar_trkb0 sar_trkb1 sinn sinp topan topap topbn topbp vbg vdd vdd_sar vdda vrefa vrefla vss_sar r1_adc_b5w
* hardened SAR sub-macro
XSAR adc_hold adc_sel adc_start adc_valid_a adc_valid_b clk sar_clka sar_clkab sar_clkb sar_clkbb sar_clkna sar_clknab sar_clknb sar_clknbb cur_trk is_smp sar_mclk sar_oan sar_oann sar_oanp sar_oap sar_obn sar_obnn sar_obnp sar_obp por_n sar_trka0 sar_trka1 sar_trkb0 sar_trkb1 adc_raw_a_13 adc_raw_a_12 adc_raw_a_11 adc_raw_a_10 adc_raw_a_9 adc_raw_a_8 adc_raw_a_7 adc_raw_a_6 adc_raw_a_5 adc_raw_a_4 adc_raw_a_3 adc_raw_a_2 adc_raw_a_1 adc_raw_a_0 adc_raw_b_13 adc_raw_b_12 adc_raw_b_11 adc_raw_b_10 adc_raw_b_9 adc_raw_b_8 adc_raw_b_7 adc_raw_b_6 adc_raw_b_5 adc_raw_b_4 adc_raw_b_3 adc_raw_b_2 adc_raw_b_1 adc_raw_b_0 sar_cna12 sar_cna11 sar_cna10 sar_cna9 sar_cna8 sar_cna7 sar_cna6 sar_cna5 sar_cna4 sar_cna3 sar_cna2 sar_cna1 sar_cna0 sar_cnb12 sar_cnb11 sar_cnb10 sar_cnb9 sar_cnb8 sar_cnb7 sar_cnb6 sar_cnb5 sar_cnb4 sar_cnb3 sar_cnb2 sar_cnb1 sar_cnb0 sar_cpa12 sar_cpa11 sar_cpa10 sar_cpa9 sar_cpa8 sar_cpa7 sar_cpa6 sar_cpa5 sar_cpa4 sar_cpa3 sar_cpa2 sar_cpa1 sar_cpa0 sar_cpb12 sar_cpb11 sar_cpb10 sar_cpb9 sar_cpb8 sar_cpb7 sar_cpb6 sar_cpb5 sar_cpb4 sar_cpb3 sar_cpb2 sar_cpb1 sar_cpb0 vdd_sar vss_sar r1_adc_sar_glc
.control
set num_threads=1
save v(clk) v(por_n) v(adc_hold) v(is_smp) v(adc_start) v(cur_trk) v(topap) v(topan) v(topbp) v(topbn) v(vrefa) v(vrefla) v(vbg) v(adc_valid_a) v(adc_valid_b) v(adc_raw_a_0) v(adc_raw_a_1) v(adc_raw_a_2) v(adc_raw_a_3) v(adc_raw_a_4) v(adc_raw_a_5) v(adc_raw_a_6) v(adc_raw_a_7) v(adc_raw_a_8) v(adc_raw_a_9) v(adc_raw_a_10) v(adc_raw_a_11) v(adc_raw_a_12) v(adc_raw_a_13) v(adc_raw_b_0) v(adc_raw_b_1) v(adc_raw_b_2) v(adc_raw_b_3) v(adc_raw_b_4) v(adc_raw_b_5) v(adc_raw_b_6) v(adc_raw_b_7) v(adc_raw_b_8) v(adc_raw_b_9) v(adc_raw_b_10) v(adc_raw_b_11) v(adc_raw_b_12) v(adc_raw_b_13) v(sar_clka) v(sar_clkab) v(sar_clkb) v(sar_clkbb) v(sar_clkna) v(sar_clknab) v(sar_clknb) v(sar_clknbb) v(sar_cna0) v(sar_cna1) v(sar_cna10) v(sar_cna11) v(sar_cna12) v(sar_cna2) v(sar_cna3) v(sar_cna4) v(sar_cna5) v(sar_cna6) v(sar_cna7) v(sar_cna8) v(sar_cna9) v(sar_cnb0) v(sar_cnb1) v(sar_cnb10) v(sar_cnb11) v(sar_cnb12) v(sar_cnb2) v(sar_cnb3) v(sar_cnb4) v(sar_cnb5) v(sar_cnb6) v(sar_cnb7) v(sar_cnb8) v(sar_cnb9) v(sar_cpa0) v(sar_cpa1) v(sar_cpa10) v(sar_cpa11) v(sar_cpa12) v(sar_cpa2) v(sar_cpa3) v(sar_cpa4) v(sar_cpa5) v(sar_cpa6) v(sar_cpa7) v(sar_cpa8) v(sar_cpa9) v(sar_cpb0) v(sar_cpb1) v(sar_cpb10) v(sar_cpb11) v(sar_cpb12) v(sar_cpb2) v(sar_cpb3) v(sar_cpb4) v(sar_cpb5) v(sar_cpb6) v(sar_cpb7) v(sar_cpb8) v(sar_cpb9) v(sar_mclk) v(sar_oan) v(sar_oann) v(sar_oanp) v(sar_oap) v(sar_obn) v(sar_obnn) v(sar_obnp) v(sar_obp) v(sar_trka0) v(sar_trka1) v(sar_trkb0) v(sar_trkb1) i(vdd) i(vdda) i(vsarm)
tran 1n 1.86u 0 0.2n
write <G1_RESULTS_ROOT>/r1_adc/b5-ms-fc-ss125/b5.raw
.endc
.end
