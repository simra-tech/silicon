* r1_adc_sar_gl_lumpc.spice -- written by sim/post/b5/gen_b5_decks.py (do not edit): the gate-level netlist <G1_RESULTS_ROOT>/r1_adc_sar/release-t2j-h/r1_adc_sar_gl_sim.spice (sha256 f986e9611d8f3d407619275e222c6deecb5617dbab03abea36fab5d6657a5b04)
* + one capacitor per SPEF net (r1_adc_sar.nom.spef, sha256 346eb6b329787298dfd17a490e06787a90b84a2350a76e0b3e4dc9defa27bcc8; 408 nets, total 4.1138 pF)
* r1_adc_sar_gl: generated by sar/tools/v2spice.py from r1_adc_sar.pnl.v (618 cell instances, 0 assigns)
* skipped cells (no SPICE subcircuit, or antenna diode only): sg13g2_antennanp x1
.subckt r1_adc_sar_glc adc_hold adc_sel adc_start adc_valid_a adc_valid_b clk clka clkab clkb clkbb clkna clknab clknb clknbb cur_trk is_smp mclk oan oann oanp oap obn obnn obnp obp por_n trka0 trka1 trkb0 trkb1 adc_raw_a_13 adc_raw_a_12 adc_raw_a_11 adc_raw_a_10 adc_raw_a_9 adc_raw_a_8 adc_raw_a_7 adc_raw_a_6 adc_raw_a_5 adc_raw_a_4 adc_raw_a_3 adc_raw_a_2 adc_raw_a_1 adc_raw_a_0 adc_raw_b_13 adc_raw_b_12 adc_raw_b_11 adc_raw_b_10 adc_raw_b_9 adc_raw_b_8 adc_raw_b_7 adc_raw_b_6 adc_raw_b_5 adc_raw_b_4 adc_raw_b_3 adc_raw_b_2 adc_raw_b_1 adc_raw_b_0 cna_12 cna_11 cna_10 cna_9 cna_8 cna_7 cna_6 cna_5 cna_4 cna_3 cna_2 cna_1 cna_0 cnb_12 cnb_11 cnb_10 cnb_9 cnb_8 cnb_7 cnb_6 cnb_5 cnb_4 cnb_3 cnb_2 cnb_1 cnb_0 cpa_12 cpa_11 cpa_10 cpa_9 cpa_8 cpa_7 cpa_6 cpa_5 cpa_4 cpa_3 cpa_2 cpa_1 cpa_0 cpb_12 cpb_11 cpb_10 cpb_9 cpb_8 cpb_7 cpb_6 cpb_5 cpb_4 cpb_3 cpb_2 cpb_1 cpb_0 VDD VSS
XFILLER_0_0 VDD VSS sg13g2_decap_8
XFILLER_0_110 VDD VSS sg13g2_fill_1
XFILLER_0_132 VDD VSS sg13g2_fill_2
XFILLER_0_134 VDD VSS sg13g2_fill_1
XFILLER_0_14 VDD VSS sg13g2_decap_8
XFILLER_0_152 VDD VSS sg13g2_fill_2
XFILLER_0_203 VDD VSS sg13g2_fill_1
XFILLER_0_210 VDD VSS sg13g2_fill_1
XFILLER_0_222 VDD VSS sg13g2_fill_2
XFILLER_0_224 VDD VSS sg13g2_fill_1
XFILLER_0_231 VDD VSS sg13g2_fill_2
XFILLER_0_233 VDD VSS sg13g2_fill_1
XFILLER_0_275 VDD VSS sg13g2_decap_4
XFILLER_0_316 VDD VSS sg13g2_decap_4
XFILLER_0_370 VDD VSS sg13g2_decap_4
XFILLER_0_382 VDD VSS sg13g2_fill_2
XFILLER_0_391 VDD VSS sg13g2_fill_2
XFILLER_0_398 VDD VSS sg13g2_decap_8
XFILLER_0_405 VDD VSS sg13g2_fill_1
XFILLER_0_422 VDD VSS sg13g2_fill_2
XFILLER_0_424 VDD VSS sg13g2_fill_1
XFILLER_0_452 VDD VSS sg13g2_fill_1
XFILLER_0_475 VDD VSS sg13g2_fill_2
XFILLER_0_477 VDD VSS sg13g2_fill_1
XFILLER_0_510 VDD VSS sg13g2_decap_4
XFILLER_0_521 VDD VSS sg13g2_fill_1
XFILLER_0_557 VDD VSS sg13g2_fill_1
XFILLER_0_618 VDD VSS sg13g2_fill_1
XFILLER_0_634 VDD VSS sg13g2_fill_2
XFILLER_0_657 VDD VSS sg13g2_decap_4
XFILLER_0_661 VDD VSS sg13g2_fill_1
XFILLER_0_67 VDD VSS sg13g2_fill_1
XFILLER_0_674 VDD VSS sg13g2_decap_4
XFILLER_0_689 VDD VSS sg13g2_fill_1
XFILLER_0_7 VDD VSS sg13g2_decap_8
XFILLER_0_728 VDD VSS sg13g2_decap_4
XFILLER_0_742 VDD VSS sg13g2_fill_1
XFILLER_0_761 VDD VSS sg13g2_fill_2
XFILLER_0_792 VDD VSS sg13g2_fill_2
XFILLER_0_794 VDD VSS sg13g2_fill_1
XFILLER_0_83 VDD VSS sg13g2_decap_4
XFILLER_0_839 VDD VSS sg13g2_fill_2
XFILLER_0_888 VDD VSS sg13g2_decap_8
XFILLER_0_895 VDD VSS sg13g2_decap_8
XFILLER_0_902 VDD VSS sg13g2_fill_1
XFILLER_1_0 VDD VSS sg13g2_decap_8
XFILLER_1_101 VDD VSS sg13g2_fill_1
XFILLER_1_14 VDD VSS sg13g2_fill_2
XFILLER_1_246 VDD VSS sg13g2_fill_1
XFILLER_1_280 VDD VSS sg13g2_fill_2
XFILLER_1_282 VDD VSS sg13g2_fill_1
XFILLER_1_295 VDD VSS sg13g2_fill_2
XFILLER_1_312 VDD VSS sg13g2_fill_1
XFILLER_1_341 VDD VSS sg13g2_fill_2
XFILLER_1_354 VDD VSS sg13g2_decap_4
XFILLER_1_414 VDD VSS sg13g2_fill_1
XFILLER_1_435 VDD VSS sg13g2_decap_4
XFILLER_1_443 VDD VSS sg13g2_decap_8
XFILLER_1_450 VDD VSS sg13g2_decap_4
XFILLER_1_477 VDD VSS sg13g2_fill_1
XFILLER_1_506 VDD VSS sg13g2_fill_2
XFILLER_1_508 VDD VSS sg13g2_fill_1
XFILLER_1_537 VDD VSS sg13g2_fill_2
XFILLER_1_539 VDD VSS sg13g2_fill_1
XFILLER_1_545 VDD VSS sg13g2_decap_8
XFILLER_1_552 VDD VSS sg13g2_fill_1
XFILLER_1_585 VDD VSS sg13g2_fill_2
XFILLER_1_587 VDD VSS sg13g2_fill_1
XFILLER_1_61 VDD VSS sg13g2_fill_2
XFILLER_1_63 VDD VSS sg13g2_fill_1
XFILLER_1_7 VDD VSS sg13g2_decap_8
XFILLER_1_710 VDD VSS sg13g2_fill_1
XFILLER_1_762 VDD VSS sg13g2_fill_2
XFILLER_1_764 VDD VSS sg13g2_fill_1
XFILLER_1_810 VDD VSS sg13g2_decap_4
XFILLER_1_854 VDD VSS sg13g2_fill_1
XFILLER_1_882 VDD VSS sg13g2_decap_8
XFILLER_1_889 VDD VSS sg13g2_decap_8
XFILLER_1_896 VDD VSS sg13g2_decap_8
XFILLER_2_0 VDD VSS sg13g2_decap_8
XFILLER_2_108 VDD VSS sg13g2_fill_2
XFILLER_2_14 VDD VSS sg13g2_decap_4
XFILLER_2_142 VDD VSS sg13g2_fill_2
XFILLER_2_154 VDD VSS sg13g2_fill_1
XFILLER_2_169 VDD VSS sg13g2_fill_1
XFILLER_2_18 VDD VSS sg13g2_fill_2
XFILLER_2_184 VDD VSS sg13g2_decap_8
XFILLER_2_191 VDD VSS sg13g2_decap_4
XFILLER_2_200 VDD VSS sg13g2_decap_8
XFILLER_2_211 VDD VSS sg13g2_fill_2
XFILLER_2_213 VDD VSS sg13g2_fill_1
XFILLER_2_232 VDD VSS sg13g2_fill_2
XFILLER_2_239 VDD VSS sg13g2_fill_1
XFILLER_2_259 VDD VSS sg13g2_decap_8
XFILLER_2_266 VDD VSS sg13g2_decap_8
XFILLER_2_273 VDD VSS sg13g2_fill_2
XFILLER_2_275 VDD VSS sg13g2_fill_1
XFILLER_2_301 VDD VSS sg13g2_decap_8
XFILLER_2_308 VDD VSS sg13g2_fill_2
XFILLER_2_310 VDD VSS sg13g2_fill_1
XFILLER_2_321 VDD VSS sg13g2_fill_1
XFILLER_2_360 VDD VSS sg13g2_decap_4
XFILLER_2_388 VDD VSS sg13g2_fill_1
XFILLER_2_398 VDD VSS sg13g2_decap_4
XFILLER_2_402 VDD VSS sg13g2_fill_2
XFILLER_2_422 VDD VSS sg13g2_decap_8
XFILLER_2_429 VDD VSS sg13g2_fill_1
XFILLER_2_499 VDD VSS sg13g2_decap_4
XFILLER_2_56 VDD VSS sg13g2_decap_4
XFILLER_2_562 VDD VSS sg13g2_fill_2
XFILLER_2_60 VDD VSS sg13g2_fill_2
XFILLER_2_602 VDD VSS sg13g2_decap_4
XFILLER_2_638 VDD VSS sg13g2_decap_4
XFILLER_2_642 VDD VSS sg13g2_fill_1
XFILLER_2_658 VDD VSS sg13g2_decap_8
XFILLER_2_685 VDD VSS sg13g2_decap_8
XFILLER_2_692 VDD VSS sg13g2_fill_2
XFILLER_2_694 VDD VSS sg13g2_fill_1
XFILLER_2_7 VDD VSS sg13g2_decap_8
XFILLER_2_705 VDD VSS sg13g2_fill_1
XFILLER_2_721 VDD VSS sg13g2_decap_8
XFILLER_2_728 VDD VSS sg13g2_decap_8
XFILLER_2_735 VDD VSS sg13g2_fill_1
XFILLER_2_788 VDD VSS sg13g2_decap_8
XFILLER_2_795 VDD VSS sg13g2_fill_2
XFILLER_2_797 VDD VSS sg13g2_fill_1
XFILLER_2_808 VDD VSS sg13g2_decap_4
XFILLER_2_828 VDD VSS sg13g2_decap_4
XFILLER_2_832 VDD VSS sg13g2_fill_2
XFILLER_3_0 VDD VSS sg13g2_fill_1
XFILLER_3_106 VDD VSS sg13g2_decap_4
XFILLER_3_110 VDD VSS sg13g2_fill_1
XFILLER_3_188 VDD VSS sg13g2_decap_4
XFILLER_3_235 VDD VSS sg13g2_fill_2
XFILLER_3_237 VDD VSS sg13g2_fill_1
XFILLER_3_247 VDD VSS sg13g2_fill_1
XFILLER_3_267 VDD VSS sg13g2_decap_4
XFILLER_3_271 VDD VSS sg13g2_fill_1
XFILLER_3_28 VDD VSS sg13g2_fill_2
XFILLER_3_316 VDD VSS sg13g2_fill_1
XFILLER_3_370 VDD VSS sg13g2_decap_4
XFILLER_3_419 VDD VSS sg13g2_decap_8
XFILLER_3_426 VDD VSS sg13g2_fill_1
XFILLER_3_454 VDD VSS sg13g2_fill_2
XFILLER_3_487 VDD VSS sg13g2_fill_2
XFILLER_3_521 VDD VSS sg13g2_decap_8
XFILLER_3_528 VDD VSS sg13g2_decap_8
XFILLER_3_535 VDD VSS sg13g2_fill_2
XFILLER_3_54 VDD VSS sg13g2_decap_8
XFILLER_3_547 VDD VSS sg13g2_fill_1
XFILLER_3_561 VDD VSS sg13g2_fill_1
XFILLER_3_590 VDD VSS sg13g2_fill_1
XFILLER_3_61 VDD VSS sg13g2_decap_8
XFILLER_3_624 VDD VSS sg13g2_fill_2
XFILLER_3_626 VDD VSS sg13g2_fill_1
XFILLER_3_637 VDD VSS sg13g2_fill_2
XFILLER_3_68 VDD VSS sg13g2_decap_4
XFILLER_3_695 VDD VSS sg13g2_decap_4
XFILLER_3_699 VDD VSS sg13g2_fill_2
XFILLER_3_716 VDD VSS sg13g2_decap_8
XFILLER_3_72 VDD VSS sg13g2_fill_1
XFILLER_3_723 VDD VSS sg13g2_fill_2
XFILLER_3_725 VDD VSS sg13g2_fill_1
XFILLER_3_741 VDD VSS sg13g2_decap_4
XFILLER_3_784 VDD VSS sg13g2_decap_4
XFILLER_3_803 VDD VSS sg13g2_decap_4
XFILLER_3_813 VDD VSS sg13g2_decap_4
XFILLER_3_817 VDD VSS sg13g2_fill_1
XFILLER_3_828 VDD VSS sg13g2_decap_8
XFILLER_3_835 VDD VSS sg13g2_fill_2
XFILLER_3_852 VDD VSS sg13g2_fill_2
XFILLER_3_882 VDD VSS sg13g2_decap_8
XFILLER_3_889 VDD VSS sg13g2_fill_1
XFILLER_4_0 VDD VSS sg13g2_fill_2
XFILLER_4_126 VDD VSS sg13g2_fill_2
XFILLER_4_128 VDD VSS sg13g2_fill_1
XFILLER_4_143 VDD VSS sg13g2_fill_2
XFILLER_4_145 VDD VSS sg13g2_fill_1
XFILLER_4_151 VDD VSS sg13g2_fill_2
XFILLER_4_153 VDD VSS sg13g2_fill_1
XFILLER_4_213 VDD VSS sg13g2_decap_8
XFILLER_4_220 VDD VSS sg13g2_fill_2
XFILLER_4_222 VDD VSS sg13g2_fill_1
XFILLER_4_283 VDD VSS sg13g2_decap_4
XFILLER_4_298 VDD VSS sg13g2_fill_1
XFILLER_4_336 VDD VSS sg13g2_fill_1
XFILLER_4_347 VDD VSS sg13g2_decap_8
XFILLER_4_354 VDD VSS sg13g2_fill_2
XFILLER_4_356 VDD VSS sg13g2_fill_1
XFILLER_4_401 VDD VSS sg13g2_fill_2
XFILLER_4_435 VDD VSS sg13g2_fill_2
XFILLER_4_450 VDD VSS sg13g2_decap_8
XFILLER_4_500 VDD VSS sg13g2_decap_8
XFILLER_4_507 VDD VSS sg13g2_decap_4
XFILLER_4_511 VDD VSS sg13g2_fill_2
XFILLER_4_540 VDD VSS sg13g2_fill_2
XFILLER_4_55 VDD VSS sg13g2_fill_2
XFILLER_4_57 VDD VSS sg13g2_fill_1
XFILLER_4_573 VDD VSS sg13g2_fill_2
XFILLER_4_584 VDD VSS sg13g2_fill_1
XFILLER_4_592 VDD VSS sg13g2_decap_4
XFILLER_4_596 VDD VSS sg13g2_fill_1
XFILLER_4_606 VDD VSS sg13g2_fill_1
XFILLER_4_635 VDD VSS sg13g2_decap_8
XFILLER_4_642 VDD VSS sg13g2_fill_2
XFILLER_4_648 VDD VSS sg13g2_fill_1
XFILLER_4_659 VDD VSS sg13g2_decap_8
XFILLER_4_666 VDD VSS sg13g2_decap_8
XFILLER_4_673 VDD VSS sg13g2_decap_4
XFILLER_4_770 VDD VSS sg13g2_fill_2
XFILLER_4_828 VDD VSS sg13g2_fill_2
XFILLER_4_85 VDD VSS sg13g2_fill_2
XFILLER_4_858 VDD VSS sg13g2_fill_1
XFILLER_4_867 VDD VSS sg13g2_decap_4
XFILLER_4_871 VDD VSS sg13g2_fill_1
XFILLER_4_92 VDD VSS sg13g2_fill_2
XFILLER_4_97 VDD VSS sg13g2_fill_1
X_160_ _063_ done_q VDD VSS sg13g2_inv_1
X_161_ _064_ net46 VDD VSS sg13g2_inv_1
X_162_ _065_ net47 VDD VSS sg13g2_inv_1
X_163_ _066_ net30 VDD VSS sg13g2_inv_1
X_164_ _067_ net11 VDD VSS sg13g2_inv_1
X_165_ _068_ net9 VDD VSS sg13g2_inv_1
X_166_ _057_ sel1 net57 VDD VSS sg13g2_or2_1
X_167_ hs net4 net1 VDD VSS sg13g2_or2_1
X_168_ _054_ net57 _056_ VDD VSS sg13g2_and2_1
X_169_ _069_ net36 net4 net1 VDD VSS sg13g2_nor3_1
X_170_ _070_ _063_ hs net36 VDD VSS sg13g2_a21o_1
X_171_ trka0 _056_ _070_ VDD VSS sg13g2_nor2_1
X_172_ trka1 _070_ sel1 VDD VSS sg13g2_nor2b_1
X_173_ _071_ step_2 net45 VDD VSS sg13g2_nand2_1
X_174_ _072_ net46 net47 VDD VSS sg13g2_nand2b_1
X_175_ _073_ _071_ _072_ net40 VDD VSS sg13g2_o21ai_1
X_176_ wq_d net48 _073_ VDD VSS sg13g2_nand2b_1
X_177_ fv0_d fv0 _066_ net48 VDD VSS sg13g2_a21o_1
X_178_ _074_ net2 net52 VDD VSS sg13g2_or2_1
X_179_ net14 net5 hsd _074_ VDD VSS sg13g2_nand3_1
X_180_ clka net51 VDD VSS sg13g2_inv_2
X_181_ net13 fv0 net51 VDD VSS sg13g2_nor2_1
X_182_ clknab net51 fv0 VDD VSS sg13g2_or2_2
X_183_ _075_ net48 net30 VDD VSS sg13g2_nor2_1
X_184_ _076_ net48 lna adc_raw_a_13 _075_ VDD VSS sg13g2_a22oi_1
X_185_ _026_ _076_ VDD VSS sg13g2_inv_1
X_186_ _077_ step_2 net40 VDD VSS sg13g2_nand2b_1
X_187_ _078_ net45 _072_ _077_ VDD VSS sg13g2_nor3_1
X_188_ _079_ net29 adc_raw_a_12 VDD VSS sg13g2_nor2b_1
X_189_ _031_ _079_ net11 _078_ VDD VSS sg13g2_mux2_1
X_190_ _080_ _064_ net47 net45 _077_ VDD VSS sg13g2_nor4_1
X_191_ _081_ net29 adc_raw_a_11 VDD VSS sg13g2_nor2b_1
X_192_ _032_ _081_ net11 _080_ VDD VSS sg13g2_mux2_1
X_193_ _082_ _064_ _065_ net45 _077_ VDD VSS sg13g2_nor4_1
X_194_ _083_ net29 adc_raw_a_10 VDD VSS sg13g2_nor2b_1
X_195_ _033_ _083_ net12 _082_ VDD VSS sg13g2_mux2_1
X_196_ _084_ net47 net40 VDD VSS sg13g2_nand2b_1
X_197_ _085_ net45 step_2 VDD VSS sg13g2_nand2b_1
X_198_ _086_ net46 _084_ _085_ VDD VSS sg13g2_nor3_1
X_199_ _087_ net29 adc_raw_a_9 VDD VSS sg13g2_nor2b_1
X_200_ _034_ _087_ net12 _086_ VDD VSS sg13g2_mux2_1
X_201_ _088_ net46 net47 net40 VDD VSS sg13g2_nand3b_1
X_202_ _089_ _085_ _088_ VDD VSS sg13g2_or2_1
X_203_ _090_ net29 adc_raw_a_8 VDD VSS sg13g2_nor2b_1
X_204_ _035_ net12 _090_ _089_ VDD VSS sg13g2_mux2_1
X_205_ _091_ net47 net46 net40 VDD VSS sg13g2_nand3b_1
X_206_ _092_ _085_ _091_ VDD VSS sg13g2_nor2_1
X_207_ _093_ net34 adc_raw_a_7 VDD VSS sg13g2_nor2b_1
X_208_ _036_ _093_ net12 _092_ VDD VSS sg13g2_mux2_1
X_209_ _094_ net39 net46 net47 VDD VSS sg13g2_and3_1
X_210_ _095_ net40 net46 step_0 step_2 VDD VSS sg13g2_nand4_1
X_211_ _096_ step_3 _095_ VDD VSS sg13g2_or2_1
X_212_ _097_ net45 net12 _095_ VDD VSS sg13g2_nor3_1
X_213_ _098_ _066_ adc_raw_a_6 VDD VSS sg13g2_nand2_1
X_214_ _037_ _096_ _098_ _097_ VDD VSS sg13g2_a21oi_1
X_215_ _099_ step_2 net45 VDD VSS sg13g2_nand2b_1
X_216_ _100_ step_1 _084_ _099_ VDD VSS sg13g2_nor3_1
X_217_ _101_ net28 adc_raw_a_5 VDD VSS sg13g2_nor2b_1
X_218_ _038_ _101_ net12 net64 VDD VSS sg13g2_mux2_1
X_219_ _102_ _088_ _099_ VDD VSS sg13g2_or2_1
X_220_ _103_ net28 adc_raw_a_4 VDD VSS sg13g2_nor2b_1
X_221_ _039_ net11 _103_ _102_ VDD VSS sg13g2_mux2_1
X_222_ _104_ _091_ _099_ VDD VSS sg13g2_nor2_1
X_223_ _105_ net28 adc_raw_a_3 VDD VSS sg13g2_nor2b_1
X_224_ _027_ _105_ net11 _104_ VDD VSS sg13g2_mux2_1
X_225_ _106_ step_2 net45 _094_ VDD VSS sg13g2_nand3b_1
X_226_ _107_ net27 adc_raw_a_2 VDD VSS sg13g2_nor2b_1
X_227_ _028_ net11 _107_ _106_ VDD VSS sg13g2_mux2_1
X_228_ _108_ step_1 _071_ _084_ VDD VSS sg13g2_nor3_1
X_229_ _109_ net27 adc_raw_a_1 VDD VSS sg13g2_nor2b_1
X_230_ _029_ _109_ net11 net63 VDD VSS sg13g2_mux2_1
X_231_ _110_ _071_ _088_ VDD VSS sg13g2_nor2_1
X_232_ _111_ net27 adc_raw_a_0 VDD VSS sg13g2_nor2b_1
X_233_ _030_ _111_ net11 _110_ VDD VSS sg13g2_mux2_1
X_234_ _112_ net48 lnb adc_raw_b_13 _075_ VDD VSS sg13g2_a22oi_1
X_235_ _040_ _112_ VDD VSS sg13g2_inv_1
X_236_ _113_ net31 adc_raw_b_12 VDD VSS sg13g2_nor2b_1
X_237_ _045_ _113_ net9 net66 VDD VSS sg13g2_mux2_1
X_238_ _114_ net31 adc_raw_b_11 VDD VSS sg13g2_nor2b_1
X_239_ _046_ _114_ net10 net16 VDD VSS sg13g2_mux2_1
X_240_ _115_ net31 adc_raw_b_10 VDD VSS sg13g2_nor2b_1
X_241_ _047_ _115_ net10 net15 VDD VSS sg13g2_mux2_1
X_242_ _116_ net31 adc_raw_b_9 VDD VSS sg13g2_nor2b_1
X_243_ _048_ _116_ net10 net65 VDD VSS sg13g2_mux2_1
X_244_ _117_ net31 adc_raw_b_8 VDD VSS sg13g2_nor2b_1
X_245_ _049_ net10 _117_ _089_ VDD VSS sg13g2_mux2_1
X_246_ _118_ net32 adc_raw_b_7 VDD VSS sg13g2_nor2b_1
X_247_ _050_ _118_ net10 _092_ VDD VSS sg13g2_mux2_1
X_248_ _119_ step_3 net9 _095_ VDD VSS sg13g2_nor3_1
X_249_ _120_ _066_ adc_raw_b_6 VDD VSS sg13g2_nand2_1
X_250_ _051_ _096_ _120_ _119_ VDD VSS sg13g2_a21oi_1
X_251_ _121_ net32 adc_raw_b_5 VDD VSS sg13g2_nor2b_1
X_252_ _052_ _121_ net10 _100_ VDD VSS sg13g2_mux2_1
X_253_ _122_ net32 adc_raw_b_4 VDD VSS sg13g2_nor2b_1
X_254_ _053_ net9 _122_ _102_ VDD VSS sg13g2_mux2_1
X_255_ _123_ net30 adc_raw_b_3 VDD VSS sg13g2_nor2b_1
X_256_ _041_ _123_ net9 _104_ VDD VSS sg13g2_mux2_1
X_257_ _124_ net30 adc_raw_b_2 VDD VSS sg13g2_nor2b_1
X_258_ _042_ net9 _124_ _106_ VDD VSS sg13g2_mux2_1
X_259_ _125_ net30 adc_raw_b_1 VDD VSS sg13g2_nor2b_1
X_260_ _043_ _125_ net9 _108_ VDD VSS sg13g2_mux2_1
X_261_ _126_ net30 adc_raw_b_0 VDD VSS sg13g2_nor2b_1
X_262_ _044_ _126_ net9 _110_ VDD VSS sg13g2_mux2_1
X_263_ _127_ _066_ fna_0 net49 VDD VSS sg13g2_a21oi_1
X_264_ _000_ net49 lna _127_ VDD VSS sg13g2_a21oi_1
X_265_ _128_ net28 net54 VDD VSS sg13g2_nor2b_1
X_266_ _004_ _128_ net8 _078_ VDD VSS sg13g2_mux2_1
X_267_ _129_ net28 fna_2 VDD VSS sg13g2_nor2b_1
X_268_ _005_ _129_ net8 _080_ VDD VSS sg13g2_mux2_1
X_269_ _130_ net29 fna_3 VDD VSS sg13g2_nor2b_1
X_270_ _006_ _130_ net8 _082_ VDD VSS sg13g2_mux2_1
X_271_ _131_ net29 net55 VDD VSS sg13g2_nor2b_1
X_272_ _007_ _131_ _067_ _086_ VDD VSS sg13g2_mux2_1
X_273_ _132_ net27 fna_5 VDD VSS sg13g2_nor2b_1
X_274_ _008_ _067_ _132_ _089_ VDD VSS sg13g2_mux2_1
X_275_ _133_ net28 fna_6 VDD VSS sg13g2_nor2b_1
X_276_ _009_ _133_ _067_ _092_ VDD VSS sg13g2_mux2_1
X_277_ _134_ net34 fna_7 VDD VSS sg13g2_nor2b_1
X_278_ _010_ _096_ _134_ _097_ VDD VSS sg13g2_a21o_1
X_279_ _135_ net28 fna_8 VDD VSS sg13g2_nor2b_1
X_280_ _011_ _135_ net8 net64 VDD VSS sg13g2_mux2_1
X_281_ _136_ net27 fna_9 VDD VSS sg13g2_nor2b_1
X_282_ _012_ net8 _136_ _102_ VDD VSS sg13g2_mux2_1
X_283_ _137_ net27 fna_10 VDD VSS sg13g2_nor2b_1
X_284_ _001_ _137_ net8 _104_ VDD VSS sg13g2_mux2_1
X_285_ _138_ net27 fna_11 VDD VSS sg13g2_nor2b_1
X_286_ _002_ net8 _138_ _106_ VDD VSS sg13g2_mux2_1
X_287_ _139_ net27 net53 VDD VSS sg13g2_nor2b_1
X_288_ _003_ _139_ net8 net63 VDD VSS sg13g2_mux2_1
X_289_ _140_ _066_ fnb_0 net48 VDD VSS sg13g2_a21oi_1
X_290_ _013_ net48 lnb _140_ VDD VSS sg13g2_a21oi_1
X_291_ _141_ net31 fnb_1 VDD VSS sg13g2_nor2b_1
X_292_ _017_ _141_ net7 net66 VDD VSS sg13g2_mux2_1
X_293_ _142_ net33 fnb_2 VDD VSS sg13g2_nor2b_1
X_294_ _018_ _142_ net7 net16 VDD VSS sg13g2_mux2_1
X_295_ _143_ net32 fnb_3 VDD VSS sg13g2_nor2b_1
X_296_ _019_ _143_ _068_ net15 VDD VSS sg13g2_mux2_1
X_297_ _144_ net31 fnb_4 VDD VSS sg13g2_nor2b_1
X_298_ _020_ _144_ _068_ net65 VDD VSS sg13g2_mux2_1
X_299_ _145_ net31 fnb_5 VDD VSS sg13g2_nor2b_1
X_300_ _021_ _068_ _145_ _089_ VDD VSS sg13g2_mux2_1
X_301_ _146_ net32 fnb_6 VDD VSS sg13g2_nor2b_1
X_302_ _022_ _146_ net7 _092_ VDD VSS sg13g2_mux2_1
X_303_ _147_ net30 fnb_7 VDD VSS sg13g2_nor2b_1
X_304_ _023_ _096_ _147_ _119_ VDD VSS sg13g2_a21o_1
X_305_ _148_ net32 fnb_8 VDD VSS sg13g2_nor2b_1
X_306_ _024_ _148_ net7 _100_ VDD VSS sg13g2_mux2_1
X_307_ _149_ net32 fnb_9 VDD VSS sg13g2_nor2b_1
X_308_ _025_ net7 _149_ _102_ VDD VSS sg13g2_mux2_1
X_309_ _150_ net30 fnb_10 VDD VSS sg13g2_nor2b_1
X_310_ _014_ _150_ net7 _104_ VDD VSS sg13g2_mux2_1
X_311_ _151_ net33 fnb_11 VDD VSS sg13g2_nor2b_1
X_312_ _015_ net7 _151_ _106_ VDD VSS sg13g2_mux2_1
X_313_ _152_ net33 fnb_12 VDD VSS sg13g2_nor2b_1
X_314_ _016_ _152_ net7 _108_ VDD VSS sg13g2_mux2_1
X_315_ cpa_12 adc_raw_a_13 wq VDD VSS sg13g2_and2_2
X_316_ cna_12 fna_0 wq VDD VSS sg13g2_and2_2
X_317_ cpb_12 adc_raw_b_13 wq VDD VSS sg13g2_and2_2
X_318_ cnb_12 wq fnb_0 VDD VSS sg13g2_and2_2
X_319_ cpa_11 adc_raw_a_12 net37 VDD VSS sg13g2_and2_2
X_320_ cna_11 net38 fna_1 VDD VSS sg13g2_and2_2
X_321_ cpb_11 adc_raw_b_12 net41 VDD VSS sg13g2_and2_2
X_322_ cnb_11 net41 fnb_1 VDD VSS sg13g2_and2_2
X_323_ cpa_10 adc_raw_a_11 net37 VDD VSS sg13g2_and2_2
X_324_ cna_10 net35 fna_2 VDD VSS sg13g2_and2_2
X_325_ cpb_10 adc_raw_b_11 net41 VDD VSS sg13g2_and2_2
X_326_ cnb_10 net41 fnb_2 VDD VSS sg13g2_and2_2
X_327_ cpa_9 adc_raw_a_10 net39 VDD VSS sg13g2_and2_2
X_328_ cna_9 net35 fna_3 VDD VSS sg13g2_and2_2
X_329_ cpb_9 net43 adc_raw_b_10 VDD VSS sg13g2_and2_2
X_330_ cnb_9 net43 fnb_3 VDD VSS sg13g2_and2_2
X_331_ cpa_8 adc_raw_a_9 net39 VDD VSS sg13g2_and2_2
X_332_ cna_8 net35 fna_4 VDD VSS sg13g2_and2_2
X_333_ cpb_8 adc_raw_b_9 net42 VDD VSS sg13g2_and2_2
X_334_ cnb_8 net41 fnb_4 VDD VSS sg13g2_and2_2
X_335_ cpa_7 adc_raw_a_8 net37 VDD VSS sg13g2_and2_2
X_336_ cna_7 net36 fna_5 VDD VSS sg13g2_and2_2
X_337_ cpb_7 adc_raw_b_8 net41 VDD VSS sg13g2_and2_2
X_338_ cnb_7 net42 fnb_5 VDD VSS sg13g2_and2_2
X_339_ cpa_6 adc_raw_a_7 net37 VDD VSS sg13g2_and2_2
X_340_ cna_6 net35 fna_6 VDD VSS sg13g2_and2_2
X_341_ cpb_6 adc_raw_b_7 net42 VDD VSS sg13g2_and2_2
X_342_ cnb_6 net43 fnb_6 VDD VSS sg13g2_and2_2
X_343_ cpa_5 adc_raw_a_6 net37 VDD VSS sg13g2_and2_2
X_344_ cna_5 net35 fna_7 VDD VSS sg13g2_and2_2
X_345_ cpb_5 adc_raw_b_6 net42 VDD VSS sg13g2_and2_2
X_346_ cnb_5 net44 fnb_7 VDD VSS sg13g2_and2_2
X_347_ cpa_4 adc_raw_a_5 net37 VDD VSS sg13g2_and2_2
X_348_ cna_4 net35 fna_8 VDD VSS sg13g2_and2_2
X_349_ cpb_4 adc_raw_b_5 net42 VDD VSS sg13g2_and2_2
X_350_ cnb_4 net43 fnb_8 VDD VSS sg13g2_and2_2
X_351_ cpa_3 adc_raw_a_4 net37 VDD VSS sg13g2_and2_2
X_352_ cna_3 net35 fna_9 VDD VSS sg13g2_and2_2
X_353_ cpb_3 adc_raw_b_4 net42 VDD VSS sg13g2_and2_2
X_354_ cnb_3 net43 fnb_9 VDD VSS sg13g2_and2_2
X_355_ cpa_2 adc_raw_a_3 net37 VDD VSS sg13g2_and2_2
X_356_ cna_2 net35 fna_10 VDD VSS sg13g2_and2_2
X_357_ cpb_2 adc_raw_b_3 net42 VDD VSS sg13g2_and2_2
X_358_ cnb_2 net43 fnb_10 VDD VSS sg13g2_and2_2
X_359_ cpa_1 adc_raw_a_2 net38 VDD VSS sg13g2_and2_2
X_360_ cna_1 net36 fna_11 VDD VSS sg13g2_and2_2
X_361_ cpb_1 adc_raw_b_2 net41 VDD VSS sg13g2_and2_2
X_362_ cnb_1 net43 fnb_11 VDD VSS sg13g2_and2_2
X_363_ cpa_0 adc_raw_a_1 net38 VDD VSS sg13g2_and2_2
X_364_ cna_0 net36 fna_12 VDD VSS sg13g2_and2_2
X_365_ cpb_0 adc_raw_b_1 net41 VDD VSS sg13g2_and2_2
X_366_ cnb_0 net44 fnb_12 VDD VSS sg13g2_and2_2
X_367_ _055_ net49 _071_ _088_ VDD VSS sg13g2_nor3_1
X_368_ _153_ net48 _084_ VDD VSS sg13g2_nor2b_1
X_369_ _058_ net40 _065_ _153_ VDD VSS sg13g2_o21ai_1
X_370_ _154_ net40 net47 net46 VDD VSS sg13g2_a21oi_1
X_371_ _059_ net49 _094_ _154_ VDD VSS sg13g2_nor3_1
X_372_ _155_ step_2 _094_ VDD VSS sg13g2_xnor2_1
X_373_ _060_ net49 _155_ VDD VSS sg13g2_nor2_1
X_374_ _156_ step_3 _095_ VDD VSS sg13g2_nand2_1
X_375_ _061_ _096_ _156_ net49 VDD VSS sg13g2_a21oi_1
X_376_ _157_ _071_ _088_ _063_ VDD VSS sg13g2_o21ai_1
X_377_ _158_ net2 _069_ VDD VSS sg13g2_nor2_1
X_378_ _062_ _157_ net59 VDD VSS sg13g2_and2_1
X_379_ step_0 clknet_4_7__leaf_clk _058_ net23 VDD VSS sg13g2_dfrbpq_1
X_380_ step_1 clknet_4_7__leaf_clk _059_ net19 VDD VSS sg13g2_dfrbpq_1
X_381_ step_2 clknet_4_5__leaf_clk _060_ net20 VDD VSS sg13g2_dfrbpq_1
X_382_ step_3 clknet_4_9__leaf_clk _061_ net23 VDD VSS sg13g2_dfrbpq_1
X_383_ done_q clknet_4_3__leaf_clk _062_ net17 VDD VSS sg13g2_dfrbpq_1
X_384_ adc_raw_a_13 clknet_4_13__leaf_clk _026_ net23 VDD VSS sg13g2_dfrbpq_2
X_385_ adc_raw_a_12 clknet_4_4__leaf_clk _031_ net19 VDD VSS sg13g2_dfrbpq_2
X_386_ adc_raw_a_11 clknet_4_7__leaf_clk _032_ net20 VDD VSS sg13g2_dfrbpq_2
X_387_ adc_raw_a_10 clknet_4_4__leaf_clk _033_ net20 VDD VSS sg13g2_dfrbpq_2
X_388_ adc_raw_a_9 clknet_4_4__leaf_clk _034_ net19 VDD VSS sg13g2_dfrbpq_2
X_389_ adc_raw_a_8 clknet_4_6__leaf_clk _035_ net19 VDD VSS sg13g2_dfrbpq_2
X_390_ adc_raw_a_7 clknet_4_6__leaf_clk _036_ net19 VDD VSS sg13g2_dfrbpq_2
X_391_ adc_raw_a_6 clknet_4_5__leaf_clk _037_ net20 VDD VSS sg13g2_dfrbpq_2
X_392_ adc_raw_a_5 clknet_4_6__leaf_clk _038_ net19 VDD VSS sg13g2_dfrbpq_2
X_393_ adc_raw_a_4 clknet_4_2__leaf_clk _039_ net18 VDD VSS sg13g2_dfrbpq_2
X_394_ adc_raw_a_3 clknet_4_2__leaf_clk _027_ net18 VDD VSS sg13g2_dfrbpq_2
X_395_ adc_raw_a_2 clknet_4_2__leaf_clk _028_ net18 VDD VSS sg13g2_dfrbpq_2
X_396_ adc_raw_a_1 clknet_4_3__leaf_clk _029_ net17 VDD VSS sg13g2_dfrbpq_2
X_397_ adc_raw_a_0 clknet_4_3__leaf_clk _030_ net17 VDD VSS sg13g2_dfrbpq_1
X_398_ adc_raw_b_13 clknet_4_13__leaf_clk _040_ net22 VDD VSS sg13g2_dfrbpq_2
X_399_ adc_raw_b_12 clknet_4_11__leaf_clk _045_ net24 VDD VSS sg13g2_dfrbpq_2
X_400_ adc_raw_b_11 clknet_4_14__leaf_clk _046_ net24 VDD VSS sg13g2_dfrbpq_2
X_401_ adc_raw_b_10 clknet_4_14__leaf_clk _047_ net24 VDD VSS sg13g2_dfrbpq_2
X_402_ adc_raw_b_9 clknet_4_14__leaf_clk _048_ net24 VDD VSS sg13g2_dfrbpq_2
X_403_ adc_raw_b_8 clknet_4_15__leaf_clk _049_ net24 VDD VSS sg13g2_dfrbpq_2
X_404_ adc_raw_b_7 clknet_4_15__leaf_clk _050_ net25 VDD VSS sg13g2_dfrbpq_2
X_405_ adc_raw_b_6 clknet_4_8__leaf_clk _051_ net22 VDD VSS sg13g2_dfrbpq_2
X_406_ adc_raw_b_5 clknet_4_15__leaf_clk _052_ net25 VDD VSS sg13g2_dfrbpq_2
X_407_ adc_raw_b_4 clknet_4_15__leaf_clk _053_ net25 VDD VSS sg13g2_dfrbpq_2
X_408_ adc_raw_b_3 clknet_4_12__leaf_clk _041_ net25 VDD VSS sg13g2_dfrbpq_2
X_409_ adc_raw_b_2 clknet_4_12__leaf_clk _042_ net22 VDD VSS sg13g2_dfrbpq_2
X_410_ adc_raw_b_1 clknet_4_12__leaf_clk _043_ net22 VDD VSS sg13g2_dfrbpq_2
X_411_ adc_raw_b_0 clknet_4_13__leaf_clk _044_ net23 VDD VSS sg13g2_dfrbpq_1
X_412_ fna_0 clknet_4_5__leaf_clk _000_ net20 VDD VSS sg13g2_dfrbpq_1
X_413_ fna_1 clknet_4_4__leaf_clk _004_ net19 VDD VSS sg13g2_dfrbpq_1
X_414_ fna_2 clknet_4_4__leaf_clk _005_ net19 VDD VSS sg13g2_dfrbpq_1
X_415_ fna_3 clknet_4_0__leaf_clk _006_ net18 VDD VSS sg13g2_dfrbpq_1
X_416_ fna_4 clknet_4_0__leaf_clk _007_ net18 VDD VSS sg13g2_dfrbpq_1
X_417_ fna_5 clknet_4_2__leaf_clk _008_ net21 VDD VSS sg13g2_dfrbpq_1
X_418_ fna_6 clknet_4_0__leaf_clk _009_ net21 VDD VSS sg13g2_dfrbpq_1
X_419_ fna_7 clknet_4_6__leaf_clk _010_ net20 VDD VSS sg13g2_dfrbpq_2
X_420_ fna_8 clknet_4_3__leaf_clk _011_ net17 VDD VSS sg13g2_dfrbpq_1
X_421_ fna_9 clknet_4_0__leaf_clk _012_ net18 VDD VSS sg13g2_dfrbpq_1
X_422_ fna_10 clknet_4_0__leaf_clk _001_ net18 VDD VSS sg13g2_dfrbpq_1
X_423_ fna_11 clknet_4_1__leaf_clk _002_ net17 VDD VSS sg13g2_dfrbpq_1
X_424_ fna_12 clknet_4_1__leaf_clk _003_ net17 VDD VSS sg13g2_dfrbpq_1
X_425_ fnb_0 clknet_4_9__leaf_clk _013_ net22 VDD VSS sg13g2_dfrbpq_1
X_426_ fnb_1 clknet_4_10__leaf_clk _017_ net24 VDD VSS sg13g2_dfrbpq_1
X_427_ fnb_2 clknet_4_10__leaf_clk _018_ net26 VDD VSS sg13g2_dfrbpq_1
X_428_ fnb_3 clknet_4_10__leaf_clk _019_ net24 VDD VSS sg13g2_dfrbpq_1
X_429_ fnb_4 clknet_4_11__leaf_clk _020_ net24 VDD VSS sg13g2_dfrbpq_1
X_430_ fnb_5 clknet_4_11__leaf_clk _021_ net25 VDD VSS sg13g2_dfrbpq_1
X_431_ fnb_6 clknet_4_10__leaf_clk _022_ net25 VDD VSS sg13g2_dfrbpq_1
X_432_ fnb_7 clknet_4_8__leaf_clk _023_ net22 VDD VSS sg13g2_dfrbpq_1
X_433_ fnb_8 clknet_4_8__leaf_clk _024_ net25 VDD VSS sg13g2_dfrbpq_1
X_434_ fnb_9 clknet_4_12__leaf_clk _025_ net25 VDD VSS sg13g2_dfrbpq_1
X_435_ fnb_10 clknet_4_12__leaf_clk _014_ net22 VDD VSS sg13g2_dfrbpq_1
X_436_ fnb_11 clknet_4_8__leaf_clk _015_ net22 VDD VSS sg13g2_dfrbpq_1
X_437_ fnb_12 clknet_4_8__leaf_clk _016_ net26 VDD VSS sg13g2_dfrbpq_1
X_438_ _056_ clknet_4_1__leaf_clk _057_ net17 VDD VSS sg13g2_dfrbpq_1
X_439_ sel1 clknet_4_1__leaf_clk _054_ net17 VDD VSS sg13g2_dfrbpq_1
X_440_ busy clknet_4_9__leaf_clk wq_d net23 VDD VSS sg13g2_dfrbpq_1
X_441_ net60 clknet_4_7__leaf_clk _055_ net20 VDD VSS sg13g2_dfrbpq_1
X_442_ vd clknet_4_13__leaf_clk net61 net23 VDD VSS sg13g2_dfrbpq_1
X_443_ rs_0 clknet_4_11__leaf_clk net net6 VDD VSS sg13g2_dfrbpq_1
X_443__50 net VDD VSS sg13g2_tiehi
X_444_ rs_1 clknet_4_14__leaf_clk net62 net6 VDD VSS sg13g2_dfrbpq_1
X_446_ adc_valid_b adc_valid_a VDD VSS sg13g2_buf_1
X_447_ clkb clka VDD VSS sg13g2_buf_2
X_448_ clkbb net51 VDD VSS sg13g2_buf_1
X_449_ clknb net13 VDD VSS sg13g2_buf_2
X_450_ clknbb clknab VDD VSS sg13g2_buf_2
X_451_ trkb0 trka0 VDD VSS sg13g2_buf_1
X_452_ trkb1 trka1 VDD VSS sg13g2_buf_1
Xclkbuf_0_clk clknet_0_clk clk VDD VSS sg13g2_buf_2
Xclkbuf_3_0_0_clk clknet_3_0_0_clk clknet_0_clk VDD VSS sg13g2_buf_4
Xclkbuf_3_1_0_clk clknet_3_1_0_clk clknet_0_clk VDD VSS sg13g2_buf_4
Xclkbuf_3_2_0_clk clknet_3_2_0_clk clknet_0_clk VDD VSS sg13g2_buf_4
Xclkbuf_3_3_0_clk clknet_3_3_0_clk clknet_0_clk VDD VSS sg13g2_buf_4
Xclkbuf_3_4_0_clk clknet_3_4_0_clk clknet_0_clk VDD VSS sg13g2_buf_4
Xclkbuf_3_5_0_clk clknet_3_5_0_clk clknet_0_clk VDD VSS sg13g2_buf_4
Xclkbuf_3_6_0_clk clknet_3_6_0_clk clknet_0_clk VDD VSS sg13g2_buf_4
Xclkbuf_3_7_0_clk clknet_3_7_0_clk clknet_0_clk VDD VSS sg13g2_buf_4
Xclkbuf_4_0__f_clk clknet_4_0__leaf_clk clknet_3_0_0_clk VDD VSS sg13g2_buf_2
Xclkbuf_4_10__f_clk clknet_4_10__leaf_clk clknet_3_5_0_clk VDD VSS sg13g2_buf_2
Xclkbuf_4_11__f_clk clknet_4_11__leaf_clk clknet_3_5_0_clk VDD VSS sg13g2_buf_2
Xclkbuf_4_12__f_clk clknet_4_12__leaf_clk clknet_3_6_0_clk VDD VSS sg13g2_buf_2
Xclkbuf_4_13__f_clk clknet_4_13__leaf_clk clknet_3_6_0_clk VDD VSS sg13g2_buf_2
Xclkbuf_4_14__f_clk clknet_4_14__leaf_clk clknet_3_7_0_clk VDD VSS sg13g2_buf_2
Xclkbuf_4_15__f_clk clknet_4_15__leaf_clk clknet_3_7_0_clk VDD VSS sg13g2_buf_2
Xclkbuf_4_1__f_clk clknet_4_1__leaf_clk clknet_3_0_0_clk VDD VSS sg13g2_buf_2
Xclkbuf_4_2__f_clk clknet_4_2__leaf_clk clknet_3_1_0_clk VDD VSS sg13g2_buf_2
Xclkbuf_4_3__f_clk clknet_4_3__leaf_clk clknet_3_1_0_clk VDD VSS sg13g2_buf_2
Xclkbuf_4_4__f_clk clknet_4_4__leaf_clk clknet_3_2_0_clk VDD VSS sg13g2_buf_2
Xclkbuf_4_5__f_clk clknet_4_5__leaf_clk clknet_3_2_0_clk VDD VSS sg13g2_buf_2
Xclkbuf_4_6__f_clk clknet_4_6__leaf_clk clknet_3_3_0_clk VDD VSS sg13g2_buf_2
Xclkbuf_4_7__f_clk clknet_4_7__leaf_clk clknet_3_3_0_clk VDD VSS sg13g2_buf_2
Xclkbuf_4_8__f_clk clknet_4_8__leaf_clk clknet_3_4_0_clk VDD VSS sg13g2_buf_2
Xclkbuf_4_9__f_clk clknet_4_9__leaf_clk clknet_3_4_0_clk VDD VSS sg13g2_buf_2
Xclkload0 nc_clkload0_Y clknet_4_1__leaf_clk VDD VSS sg13g2_inv_1
Xclkload1 nc_clkload1_Y clknet_4_5__leaf_clk VDD VSS sg13g2_inv_1
Xclkload2 nc_clkload2_Y clknet_4_9__leaf_clk VDD VSS sg13g2_inv_1
Xclkload3 nc_clkload3_Y clknet_4_13__leaf_clk VDD VSS sg13g2_inv_1
Xfanout10 net10 lpb VDD VSS sg13g2_buf_1
Xfanout11 net11 lpa VDD VSS sg13g2_buf_1
Xfanout12 net12 lpa VDD VSS sg13g2_buf_1
Xfanout17 net17 net18 VDD VSS sg13g2_buf_1
Xfanout18 net18 net21 VDD VSS sg13g2_buf_1
Xfanout19 net19 net21 VDD VSS sg13g2_buf_1
Xfanout20 net20 net21 VDD VSS sg13g2_buf_1
Xfanout21 net21 rs_1 VDD VSS sg13g2_buf_1
Xfanout22 net22 net26 VDD VSS sg13g2_buf_1
Xfanout23 net23 net26 VDD VSS sg13g2_buf_1
Xfanout24 net24 net26 VDD VSS sg13g2_buf_1
Xfanout25 net25 net26 VDD VSS sg13g2_buf_1
Xfanout26 net26 rs_1 VDD VSS sg13g2_buf_1
Xfanout27 net27 net28 VDD VSS sg13g2_buf_1
Xfanout28 net28 net29 VDD VSS sg13g2_buf_1
Xfanout29 net29 net34 VDD VSS sg13g2_buf_1
Xfanout30 net30 net33 VDD VSS sg13g2_buf_1
Xfanout31 net31 net32 VDD VSS sg13g2_buf_1
Xfanout32 net32 net33 VDD VSS sg13g2_buf_1
Xfanout33 net33 net34 VDD VSS sg13g2_buf_1
Xfanout34 net34 vd VDD VSS sg13g2_buf_1
Xfanout35 net35 net36 VDD VSS sg13g2_buf_1
Xfanout36 net36 busy VDD VSS sg13g2_buf_1
Xfanout37 net37 net38 VDD VSS sg13g2_buf_1
Xfanout38 net38 net39 VDD VSS sg13g2_buf_1
Xfanout39 net39 busy VDD VSS sg13g2_buf_1
Xfanout40 net40 net44 VDD VSS sg13g2_buf_1
Xfanout41 net41 net42 VDD VSS sg13g2_buf_1
Xfanout42 net42 net43 VDD VSS sg13g2_buf_1
Xfanout43 net43 net44 VDD VSS sg13g2_buf_1
Xfanout44 net44 busy VDD VSS sg13g2_buf_1
Xfanout45 net45 step_3 VDD VSS sg13g2_buf_1
Xfanout46 net46 step_1 VDD VSS sg13g2_buf_1
Xfanout47 net47 step_0 VDD VSS sg13g2_buf_1
Xfanout48 net48 net49 VDD VSS sg13g2_buf_1
Xfanout49 net49 net2 VDD VSS sg13g2_buf_1
Xfanout7 net7 _068_ VDD VSS sg13g2_buf_1
Xfanout8 net8 _067_ VDD VSS sg13g2_buf_1
Xfanout9 net9 lpb VDD VSS sg13g2_buf_1
Xhold57 net56 cur_trk VDD VSS sg13g2_dlygate4sd3_1
Xhold58 net57 net3 VDD VSS sg13g2_dlygate4sd3_1
Xhold59 net58 adc_start VDD VSS sg13g2_dlygate4sd3_1
Xhold60 net59 _158_ VDD VSS sg13g2_dlygate4sd3_1
Xhold61 adc_valid_a net60 VDD VSS sg13g2_dlygate4sd3_1
Xhold62 net61 net60 VDD VSS sg13g2_dlygate4sd3_1
Xhold63 net62 rs_0 VDD VSS sg13g2_dlygate4sd3_1
Xinput1 net1 adc_hold VDD VSS sg13g2_buf_1
Xinput2 net2 net58 VDD VSS sg13g2_buf_1
Xinput3 net3 net56 VDD VSS sg13g2_buf_1
Xinput4 net4 is_smp VDD VSS sg13g2_buf_1
Xinput5 net5 mclk VDD VSS sg13g2_buf_1
Xinput6 net6 por_n VDD VSS sg13g2_buf_1
Xmax_cap15 net15 _082_ VDD VSS sg13g2_buf_2
Xmax_cap16 net16 _080_ VDD VSS sg13g2_buf_2
Xmax_cap64 net63 _108_ VDD VSS sg13g2_buf_4
Xmax_cap65 net64 _100_ VDD VSS sg13g2_buf_4
Xmax_cap66 net65 _086_ VDD VSS sg13g2_buf_4
Xmax_cap67 net66 _078_ VDD VSS sg13g2_buf_4
Xrebuffer51 net50 net51 VDD VSS sg13g2_buf_1
Xrebuffer52 net51 net14 VDD VSS sg13g2_buf_2
Xrebuffer53 net52 wq VDD VSS sg13g2_buf_1
Xrebuffer54 net53 fna_12 VDD VSS sg13g2_buf_1
Xrebuffer55 net54 fna_1 VDD VSS sg13g2_buf_1
Xrebuffer56 net55 fna_4 VDD VSS sg13g2_buf_1
Xu_dly_hs1 hsd1 hs VDD VSS sg13g2_dlygate4sd3_1
Xu_dly_hs2 hsd hsd1 VDD VSS sg13g2_dlygate4sd3_1
Xu_fv0 fv0 clknet_4_9__leaf_clk fv0_d net23 VDD VSS sg13g2_dfrbpq_2
Xu_lat_na lna oanp net13 VDD VSS sg13g2_dlhq_1
Xu_lat_nb lnb obnp net13 VDD VSS sg13g2_dlhq_1
Xu_lat_pa lpa oap clka VDD VSS sg13g2_dlhq_1
Xu_lat_pb lpb obp clka VDD VSS sg13g2_dlhq_1
Xu_ld_oan nc_oan oan VDD VSS sg13g2_buf_1
Xu_ld_oann nc_oann oann VDD VSS sg13g2_buf_1
Xu_ld_obn nc_obn obn VDD VSS sg13g2_buf_1
Xu_ld_obnn nc_obnn obnn VDD VSS sg13g2_buf_1
Xu_ld_sel nc_sel adc_sel VDD VSS sg13g2_buf_1
Xu_wq wq clknet_4_5__leaf_clk wq_d net23 VDD VSS sg13g2_dfrbpq_2
Xwire13 clkna net13 VDD VSS sg13g2_buf_8
Xwire14 clkab net50 VDD VSS sg13g2_buf_8
* SPEF lumped wire C (total per net, coupling included, to VSS); wire R not modelled
Cspef0 adc_hold VSS 0.000967648p
Cspef1 adc_raw_a_0 VSS 0.00204686p
Cspef2 adc_raw_a_10 VSS 0.0142379p
Cspef3 adc_raw_a_11 VSS 0.0228807p
Cspef4 adc_raw_a_12 VSS 0.025811p
Cspef5 adc_raw_a_13 VSS 0.0419682p
Cspef6 adc_raw_a_1 VSS 0.0201718p
Cspef7 adc_raw_a_2 VSS 0.0177752p
Cspef8 adc_raw_a_3 VSS 0.0159601p
Cspef9 adc_raw_a_4 VSS 0.0117561p
Cspef10 adc_raw_a_5 VSS 0.00666672p
Cspef11 adc_raw_a_6 VSS 0.0199014p
Cspef12 adc_raw_a_7 VSS 0.0051597p
Cspef13 adc_raw_a_8 VSS 0.00898027p
Cspef14 adc_raw_a_9 VSS 0.00994527p
Cspef15 adc_raw_b_0 VSS 0.00318886p
Cspef16 adc_raw_b_10 VSS 0.00441256p
Cspef17 adc_raw_b_11 VSS 0.0067999p
Cspef18 adc_raw_b_12 VSS 0.00845585p
Cspef19 adc_raw_b_13 VSS 0.037399p
Cspef20 adc_raw_b_1 VSS 0.0210739p
Cspef21 adc_raw_b_2 VSS 0.0216752p
Cspef22 adc_raw_b_3 VSS 0.0169113p
Cspef23 adc_raw_b_4 VSS 0.00868903p
Cspef24 adc_raw_b_5 VSS 0.00730767p
Cspef25 adc_raw_b_6 VSS 0.0261815p
Cspef26 adc_raw_b_7 VSS 0.00554858p
Cspef27 adc_raw_b_8 VSS 0.00317422p
Cspef28 adc_raw_b_9 VSS 0.00638282p
Cspef29 adc_sel VSS 0.000811014p
Cspef30 adc_start VSS 0.000908155p
Cspef31 adc_valid_a VSS 0.0627453p
Cspef32 adc_valid_b VSS 0.00102364p
Cspef33 clk VSS 0.0305647p
Cspef34 clka VSS 0.0660513p
Cspef35 clkab VSS 0.00109473p
Cspef36 clkb VSS 0.00244808p
Cspef37 clkbb VSS 0.00133134p
Cspef38 clkna VSS 0.00163978p
Cspef39 clknab VSS 0.00959425p
Cspef40 clknb VSS 0.00260147p
Cspef41 clknbb VSS 0.0404219p
Cspef42 cna_0 VSS 0.00581895p
Cspef43 cna_10 VSS 0.000814951p
Cspef44 cna_11 VSS 0.0014276p
Cspef45 cna_12 VSS 0.0173065p
Cspef46 cna_1 VSS 0.00397714p
Cspef47 cna_2 VSS 0.00149962p
Cspef48 cna_3 VSS 0.00159513p
Cspef49 cna_4 VSS 0.00228013p
Cspef50 cna_5 VSS 0.00278577p
Cspef51 cna_6 VSS 0.0014539p
Cspef52 cna_7 VSS 0.00153664p
Cspef53 cna_8 VSS 0.000726577p
Cspef54 cna_9 VSS 0.00227774p
Cspef55 cnb_0 VSS 0.00218637p
Cspef56 cnb_10 VSS 0.0129766p
Cspef57 cnb_11 VSS 0.021005p
Cspef58 cnb_12 VSS 0.000850293p
Cspef59 cnb_1 VSS 0.00568735p
Cspef60 cnb_2 VSS 0.00596792p
Cspef61 cnb_3 VSS 0.00794814p
Cspef62 cnb_4 VSS 0.00871158p
Cspef63 cnb_5 VSS 0.000823666p
Cspef64 cnb_6 VSS 0.0114623p
Cspef65 cnb_7 VSS 0.00852332p
Cspef66 cnb_8 VSS 0.0156478p
Cspef67 cnb_9 VSS 0.0168917p
Cspef68 cpa_0 VSS 0.00325048p
Cspef69 cpa_10 VSS 0.00617382p
Cspef70 cpa_11 VSS 0.00712656p
Cspef71 cpa_12 VSS 0.000744023p
Cspef72 cpa_1 VSS 0.00301536p
Cspef73 cpa_2 VSS 0.00309682p
Cspef74 cpa_3 VSS 0.00367286p
Cspef75 cpa_4 VSS 0.00226746p
Cspef76 cpa_5 VSS 0.00146814p
Cspef77 cpa_6 VSS 0.00219893p
Cspef78 cpa_7 VSS 0.00252464p
Cspef79 cpa_8 VSS 0.00977963p
Cspef80 cpa_9 VSS 0.00717127p
Cspef81 cpb_0 VSS 0.00123507p
Cspef82 cpb_10 VSS 0.0162545p
Cspef83 cpb_11 VSS 0.0153597p
Cspef84 cpb_12 VSS 0.000579823p
Cspef85 cpb_1 VSS 0.00111674p
Cspef86 cpb_2 VSS 0.00128468p
Cspef87 cpb_3 VSS 0.00377819p
Cspef88 cpb_4 VSS 0.000944149p
Cspef89 cpb_5 VSS 0.000830289p
Cspef90 cpb_6 VSS 0.00365214p
Cspef91 cpb_7 VSS 0.00743539p
Cspef92 cpb_8 VSS 0.0101048p
Cspef93 cpb_9 VSS 0.0145557p
Cspef94 cur_trk VSS 0.00126381p
Cspef95 is_smp VSS 0.000785345p
Cspef96 mclk VSS 0.0015577p
Cspef97 oan VSS 0.00306576p
Cspef98 oann VSS 0.00131702p
Cspef99 oanp VSS 0.0269265p
Cspef100 oap VSS 0.000842827p
Cspef101 obn VSS 0.0018491p
Cspef102 obnn VSS 0.00142598p
Cspef103 obnp VSS 0.00154952p
Cspef104 obp VSS 0.00122591p
Cspef105 por_n VSS 0.00119069p
Cspef106 trka0 VSS 0.0535057p
Cspef107 trka1 VSS 0.0568243p
Cspef108 trkb0 VSS 0.00173256p
Cspef109 trkb1 VSS 0.00384083p
Cspef110 _000_ VSS 0.00312387p
Cspef111 _001_ VSS 0.00284319p
Cspef112 _002_ VSS 0.00283983p
Cspef113 _003_ VSS 0.00372019p
Cspef114 _004_ VSS 0.00021358p
Cspef115 _005_ VSS 0.000696109p
Cspef116 _006_ VSS 0.000279939p
Cspef117 _007_ VSS 0.0028495p
Cspef118 _008_ VSS 0.00376399p
Cspef119 _009_ VSS 0.00382363p
Cspef120 _010_ VSS 0.00398274p
Cspef121 _011_ VSS 0.00351372p
Cspef122 _012_ VSS 0.00329886p
Cspef123 _013_ VSS 0.000550099p
Cspef124 _014_ VSS 0.00127624p
Cspef125 _015_ VSS 0.000331838p
Cspef126 _016_ VSS 0.00171394p
Cspef127 _017_ VSS 0.00241748p
Cspef128 _018_ VSS 0.00128368p
Cspef129 _019_ VSS 0.000544334p
Cspef130 _020_ VSS 0.000286429p
Cspef131 _021_ VSS 0.000281261p
Cspef132 _022_ VSS 0.000208913p
Cspef133 _023_ VSS 0.000486421p
Cspef134 _024_ VSS 0.00117155p
Cspef135 _025_ VSS 0.00105965p
Cspef136 _026_ VSS 0.000703396p
Cspef137 _027_ VSS 0.000208603p
Cspef138 _028_ VSS 0.0013329p
Cspef139 _029_ VSS 0.00079837p
Cspef140 _030_ VSS 0.00294197p
Cspef141 _031_ VSS 0.000253188p
Cspef142 _032_ VSS 0.00150231p
Cspef143 _033_ VSS 0.000295363p
Cspef144 _034_ VSS 0.000656317p
Cspef145 _035_ VSS 0.00138536p
Cspef146 _036_ VSS 0.000360867p
Cspef147 _037_ VSS 0.00104042p
Cspef148 _038_ VSS 0.000914716p
Cspef149 _039_ VSS 0.00108206p
Cspef150 _040_ VSS 0.00115335p
Cspef151 _041_ VSS 0.00108035p
Cspef152 _042_ VSS 0.000334488p
Cspef153 _043_ VSS 0.000703541p
Cspef154 _044_ VSS 0.000778195p
Cspef155 _045_ VSS 0.000749035p
Cspef156 _046_ VSS 0.000346348p
Cspef157 _047_ VSS 0.000640198p
Cspef158 _048_ VSS 0.000853737p
Cspef159 _049_ VSS 0.000837746p
Cspef160 _050_ VSS 0.00130717p
Cspef161 _051_ VSS 0.000533866p
Cspef162 _052_ VSS 0.00167427p
Cspef163 _053_ VSS 0.00130047p
Cspef164 _054_ VSS 0.000340941p
Cspef165 _055_ VSS 0.00144357p
Cspef166 _056_ VSS 0.0035282p
Cspef167 _057_ VSS 0.000537038p
Cspef168 _058_ VSS 0.00102012p
Cspef169 _059_ VSS 0.00062348p
Cspef170 _060_ VSS 0.00234893p
Cspef171 _061_ VSS 0.000240003p
Cspef172 _062_ VSS 0.000498626p
Cspef173 _063_ VSS 0.000585546p
Cspef174 _064_ VSS 0.00180264p
Cspef175 _065_ VSS 0.00303437p
Cspef176 _066_ VSS 0.0331219p
Cspef177 _067_ VSS 0.0169848p
Cspef178 _068_ VSS 0.0114876p
Cspef179 _069_ VSS 0.000259184p
Cspef180 _070_ VSS 0.00280467p
Cspef181 _071_ VSS 0.0594148p
Cspef182 _072_ VSS 0.00259115p
Cspef183 _073_ VSS 0.00375069p
Cspef184 _074_ VSS 0.000875705p
Cspef185 _075_ VSS 0.00784166p
Cspef186 _076_ VSS 0.000929104p
Cspef187 _077_ VSS 0.0045053p
Cspef188 _078_ VSS 0.0338263p
Cspef189 _079_ VSS 0.000458001p
Cspef190 _080_ VSS 0.0321017p
Cspef191 _081_ VSS 0.00118162p
Cspef192 _082_ VSS 0.0377253p
Cspef193 _083_ VSS 0.0018304p
Cspef194 _084_ VSS 0.00498261p
Cspef195 _085_ VSS 0.00388136p
Cspef196 _086_ VSS 0.0335478p
Cspef197 _087_ VSS 0.000434027p
Cspef198 _088_ VSS 0.0521688p
Cspef199 _089_ VSS 0.0742503p
Cspef200 _090_ VSS 0.00143865p
Cspef201 _091_ VSS 0.00203686p
Cspef202 _092_ VSS 0.0662117p
Cspef203 _093_ VSS 0.000809052p
Cspef204 _094_ VSS 0.00393694p
Cspef205 _095_ VSS 0.0217254p
Cspef206 _096_ VSS 0.025454p
Cspef207 _097_ VSS 0.0023971p
Cspef208 _098_ VSS 0.000339162p
Cspef209 _099_ VSS 0.00535482p
Cspef210 _100_ VSS 0.0300583p
Cspef211 _101_ VSS 0.00108966p
Cspef212 _102_ VSS 0.062005p
Cspef213 _103_ VSS 0.00180541p
Cspef214 _104_ VSS 0.0664555p
Cspef215 _105_ VSS 0.000379952p
Cspef216 _106_ VSS 0.0640776p
Cspef217 _107_ VSS 0.00143006p
Cspef218 _108_ VSS 0.0165333p
Cspef219 _109_ VSS 0.00109357p
Cspef220 _110_ VSS 0.0512444p
Cspef221 _111_ VSS 0.000463789p
Cspef222 _112_ VSS 0.000461188p
Cspef223 _113_ VSS 0.00283939p
Cspef224 _114_ VSS 0.000523864p
Cspef225 _115_ VSS 0.000656717p
Cspef226 _116_ VSS 0.00093642p
Cspef227 _117_ VSS 0.00169493p
Cspef228 _118_ VSS 0.0016843p
Cspef229 _119_ VSS 0.00433155p
Cspef230 _120_ VSS 0.00219906p
Cspef231 _121_ VSS 0.000998944p
Cspef232 _122_ VSS 0.00164875p
Cspef233 _123_ VSS 0.00114044p
Cspef234 _124_ VSS 0.000681813p
Cspef235 _125_ VSS 0.000392849p
Cspef236 _126_ VSS 0.00103473p
Cspef237 _127_ VSS 0.00284609p
Cspef238 _128_ VSS 0.000561672p
Cspef239 _129_ VSS 0.00128651p
Cspef240 _130_ VSS 0.000919958p
Cspef241 _131_ VSS 0.00114569p
Cspef242 _132_ VSS 0.00379001p
Cspef243 _133_ VSS 0.00127257p
Cspef244 _134_ VSS 0.00231123p
Cspef245 _135_ VSS 0.0012213p
Cspef246 _136_ VSS 0.00155264p
Cspef247 _137_ VSS 0.000438155p
Cspef248 _138_ VSS 0.00333373p
Cspef249 _139_ VSS 0.00108863p
Cspef250 _140_ VSS 0.000818067p
Cspef251 _141_ VSS 0.00120487p
Cspef252 _142_ VSS 0.00108758p
Cspef253 _143_ VSS 0.00243154p
Cspef254 _144_ VSS 0.000832449p
Cspef255 _145_ VSS 0.000433526p
Cspef256 _146_ VSS 0.000574896p
Cspef257 _147_ VSS 0.00343857p
Cspef258 _148_ VSS 0.00135814p
Cspef259 _149_ VSS 0.00314884p
Cspef260 _150_ VSS 0.00122236p
Cspef261 _151_ VSS 0.000718857p
Cspef262 _152_ VSS 0.00122592p
Cspef263 _153_ VSS 0.000674329p
Cspef264 _154_ VSS 0.000235478p
Cspef265 _155_ VSS 0.00191759p
Cspef266 _156_ VSS 0.000781018p
Cspef267 _157_ VSS 0.00151124p
Cspef268 _158_ VSS 0.000549466p
Cspef269 busy VSS 0.0431401p
Cspef270 clknet_0_clk VSS 0.0472536p
Cspef271 clknet_3_0_0_clk VSS 0.00767651p
Cspef272 clknet_3_1_0_clk VSS 0.0106078p
Cspef273 clknet_3_2_0_clk VSS 0.0124865p
Cspef274 clknet_3_3_0_clk VSS 0.00808091p
Cspef275 clknet_3_4_0_clk VSS 0.00989289p
Cspef276 clknet_3_5_0_clk VSS 0.00605255p
Cspef277 clknet_3_6_0_clk VSS 0.0085534p
Cspef278 clknet_3_7_0_clk VSS 0.00799546p
Cspef279 clknet_4_0__leaf_clk VSS 0.0135552p
Cspef280 clknet_4_10__leaf_clk VSS 0.0147353p
Cspef281 clknet_4_11__leaf_clk VSS 0.0109111p
Cspef282 clknet_4_12__leaf_clk VSS 0.0109936p
Cspef283 clknet_4_13__leaf_clk VSS 0.0080877p
Cspef284 clknet_4_14__leaf_clk VSS 0.00829297p
Cspef285 clknet_4_15__leaf_clk VSS 0.0100108p
Cspef286 clknet_4_1__leaf_clk VSS 0.00883872p
Cspef287 clknet_4_2__leaf_clk VSS 0.00879647p
Cspef288 clknet_4_3__leaf_clk VSS 0.00839659p
Cspef289 clknet_4_4__leaf_clk VSS 0.0148707p
Cspef290 clknet_4_5__leaf_clk VSS 0.0184385p
Cspef291 clknet_4_6__leaf_clk VSS 0.0139516p
Cspef292 clknet_4_7__leaf_clk VSS 0.0144657p
Cspef293 clknet_4_8__leaf_clk VSS 0.0173022p
Cspef294 clknet_4_9__leaf_clk VSS 0.0105823p
Cspef295 done_q VSS 0.000434315p
Cspef296 fna_0 VSS 0.00398876p
Cspef297 fna_10 VSS 0.00252451p
Cspef298 fna_11 VSS 0.0040551p
Cspef299 fna_12 VSS 0.00364606p
Cspef300 fna_1 VSS 0.00736742p
Cspef301 fna_2 VSS 0.0107447p
Cspef302 fna_3 VSS 0.00799895p
Cspef303 fna_4 VSS 0.00391586p
Cspef304 fna_5 VSS 0.00518908p
Cspef305 fna_6 VSS 0.00288834p
Cspef306 fna_7 VSS 0.0278337p
Cspef307 fna_8 VSS 0.00283335p
Cspef308 fna_9 VSS 0.00086485p
Cspef309 fnb_0 VSS 0.0104133p
Cspef310 fnb_10 VSS 0.00677483p
Cspef311 fnb_11 VSS 0.00393769p
Cspef312 fnb_12 VSS 0.0070405p
Cspef313 fnb_1 VSS 0.00478962p
Cspef314 fnb_2 VSS 0.00913887p
Cspef315 fnb_3 VSS 0.00454541p
Cspef316 fnb_4 VSS 0.00293892p
Cspef317 fnb_5 VSS 0.00468272p
Cspef318 fnb_6 VSS 0.00499457p
Cspef319 fnb_7 VSS 0.000974815p
Cspef320 fnb_8 VSS 0.00445824p
Cspef321 fnb_9 VSS 0.00528073p
Cspef322 fv0 VSS 0.00261743p
Cspef323 fv0_d VSS 0.000623573p
Cspef324 hs VSS 0.00265653p
Cspef325 hsd VSS 0.00103845p
Cspef326 hsd1 VSS 0.000439815p
Cspef327 lna VSS 0.0248858p
Cspef328 lnb VSS 0.00116396p
Cspef329 lpa VSS 0.0158665p
Cspef330 lpb VSS 0.0147423p
Cspef331 net VSS 0.00113883p
Cspef332 net1 VSS 0.00118682p
Cspef333 net10 VSS 0.015549p
Cspef334 net11 VSS 0.042253p
Cspef335 net12 VSS 0.0201762p
Cspef336 net13 VSS 0.0512751p
Cspef337 net14 VSS 0.000614079p
Cspef338 net15 VSS 0.0374024p
Cspef339 net16 VSS 0.0443944p
Cspef340 net17 VSS 0.0149458p
Cspef341 net18 VSS 0.0216133p
Cspef342 net19 VSS 0.0247834p
Cspef343 net2 VSS 0.0418124p
Cspef344 net20 VSS 0.0148576p
Cspef345 net21 VSS 0.0389573p
Cspef346 net22 VSS 0.0174256p
Cspef347 net23 VSS 0.0132896p
Cspef348 net24 VSS 0.0173475p
Cspef349 net25 VSS 0.0210794p
Cspef350 net26 VSS 0.0401245p
Cspef351 net27 VSS 0.018884p
Cspef352 net28 VSS 0.0180016p
Cspef353 net29 VSS 0.0307522p
Cspef354 net3 VSS 0.00156394p
Cspef355 net30 VSS 0.0208542p
Cspef356 net31 VSS 0.0188074p
Cspef357 net32 VSS 0.0203725p
Cspef358 net33 VSS 0.0340255p
Cspef359 net34 VSS 0.0364406p
Cspef360 net35 VSS 0.0140366p
Cspef361 net36 VSS 0.022089p
Cspef362 net37 VSS 0.0093176p
Cspef363 net38 VSS 0.0149518p
Cspef364 net39 VSS 0.0166931p
Cspef365 net4 VSS 0.00136722p
Cspef366 net40 VSS 0.0149822p
Cspef367 net41 VSS 0.0157516p
Cspef368 net42 VSS 0.0100097p
Cspef369 net43 VSS 0.027074p
Cspef370 net44 VSS 0.0182973p
Cspef371 net45 VSS 0.0144413p
Cspef372 net46 VSS 0.00973159p
Cspef373 net47 VSS 0.0144178p
Cspef374 net48 VSS 0.0165889p
Cspef375 net49 VSS 0.0271879p
Cspef376 net5 VSS 0.000831357p
Cspef377 net50 VSS 0.00256039p
Cspef378 net51 VSS 0.0575457p
Cspef379 net52 VSS 0.0166823p
Cspef380 net53 VSS 0.00353816p
Cspef381 net54 VSS 0.00059875p
Cspef382 net55 VSS 0.00136789p
Cspef383 net56 VSS 0.000453175p
Cspef384 net57 VSS 0.00214726p
Cspef385 net58 VSS 0.00167413p
Cspef386 net59 VSS 0.000409728p
Cspef387 net6 VSS 0.00149163p
Cspef388 net60 VSS 0.0203957p
Cspef389 net61 VSS 0.0216584p
Cspef390 net62 VSS 0.00151389p
Cspef391 net63 VSS 0.0533812p
Cspef392 net64 VSS 0.0372455p
Cspef393 net65 VSS 0.0402775p
Cspef394 net66 VSS 0.0425384p
Cspef395 net7 VSS 0.0296001p
Cspef396 net8 VSS 0.0219478p
Cspef397 net9 VSS 0.0392047p
Cspef398 rs_0 VSS 0.00059943p
Cspef399 rs_1 VSS 0.0452108p
Cspef400 sel1 VSS 0.00290027p
Cspef401 step_0 VSS 0.00521326p
Cspef402 step_1 VSS 0.00382447p
Cspef403 step_2 VSS 0.00833758p
Cspef404 step_3 VSS 0.0103486p
Cspef405 vd VSS 0.00538153p
Cspef406 wq VSS 0.0587401p
Cspef407 wq_d VSS 0.000946128p
.ends r1_adc_sar_gl
