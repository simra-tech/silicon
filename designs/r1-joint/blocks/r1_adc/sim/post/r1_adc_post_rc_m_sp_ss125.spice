* r1_adc_post_rc_m_sp_ss125.spice: r1_adc_post_rc_m.spice with ideal slice references from op run post-op-ss125-rc3 (sim/post/make_sp_netlist.py)
* merged by sim/post/merge_parallel.py from pex/r1_adc_post_rc.spice (sha256 dab1c57ab9ae0af4): 668 -> 285 device instances (identical parallel devices as m = count)
* r1_adc post-layout netlist, layout A (RC), written by pex/pex_build.py; see its docstring
* devices: LVS reference of layout/r1_adc_netlist.py; R: KLayout RNetExtractor Metal1-5/Via1-4; C: kpex 0.3.12 2.5D CC
* requires cornerMOSlv/hv.lib, cornerCAP.lib, cornerRES.lib
.subckt r1_adc_slice_post in0p in0n in1p in1n trk0 trk1 cp0 cp1 cp2 cp3 cp4 cp5 cp6 cp7 cp8 cp9 cp10 cp11 cp12 cn0 cn1 cn2 cn3 cn4 cn5 cn6 cn7 cn8 cn9 cn10 cn11 cn12 clk clkb clkn clknb op on onp onn vbp vbn vref vrefl vrefl__p19 top_p top_n vdd vdd__p36 vdd__p37 vdd__p38 gnd gnd__p59 gnd__p60 gnd__p61
Xxpt0a t0b__p7 trk0__p1 vdd__p12 vdd sg13_lv_pmos w=2u l=0.13u ng=1 m=1
Xxnt0a t0b__p4 trk0 gnd__p36 gnd sg13_lv_nmos w=1u l=0.13u ng=1 m=1
Xxpt0b t0__p5 t0b__p8 vdd__p13 vdd sg13_lv_pmos w=4u l=0.13u ng=1 m=1
Xxnt0b t0__p4 t0b__p5 gnd__p37 gnd sg13_lv_nmos w=2u l=0.13u ng=1 m=1
Xxpt1a t1b__p7 trk1__p1 vdd__p14 vdd sg13_lv_pmos w=2u l=0.13u ng=1 m=1
Xxnt1a t1b__p4 trk1 gnd__p38 gnd sg13_lv_nmos w=1u l=0.13u ng=1 m=1
Xxpt1b t1__p5 t1b__p8 vdd__p15 vdd sg13_lv_pmos w=4u l=0.13u ng=1 m=1
Xxnt1b t1__p4 t1b__p5 gnd__p39 gnd sg13_lv_nmos w=2u l=0.13u ng=1 m=1
Xxs0p_xms in0p__p0 xs0p_g top_p__p2 gnd sg13_lv_nmos w=6u l=0.13u ng=2 m=1
Xxs0p_cboot xs0p_cbp__p2 xs0p_cbn__p4 cap_cmim w=11.49u l=11.49u m=1
Xxs0p_xm1 xs0p_cbn__p1 t0b__p2 gnd__p30 gnd sg13_lv_nmos w=1u l=0.13u ng=1 m=1
Xxs0p_xm3 xs0p_cbp xs0p_g__p4 vdd__p4 xs0p_cbp sg13_lv_pmos w=1u l=0.13u ng=1 m=1
Xxs0p_xm8 xs0p_g__p5 xs0p_x__p2 xs0p_cbp__p1 xs0p_cbp sg13_lv_pmos w=2u l=0.13u ng=1 m=1
Xxs0p_xm4 xs0p_x__p3 t0__p3 vdd__p5 vdd sg13_lv_pmos w=0.5u l=0.13u ng=1 m=1
Xxs0p_xm5 xs0p_x t0__p2 xs0p_cbn__p2 gnd sg13_lv_nmos w=1u l=0.13u ng=1 m=1
Xxs0p_xm7 xs0p_x__p1 xs0p_g__p2 xs0p_cbn__p3 gnd sg13_lv_nmos w=0.5u l=0.13u ng=1 m=1
Xxs0p_xm9 xs0p_cbn xs0p_g__p1 in0p__p1 gnd sg13_lv_nmos w=2u l=0.13u ng=1 m=1
Xxs0p_xm10 xs0p_g__p3 vdd__p3 xs0p_n10 gnd sg13_lv_nmos w=2u l=0.13u ng=1 m=1
Xxs0p_xm11 xs0p_n10__p1 t0b__p3 gnd__p31 gnd sg13_lv_nmos w=2u l=0.13u ng=1 m=1
Xxs0n_xms in0n__p0 xs0n_g top_n__p2 gnd sg13_lv_nmos w=6u l=0.13u ng=2 m=1
Xxs0n_cboot xs0n_cbp__p2 xs0n_cbn__p4 cap_cmim w=11.49u l=11.49u m=1
Xxs0n_xm1 xs0n_cbn__p1 t0b gnd__p28 gnd sg13_lv_nmos w=1u l=0.13u ng=1 m=1
Xxs0n_xm3 xs0n_cbp xs0n_g__p4 vdd__p1 xs0n_cbp sg13_lv_pmos w=1u l=0.13u ng=1 m=1
Xxs0n_xm8 xs0n_g__p5 xs0n_x__p2 xs0n_cbp__p1 xs0n_cbp sg13_lv_pmos w=2u l=0.13u ng=1 m=1
Xxs0n_xm4 xs0n_x__p3 t0__p1 vdd__p2 vdd sg13_lv_pmos w=0.5u l=0.13u ng=1 m=1
Xxs0n_xm5 xs0n_x t0 xs0n_cbn__p2 gnd sg13_lv_nmos w=1u l=0.13u ng=1 m=1
Xxs0n_xm7 xs0n_x__p1 xs0n_g__p2 xs0n_cbn__p3 gnd sg13_lv_nmos w=0.5u l=0.13u ng=1 m=1
Xxs0n_xm9 xs0n_cbn xs0n_g__p1 in0n__p1 gnd sg13_lv_nmos w=2u l=0.13u ng=1 m=1
Xxs0n_xm10 xs0n_g__p3 vdd__p0 xs0n_n10 gnd sg13_lv_nmos w=2u l=0.13u ng=1 m=1
Xxs0n_xm11 xs0n_n10__p1 t0b__p1 gnd__p29 gnd sg13_lv_nmos w=2u l=0.13u ng=1 m=1
Xxs1p_xms in1p__p0 xs1p_g top_p__p3 gnd sg13_lv_nmos w=6u l=0.13u ng=2 m=1
Xxs1p_cboot xs1p_cbp__p2 xs1p_cbn__p4 cap_cmim w=11.49u l=11.49u m=1
Xxs1p_xm1 xs1p_cbn__p1 t1b__p2 gnd__p34 gnd sg13_lv_nmos w=1u l=0.13u ng=1 m=1
Xxs1p_xm3 xs1p_cbp xs1p_g__p4 vdd__p10 xs1p_cbp sg13_lv_pmos w=1u l=0.13u ng=1 m=1
Xxs1p_xm8 xs1p_g__p5 xs1p_x__p2 xs1p_cbp__p1 xs1p_cbp sg13_lv_pmos w=2u l=0.13u ng=1 m=1
Xxs1p_xm4 xs1p_x__p3 t1__p3 vdd__p11 vdd sg13_lv_pmos w=0.5u l=0.13u ng=1 m=1
Xxs1p_xm5 xs1p_x t1__p2 xs1p_cbn__p2 gnd sg13_lv_nmos w=1u l=0.13u ng=1 m=1
Xxs1p_xm7 xs1p_x__p1 xs1p_g__p2 xs1p_cbn__p3 gnd sg13_lv_nmos w=0.5u l=0.13u ng=1 m=1
Xxs1p_xm9 xs1p_cbn xs1p_g__p1 in1p__p1 gnd sg13_lv_nmos w=2u l=0.13u ng=1 m=1
Xxs1p_xm10 xs1p_g__p3 vdd__p9 xs1p_n10 gnd sg13_lv_nmos w=2u l=0.13u ng=1 m=1
Xxs1p_xm11 xs1p_n10__p1 t1b__p3 gnd__p35 gnd sg13_lv_nmos w=2u l=0.13u ng=1 m=1
Xxs1n_xms in1n__p0 xs1n_g top_n__p3 gnd sg13_lv_nmos w=6u l=0.13u ng=2 m=1
Xxs1n_cboot xs1n_cbp__p2 xs1n_cbn__p4 cap_cmim w=11.49u l=11.49u m=1
Xxs1n_xm1 xs1n_cbn__p1 t1b gnd__p32 gnd sg13_lv_nmos w=1u l=0.13u ng=1 m=1
Xxs1n_xm3 xs1n_cbp xs1n_g__p4 vdd__p7 xs1n_cbp sg13_lv_pmos w=1u l=0.13u ng=1 m=1
Xxs1n_xm8 xs1n_g__p5 xs1n_x__p2 xs1n_cbp__p1 xs1n_cbp sg13_lv_pmos w=2u l=0.13u ng=1 m=1
Xxs1n_xm4 xs1n_x__p3 t1__p1 vdd__p8 vdd sg13_lv_pmos w=0.5u l=0.13u ng=1 m=1
Xxs1n_xm5 xs1n_x t1 xs1n_cbn__p2 gnd sg13_lv_nmos w=1u l=0.13u ng=1 m=1
Xxs1n_xm7 xs1n_x__p1 xs1n_g__p2 xs1n_cbn__p3 gnd sg13_lv_nmos w=0.5u l=0.13u ng=1 m=1
Xxs1n_xm9 xs1n_cbn xs1n_g__p1 in1n__p1 gnd sg13_lv_nmos w=2u l=0.13u ng=1 m=1
Xxs1n_xm10 xs1n_g__p3 vdd__p6 xs1n_n10 gnd sg13_lv_nmos w=2u l=0.13u ng=1 m=1
Xxs1n_xm11 xs1n_n10__p1 t1b__p1 gnd__p33 gnd sg13_lv_nmos w=2u l=0.13u ng=1 m=1
Xxpr1 rstb_n__p2 t0b__p9 vdd__p16 vdd sg13_lv_pmos w=1u l=0.13u ng=1 m=1
Xxpr2 rstb_n__p3 t1b__p9 vdd__p17 vdd sg13_lv_pmos w=1u l=0.13u ng=1 m=1
Xxnr1 rstb_n t0b__p6 nr gnd sg13_lv_nmos w=1u l=0.13u ng=1 m=1
Xxnr2 nr__p1 t1b__p6 gnd__p40 gnd sg13_lv_nmos w=1u l=0.13u ng=1 m=1
Xxpr3 rstb__p3 rstb_n__p4 vdd__p18 vdd sg13_lv_pmos w=1u l=0.13u ng=1 m=1
Xxnr3 rstb__p2 rstb_n__p1 gnd__p41 gnd sg13_lv_nmos w=0.5u l=0.13u ng=1 m=1
Xxlrp lsb_p rstb__p1 vrefl__p9 vrefl sg13_lv_pmos w=1u l=0.13u ng=1 m=1
Xxlrn lsb_n rstb vrefl__p8 vrefl sg13_lv_pmos w=1u l=0.13u ng=1 m=1
Xxdp12_xmp bp12 cp12 vref__p5 vref sg13_lv_pmos w=2u l=0.13u ng=1 m=1
Xxdp12_xmn bp12__p1 cp12__p1 gnd__p13 gnd sg13_lv_nmos w=1u l=0.13u ng=1 m=1
Xxdp11_xmp bp11 cp11 vref__p6 vref sg13_lv_pmos w=2u l=0.13u ng=1 m=1
Xxdp11_xmn bp11__p1 cp11__p1 gnd__p14 gnd sg13_lv_nmos w=1u l=0.13u ng=1 m=1
Xxdp10_xmp bp10 cp10 vref__p7 vref sg13_lv_pmos w=2u l=0.13u ng=1 m=1
Xxdp10_xmn bp10__p1 cp10__p1 gnd__p15 gnd sg13_lv_nmos w=1u l=0.13u ng=1 m=1
Xxdp9_xmp bp9 cp9 vref__p8 vref sg13_lv_pmos w=1u l=0.13u ng=1 m=1
Xxdp9_xmn bp9__p1 cp9__p1 gnd__p16 gnd sg13_lv_nmos w=0.5u l=0.13u ng=1 m=1
Xxdp8_xmp bp8 cp8 vref__p9 vref sg13_lv_pmos w=1u l=0.13u ng=1 m=1
Xxdp8_xmn bp8__p1 cp8__p1 gnd__p17 gnd sg13_lv_nmos w=0.5u l=0.13u ng=1 m=1
Xxdp7_xmp bp7 cp7 vrefl__p10 vrefl sg13_lv_pmos w=1u l=0.13u ng=1 m=1
Xxdp7_xmn bp7__p1 cp7__p1 gnd__p18 gnd sg13_lv_nmos w=0.5u l=0.13u ng=1 m=1
Xxdp6_xmp bp6 cp6 vrefl__p11 vrefl sg13_lv_pmos w=1u l=0.13u ng=1 m=1
Xxdp6_xmn bp6__p1 cp6__p1 gnd__p19 gnd sg13_lv_nmos w=0.5u l=0.13u ng=1 m=1
Xxdp5_xmp bp5 cp5 vrefl__p12 vrefl sg13_lv_pmos w=1u l=0.13u ng=1 m=1
Xxdp5_xmn bp5__p1 cp5__p1 gnd__p20 gnd sg13_lv_nmos w=0.5u l=0.13u ng=1 m=1
Xxdp4_xmp bp4 cp4 vrefl__p13 vrefl sg13_lv_pmos w=1u l=0.13u ng=1 m=1
Xxdp4_xmn bp4__p1 cp4__p1 gnd__p21 gnd sg13_lv_nmos w=0.5u l=0.13u ng=1 m=1
Xxdp3_xmp bp3 cp3 vrefl__p14 vrefl sg13_lv_pmos w=1u l=0.13u ng=1 m=1
Xxdp3_xmn bp3__p1 cp3__p1 gnd__p22 gnd sg13_lv_nmos w=0.5u l=0.13u ng=1 m=1
Xxdp2_xmp bp2 cp2 vrefl__p15 vrefl sg13_lv_pmos w=1u l=0.13u ng=1 m=1
Xxdp2_xmn bp2__p1 cp2__p1 gnd__p23 gnd sg13_lv_nmos w=0.5u l=0.13u ng=1 m=1
Xxdp1_xmp bp1 cp1 vrefl__p16 vrefl sg13_lv_pmos w=1u l=0.13u ng=1 m=1
Xxdp1_xmn bp1__p1 cp1__p1 gnd__p24 gnd sg13_lv_nmos w=0.5u l=0.13u ng=1 m=1
Xxdp0_xmp bp0 cp0 vrefl__p17 vrefl sg13_lv_pmos w=1u l=0.13u ng=1 m=1
Xxdp0_xmn bp0__p1 cp0__p1 gnd__p25 gnd sg13_lv_nmos w=0.5u l=0.13u ng=1 m=1
Xxdn12_xmp bn12 cn12 vref__p4 vref sg13_lv_pmos w=2u l=0.13u ng=1 m=1
Xxdn12_xmn bn12__p1 cn12__p1 gnd__p12 gnd sg13_lv_nmos w=1u l=0.13u ng=1 m=1
Xxdn11_xmp bn11 cn11 vref__p3 vref sg13_lv_pmos w=2u l=0.13u ng=1 m=1
Xxdn11_xmn bn11__p1 cn11__p1 gnd__p11 gnd sg13_lv_nmos w=1u l=0.13u ng=1 m=1
Xxdn10_xmp bn10 cn10 vref__p2 vref sg13_lv_pmos w=2u l=0.13u ng=1 m=1
Xxdn10_xmn bn10__p1 cn10__p1 gnd__p10 gnd sg13_lv_nmos w=1u l=0.13u ng=1 m=1
Xxdn9_xmp bn9 cn9 vref__p1 vref sg13_lv_pmos w=1u l=0.13u ng=1 m=1
Xxdn9_xmn bn9__p1 cn9__p1 gnd__p9 gnd sg13_lv_nmos w=0.5u l=0.13u ng=1 m=1
Xxdn8_xmp bn8 cn8 vref__p0 vref sg13_lv_pmos w=1u l=0.13u ng=1 m=1
Xxdn8_xmn bn8__p1 cn8__p1 gnd__p8 gnd sg13_lv_nmos w=0.5u l=0.13u ng=1 m=1
Xxdn7_xmp bn7 cn7 vrefl__p7 vrefl sg13_lv_pmos w=1u l=0.13u ng=1 m=1
Xxdn7_xmn bn7__p1 cn7__p1 gnd__p7 gnd sg13_lv_nmos w=0.5u l=0.13u ng=1 m=1
Xxdn6_xmp bn6 cn6 vrefl__p6 vrefl sg13_lv_pmos w=1u l=0.13u ng=1 m=1
Xxdn6_xmn bn6__p1 cn6__p1 gnd__p6 gnd sg13_lv_nmos w=0.5u l=0.13u ng=1 m=1
Xxdn5_xmp bn5 cn5 vrefl__p5 vrefl sg13_lv_pmos w=1u l=0.13u ng=1 m=1
Xxdn5_xmn bn5__p1 cn5__p1 gnd__p5 gnd sg13_lv_nmos w=0.5u l=0.13u ng=1 m=1
Xxdn4_xmp bn4 cn4 vrefl__p4 vrefl sg13_lv_pmos w=1u l=0.13u ng=1 m=1
Xxdn4_xmn bn4__p1 cn4__p1 gnd__p4 gnd sg13_lv_nmos w=0.5u l=0.13u ng=1 m=1
Xxdn3_xmp bn3 cn3 vrefl__p3 vrefl sg13_lv_pmos w=1u l=0.13u ng=1 m=1
Xxdn3_xmn bn3__p1 cn3__p1 gnd__p3 gnd sg13_lv_nmos w=0.5u l=0.13u ng=1 m=1
Xxdn2_xmp bn2 cn2 vrefl__p2 vrefl sg13_lv_pmos w=1u l=0.13u ng=1 m=1
Xxdn2_xmn bn2__p1 cn2__p1 gnd__p2 gnd sg13_lv_nmos w=0.5u l=0.13u ng=1 m=1
Xxdn1_xmp bn1 cn1 vrefl__p1 vrefl sg13_lv_pmos w=1u l=0.13u ng=1 m=1
Xxdn1_xmn bn1__p1 cn1__p1 gnd__p1 gnd sg13_lv_nmos w=0.5u l=0.13u ng=1 m=1
Xxdn0_xmp bn0 cn0 vrefl__p0 vrefl sg13_lv_pmos w=1u l=0.13u ng=1 m=1
Xxdn0_xmn bn0__p1 cn0__p1 gnd__p0 gnd sg13_lv_nmos w=0.5u l=0.13u ng=1 m=1
Xxc4_xs1_xmt1 xc4_xs1_tail0 clkb__p2 vdd__p28 vdd sg13_lv_pmos w=16u l=0.13u ng=4 m=1
Xxc4_xs1_xmtc xc4_xs1_tail__p2 vbp xc4_xs1_tail0__p1 vdd sg13_lv_pmos w=16u l=0.5u ng=4 m=1
Xxc4_xs1_xm1 xc4_dip top_p__p4 xc4_xs1_tail vdd sg13_lv_pmos w=48u l=0.3u ng=12 m=1
Xxc4_xs1_xm2 xc4_din top_n__p4 xc4_xs1_tail__p1 vdd sg13_lv_pmos w=48u l=0.3u ng=12 m=1
Xxc4_xci1 vdd__p23 xc4_dip vdd__p22 vdd sg13_lv_pmos w=80u l=4u ng=8 m=1
Xxc4_xci2 vdd__p25 xc4_din vdd__p24 vdd sg13_lv_pmos w=80u l=4u ng=8 m=1
Xxc4_xmr1 xc4_dip__p1 clkb gnd__p49 gnd sg13_lv_nmos w=20u l=0.13u ng=2 m=1
Xxc4_xmr2 xc4_din__p1 clkb__p1 gnd__p50 gnd sg13_lv_nmos w=20u l=0.13u ng=2 m=1
Xxc4_xmt2 xc4_lt clk gnd__p55 gnd sg13_lv_nmos w=4u l=0.13u ng=1 m=1
Xxc4_xmn1 op on xc4_lt__p1 gnd sg13_lv_nmos w=2u l=0.13u ng=1 m=1
Xxc4_xmn2 on__p1 op__p1 xc4_lt__p2 gnd sg13_lv_nmos w=2u l=0.13u ng=1 m=1
Xxc4_xmp1 op__p4 on__p4 vdd__p31 vdd sg13_lv_pmos w=2u l=0.13u ng=1 m=1
Xxc4_xmp2 on__p5 op__p5 vdd__p32 vdd sg13_lv_pmos w=2u l=0.13u ng=1 m=1
Xxc4_xmh1 op__p3 xc4_dip__p2 vdd__p29 vdd sg13_lv_pmos w=8u l=0.13u ng=2 m=1
Xxc4_xmh2 on__p3 xc4_din__p2 vdd__p30 vdd sg13_lv_pmos w=8u l=0.13u ng=2 m=1
Xxc4_xbp1 xc4_outpb__p1 op__p6 vdd__p33 vdd sg13_lv_pmos w=1u l=0.13u ng=1 m=1
Xxc4_xbn1 xc4_outpb op__p2 gnd__p56 gnd sg13_lv_nmos w=0.5u l=0.13u ng=1 m=1
Xxc4_xbp2 xc4_outnb__p1 on__p6 vdd__p34 vdd sg13_lv_pmos w=1u l=0.13u ng=1 m=1
Xxc4_xbn2 xc4_outnb on__p2 gnd__p57 gnd sg13_lv_nmos w=0.5u l=0.13u ng=1 m=1
Xxc5_xs1_xmt1 xc5_xs1_tail0 clkn__p2 gnd__p46 gnd sg13_lv_nmos w=8u l=0.13u ng=2 m=1
Xxc5_xs1_xmtc xc5_xs1_tail__p2 vbn xc5_xs1_tail0__p1 gnd sg13_lv_nmos w=4u l=0.5u ng=1 m=1
Xxc5_xs1_xm1 xc5_dip__p1 top_p xc5_xs1_tail gnd sg13_lv_nmos w=16u l=0.5u ng=4 m=1
Xxc5_xs1_xm2 xc5_din__p1 top_n xc5_xs1_tail__p1 gnd sg13_lv_nmos w=16u l=0.5u ng=4 m=1
Xxc5_xci1 gnd__p43 xc5_dip gnd__p42 gnd sg13_lv_nmos w=30u l=4u ng=4 m=1
Xxc5_xci2 gnd__p45 xc5_din gnd__p44 gnd sg13_lv_nmos w=30u l=4u ng=4 m=1
Xxc5_xmr1 xc5_dip clkn vdd__p19 vdd sg13_lv_pmos w=16u l=0.13u ng=2 m=1
Xxc5_xmr2 xc5_din clkn__p1 vdd__p20 vdd sg13_lv_pmos w=16u l=0.13u ng=2 m=1
Xxc5_xmt2 xc5_lt clknb vdd__p21 vdd sg13_lv_pmos w=8u l=0.13u ng=1 m=1
Xxc5_xmp1 onp__p4 onn__p4 xc5_lt__p1 vdd sg13_lv_pmos w=4u l=0.13u ng=1 m=1
Xxc5_xmp2 onn__p5 onp__p5 xc5_lt__p2 vdd sg13_lv_pmos w=4u l=0.13u ng=1 m=1
Xxc5_xmn1 onp__p1 onn__p1 gnd__p51 gnd sg13_lv_nmos w=1u l=0.13u ng=1 m=1
Xxc5_xmn2 onn__p2 onp__p2 gnd__p52 gnd sg13_lv_nmos w=1u l=0.13u ng=1 m=1
Xxc5_xmh1 onp xc5_dip__p2 gnd__p47 gnd sg13_lv_nmos w=8u l=0.13u ng=1 m=1
Xxc5_xmh2 onn xc5_din__p2 gnd__p48 gnd sg13_lv_nmos w=8u l=0.13u ng=1 m=1
Xxc5_xbp1 xc5_outpb__p1 onp__p6 vdd__p26 vdd sg13_lv_pmos w=1u l=0.13u ng=1 m=1
Xxc5_xbn1 xc5_outpb onp__p3 gnd__p53 gnd sg13_lv_nmos w=0.5u l=0.13u ng=1 m=1
Xxc5_xbp2 xc5_outnb__p1 onn__p6 vdd__p27 vdd sg13_lv_pmos w=1u l=0.13u ng=1 m=1
Xxc5_xbn2 xc5_outnb onn__p3 gnd__p54 gnd sg13_lv_nmos w=0.5u l=0.13u ng=1 m=1
Xxdacp_xc12_u0 top_p__p1 bp12__p2 cap_cmim w=3.78u l=3.78u m=16
Xxdacp_xc11_u0 top_p__p1 bp11__p2 cap_cmim w=3.78u l=3.78u m=8
Xxdacp_xc10_u0 top_p__p1 bp10__p2 cap_cmim w=3.78u l=3.78u m=4
Xxdacp_xc9_u0 top_p__p1 bp9__p2 cap_cmim w=3.78u l=3.78u m=2
Xxdacp_xc8_u0 top_p__p1 bp8__p2 cap_cmim w=3.78u l=3.78u m=1
Xxdacp_xcb top_p__p1 lsb_p__p1 cap_cmim w=4.23u l=4.23u m=1
Xxdacp_xc7_u0 lsb_p__p1 bp7__p2 cap_cmim w=3.78u l=3.78u m=64
Xxdacp_xc6_u0 lsb_p__p1 bp6__p2 cap_cmim w=3.78u l=3.78u m=32
Xxdacp_xc5_u0 lsb_p__p1 bp5__p2 cap_cmim w=3.78u l=3.78u m=16
Xxdacp_xc4_u0 lsb_p__p1 bp4__p2 cap_cmim w=3.78u l=3.78u m=8
Xxdacp_xc3_u0 lsb_p__p1 bp3__p2 cap_cmim w=3.78u l=3.78u m=4
Xxdacp_xc2_u0 lsb_p__p1 bp2__p2 cap_cmim w=3.78u l=3.78u m=2
Xxdacp_xc1_u0 lsb_p__p1 bp1__p2 cap_cmim w=3.78u l=3.78u m=1
Xxdacp_xc0 lsb_p__p1 bp0__p2 cap_cmim w=2.67u l=2.67u m=1
Xxdacn_xc12_u0 top_n__p1 bn12__p2 cap_cmim w=3.78u l=3.78u m=16
Xxdacn_xc11_u0 top_n__p1 bn11__p2 cap_cmim w=3.78u l=3.78u m=8
Xxdacn_xc10_u0 top_n__p1 bn10__p2 cap_cmim w=3.78u l=3.78u m=4
Xxdacn_xc9_u0 top_n__p1 bn9__p2 cap_cmim w=3.78u l=3.78u m=2
Xxdacn_xc8_u0 top_n__p1 bn8__p2 cap_cmim w=3.78u l=3.78u m=1
Xxdacn_xcb top_n__p1 lsb_n__p1 cap_cmim w=4.23u l=4.23u m=1
Xxdacn_xc7_u0 lsb_n__p1 bn7__p2 cap_cmim w=3.78u l=3.78u m=64
Xxdacn_xc6_u0 lsb_n__p1 bn6__p2 cap_cmim w=3.78u l=3.78u m=32
Xxdacn_xc5_u0 lsb_n__p1 bn5__p2 cap_cmim w=3.78u l=3.78u m=16
Xxdacn_xc4_u0 lsb_n__p1 bn4__p2 cap_cmim w=3.78u l=3.78u m=8
Xxdacn_xc3_u0 lsb_n__p1 bn3__p2 cap_cmim w=3.78u l=3.78u m=4
Xxdacn_xc2_u0 lsb_n__p1 bn2__p2 cap_cmim w=3.78u l=3.78u m=2
Xxdacn_xc1_u0 lsb_n__p1 bn1__p2 cap_cmim w=3.78u l=3.78u m=1
Xxdacn_xc0 lsb_n__p1 bn0__p2 cap_cmim w=2.67u l=2.67u m=1
Xxdmy_u0 gnd__p27 gnd__p27 cap_cmim w=3.78u l=3.78u m=82
Cld_xc4_outpb xc4_outpb gnd 3f
Cld_xc4_outnb xc4_outnb gnd 3f
Cld_xc5_outpb xc5_outpb gnd 3f
Cld_xc5_outnb xc5_outnb gnd 3f
Rw0 bn0 bn0__p1 30.5072
Rw1 bn0 bn0__p2 26.3744
Rw2 bn0__p1 bn0__p2 32.1711
Rw3 bn1 bn1__p1 31.7277
Rw4 bn1 bn1__p2 26.1343
Rw5 bn1__p1 bn1__p2 32.3351
Rw6 bn10 bn10__p1 69.8616
Rw7 bn10 bn10__p2 21.3825
Rw8 bn10__p1 bn10__p2 70.9295
Rw9 bn11 bn11__p2 18.369
Rw10 bn11__p1 bn11__p2 21.7992
Rw11 bn12 bn12__p1 70.4054
Rw12 bn12 bn12__p2 21.1472
Rw13 bn12__p1 bn12__p2 70.4054
Rw14 bn2 bn2__p1 30.7888
Rw15 bn2 bn2__p2 26.7387
Rw16 bn2__p1 bn2__p2 31.8477
Rw17 bn3 bn3__p1 31.7277
Rw18 bn3 bn3__p2 26.1343
Rw19 bn3__p1 bn3__p2 32.3351
Rw20 bn4 bn4__p1 31.7277
Rw21 bn4 bn4__p2 26.1343
Rw22 bn4__p1 bn4__p2 32.3351
Rw23 bn5 bn5__p1 31.7277
Rw24 bn5 bn5__p2 26.1343
Rw25 bn5__p1 bn5__p2 32.3351
Rw26 bn6 bn6__p1 31.7277
Rw27 bn6 bn6__p2 26.1343
Rw28 bn6__p1 bn6__p2 32.3351
Rw29 bn7 bn7__p1 30.7888
Rw30 bn7 bn7__p2 26.7387
Rw31 bn7__p1 bn7__p2 31.8477
Rw32 bn8 bn8__p2 18.5632
Rw33 bn8__p1 bn8__p2 21.7312
Rw34 bn9 bn9__p2 18.545
Rw35 bn9__p1 bn9__p2 21.957
Rw36 bp0 bp0__p1 71.1014
Rw37 bp0 bp0__p2 21.5492
Rw38 bp0__p1 bp0__p2 75.9024
Rw39 bp1 bp1__p1 73.6661
Rw40 bp1 bp1__p2 21.2087
Rw41 bp1__p1 bp1__p2 75.0764
Rw42 bp10 bp10__p1 69.8616
Rw43 bp10 bp10__p2 21.3825
Rw44 bp10__p1 bp10__p2 70.9295
Rw45 bp11 bp11__p1 70.4054
Rw46 bp11 bp11__p2 21.1472
Rw47 bp11__p1 bp11__p2 70.4054
Rw48 bp12 bp12__p2 18.369
Rw49 bp12__p1 bp12__p2 21.7992
Rw50 bp2 bp2__p1 72.3852
Rw51 bp2 bp2__p2 21.4715
Rw52 bp2__p1 bp2__p2 74.8747
Rw53 bp3 bp3__p2 18.545
Rw54 bp3__p1 bp3__p2 23.609
Rw55 bp4 bp4__p1 74.1237
Rw56 bp4 bp4__p2 21.19
Rw57 bp4__p1 bp4__p2 75.5428
Rw58 bp5 bp5__p1 72.9326
Rw59 bp5 bp5__p2 21.2391
Rw60 bp5__p1 bp5__p2 74.3289
Rw61 bp6 bp6__p1 72.9687
Rw62 bp6 bp6__p2 21.2376
Rw63 bp6__p1 bp6__p2 74.3657
Rw64 bp7 bp7__p2 18.545
Rw65 bp7__p1 bp7__p2 41.541
Rw66 bp8 bp8__p1 70.5278
Rw67 bp8 bp8__p2 21.3441
Rw68 bp8__p1 bp8__p2 71.8781
Rw69 bp9 bp9__p1 69.8304
Rw70 bp9 bp9__p2 21.3761
Rw71 bp9__p1 bp9__p2 71.1673
Rw72 clkb clkb__p1 0.72754
Rw73 clkb clkb__p2 68.0056
Rw74 clkn clkn__p1 0.756757
Rw75 clkn clkn__p2 53.716
Rw76 clkn__p1 clkn__p2 328.079
Rw77 cn0 cn0__p1 19.6116
Rw78 cn1 cn1__p1 19.6179
Rw79 cn10 cn10__p1 39.168
Rw80 cn11 cn11__p1 39.168
Rw81 cn12 cn12__p1 39.168
Rw82 cn2 cn2__p1 19.6179
Rw83 cn3 cn3__p1 19.6179
Rw84 cn4 cn4__p1 19.6179
Rw85 cn5 cn5__p1 19.6179
Rw86 cn6 cn6__p1 19.6179
Rw87 cn7 cn7__p1 19.6179
Rw88 cn8 cn8__p1 39.1405
Rw89 cn9 cn9__p1 39.168
Rw90 cp0 cp0__p1 41.1379
Rw91 cp1 cp1__p1 40.752
Rw92 cp10 cp10__p1 39.168
Rw93 cp11 cp11__p1 39.168
Rw94 cp12 cp12__p1 39.168
Rw95 cp2 cp2__p1 40.752
Rw96 cp3 cp3__p1 40.752
Rw97 cp4 cp4__p1 40.7859
Rw98 cp5 cp5__p1 40.752
Rw99 cp6 cp6__p1 40.7521
Rw100 cp7 cp7__p1 40.7521
Rw101 cp8 cp8__p1 39.168
Rw102 cp9 cp9__p1 39.168
Rw103 gnd__i56 gnd__i57 9
Rw104 gnd__i58 gnd__i59 9
Rw105 gnd__i61 gnd__i62 9
Rw106 gnd__i66 gnd__i67 9
Rw107 gnd__i69 gnd__i70 9
Rw108 gnd__i41 gnd__i18 23.6585
Rw109 gnd__i42 gnd__i41 6.05846
Rw110 gnd__i39 gnd__i42 1.32
Rw111 gnd__i40 gnd__i39 1.99692
Rw112 gnd__i16 gnd__i15 1.99692
Rw113 gnd__i17 gnd__i16 3.68923
Rw114 gnd__i28 gnd__i27 1.32
Rw115 gnd__i29 gnd__i28 1.32
Rw116 gnd__i30 gnd__i29 1.32
Rw117 gnd__i31 gnd__i30 1.32
Rw118 gnd__i32 gnd__i31 1.32
Rw119 gnd__i7 gnd__i32 1.32
Rw120 gnd__i8 gnd__i7 1.32
Rw121 gnd__i9 gnd__i8 1.32
Rw122 gnd__i10 gnd__i9 1.32
Rw123 gnd__i11 gnd__i10 1.32
Rw124 gnd__i12 gnd__i11 1.32
Rw125 gnd__i13 gnd__i12 0.643077
Rw126 gnd__i14 gnd__i13 0.643077
Rw127 gnd__i0 gnd__i14 1.32
Rw128 gnd__i35 gnd__i36 1.32
Rw129 gnd__i43 gnd__i44 1.32
Rw130 gnd__i45 gnd__i46 1.32
Rw131 gnd__i45 gnd__i44 1.32
Rw132 gnd__i37 gnd__i36 1.32
Rw133 gnd__i34 gnd__i35 1.32
Rw134 gnd__i47 gnd__i33 1.32
Rw135 gnd__i0 gnd__i43 1.32
Rw136 gnd__i34 gnd__i33 1.32
Rw137 gnd__i47 gnd__i46 1.32
Rw138 gnd__i22 gnd__i21 2.67385
Rw139 gnd__i22 gnd__i23 1.32
Rw140 gnd__i24 gnd__i23 4.02769
Rw141 gnd__i25 gnd__i24 1.32
Rw142 gnd__i48 gnd__i19 0.176
Rw143 gnd__i52 gnd__i73 0.526271
Rw144 gnd__i58 gnd__i53 0.134858
Rw145 gnd__i65 gnd__i63 0.0457844
Rw146 gnd__i64 gnd__p26 0.2464
Rw147 gnd__i72 gnd__p27 0.1408
Rw148 gnd__i56 gnd__i51 0.176
Rw149 gnd__i64 gnd__i63 9
Rw150 gnd__i61 gnd__i63 0.0423898
Rw151 gnd__i68 gnd__i54 9
Rw152 gnd__i66 gnd__i54 0.0653048
Rw153 gnd__i72 gnd__i71 9
Rw154 gnd__i69 gnd__i71 0.0361467
Rw155 gnd__i51 gnd__i57 9
Rw156 gnd__i60 gnd__i59 0.0586667
Rw157 gnd__i53 gnd__i59 9
Rw158 gnd__i63 gnd__i62 9
Rw159 gnd__i65 gnd__i62 9
Rw160 gnd__i64 gnd__i62 0.0352
Rw161 gnd__i68 gnd__i67 0.0432373
Rw162 gnd__i54 gnd__i67 9
Rw163 gnd__i71 gnd__i70 9
Rw164 gnd__i72 gnd__i70 0.0352
Rw165 gnd__i1 gnd__p32 9.10676
Rw166 gnd__i2 gnd__p33 9.07441
Rw167 gnd__i3 gnd__p34 9.10676
Rw168 gnd__i4 gnd__p28 9.06632
Rw169 gnd__i5 gnd__p30 9.06632
Rw170 gnd__i6 gnd__p29 9.07441
Rw171 gnd__i16 gnd__i20 9.88
Rw172 gnd__i19 gnd__p36 9.06632
Rw173 gnd__i20 gnd__p38 9.10676
Rw174 gnd__i26 gnd__i27 10.32
Rw175 gnd__i38 gnd__p48 9.07441
Rw176 gnd__i48 gnd__i73 11.8962
Rw177 gnd__i60 gnd__i53 9.06433
Rw178 gnd__i0 gnd__p14 18.9868
Rw179 gnd__p31 gnd__i54 18.2504
Rw180 gnd__p54 gnd__i22 18.7784
Rw181 gnd__p57 gnd__i25 18.7784
Rw182 gnd__i26 gnd__p0 9.77032
Rw183 gnd__p1 gnd__i27 18.8108
Rw184 gnd__p2 gnd__i28 18.8108
Rw185 gnd__p3 gnd__i29 18.8108
Rw186 gnd__p4 gnd__i30 18.8108
Rw187 gnd__p5 gnd__i31 18.8108
Rw188 gnd__p6 gnd__i32 18.8108
Rw189 gnd__i7 gnd__p7 18.8108
Rw190 gnd__i8 gnd__p8 18.8108
Rw191 gnd__i9 gnd__p9 18.8108
Rw192 gnd__p52 gnd__i53 18.252
Rw193 gnd__i10 gnd__p10 18.9868
Rw194 gnd__i11 gnd__p11 18.9868
Rw195 gnd__i12 gnd__p12 18.9868
Rw196 gnd__i14 gnd__p13 18.9868
Rw197 gnd__i18 gnd__p42 18.3537
Rw198 gnd__p42 gnd__i50 18.9332
Rw199 gnd__i48 gnd__p37 10.2308
Rw200 gnd__i20 gnd__p39 10.4068
Rw201 gnd__p43 gnd__i50 18.2259
Rw202 gnd__i21 gnd__i52 19.1575
Rw203 gnd__p15 gnd__i43 18.9868
Rw204 gnd__p50 gnd__i51 18.3928
Rw205 gnd__i41 gnd__p44 18.6437
Rw206 gnd__p47 gnd__i49 18.2553
Rw207 gnd__p16 gnd__i44 18.8108
Rw208 gnd__p17 gnd__i45 18.8108
Rw209 gnd__p18 gnd__i46 18.8108
Rw210 gnd__p19 gnd__i47 18.8108
Rw211 gnd__i33 gnd__p20 18.8108
Rw212 gnd__i34 gnd__p21 18.8108
Rw213 gnd__i35 gnd__p22 18.8108
Rw214 gnd__i36 gnd__p23 18.8108
Rw215 gnd__i37 gnd__p24 18.8108
Rw216 gnd__i15 gnd 18.297
Rw217 gnd__i39 gnd__p60 18.297
Rw218 gnd__i40 gnd__i49 18.8372
Rw219 gnd__i55 gnd__i38 18.176
Rw220 gnd__i21 gnd__i58 18.5321
Rw221 gnd__i55 gnd__i49 4.69062
Rw222 gnd__p27 gnd__p26 19.4416
Rw223 gnd__i2 gnd__i1 20.5995
Rw224 gnd__i3 gnd__p35 29.5795
Rw225 gnd__i6 gnd__i4 20.745
Rw226 gnd__i5 gnd__i66 29.461
Rw227 gnd__p25 gnd__i37 20.1308
Rw228 gnd__i15 gnd__i19 28.4861
Rw229 gnd__p40 gnd__i17 36.6934
Rw230 gnd__p44 gnd__p45 36.7157
Rw231 gnd__p56 gnd__i24 36.7784
Rw232 gnd__i52 gnd__p51 18.6469
Rw233 gnd__p55 gnd__i23 37.3026
Rw234 gnd__i56 gnd__i55 5.18891
Rw235 gnd__i50 gnd__i13 18.8817
Rw236 gnd__i60 gnd__p53 27.2504
Rw237 gnd__i69 gnd__i68 5.91
Rw238 gnd__i38 gnd__p49 10.4618
Rw239 gnd__p41 gnd__i17 38.4692
Rw240 gnd__p46 gnd__i42 36.8641
Rw241 gnd__i73 gnd__i61 43.007
Rw242 gnd__i65 gnd__i4 30.6571
Rw243 gnd__p59 gnd__i18 38.2905
Rw244 gnd__i26 gnd__i25 47.2623
Rw245 gnd__i1 gnd__i57 74.1862
Rw246 gnd__i5 gnd__i6 80.1772
Rw247 gnd__i3 gnd__i2 80.4342
Rw248 gnd__p61 gnd__i40 36.7352
Rw249 in0n in0n__p0 30.4198
Rw250 in0n in0n__p1 1230.53
Rw251 in0n__p0 in0n__p1 9.97277
Rw252 in0p in0p__p0 56.0447
Rw253 in0p in0p__p1 897.293
Rw254 in0p__p0 in0p__p1 9.95162
Rw255 in1n in1n__p0 55.9305
Rw256 in1n in1n__p1 1315.01
Rw257 in1n__p0 in1n__p1 9.97958
Rw258 in1p in1p__p0 32.5875
Rw259 in1p in1p__p1 494.883
Rw260 in1p__p0 in1p__p1 10.1324
Rw261 lsb_n lsb_n__p1 18.545
Rw262 lsb_n__p1 lsb_n__p2 39.892
Rw263 lsb_p lsb_p__p1 19.6278
Rw264 lsb_p lsb_p__p2 169.301
Rw265 lsb_p__p1 lsb_p__p2 172.542
Rw266 nr nr__p1 46.253
Rw267 on on__p1 57.6845
Rw268 on on__p2 80.1035
Rw269 on on__p3 859.79
Rw270 on on__p4 926.262
Rw271 on on__p5 667.597
Rw272 on on__p6 731.371
Rw273 on__p1 on__p2 74.3494
Rw274 on__p1 on__p3 798.029
Rw275 on__p1 on__p4 859.725
Rw276 on__p1 on__p5 619.641
Rw277 on__p1 on__p6 678.834
Rw278 on__p2 on__p3 186.876
Rw279 on__p2 on__p4 201.323
Rw280 on__p2 on__p5 145.102
Rw281 on__p2 on__p6 158.964
Rw282 on__p3 on__p4 25.8041
Rw283 on__p3 on__p5 115.953
Rw284 on__p3 on__p6 127.03
Rw285 on__p4 on__p5 124.917
Rw286 on__p4 on__p6 136.85
Rw287 on__p5 on__p6 73.96
Rw288 onn onn__p1 3848.34
Rw289 onn onn__p2 3812.83
Rw290 onn onn__p3 892.65
Rw291 onn onn__p4 525.521
Rw292 onn onn__p5 505.395
Rw293 onn onn__p6 97.2946
Rw294 onn__p1 onn__p2 59.6084
Rw295 onn__p1 onn__p3 75.1816
Rw296 onn__p1 onn__p4 486.378
Rw297 onn__p1 onn__p5 558.17
Rw298 onn__p1 onn__p6 615.736
Rw299 onn__p2 onn__p3 74.4879
Rw300 onn__p2 onn__p4 481.89
Rw301 onn__p2 onn__p5 553.019
Rw302 onn__p2 onn__p6 610.054
Rw303 onn__p3 onn__p4 112.819
Rw304 onn__p3 onn__p5 129.472
Rw305 onn__p3 onn__p6 142.824
Rw306 onn__p4 onn__p5 76.2225
Rw307 onn__p4 onn__p6 84.0836
Rw308 onn__p5 onn__p6 80.8634
Rw309 onp onp__p5 274.543
Rw310 onp onp__p6 88.0395
Rw311 onp__p1 onp__p2 19.2467
Rw312 onp__p2 onp__p3 0.715378
Rw313 onp__p3 onp__p4 70.8715
Rw314 onp__p3 onp__p5 81.5562
Rw315 onp__p4 onp__p5 22.7189
Rw316 onp__p5 onp__p6 0.70537
Rw317 op op__p1 19.4601
Rw318 op__p1 op__p2 0.704
Rw319 op__p2 op__p3 60.2277
Rw320 op__p2 op__p4 248.332
Rw321 op__p2 op__p5 268.234
Rw322 op__p3 op__p4 66.0945
Rw323 op__p3 op__p5 71.3915
Rw324 op__p4 op__p5 57.5869
Rw325 op__p5 op__p6 0.69894
Rw326 rstb rstb__p1 61.8906
Rw327 rstb rstb__p2 160.627
Rw328 rstb rstb__p3 132.73
Rw329 rstb__p1 rstb__p2 240.909
Rw330 rstb__p1 rstb__p3 199.069
Rw331 rstb__p2 rstb__p3 23.0213
Rw332 rstb_n rstb_n__p1 88.824
Rw333 rstb_n rstb_n__p3 101.63
Rw334 rstb_n rstb_n__p4 96.0304
Rw335 rstb_n__p1 rstb_n__p3 37.1031
Rw336 rstb_n__p1 rstb_n__p4 35.059
Rw337 rstb_n__p2 rstb_n__p3 0.6534
Rw338 rstb_n__p3 rstb_n__p4 30.359
Rw339 t0 t0__p1 75.6109
Rw340 t0 t0__p2 342.012
Rw341 t0 t0__p3 148.019
Rw342 t0 t0__p4 391.687
Rw343 t0 t0__p5 318.63
Rw344 t0__p1 t0__p2 93.531
Rw345 t0__p1 t0__p3 40.4792
Rw346 t0__p1 t0__p4 188.995
Rw347 t0__p1 t0__p5 153.744
Rw348 t0__p2 t0__p3 78.2282
Rw349 t0__p2 t0__p4 854.883
Rw350 t0__p2 t0__p5 695.431
Rw351 t0__p3 t0__p4 369.985
Rw352 t0__p3 t0__p5 300.975
Rw353 t0__p4 t0__p5 23.6755
Rw354 t0b t0b__p1 72.0171
Rw355 t0b t0b__p2 134.652
Rw356 t0b t0b__p3 427.407
Rw357 t0b t0b__p4 280.967
Rw358 t0b t0b__p5 313.141
Rw359 t0b t0b__p6 985.352
Rw360 t0b t0b__p7 170.495
Rw361 t0b t0b__p8 213.892
Rw362 t0b t0b__p9 681.836
Rw363 t0b__p1 t0b__p2 35.1166
Rw364 t0b__p1 t0b__p3 111.466
Rw365 t0b__p1 t0b__p4 1322.36
Rw366 t0b__p1 t0b__p5 1473.79
Rw367 t0b__p1 t0b__p6 4637.52
Rw368 t0b__p1 t0b__p7 802.43
Rw369 t0b__p1 t0b__p8 1006.67
Rw370 t0b__p1 t0b__p9 3209.04
Rw371 t0b__p2 t0b__p3 59.1004
Rw372 t0b__p2 t0b__p4 2472.45
Rw373 t0b__p2 t0b__p5 2755.58
Rw374 t0b__p2 t0b__p6 8670.9
Rw375 t0b__p2 t0b__p7 1500.33
Rw376 t0b__p2 t0b__p8 1882.2
Rw377 t0b__p2 t0b__p9 6000.02
Rw378 t0b__p3 t0b__p4 7847.94
Rw379 t0b__p3 t0b__p5 8746.64
Rw380 t0b__p3 t0b__p6 27522.8
Rw381 t0b__p3 t0b__p7 4762.27
Rw382 t0b__p3 t0b__p8 5974.4
Rw383 t0b__p3 t0b__p9 19045
Rw384 t0b__p4 t0b__p5 41.1599
Rw385 t0b__p4 t0b__p6 129.516
Rw386 t0b__p4 t0b__p7 56.5618
Rw387 t0b__p4 t0b__p8 49.3518
Rw388 t0b__p4 t0b__p9 157.322
Rw389 t0b__p5 t0b__p6 108.145
Rw390 t0b__p5 t0b__p7 63.039
Rw391 t0b__p5 t0b__p8 55.0033
Rw392 t0b__p5 t0b__p9 175.338
Rw393 t0b__p6 t0b__p7 198.363
Rw394 t0b__p6 t0b__p8 173.077
Rw395 t0b__p6 t0b__p9 551.73
Rw396 t0b__p7 t0b__p8 43.0588
Rw397 t0b__p7 t0b__p9 137.261
Rw398 t0b__p8 t0b__p9 119.765
Rw399 t1 t1__p1 54.5149
Rw400 t1 t1__p2 599.36
Rw401 t1 t1__p3 263.432
Rw402 t1 t1__p4 237.413
Rw403 t1 t1__p5 193.13
Rw404 t1__p1 t1__p2 161.977
Rw405 t1__p1 t1__p3 71.1922
Rw406 t1__p1 t1__p4 953.516
Rw407 t1__p1 t1__p5 775.666
Rw408 t1__p2 t1__p3 52.1911
Rw409 t1__p2 t1__p4 10483.4
Rw410 t1__p2 t1__p5 8528.01
Rw411 t1__p3 t1__p4 4607.67
Rw412 t1__p3 t1__p5 3748.25
Rw413 t1__p4 t1__p5 21.9176
Rw414 t1b t1b__p1 63.1567
Rw415 t1b t1b__p2 120.949
Rw416 t1b t1b__p3 388.477
Rw417 t1b t1b__p4 1000.96
Rw418 t1b t1b__p5 1113.52
Rw419 t1b t1b__p6 3377.67
Rw420 t1b t1b__p7 922.286
Rw421 t1b t1b__p8 435.419
Rw422 t1b t1b__p9 377.573
Rw423 t1b__p1 t1b__p2 35.3839
Rw424 t1b__p1 t1b__p3 113.65
Rw425 t1b__p1 t1b__p4 4670.51
Rw426 t1b__p1 t1b__p5 5195.71
Rw427 t1b__p1 t1b__p6 15760.3
Rw428 t1b__p1 t1b__p7 4303.41
Rw429 t1b__p1 t1b__p8 2031.67
Rw430 t1b__p1 t1b__p9 1761.77
Rw431 t1b__p2 t1b__p3 59.0486
Rw432 t1b__p2 t1b__p4 8944.29
Rw433 t1b__p2 t1b__p5 9950.09
Rw434 t1b__p2 t1b__p6 30181.9
Rw435 t1b__p2 t1b__p7 8241.28
Rw436 t1b__p2 t1b__p8 3890.78
Rw437 t1b__p2 t1b__p9 3373.89
Rw438 t1b__p3 t1b__p4 28728.3
Rw439 t1b__p3 t1b__p5 31958.8
Rw440 t1b__p3 t1b__p6 96941.6
Rw441 t1b__p3 t1b__p7 26470.3
Rw442 t1b__p3 t1b__p8 12496.8
Rw443 t1b__p3 t1b__p9 10836.6
Rw444 t1b__p4 t1b__p5 35.2314
Rw445 t1b__p4 t1b__p6 106.868
Rw446 t1b__p4 t1b__p7 40.0575
Rw447 t1b__p4 t1b__p8 148.225
Rw448 t1b__p4 t1b__p9 161.905
Rw449 t1b__p5 t1b__p6 98.1246
Rw450 t1b__p5 t1b__p7 44.562
Rw451 t1b__p5 t1b__p8 164.893
Rw452 t1b__p5 t1b__p9 180.112
Rw453 t1b__p6 t1b__p7 135.171
Rw454 t1b__p6 t1b__p8 500.173
Rw455 t1b__p6 t1b__p9 546.338
Rw456 t1b__p7 t1b__p8 136.574
Rw457 t1b__p7 t1b__p9 149.18
Rw458 t1b__p8 t1b__p9 70.429
Rw459 top_n top_n__p1 0.001
Rw460 top_n top_n__p2 0.001
Rw461 top_n__p1 top_n__p3 66.551
Rw462 top_n__p1 top_n__p4 214.366
Rw463 top_n__p3 top_n__p4 45.214
Rw464 top_p top_p__p1 0.001
Rw465 top_p top_p__p2 0.001
Rw466 top_p__p1 top_p__p3 31.2837
Rw467 top_p__p1 top_p__p4 82.8984
Rw468 top_p__p3 top_p__p4 163.124
Rw469 trk0 trk0__p1 20.4429
Rw470 trk1 trk1__p1 19.7939
Rw471 vdd vdd__p0 1128.17
Rw472 vdd vdd__p1 6542.79
Rw473 vdd vdd__p12 579.864
Rw474 vdd vdd__p13 587.318
Rw475 vdd vdd__p14 488.524
Rw476 vdd vdd__p15 423.646
Rw477 vdd vdd__p16 530.358
Rw478 vdd vdd__p17 149.629
Rw479 vdd vdd__p18 523.887
Rw480 vdd vdd__p2 1479.67
Rw481 vdd vdd__p22 158311
Rw482 vdd vdd__p24 413711
Rw483 vdd vdd__p26 2783.8
Rw484 vdd vdd__p27 3153.48
Rw485 vdd vdd__p28 3665.91
Rw486 vdd vdd__p29 16793.6
Rw487 vdd vdd__p3 7274.07
Rw488 vdd vdd__p30 15673.8
Rw489 vdd vdd__p31 16142.5
Rw490 vdd vdd__p32 7837.98
Rw491 vdd vdd__p33 8698.5
Rw492 vdd vdd__p34 15889.1
Rw493 vdd vdd__p36 5717.06
Rw494 vdd vdd__p4 38407.9
Rw495 vdd vdd__p5 7551.45
Rw496 vdd__p0 vdd__p1 488.136
Rw497 vdd__p0 vdd__p12 559.684
Rw498 vdd__p0 vdd__p13 566.879
Rw499 vdd__p0 vdd__p14 195.668
Rw500 vdd__p0 vdd__p15 423.921
Rw501 vdd__p0 vdd__p16 559.199
Rw502 vdd__p0 vdd__p17 515.704
Rw503 vdd__p0 vdd__p18 572.84
Rw504 vdd__p0 vdd__p2 110.394
Rw505 vdd__p0 vdd__p22 173104
Rw506 vdd__p0 vdd__p24 452370
Rw507 vdd__p0 vdd__p26 3043.92
Rw508 vdd__p0 vdd__p27 3448.15
Rw509 vdd__p0 vdd__p28 4008.46
Rw510 vdd__p0 vdd__p29 18362.8
Rw511 vdd__p0 vdd__p3 542.694
Rw512 vdd__p0 vdd__p30 17138.4
Rw513 vdd__p0 vdd__p31 17650.9
Rw514 vdd__p0 vdd__p32 8570.38
Rw515 vdd__p0 vdd__p33 9511.31
Rw516 vdd__p0 vdd__p34 17373.8
Rw517 vdd__p0 vdd__p36 6251.28
Rw518 vdd__p0 vdd__p4 2865.49
Rw519 vdd__p0 vdd__p5 563.388
Rw520 vdd__p1 vdd__p12 3245.88
Rw521 vdd__p1 vdd__p13 3287.61
Rw522 vdd__p1 vdd__p14 1134.77
Rw523 vdd__p1 vdd__p15 2458.52
Rw524 vdd__p1 vdd__p16 3243.07
Rw525 vdd__p1 vdd__p17 2990.81
Rw526 vdd__p1 vdd__p18 3322.17
Rw527 vdd__p1 vdd__p2 87.741
Rw528 vdd__p1 vdd__p26 17653.2
Rw529 vdd__p1 vdd__p27 19997.5
Rw530 vdd__p1 vdd__p28 23247
Rw531 vdd__p1 vdd__p29 106495
Rw532 vdd__p1 vdd__p3 431.334
Rw533 vdd__p1 vdd__p30 99393.7
Rw534 vdd__p1 vdd__p31 102366
Rw535 vdd__p1 vdd__p32 49703.8
Rw536 vdd__p1 vdd__p33 55160.7
Rw537 vdd__p1 vdd__p34 100759
Rw538 vdd__p1 vdd__p36 36254.2
Rw539 vdd__p1 vdd__p4 2277.49
Rw540 vdd__p1 vdd__p5 447.782
Rw541 vdd__p10 vdd__p11 198.01
Rw542 vdd__p10 vdd__p19 2703.76
Rw543 vdd__p10 vdd__p20 2272.22
Rw544 vdd__p10 vdd__p21 2204.75
Rw545 vdd__p10 vdd__p37 14886.3
Rw546 vdd__p10 vdd__p38 7412.43
Rw547 vdd__p10 vdd__p6 848.157
Rw548 vdd__p10 vdd__p7 237.718
Rw549 vdd__p10 vdd__p8 165.889
Rw550 vdd__p10 vdd__p9 71.7262
Rw551 vdd__p11 vdd__p19 3178.78
Rw552 vdd__p11 vdd__p20 2671.43
Rw553 vdd__p11 vdd__p21 2592.1
Rw554 vdd__p11 vdd__p37 17501.7
Rw555 vdd__p11 vdd__p38 8714.73
Rw556 vdd__p11 vdd__p6 997.172
Rw557 vdd__p11 vdd__p7 279.483
Rw558 vdd__p11 vdd__p8 195.035
Rw559 vdd__p11 vdd__p9 153.835
Rw560 vdd__p12 vdd__p13 239.958
Rw561 vdd__p12 vdd__p14 242.16
Rw562 vdd__p12 vdd__p15 220.492
Rw563 vdd__p12 vdd__p16 284.828
Rw564 vdd__p12 vdd__p17 265.065
Rw565 vdd__p12 vdd__p18 294.432
Rw566 vdd__p12 vdd__p2 734.066
Rw567 vdd__p12 vdd__p22 88973.1
Rw568 vdd__p12 vdd__p24 232512
Rw569 vdd__p12 vdd__p26 1564.53
Rw570 vdd__p12 vdd__p27 1772.3
Rw571 vdd__p12 vdd__p28 2060.29
Rw572 vdd__p12 vdd__p29 9438.25
Rw573 vdd__p12 vdd__p3 3608.66
Rw574 vdd__p12 vdd__p30 8808.9
Rw575 vdd__p12 vdd__p31 9072.33
Rw576 vdd__p12 vdd__p32 4405.06
Rw577 vdd__p12 vdd__p33 4888.69
Rw578 vdd__p12 vdd__p34 8929.88
Rw579 vdd__p12 vdd__p36 3213.07
Rw580 vdd__p12 vdd__p37 640470
Rw581 vdd__p12 vdd__p4 19054.2
Rw582 vdd__p12 vdd__p5 3746.27
Rw583 vdd__p13 vdd__p14 245.274
Rw584 vdd__p13 vdd__p15 223.327
Rw585 vdd__p13 vdd__p16 288.49
Rw586 vdd__p13 vdd__p17 268.472
Rw587 vdd__p13 vdd__p18 298.217
Rw588 vdd__p13 vdd__p2 743.503
Rw589 vdd__p13 vdd__p22 90116.9
Rw590 vdd__p13 vdd__p24 235501
Rw591 vdd__p13 vdd__p26 1584.65
Rw592 vdd__p13 vdd__p27 1795.09
Rw593 vdd__p13 vdd__p28 2086.78
Rw594 vdd__p13 vdd__p29 9559.58
Rw595 vdd__p13 vdd__p3 3655.06
Rw596 vdd__p13 vdd__p30 8922.15
Rw597 vdd__p13 vdd__p31 9188.96
Rw598 vdd__p13 vdd__p32 4461.69
Rw599 vdd__p13 vdd__p33 4951.54
Rw600 vdd__p13 vdd__p34 9044.68
Rw601 vdd__p13 vdd__p36 3254.38
Rw602 vdd__p13 vdd__p37 648703
Rw603 vdd__p13 vdd__p4 19299.1
Rw604 vdd__p13 vdd__p5 3794.43
Rw605 vdd__p14 vdd__p15 183.605
Rw606 vdd__p14 vdd__p16 242.108
Rw607 vdd__p14 vdd__p17 223.312
Rw608 vdd__p14 vdd__p18 248.053
Rw609 vdd__p14 vdd__p2 256.632
Rw610 vdd__p14 vdd__p22 74958.1
Rw611 vdd__p14 vdd__p24 195887
Rw612 vdd__p14 vdd__p26 1318.09
Rw613 vdd__p14 vdd__p27 1493.13
Rw614 vdd__p14 vdd__p28 1735.76
Rw615 vdd__p14 vdd__p29 7951.54
Rw616 vdd__p14 vdd__p3 1261.6
Rw617 vdd__p14 vdd__p30 7421.33
Rw618 vdd__p14 vdd__p31 7643.26
Rw619 vdd__p14 vdd__p32 3711.18
Rw620 vdd__p14 vdd__p33 4118.63
Rw621 vdd__p14 vdd__p34 7523.26
Rw622 vdd__p14 vdd__p36 2706.95
Rw623 vdd__p14 vdd__p37 539583
Rw624 vdd__p14 vdd__p4 6661.41
Rw625 vdd__p14 vdd__p5 1309.71
Rw626 vdd__p15 vdd__p16 209.959
Rw627 vdd__p15 vdd__p17 193.655
Rw628 vdd__p15 vdd__p18 215.111
Rw629 vdd__p15 vdd__p2 556.003
Rw630 vdd__p15 vdd__p22 65003.3
Rw631 vdd__p15 vdd__p24 169872
Rw632 vdd__p15 vdd__p26 1143.04
Rw633 vdd__p15 vdd__p27 1294.84
Rw634 vdd__p15 vdd__p28 1505.24
Rw635 vdd__p15 vdd__p29 6895.54
Rw636 vdd__p15 vdd__p3 2733.31
Rw637 vdd__p15 vdd__p30 6435.75
Rw638 vdd__p15 vdd__p31 6628.2
Rw639 vdd__p15 vdd__p32 3218.32
Rw640 vdd__p15 vdd__p33 3571.65
Rw641 vdd__p15 vdd__p34 6524.13
Rw642 vdd__p15 vdd__p36 2347.46
Rw643 vdd__p15 vdd__p37 467924
Rw644 vdd__p15 vdd__p4 14432.2
Rw645 vdd__p15 vdd__p5 2837.53
Rw646 vdd__p16 vdd__p17 242.435
Rw647 vdd__p16 vdd__p18 269.295
Rw648 vdd__p16 vdd__p2 733.43
Rw649 vdd__p16 vdd__p22 81377
Rw650 vdd__p16 vdd__p24 212661
Rw651 vdd__p16 vdd__p26 1430.96
Rw652 vdd__p16 vdd__p27 1620.99
Rw653 vdd__p16 vdd__p28 1884.4
Rw654 vdd__p16 vdd__p29 8632.46
Rw655 vdd__p16 vdd__p3 3605.54
Rw656 vdd__p16 vdd__p30 8056.84
Rw657 vdd__p16 vdd__p31 8297.78
Rw658 vdd__p16 vdd__p32 4028.98
Rw659 vdd__p16 vdd__p33 4471.32
Rw660 vdd__p16 vdd__p34 8167.5
Rw661 vdd__p16 vdd__p36 2938.76
Rw662 vdd__p16 vdd__p37 585789
Rw663 vdd__p16 vdd__p4 19037.7
Rw664 vdd__p16 vdd__p5 3743.03
Rw665 vdd__p17 vdd__p18 239.477
Rw666 vdd__p17 vdd__p2 676.382
Rw667 vdd__p17 vdd__p22 72366.4
Rw668 vdd__p17 vdd__p24 189114
Rw669 vdd__p17 vdd__p26 1272.52
Rw670 vdd__p17 vdd__p27 1441.51
Rw671 vdd__p17 vdd__p28 1675.74
Rw672 vdd__p17 vdd__p29 7676.61
Rw673 vdd__p17 vdd__p3 3325.09
Rw674 vdd__p17 vdd__p30 7164.74
Rw675 vdd__p17 vdd__p31 7379
Rw676 vdd__p17 vdd__p32 3582.87
Rw677 vdd__p17 vdd__p33 3976.22
Rw678 vdd__p17 vdd__p34 7263.14
Rw679 vdd__p17 vdd__p36 2613.36
Rw680 vdd__p17 vdd__p37 520927
Rw681 vdd__p17 vdd__p4 17556.9
Rw682 vdd__p17 vdd__p5 3451.89
Rw683 vdd__p18 vdd__p2 751.32
Rw684 vdd__p18 vdd__p22 74930.6
Rw685 vdd__p18 vdd__p24 195815
Rw686 vdd__p18 vdd__p26 1317.61
Rw687 vdd__p18 vdd__p27 1492.58
Rw688 vdd__p18 vdd__p28 1735.12
Rw689 vdd__p18 vdd__p29 7948.63
Rw690 vdd__p18 vdd__p3 3693.49
Rw691 vdd__p18 vdd__p30 7418.61
Rw692 vdd__p18 vdd__p31 7640.46
Rw693 vdd__p18 vdd__p32 3709.82
Rw694 vdd__p18 vdd__p33 4117.12
Rw695 vdd__p18 vdd__p34 7520.5
Rw696 vdd__p18 vdd__p36 2705.96
Rw697 vdd__p18 vdd__p37 539385
Rw698 vdd__p18 vdd__p4 19502
Rw699 vdd__p18 vdd__p5 3834.33
Rw700 vdd__p19 vdd__p20 110.662
Rw701 vdd__p19 vdd__p21 111.26
Rw702 vdd__p19 vdd__p22 343264
Rw703 vdd__p19 vdd__p24 128178
Rw704 vdd__p19 vdd__p37 319.309
Rw705 vdd__p19 vdd__p38 158.995
Rw706 vdd__p19 vdd__p6 238.054
Rw707 vdd__p19 vdd__p7 1977.51
Rw708 vdd__p19 vdd__p8 282.044
Rw709 vdd__p19 vdd__p9 2100.55
Rw710 vdd__p2 vdd__p22 227038
Rw711 vdd__p2 vdd__p24 593315
Rw712 vdd__p2 vdd__p26 3992.32
Rw713 vdd__p2 vdd__p27 4522.5
Rw714 vdd__p2 vdd__p28 5257.38
Rw715 vdd__p2 vdd__p29 24084.2
Rw716 vdd__p2 vdd__p3 93.6757
Rw717 vdd__p2 vdd__p30 22478.2
Rw718 vdd__p2 vdd__p31 23150.4
Rw719 vdd__p2 vdd__p32 11240.7
Rw720 vdd__p2 vdd__p33 12474.8
Rw721 vdd__p2 vdd__p34 22786.9
Rw722 vdd__p2 vdd__p36 8199
Rw723 vdd__p2 vdd__p4 494.619
Rw724 vdd__p2 vdd__p5 97.2478
Rw725 vdd__p20 vdd__p21 93.5025
Rw726 vdd__p20 vdd__p22 654994
Rw727 vdd__p20 vdd__p24 244581
Rw728 vdd__p20 vdd__p37 609.284
Rw729 vdd__p20 vdd__p38 303.384
Rw730 vdd__p20 vdd__p6 200.06
Rw731 vdd__p20 vdd__p7 1661.89
Rw732 vdd__p20 vdd__p8 237.029
Rw733 vdd__p20 vdd__p9 1765.29
Rw734 vdd__p21 vdd__p22 658533
Rw735 vdd__p21 vdd__p24 245903
Rw736 vdd__p21 vdd__p37 612.576
Rw737 vdd__p21 vdd__p38 305.023
Rw738 vdd__p21 vdd__p6 194.119
Rw739 vdd__p21 vdd__p7 1612.54
Rw740 vdd__p21 vdd__p8 229.99
Rw741 vdd__p21 vdd__p9 1712.87
Rw742 vdd__p22 vdd__p23 21.6962
Rw743 vdd__p22 vdd__p24 91.8193
Rw744 vdd__p22 vdd__p25 144132
Rw745 vdd__p22 vdd__p26 12383.9
Rw746 vdd__p22 vdd__p27 11313.5
Rw747 vdd__p22 vdd__p28 9951.71
Rw748 vdd__p22 vdd__p29 343.466
Rw749 vdd__p22 vdd__p30 288.306
Rw750 vdd__p22 vdd__p31 330.15
Rw751 vdd__p22 vdd__p32 7784.47
Rw752 vdd__p22 vdd__p33 8639.11
Rw753 vdd__p22 vdd__p34 15780.6
Rw754 vdd__p22 vdd__p36 5678.03
Rw755 vdd__p22 vdd__p37 252.922
Rw756 vdd__p22 vdd__p38 100653
Rw757 vdd__p24 vdd__p25 21.921
Rw758 vdd__p24 vdd__p26 32362.6
Rw759 vdd__p24 vdd__p27 29565.5
Rw760 vdd__p24 vdd__p28 26006.6
Rw761 vdd__p24 vdd__p29 897.575
Rw762 vdd__p24 vdd__p30 753.425
Rw763 vdd__p24 vdd__p31 862.776
Rw764 vdd__p24 vdd__p32 20343
Rw765 vdd__p24 vdd__p33 22576.5
Rw766 vdd__p24 vdd__p34 41239.1
Rw767 vdd__p24 vdd__p36 14838.3
Rw768 vdd__p24 vdd__p37 94.4436
Rw769 vdd__p24 vdd__p38 37584.9
Rw770 vdd__p24 vdd__p6 526137
Rw771 vdd__p24 vdd__p8 623362
Rw772 vdd__p25 vdd__p37 148252
Rw773 vdd__p26 vdd__p27 246.681
Rw774 vdd__p26 vdd__p28 286.766
Rw775 vdd__p26 vdd__p29 1313.68
Rw776 vdd__p26 vdd__p3 19626.2
Rw777 vdd__p26 vdd__p30 1226.08
Rw778 vdd__p26 vdd__p31 1262.75
Rw779 vdd__p26 vdd__p32 613.127
Rw780 vdd__p26 vdd__p33 680.441
Rw781 vdd__p26 vdd__p34 1242.92
Rw782 vdd__p26 vdd__p36 447.218
Rw783 vdd__p26 vdd__p37 89144.9
Rw784 vdd__p26 vdd__p4 103629
Rw785 vdd__p26 vdd__p5 20374.6
Rw786 vdd__p27 vdd__p28 261.981
Rw787 vdd__p27 vdd__p29 1200.14
Rw788 vdd__p27 vdd__p3 22232.6
Rw789 vdd__p27 vdd__p30 1120.11
Rw790 vdd__p27 vdd__p31 1153.61
Rw791 vdd__p27 vdd__p32 560.134
Rw792 vdd__p27 vdd__p33 621.63
Rw793 vdd__p27 vdd__p34 1135.5
Rw794 vdd__p27 vdd__p36 408.564
Rw795 vdd__p27 vdd__p37 81440.1
Rw796 vdd__p27 vdd__p4 117391
Rw797 vdd__p27 vdd__p5 23080.4
Rw798 vdd__p28 vdd__p29 1055.68
Rw799 vdd__p28 vdd__p3 25845.3
Rw800 vdd__p28 vdd__p30 985.282
Rw801 vdd__p28 vdd__p31 1014.75
Rw802 vdd__p28 vdd__p32 492.71
Rw803 vdd__p28 vdd__p33 546.803
Rw804 vdd__p28 vdd__p34 998.814
Rw805 vdd__p28 vdd__p36 359.385
Rw806 vdd__p28 vdd__p37 71637
Rw807 vdd__p28 vdd__p4 136466
Rw808 vdd__p28 vdd__p5 26830.8
Rw809 vdd__p29 vdd__p3 118398
Rw810 vdd__p29 vdd__p30 34.0053
Rw811 vdd__p29 vdd__p31 35.0223
Rw812 vdd__p29 vdd__p32 825.775
Rw813 vdd__p29 vdd__p33 916.435
Rw814 vdd__p29 vdd__p34 1674
Rw815 vdd__p29 vdd__p36 602.324
Rw816 vdd__p29 vdd__p37 2472.43
Rw817 vdd__p29 vdd__p38 983930
Rw818 vdd__p29 vdd__p4 625153
Rw819 vdd__p29 vdd__p5 122912
Rw820 vdd__p3 vdd__p30 110503
Rw821 vdd__p3 vdd__p31 113807
Rw822 vdd__p3 vdd__p32 55259.1
Rw823 vdd__p3 vdd__p33 61325.9
Rw824 vdd__p3 vdd__p34 112020
Rw825 vdd__p3 vdd__p36 40306.2
Rw826 vdd__p3 vdd__p4 372.752
Rw827 vdd__p3 vdd__p5 73.2874
Rw828 vdd__p30 vdd__p31 32.687
Rw829 vdd__p30 vdd__p32 770.712
Rw830 vdd__p30 vdd__p33 855.327
Rw831 vdd__p30 vdd__p34 1562.38
Rw832 vdd__p30 vdd__p36 562.161
Rw833 vdd__p30 vdd__p37 2075.36
Rw834 vdd__p30 vdd__p38 825911
Rw835 vdd__p30 vdd__p4 583468
Rw836 vdd__p30 vdd__p5 114717
Rw837 vdd__p31 vdd__p32 793.76
Rw838 vdd__p31 vdd__p33 880.905
Rw839 vdd__p31 vdd__p34 1609.1
Rw840 vdd__p31 vdd__p36 578.972
Rw841 vdd__p31 vdd__p37 2376.57
Rw842 vdd__p31 vdd__p38 945783
Rw843 vdd__p31 vdd__p4 600916
Rw844 vdd__p31 vdd__p5 118147
Rw845 vdd__p32 vdd__p33 267.069
Rw846 vdd__p32 vdd__p34 487.84
Rw847 vdd__p32 vdd__p36 175.53
Rw848 vdd__p32 vdd__p37 56036.2
Rw849 vdd__p32 vdd__p4 291774
Rw850 vdd__p32 vdd__p5 57366.2
Rw851 vdd__p33 vdd__p34 428.838
Rw852 vdd__p33 vdd__p36 154.301
Rw853 vdd__p33 vdd__p37 62188.3
Rw854 vdd__p33 vdd__p4 323808
Rw855 vdd__p33 vdd__p5 63664.4
Rw856 vdd__p34 vdd__p36 52.9087
Rw857 vdd__p34 vdd__p37 113596
Rw858 vdd__p34 vdd__p4 591481
Rw859 vdd__p34 vdd__p5 116292
Rw860 vdd__p36 vdd__p37 40873.1
Rw861 vdd__p36 vdd__p4 212822
Rw862 vdd__p36 vdd__p5 41843.2
Rw863 vdd__p37 vdd__p38 93.6289
Rw864 vdd__p37 vdd__p6 1310.68
Rw865 vdd__p37 vdd__p7 10887.8
Rw866 vdd__p37 vdd__p8 1552.88
Rw867 vdd__p37 vdd__p9 11565.2
Rw868 vdd__p38 vdd__p6 652.633
Rw869 vdd__p38 vdd__p7 5421.41
Rw870 vdd__p38 vdd__p8 773.233
Rw871 vdd__p38 vdd__p9 5758.72
Rw872 vdd__p4 vdd__p5 76.5135
Rw873 vdd__p6 vdd__p7 620.338
Rw874 vdd__p6 vdd__p8 88.4762
Rw875 vdd__p6 vdd__p9 658.934
Rw876 vdd__p7 vdd__p8 121.331
Rw877 vdd__p7 vdd__p9 184.683
Rw878 vdd__p8 vdd__p9 128.88
Rw879 vref vref__p0 904.248
Rw880 vref vref__p1 900.128
Rw881 vref vref__p2 684.24
Rw882 vref vref__p3 665.538
Rw883 vref vref__p4 689.98
Rw884 vref vref__p5 592.398
Rw885 vref vref__p6 584.169
Rw886 vref vref__p7 526.571
Rw887 vref vref__p8 653.311
Rw888 vref vref__p9 249.676
Rw889 vref__p0 vref__p1 270.872
Rw890 vref__p0 vref__p2 235.259
Rw891 vref__p0 vref__p3 251.747
Rw892 vref__p0 vref__p4 285.253
Rw893 vref__p0 vref__p5 270.167
Rw894 vref__p0 vref__p6 291.423
Rw895 vref__p0 vref__p7 291.428
Rw896 vref__p0 vref__p8 396.513
Rw897 vref__p0 vref__p9 312.62
Rw898 vref__p1 vref__p2 234.187
Rw899 vref__p1 vref__p3 250.6
Rw900 vref__p1 vref__p4 283.954
Rw901 vref__p1 vref__p5 268.936
Rw902 vref__p1 vref__p6 290.095
Rw903 vref__p1 vref__p7 290.1
Rw904 vref__p1 vref__p8 394.706
Rw905 vref__p1 vref__p9 311.196
Rw906 vref__p2 vref__p3 190.496
Rw907 vref__p2 vref__p4 215.85
Rw908 vref__p2 vref__p5 204.434
Rw909 vref__p2 vref__p6 220.518
Rw910 vref__p2 vref__p7 220.522
Rw911 vref__p2 vref__p8 300.039
Rw912 vref__p2 vref__p9 236.558
Rw913 vref__p3 vref__p4 209.95
Rw914 vref__p3 vref__p5 198.846
Rw915 vref__p3 vref__p6 214.491
Rw916 vref__p3 vref__p7 214.494
Rw917 vref__p3 vref__p8 291.839
Rw918 vref__p3 vref__p9 230.092
Rw919 vref__p4 vref__p5 206.149
Rw920 vref__p4 vref__p6 222.368
Rw921 vref__p4 vref__p7 222.372
Rw922 vref__p4 vref__p8 302.557
Rw923 vref__p4 vref__p9 238.543
Rw924 vref__p5 vref__p6 190.919
Rw925 vref__p5 vref__p7 190.922
Rw926 vref__p5 vref__p8 259.767
Rw927 vref__p5 vref__p9 204.806
Rw928 vref__p6 vref__p7 188.27
Rw929 vref__p6 vref__p8 256.158
Rw930 vref__p6 vref__p9 201.961
Rw931 vref__p7 vref__p8 230.902
Rw932 vref__p7 vref__p9 182.048
Rw933 vref__p8 vref__p9 225.865
Rw934 vrefl vrefl__p0 3256.26
Rw935 vrefl vrefl__p1 3050.67
Rw936 vrefl vrefl__p10 919.591
Rw937 vrefl vrefl__p11 1056.52
Rw938 vrefl vrefl__p12 2169.88
Rw939 vrefl vrefl__p13 9244.46
Rw940 vrefl vrefl__p14 4733.33
Rw941 vrefl vrefl__p15 9606.2
Rw942 vrefl vrefl__p16 10061.9
Rw943 vrefl vrefl__p17 10321.5
Rw944 vrefl vrefl__p19 25.596
Rw945 vrefl vrefl__p2 2688.63
Rw946 vrefl vrefl__p3 2262.78
Rw947 vrefl vrefl__p4 1842.79
Rw948 vrefl vrefl__p5 1468.21
Rw949 vrefl vrefl__p6 1153.53
Rw950 vrefl vrefl__p7 898.495
Rw951 vrefl vrefl__p8 696.177
Rw952 vrefl vrefl__p9 188.414
Rw953 vrefl__p0 vrefl__p1 104.365
Rw954 vrefl__p0 vrefl__p10 17915.9
Rw955 vrefl__p0 vrefl__p11 20583.6
Rw956 vrefl__p0 vrefl__p12 42274.6
Rw957 vrefl__p0 vrefl__p13 180105
Rw958 vrefl__p0 vrefl__p14 92217
Rw959 vrefl__p0 vrefl__p15 187153
Rw960 vrefl__p0 vrefl__p16 196030
Rw961 vrefl__p0 vrefl__p17 201088
Rw962 vrefl__p0 vrefl__p19 2490.91
Rw963 vrefl__p0 vrefl__p2 134.38
Rw964 vrefl__p0 vrefl__p3 171.858
Rw965 vrefl__p0 vrefl__p4 217.37
Rw966 vrefl__p0 vrefl__p5 270.126
Rw967 vrefl__p0 vrefl__p6 326.704
Rw968 vrefl__p0 vrefl__p7 379.857
Rw969 vrefl__p0 vrefl__p8 418.886
Rw970 vrefl__p0 vrefl__p9 3670.77
Rw971 vrefl__p1 vrefl__p10 16784.8
Rw972 vrefl__p1 vrefl__p11 19284
Rw973 vrefl__p1 vrefl__p12 39605.5
Rw974 vrefl__p1 vrefl__p13 168734
Rw975 vrefl__p1 vrefl__p14 86394.7
Rw976 vrefl__p1 vrefl__p15 175336
Rw977 vrefl__p1 vrefl__p16 183653
Rw978 vrefl__p1 vrefl__p17 188392
Rw979 vrefl__p1 vrefl__p19 2333.64
Rw980 vrefl__p1 vrefl__p2 125.896
Rw981 vrefl__p1 vrefl__p3 161.007
Rw982 vrefl__p1 vrefl__p4 203.646
Rw983 vrefl__p1 vrefl__p5 253.071
Rw984 vrefl__p1 vrefl__p6 306.077
Rw985 vrefl__p1 vrefl__p7 355.874
Rw986 vrefl__p1 vrefl__p8 392.439
Rw987 vrefl__p1 vrefl__p9 3439.01
Rw988 vrefl__p10 vrefl__p11 85.8062
Rw989 vrefl__p10 vrefl__p12 176.229
Rw990 vrefl__p10 vrefl__p13 750.799
Rw991 vrefl__p10 vrefl__p14 384.423
Rw992 vrefl__p10 vrefl__p15 780.178
Rw993 vrefl__p10 vrefl__p16 817.185
Rw994 vrefl__p10 vrefl__p17 838.271
Rw995 vrefl__p10 vrefl__p19 703.452
Rw996 vrefl__p10 vrefl__p2 14792.8
Rw997 vrefl__p10 vrefl__p3 12449.8
Rw998 vrefl__p10 vrefl__p4 10139
Rw999 vrefl__p10 vrefl__p5 8078.06
Rw1000 vrefl__p10 vrefl__p6 6346.72
Rw1001 vrefl__p10 vrefl__p7 4943.52
Rw1002 vrefl__p10 vrefl__p8 3830.36
Rw1003 vrefl__p10 vrefl__p9 93.4324
Rw1004 vrefl__p11 vrefl__p12 154.064
Rw1005 vrefl__p11 vrefl__p13 656.368
Rw1006 vrefl__p11 vrefl__p14 336.072
Rw1007 vrefl__p11 vrefl__p15 682.052
Rw1008 vrefl__p11 vrefl__p16 714.404
Rw1009 vrefl__p11 vrefl__p17 732.839
Rw1010 vrefl__p11 vrefl__p19 808.195
Rw1011 vrefl__p11 vrefl__p2 16995.5
Rw1012 vrefl__p11 vrefl__p3 14303.6
Rw1013 vrefl__p11 vrefl__p4 11648.7
Rw1014 vrefl__p11 vrefl__p5 9280.87
Rw1015 vrefl__p11 vrefl__p6 7291.74
Rw1016 vrefl__p11 vrefl__p7 5679.6
Rw1017 vrefl__p11 vrefl__p8 4400.7
Rw1018 vrefl__p11 vrefl__p9 107.344
Rw1019 vrefl__p12 vrefl__p13 1107.63
Rw1020 vrefl__p12 vrefl__p14 567.128
Rw1021 vrefl__p12 vrefl__p15 1150.98
Rw1022 vrefl__p12 vrefl__p16 1205.57
Rw1023 vrefl__p12 vrefl__p17 1236.68
Rw1024 vrefl__p12 vrefl__p19 1659.87
Rw1025 vrefl__p12 vrefl__p2 34905.3
Rw1026 vrefl__p12 vrefl__p3 29376.7
Rw1027 vrefl__p12 vrefl__p4 23924.1
Rw1028 vrefl__p12 vrefl__p5 19061.1
Rw1029 vrefl__p12 vrefl__p6 14975.8
Rw1030 vrefl__p12 vrefl__p7 11664.8
Rw1031 vrefl__p12 vrefl__p8 9038.16
Rw1032 vrefl__p12 vrefl__p9 220.464
Rw1033 vrefl__p13 vrefl__p14 129.075
Rw1034 vrefl__p13 vrefl__p15 171.864
Rw1035 vrefl__p13 vrefl__p16 180.791
Rw1036 vrefl__p13 vrefl__p17 185.456
Rw1037 vrefl__p13 vrefl__p19 7071.65
Rw1038 vrefl__p13 vrefl__p2 148709
Rw1039 vrefl__p13 vrefl__p3 125155
Rw1040 vrefl__p13 vrefl__p4 101925
Rw1041 vrefl__p13 vrefl__p5 81207
Rw1042 vrefl__p13 vrefl__p6 63802.3
Rw1043 vrefl__p13 vrefl__p7 49696.1
Rw1044 vrefl__p13 vrefl__p8 38505.8
Rw1045 vrefl__p13 vrefl__p9 939.256
Rw1046 vrefl__p14 vrefl__p15 133.994
Rw1047 vrefl__p14 vrefl__p16 140.333
Rw1048 vrefl__p14 vrefl__p17 143.954
Rw1049 vrefl__p14 vrefl__p19 3620.81
Rw1050 vrefl__p14 vrefl__p2 76141.8
Rw1051 vrefl__p14 vrefl__p3 64081.8
Rw1052 vrefl__p14 vrefl__p4 52187.7
Rw1053 vrefl__p14 vrefl__p5 41579.5
Rw1054 vrefl__p14 vrefl__p6 32667.9
Rw1055 vrefl__p14 vrefl__p7 25445.3
Rw1056 vrefl__p14 vrefl__p8 19715.7
Rw1057 vrefl__p14 vrefl__p9 480.916
Rw1058 vrefl__p15 vrefl__p16 164.699
Rw1059 vrefl__p15 vrefl__p17 168.949
Rw1060 vrefl__p15 vrefl__p19 7348.37
Rw1061 vrefl__p15 vrefl__p2 154528
Rw1062 vrefl__p15 vrefl__p3 130053
Rw1063 vrefl__p15 vrefl__p4 105914
Rw1064 vrefl__p15 vrefl__p5 84384.7
Rw1065 vrefl__p15 vrefl__p6 66298.9
Rw1066 vrefl__p15 vrefl__p7 51640.8
Rw1067 vrefl__p15 vrefl__p8 40012.6
Rw1068 vrefl__p15 vrefl__p9 976.01
Rw1069 vrefl__p16 vrefl__p17 153.904
Rw1070 vrefl__p16 vrefl__p19 7696.93
Rw1071 vrefl__p16 vrefl__p2 161858
Rw1072 vrefl__p16 vrefl__p3 136222
Rw1073 vrefl__p16 vrefl__p4 110938
Rw1074 vrefl__p16 vrefl__p5 88387.4
Rw1075 vrefl__p16 vrefl__p6 69443.7
Rw1076 vrefl__p16 vrefl__p7 54090.3
Rw1077 vrefl__p16 vrefl__p8 41910.5
Rw1078 vrefl__p16 vrefl__p9 1022.31
Rw1079 vrefl__p17 vrefl__p19 7895.54
Rw1080 vrefl__p17 vrefl__p2 166035
Rw1081 vrefl__p17 vrefl__p3 139737
Rw1082 vrefl__p17 vrefl__p4 113800
Rw1083 vrefl__p17 vrefl__p5 90668.1
Rw1084 vrefl__p17 vrefl__p6 71235.6
Rw1085 vrefl__p17 vrefl__p7 55486
Rw1086 vrefl__p17 vrefl__p8 42992
Rw1087 vrefl__p17 vrefl__p9 1048.69
Rw1088 vrefl__p19 vrefl__p2 2056.7
Rw1089 vrefl__p19 vrefl__p3 1730.94
Rw1090 vrefl__p19 vrefl__p4 1409.66
Rw1091 vrefl__p19 vrefl__p5 1123.12
Rw1092 vrefl__p19 vrefl__p6 882.407
Rw1093 vrefl__p19 vrefl__p7 687.314
Rw1094 vrefl__p19 vrefl__p8 532.548
Rw1095 vrefl__p19 vrefl__p9 144.129
Rw1096 vrefl__p2 vrefl__p3 141.9
Rw1097 vrefl__p2 vrefl__p4 179.478
Rw1098 vrefl__p2 vrefl__p5 223.038
Rw1099 vrefl__p2 vrefl__p6 269.753
Rw1100 vrefl__p2 vrefl__p7 313.641
Rw1101 vrefl__p2 vrefl__p8 345.866
Rw1102 vrefl__p2 vrefl__p9 3030.88
Rw1103 vrefl__p3 vrefl__p4 151.051
Rw1104 vrefl__p3 vrefl__p5 187.711
Rw1105 vrefl__p3 vrefl__p6 227.028
Rw1106 vrefl__p3 vrefl__p7 263.964
Rw1107 vrefl__p3 vrefl__p8 291.085
Rw1108 vrefl__p3 vrefl__p9 2550.83
Rw1109 vrefl__p4 vrefl__p5 152.87
Rw1110 vrefl__p4 vrefl__p6 184.889
Rw1111 vrefl__p4 vrefl__p7 214.97
Rw1112 vrefl__p4 vrefl__p8 237.057
Rw1113 vrefl__p4 vrefl__p9 2077.37
Rw1114 vrefl__p5 vrefl__p6 147.307
Rw1115 vrefl__p5 vrefl__p7 171.273
Rw1116 vrefl__p5 vrefl__p8 188.87
Rw1117 vrefl__p5 vrefl__p9 1655.1
Rw1118 vrefl__p6 vrefl__p7 134.565
Rw1119 vrefl__p6 vrefl__p8 148.391
Rw1120 vrefl__p6 vrefl__p9 1300.37
Rw1121 vrefl__p7 vrefl__p8 115.583
Rw1122 vrefl__p7 vrefl__p9 1012.87
Rw1123 vrefl__p8 vrefl__p9 784.798
Rw1124 xc4_din xc4_din__p1 47.9542
Rw1125 xc4_din xc4_din__p2 339.284
Rw1126 xc4_din__p1 xc4_din__p2 90.493
Rw1127 xc4_dip xc4_dip__p1 46.5251
Rw1128 xc4_dip xc4_dip__p2 277.868
Rw1129 xc4_dip__p1 xc4_dip__p2 80.3173
Rw1130 xc4_lt xc4_lt__p1 10.8365
Rw1131 xc4_lt xc4_lt__p2 12.6193
Rw1132 xc4_lt__p1 xc4_lt__p2 120.796
Rw1133 xc4_outnb xc4_outnb__p1 47.3382
Rw1134 xc4_outpb xc4_outpb__p1 47.3382
Rw1135 xc4_xs1_tail xc4_xs1_tail__p1 67.1779
Rw1136 xc4_xs1_tail xc4_xs1_tail__p2 120.536
Rw1137 xc4_xs1_tail__p1 xc4_xs1_tail__p2 254.242
Rw1138 xc4_xs1_tail0 xc4_xs1_tail0__p1 29.2884
Rw1139 xc5_din xc5_din__p1 214.575
Rw1140 xc5_din xc5_din__p2 53.4467
Rw1141 xc5_din__p1 xc5_din__p2 144.493
Rw1142 xc5_dip xc5_dip__p1 121.21
Rw1143 xc5_dip xc5_dip__p2 60.0692
Rw1144 xc5_dip__p1 xc5_dip__p2 84.3382
Rw1145 xc5_lt xc5_lt__p1 162.559
Rw1146 xc5_lt xc5_lt__p2 170.36
Rw1147 xc5_lt__p1 xc5_lt__p2 20.9602
Rw1148 xc5_outnb xc5_outnb__p1 44.1702
Rw1149 xc5_outpb xc5_outpb__p1 44.1702
Rw1150 xc5_xs1_tail xc5_xs1_tail__p1 19.0043
Rw1151 xc5_xs1_tail__p1 xc5_xs1_tail__p2 64.086
Rw1152 xc5_xs1_tail0 xc5_xs1_tail0__p1 29.0647
Rw1153 xs0n_cbn xs0n_cbn__p1 1089.56
Rw1154 xs0n_cbn xs0n_cbn__p2 16589.4
Rw1155 xs0n_cbn xs0n_cbn__p3 784.446
Rw1156 xs0n_cbn xs0n_cbn__p4 21.0451
Rw1157 xs0n_cbn__p1 xs0n_cbn__p2 9.96169
Rw1158 xs0n_cbn__p1 xs0n_cbn__p3 1561.64
Rw1159 xs0n_cbn__p1 xs0n_cbn__p4 21.0507
Rw1160 xs0n_cbn__p2 xs0n_cbn__p3 23777.3
Rw1161 xs0n_cbn__p2 xs0n_cbn__p4 320.514
Rw1162 xs0n_cbn__p3 xs0n_cbn__p4 30.1636
Rw1163 xs0n_cbp xs0n_cbp__p1 9.57598
Rw1164 xs0n_cbp xs0n_cbp__p2 59.1671
Rw1165 xs0n_cbp__p1 xs0n_cbp__p2 1243.71
Rw1166 xs0n_g xs0n_g__p1 0.67694
Rw1167 xs0n_g__p1 xs0n_g__p2 25.2118
Rw1168 xs0n_g__p1 xs0n_g__p3 209.923
Rw1169 xs0n_g__p1 xs0n_g__p4 198.15
Rw1170 xs0n_g__p1 xs0n_g__p5 133.079
Rw1171 xs0n_g__p2 xs0n_g__p3 167.588
Rw1172 xs0n_g__p2 xs0n_g__p4 158.189
Rw1173 xs0n_g__p2 xs0n_g__p5 106.241
Rw1174 xs0n_g__p3 xs0n_g__p4 23.6529
Rw1175 xs0n_g__p3 xs0n_g__p5 102.437
Rw1176 xs0n_g__p4 xs0n_g__p5 96.6917
Rw1177 xs0n_n10 xs0n_n10__p1 46.1685
Rw1178 xs0n_x xs0n_x__p1 1.00108
Rw1179 xs0n_x xs0n_x__p2 42.4395
Rw1180 xs0n_x xs0n_x__p3 126.624
Rw1181 xs0n_x__p1 xs0n_x__p2 60.0491
Rw1182 xs0n_x__p1 xs0n_x__p3 179.165
Rw1183 xs0n_x__p2 xs0n_x__p3 61.5879
Rw1184 xs0p_cbn xs0p_cbn__p1 90.3104
Rw1185 xs0p_cbn xs0p_cbn__p2 2073.02
Rw1186 xs0p_cbn xs0p_cbn__p3 36.3159
Rw1187 xs0p_cbn xs0p_cbn__p4 107.321
Rw1188 xs0p_cbn__p1 xs0p_cbn__p2 9.87285
Rw1189 xs0p_cbn__p1 xs0p_cbn__p3 160.393
Rw1190 xs0p_cbn__p1 xs0p_cbn__p4 26.4214
Rw1191 xs0p_cbn__p2 xs0p_cbn__p3 3681.73
Rw1192 xs0p_cbn__p2 xs0p_cbn__p4 606.486
Rw1193 xs0p_cbn__p3 xs0p_cbn__p4 190.604
Rw1194 xs0p_cbp xs0p_cbp__p1 9.5749
Rw1195 xs0p_cbp xs0p_cbp__p2 60.089
Rw1196 xs0p_cbp__p1 xs0p_cbp__p2 1263.09
Rw1197 xs0p_g xs0p_g__p1 0.67694
Rw1198 xs0p_g__p1 xs0p_g__p2 25.2118
Rw1199 xs0p_g__p1 xs0p_g__p3 209.923
Rw1200 xs0p_g__p1 xs0p_g__p4 198.15
Rw1201 xs0p_g__p1 xs0p_g__p5 133.079
Rw1202 xs0p_g__p2 xs0p_g__p3 167.588
Rw1203 xs0p_g__p2 xs0p_g__p4 158.189
Rw1204 xs0p_g__p2 xs0p_g__p5 106.241
Rw1205 xs0p_g__p3 xs0p_g__p4 23.6529
Rw1206 xs0p_g__p3 xs0p_g__p5 102.437
Rw1207 xs0p_g__p4 xs0p_g__p5 96.6917
Rw1208 xs0p_n10 xs0p_n10__p1 46.1685
Rw1209 xs0p_x xs0p_x__p1 1.00105
Rw1210 xs0p_x xs0p_x__p2 42.5398
Rw1211 xs0p_x xs0p_x__p3 126.923
Rw1212 xs0p_x__p1 xs0p_x__p2 60.1909
Rw1213 xs0p_x__p1 xs0p_x__p3 179.588
Rw1214 xs0p_x__p2 xs0p_x__p3 61.4978
Rw1215 xs1n_cbn xs1n_cbn__p1 2014.59
Rw1216 xs1n_cbn xs1n_cbn__p2 83669.4
Rw1217 xs1n_cbn xs1n_cbn__p3 778.144
Rw1218 xs1n_cbn xs1n_cbn__p4 20.8348
Rw1219 xs1n_cbn__p1 xs1n_cbn__p2 9.8245
Rw1220 xs1n_cbn__p1 xs1n_cbn__p3 2889.51
Rw1221 xs1n_cbn__p1 xs1n_cbn__p4 19.1605
Rw1222 xs1n_cbn__p2 xs1n_cbn__p3 120006
Rw1223 xs1n_cbn__p2 xs1n_cbn__p4 795.767
Rw1224 xs1n_cbn__p3 xs1n_cbn__p4 29.8832
Rw1225 xs1n_cbp xs1n_cbp__p1 9.54403
Rw1226 xs1n_cbp xs1n_cbp__p2 58.9697
Rw1227 xs1n_cbp__p1 xs1n_cbp__p2 1323.9
Rw1228 xs1n_g xs1n_g__p1 0.6347
Rw1229 xs1n_g__p1 xs1n_g__p2 25.0282
Rw1230 xs1n_g__p1 xs1n_g__p3 227.075
Rw1231 xs1n_g__p1 xs1n_g__p4 204.371
Rw1232 xs1n_g__p1 xs1n_g__p5 130.835
Rw1233 xs1n_g__p2 xs1n_g__p3 181.724
Rw1234 xs1n_g__p2 xs1n_g__p4 163.555
Rw1235 xs1n_g__p2 xs1n_g__p5 104.705
Rw1236 xs1n_g__p3 xs1n_g__p4 24.22
Rw1237 xs1n_g__p3 xs1n_g__p5 104.731
Rw1238 xs1n_g__p4 xs1n_g__p5 94.2599
Rw1239 xs1n_n10 xs1n_n10__p1 46.209
Rw1240 xs1n_x xs1n_x__p1 1.00108
Rw1241 xs1n_x xs1n_x__p2 42.4395
Rw1242 xs1n_x xs1n_x__p3 126.624
Rw1243 xs1n_x__p1 xs1n_x__p2 60.0491
Rw1244 xs1n_x__p1 xs1n_x__p3 179.165
Rw1245 xs1n_x__p2 xs1n_x__p3 61.5879
Rw1246 xs1p_cbn xs1p_cbn__p1 90.6795
Rw1247 xs1p_cbn xs1p_cbn__p2 1917.8
Rw1248 xs1p_cbn xs1p_cbn__p3 36.2644
Rw1249 xs1p_cbn xs1p_cbn__p4 107.009
Rw1250 xs1p_cbn__p1 xs1p_cbn__p2 9.94467
Rw1251 xs1p_cbn__p1 xs1p_cbn__p3 161.481
Rw1252 xs1p_cbn__p1 xs1p_cbn__p4 26.5667
Rw1253 xs1p_cbn__p2 xs1p_cbn__p3 3415.2
Rw1254 xs1p_cbn__p2 xs1p_cbn__p4 561.866
Rw1255 xs1p_cbn__p3 xs1p_cbn__p4 190.561
Rw1256 xs1p_cbp xs1p_cbp__p1 9.54302
Rw1257 xs1p_cbp xs1p_cbp__p2 59.8889
Rw1258 xs1p_cbp__p1 xs1p_cbp__p2 1344.53
Rw1259 xs1p_g xs1p_g__p1 0.6347
Rw1260 xs1p_g__p1 xs1p_g__p2 25.0282
Rw1261 xs1p_g__p1 xs1p_g__p3 227.075
Rw1262 xs1p_g__p1 xs1p_g__p4 204.371
Rw1263 xs1p_g__p1 xs1p_g__p5 130.835
Rw1264 xs1p_g__p2 xs1p_g__p3 181.724
Rw1265 xs1p_g__p2 xs1p_g__p4 163.555
Rw1266 xs1p_g__p2 xs1p_g__p5 104.705
Rw1267 xs1p_g__p3 xs1p_g__p4 24.22
Rw1268 xs1p_g__p3 xs1p_g__p5 104.731
Rw1269 xs1p_g__p4 xs1p_g__p5 94.2599
Rw1270 xs1p_n10 xs1p_n10__p1 46.209
Rw1271 xs1p_x xs1p_x__p1 1.00105
Rw1272 xs1p_x xs1p_x__p2 42.5398
Rw1273 xs1p_x xs1p_x__p3 126.923
Rw1274 xs1p_x__p1 xs1p_x__p2 60.1909
Rw1275 xs1p_x__p1 xs1p_x__p3 179.588
Rw1276 xs1p_x__p2 xs1p_x__p3 61.4978
Cp0 bn0 bn1 2.621e-16
Cp1 bn0 bn10 4.539e-17
Cp2 bn0 bn11 4.486e-17
Cp3 bn0 bn12 6.037e-17
Cp4 bn0 bn2 7.057e-15
Cp5 bn0 bn3 2.248e-16
Cp6 bn0 bn4 2.663e-16
Cp7 bn0 bn5 1.004e-15
Cp8 bn0 bn6 9.648e-16
Cp9 bn0 bn7 1.72e-15
Cp10 bn0 bn8 4.759e-17
Cp11 bn0 bn9 4.682e-17
Cp12 bn0 bp11 1.837e-16
Cp13 bn0 bp12 6.813e-16
Cp14 bn0 cn0 5.873e-16
Cp15 bn0 cn1 7.702e-17
Cp16 bn0 cn2 2.003e-19
Cp17 bn0 gnd 3.561e-15
Cp18 bn0 lsb_n 1.472e-16
Cp19 bn0 lsb_p 9.068e-17
Cp20 bn0 rstb 7.084e-17
Cp21 bn0 vdd 1.51e-16
Cp22 bn0 vrefl 3.905e-16
Cp23 bn0 xc4_din 5.426e-17
Cp24 bn0 xc4_dip 2.665e-16
Cp25 bn0 xc4_outnb 5.431e-19
Cp26 bn1 bn10 7.366e-17
Cp27 bn1 bn11 5.327e-16
Cp28 bn1 bn12 5.054e-16
Cp29 bn1 bn2 1.007e-15
Cp30 bn1 bn3 8.081e-16
Cp31 bn1 bn4 5.043e-16
Cp32 bn1 bn5 1.047e-15
Cp33 bn1 bn6 1.98e-15
Cp34 bn1 bn7 1.573e-15
Cp35 bn1 bn8 5.488e-17
Cp36 bn1 bn9 5.508e-17
Cp37 bn1 bp12 1.302e-17
Cp38 bn1 cn1 2.505e-16
Cp39 bn1 cn2 1.529e-16
Cp40 bn1 gnd 2.387e-15
Cp41 bn1 lsb_n 1.641e-16
Cp42 bn1 lsb_p 9.778e-17
Cp43 bn1 rstb 7.703e-17
Cp44 bn1 vdd 3.148e-16
Cp45 bn1 vrefl 3.954e-16
Cp46 bn1 xc4_din 9.7e-17
Cp47 bn1 xc4_dip 1.489e-15
Cp48 bn1 xc4_outnb 1.049e-18
Cp49 bn10 bn11 2.092e-14
Cp50 bn10 bn12 6.425e-15
Cp51 bn10 bn2 3.845e-17
Cp52 bn10 bn3 3.845e-17
Cp53 bn10 bn4 3.845e-17
Cp54 bn10 bn5 4.892e-16
Cp55 bn10 bn6 2.083e-15
Cp56 bn10 bn7 2.302e-15
Cp57 bn10 bn8 1.116e-15
Cp58 bn10 bn9 1.299e-14
Cp59 bn10 bp0 4.911e-17
Cp60 bn10 bp1 4.662e-17
Cp61 bn10 bp10 2.248e-15
Cp62 bn10 bp11 5.482e-17
Cp63 bn10 bp12 9.046e-17
Cp64 bn10 bp2 4.145e-17
Cp65 bn10 bp3 3.846e-17
Cp66 bn10 bp4 3.882e-17
Cp67 bn10 bp5 3.882e-17
Cp68 bn10 bp6 3.882e-17
Cp69 bn10 bp7 3.882e-17
Cp70 bn10 bp8 2.021e-16
Cp71 bn10 bp9 7.85e-17
Cp72 bn10 cn10 1.842e-16
Cp73 bn10 cn11 6.948e-16
Cp74 bn10 cn12 1.311e-18
Cp75 bn10 cn8 8.374e-18
Cp76 bn10 cn9 1.469e-17
Cp77 bn10 gnd 4.854e-15
Cp78 bn10 lsb_n 6.709e-16
Cp79 bn10 lsb_p 3.103e-16
Cp80 bn10 rstb 4.807e-17
Cp81 bn10 vdd 4.482e-17
Cp82 bn10 vref 7.16e-16
Cp83 bn10 vrefl 1.039e-15
Cp84 bn10 xc4_din 7.739e-17
Cp85 bn10 xc4_dip 3.425e-17
Cp86 bn10 xc4_xs1_tail 1.502e-19
Cp87 bn11 bn12 3.362e-14
Cp88 bn11 bn2 3.792e-17
Cp89 bn11 bn3 3.792e-17
Cp90 bn11 bn4 3.792e-17
Cp91 bn11 bn5 6.931e-17
Cp92 bn11 bn6 2.969e-15
Cp93 bn11 bn7 3.341e-15
Cp94 bn11 bn8 5.339e-16
Cp95 bn11 bn9 7.952e-16
Cp96 bn11 bp0 9.649e-17
Cp97 bn11 bp1 3.792e-17
Cp98 bn11 bp10 5.726e-16
Cp99 bn11 bp11 4.595e-15
Cp100 bn11 bp12 1.595e-16
Cp101 bn11 bp2 3.275e-17
Cp102 bn11 bp3 3.846e-17
Cp103 bn11 bp4 4.971e-17
Cp104 bn11 bp5 4.698e-16
Cp105 bn11 bp6 4.754e-16
Cp106 bn11 bp7 5.071e-17
Cp107 bn11 bp8 1.873e-16
Cp108 bn11 bp9 2.238e-16
Cp109 bn11 cn10 4.904e-16
Cp110 bn11 cn11 9.808e-17
Cp111 bn11 cn12 2.263e-19
Cp112 bn11 cn8 6.239e-18
Cp113 bn11 cn9 4.157e-17
Cp114 bn11 gnd 5.864e-15
Cp115 bn11 lsb_n 6.01e-16
Cp116 bn11 lsb_p 1.053e-16
Cp117 bn11 rstb 5.76e-17
Cp118 bn11 vdd 5.146e-17
Cp119 bn11 vref 7.986e-16
Cp120 bn11 vrefl 1.245e-16
Cp121 bn11 xc4_din 6.779e-16
Cp122 bn11 xc4_dip 1.419e-17
Cp123 bn12 bn2 3.882e-17
Cp124 bn12 bn3 3.882e-17
Cp125 bn12 bn4 3.882e-17
Cp126 bn12 bn5 4.317e-17
Cp127 bn12 bn6 5.075e-15
Cp128 bn12 bn7 5.505e-15
Cp129 bn12 bn8 1.244e-15
Cp130 bn12 bn9 3.1e-15
Cp131 bn12 bp0 4.93e-16
Cp132 bn12 bp1 4.199e-16
Cp133 bn12 bp10 3.478e-16
Cp134 bn12 bp11 6.229e-16
Cp135 bn12 bp12 1.038e-14
Cp136 bn12 bp2 4.482e-17
Cp137 bn12 bp3 3.104e-16
Cp138 bn12 bp4 5.713e-16
Cp139 bn12 bp5 8.047e-17
Cp140 bn12 bp6 7.773e-17
Cp141 bn12 bp7 5.569e-16
Cp142 bn12 bp8 8.083e-16
Cp143 bn12 bp9 8.832e-16
Cp144 bn12 cn10 2.336e-16
Cp145 bn12 cn11 4.689e-17
Cp146 bn12 cn12 1.127e-16
Cp147 bn12 cn9 1.38e-19
Cp148 bn12 cp11 2.231e-18
Cp149 bn12 cp12 6.343e-19
Cp150 bn12 gnd 8.124e-15
Cp151 bn12 lsb_n 1.732e-14
Cp152 bn12 lsb_p 3.994e-16
Cp153 bn12 rstb 2.01e-16
Cp154 bn12 top_n 1.311e-17
Cp155 bn12 vdd 3.388e-17
Cp156 bn12 vref 1.533e-15
Cp157 bn12 vrefl 1.047e-16
Cp158 bn12 xc4_din 7.893e-17
Cp159 bn12 xc4_xs1_tail 1.502e-19
Cp160 bn2 bn3 1.446e-14
Cp161 bn2 bn4 4.308e-16
Cp162 bn2 bn5 3.373e-15
Cp163 bn2 bn6 1.877e-15
Cp164 bn2 bn7 2.699e-15
Cp165 bn2 bn8 4.065e-17
Cp166 bn2 bn9 3.988e-17
Cp167 bn2 bp0 5.211e-16
Cp168 bn2 bp1 4.677e-16
Cp169 bn2 bp10 4.595e-17
Cp170 bn2 bp11 4.598e-17
Cp171 bn2 bp12 3.024e-17
Cp172 bn2 bp2 5.659e-17
Cp173 bn2 bp3 4.685e-17
Cp174 bn2 bp4 4.632e-17
Cp175 bn2 bp5 4.632e-17
Cp176 bn2 bp6 4.632e-17
Cp177 bn2 bp7 4.632e-17
Cp178 bn2 bp8 4.776e-17
Cp179 bn2 bp9 4.542e-17
Cp180 bn2 cn2 2.505e-16
Cp181 bn2 cn3 1.53e-16
Cp182 bn2 gnd 3.475e-15
Cp183 bn2 lsb_n 1.427e-16
Cp184 bn2 lsb_p 1.419e-16
Cp185 bn2 rstb 7.711e-17
Cp186 bn2 vdd 1.511e-16
Cp187 bn2 vrefl 3.948e-16
Cp188 bn2 xc4_din 5.831e-17
Cp189 bn2 xc4_dip 4.205e-16
Cp190 bn2 xc4_outnb 1.049e-18
Cp191 bn3 bn4 2.364e-14
Cp192 bn3 bn5 5.932e-15
Cp193 bn3 bn6 3.469e-15
Cp194 bn3 bn7 3.98e-15
Cp195 bn3 bn8 4.065e-17
Cp196 bn3 bn9 3.988e-17
Cp197 bn3 bp0 4.399e-17
Cp198 bn3 bp1 3.601e-17
Cp199 bn3 bp10 3.845e-17
Cp200 bn3 bp11 3.849e-17
Cp201 bn3 bp12 3.024e-17
Cp202 bn3 bp2 3.845e-17
Cp203 bn3 bp3 3.935e-17
Cp204 bn3 bp4 3.882e-17
Cp205 bn3 bp5 3.882e-17
Cp206 bn3 bp6 7.995e-17
Cp207 bn3 bp7 6.755e-16
Cp208 bn3 bp8 4.026e-17
Cp209 bn3 bp9 3.792e-17
Cp210 bn3 cn3 2.505e-16
Cp211 bn3 cn4 1.53e-16
Cp212 bn3 gnd 4.559e-15
Cp213 bn3 lsb_n 2.164e-16
Cp214 bn3 lsb_p 4.352e-16
Cp215 bn3 rstb 7.703e-17
Cp216 bn3 vdd 2.521e-16
Cp217 bn3 vrefl 3.954e-16
Cp218 bn3 xc4_din 9.656e-17
Cp219 bn3 xc4_dip 5.459e-16
Cp220 bn3 xc4_outnb 6.181e-19
Cp221 bn4 bn5 3.796e-14
Cp222 bn4 bn6 5.494e-15
Cp223 bn4 bn7 5.632e-15
Cp224 bn4 bn8 5.675e-16
Cp225 bn4 bn9 2.682e-16
Cp226 bn4 bp0 3.777e-17
Cp227 bn4 bp1 3.601e-17
Cp228 bn4 bp10 4.598e-17
Cp229 bn4 bp11 3.849e-17
Cp230 bn4 bp12 3.024e-17
Cp231 bn4 bp2 3.845e-17
Cp232 bn4 bp3 3.181e-16
Cp233 bn4 bp4 6.238e-16
Cp234 bn4 bp5 8.256e-17
Cp235 bn4 bp6 3.882e-17
Cp236 bn4 bp7 2.969e-17
Cp237 bn4 bp8 5.161e-16
Cp238 bn4 bp9 4.129e-16
Cp239 bn4 cn4 2.505e-16
Cp240 bn4 cn5 1.53e-16
Cp241 bn4 gnd 5.061e-15
Cp242 bn4 lsb_n 1.971e-16
Cp243 bn4 lsb_p 1.382e-16
Cp244 bn4 rstb 7.703e-17
Cp245 bn4 vdd 5.801e-16
Cp246 bn4 vrefl 3.954e-16
Cp247 bn4 xc4_din 9.768e-17
Cp248 bn4 xc4_dip 5.388e-16
Cp249 bn5 bn6 1.213e-14
Cp250 bn5 bn7 1.74e-14
Cp251 bn5 bn8 1.194e-16
Cp252 bn5 bn9 3.529e-16
Cp253 bn5 bp0 9.703e-17
Cp254 bn5 bp1 9.466e-17
Cp255 bn5 bp10 5.215e-16
Cp256 bn5 bp11 2.356e-16
Cp257 bn5 bp12 4.034e-17
Cp258 bn5 bp2 5.141e-16
Cp259 bn5 bp3 2.481e-16
Cp260 bn5 bp4 4.992e-17
Cp261 bn5 bp5 4.665e-16
Cp262 bn5 bp6 4.717e-16
Cp263 bn5 bp7 5.137e-17
Cp264 bn5 bp8 9.334e-17
Cp265 bn5 bp9 1.033e-16
Cp266 bn5 cn5 2.505e-16
Cp267 bn5 cn6 1.53e-16
Cp268 bn5 gnd 1.028e-14
Cp269 bn5 lsb_n 5.513e-16
Cp270 bn5 lsb_p 3.329e-16
Cp271 bn5 rstb 7.703e-17
Cp272 bn5 top_n 1.26e-19
Cp273 bn5 top_p 7.569e-18
Cp274 bn5 vdd 4.232e-16
Cp275 bn5 vrefl 3.954e-16
Cp276 bn5 xc4_din 1.012e-16
Cp277 bn5 xc4_dip 5.796e-16
Cp278 bn5 xs1n_cbp 2.091e-19
Cp279 bn5 xs1n_n10 1.712e-18
Cp280 bn6 bn7 1.163e-14
Cp281 bn6 bn8 7.423e-16
Cp282 bn6 bn9 1.994e-15
Cp283 bn6 bp0 6.733e-16
Cp284 bn6 bp1 5.426e-16
Cp285 bn6 bp10 6.568e-16
Cp286 bn6 bp11 5.943e-16
Cp287 bn6 bp12 8.15e-16
Cp288 bn6 bp2 6.364e-16
Cp289 bn6 bp3 6.091e-16
Cp290 bn6 bp4 9.209e-16
Cp291 bn6 bp5 5.852e-16
Cp292 bn6 bp6 5.901e-16
Cp293 bn6 bp7 8.532e-16
Cp294 bn6 bp8 6.868e-16
Cp295 bn6 bp9 5.326e-16
Cp296 bn6 cn6 2.505e-16
Cp297 bn6 cn7 1.53e-16
Cp298 bn6 gnd 2.873e-14
Cp299 bn6 lsb_n 1.803e-15
Cp300 bn6 lsb_p 7.002e-16
Cp301 bn6 rstb 7.73e-17
Cp302 bn6 top_n 5.775e-18
Cp303 bn6 top_p 7.569e-18
Cp304 bn6 vdd 1.362e-15
Cp305 bn6 vrefl 3.96e-16
Cp306 bn6 xc4_din 9.782e-17
Cp307 bn6 xc4_dip 3.614e-15
Cp308 bn6 xs1n_g 5.339e-19
Cp309 bn7 bn8 3.592e-15
Cp310 bn7 bn9 2.051e-15
Cp311 bn7 bp0 1.241e-15
Cp312 bn7 bp1 1.033e-15
Cp313 bn7 bp10 1.198e-15
Cp314 bn7 bp11 1.112e-15
Cp315 bn7 bp12 1.391e-15
Cp316 bn7 bp2 1.174e-15
Cp317 bn7 bp3 1.157e-15
Cp318 bn7 bp4 1.523e-15
Cp319 bn7 bp5 1.108e-15
Cp320 bn7 bp6 1.116e-15
Cp321 bn7 bp7 1.456e-15
Cp322 bn7 bp8 1.256e-15
Cp323 bn7 bp9 1.016e-15
Cp324 bn7 cn7 2.505e-16
Cp325 bn7 cn8 4.977e-17
Cp326 bn7 gnd 4.291e-14
Cp327 bn7 lsb_n 2.155e-15
Cp328 bn7 lsb_p 1.237e-15
Cp329 bn7 rstb 1.106e-16
Cp330 bn7 t0 3.223e-19
Cp331 bn7 top_n 7.174e-18
Cp332 bn7 top_p 1.514e-17
Cp333 bn7 vdd 2.345e-15
Cp334 bn7 vref 1.17e-19
Cp335 bn7 vrefl 4.117e-16
Cp336 bn7 xc4_din 4.833e-15
Cp337 bn7 xc4_dip 7.909e-16
Cp338 bn7 xs1n_n10 1.903e-19
Cp339 bn8 bn9 5.265e-15
Cp340 bn8 bp12 6.613e-18
Cp341 bn8 cn7 7.938e-19
Cp342 bn8 cn8 7.04e-16
Cp343 bn8 cn9 1.773e-17
Cp344 bn8 gnd 5.835e-15
Cp345 bn8 lsb_n 3.389e-16
Cp346 bn8 lsb_p 1.166e-15
Cp347 bn8 rstb 7.757e-17
Cp348 bn8 top_n 2.126e-16
Cp349 bn8 top_p 3.132e-18
Cp350 bn8 vdd 2.072e-16
Cp351 bn8 vref 3.238e-16
Cp352 bn8 vrefl 1.393e-16
Cp353 bn8 xc4_din 1.741e-16
Cp354 bn8 xc4_dip 5.24e-16
Cp355 bn9 bp1 5.089e-17
Cp356 bn9 bp10 6.415e-17
Cp357 bn9 bp11 4.808e-17
Cp358 bn9 bp12 4.742e-17
Cp359 bn9 bp2 5.494e-16
Cp360 bn9 bp3 2.762e-16
Cp361 bn9 bp4 4.742e-17
Cp362 bn9 bp5 4.742e-17
Cp363 bn9 bp6 4.742e-17
Cp364 bn9 bp7 4.742e-17
Cp365 bn9 bp8 9.711e-17
Cp366 bn9 bp9 1.172e-15
Cp367 bn9 cn10 1.354e-18
Cp368 bn9 cn11 1.025e-19
Cp369 bn9 cn7 1.2e-19
Cp370 bn9 cn8 5.885e-17
Cp371 bn9 cn9 5.893e-16
Cp372 bn9 gnd 4.85e-15
Cp373 bn9 lsb_n 1.58e-16
Cp374 bn9 lsb_p 1.311e-16
Cp375 bn9 rstb 4.263e-17
Cp376 bn9 vdd 1.801e-16
Cp377 bn9 vref 3.362e-16
Cp378 bn9 vrefl 1.116e-16
Cp379 bn9 xc4_din 7.848e-16
Cp380 bn9 xc4_dip 3.116e-16
Cp381 bp0 bp1 9.277e-16
Cp382 bp0 bp10 4.444e-17
Cp383 bp0 bp11 9.649e-17
Cp384 bp0 bp12 5.005e-16
Cp385 bp0 bp2 1.129e-15
Cp386 bp0 bp3 9.758e-16
Cp387 bp0 bp4 5.553e-16
Cp388 bp0 bp5 7.439e-16
Cp389 bp0 bp6 1.796e-15
Cp390 bp0 bp7 8.897e-16
Cp391 bp0 bp8 5.138e-17
Cp392 bp0 cp0 1.1e-16
Cp393 bp0 cp1 5.006e-17
Cp394 bp0 cp2 2.932e-17
Cp395 bp0 cp3 8.662e-17
Cp396 bp0 cp4 2.665e-16
Cp397 bp0 cp5 3.134e-17
Cp398 bp0 cp6 3.139e-17
Cp399 bp0 gnd 5.588e-15
Cp400 bp0 lsb_n 4.735e-17
Cp401 bp0 vdd 5.483e-16
Cp402 bp0 vrefl 2.206e-15
Cp403 bp0 xc4_din 4.264e-16
Cp404 bp1 bp10 4.195e-17
Cp405 bp1 bp11 3.792e-17
Cp406 bp1 bp12 4.274e-16
Cp407 bp1 bp2 1.008e-14
Cp408 bp1 bp3 2.467e-16
Cp409 bp1 bp4 2.976e-16
Cp410 bp1 bp5 1.351e-15
Cp411 bp1 bp6 1.206e-15
Cp412 bp1 bp7 2.272e-15
Cp413 bp1 bp8 4.889e-17
Cp414 bp1 bp9 5.089e-17
Cp415 bp1 cp0 6.041e-16
Cp416 bp1 cp1 5.482e-16
Cp417 bp1 cp2 6.466e-17
Cp418 bp1 cp3 8.155e-16
Cp419 bp1 cp4 8.788e-19
Cp420 bp1 cp5 1.242e-17
Cp421 bp1 cp6 1.285e-17
Cp422 bp1 cp7 1.024e-19
Cp423 bp1 gnd 4.148e-15
Cp424 bp1 lsb_n 4.486e-17
Cp425 bp1 vdd 3.809e-16
Cp426 bp1 vrefl 4.944e-16
Cp427 bp1 xc4_din 1.681e-16
Cp428 bp10 bp11 2.034e-14
Cp429 bp10 bp12 5.797e-15
Cp430 bp10 bp2 3.679e-17
Cp431 bp10 bp3 3.846e-17
Cp432 bp10 bp4 3.882e-17
Cp433 bp10 bp5 3.882e-17
Cp434 bp10 bp6 1.262e-15
Cp435 bp10 bp7 1.245e-15
Cp436 bp10 bp8 1.281e-15
Cp437 bp10 bp9 1.378e-14
Cp438 bp10 cn12 3.545e-19
Cp439 bp10 cp10 4.622e-16
Cp440 bp10 cp11 8.234e-17
Cp441 bp10 cp12 7.968e-17
Cp442 bp10 cp8 3.516e-17
Cp443 bp10 cp9 4.872e-16
Cp444 bp10 gnd 4.597e-15
Cp445 bp10 lsb_n 6.515e-17
Cp446 bp10 lsb_p 6.021e-16
Cp447 bp10 rstb 5.525e-17
Cp448 bp10 vdd 1.848e-16
Cp449 bp10 vref 6.304e-16
Cp450 bp10 vrefl 1.062e-15
Cp451 bp10 xc4_din 4.02e-16
Cp452 bp11 bp12 3.368e-14
Cp453 bp11 bp2 3.275e-17
Cp454 bp11 bp3 3.846e-17
Cp455 bp11 bp4 4.971e-17
Cp456 bp11 bp5 4.698e-16
Cp457 bp11 bp6 2.927e-15
Cp458 bp11 bp7 2.409e-15
Cp459 bp11 bp8 5.197e-16
Cp460 bp11 bp9 6.658e-16
Cp461 bp11 cn12 2.334e-16
Cp462 bp11 cp10 5.94e-19
Cp463 bp11 cp11 1.128e-16
Cp464 bp11 cp12 1.979e-16
Cp465 bp11 cp9 2.231e-18
Cp466 bp11 gnd 5.594e-15
Cp467 bp11 lsb_n 7.72e-17
Cp468 bp11 lsb_p 6.885e-16
Cp469 bp11 rstb 2.067e-16
Cp470 bp11 vdd 1.421e-16
Cp471 bp11 vref 1.496e-15
Cp472 bp11 vrefl 1.343e-16
Cp473 bp11 xc4_din 3.741e-16
Cp474 bp11 xc4_xs1_tail 1.502e-19
Cp475 bp12 bp2 5.232e-17
Cp476 bp12 bp3 3.179e-16
Cp477 bp12 bp4 5.788e-16
Cp478 bp12 bp5 8.797e-17
Cp479 bp12 bp6 5.779e-15
Cp480 bp12 bp7 5.302e-15
Cp481 bp12 bp8 1.224e-15
Cp482 bp12 bp9 3.169e-15
Cp483 bp12 cn10 1.758e-19
Cp484 bp12 cn11 1.194e-16
Cp485 bp12 cn12 4.869e-16
Cp486 bp12 cp11 2.263e-19
Cp487 bp12 cp12 1.002e-16
Cp488 bp12 gnd 8.255e-15
Cp489 bp12 lsb_n 1.038e-16
Cp490 bp12 lsb_p 1.769e-14
Cp491 bp12 rstb 5.442e-17
Cp492 bp12 top_p 1.311e-17
Cp493 bp12 vdd 6.502e-17
Cp494 bp12 vref 1.083e-15
Cp495 bp12 vrefl 1.001e-16
Cp496 bp12 xc4_din 6.501e-16
Cp497 bp2 bp3 1.425e-14
Cp498 bp2 bp4 4.533e-16
Cp499 bp2 bp5 3.428e-15
Cp500 bp2 bp6 1.845e-15
Cp501 bp2 bp7 2.839e-15
Cp502 bp2 bp8 4.942e-17
Cp503 bp2 bp9 5.494e-16
Cp504 bp2 cp0 4.821e-19
Cp505 bp2 cp1 4.784e-16
Cp506 bp2 cp2 2.442e-16
Cp507 bp2 cp3 2.505e-16
Cp508 bp2 cp4 4.66e-17
Cp509 bp2 cp5 6.6e-17
Cp510 bp2 cp6 1.529e-16
Cp511 bp2 cp7 1.627e-17
Cp512 bp2 gnd 4.908e-15
Cp513 bp2 lsb_n 4.539e-17
Cp514 bp2 vdd 4.285e-17
Cp515 bp2 vrefl 5.766e-16
Cp516 bp2 xc4_din 1.832e-16
Cp517 bp3 bp4 2.427e-14
Cp518 bp3 bp5 6.336e-15
Cp519 bp3 bp6 3.619e-15
Cp520 bp3 bp7 4.576e-15
Cp521 bp3 bp8 4.656e-17
Cp522 bp3 bp9 2.676e-16
Cp523 bp3 cp2 2.02e-19
Cp524 bp3 cp3 1.504e-16
Cp525 bp3 cp4 9.31e-17
Cp526 bp3 cp5 5.761e-17
Cp527 bp3 cp6 1.496e-17
Cp528 bp3 cp7 4.585e-16
Cp529 bp3 gnd 6.39e-15
Cp530 bp3 lsb_n 4.629e-17
Cp531 bp3 lsb_p 4.095e-17
Cp532 bp3 rstb 2.607e-17
Cp533 bp3 vdd 1.42e-16
Cp534 bp3 vrefl 4.857e-16
Cp535 bp3 xc4_din 2.125e-15
Cp536 bp4 bp5 4.046e-14
Cp537 bp4 bp6 5.933e-15
Cp538 bp4 bp7 5.706e-15
Cp539 bp4 bp8 4.969e-17
Cp540 bp4 bp9 3.882e-17
Cp541 bp4 cp3 1.064e-18
Cp542 bp4 cp4 7.367e-16
Cp543 bp4 cp5 5.14e-16
Cp544 bp4 cp6 2.58e-17
Cp545 bp4 cp7 3.605e-18
Cp546 bp4 cp8 3.585e-19
Cp547 bp4 gnd 6.479e-15
Cp548 bp4 lsb_n 4.576e-17
Cp549 bp4 lsb_p 3.746e-16
Cp550 bp4 rstb 3.792e-17
Cp551 bp4 vdd 1.019e-16
Cp552 bp4 vref 5.436e-18
Cp553 bp4 vrefl 9.148e-16
Cp554 bp4 xc4_din 9.818e-16
Cp555 bp5 bp6 1.392e-14
Cp556 bp5 bp7 1.852e-14
Cp557 bp5 bp8 6.42e-17
Cp558 bp5 bp9 3.882e-17
Cp559 bp5 cp3 1.105e-19
Cp560 bp5 cp4 1.413e-16
Cp561 bp5 cp5 5.147e-16
Cp562 bp5 cp6 2.233e-17
Cp563 bp5 cp7 1.277e-18
Cp564 bp5 cp8 2.154e-18
Cp565 bp5 gnd 1.148e-14
Cp566 bp5 lsb_n 4.576e-17
Cp567 bp5 lsb_p 8.334e-17
Cp568 bp5 rstb 4.705e-17
Cp569 bp5 t0 2.382e-18
Cp570 bp5 top_p 3.138e-19
Cp571 bp5 vdd 1.17e-16
Cp572 bp5 vref 7.324e-18
Cp573 bp5 vrefl 6.301e-16
Cp574 bp5 xc4_din 4.76e-16
Cp575 bp5 xs0p_x 1.022e-19
Cp576 bp5 xs1p_n10 1.771e-18
Cp577 bp6 bp7 1.328e-14
Cp578 bp6 bp8 1.458e-15
Cp579 bp6 bp9 6.529e-16
Cp580 bp6 cp4 1.04e-15
Cp581 bp6 cp5 6.874e-17
Cp582 bp6 cp6 1.399e-16
Cp583 bp6 cp7 8.527e-18
Cp584 bp6 cp8 2.314e-16
Cp585 bp6 cp9 3.838e-19
Cp586 bp6 gnd 3.132e-14
Cp587 bp6 lsb_n 4.586e-17
Cp588 bp6 lsb_p 4.355e-16
Cp589 bp6 rstb 1.352e-16
Cp590 bp6 t1b 6.844e-18
Cp591 bp6 top_p 1.027e-17
Cp592 bp6 vdd 1.116e-16
Cp593 bp6 vref 5.701e-17
Cp594 bp6 vrefl 7.854e-16
Cp595 bp6 xc4_din 4.643e-16
Cp596 bp7 bp8 1.681e-15
Cp597 bp7 bp9 6.288e-16
Cp598 bp7 cp10 3.974e-19
Cp599 bp7 cp4 2.525e-18
Cp600 bp7 cp5 8.046e-18
Cp601 bp7 cp6 2.11e-17
Cp602 bp7 cp7 8.041e-17
Cp603 bp7 cp8 5.36e-17
Cp604 bp7 cp9 1.186e-16
Cp605 bp7 gnd 4.91e-14
Cp606 bp7 lsb_n 4.576e-17
Cp607 bp7 lsb_p 3.452e-15
Cp608 bp7 rstb 4.524e-17
Cp609 bp7 t0 5.596e-18
Cp610 bp7 top_p 4.329e-18
Cp611 bp7 vdd 1.676e-16
Cp612 bp7 vref 8.909e-18
Cp613 bp7 vrefl 1.372e-15
Cp614 bp7 xc4_din 1.48e-15
Cp615 bp7 xs1p_cbp 2.091e-19
Cp616 bp7 xs1p_g 5.339e-19
Cp617 bp8 bp9 4.563e-15
Cp618 bp8 cp10 5.973e-17
Cp619 bp8 cp11 3.642e-19
Cp620 bp8 cp4 4.667e-19
Cp621 bp8 cp5 1.691e-17
Cp622 bp8 cp6 8.452e-17
Cp623 bp8 cp7 1.04e-17
Cp624 bp8 cp8 8.176e-16
Cp625 bp8 cp9 8.711e-17
Cp626 bp8 gnd 4.988e-15
Cp627 bp8 lsb_n 2.353e-15
Cp628 bp8 lsb_p 3.375e-16
Cp629 bp8 rstb 4.89e-17
Cp630 bp8 t1b 1.615e-18
Cp631 bp8 top_n 3.779e-18
Cp632 bp8 top_p 2.178e-16
Cp633 bp8 vdd 1.342e-16
Cp634 bp8 vref 2.21e-16
Cp635 bp8 vrefl 2.411e-16
Cp636 bp8 xc4_din 5.711e-16
Cp637 bp9 cp10 2.303e-16
Cp638 bp9 cp11 2.49e-16
Cp639 bp9 cp12 1.344e-19
Cp640 bp9 cp8 3.744e-19
Cp641 bp9 cp9 1.432e-16
Cp642 bp9 gnd 3.969e-15
Cp643 bp9 lsb_n 5.491e-16
Cp644 bp9 lsb_p 2.342e-16
Cp645 bp9 rstb 2.066e-16
Cp646 bp9 vdd 1.219e-16
Cp647 bp9 vref 1.572e-15
Cp648 bp9 vrefl 1.28e-16
Cp649 bp9 xc4_din 4.463e-16
Cp650 clkb clkn 5.236e-17
Cp651 clkb gnd 4.307e-14
Cp652 clkb on 1.987e-16
Cp653 clkb onn 2.957e-17
Cp654 clkb onp 1.608e-17
Cp655 clkb op 4.354e-17
Cp656 clkb t1 4.415e-17
Cp657 clkb t1b 5.292e-17
Cp658 clkb top_n 4.394e-17
Cp659 clkb top_p 6.95e-17
Cp660 clkb vbp 1.824e-16
Cp661 clkb vdd 8.556e-16
Cp662 clkb vref 1.491e-16
Cp663 clkb vrefl 1.519e-16
Cp664 clkb xc4_din 2.634e-16
Cp665 clkb xc4_dip 4.773e-16
Cp666 clkb xc4_outnb 1.737e-18
Cp667 clkb xc4_outpb 4.381e-18
Cp668 clkb xc4_xs1_tail 4.954e-18
Cp669 clkb xc4_xs1_tail0 2.97e-16
Cp670 clkb xc5_din 1.03e-16
Cp671 clkb xc5_dip 6.237e-17
Cp672 clkb xc5_lt 9.615e-18
Cp673 clkb xc5_outnb 7.584e-18
Cp674 clkb xc5_outpb 1.593e-19
Cp675 clkn gnd 1.632e-14
Cp676 clkn onn 2.96e-19
Cp677 clkn onp 3.947e-19
Cp678 clkn t1b 9.702e-19
Cp679 clkn top_n 3.273e-16
Cp680 clkn top_p 2.253e-16
Cp681 clkn vbn 6.795e-17
Cp682 clkn vdd 6.852e-16
Cp683 clkn xc4_din 9.147e-18
Cp684 clkn xc4_dip 2.315e-18
Cp685 clkn xc4_xs1_tail 7.844e-18
Cp686 clkn xc5_din 8.807e-16
Cp687 clkn xc5_dip 2.174e-16
Cp688 clkn xc5_lt 2.146e-19
Cp689 clkn xc5_xs1_tail 4.9e-18
Cp690 clkn xc5_xs1_tail0 1.768e-16
Cp691 cn0 cn1 5.948e-17
Cp692 cn0 gnd 7.61e-16
Cp693 cn0 lsb_p 1.684e-18
Cp694 cn0 op 5.543e-18
Cp695 cn0 rstb 6.073e-17
Cp696 cn0 vdd 3.659e-18
Cp697 cn0 vrefl 2.457e-16
Cp698 cn0 xc4_din 1.492e-18
Cp699 cn0 xc4_dip 2.294e-16
Cp700 cn0 xc4_outnb 6.972e-19
Cp701 cn0 xc4_outpb 1.372e-19
Cp702 cn0 xc4_xs1_tail 1.102e-19
Cp703 cn1 cn2 5.025e-17
Cp704 cn1 gnd 8.21e-16
Cp705 cn1 lsb_p 2.681e-18
Cp706 cn1 on 1.489e-18
Cp707 cn1 op 1.995e-18
Cp708 cn1 rstb 6.956e-17
Cp709 cn1 vdd 1.291e-18
Cp710 cn1 vrefl 2.453e-16
Cp711 cn1 xc4_din 2.245e-19
Cp712 cn1 xc4_dip 3.125e-18
Cp713 cn1 xc4_outnb 5.693e-19
Cp714 cn10 cn11 5.632e-16
Cp715 cn10 cn12 1.167e-16
Cp716 cn10 cn8 3.81e-18
Cp717 cn10 cn9 6.566e-17
Cp718 cn10 cp12 4.429e-18
Cp719 cn10 gnd 1.335e-15
Cp720 cn10 lsb_p 7.468e-19
Cp721 cn10 rstb 5.42e-17
Cp722 cn10 vdd 1.418e-18
Cp723 cn10 vref 1.341e-16
Cp724 cn10 vrefl 1.155e-16
Cp725 cn10 xc4_din 4.49e-19
Cp726 cn10 xc4_xs1_tail 3.974e-17
Cp727 cn11 cn12 4e-16
Cp728 cn11 cn9 1.012e-17
Cp729 cn11 cp12 1.047e-16
Cp730 cn11 gnd 1.151e-15
Cp731 cn11 lsb_p 7.468e-19
Cp732 cn11 rstb 5.624e-17
Cp733 cn11 vdd 1.418e-18
Cp734 cn11 vref 3.089e-16
Cp735 cn11 vrefl 1.106e-16
Cp736 cn11 xc4_din 4.49e-19
Cp737 cn11 xc4_xs1_tail 4.833e-19
Cp738 cn12 cp10 4.424e-18
Cp739 cn12 cp11 1.162e-16
Cp740 cn12 cp12 5.268e-16
Cp741 cn12 gnd 1.184e-15
Cp742 cn12 lsb_p 4.329e-19
Cp743 cn12 rstb 5.413e-17
Cp744 cn12 vdd 1.418e-18
Cp745 cn12 vref 4.026e-16
Cp746 cn12 vrefl 1.159e-16
Cp747 cn12 xc4_din 3.097e-19
Cp748 cn12 xc4_xs1_tail 3.921e-17
Cp749 cn2 cn3 5.025e-17
Cp750 cn2 gnd 7.967e-16
Cp751 cn2 lsb_p 2.681e-18
Cp752 cn2 rstb 6.741e-17
Cp753 cn2 vdd 1.291e-18
Cp754 cn2 vrefl 2.435e-16
Cp755 cn2 xc4_din 2.245e-19
Cp756 cn2 xc4_dip 3.255e-18
Cp757 cn2 xc4_outnb 7.981e-19
Cp758 cn2 xc4_outpb 1.904e-19
Cp759 cn2 xc4_xs1_tail 1.529e-19
Cp760 cn3 cn4 5.025e-17
Cp761 cn3 gnd 7.965e-16
Cp762 cn3 lsb_p 2.616e-18
Cp763 cn3 rstb 6.741e-17
Cp764 cn3 vdd 1.291e-18
Cp765 cn3 vrefl 2.435e-16
Cp766 cn3 xc4_din 1.006e-19
Cp767 cn3 xc4_dip 3.255e-18
Cp768 cn3 xc4_outnb 7.981e-19
Cp769 cn3 xc4_xs1_tail 1.529e-19
Cp770 cn4 cn5 5.025e-17
Cp771 cn4 gnd 7.967e-16
Cp772 cn4 lsb_p 2.681e-18
Cp773 cn4 rstb 6.741e-17
Cp774 cn4 vdd 1.291e-18
Cp775 cn4 vrefl 2.435e-16
Cp776 cn4 xc4_din 2.245e-19
Cp777 cn4 xc4_dip 3.255e-18
Cp778 cn4 xc4_xs1_tail 1.529e-19
Cp779 cn5 cn6 5.025e-17
Cp780 cn5 gnd 7.967e-16
Cp781 cn5 lsb_p 2.681e-18
Cp782 cn5 rstb 6.741e-17
Cp783 cn5 vdd 1.291e-18
Cp784 cn5 vrefl 2.435e-16
Cp785 cn5 xc4_din 2.245e-19
Cp786 cn5 xc4_dip 3.255e-18
Cp787 cn5 xc4_xs1_tail 1.529e-19
Cp788 cn6 cn7 5.025e-17
Cp789 cn6 gnd 7.967e-16
Cp790 cn6 lsb_p 2.681e-18
Cp791 cn6 rstb 6.741e-17
Cp792 cn6 vdd 1.291e-18
Cp793 cn6 vrefl 2.439e-16
Cp794 cn6 xc4_din 2.245e-19
Cp795 cn6 xc4_dip 3.255e-18
Cp796 cn6 xc4_xs1_tail 1.529e-19
Cp797 cn7 cn8 2.997e-17
Cp798 cn7 cn9 1.558e-19
Cp799 cn7 gnd 8.065e-16
Cp800 cn7 lsb_p 2.681e-18
Cp801 cn7 rstb 7.754e-17
Cp802 cn7 vdd 1.291e-18
Cp803 cn7 vrefl 2.447e-16
Cp804 cn7 xc4_din 2.245e-19
Cp805 cn7 xc4_dip 3.255e-18
Cp806 cn7 xc4_xs1_tail 1.529e-19
Cp807 cn8 cn9 4.676e-16
Cp808 cn8 gnd 1.079e-15
Cp809 cn8 lsb_p 4.455e-17
Cp810 cn8 rstb 7.978e-16
Cp811 cn8 vdd 2.19e-18
Cp812 cn8 vref 8.427e-17
Cp813 cn8 vrefl 1.834e-16
Cp814 cn8 xc4_din 4.041e-19
Cp815 cn8 xc4_dip 2.667e-18
Cp816 cn8 xc4_xs1_tail 1.336e-18
Cp817 cn9 gnd 1.151e-15
Cp818 cn9 lsb_p 2.92e-17
Cp819 cn9 rstb 1.867e-16
Cp820 cn9 vdd 3.033e-18
Cp821 cn9 vref 5.416e-16
Cp822 cn9 vrefl 1.326e-16
Cp823 cn9 xc4_din 6.49e-19
Cp824 cn9 xc4_dip 5.349e-18
Cp825 cn9 xc4_xs1_tail 1.336e-18
Cp826 cp0 cp1 1.909e-16
Cp827 cp0 cp2 9.705e-16
Cp828 cp0 cp3 2.317e-18
Cp829 cp0 cp4 2.155e-19
Cp830 cp0 gnd 1.697e-15
Cp831 cp0 vdd 3.334e-18
Cp832 cp0 vrefl 8.677e-17
Cp833 cp0 xc4_din 2.732e-18
Cp834 cp0 xc4_xs1_tail 1.156e-16
Cp835 cp1 cp2 1.425e-15
Cp836 cp1 cp3 8.438e-16
Cp837 cp1 cp4 3.276e-19
Cp838 cp1 cp5 2.924e-18
Cp839 cp1 cp6 1.866e-17
Cp840 cp1 cp7 2.924e-18
Cp841 cp1 gnd 1.087e-15
Cp842 cp1 vdd 1.311e-18
Cp843 cp1 vrefl 9.745e-17
Cp844 cp1 xc4_din 6.108e-18
Cp845 cp1 xc4_xs1_tail 3.306e-19
Cp846 cp10 cp11 5.52e-16
Cp847 cp10 cp12 1.049e-16
Cp848 cp10 cp8 1.038e-16
Cp849 cp10 cp9 4.045e-16
Cp850 cp10 gnd 1.161e-15
Cp851 cp10 lsb_p 7.468e-19
Cp852 cp10 rstb 6.19e-17
Cp853 cp10 vdd 1.524e-18
Cp854 cp10 vref 1.144e-16
Cp855 cp10 vrefl 1.429e-16
Cp856 cp10 xc4_din 6.079e-18
Cp857 cp10 xc4_xs1_tail 4.833e-19
Cp858 cp11 cp12 4.602e-16
Cp859 cp11 cp8 4.24e-18
Cp860 cp11 cp9 1.155e-16
Cp861 cp11 gnd 1.308e-15
Cp862 cp11 lsb_p 2.814e-19
Cp863 cp11 rstb 6.299e-17
Cp864 cp11 vdd 1.418e-18
Cp865 cp11 vref 1.379e-16
Cp866 cp11 vrefl 1.328e-16
Cp867 cp11 xc4_din 7.475e-19
Cp868 cp11 xc4_xs1_tail 3.956e-17
Cp869 cp12 gnd 1.15e-15
Cp870 cp12 lsb_p 7.468e-19
Cp871 cp12 rstb 6.294e-17
Cp872 cp12 vdd 1.418e-18
Cp873 cp12 vref 4.722e-16
Cp874 cp12 vrefl 2.829e-16
Cp875 cp12 xc4_din 4.49e-19
Cp876 cp12 xc4_xs1_tail 3.731e-19
Cp877 cp2 cp3 1.996e-16
Cp878 cp2 cp4 5.958e-19
Cp879 cp2 cp6 1.627e-16
Cp880 cp2 cp7 2.469e-17
Cp881 cp2 gnd 1.268e-15
Cp882 cp2 vdd 1.311e-18
Cp883 cp2 vrefl 9.838e-17
Cp884 cp2 xc4_din 6.108e-18
Cp885 cp2 xc4_xs1_tail 4.109e-17
Cp886 cp3 cp4 5.172e-17
Cp887 cp3 cp5 3.635e-17
Cp888 cp3 cp6 6.48e-16
Cp889 cp3 cp7 3.287e-16
Cp890 cp3 gnd 1.182e-15
Cp891 cp3 vdd 1.311e-18
Cp892 cp3 vrefl 2.904e-16
Cp893 cp3 xc4_din 5.999e-18
Cp894 cp3 xc4_xs1_tail 3.306e-19
Cp895 cp4 cp5 1.532e-15
Cp896 cp4 cp6 8.136e-17
Cp897 cp4 cp7 9.455e-17
Cp898 cp4 cp8 8.216e-19
Cp899 cp4 gnd 9.856e-16
Cp900 cp4 lsb_p 2.187e-18
Cp901 cp4 rstb 1.059e-16
Cp902 cp4 vdd 3.148e-18
Cp903 cp4 vref 3.107e-19
Cp904 cp4 vrefl 4.737e-16
Cp905 cp4 xc4_din 6.269e-18
Cp906 cp4 xc4_xs1_tail 1.529e-19
Cp907 cp5 cp6 1.863e-16
Cp908 cp5 cp7 1.31e-16
Cp909 cp5 cp8 7.262e-18
Cp910 cp5 gnd 1.143e-15
Cp911 cp5 lsb_p 1.029e-18
Cp912 cp5 rstb 5.301e-16
Cp913 cp5 vdd 2.093e-18
Cp914 cp5 vref 1.124e-18
Cp915 cp5 vrefl 4.622e-16
Cp916 cp5 xc4_din 5.694e-18
Cp917 cp5 xc4_xs1_tail 5.51e-19
Cp918 cp6 cp7 1.526e-15
Cp919 cp6 cp8 1.271e-17
Cp920 cp6 cp9 5.624e-18
Cp921 cp6 gnd 1.256e-15
Cp922 cp6 rstb 9.32e-18
Cp923 cp6 vdd 1.291e-18
Cp924 cp6 vref 2.478e-18
Cp925 cp6 vrefl 4.459e-16
Cp926 cp6 xc4_din 3.255e-18
Cp927 cp6 xc4_xs1_tail 1.336e-17
Cp928 cp7 cp8 1.346e-16
Cp929 cp7 cp9 2.419e-17
Cp930 cp7 gnd 1.286e-15
Cp931 cp7 rstb 9.265e-18
Cp932 cp7 vdd 1.291e-18
Cp933 cp7 vref 1.943e-18
Cp934 cp7 vrefl 5.756e-16
Cp935 cp7 xc4_din 3.255e-18
Cp936 cp7 xc4_xs1_tail 1.021e-16
Cp937 cp8 cp9 5.347e-16
Cp938 cp8 gnd 9.662e-16
Cp939 cp8 lsb_p 4.236e-18
Cp940 cp8 rstb 6.781e-17
Cp941 cp8 vdd 1.417e-18
Cp942 cp8 vref 2.759e-16
Cp943 cp8 vrefl 5.491e-16
Cp944 cp8 xc4_din 5.999e-18
Cp945 cp8 xc4_xs1_tail 4.833e-19
Cp946 cp9 gnd 1.086e-15
Cp947 cp9 lsb_p 4.329e-19
Cp948 cp9 rstb 5.733e-17
Cp949 cp9 vdd 1.392e-18
Cp950 cp9 vref 1.512e-16
Cp951 cp9 vrefl 4.075e-16
Cp952 cp9 xc4_din 5.731e-18
Cp953 cp9 xc4_xs1_tail 3.956e-17
Cp954 gnd in0n 2.771e-15
Cp955 gnd in0p 1.772e-15
Cp956 gnd in1n 1.711e-15
Cp957 gnd in1p 2.492e-15
Cp958 gnd lsb_n 1.134e-14
Cp959 gnd lsb_p 1.13e-14
Cp960 gnd nr 9.207e-16
Cp961 gnd on 4.379e-15
Cp962 gnd onn 1.294e-14
Cp963 gnd onp 2.404e-14
Cp964 gnd op 5.558e-15
Cp965 gnd rstb 5.912e-15
Cp966 gnd rstb_n 2.576e-15
Cp967 gnd t0 5.744e-15
Cp968 gnd t0b 1.449e-14
Cp969 gnd t1 1.169e-14
Cp970 gnd t1b 1.892e-14
Cp971 gnd top_n 1.875e-14
Cp972 gnd top_p 2.115e-14
Cp973 gnd trk0 2.286e-15
Cp974 gnd trk1 1.091e-15
Cp975 gnd vbn 2.47e-15
Cp976 gnd vbp 1.003e-14
Cp977 gnd vdd 7.638e-14
Cp978 gnd vref 1.071e-14
Cp979 gnd vrefl 1.71e-14
Cp980 gnd xc4_din 4.971e-14
Cp981 gnd xc4_dip 6.358e-14
Cp982 gnd xc4_lt 1.897e-15
Cp983 gnd xc4_outnb 2.917e-15
Cp984 gnd xc4_outpb 1.705e-15
Cp985 gnd xc4_xs1_tail 9.599e-15
Cp986 gnd xc4_xs1_tail0 1.838e-15
Cp987 gnd xc5_din 2.49e-14
Cp988 gnd xc5_dip 2.509e-14
Cp989 gnd xc5_lt 6.444e-15
Cp990 gnd xc5_outnb 3.773e-15
Cp991 gnd xc5_outpb 2.018e-15
Cp992 gnd xc5_xs1_tail 3.937e-15
Cp993 gnd xc5_xs1_tail0 2.309e-15
Cp994 gnd xs0n_cbn 4.12e-15
Cp995 gnd xs0n_cbp 1.813e-15
Cp996 gnd xs0n_g 4.703e-15
Cp997 gnd xs0n_n10 1.151e-15
Cp998 gnd xs0n_x 1.657e-15
Cp999 gnd xs0p_cbn 6.384e-15
Cp1000 gnd xs0p_cbp 2.141e-15
Cp1001 gnd xs0p_g 4.494e-15
Cp1002 gnd xs0p_n10 1.354e-15
Cp1003 gnd xs0p_x 2.479e-15
Cp1004 gnd xs1n_cbn 4.459e-15
Cp1005 gnd xs1n_cbp 1.817e-15
Cp1006 gnd xs1n_g 4.32e-15
Cp1007 gnd xs1n_n10 1.253e-15
Cp1008 gnd xs1n_x 1.637e-15
Cp1009 gnd xs1p_cbn 5.351e-15
Cp1010 gnd xs1p_cbp 1.664e-15
Cp1011 gnd xs1p_g 3.965e-15
Cp1012 gnd xs1p_n10 1.141e-15
Cp1013 gnd xs1p_x 1.912e-15
Cp1014 in0n in0p 7.903e-17
Cp1015 in0n onn 2.507e-17
Cp1016 in0n onp 9.398e-17
Cp1017 in0n t0 9.257e-17
Cp1018 in0n t0b 9.307e-16
Cp1019 in0n top_n 9.443e-16
Cp1020 in0n vdd 6.55e-16
Cp1021 in0n xc4_lt 2.686e-19
Cp1022 in0n xs0n_cbn 1.185e-15
Cp1023 in0n xs0n_cbp 8.6e-19
Cp1024 in0n xs0n_g 2.257e-16
Cp1025 in0n xs0n_n10 4.878e-17
Cp1026 in0n xs0n_x 6.138e-18
Cp1027 in0p lsb_n 8.447e-19
Cp1028 in0p t0 1.02e-16
Cp1029 in0p t0b 1.32e-15
Cp1030 in0p top_n 9.216e-17
Cp1031 in0p top_p 1.012e-15
Cp1032 in0p vdd 3.576e-16
Cp1033 in0p xs0n_cbn 1.286e-15
Cp1034 in0p xs0n_cbp 1.652e-16
Cp1035 in0p xs0n_g 5.839e-16
Cp1036 in0p xs0n_n10 4.326e-17
Cp1037 in0p xs0n_x 1.465e-15
Cp1038 in0p xs0p_cbn 2.906e-16
Cp1039 in0p xs0p_g 2.342e-16
Cp1040 in1n in1p 1.595e-16
Cp1041 in1n t1 1.795e-15
Cp1042 in1n t1b 7.866e-17
Cp1043 in1n top_n 8.747e-16
Cp1044 in1n top_p 5.475e-19
Cp1045 in1n vdd 3.153e-15
Cp1046 in1n xs1n_cbn 1.129e-15
Cp1047 in1n xs1n_cbp 8.615e-18
Cp1048 in1n xs1n_g 7.12e-16
Cp1049 in1n xs1n_n10 1.874e-18
Cp1050 in1n xs1n_x 9.091e-17
Cp1051 in1n xs1p_cbn 4.676e-18
Cp1052 in1n xs1p_g 3.31e-18
Cp1053 in1p t1 5.057e-16
Cp1054 in1p t1b 2.404e-16
Cp1055 in1p top_n 4.549e-16
Cp1056 in1p top_p 7.999e-16
Cp1057 in1p vdd 5.419e-16
Cp1058 in1p xs1n_cbn 1.827e-16
Cp1059 in1p xs1n_cbp 4.004e-18
Cp1060 in1p xs1n_g 6.026e-19
Cp1061 in1p xs1n_n10 5.198e-19
Cp1062 in1p xs1n_x 4.703e-17
Cp1063 in1p xs1p_cbn 2.963e-16
Cp1064 in1p xs1p_g 2.969e-16
Cp1065 lsb_n lsb_p 4.662e-15
Cp1066 lsb_n on 2.076e-19
Cp1067 lsb_n rstb 4.618e-17
Cp1068 lsb_n t0 1.606e-16
Cp1069 lsb_n top_n 5.459e-16
Cp1070 lsb_n top_p 2.223e-17
Cp1071 lsb_n vdd 9.118e-16
Cp1072 lsb_n vref 1.468e-17
Cp1073 lsb_n vrefl 2.256e-16
Cp1074 lsb_n xc4_din 3.618e-15
Cp1075 lsb_n xc4_dip 7.252e-16
Cp1076 lsb_n xc4_lt 1.307e-18
Cp1077 lsb_n xs0n_cbn 6.4e-17
Cp1078 lsb_n xs0n_cbp 3.153e-18
Cp1079 lsb_n xs0n_g 1.196e-18
Cp1080 lsb_n xs0n_x 2.139e-17
Cp1081 lsb_n xs1p_g 1.34e-19
Cp1082 lsb_p on 3.61e-17
Cp1083 lsb_p onp 3.387e-17
Cp1084 lsb_p op 1.059e-18
Cp1085 lsb_p rstb 7.646e-16
Cp1086 lsb_p t0 3.035e-15
Cp1087 lsb_p t0b 2.267e-18
Cp1088 lsb_p top_n 6.452e-17
Cp1089 lsb_p top_p 5.789e-16
Cp1090 lsb_p vdd 3.709e-16
Cp1091 lsb_p vref 3.719e-15
Cp1092 lsb_p vrefl 4.368e-16
Cp1093 lsb_p xc4_din 9.498e-15
Cp1094 lsb_p xc4_dip 7.073e-17
Cp1095 lsb_p xc4_lt 1.014e-17
Cp1096 lsb_p xc4_outnb 4.785e-19
Cp1097 lsb_p xc4_outpb 3.882e-19
Cp1098 lsb_p xc5_outnb 2.708e-19
Cp1099 lsb_p xs0n_cbn 2.053e-16
Cp1100 lsb_p xs0n_cbp 3.703e-18
Cp1101 lsb_p xs0n_g 5.955e-19
Cp1102 lsb_p xs0n_n10 5.198e-19
Cp1103 lsb_p xs0n_x 1.104e-16
Cp1104 lsb_p xs0p_cbn 8.246e-18
Cp1105 lsb_p xs0p_g 4.202e-18
Cp1106 lsb_p xs0p_x 1.849e-17
Cp1107 nr rstb 1.182e-17
Cp1108 nr rstb_n 6.519e-16
Cp1109 nr t0b 4.479e-17
Cp1110 nr t1 5.443e-17
Cp1111 nr t1b 1.631e-16
Cp1112 nr trk1 1.142e-19
Cp1113 nr vdd 4.708e-17
Cp1114 on onn 1.249e-16
Cp1115 on onp 3.35e-16
Cp1116 on op 1.934e-15
Cp1117 on rstb 3.192e-16
Cp1118 on t0 2.605e-18
Cp1119 on t1 6.694e-17
Cp1120 on t1b 1.487e-19
Cp1121 on vbp 3.323e-17
Cp1122 on vdd 2.613e-15
Cp1123 on xc4_din 7.775e-16
Cp1124 on xc4_dip 6.496e-16
Cp1125 on xc4_lt 4.295e-16
Cp1126 on xc4_outnb 1.099e-15
Cp1127 on xc4_outpb 7.854e-16
Cp1128 on xc4_xs1_tail 5.337e-16
Cp1129 on xc4_xs1_tail0 9.496e-17
Cp1130 on xc5_lt 4.788e-15
Cp1131 on xc5_outnb 9.073e-17
Cp1132 on xc5_outpb 4.766e-16
Cp1133 onn onp 1.555e-15
Cp1134 onn op 5.661e-16
Cp1135 onn rstb 8.362e-17
Cp1136 onn rstb_n 2.172e-18
Cp1137 onn t0 5.412e-16
Cp1138 onn t0b 3.545e-18
Cp1139 onn t1 2.121e-15
Cp1140 onn t1b 3.151e-15
Cp1141 onn top_n 2.009e-18
Cp1142 onn top_p 2.009e-18
Cp1143 onn vbp 7.864e-17
Cp1144 onn vdd 1.53e-15
Cp1145 onn vref 2.538e-16
Cp1146 onn vrefl 2.589e-16
Cp1147 onn xc4_din 8.636e-19
Cp1148 onn xc4_dip 2.306e-16
Cp1149 onn xc4_outnb 4.427e-18
Cp1150 onn xc4_outpb 4.194e-17
Cp1151 onn xc4_xs1_tail0 1.097e-18
Cp1152 onn xc5_din 1.803e-16
Cp1153 onn xc5_dip 5.628e-17
Cp1154 onn xc5_lt 1.037e-15
Cp1155 onn xc5_outnb 9.481e-17
Cp1156 onn xc5_outpb 6.645e-17
Cp1157 onn xc5_xs1_tail 1.027e-18
Cp1158 onn xc5_xs1_tail0 2.453e-18
Cp1159 onp op 1.718e-16
Cp1160 onp rstb 1.173e-16
Cp1161 onp t0 5.459e-16
Cp1162 onp t0b 1.272e-18
Cp1163 onp t1 1.574e-14
Cp1164 onp t1b 9.338e-18
Cp1165 onp top_n 4.219e-18
Cp1166 onp top_p 4.187e-18
Cp1167 onp vbp 6.103e-17
Cp1168 onp vdd 2.234e-15
Cp1169 onp vref 1.491e-16
Cp1170 onp vrefl 1.519e-16
Cp1171 onp xc4_din 2.478e-18
Cp1172 onp xc4_dip 5.674e-17
Cp1173 onp xc4_lt 2.577e-17
Cp1174 onp xc4_outnb 7.402e-19
Cp1175 onp xc4_outpb 3.76e-16
Cp1176 onp xc4_xs1_tail0 1.402e-17
Cp1177 onp xc5_din 9.445e-18
Cp1178 onp xc5_dip 1.239e-16
Cp1179 onp xc5_lt 1.271e-15
Cp1180 onp xc5_outnb 1.81e-16
Cp1181 onp xc5_outpb 4.055e-16
Cp1182 onp xc5_xs1_tail 6.384e-19
Cp1183 op rstb 4.535e-16
Cp1184 op t0 4.402e-18
Cp1185 op t1 5.523e-18
Cp1186 op vbp 3.142e-18
Cp1187 op vdd 3.084e-15
Cp1188 op xc4_din 1.067e-16
Cp1189 op xc4_dip 2.255e-16
Cp1190 op xc4_lt 6.702e-16
Cp1191 op xc4_outnb 1.083e-16
Cp1192 op xc4_outpb 2.656e-16
Cp1193 op xc4_xs1_tail 1.12e-15
Cp1194 op xc4_xs1_tail0 1.423e-18
Cp1195 op xc5_lt 7.094e-17
Cp1196 op xc5_outnb 2.62e-15
Cp1197 op xc5_outpb 2.631e-15
Cp1198 rstb rstb_n 2.029e-16
Cp1199 rstb t1 7.299e-17
Cp1200 rstb t1b 8.35e-17
Cp1201 rstb vdd 7.579e-16
Cp1202 rstb vref 3.537e-16
Cp1203 rstb vrefl 5.924e-15
Cp1204 rstb xc4_din 6.818e-17
Cp1205 rstb xc4_dip 7.445e-17
Cp1206 rstb xc4_lt 1.192e-17
Cp1207 rstb xc4_outnb 5.119e-18
Cp1208 rstb xc4_outpb 1.083e-16
Cp1209 rstb xc5_lt 1.685e-17
Cp1210 rstb xc5_outnb 6.228e-17
Cp1211 rstb xc5_outpb 1.233e-16
Cp1212 rstb_n t0b 3.764e-17
Cp1213 rstb_n t1 6.132e-17
Cp1214 rstb_n t1b 3.409e-16
Cp1215 rstb_n vdd 1.288e-15
Cp1216 t0 t0b 4.571e-16
Cp1217 t0 t1 6.791e-18
Cp1218 t0 t1b 6.1e-17
Cp1219 t0 top_n 3.625e-16
Cp1220 t0 top_p 4.8e-16
Cp1221 t0 trk1 1.313e-16
Cp1222 t0 vdd 7.901e-15
Cp1223 t0 xc4_lt 2.654e-18
Cp1224 t0 xc5_outpb 5.702e-17
Cp1225 t0 xs0n_cbn 1.193e-15
Cp1226 t0 xs0n_cbp 4.843e-18
Cp1227 t0 xs0n_g 1.428e-16
Cp1228 t0 xs0n_n10 8.078e-19
Cp1229 t0 xs0n_x 2.121e-16
Cp1230 t0 xs0p_cbn 3.282e-16
Cp1231 t0 xs0p_cbp 4.547e-18
Cp1232 t0 xs0p_g 8.159e-17
Cp1233 t0 xs0p_x 1.162e-16
Cp1234 t0b t1 1.071e-16
Cp1235 t0b t1b 1.375e-15
Cp1236 t0b top_n 2.126e-16
Cp1237 t0b top_p 1.897e-16
Cp1238 t0b trk0 1.366e-16
Cp1239 t0b trk1 1.815e-16
Cp1240 t0b vdd 2.722e-15
Cp1241 t0b xs0n_cbn 1.283e-15
Cp1242 t0b xs0n_cbp 5.384e-16
Cp1243 t0b xs0n_g 1.544e-16
Cp1244 t0b xs0n_n10 1.44e-16
Cp1245 t0b xs0n_x 6.237e-17
Cp1246 t0b xs0p_cbn 6.92e-16
Cp1247 t0b xs0p_cbp 2.112e-18
Cp1248 t0b xs0p_g 9.023e-17
Cp1249 t0b xs0p_n10 3.396e-17
Cp1250 t0b xs0p_x 1.029e-16
Cp1251 t1 t1b 4.611e-16
Cp1252 t1 top_n 2.693e-16
Cp1253 t1 top_p 6.425e-17
Cp1254 t1 vbp 7.181e-17
Cp1255 t1 vdd 6.801e-15
Cp1256 t1 vref 2.076e-16
Cp1257 t1 vrefl 2.105e-16
Cp1258 t1 xc4_din 8.103e-17
Cp1259 t1 xc4_dip 5.325e-16
Cp1260 t1 xc4_outnb 2.885e-19
Cp1261 t1 xc4_outpb 2.885e-19
Cp1262 t1 xc4_xs1_tail 7.733e-17
Cp1263 t1 xc4_xs1_tail0 5.752e-18
Cp1264 t1 xc5_din 9.074e-18
Cp1265 t1 xc5_dip 4.925e-18
Cp1266 t1 xc5_lt 4.474e-16
Cp1267 t1 xc5_outnb 2.885e-19
Cp1268 t1 xc5_outpb 2.885e-19
Cp1269 t1 xc5_xs1_tail 1.272e-19
Cp1270 t1 xc5_xs1_tail0 6.523e-19
Cp1271 t1 xs1n_cbn 1.471e-15
Cp1272 t1 xs1n_cbp 5.899e-18
Cp1273 t1 xs1n_g 7.626e-16
Cp1274 t1 xs1n_n10 8.078e-19
Cp1275 t1 xs1n_x 2.788e-16
Cp1276 t1 xs1p_cbn 4.149e-16
Cp1277 t1 xs1p_cbp 4.644e-18
Cp1278 t1 xs1p_g 1.19e-15
Cp1279 t1 xs1p_n10 1.822e-18
Cp1280 t1 xs1p_x 1.623e-16
Cp1281 t1b top_n 1.765e-15
Cp1282 t1b top_p 4.244e-15
Cp1283 t1b trk1 4.346e-16
Cp1284 t1b vbn 2.852e-19
Cp1285 t1b vbp 7.887e-17
Cp1286 t1b vdd 4.32e-15
Cp1287 t1b vref 2.418e-16
Cp1288 t1b vrefl 2.486e-16
Cp1289 t1b xc4_din 3.079e-15
Cp1290 t1b xc4_dip 1.352e-16
Cp1291 t1b xc4_xs1_tail 8.809e-17
Cp1292 t1b xc4_xs1_tail0 4.514e-19
Cp1293 t1b xc5_din 6.76e-16
Cp1294 t1b xc5_dip 2.044e-15
Cp1295 t1b xc5_lt 7.074e-17
Cp1296 t1b xc5_xs1_tail 6.671e-18
Cp1297 t1b xc5_xs1_tail0 2.024e-17
Cp1298 t1b xs1n_cbn 1.337e-15
Cp1299 t1b xs1n_cbp 5.419e-16
Cp1300 t1b xs1n_g 1.833e-16
Cp1301 t1b xs1n_n10 1.466e-16
Cp1302 t1b xs1n_x 6.384e-17
Cp1303 t1b xs1p_cbn 2.676e-16
Cp1304 t1b xs1p_cbp 6.512e-18
Cp1305 t1b xs1p_g 9.18e-17
Cp1306 t1b xs1p_n10 3.666e-17
Cp1307 t1b xs1p_x 1.288e-17
Cp1308 top_n top_p 1.431e-14
Cp1309 top_n vbn 7.955e-18
Cp1310 top_n vbp 5.288e-16
Cp1311 top_n vdd 4.478e-15
Cp1312 top_n vrefl 1.59e-16
Cp1313 top_n xc4_din 1.187e-15
Cp1314 top_n xc4_dip 3.358e-17
Cp1315 top_n xc4_xs1_tail 1.234e-15
Cp1316 top_n xc5_din 6.852e-15
Cp1317 top_n xc5_dip 2.554e-16
Cp1318 top_n xc5_lt 6.573e-17
Cp1319 top_n xc5_xs1_tail 2.086e-15
Cp1320 top_n xc5_xs1_tail0 6.266e-17
Cp1321 top_n xs0n_cbn 9.294e-16
Cp1322 top_n xs0n_cbp 8.615e-18
Cp1323 top_n xs0n_g 3.451e-16
Cp1324 top_n xs0n_n10 1.874e-18
Cp1325 top_n xs0n_x 1.085e-16
Cp1326 top_n xs0p_g 3.013e-18
Cp1327 top_n xs1n_cbn 1.367e-15
Cp1328 top_n xs1n_cbp 2.206e-16
Cp1329 top_n xs1n_g 4.367e-16
Cp1330 top_n xs1n_n10 5.751e-17
Cp1331 top_n xs1n_x 1.471e-15
Cp1332 top_n xs1p_cbn 1.095e-19
Cp1333 top_n xs1p_g 2.809e-17
Cp1334 top_p vbn 9.213e-18
Cp1335 top_p vbp 3.106e-16
Cp1336 top_p vdd 1.531e-15
Cp1337 top_p vref 2.671e-18
Cp1338 top_p vrefl 4.587e-16
Cp1339 top_p xc4_din 2.829e-16
Cp1340 top_p xc4_dip 1.12e-15
Cp1341 top_p xc4_xs1_tail 1.316e-15
Cp1342 top_p xc5_din 4.711e-15
Cp1343 top_p xc5_dip 7.672e-16
Cp1344 top_p xc5_lt 6.573e-17
Cp1345 top_p xc5_xs1_tail 1.146e-15
Cp1346 top_p xc5_xs1_tail0 6.207e-17
Cp1347 top_p xs0n_cbn 1.047e-16
Cp1348 top_p xs0n_cbp 1.138e-17
Cp1349 top_p xs0n_g 1.068e-15
Cp1350 top_p xs0n_n10 2.662e-18
Cp1351 top_p xs0n_x 2.049e-16
Cp1352 top_p xs0p_cbn 1.02e-16
Cp1353 top_p xs0p_g 7.132e-16
Cp1354 top_p xs0p_x 1.984e-18
Cp1355 top_p xs1n_cbn 2.984e-16
Cp1356 top_p xs1n_cbp 7.495e-18
Cp1357 top_p xs1n_g 5.256e-16
Cp1358 top_p xs1n_n10 7.713e-17
Cp1359 top_p xs1p_cbn 6.563e-18
Cp1360 top_p xs1p_g 9.282e-17
Cp1361 trk0 vdd 8.227e-17
Cp1362 trk1 vdd 8.316e-17
Cp1363 vbn vbp 6.149e-16
Cp1364 vbn vdd 1.39e-17
Cp1365 vbn xc5_din 2.446e-16
Cp1366 vbn xc5_dip 2.688e-17
Cp1367 vbn xc5_xs1_tail 1.228e-16
Cp1368 vbn xc5_xs1_tail0 3.32e-16
Cp1369 vbp vdd 2.736e-16
Cp1370 vbp vref 3.765e-16
Cp1371 vbp vrefl 2.524e-15
Cp1372 vbp xc4_din 8.025e-19
Cp1373 vbp xc4_dip 9.96e-17
Cp1374 vbp xc4_outnb 1.346e-18
Cp1375 vbp xc4_outpb 9.086e-18
Cp1376 vbp xc4_xs1_tail 4.683e-16
Cp1377 vbp xc4_xs1_tail0 1.067e-15
Cp1378 vbp xc5_din 3.072e-16
Cp1379 vbp xc5_dip 3.587e-16
Cp1380 vbp xc5_lt 3.65e-17
Cp1381 vbp xc5_outnb 1.781e-18
Cp1382 vbp xc5_xs1_tail 5.22e-17
Cp1383 vdd vref 2.004e-16
Cp1384 vdd vrefl 4.625e-16
Cp1385 vdd xc4_din 1.739e-14
Cp1386 vdd xc4_dip 1.398e-14
Cp1387 vdd xc4_lt 1.327e-18
Cp1388 vdd xc4_outnb 3.098e-16
Cp1389 vdd xc4_outpb 3.796e-16
Cp1390 vdd xc4_xs1_tail 5.159e-16
Cp1391 vdd xc4_xs1_tail0 2.388e-15
Cp1392 vdd xc5_din 2.819e-15
Cp1393 vdd xc5_dip 2.866e-15
Cp1394 vdd xc5_lt 3.1e-15
Cp1395 vdd xc5_outnb 3.207e-16
Cp1396 vdd xc5_outpb 6.032e-16
Cp1397 vdd xc5_xs1_tail 7.043e-19
Cp1398 vdd xs0n_cbn 2.79e-15
Cp1399 vdd xs0n_cbp 5.211e-16
Cp1400 vdd xs0n_g 1.78e-15
Cp1401 vdd xs0n_n10 7.497e-17
Cp1402 vdd xs0n_x 1.264e-15
Cp1403 vdd xs0p_cbn 2.701e-15
Cp1404 vdd xs0p_cbp 7.308e-16
Cp1405 vdd xs0p_g 1.077e-15
Cp1406 vdd xs0p_n10 8.715e-17
Cp1407 vdd xs0p_x 1.033e-15
Cp1408 vdd xs1n_cbn 2.568e-15
Cp1409 vdd xs1n_cbp 4.049e-16
Cp1410 vdd xs1n_g 1.417e-15
Cp1411 vdd xs1n_n10 1.028e-16
Cp1412 vdd xs1n_x 1.109e-15
Cp1413 vdd xs1p_cbn 1.204e-15
Cp1414 vdd xs1p_cbp 5.98e-16
Cp1415 vdd xs1p_g 8.987e-16
Cp1416 vdd xs1p_n10 3.202e-16
Cp1417 vdd xs1p_x 3.973e-16
Cp1418 vref vrefl 4.924e-16
Cp1419 vref xc4_din 8.874e-17
Cp1420 vref xc4_dip 1.645e-16
Cp1421 vref xc4_xs1_tail 2.626e-16
Cp1422 vref xc5_dip 1.073e-15
Cp1423 vref xc5_lt 1.974e-16
Cp1424 vref xc5_xs1_tail 5.098e-18
Cp1425 vrefl xc4_din 5.883e-16
Cp1426 vrefl xc4_dip 2.793e-16
Cp1427 vrefl xc4_xs1_tail 2.65e-16
Cp1428 vrefl xc5_din 3.18e-17
Cp1429 vrefl xc5_dip 2.877e-16
Cp1430 vrefl xc5_lt 2.003e-16
Cp1431 vrefl xc5_xs1_tail 3.572e-16
Cp1432 xc4_din xc4_dip 3.648e-15
Cp1433 xc4_din xc4_outnb 5e-17
Cp1434 xc4_din xc4_outpb 4.033e-17
Cp1435 xc4_din xc4_xs1_tail 3.916e-15
Cp1436 xc4_din xc5_din 4.839e-17
Cp1437 xc4_din xc5_dip 5.972e-16
Cp1438 xc4_din xc5_lt 1.103e-16
Cp1439 xc4_dip xc4_outnb 7.511e-17
Cp1440 xc4_dip xc4_outpb 6.046e-17
Cp1441 xc4_dip xc4_xs1_tail 3.94e-15
Cp1442 xc4_dip xc4_xs1_tail0 4.975e-18
Cp1443 xc4_dip xc5_din 3.496e-17
Cp1444 xc4_dip xc5_dip 2.112e-15
Cp1445 xc4_dip xc5_lt 1.487e-14
Cp1446 xc4_lt xc4_outpb 3.852e-19
Cp1447 xc4_lt xc5_outnb 3.807e-18
Cp1448 xc4_lt xc5_outpb 2.797e-17
Cp1449 xc4_outnb xc4_outpb 4.455e-15
Cp1450 xc4_outnb xc4_xs1_tail 2.092e-16
Cp1451 xc4_outnb xc4_xs1_tail0 1.371e-17
Cp1452 xc4_outnb xc5_lt 3.878e-17
Cp1453 xc4_outnb xc5_outnb 1.097e-16
Cp1454 xc4_outnb xc5_outpb 2.039e-16
Cp1455 xc4_outpb xc4_xs1_tail 2.411e-15
Cp1456 xc4_outpb xc4_xs1_tail0 1.152e-16
Cp1457 xc4_outpb xc5_lt 3.586e-17
Cp1458 xc4_outpb xc5_outnb 1.521e-16
Cp1459 xc4_outpb xc5_outpb 1.461e-16
Cp1460 xc4_xs1_tail xc4_xs1_tail0 7.609e-16
Cp1461 xc4_xs1_tail xc5_din 1.331e-15
Cp1462 xc4_xs1_tail xc5_dip 1.471e-15
Cp1463 xc4_xs1_tail xc5_lt 2.895e-15
Cp1464 xc4_xs1_tail0 xc5_lt 8.614e-17
Cp1465 xc4_xs1_tail0 xc5_outnb 1.852e-17
Cp1466 xc5_din xc5_dip 3.004e-15
Cp1467 xc5_din xc5_lt 2.205e-17
Cp1468 xc5_din xc5_xs1_tail 3.147e-15
Cp1469 xc5_din xc5_xs1_tail0 1.229e-16
Cp1470 xc5_dip xc5_lt 1.056e-19
Cp1471 xc5_dip xc5_xs1_tail 5.565e-15
Cp1472 xc5_dip xc5_xs1_tail0 8.93e-17
Cp1473 xc5_lt xc5_outnb 1.916e-17
Cp1474 xc5_lt xc5_outpb 2.058e-17
Cp1475 xc5_outnb xc5_outpb 5.331e-16
Cp1476 xc5_xs1_tail xc5_xs1_tail0 3.245e-16
Cp1477 xs0n_cbn xs0n_cbp 3.653e-16
Cp1478 xs0n_cbn xs0n_g 6.406e-16
Cp1479 xs0n_cbn xs0n_n10 5.002e-16
Cp1480 xs0n_cbn xs0n_x 8.496e-16
Cp1481 xs0n_cbp xs0n_g 7.15e-16
Cp1482 xs0n_cbp xs0n_n10 3.924e-17
Cp1483 xs0n_cbp xs0n_x 9.969e-17
Cp1484 xs0n_cbp xs0p_g 2.295e-17
Cp1485 xs0n_g xs0n_n10 4.966e-16
Cp1486 xs0n_g xs0n_x 1.317e-15
Cp1487 xs0n_g xs0p_g 7.106e-18
Cp1488 xs0n_n10 xs0n_x 2.348e-17
Cp1489 xs0n_x xs0p_g 1.341e-17
Cp1490 xs0p_cbn xs0p_cbp 9.998e-16
Cp1491 xs0p_cbn xs0p_g 1.551e-15
Cp1492 xs0p_cbn xs0p_n10 6.111e-16
Cp1493 xs0p_cbn xs0p_x 1.104e-15
Cp1494 xs0p_cbp xs0p_g 6.461e-16
Cp1495 xs0p_cbp xs0p_n10 7.24e-17
Cp1496 xs0p_cbp xs0p_x 6.7e-16
Cp1497 xs0p_g xs0p_n10 5.16e-16
Cp1498 xs0p_g xs0p_x 1.545e-15
Cp1499 xs0p_n10 xs0p_x 2.417e-17
Cp1500 xs1n_cbn xs1n_cbp 3.588e-16
Cp1501 xs1n_cbn xs1n_g 6.176e-16
Cp1502 xs1n_cbn xs1n_n10 5.01e-16
Cp1503 xs1n_cbn xs1n_x 8.503e-16
Cp1504 xs1n_cbp xs1n_g 5.548e-16
Cp1505 xs1n_cbp xs1n_n10 4.161e-17
Cp1506 xs1n_cbp xs1n_x 1.126e-16
Cp1507 xs1n_cbp xs1p_g 2.233e-17
Cp1508 xs1n_g xs1n_n10 5.029e-16
Cp1509 xs1n_g xs1n_x 1.692e-15
Cp1510 xs1n_g xs1p_g 1.03e-17
Cp1511 xs1n_n10 xs1n_x 2.414e-17
Cp1512 xs1n_x xs1p_g 1.184e-17
Cp1513 xs1p_cbn xs1p_cbp 1.198e-15
Cp1514 xs1p_cbn xs1p_g 1.946e-15
Cp1515 xs1p_cbn xs1p_n10 6.651e-16
Cp1516 xs1p_cbn xs1p_x 1.323e-15
Cp1517 xs1p_cbp xs1p_g 5.822e-16
Cp1518 xs1p_cbp xs1p_n10 7.928e-17
Cp1519 xs1p_cbp xs1p_x 7.135e-16
Cp1520 xs1p_g xs1p_n10 5.137e-16
Cp1521 xs1p_g xs1p_x 1.824e-15
Cp1522 xs1p_n10 xs1p_x 2.53e-17
.ends
.subckt r1_adc_lay adc_hold is_smp clk adc_start adc_sel adc_valid_a adc_raw_a_0 adc_raw_a_1 adc_raw_a_2 adc_raw_a_3 adc_raw_a_4 adc_raw_a_5 adc_raw_a_6 adc_raw_a_7 adc_raw_a_8 adc_raw_a_9 adc_raw_a_10 adc_raw_a_11 adc_raw_a_12 adc_raw_a_13 adc_valid_b adc_raw_b_0 adc_raw_b_1 adc_raw_b_2 adc_raw_b_3 adc_raw_b_4 adc_raw_b_5 adc_raw_b_6 adc_raw_b_7 adc_raw_b_8 adc_raw_b_9 adc_raw_b_10 adc_raw_b_11 adc_raw_b_12 adc_raw_b_13 por_n ain_sin_p ain_sin_n ain_cos_p ain_cos_n vcm2 ibias ain_isa_p ain_isa_n ain_isb_p ain_isb_n vcm vdda vdd vss vref_in topap topan topbp topbn sar_clka sar_clkab sar_clkb sar_clkbb sar_clkna sar_clknab sar_clknb sar_clknbb sar_cna0 sar_cna1 sar_cna10 sar_cna11 sar_cna12 sar_cna2 sar_cna3 sar_cna4 sar_cna5 sar_cna6 sar_cna7 sar_cna8 sar_cna9 sar_cnb0 sar_cnb1 sar_cnb10 sar_cnb11 sar_cnb12 sar_cnb2 sar_cnb3 sar_cnb4 sar_cnb5 sar_cnb6 sar_cnb7 sar_cnb8 sar_cnb9 sar_cpa0 sar_cpa1 sar_cpa10 sar_cpa11 sar_cpa12 sar_cpa2 sar_cpa3 sar_cpa4 sar_cpa5 sar_cpa6 sar_cpa7 sar_cpa8 sar_cpa9 sar_cpb0 sar_cpb1 sar_cpb10 sar_cpb11 sar_cpb12 sar_cpb2 sar_cpb3 sar_cpb4 sar_cpb5 sar_cpb6 sar_cpb7 sar_cpb8 sar_cpb9 sar_oan sar_oann sar_oanp sar_oap sar_obn sar_obnn sar_obnp sar_obp sar_trka0 sar_trka1 sar_trkb0 sar_trkb1 sar_mclk
Xxckg_xpd0 xckg_d0__p1 clk vdd__p2 vdd sg13_lv_pmos w=1u l=0.5u ng=1 m=1
Xxckg_xnd0 xckg_d0 clk vss__p9 vss sg13_lv_nmos w=0.5u l=0.5u ng=1 m=1
Xxckg_cd0 xckg_d0__p2 vss__p16 cap_cmim w=2.53u l=2.53u m=1
Xxckg_xpd1 xckg_d1__p1 xckg_d0 vdd__p3 vdd sg13_lv_pmos w=1u l=0.5u ng=1 m=1
Xxckg_xnd1 xckg_d1 xckg_d0 vss__p10 vss sg13_lv_nmos w=0.5u l=0.5u ng=1 m=1
Xxckg_cd1 xckg_d1__p2 vss__p17 cap_cmim w=2.53u l=2.53u m=1
Xxckg_xpd2 xckg_d2__p1 xckg_d1 vdd__p4 vdd sg13_lv_pmos w=1u l=0.5u ng=1 m=1
Xxckg_xnd2 xckg_d2 xckg_d1 vss__p11 vss sg13_lv_nmos w=0.5u l=0.5u ng=1 m=1
Xxckg_cd2 xckg_d2__p2 vss__p18 cap_cmim w=2.53u l=2.53u m=1
Xxckg_xpd3 xckg_d3__p1 xckg_d2 vdd__p5 vdd sg13_lv_pmos w=1u l=0.5u ng=1 m=1
Xxckg_xnd3 xckg_d3 xckg_d2 vss__p12 vss sg13_lv_nmos w=0.5u l=0.5u ng=1 m=1
Xxckg_cd3 xckg_d3__p2 vss__p19 cap_cmim w=2.53u l=2.53u m=1
Xxckg_xpd4 xckg_x__p2 xckg_d3 vdd__p6 vdd sg13_lv_pmos w=1u l=0.5u ng=1 m=1
Xxckg_xnd4 xckg_x xckg_d3 vss__p13 vss sg13_lv_nmos w=0.5u l=0.5u ng=1 m=1
Xxckg_cd4 xckg_x__p4 vss__p20 cap_cmim w=2.53u l=2.53u m=1
Xxckg_xpa sar_mclk__p2 clk__p1 vdd__p7 vdd sg13_lv_pmos w=2u l=0.13u ng=1 m=1
Xxckg_xpb sar_mclk__p3 xckg_x__p3 vdd__p8 vdd sg13_lv_pmos w=2u l=0.13u ng=1 m=1
Xxckg_xna sar_mclk clk__p0 xckg_nn vss sg13_lv_nmos w=2u l=0.13u ng=1 m=1
Xxckg_xnb xckg_nn__p1 xckg_x__p1 vss__p14 vss sg13_lv_nmos w=2u l=0.13u ng=1 m=1
Xxckg_xpi mclkb__p1 sar_mclk__p4 vdd__p9 vdd sg13_lv_pmos w=2u l=0.13u ng=1 m=1
Xxckg_xni mclkb sar_mclk__p1 vss__p15 vss sg13_lv_nmos w=1u l=0.13u ng=1 m=1
Xxcbias_xmbd vbp__p1 vbp vdd__p1 vdd sg13_lv_pmos w=0.8u l=0.5u ng=1 m=1
Xxcbias_xrb_g0 vbp xcbias_xrb_s1 vss rppd w=1u l=40u m=1 b=0
Xxcbias_xrb_g1 xcbias_xrb_s1 xcbias_xrb_s2 vss rppd w=1u l=40u m=1 b=0
Xxcbias_xrb_g2 xcbias_xrb_s2 xcbias_xrb_s3 vss rppd w=1u l=40u m=1 b=0
Xxcbias_xrb_g3 xcbias_xrb_s3 vss__p7 vss rppd w=1u l=40u m=1 b=0
Xxcbiasn_xmbd vbn__p1 vbn vss__p8 vss sg13_lv_nmos w=0.2u l=0.5u ng=1 m=1
Xxcbiasn_xrb_g0 vdd__p0 xcbiasn_xrb_s1 vss rppd w=1u l=40u m=1 b=0
Xxcbiasn_xrb_g1 xcbiasn_xrb_s1 xcbiasn_xrb_s2 vss rppd w=1u l=40u m=1 b=0
Xxcbiasn_xrb_g2 xcbiasn_xrb_s2 xcbiasn_xrb_s3 vss rppd w=1u l=40u m=1 b=0
Xxcbiasn_xrb_g3 xcbiasn_xrb_s3 vbn vss rppd w=1u l=40u m=1 b=0
Xxref_xmb0 ibias__p0 ibias vss__p5 vss sg13_hv_nmos w=2u l=1u ng=1 m=1
Xxref_xmt xref_ntl ibias vss__p6 vss sg13_hv_nmos w=2u l=8u ng=1 m=1
Xxref_xm1 xref_na vref_in xref_ntl__p1 vss sg13_hv_nmos w=10u l=1u ng=2 m=1
Xxref_xm2 xref_ng vref xref_ntl__p2 vss sg13_hv_nmos w=10u l=1u ng=2 m=1
Xxref_xm3 xref_na__p1 xref_na vdda__p5 vdda sg13_hv_pmos w=4u l=1u ng=1 m=1
Xxref_xm4 xref_ng__p1 xref_na vdda__p6 vdda sg13_hv_pmos w=4u l=1u ng=1 m=1
Xxref_xcg_u0 vss xref_ng cap_cmim w=26.32u l=95u m=1
Xxref_xmsf_s0 vdda__p1 xref_ng vref vss sg13_hv_nmos w=80u l=0.45u ng=32 m=1
Xxref_xmsf_s1 vdda__p2 xref_ng vref__p5 vss sg13_hv_nmos w=80u l=0.45u ng=32 m=1
Xxref_xmsf_s2 vdda__p3 xref_ng vref__p6 vss sg13_hv_nmos w=80u l=0.45u ng=32 m=1
Xxref_xmsf_s3 vdda__p4 xref_ng vref__p7 vss sg13_hv_nmos w=80u l=0.45u ng=32 m=1
Xxref_xmib_s0 vref__p0 ibias vss__p0 vss sg13_hv_nmos w=80u l=1u ng=40 m=1
Xxref_xmib_s1 vref__p1 ibias vss__p1 vss sg13_hv_nmos w=80u l=1u ng=40 m=1
Xxref_xmib_s2 vref__p2 ibias vss__p2 vss sg13_hv_nmos w=80u l=1u ng=40 m=1
Xxref_xmib_s3 vref__p3 ibias vss__p3 vss sg13_hv_nmos w=80u l=1u ng=40 m=1
Xxref_xcd_u0 vss vref cap_cmim w=51.58u l=95u m=4
Xxref_xmsfl_s0 vdda__p0 xref_ng vrefl vss sg13_hv_nmos w=80u l=0.45u ng=32 m=1
Xxref_xmibl_s0 vrefl__p0 ibias vss__p4 vss sg13_hv_nmos w=80u l=1u ng=40 m=1
Xxref_xcdl_u0 vss vrefl cap_cmim w=51.58u l=95u m=2
Xxfilt_xcf_u0 vss vref_in cap_cmim w=37.36u l=90u m=2
Xslice_a ain_sin_p__p1 ain_sin_n__p1 ain_isa_p__p1 ain_isa_n__p1 sar_trka0 sar_trka1 sar_cpa0 sar_cpa1 sar_cpa2 sar_cpa3 sar_cpa4 sar_cpa5 sar_cpa6 sar_cpa7 sar_cpa8 sar_cpa9 sar_cpa10 sar_cpa11 sar_cpa12 sar_cna0 sar_cna1 sar_cna2 sar_cna3 sar_cna4 sar_cna5 sar_cna6 sar_cna7 sar_cna8 sar_cna9 sar_cna10 sar_cna11 sar_cna12 sar_clka sar_clkab sar_clkna sar_clknab sar_oap sar_oan sar_oanp sar_oann vbp__p2 vbn__p2 vref__p8 vrefl__p2 vrefl__p3 topap topan vdd__p11 vdd__p12 vdd__p13 vdd__p14 vss__p22 vss__p23 vss__p24 vss__p25 r1_adc_slice_post
Xslice_b ain_cos_p__p1 ain_cos_n__p1 ain_isb_p__p1 ain_isb_n__p1 sar_trkb0 sar_trkb1 sar_cpb0 sar_cpb1 sar_cpb2 sar_cpb3 sar_cpb4 sar_cpb5 sar_cpb6 sar_cpb7 sar_cpb8 sar_cpb9 sar_cpb10 sar_cpb11 sar_cpb12 sar_cnb0 sar_cnb1 sar_cnb2 sar_cnb3 sar_cnb4 sar_cnb5 sar_cnb6 sar_cnb7 sar_cnb8 sar_cnb9 sar_cnb10 sar_cnb11 sar_cnb12 sar_clkb sar_clkbb sar_clknb sar_clknbb sar_obp sar_obn sar_obnp sar_obnn vbp__p3 vbn__p3 vref__p9 vrefl__p4 vrefl__p5 topbp topbn vdd__p15 vdd__p16 vdd__p17 vdd__p18 vss__p26 vss__p27 vss__p28 vss__p29 r1_adc_slice_post
Rt0 ain_cos_n ain_cos_n__p1 126.843
Rt1 ain_cos_p ain_cos_p__p1 128.661
Rt2 ain_isa_n ain_isa_n__p1 127.972
Rt3 ain_isa_p ain_isa_p__p1 129.791
Rt4 ain_isb_n ain_isb_n__p1 0.198
Rt5 ain_isb_p ain_isb_p__p1 0.198
Rt6 ain_sin_n ain_sin_n__p1 0.308
Rt7 ain_sin_p ain_sin_p__p1 0.308
Rt8 clk clk__p0 45.3911
Rt9 clk clk__p1 62.5679
Rt10 clk__p0 clk__p1 72.0627
Rt11 ibias ibias__p0 139.589
Rt12 mclkb mclkb__p1 43.3194
Rt13 sar_mclk sar_mclk__p1 56.5336
Rt14 sar_mclk sar_mclk__p3 125.793
Rt15 sar_mclk sar_mclk__p4 124.991
Rt16 sar_mclk__p1 sar_mclk__p3 116.67
Rt17 sar_mclk__p1 sar_mclk__p4 115.926
Rt18 sar_mclk__p2 sar_mclk__p3 0.6204
Rt19 sar_mclk__p3 sar_mclk__p4 23.2017
Rt20 vbn vbn__p1 68.3734
Rt21 vbn vbn__p2 257.848
Rt22 vbn vbn__p3 52140.1
Rt23 vbn__p1 vbn__p2 121.538
Rt24 vbn__p1 vbn__p3 24576.5
Rt25 vbn__p2 vbn__p3 67.329
Rt26 vbp vbp__p1 78.6118
Rt27 vbp vbp__p2 170.544
Rt28 vbp vbp__p3 22550.2
Rt29 vbp__p1 vbp__p2 136.122
Rt30 vbp__p1 vbp__p3 17998.8
Rt31 vbp__p2 vbp__p3 67.8656
Rt32 vdd vdd__p0 51.7969
Rt33 vdd vdd__p1 129.356
Rt34 vdd vdd__p11 227.932
Rt35 vdd vdd__p12 340.649
Rt36 vdd vdd__p13 1516.8
Rt37 vdd vdd__p14 3969.78
Rt38 vdd vdd__p15 7290.2
Rt39 vdd vdd__p16 18493.6
Rt40 vdd vdd__p17 198850
Rt41 vdd vdd__p18 378541
Rt42 vdd vdd__p2 9366.97
Rt43 vdd vdd__p3 12380.2
Rt44 vdd vdd__p4 16093
Rt45 vdd vdd__p5 20342.3
Rt46 vdd vdd__p6 24598.2
Rt47 vdd vdd__p7 53237.1
Rt48 vdd vdd__p8 57510.5
Rt49 vdd vdd__p9 60223.6
Rt50 vdd__p0 vdd__p1 185.206
Rt51 vdd__p0 vdd__p11 326.344
Rt52 vdd__p0 vdd__p12 487.728
Rt53 vdd__p0 vdd__p13 2171.69
Rt54 vdd__p0 vdd__p14 5683.77
Rt55 vdd__p0 vdd__p15 10437.8
Rt56 vdd__p0 vdd__p16 26478.5
Rt57 vdd__p0 vdd__p17 284706
Rt58 vdd__p0 vdd__p18 541980
Rt59 vdd__p0 vdd__p2 13411.3
Rt60 vdd__p0 vdd__p3 17725.5
Rt61 vdd__p0 vdd__p4 23041.3
Rt62 vdd__p0 vdd__p5 29125.3
Rt63 vdd__p0 vdd__p6 35218.7
Rt64 vdd__p0 vdd__p7 76222.8
Rt65 vdd__p0 vdd__p8 82341.3
Rt66 vdd__p0 vdd__p9 86225.7
Rt67 vdd__p1 vdd__p11 271.988
Rt68 vdd__p1 vdd__p12 406.492
Rt69 vdd__p1 vdd__p13 1809.98
Rt70 vdd__p1 vdd__p14 4737.09
Rt71 vdd__p1 vdd__p15 8699.31
Rt72 vdd__p1 vdd__p16 22068.2
Rt73 vdd__p1 vdd__p17 237286
Rt74 vdd__p1 vdd__p18 451709
Rt75 vdd__p1 vdd__p2 11177.5
Rt76 vdd__p1 vdd__p3 14773.1
Rt77 vdd__p1 vdd__p4 19203.5
Rt78 vdd__p1 vdd__p5 24274.2
Rt79 vdd__p1 vdd__p6 29352.7
Rt80 vdd__p1 vdd__p7 63527.2
Rt81 vdd__p1 vdd__p8 68626.7
Rt82 vdd__p1 vdd__p9 71864.1
Rt83 vdd__p11 vdd__p12 48.8126
Rt84 vdd__p11 vdd__p13 217.347
Rt85 vdd__p11 vdd__p14 568.842
Rt86 vdd__p11 vdd__p15 1044.64
Rt87 vdd__p11 vdd__p16 2650.01
Rt88 vdd__p11 vdd__p17 28493.9
Rt89 vdd__p11 vdd__p18 54242.4
Rt90 vdd__p11 vdd__p2 640.666
Rt91 vdd__p11 vdd__p3 846.759
Rt92 vdd__p11 vdd__p4 1100.7
Rt93 vdd__p11 vdd__p5 1391.34
Rt94 vdd__p11 vdd__p6 1682.42
Rt95 vdd__p11 vdd__p7 3641.22
Rt96 vdd__p11 vdd__p8 3933.51
Rt97 vdd__p11 vdd__p9 4119.07
Rt98 vdd__p12 vdd__p13 77.2099
Rt99 vdd__p12 vdd__p14 202.075
Rt100 vdd__p12 vdd__p15 371.095
Rt101 vdd__p12 vdd__p16 941.386
Rt102 vdd__p12 vdd__p17 10122.1
Rt103 vdd__p12 vdd__p18 19269
Rt104 vdd__p12 vdd__p2 2005.98
Rt105 vdd__p12 vdd__p3 2651.28
Rt106 vdd__p12 vdd__p4 3446.38
Rt107 vdd__p12 vdd__p5 4356.4
Rt108 vdd__p12 vdd__p6 5267.82
Rt109 vdd__p12 vdd__p7 11401
Rt110 vdd__p12 vdd__p8 12316.2
Rt111 vdd__p12 vdd__p9 12897.2
Rt112 vdd__p13 vdd__p14 49.1805
Rt113 vdd__p13 vdd__p15 90.3164
Rt114 vdd__p13 vdd__p16 229.113
Rt115 vdd__p13 vdd__p17 2463.51
Rt116 vdd__p13 vdd__p18 4689.65
Rt117 vdd__p13 vdd__p2 8931.97
Rt118 vdd__p13 vdd__p3 11805.3
Rt119 vdd__p13 vdd__p4 15345.6
Rt120 vdd__p13 vdd__p5 19397.6
Rt121 vdd__p13 vdd__p6 23455.9
Rt122 vdd__p13 vdd__p7 50764.8
Rt123 vdd__p13 vdd__p8 54839.8
Rt124 vdd__p13 vdd__p9 57426.8
Rt125 vdd__p14 vdd__p15 40.3724
Rt126 vdd__p14 vdd__p16 102.416
Rt127 vdd__p14 vdd__p17 1101.21
Rt128 vdd__p14 vdd__p18 2096.32
Rt129 vdd__p14 vdd__p2 23376.8
Rt130 vdd__p14 vdd__p3 30896.9
Rt131 vdd__p14 vdd__p4 40162.7
Rt132 vdd__p14 vdd__p5 50767.6
Rt133 vdd__p14 vdd__p6 61388.9
Rt134 vdd__p14 vdd__p7 132862
Rt135 vdd__p14 vdd__p8 143527
Rt136 vdd__p14 vdd__p9 150298
Rt137 vdd__p15 vdd__p16 53.0715
Rt138 vdd__p15 vdd__p17 570.644
Rt139 vdd__p15 vdd__p18 1086.31
Rt140 vdd__p15 vdd__p2 42929.8
Rt141 vdd__p15 vdd__p3 56739.8
Rt142 vdd__p15 vdd__p4 73755.8
Rt143 vdd__p15 vdd__p5 93230.9
Rt144 vdd__p15 vdd__p6 112736
Rt145 vdd__p15 vdd__p7 243991
Rt146 vdd__p15 vdd__p8 263577
Rt147 vdd__p15 vdd__p9 276011
Rt148 vdd__p16 vdd__p17 164.448
Rt149 vdd__p16 vdd__p18 313.051
Rt150 vdd__p16 vdd__p2 108904
Rt151 vdd__p16 vdd__p3 143936
Rt152 vdd__p16 vdd__p4 187102
Rt153 vdd__p16 vdd__p5 236506
Rt154 vdd__p16 vdd__p6 285987
Rt155 vdd__p16 vdd__p7 618953
Rt156 vdd__p16 vdd__p8 668637
Rt157 vdd__p16 vdd__p9 700179
Rt158 vdd__p17 vdd__p18 29.0526
Rt159 vdd__p2 vdd__p3 92.6957
Rt160 vdd__p2 vdd__p4 120.495
Rt161 vdd__p2 vdd__p5 152.311
Rt162 vdd__p2 vdd__p6 184.177
Rt163 vdd__p2 vdd__p7 398.608
Rt164 vdd__p2 vdd__p8 430.605
Rt165 vdd__p2 vdd__p9 450.919
Rt166 vdd__p3 vdd__p4 108.814
Rt167 vdd__p3 vdd__p5 137.546
Rt168 vdd__p3 vdd__p6 166.322
Rt169 vdd__p3 vdd__p7 359.966
Rt170 vdd__p3 vdd__p8 388.861
Rt171 vdd__p3 vdd__p9 407.206
Rt172 vdd__p4 vdd__p5 115.772
Rt173 vdd__p4 vdd__p6 139.993
Rt174 vdd__p4 vdd__p7 302.983
Rt175 vdd__p4 vdd__p8 327.304
Rt176 vdd__p4 vdd__p9 342.744
Rt177 vdd__p5 vdd__p6 112.042
Rt178 vdd__p5 vdd__p7 242.489
Rt179 vdd__p5 vdd__p8 261.954
Rt180 vdd__p5 vdd__p9 274.312
Rt181 vdd__p6 vdd__p7 187.851
Rt182 vdd__p6 vdd__p8 202.93
Rt183 vdd__p6 vdd__p9 212.503
Rt184 vdd__p7 vdd__p8 373.265
Rt185 vdd__p7 vdd__p9 390.874
Rt186 vdd__p8 vdd__p9 274.094
Rt187 vdda vdda__p1 30.7341
Rt188 vdda__p0 vdda__p3 66.7792
Rt189 vdda__p0 vdda__p4 64.5261
Rt190 vdda__p1 vdda__p2 19.5742
Rt191 vdda__p2 vdda__p3 93.9618
Rt192 vdda__p2 vdda__p5 66.6691
Rt193 vdda__p2 vdda__p6 85.2968
Rt194 vdda__p3 vdda__p4 23.0035
Rt195 vdda__p3 vdda__p5 88.1947
Rt196 vdda__p3 vdda__p6 68.6694
Rt197 vdda__p5 vdda__p6 80.0616
Rt198 vref vref__p1 86.8906
Rt199 vref vref__p5 23.6974
Rt200 vref vref__p8 154.432
Rt201 vref vref__p9 282.142
Rt202 vref__p0 vref__p1 54.8427
Rt203 vref__p1 vref__p5 91.2944
Rt204 vref__p1 vref__p8 108.337
Rt205 vref__p1 vref__p9 197.929
Rt206 vref__p2 vref__p3 54.8427
Rt207 vref__p2 vref__p6 37.2232
Rt208 vref__p5 vref__p6 54.9082
Rt209 vref__p5 vref__p8 162.259
Rt210 vref__p5 vref__p9 296.442
Rt211 vref__p6 vref__p7 18.9765
Rt212 vref__p8 vref__p9 6.67381
Rt213 vrefl vrefl__p0 91.2046
Rt214 vrefl vrefl__p2 13503.5
Rt215 vrefl vrefl__p3 90.8685
Rt216 vrefl vrefl__p4 76.5298
Rt217 vrefl vrefl__p5 5238.83
Rt218 vrefl__p0 vrefl__p2 10160.7
Rt219 vrefl__p0 vrefl__p3 68.3742
Rt220 vrefl__p0 vrefl__p4 96.5153
Rt221 vrefl__p0 vrefl__p5 6606.94
Rt222 vrefl__p2 vrefl__p3 16.5223
Rt223 vrefl__p2 vrefl__p4 14289.8
Rt224 vrefl__p2 vrefl__p5 978205
Rt225 vrefl__p3 vrefl__p4 96.1596
Rt226 vrefl__p3 vrefl__p5 6582.59
Rt227 vrefl__p4 vrefl__p5 16.6771
Rt228 vss vss__p0 64.0123
Rt229 vss vss__p1 683.259
Rt230 vss vss__p10 0.001
Rt231 vss vss__p2 371.2
Rt232 vss vss__p22 97.4665
Rt233 vss vss__p23 273.377
Rt234 vss vss__p24 471242
Rt235 vss vss__p25 358523
Rt236 vss vss__p26 51921.8
Rt237 vss vss__p27 86075
Rt238 vss vss__p28 244.041
Rt239 vss vss__p29 100.595
Rt240 vss vss__p3 217.277
Rt241 vss vss__p4 1870.56
Rt242 vss vss__p5 2480.51
Rt243 vss vss__p6 3517.19
Rt244 vss vss__p7 118.25
Rt245 vss vss__p8 119.221
Rt246 vss__p0 vss__p1 161.851
Rt247 vss__p0 vss__p2 2839.25
Rt248 vss__p0 vss__p22 263.99
Rt249 vss__p0 vss__p23 740.446
Rt250 vss__p0 vss__p24 111628
Rt251 vss__p0 vss__p25 84927.1
Rt252 vss__p0 vss__p26 12299.3
Rt253 vss__p0 vss__p27 20389.5
Rt254 vss__p0 vss__p28 1815.36
Rt255 vss__p0 vss__p29 748.299
Rt256 vss__p0 vss__p3 1661.92
Rt257 vss__p0 vss__p4 443.099
Rt258 vss__p0 vss__p5 587.584
Rt259 vss__p0 vss__p6 833.152
Rt260 vss__p0 vss__p7 320.451
Rt261 vss__p0 vss__p8 322.646
Rt262 vss__p1 vss__p2 30305.8
Rt263 vss__p1 vss__p22 2817.79
Rt264 vss__p1 vss__p23 7903.42
Rt265 vss__p1 vss__p24 84165.5
Rt266 vss__p1 vss__p25 64033.5
Rt267 vss__p1 vss__p26 9273.42
Rt268 vss__p1 vss__p27 15373.3
Rt269 vss__p1 vss__p28 19376.9
Rt270 vss__p1 vss__p29 7987.25
Rt271 vss__p1 vss__p3 17739.1
Rt272 vss__p1 vss__p4 334.089
Rt273 vss__p1 vss__p5 443.028
Rt274 vss__p1 vss__p6 628.182
Rt275 vss__p1 vss__p7 3420.45
Rt276 vss__p1 vss__p8 3443.88
Rt277 vss__p10 vss__p11 113.514
Rt278 vss__p10 vss__p12 143.98
Rt279 vss__p10 vss__p13 175.022
Rt280 vss__p10 vss__p14 393.007
Rt281 vss__p10 vss__p15 251.471
Rt282 vss__p10 vss__p16 619.655
Rt283 vss__p10 vss__p17 663.526
Rt284 vss__p10 vss__p18 489.378
Rt285 vss__p10 vss__p19 10540.7
Rt286 vss__p10 vss__p20 51601.3
Rt287 vss__p10 vss__p9 98.2846
Rt288 vss__p11 vss__p12 120.167
Rt289 vss__p11 vss__p13 146.721
Rt290 vss__p11 vss__p14 381.007
Rt291 vss__p11 vss__p15 213.501
Rt292 vss__p11 vss__p16 622.078
Rt293 vss__p11 vss__p17 666.121
Rt294 vss__p11 vss__p18 491.292
Rt295 vss__p11 vss__p19 10581.9
Rt296 vss__p11 vss__p20 51803
Rt297 vss__p11 vss__p9 127.728
Rt298 vss__p12 vss__p13 117.108
Rt299 vss__p12 vss__p14 339.683
Rt300 vss__p12 vss__p15 171.879
Rt301 vss__p12 vss__p16 572.183
Rt302 vss__p12 vss__p17 612.694
Rt303 vss__p12 vss__p18 451.887
Rt304 vss__p12 vss__p19 9733.2
Rt305 vss__p12 vss__p20 47648.1
Rt306 vss__p12 vss__p9 161.388
Rt307 vss__p13 vss__p14 283.157
Rt308 vss__p13 vss__p15 133.639
Rt309 vss__p13 vss__p16 488.476
Rt310 vss__p13 vss__p17 523.06
Rt311 vss__p13 vss__p18 385.779
Rt312 vss__p13 vss__p19 8309.28
Rt313 vss__p13 vss__p20 40677.4
Rt314 vss__p13 vss__p9 195.03
Rt315 vss__p14 vss__p15 225.414
Rt316 vss__p14 vss__p16 211.446
Rt317 vss__p14 vss__p17 226.416
Rt318 vss__p14 vss__p18 166.991
Rt319 vss__p14 vss__p19 3596.83
Rt320 vss__p14 vss__p20 17608
Rt321 vss__p14 vss__p9 371.254
Rt322 vss__p15 vss__p16 338.846
Rt323 vss__p15 vss__p17 362.836
Rt324 vss__p15 vss__p18 267.607
Rt325 vss__p15 vss__p19 5763.98
Rt326 vss__p15 vss__p20 28217.1
Rt327 vss__p15 vss__p9 275.605
Rt328 vss__p16 vss__p17 48.9479
Rt329 vss__p16 vss__p18 36.1012
Rt330 vss__p16 vss__p19 777.582
Rt331 vss__p16 vss__p20 3806.59
Rt332 vss__p16 vss__p9 566.446
Rt333 vss__p17 vss__p18 34.3505
Rt334 vss__p17 vss__p19 739.876
Rt335 vss__p17 vss__p20 3622
Rt336 vss__p17 vss__p9 606.55
Rt337 vss__p18 vss__p19 0.666482
Rt338 vss__p18 vss__p20 3.26271
Rt339 vss__p18 vss__p9 447.356
Rt340 vss__p19 vss__p20 0.970961
Rt341 vss__p19 vss__p9 9635.59
Rt342 vss__p2 vss__p22 4002.37
Rt343 vss__p2 vss__p23 11226
Rt344 vss__p2 vss__p28 1236.98
Rt345 vss__p2 vss__p29 509.888
Rt346 vss__p2 vss__p3 62.1518
Rt347 vss__p2 vss__p4 82968.3
Rt348 vss__p2 vss__p5 110022
Rt349 vss__p2 vss__p6 156004
Rt350 vss__p2 vss__p7 4737.78
Rt351 vss__p2 vss__p8 4990.17
Rt352 vss__p20 vss__p9 47170.3
Rt353 vss__p22 vss__p23 13.1644
Rt354 vss__p22 vss__p26 214128
Rt355 vss__p22 vss__p27 354978
Rt356 vss__p22 vss__p28 2291.22
Rt357 vss__p22 vss__p29 944.448
Rt358 vss__p22 vss__p3 2342.74
Rt359 vss__p22 vss__p4 7714.29
Rt360 vss__p22 vss__p5 10229.7
Rt361 vss__p22 vss__p6 14505
Rt362 vss__p22 vss__p7 105.519
Rt363 vss__p22 vss__p8 133.386
Rt364 vss__p23 vss__p26 600593
Rt365 vss__p23 vss__p27 995651
Rt366 vss__p23 vss__p28 6426.46
Rt367 vss__p23 vss__p29 2649.01
Rt368 vss__p23 vss__p3 6570.98
Rt369 vss__p23 vss__p4 21637.2
Rt370 vss__p23 vss__p5 28692.7
Rt371 vss__p23 vss__p6 40684.2
Rt372 vss__p23 vss__p7 295.961
Rt373 vss__p23 vss__p8 374.125
Rt374 vss__p24 vss__p25 97.1468
Rt375 vss__p24 vss__p26 129.246
Rt376 vss__p24 vss__p27 1768.45
Rt377 vss__p24 vss__p4 19241.6
Rt378 vss__p24 vss__p5 8459.44
Rt379 vss__p24 vss__p6 1790.84
Rt380 vss__p25 vss__p26 98.3311
Rt381 vss__p25 vss__p27 1345.45
Rt382 vss__p25 vss__p4 14639.1
Rt383 vss__p25 vss__p5 6435.98
Rt384 vss__p25 vss__p6 1362.48
Rt385 vss__p26 vss__p27 194.85
Rt386 vss__p26 vss__p29 606963
Rt387 vss__p26 vss__p4 2120.05
Rt388 vss__p26 vss__p5 932.068
Rt389 vss__p26 vss__p6 197.317
Rt390 vss__p26 vss__p7 259925
Rt391 vss__p26 vss__p8 261706
Rt392 vss__p27 vss__p4 3514.58
Rt393 vss__p27 vss__p5 1545.17
Rt394 vss__p27 vss__p6 327.108
Rt395 vss__p27 vss__p7 430899
Rt396 vss__p27 vss__p8 433851
Rt397 vss__p28 vss__p29 11.3118
Rt398 vss__p28 vss__p3 724.052
Rt399 vss__p28 vss__p4 53048.4
Rt400 vss__p28 vss__p5 70346.2
Rt401 vss__p28 vss__p6 99746
Rt402 vss__p28 vss__p7 2611
Rt403 vss__p28 vss__p8 2945.87
Rt404 vss__p29 vss__p3 298.457
Rt405 vss__p29 vss__p4 21866.7
Rt406 vss__p29 vss__p5 28997
Rt407 vss__p29 vss__p6 41115.7
Rt408 vss__p29 vss__p7 1076.26
Rt409 vss__p29 vss__p8 1214.3
Rt410 vss__p3 vss__p4 48564.5
Rt411 vss__p3 vss__p5 64400.3
Rt412 vss__p3 vss__p6 91315
Rt413 vss__p3 vss__p7 2773.2
Rt414 vss__p3 vss__p8 2920.94
Rt415 vss__p4 vss__p5 101.283
Rt416 vss__p4 vss__p6 143.612
Rt417 vss__p4 vss__p7 9364.19
Rt418 vss__p4 vss__p8 9428.33
Rt419 vss__p5 vss__p6 63.1383
Rt420 vss__p5 vss__p7 12417.6
Rt421 vss__p5 vss__p8 12502.7
Rt422 vss__p6 vss__p7 17607.3
Rt423 vss__p6 vss__p8 17727.9
Rt424 vss__p7 vss__p8 171.407
Rt425 xckg_d0 xckg_d0__p1 206.411
Rt426 xckg_d0 xckg_d0__p2 50.6383
Rt427 xckg_d0__p1 xckg_d0__p2 40.5376
Rt428 xckg_d1 xckg_d1__p1 176.827
Rt429 xckg_d1 xckg_d1__p2 53.6164
Rt430 xckg_d1__p1 xckg_d1__p2 42.2433
Rt431 xckg_d2 xckg_d2__p1 98.5076
Rt432 xckg_d2 xckg_d2__p2 97.0379
Rt433 xckg_d2__p1 xckg_d2__p2 76.6587
Rt434 xckg_d3 xckg_d3__p1 99.3636
Rt435 xckg_d3 xckg_d3__p2 100.408
Rt436 xckg_d3__p1 xckg_d3__p2 78.0493
Rt437 xckg_nn xckg_nn__p1 46.1928
Rt438 xckg_x xckg_x__p1 68.4444
Rt439 xckg_x xckg_x__p2 147.088
Rt440 xckg_x xckg_x__p3 1240.78
Rt441 xckg_x xckg_x__p4 614.493
Rt442 xckg_x__p1 xckg_x__p2 97.458
Rt443 xckg_x__p1 xckg_x__p3 822.123
Rt444 xckg_x__p1 xckg_x__p4 407.153
Rt445 xckg_x__p2 xckg_x__p3 124.848
Rt446 xckg_x__p2 xckg_x__p4 61.8301
Rt447 xckg_x__p3 xckg_x__p4 33.2764
Rt448 xref_na xref_na__p1 77.984
Rt449 xref_ng xref_ng__p1 98.1201
Rt450 xref_ntl xref_ntl__p1 60.2546
Rt451 xref_ntl__p1 xref_ntl__p2 19.318
Cq0 ain_cos_n ain_cos_p 2.709e-14
Cq1 ain_cos_n ain_isa_n 3.644e-17
Cq2 ain_cos_n ain_isa_p 4.64e-17
Cq3 ain_cos_n ibias 5.314e-17
Cq4 ain_cos_n vdd 5.829e-16
Cq5 ain_cos_n vss 2.705e-14
Cq6 ain_cos_n xckg_d0 9.755e-19
Cq7 ain_cos_n xckg_d1 9.755e-19
Cq8 ain_cos_n xckg_d2 9.755e-19
Cq9 ain_cos_n xckg_d3 1.006e-18
Cq10 ain_cos_n xckg_x 5.633e-18
Cq11 ain_cos_p ain_isa_n 4.287e-17
Cq12 ain_cos_p ain_isa_p 7.229e-16
Cq13 ain_cos_p ibias 3.52e-15
Cq14 ain_cos_p vdd 2.509e-15
Cq15 ain_cos_p vss 1.273e-14
Cq16 ain_isa_n ain_isa_p 2.783e-14
Cq17 ain_isa_n ain_isb_n 6.15e-17
Cq18 ain_isa_n ain_isb_p 6.417e-17
Cq19 ain_isa_n vss 2.894e-14
Cq20 ain_isa_p ain_isb_n 7.645e-17
Cq21 ain_isa_p ain_isb_p 7.912e-17
Cq22 ain_isa_p vss 2.868e-14
Cq23 ain_isb_n ain_isb_p 7.431e-17
Cq24 ain_isb_n vss 9.265e-16
Cq25 ain_isb_p vss 8.611e-16
Cq26 ain_sin_n ain_sin_p 8.625e-17
Cq27 ain_sin_n ibias 9.414e-17
Cq28 ain_sin_n vdd 2.257e-16
Cq29 ain_sin_n vss 7.685e-16
Cq30 ain_sin_p ibias 9.681e-17
Cq31 ain_sin_p vdd 1.633e-16
Cq32 ain_sin_p vss 7.651e-16
Cq33 clk mclkb 2.216e-18
Cq34 clk sar_mclk 1.431e-16
Cq35 clk vdd 4.347e-16
Cq36 clk vss 1.85e-14
Cq37 clk xckg_d0 2.205e-16
Cq38 clk xckg_d1 1.236e-16
Cq39 clk xckg_d2 1.227e-16
Cq40 clk xckg_d3 1.663e-16
Cq41 clk xckg_nn 2.534e-17
Cq42 clk xckg_x 1.452e-16
Cq43 ibias vbn 3.378e-16
Cq44 ibias vbp 1.24e-16
Cq45 ibias vdd 6.258e-15
Cq46 ibias vdda 2.57e-16
Cq47 ibias vref 3.367e-14
Cq48 ibias vref_in 1.257e-14
Cq49 ibias vrefl 1.528e-14
Cq50 ibias vss 1.669e-13
Cq51 ibias xref_ng 2.502e-15
Cq52 ibias xref_ntl 1.763e-16
Cq53 mclkb sar_mclk 2.613e-16
Cq54 mclkb vdd 3.849e-16
Cq55 mclkb vss 1.23e-15
Cq56 mclkb xckg_d0 5.604e-17
Cq57 mclkb xckg_d1 3.991e-15
Cq58 mclkb xckg_d2 3.955e-15
Cq59 mclkb xckg_d3 6.865e-17
Cq60 mclkb xckg_nn 1.864e-17
Cq61 mclkb xckg_x 9.575e-17
Cq62 sar_mclk vdd 1.621e-15
Cq63 sar_mclk vss 6.739e-15
Cq64 sar_mclk xckg_d0 4.707e-15
Cq65 sar_mclk xckg_d1 2.058e-16
Cq66 sar_mclk xckg_d2 7.519e-17
Cq67 sar_mclk xckg_d3 9.271e-17
Cq68 sar_mclk xckg_nn 4.141e-16
Cq69 sar_mclk xckg_x 1.044e-15
Cq70 vbn vbp 4.048e-14
Cq71 vbn vdd 2.668e-14
Cq72 vbn vdda 4.597e-16
Cq73 vbn vref 1.548e-14
Cq74 vbn vref_in 2.405e-15
Cq75 vbn vrefl 8.131e-15
Cq76 vbn vss 1.116e-14
Cq77 vbn xref_ng 1.543e-15
Cq78 vbp vdd 1.669e-15
Cq79 vbp vdda 1.395e-15
Cq80 vbp vref 2.767e-14
Cq81 vbp vref_in 4.117e-15
Cq82 vbp vrefl 7.984e-15
Cq83 vbp vss 1.325e-14
Cq84 vbp xref_ng 1.886e-15
Cq85 vdd vdda 3.895e-16
Cq86 vdd vref 3.92e-14
Cq87 vdd vref_in 2.491e-14
Cq88 vdd vrefl 1.224e-14
Cq89 vdd vss 6.927e-14
Cq90 vdd xckg_d0 5.466e-16
Cq91 vdd xckg_d1 3.974e-16
Cq92 vdd xckg_d2 2.624e-16
Cq93 vdd xckg_d3 3.649e-16
Cq94 vdd xckg_x 1.1e-15
Cq95 vdd xref_ng 3.009e-15
Cq96 vdda vref 4e-14
Cq97 vdda vref_in 3.048e-16
Cq98 vdda vrefl 1.272e-14
Cq99 vdda vss 3.096e-14
Cq100 vdda xref_na 7.939e-16
Cq101 vdda xref_ng 1.455e-14
Cq102 vdda xref_ntl 1.132e-17
Cq103 vref vref_in 4.546e-14
Cq104 vref vrefl 1.197e-13
Cq105 vref vss 3.586e-13
Cq106 vref xref_na 1.908e-16
Cq107 vref xref_ng 3.832e-14
Cq108 vref xref_ntl 9.852e-16
Cq109 vref_in vrefl 3.069e-14
Cq110 vref_in vss 1.048e-13
Cq111 vref_in xref_na 4.222e-16
Cq112 vref_in xref_ng 3.86e-15
Cq113 vref_in xref_ntl 1.282e-15
Cq114 vrefl vss 1.991e-13
Cq115 vrefl xref_na 8.519e-18
Cq116 vrefl xref_ng 2.644e-14
Cq117 vrefl xref_ntl 5.775e-16
Cq118 vss xckg_d0 4.966e-15
Cq119 vss xckg_d1 4.102e-15
Cq120 vss xckg_d2 4.83e-15
Cq121 vss xckg_d3 5.854e-15
Cq122 vss xckg_nn 1.117e-15
Cq123 vss xckg_x 1.086e-14
Cq124 vss xref_na 4.919e-15
Cq125 vss xref_ng 9.404e-14
Cq126 vss xref_ntl 4.054e-15
Cq127 xckg_d0 xckg_d1 8.434e-15
Cq128 xckg_d0 xckg_d2 2.37e-16
Cq129 xckg_d0 xckg_d3 1.818e-16
Cq130 xckg_d0 xckg_nn 2.011e-17
Cq131 xckg_d0 xckg_x 6.919e-16
Cq132 xckg_d1 xckg_d2 2.001e-15
Cq133 xckg_d1 xckg_d3 1.378e-16
Cq134 xckg_d1 xckg_nn 5.907e-16
Cq135 xckg_d1 xckg_x 4.219e-16
Cq136 xckg_d2 xckg_d3 8.547e-15
Cq137 xckg_d2 xckg_nn 5.574e-16
Cq138 xckg_d2 xckg_x 4.153e-16
Cq139 xckg_d3 xckg_nn 3.667e-17
Cq140 xckg_d3 xckg_x 5.111e-15
Cq141 xckg_nn xckg_x 1.118e-16
Cq142 xref_na xref_ng 2.502e-15
Cq143 xref_na xref_ntl 3.114e-16
Cq144 xref_ng xref_ntl 2.861e-15
.ends
.subckt r1_adc_lay_pr adc_hold is_smp clk adc_start adc_sel adc_valid_a adc_raw_a_0 adc_raw_a_1 adc_raw_a_2 adc_raw_a_3 adc_raw_a_4 adc_raw_a_5 adc_raw_a_6 adc_raw_a_7 adc_raw_a_8 adc_raw_a_9 adc_raw_a_10 adc_raw_a_11 adc_raw_a_12 adc_raw_a_13 adc_valid_b adc_raw_b_0 adc_raw_b_1 adc_raw_b_2 adc_raw_b_3 adc_raw_b_4 adc_raw_b_5 adc_raw_b_6 adc_raw_b_7 adc_raw_b_8 adc_raw_b_9 adc_raw_b_10 adc_raw_b_11 adc_raw_b_12 adc_raw_b_13 por_n ain_sin_p ain_sin_n ain_cos_p ain_cos_n vcm2 ibias ain_isa_p ain_isa_n ain_isb_p ain_isb_n vcm vdda vdd vss vref_in topap topan topbp topbn sar_clka sar_clkab sar_clkb sar_clkbb sar_clkna sar_clknab sar_clknb sar_clknbb sar_cna0 sar_cna1 sar_cna10 sar_cna11 sar_cna12 sar_cna2 sar_cna3 sar_cna4 sar_cna5 sar_cna6 sar_cna7 sar_cna8 sar_cna9 sar_cnb0 sar_cnb1 sar_cnb10 sar_cnb11 sar_cnb12 sar_cnb2 sar_cnb3 sar_cnb4 sar_cnb5 sar_cnb6 sar_cnb7 sar_cnb8 sar_cnb9 sar_cpa0 sar_cpa1 sar_cpa10 sar_cpa11 sar_cpa12 sar_cpa2 sar_cpa3 sar_cpa4 sar_cpa5 sar_cpa6 sar_cpa7 sar_cpa8 sar_cpa9 sar_cpb0 sar_cpb1 sar_cpb10 sar_cpb11 sar_cpb12 sar_cpb2 sar_cpb3 sar_cpb4 sar_cpb5 sar_cpb6 sar_cpb7 sar_cpb8 sar_cpb9 sar_oan sar_oann sar_oanp sar_oap sar_obn sar_obnn sar_obnp sar_obp sar_trka0 sar_trka1 sar_trkb0 sar_trkb1 sar_mclk vref vrefl
Xxckg_xpd0 xckg_d0__p1 clk vdd__p2 vdd sg13_lv_pmos w=1u l=0.5u ng=1 m=1
Xxckg_xnd0 xckg_d0 clk vss__p9 vss sg13_lv_nmos w=0.5u l=0.5u ng=1 m=1
Xxckg_cd0 xckg_d0__p2 vss__p16 cap_cmim w=2.53u l=2.53u m=1
Xxckg_xpd1 xckg_d1__p1 xckg_d0 vdd__p3 vdd sg13_lv_pmos w=1u l=0.5u ng=1 m=1
Xxckg_xnd1 xckg_d1 xckg_d0 vss__p10 vss sg13_lv_nmos w=0.5u l=0.5u ng=1 m=1
Xxckg_cd1 xckg_d1__p2 vss__p17 cap_cmim w=2.53u l=2.53u m=1
Xxckg_xpd2 xckg_d2__p1 xckg_d1 vdd__p4 vdd sg13_lv_pmos w=1u l=0.5u ng=1 m=1
Xxckg_xnd2 xckg_d2 xckg_d1 vss__p11 vss sg13_lv_nmos w=0.5u l=0.5u ng=1 m=1
Xxckg_cd2 xckg_d2__p2 vss__p18 cap_cmim w=2.53u l=2.53u m=1
Xxckg_xpd3 xckg_d3__p1 xckg_d2 vdd__p5 vdd sg13_lv_pmos w=1u l=0.5u ng=1 m=1
Xxckg_xnd3 xckg_d3 xckg_d2 vss__p12 vss sg13_lv_nmos w=0.5u l=0.5u ng=1 m=1
Xxckg_cd3 xckg_d3__p2 vss__p19 cap_cmim w=2.53u l=2.53u m=1
Xxckg_xpd4 xckg_x__p2 xckg_d3 vdd__p6 vdd sg13_lv_pmos w=1u l=0.5u ng=1 m=1
Xxckg_xnd4 xckg_x xckg_d3 vss__p13 vss sg13_lv_nmos w=0.5u l=0.5u ng=1 m=1
Xxckg_cd4 xckg_x__p4 vss__p20 cap_cmim w=2.53u l=2.53u m=1
Xxckg_xpa sar_mclk__p2 clk__p1 vdd__p7 vdd sg13_lv_pmos w=2u l=0.13u ng=1 m=1
Xxckg_xpb sar_mclk__p3 xckg_x__p3 vdd__p8 vdd sg13_lv_pmos w=2u l=0.13u ng=1 m=1
Xxckg_xna sar_mclk clk__p0 xckg_nn vss sg13_lv_nmos w=2u l=0.13u ng=1 m=1
Xxckg_xnb xckg_nn__p1 xckg_x__p1 vss__p14 vss sg13_lv_nmos w=2u l=0.13u ng=1 m=1
Xxckg_xpi mclkb__p1 sar_mclk__p4 vdd__p9 vdd sg13_lv_pmos w=2u l=0.13u ng=1 m=1
Xxckg_xni mclkb sar_mclk__p1 vss__p15 vss sg13_lv_nmos w=1u l=0.13u ng=1 m=1
Xxcbias_xmbd vbp__p1 vbp vdd__p1 vdd sg13_lv_pmos w=0.8u l=0.5u ng=1 m=1
Xxcbias_xrb_g0 vbp xcbias_xrb_s1 vss rppd w=1u l=40u m=1 b=0
Xxcbias_xrb_g1 xcbias_xrb_s1 xcbias_xrb_s2 vss rppd w=1u l=40u m=1 b=0
Xxcbias_xrb_g2 xcbias_xrb_s2 xcbias_xrb_s3 vss rppd w=1u l=40u m=1 b=0
Xxcbias_xrb_g3 xcbias_xrb_s3 vss__p7 vss rppd w=1u l=40u m=1 b=0
Xxcbiasn_xmbd vbn__p1 vbn vss__p8 vss sg13_lv_nmos w=0.2u l=0.5u ng=1 m=1
Xxcbiasn_xrb_g0 vdd__p0 xcbiasn_xrb_s1 vss rppd w=1u l=40u m=1 b=0
Xxcbiasn_xrb_g1 xcbiasn_xrb_s1 xcbiasn_xrb_s2 vss rppd w=1u l=40u m=1 b=0
Xxcbiasn_xrb_g2 xcbiasn_xrb_s2 xcbiasn_xrb_s3 vss rppd w=1u l=40u m=1 b=0
Xxcbiasn_xrb_g3 xcbiasn_xrb_s3 vbn vss rppd w=1u l=40u m=1 b=0
Xxref_xmb0 ibias__p0 ibias vss__p5 vss sg13_hv_nmos w=2u l=1u ng=1 m=1
Xxref_xmt xref_ntl ibias vss__p6 vss sg13_hv_nmos w=2u l=8u ng=1 m=1
Xxref_xm1 xref_na vref_in xref_ntl__p1 vss sg13_hv_nmos w=10u l=1u ng=2 m=1
Xxref_xm2 xref_ng vref xref_ntl__p2 vss sg13_hv_nmos w=10u l=1u ng=2 m=1
Xxref_xm3 xref_na__p1 xref_na vdda__p5 vdda sg13_hv_pmos w=4u l=1u ng=1 m=1
Xxref_xm4 xref_ng__p1 xref_na vdda__p6 vdda sg13_hv_pmos w=4u l=1u ng=1 m=1
Xxref_xcg_u0 vss xref_ng cap_cmim w=26.32u l=95u m=1
Xxref_xmsf_s0 vdda__p1 xref_ng vref vss sg13_hv_nmos w=80u l=0.45u ng=32 m=1
Xxref_xmsf_s1 vdda__p2 xref_ng vref__p5 vss sg13_hv_nmos w=80u l=0.45u ng=32 m=1
Xxref_xmsf_s2 vdda__p3 xref_ng vref__p6 vss sg13_hv_nmos w=80u l=0.45u ng=32 m=1
Xxref_xmsf_s3 vdda__p4 xref_ng vref__p7 vss sg13_hv_nmos w=80u l=0.45u ng=32 m=1
Xxref_xmib_s0 vref__p0 ibias vss__p0 vss sg13_hv_nmos w=80u l=1u ng=40 m=1
Xxref_xmib_s1 vref__p1 ibias vss__p1 vss sg13_hv_nmos w=80u l=1u ng=40 m=1
Xxref_xmib_s2 vref__p2 ibias vss__p2 vss sg13_hv_nmos w=80u l=1u ng=40 m=1
Xxref_xmib_s3 vref__p3 ibias vss__p3 vss sg13_hv_nmos w=80u l=1u ng=40 m=1
Xxref_xcd_u0 vss vref cap_cmim w=51.58u l=95u m=4
Xxref_xmsfl_s0 vdda__p0 xref_ng vrefl vss sg13_hv_nmos w=80u l=0.45u ng=32 m=1
Xxref_xmibl_s0 vrefl__p0 ibias vss__p4 vss sg13_hv_nmos w=80u l=1u ng=40 m=1
Xxref_xcdl_u0 vss vrefl cap_cmim w=51.58u l=95u m=2
Xxfilt_xcf_u0 vss vref_in cap_cmim w=37.36u l=90u m=2
Xslice_a ain_sin_p__p1 ain_sin_n__p1 ain_isa_p__p1 ain_isa_n__p1 sar_trka0 sar_trka1 sar_cpa0 sar_cpa1 sar_cpa2 sar_cpa3 sar_cpa4 sar_cpa5 sar_cpa6 sar_cpa7 sar_cpa8 sar_cpa9 sar_cpa10 sar_cpa11 sar_cpa12 sar_cna0 sar_cna1 sar_cna2 sar_cna3 sar_cna4 sar_cna5 sar_cna6 sar_cna7 sar_cna8 sar_cna9 sar_cna10 sar_cna11 sar_cna12 sar_clka sar_clkab sar_clkna sar_clknab sar_oap sar_oan sar_oanp sar_oann vbp__p2 vbn__p2 sp_vref_a sp_vrefl_a sp_vrefl_a topap topan vdd__p11 vdd__p12 vdd__p13 vdd__p14 vss__p22 vss__p23 vss__p24 vss__p25 r1_adc_slice_post
Vsp_vref_a sp_vref_a 0 DC 1.042768
Vsp_vrefl_a sp_vrefl_a 0 DC 1.047497
Xslice_b ain_cos_p__p1 ain_cos_n__p1 ain_isb_p__p1 ain_isb_n__p1 sar_trkb0 sar_trkb1 sar_cpb0 sar_cpb1 sar_cpb2 sar_cpb3 sar_cpb4 sar_cpb5 sar_cpb6 sar_cpb7 sar_cpb8 sar_cpb9 sar_cpb10 sar_cpb11 sar_cpb12 sar_cnb0 sar_cnb1 sar_cnb2 sar_cnb3 sar_cnb4 sar_cnb5 sar_cnb6 sar_cnb7 sar_cnb8 sar_cnb9 sar_cnb10 sar_cnb11 sar_cnb12 sar_clkb sar_clkbb sar_clknb sar_clknbb sar_obp sar_obn sar_obnp sar_obnn vbp__p3 vbn__p3 sp_vref_b sp_vrefl_b sp_vrefl_b topbp topbn vdd__p15 vdd__p16 vdd__p17 vdd__p18 vss__p26 vss__p27 vss__p28 vss__p29 r1_adc_slice_post
Vsp_vref_b sp_vref_b 0 DC 1.042768
Vsp_vrefl_b sp_vrefl_b 0 DC 1.048067
Rt0 ain_cos_n ain_cos_n__p1 126.843
Rt1 ain_cos_p ain_cos_p__p1 128.661
Rt2 ain_isa_n ain_isa_n__p1 127.972
Rt3 ain_isa_p ain_isa_p__p1 129.791
Rt4 ain_isb_n ain_isb_n__p1 0.198
Rt5 ain_isb_p ain_isb_p__p1 0.198
Rt6 ain_sin_n ain_sin_n__p1 0.308
Rt7 ain_sin_p ain_sin_p__p1 0.308
Rt8 clk clk__p0 45.3911
Rt9 clk clk__p1 62.5679
Rt10 clk__p0 clk__p1 72.0627
Rt11 ibias ibias__p0 139.589
Rt12 mclkb mclkb__p1 43.3194
Rt13 sar_mclk sar_mclk__p1 56.5336
Rt14 sar_mclk sar_mclk__p3 125.793
Rt15 sar_mclk sar_mclk__p4 124.991
Rt16 sar_mclk__p1 sar_mclk__p3 116.67
Rt17 sar_mclk__p1 sar_mclk__p4 115.926
Rt18 sar_mclk__p2 sar_mclk__p3 0.6204
Rt19 sar_mclk__p3 sar_mclk__p4 23.2017
Rt20 vbn vbn__p1 68.3734
Rt21 vbn vbn__p2 257.848
Rt22 vbn vbn__p3 52140.1
Rt23 vbn__p1 vbn__p2 121.538
Rt24 vbn__p1 vbn__p3 24576.5
Rt25 vbn__p2 vbn__p3 67.329
Rt26 vbp vbp__p1 78.6118
Rt27 vbp vbp__p2 170.544
Rt28 vbp vbp__p3 22550.2
Rt29 vbp__p1 vbp__p2 136.122
Rt30 vbp__p1 vbp__p3 17998.8
Rt31 vbp__p2 vbp__p3 67.8656
Rt32 vdd vdd__p0 51.7969
Rt33 vdd vdd__p1 129.356
Rt34 vdd vdd__p11 227.932
Rt35 vdd vdd__p12 340.649
Rt36 vdd vdd__p13 1516.8
Rt37 vdd vdd__p14 3969.78
Rt38 vdd vdd__p15 7290.2
Rt39 vdd vdd__p16 18493.6
Rt40 vdd vdd__p17 198850
Rt41 vdd vdd__p18 378541
Rt42 vdd vdd__p2 9366.97
Rt43 vdd vdd__p3 12380.2
Rt44 vdd vdd__p4 16093
Rt45 vdd vdd__p5 20342.3
Rt46 vdd vdd__p6 24598.2
Rt47 vdd vdd__p7 53237.1
Rt48 vdd vdd__p8 57510.5
Rt49 vdd vdd__p9 60223.6
Rt50 vdd__p0 vdd__p1 185.206
Rt51 vdd__p0 vdd__p11 326.344
Rt52 vdd__p0 vdd__p12 487.728
Rt53 vdd__p0 vdd__p13 2171.69
Rt54 vdd__p0 vdd__p14 5683.77
Rt55 vdd__p0 vdd__p15 10437.8
Rt56 vdd__p0 vdd__p16 26478.5
Rt57 vdd__p0 vdd__p17 284706
Rt58 vdd__p0 vdd__p18 541980
Rt59 vdd__p0 vdd__p2 13411.3
Rt60 vdd__p0 vdd__p3 17725.5
Rt61 vdd__p0 vdd__p4 23041.3
Rt62 vdd__p0 vdd__p5 29125.3
Rt63 vdd__p0 vdd__p6 35218.7
Rt64 vdd__p0 vdd__p7 76222.8
Rt65 vdd__p0 vdd__p8 82341.3
Rt66 vdd__p0 vdd__p9 86225.7
Rt67 vdd__p1 vdd__p11 271.988
Rt68 vdd__p1 vdd__p12 406.492
Rt69 vdd__p1 vdd__p13 1809.98
Rt70 vdd__p1 vdd__p14 4737.09
Rt71 vdd__p1 vdd__p15 8699.31
Rt72 vdd__p1 vdd__p16 22068.2
Rt73 vdd__p1 vdd__p17 237286
Rt74 vdd__p1 vdd__p18 451709
Rt75 vdd__p1 vdd__p2 11177.5
Rt76 vdd__p1 vdd__p3 14773.1
Rt77 vdd__p1 vdd__p4 19203.5
Rt78 vdd__p1 vdd__p5 24274.2
Rt79 vdd__p1 vdd__p6 29352.7
Rt80 vdd__p1 vdd__p7 63527.2
Rt81 vdd__p1 vdd__p8 68626.7
Rt82 vdd__p1 vdd__p9 71864.1
Rt83 vdd__p11 vdd__p12 48.8126
Rt84 vdd__p11 vdd__p13 217.347
Rt85 vdd__p11 vdd__p14 568.842
Rt86 vdd__p11 vdd__p15 1044.64
Rt87 vdd__p11 vdd__p16 2650.01
Rt88 vdd__p11 vdd__p17 28493.9
Rt89 vdd__p11 vdd__p18 54242.4
Rt90 vdd__p11 vdd__p2 640.666
Rt91 vdd__p11 vdd__p3 846.759
Rt92 vdd__p11 vdd__p4 1100.7
Rt93 vdd__p11 vdd__p5 1391.34
Rt94 vdd__p11 vdd__p6 1682.42
Rt95 vdd__p11 vdd__p7 3641.22
Rt96 vdd__p11 vdd__p8 3933.51
Rt97 vdd__p11 vdd__p9 4119.07
Rt98 vdd__p12 vdd__p13 77.2099
Rt99 vdd__p12 vdd__p14 202.075
Rt100 vdd__p12 vdd__p15 371.095
Rt101 vdd__p12 vdd__p16 941.386
Rt102 vdd__p12 vdd__p17 10122.1
Rt103 vdd__p12 vdd__p18 19269
Rt104 vdd__p12 vdd__p2 2005.98
Rt105 vdd__p12 vdd__p3 2651.28
Rt106 vdd__p12 vdd__p4 3446.38
Rt107 vdd__p12 vdd__p5 4356.4
Rt108 vdd__p12 vdd__p6 5267.82
Rt109 vdd__p12 vdd__p7 11401
Rt110 vdd__p12 vdd__p8 12316.2
Rt111 vdd__p12 vdd__p9 12897.2
Rt112 vdd__p13 vdd__p14 49.1805
Rt113 vdd__p13 vdd__p15 90.3164
Rt114 vdd__p13 vdd__p16 229.113
Rt115 vdd__p13 vdd__p17 2463.51
Rt116 vdd__p13 vdd__p18 4689.65
Rt117 vdd__p13 vdd__p2 8931.97
Rt118 vdd__p13 vdd__p3 11805.3
Rt119 vdd__p13 vdd__p4 15345.6
Rt120 vdd__p13 vdd__p5 19397.6
Rt121 vdd__p13 vdd__p6 23455.9
Rt122 vdd__p13 vdd__p7 50764.8
Rt123 vdd__p13 vdd__p8 54839.8
Rt124 vdd__p13 vdd__p9 57426.8
Rt125 vdd__p14 vdd__p15 40.3724
Rt126 vdd__p14 vdd__p16 102.416
Rt127 vdd__p14 vdd__p17 1101.21
Rt128 vdd__p14 vdd__p18 2096.32
Rt129 vdd__p14 vdd__p2 23376.8
Rt130 vdd__p14 vdd__p3 30896.9
Rt131 vdd__p14 vdd__p4 40162.7
Rt132 vdd__p14 vdd__p5 50767.6
Rt133 vdd__p14 vdd__p6 61388.9
Rt134 vdd__p14 vdd__p7 132862
Rt135 vdd__p14 vdd__p8 143527
Rt136 vdd__p14 vdd__p9 150298
Rt137 vdd__p15 vdd__p16 53.0715
Rt138 vdd__p15 vdd__p17 570.644
Rt139 vdd__p15 vdd__p18 1086.31
Rt140 vdd__p15 vdd__p2 42929.8
Rt141 vdd__p15 vdd__p3 56739.8
Rt142 vdd__p15 vdd__p4 73755.8
Rt143 vdd__p15 vdd__p5 93230.9
Rt144 vdd__p15 vdd__p6 112736
Rt145 vdd__p15 vdd__p7 243991
Rt146 vdd__p15 vdd__p8 263577
Rt147 vdd__p15 vdd__p9 276011
Rt148 vdd__p16 vdd__p17 164.448
Rt149 vdd__p16 vdd__p18 313.051
Rt150 vdd__p16 vdd__p2 108904
Rt151 vdd__p16 vdd__p3 143936
Rt152 vdd__p16 vdd__p4 187102
Rt153 vdd__p16 vdd__p5 236506
Rt154 vdd__p16 vdd__p6 285987
Rt155 vdd__p16 vdd__p7 618953
Rt156 vdd__p16 vdd__p8 668637
Rt157 vdd__p16 vdd__p9 700179
Rt158 vdd__p17 vdd__p18 29.0526
Rt159 vdd__p2 vdd__p3 92.6957
Rt160 vdd__p2 vdd__p4 120.495
Rt161 vdd__p2 vdd__p5 152.311
Rt162 vdd__p2 vdd__p6 184.177
Rt163 vdd__p2 vdd__p7 398.608
Rt164 vdd__p2 vdd__p8 430.605
Rt165 vdd__p2 vdd__p9 450.919
Rt166 vdd__p3 vdd__p4 108.814
Rt167 vdd__p3 vdd__p5 137.546
Rt168 vdd__p3 vdd__p6 166.322
Rt169 vdd__p3 vdd__p7 359.966
Rt170 vdd__p3 vdd__p8 388.861
Rt171 vdd__p3 vdd__p9 407.206
Rt172 vdd__p4 vdd__p5 115.772
Rt173 vdd__p4 vdd__p6 139.993
Rt174 vdd__p4 vdd__p7 302.983
Rt175 vdd__p4 vdd__p8 327.304
Rt176 vdd__p4 vdd__p9 342.744
Rt177 vdd__p5 vdd__p6 112.042
Rt178 vdd__p5 vdd__p7 242.489
Rt179 vdd__p5 vdd__p8 261.954
Rt180 vdd__p5 vdd__p9 274.312
Rt181 vdd__p6 vdd__p7 187.851
Rt182 vdd__p6 vdd__p8 202.93
Rt183 vdd__p6 vdd__p9 212.503
Rt184 vdd__p7 vdd__p8 373.265
Rt185 vdd__p7 vdd__p9 390.874
Rt186 vdd__p8 vdd__p9 274.094
Rt187 vdda vdda__p1 30.7341
Rt188 vdda__p0 vdda__p3 66.7792
Rt189 vdda__p0 vdda__p4 64.5261
Rt190 vdda__p1 vdda__p2 19.5742
Rt191 vdda__p2 vdda__p3 93.9618
Rt192 vdda__p2 vdda__p5 66.6691
Rt193 vdda__p2 vdda__p6 85.2968
Rt194 vdda__p3 vdda__p4 23.0035
Rt195 vdda__p3 vdda__p5 88.1947
Rt196 vdda__p3 vdda__p6 68.6694
Rt197 vdda__p5 vdda__p6 80.0616
Rt198 vref vref__p1 86.8906
Rt199 vref vref__p5 23.6974
Rt200 vref vref__p8 154.432
Rt201 vref vref__p9 282.142
Rt202 vref__p0 vref__p1 54.8427
Rt203 vref__p1 vref__p5 91.2944
Rt204 vref__p1 vref__p8 108.337
Rt205 vref__p1 vref__p9 197.929
Rt206 vref__p2 vref__p3 54.8427
Rt207 vref__p2 vref__p6 37.2232
Rt208 vref__p5 vref__p6 54.9082
Rt209 vref__p5 vref__p8 162.259
Rt210 vref__p5 vref__p9 296.442
Rt211 vref__p6 vref__p7 18.9765
Rt212 vref__p8 vref__p9 6.67381
Rt213 vrefl vrefl__p0 91.2046
Rt214 vrefl vrefl__p2 13503.5
Rt215 vrefl vrefl__p3 90.8685
Rt216 vrefl vrefl__p4 76.5298
Rt217 vrefl vrefl__p5 5238.83
Rt218 vrefl__p0 vrefl__p2 10160.7
Rt219 vrefl__p0 vrefl__p3 68.3742
Rt220 vrefl__p0 vrefl__p4 96.5153
Rt221 vrefl__p0 vrefl__p5 6606.94
Rt222 vrefl__p2 vrefl__p3 16.5223
Rt223 vrefl__p2 vrefl__p4 14289.8
Rt224 vrefl__p2 vrefl__p5 978205
Rt225 vrefl__p3 vrefl__p4 96.1596
Rt226 vrefl__p3 vrefl__p5 6582.59
Rt227 vrefl__p4 vrefl__p5 16.6771
Rt228 vss vss__p0 64.0123
Rt229 vss vss__p1 683.259
Rt230 vss vss__p10 0.001
Rt231 vss vss__p2 371.2
Rt232 vss vss__p22 97.4665
Rt233 vss vss__p23 273.377
Rt234 vss vss__p24 471242
Rt235 vss vss__p25 358523
Rt236 vss vss__p26 51921.8
Rt237 vss vss__p27 86075
Rt238 vss vss__p28 244.041
Rt239 vss vss__p29 100.595
Rt240 vss vss__p3 217.277
Rt241 vss vss__p4 1870.56
Rt242 vss vss__p5 2480.51
Rt243 vss vss__p6 3517.19
Rt244 vss vss__p7 118.25
Rt245 vss vss__p8 119.221
Rt246 vss__p0 vss__p1 161.851
Rt247 vss__p0 vss__p2 2839.25
Rt248 vss__p0 vss__p22 263.99
Rt249 vss__p0 vss__p23 740.446
Rt250 vss__p0 vss__p24 111628
Rt251 vss__p0 vss__p25 84927.1
Rt252 vss__p0 vss__p26 12299.3
Rt253 vss__p0 vss__p27 20389.5
Rt254 vss__p0 vss__p28 1815.36
Rt255 vss__p0 vss__p29 748.299
Rt256 vss__p0 vss__p3 1661.92
Rt257 vss__p0 vss__p4 443.099
Rt258 vss__p0 vss__p5 587.584
Rt259 vss__p0 vss__p6 833.152
Rt260 vss__p0 vss__p7 320.451
Rt261 vss__p0 vss__p8 322.646
Rt262 vss__p1 vss__p2 30305.8
Rt263 vss__p1 vss__p22 2817.79
Rt264 vss__p1 vss__p23 7903.42
Rt265 vss__p1 vss__p24 84165.5
Rt266 vss__p1 vss__p25 64033.5
Rt267 vss__p1 vss__p26 9273.42
Rt268 vss__p1 vss__p27 15373.3
Rt269 vss__p1 vss__p28 19376.9
Rt270 vss__p1 vss__p29 7987.25
Rt271 vss__p1 vss__p3 17739.1
Rt272 vss__p1 vss__p4 334.089
Rt273 vss__p1 vss__p5 443.028
Rt274 vss__p1 vss__p6 628.182
Rt275 vss__p1 vss__p7 3420.45
Rt276 vss__p1 vss__p8 3443.88
Rt277 vss__p10 vss__p11 113.514
Rt278 vss__p10 vss__p12 143.98
Rt279 vss__p10 vss__p13 175.022
Rt280 vss__p10 vss__p14 393.007
Rt281 vss__p10 vss__p15 251.471
Rt282 vss__p10 vss__p16 619.655
Rt283 vss__p10 vss__p17 663.526
Rt284 vss__p10 vss__p18 489.378
Rt285 vss__p10 vss__p19 10540.7
Rt286 vss__p10 vss__p20 51601.3
Rt287 vss__p10 vss__p9 98.2846
Rt288 vss__p11 vss__p12 120.167
Rt289 vss__p11 vss__p13 146.721
Rt290 vss__p11 vss__p14 381.007
Rt291 vss__p11 vss__p15 213.501
Rt292 vss__p11 vss__p16 622.078
Rt293 vss__p11 vss__p17 666.121
Rt294 vss__p11 vss__p18 491.292
Rt295 vss__p11 vss__p19 10581.9
Rt296 vss__p11 vss__p20 51803
Rt297 vss__p11 vss__p9 127.728
Rt298 vss__p12 vss__p13 117.108
Rt299 vss__p12 vss__p14 339.683
Rt300 vss__p12 vss__p15 171.879
Rt301 vss__p12 vss__p16 572.183
Rt302 vss__p12 vss__p17 612.694
Rt303 vss__p12 vss__p18 451.887
Rt304 vss__p12 vss__p19 9733.2
Rt305 vss__p12 vss__p20 47648.1
Rt306 vss__p12 vss__p9 161.388
Rt307 vss__p13 vss__p14 283.157
Rt308 vss__p13 vss__p15 133.639
Rt309 vss__p13 vss__p16 488.476
Rt310 vss__p13 vss__p17 523.06
Rt311 vss__p13 vss__p18 385.779
Rt312 vss__p13 vss__p19 8309.28
Rt313 vss__p13 vss__p20 40677.4
Rt314 vss__p13 vss__p9 195.03
Rt315 vss__p14 vss__p15 225.414
Rt316 vss__p14 vss__p16 211.446
Rt317 vss__p14 vss__p17 226.416
Rt318 vss__p14 vss__p18 166.991
Rt319 vss__p14 vss__p19 3596.83
Rt320 vss__p14 vss__p20 17608
Rt321 vss__p14 vss__p9 371.254
Rt322 vss__p15 vss__p16 338.846
Rt323 vss__p15 vss__p17 362.836
Rt324 vss__p15 vss__p18 267.607
Rt325 vss__p15 vss__p19 5763.98
Rt326 vss__p15 vss__p20 28217.1
Rt327 vss__p15 vss__p9 275.605
Rt328 vss__p16 vss__p17 48.9479
Rt329 vss__p16 vss__p18 36.1012
Rt330 vss__p16 vss__p19 777.582
Rt331 vss__p16 vss__p20 3806.59
Rt332 vss__p16 vss__p9 566.446
Rt333 vss__p17 vss__p18 34.3505
Rt334 vss__p17 vss__p19 739.876
Rt335 vss__p17 vss__p20 3622
Rt336 vss__p17 vss__p9 606.55
Rt337 vss__p18 vss__p19 0.666482
Rt338 vss__p18 vss__p20 3.26271
Rt339 vss__p18 vss__p9 447.356
Rt340 vss__p19 vss__p20 0.970961
Rt341 vss__p19 vss__p9 9635.59
Rt342 vss__p2 vss__p22 4002.37
Rt343 vss__p2 vss__p23 11226
Rt344 vss__p2 vss__p28 1236.98
Rt345 vss__p2 vss__p29 509.888
Rt346 vss__p2 vss__p3 62.1518
Rt347 vss__p2 vss__p4 82968.3
Rt348 vss__p2 vss__p5 110022
Rt349 vss__p2 vss__p6 156004
Rt350 vss__p2 vss__p7 4737.78
Rt351 vss__p2 vss__p8 4990.17
Rt352 vss__p20 vss__p9 47170.3
Rt353 vss__p22 vss__p23 13.1644
Rt354 vss__p22 vss__p26 214128
Rt355 vss__p22 vss__p27 354978
Rt356 vss__p22 vss__p28 2291.22
Rt357 vss__p22 vss__p29 944.448
Rt358 vss__p22 vss__p3 2342.74
Rt359 vss__p22 vss__p4 7714.29
Rt360 vss__p22 vss__p5 10229.7
Rt361 vss__p22 vss__p6 14505
Rt362 vss__p22 vss__p7 105.519
Rt363 vss__p22 vss__p8 133.386
Rt364 vss__p23 vss__p26 600593
Rt365 vss__p23 vss__p27 995651
Rt366 vss__p23 vss__p28 6426.46
Rt367 vss__p23 vss__p29 2649.01
Rt368 vss__p23 vss__p3 6570.98
Rt369 vss__p23 vss__p4 21637.2
Rt370 vss__p23 vss__p5 28692.7
Rt371 vss__p23 vss__p6 40684.2
Rt372 vss__p23 vss__p7 295.961
Rt373 vss__p23 vss__p8 374.125
Rt374 vss__p24 vss__p25 97.1468
Rt375 vss__p24 vss__p26 129.246
Rt376 vss__p24 vss__p27 1768.45
Rt377 vss__p24 vss__p4 19241.6
Rt378 vss__p24 vss__p5 8459.44
Rt379 vss__p24 vss__p6 1790.84
Rt380 vss__p25 vss__p26 98.3311
Rt381 vss__p25 vss__p27 1345.45
Rt382 vss__p25 vss__p4 14639.1
Rt383 vss__p25 vss__p5 6435.98
Rt384 vss__p25 vss__p6 1362.48
Rt385 vss__p26 vss__p27 194.85
Rt386 vss__p26 vss__p29 606963
Rt387 vss__p26 vss__p4 2120.05
Rt388 vss__p26 vss__p5 932.068
Rt389 vss__p26 vss__p6 197.317
Rt390 vss__p26 vss__p7 259925
Rt391 vss__p26 vss__p8 261706
Rt392 vss__p27 vss__p4 3514.58
Rt393 vss__p27 vss__p5 1545.17
Rt394 vss__p27 vss__p6 327.108
Rt395 vss__p27 vss__p7 430899
Rt396 vss__p27 vss__p8 433851
Rt397 vss__p28 vss__p29 11.3118
Rt398 vss__p28 vss__p3 724.052
Rt399 vss__p28 vss__p4 53048.4
Rt400 vss__p28 vss__p5 70346.2
Rt401 vss__p28 vss__p6 99746
Rt402 vss__p28 vss__p7 2611
Rt403 vss__p28 vss__p8 2945.87
Rt404 vss__p29 vss__p3 298.457
Rt405 vss__p29 vss__p4 21866.7
Rt406 vss__p29 vss__p5 28997
Rt407 vss__p29 vss__p6 41115.7
Rt408 vss__p29 vss__p7 1076.26
Rt409 vss__p29 vss__p8 1214.3
Rt410 vss__p3 vss__p4 48564.5
Rt411 vss__p3 vss__p5 64400.3
Rt412 vss__p3 vss__p6 91315
Rt413 vss__p3 vss__p7 2773.2
Rt414 vss__p3 vss__p8 2920.94
Rt415 vss__p4 vss__p5 101.283
Rt416 vss__p4 vss__p6 143.612
Rt417 vss__p4 vss__p7 9364.19
Rt418 vss__p4 vss__p8 9428.33
Rt419 vss__p5 vss__p6 63.1383
Rt420 vss__p5 vss__p7 12417.6
Rt421 vss__p5 vss__p8 12502.7
Rt422 vss__p6 vss__p7 17607.3
Rt423 vss__p6 vss__p8 17727.9
Rt424 vss__p7 vss__p8 171.407
Rt425 xckg_d0 xckg_d0__p1 206.411
Rt426 xckg_d0 xckg_d0__p2 50.6383
Rt427 xckg_d0__p1 xckg_d0__p2 40.5376
Rt428 xckg_d1 xckg_d1__p1 176.827
Rt429 xckg_d1 xckg_d1__p2 53.6164
Rt430 xckg_d1__p1 xckg_d1__p2 42.2433
Rt431 xckg_d2 xckg_d2__p1 98.5076
Rt432 xckg_d2 xckg_d2__p2 97.0379
Rt433 xckg_d2__p1 xckg_d2__p2 76.6587
Rt434 xckg_d3 xckg_d3__p1 99.3636
Rt435 xckg_d3 xckg_d3__p2 100.408
Rt436 xckg_d3__p1 xckg_d3__p2 78.0493
Rt437 xckg_nn xckg_nn__p1 46.1928
Rt438 xckg_x xckg_x__p1 68.4444
Rt439 xckg_x xckg_x__p2 147.088
Rt440 xckg_x xckg_x__p3 1240.78
Rt441 xckg_x xckg_x__p4 614.493
Rt442 xckg_x__p1 xckg_x__p2 97.458
Rt443 xckg_x__p1 xckg_x__p3 822.123
Rt444 xckg_x__p1 xckg_x__p4 407.153
Rt445 xckg_x__p2 xckg_x__p3 124.848
Rt446 xckg_x__p2 xckg_x__p4 61.8301
Rt447 xckg_x__p3 xckg_x__p4 33.2764
Rt448 xref_na xref_na__p1 77.984
Rt449 xref_ng xref_ng__p1 98.1201
Rt450 xref_ntl xref_ntl__p1 60.2546
Rt451 xref_ntl__p1 xref_ntl__p2 19.318
Cq0 ain_cos_n ain_cos_p 2.709e-14
Cq1 ain_cos_n ain_isa_n 3.644e-17
Cq2 ain_cos_n ain_isa_p 4.64e-17
Cq3 ain_cos_n ibias 5.314e-17
Cq4 ain_cos_n vdd 5.829e-16
Cq5 ain_cos_n vss 2.705e-14
Cq6 ain_cos_n xckg_d0 9.755e-19
Cq7 ain_cos_n xckg_d1 9.755e-19
Cq8 ain_cos_n xckg_d2 9.755e-19
Cq9 ain_cos_n xckg_d3 1.006e-18
Cq10 ain_cos_n xckg_x 5.633e-18
Cq11 ain_cos_p ain_isa_n 4.287e-17
Cq12 ain_cos_p ain_isa_p 7.229e-16
Cq13 ain_cos_p ibias 3.52e-15
Cq14 ain_cos_p vdd 2.509e-15
Cq15 ain_cos_p vss 1.273e-14
Cq16 ain_isa_n ain_isa_p 2.783e-14
Cq17 ain_isa_n ain_isb_n 6.15e-17
Cq18 ain_isa_n ain_isb_p 6.417e-17
Cq19 ain_isa_n vss 2.894e-14
Cq20 ain_isa_p ain_isb_n 7.645e-17
Cq21 ain_isa_p ain_isb_p 7.912e-17
Cq22 ain_isa_p vss 2.868e-14
Cq23 ain_isb_n ain_isb_p 7.431e-17
Cq24 ain_isb_n vss 9.265e-16
Cq25 ain_isb_p vss 8.611e-16
Cq26 ain_sin_n ain_sin_p 8.625e-17
Cq27 ain_sin_n ibias 9.414e-17
Cq28 ain_sin_n vdd 2.257e-16
Cq29 ain_sin_n vss 7.685e-16
Cq30 ain_sin_p ibias 9.681e-17
Cq31 ain_sin_p vdd 1.633e-16
Cq32 ain_sin_p vss 7.651e-16
Cq33 clk mclkb 2.216e-18
Cq34 clk sar_mclk 1.431e-16
Cq35 clk vdd 4.347e-16
Cq36 clk vss 1.85e-14
Cq37 clk xckg_d0 2.205e-16
Cq38 clk xckg_d1 1.236e-16
Cq39 clk xckg_d2 1.227e-16
Cq40 clk xckg_d3 1.663e-16
Cq41 clk xckg_nn 2.534e-17
Cq42 clk xckg_x 1.452e-16
Cq43 ibias vbn 3.378e-16
Cq44 ibias vbp 1.24e-16
Cq45 ibias vdd 6.258e-15
Cq46 ibias vdda 2.57e-16
Cq47 ibias vref 3.367e-14
Cq48 ibias vref_in 1.257e-14
Cq49 ibias vrefl 1.528e-14
Cq50 ibias vss 1.669e-13
Cq51 ibias xref_ng 2.502e-15
Cq52 ibias xref_ntl 1.763e-16
Cq53 mclkb sar_mclk 2.613e-16
Cq54 mclkb vdd 3.849e-16
Cq55 mclkb vss 1.23e-15
Cq56 mclkb xckg_d0 5.604e-17
Cq57 mclkb xckg_d1 3.991e-15
Cq58 mclkb xckg_d2 3.955e-15
Cq59 mclkb xckg_d3 6.865e-17
Cq60 mclkb xckg_nn 1.864e-17
Cq61 mclkb xckg_x 9.575e-17
Cq62 sar_mclk vdd 1.621e-15
Cq63 sar_mclk vss 6.739e-15
Cq64 sar_mclk xckg_d0 4.707e-15
Cq65 sar_mclk xckg_d1 2.058e-16
Cq66 sar_mclk xckg_d2 7.519e-17
Cq67 sar_mclk xckg_d3 9.271e-17
Cq68 sar_mclk xckg_nn 4.141e-16
Cq69 sar_mclk xckg_x 1.044e-15
Cq70 vbn vbp 4.048e-14
Cq71 vbn vdd 2.668e-14
Cq72 vbn vdda 4.597e-16
Cq73 vbn vref 1.548e-14
Cq74 vbn vref_in 2.405e-15
Cq75 vbn vrefl 8.131e-15
Cq76 vbn vss 1.116e-14
Cq77 vbn xref_ng 1.543e-15
Cq78 vbp vdd 1.669e-15
Cq79 vbp vdda 1.395e-15
Cq80 vbp vref 2.767e-14
Cq81 vbp vref_in 4.117e-15
Cq82 vbp vrefl 7.984e-15
Cq83 vbp vss 1.325e-14
Cq84 vbp xref_ng 1.886e-15
Cq85 vdd vdda 3.895e-16
Cq86 vdd vref 3.92e-14
Cq87 vdd vref_in 2.491e-14
Cq88 vdd vrefl 1.224e-14
Cq89 vdd vss 6.927e-14
Cq90 vdd xckg_d0 5.466e-16
Cq91 vdd xckg_d1 3.974e-16
Cq92 vdd xckg_d2 2.624e-16
Cq93 vdd xckg_d3 3.649e-16
Cq94 vdd xckg_x 1.1e-15
Cq95 vdd xref_ng 3.009e-15
Cq96 vdda vref 4e-14
Cq97 vdda vref_in 3.048e-16
Cq98 vdda vrefl 1.272e-14
Cq99 vdda vss 3.096e-14
Cq100 vdda xref_na 7.939e-16
Cq101 vdda xref_ng 1.455e-14
Cq102 vdda xref_ntl 1.132e-17
Cq103 vref vref_in 4.546e-14
Cq104 vref vrefl 1.197e-13
Cq105 vref vss 3.586e-13
Cq106 vref xref_na 1.908e-16
Cq107 vref xref_ng 3.832e-14
Cq108 vref xref_ntl 9.852e-16
Cq109 vref_in vrefl 3.069e-14
Cq110 vref_in vss 1.048e-13
Cq111 vref_in xref_na 4.222e-16
Cq112 vref_in xref_ng 3.86e-15
Cq113 vref_in xref_ntl 1.282e-15
Cq114 vrefl vss 1.991e-13
Cq115 vrefl xref_na 8.519e-18
Cq116 vrefl xref_ng 2.644e-14
Cq117 vrefl xref_ntl 5.775e-16
Cq118 vss xckg_d0 4.966e-15
Cq119 vss xckg_d1 4.102e-15
Cq120 vss xckg_d2 4.83e-15
Cq121 vss xckg_d3 5.854e-15
Cq122 vss xckg_nn 1.117e-15
Cq123 vss xckg_x 1.086e-14
Cq124 vss xref_na 4.919e-15
Cq125 vss xref_ng 9.404e-14
Cq126 vss xref_ntl 4.054e-15
Cq127 xckg_d0 xckg_d1 8.434e-15
Cq128 xckg_d0 xckg_d2 2.37e-16
Cq129 xckg_d0 xckg_d3 1.818e-16
Cq130 xckg_d0 xckg_nn 2.011e-17
Cq131 xckg_d0 xckg_x 6.919e-16
Cq132 xckg_d1 xckg_d2 2.001e-15
Cq133 xckg_d1 xckg_d3 1.378e-16
Cq134 xckg_d1 xckg_nn 5.907e-16
Cq135 xckg_d1 xckg_x 4.219e-16
Cq136 xckg_d2 xckg_d3 8.547e-15
Cq137 xckg_d2 xckg_nn 5.574e-16
Cq138 xckg_d2 xckg_x 4.153e-16
Cq139 xckg_d3 xckg_nn 3.667e-17
Cq140 xckg_d3 xckg_x 5.111e-15
Cq141 xckg_nn xckg_x 1.118e-16
Cq142 xref_na xref_ng 2.502e-15
Cq143 xref_na xref_ntl 3.114e-16
Cq144 xref_ng xref_ntl 2.861e-15
.ends
