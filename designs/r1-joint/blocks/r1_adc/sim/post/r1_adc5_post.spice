* r1_adc5_post.spice -- wrapper of the r1_adc layout netlist with the pins of r1_adc5_core (+ vbg nb vdda),
* written by sim/post/gen_post_decks.py (do not edit). Include after schematic/r1_adc_r5.spice (r1_sar5_logic)
* and a layout netlist that defines r1_adc_lay_pr (sim/post/r1_adc_lay0.spice or a post-layout netlist).
.subckt r1_adc5_core_lay sinp sinn cosp cosn isap isan isbp isbn trka0 trka1 trkb0 trkb1 clk30 wina winb lata latb stba0 stba1 stba2 stba3 stba4 stba5 stba6 stba7 stba8 stba9 stba10 stba11 stba12 stba13 stbb0 stbb1 stbb2 stbb3 stbb4 stbb5 stbb6 stbb7 stbb8 stbb9 stbb10 stbb11 stbb12 stbb13 rawa rawb topap topan topbp topbn vdd vrefa vrefb vrefla vreflb gnd vbg nb vdda
XL nc_adc_hold nc_is_smp clk30 nc_adc_start nc_adc_sel nc_adc_valid_a nc_adc_raw_a_0 nc_adc_raw_a_1 nc_adc_raw_a_2 nc_adc_raw_a_3 nc_adc_raw_a_4 nc_adc_raw_a_5 nc_adc_raw_a_6 nc_adc_raw_a_7 nc_adc_raw_a_8 nc_adc_raw_a_9 nc_adc_raw_a_10 nc_adc_raw_a_11 nc_adc_raw_a_12 nc_adc_raw_a_13 nc_adc_valid_b nc_adc_raw_b_0 nc_adc_raw_b_1 nc_adc_raw_b_2 nc_adc_raw_b_3 nc_adc_raw_b_4 nc_adc_raw_b_5 nc_adc_raw_b_6 nc_adc_raw_b_7 nc_adc_raw_b_8 nc_adc_raw_b_9 nc_adc_raw_b_10 nc_adc_raw_b_11 nc_adc_raw_b_12 nc_adc_raw_b_13 nc_por_n sinp sinn cosp cosn nc_vcm2 nb isap isan isbp isbn nc_vcm vdda vdd gnd vbg topap topan topbp topbn sar_clka sar_clkab sar_clkb sar_clkbb sar_clkna sar_clknab sar_clknb sar_clknbb sar_cna0 sar_cna1 sar_cna10 sar_cna11 sar_cna12 sar_cna2 sar_cna3 sar_cna4 sar_cna5 sar_cna6 sar_cna7 sar_cna8 sar_cna9 sar_cnb0 sar_cnb1 sar_cnb10 sar_cnb11 sar_cnb12 sar_cnb2 sar_cnb3 sar_cnb4 sar_cnb5 sar_cnb6 sar_cnb7 sar_cnb8 sar_cnb9 sar_cpa0 sar_cpa1 sar_cpa10 sar_cpa11 sar_cpa12 sar_cpa2 sar_cpa3 sar_cpa4 sar_cpa5 sar_cpa6 sar_cpa7 sar_cpa8 sar_cpa9 sar_cpb0 sar_cpb1 sar_cpb10 sar_cpb11 sar_cpb12 sar_cpb2 sar_cpb3 sar_cpb4 sar_cpb5 sar_cpb6 sar_cpb7 sar_cpb8 sar_cpb9 sar_oan sar_oann sar_oanp sar_oap sar_obn sar_obnn sar_obnp sar_obp trka0 trka1 trkb0 trkb1 sar_mclk vrefa vrefla r1_adc_lay_pr
Rnc_adc_hold nc_adc_hold gnd 1k
Rnc_is_smp nc_is_smp gnd 1k
Rnc_adc_start nc_adc_start gnd 1k
Rnc_adc_sel nc_adc_sel gnd 1k
Rnc_adc_valid_a nc_adc_valid_a gnd 1k
Rnc_adc_raw_a_0 nc_adc_raw_a_0 gnd 1k
Rnc_adc_raw_a_1 nc_adc_raw_a_1 gnd 1k
Rnc_adc_raw_a_2 nc_adc_raw_a_2 gnd 1k
Rnc_adc_raw_a_3 nc_adc_raw_a_3 gnd 1k
Rnc_adc_raw_a_4 nc_adc_raw_a_4 gnd 1k
Rnc_adc_raw_a_5 nc_adc_raw_a_5 gnd 1k
Rnc_adc_raw_a_6 nc_adc_raw_a_6 gnd 1k
Rnc_adc_raw_a_7 nc_adc_raw_a_7 gnd 1k
Rnc_adc_raw_a_8 nc_adc_raw_a_8 gnd 1k
Rnc_adc_raw_a_9 nc_adc_raw_a_9 gnd 1k
Rnc_adc_raw_a_10 nc_adc_raw_a_10 gnd 1k
Rnc_adc_raw_a_11 nc_adc_raw_a_11 gnd 1k
Rnc_adc_raw_a_12 nc_adc_raw_a_12 gnd 1k
Rnc_adc_raw_a_13 nc_adc_raw_a_13 gnd 1k
Rnc_adc_valid_b nc_adc_valid_b gnd 1k
Rnc_adc_raw_b_0 nc_adc_raw_b_0 gnd 1k
Rnc_adc_raw_b_1 nc_adc_raw_b_1 gnd 1k
Rnc_adc_raw_b_2 nc_adc_raw_b_2 gnd 1k
Rnc_adc_raw_b_3 nc_adc_raw_b_3 gnd 1k
Rnc_adc_raw_b_4 nc_adc_raw_b_4 gnd 1k
Rnc_adc_raw_b_5 nc_adc_raw_b_5 gnd 1k
Rnc_adc_raw_b_6 nc_adc_raw_b_6 gnd 1k
Rnc_adc_raw_b_7 nc_adc_raw_b_7 gnd 1k
Rnc_adc_raw_b_8 nc_adc_raw_b_8 gnd 1k
Rnc_adc_raw_b_9 nc_adc_raw_b_9 gnd 1k
Rnc_adc_raw_b_10 nc_adc_raw_b_10 gnd 1k
Rnc_adc_raw_b_11 nc_adc_raw_b_11 gnd 1k
Rnc_adc_raw_b_12 nc_adc_raw_b_12 gnd 1k
Rnc_adc_raw_b_13 nc_adc_raw_b_13 gnd 1k
Rnc_por_n nc_por_n gnd 1k
Rnc_vcm2 nc_vcm2 gnd 1k
Rnc_vcm nc_vcm gnd 1k
Evrefb vrefb 0 vrefa 0 1
Evreflb vreflb 0 vrefla 0 1
XSAR sar_oap sar_oan sar_obp sar_obn sar_oanp sar_obnp sar_mclk wina winb trka0 trka1 trkb0 trkb1 lata latb stba0 stba1 stba2 stba3 stba4 stba5 stba6 stba7 stba8 stba9 stba10 stba11 stba12 stba13 stbb0 stbb1 stbb2 stbb3 stbb4 stbb5 stbb6 stbb7 stbb8 stbb9 stbb10 stbb11 stbb12 stbb13 sar_clka sar_clkab sar_clkb sar_clkbb sar_clkna sar_clknab sar_clknb sar_clknbb sar_cpa12 sar_cpa11 sar_cpa10 sar_cpa9 sar_cpa8 sar_cpa7 sar_cpa6 sar_cpa5 sar_cpa4 sar_cpa3 sar_cpa2 sar_cpa1 sar_cpa0 sar_cna12 sar_cna11 sar_cna10 sar_cna9 sar_cna8 sar_cna7 sar_cna6 sar_cna5 sar_cna4 sar_cna3 sar_cna2 sar_cna1 sar_cna0 sar_cpb12 sar_cpb11 sar_cpb10 sar_cpb9 sar_cpb8 sar_cpb7 sar_cpb6 sar_cpb5 sar_cpb4 sar_cpb3 sar_cpb2 sar_cpb1 sar_cpb0 sar_cnb12 sar_cnb11 sar_cnb10 sar_cnb9 sar_cnb8 sar_cnb7 sar_cnb6 sar_cnb5 sar_cnb4 sar_cnb3 sar_cnb2 sar_cnb1 sar_cnb0 rawa rawb vdd gnd r1_sar5_logic
.ends r1_adc5_core_lay
