* lev_mb7_r5.spice: drift-lever what-if of diag_mb7_e7all.spice: vdd__p22,vdd__p23,vdd__p24,vdd__p25 each tied to the slice port vdd by 5 Ohm
* T2l diagnostic (not a design netlist): r1_adc_post_rc_mb6.spice with --cut-all --balance lsb_p:lsb_n,xc4_dip:xc4_din,xc5_dip:xc5_din,op:on,onp:onn. Written by sim/post/b6/make_elim_netlist.py.
* moved couplings: top_p 16.836 fF, top_n 18.328 fF (diff -1.491 fF)
* merged by sim/post/merge_parallel.py from <G1_RESULTS_ROOT>/r1_adc/pex-b6-dev3/build/r1_adc_post_rc.spice (sha256 60201b221d550b0a): 726 -> 353 device instances (identical parallel devices as m = count)
* r1_adc post-layout netlist, layout B (RC), written by pex/pex_build.py; see its docstring
* devices: LVS reference of layout/r1_adc_netlist.py; R: KLayout RNetExtractor Metal1-5/Via1-4; C: kpex 0.3.12 2.5D CC
* requires cornerMOSlv/hv.lib, cornerCAP.lib, cornerRES.lib
.subckt r1_adc_slice_post in0p in0n in1p in1n trk0 trk1 cp0 cp1 cp2 cp3 cp4 cp5 cp6 cp7 cp8 cp9 cp10 cp11 cp12 cn0 cn1 cn2 cn3 cn4 cn5 cn6 cn7 cn8 cn9 cn10 cn11 cn12 clk clkb clkn clknb op on onp onn vbp vbn vref vref__p11 vref__p12 vrefl vrefl__p19 top_p top_n vdd vdd__p36 vdd__p37 vdd__p38 gnd gnd__p59 gnd__p60 gnd__p61 gnd__p62 gnd__p63 gnd__p64 gnd__p65
Xxpt0a t0b__p7 trk0__p1 vdd__p12 vdd sg13_lv_pmos w=2u l=0.13u ng=1 m=1
Xxnt0a t0b__p4 trk0__p0 gnd__p36 gnd sg13_lv_nmos w=1u l=0.13u ng=1 m=1
Xxpt0b t0__p5 t0b__p8 vdd__p13 vdd sg13_lv_pmos w=4u l=0.13u ng=1 m=1
Xxnt0b t0__p4 t0b__p5 gnd__p37 gnd sg13_lv_nmos w=2u l=0.13u ng=1 m=1
Xxpt1a t1b__p7 trk1__p1 vdd__p14 vdd sg13_lv_pmos w=2u l=0.13u ng=1 m=1
Xxnt1a t1b__p4 trk1__p0 gnd__p38 gnd sg13_lv_nmos w=1u l=0.13u ng=1 m=1
Xxpt1b t1__p5 t1b__p8 vdd__p15 vdd sg13_lv_pmos w=4u l=0.13u ng=1 m=1
Xxnt1b t1__p4 t1b__p5 gnd__p39 gnd sg13_lv_nmos w=2u l=0.13u ng=1 m=1
Xxs0p_xms in0p__p0 xs0p_g top_p__p2 gnd sg13_lv_nmos w=6u l=0.13u ng=2 m=1
Xxs0p_cboot xs0p_cbp__p2 xs0p_cbn__p4 cap_cmim w=11.49u l=11.49u m=1
Xxs0p_xm1 xs0p_cbn__p1 t0b__p2 gnd__p30 gnd sg13_lv_nmos w=1u l=0.13u ng=1 m=1
Xxs0p_xm3 xs0p_cbp xs0p_g__p4 vdd__p4 xs0p_cbp sg13_lv_pmos w=1u l=0.13u ng=1 m=1
Xxs0p_xm8 xs0p_g__p5 xs0p_x__p2 xs0p_cbp__p1 xs0p_cbp sg13_lv_pmos w=2u l=0.13u ng=1 m=1
Xxs0p_xm4 xs0p_x__p3 t0__p3 vdd__p5 vdd sg13_lv_pmos w=0.5u l=0.13u ng=1 m=1
Xxs0p_xm5 xs0p_x t0__p2 xs0p_cbn__p2 gnd sg13_lv_nmos w=1u l=0.13u ng=1 m=1
Xxs0p_xm7 xs0p_x__p1 xs0p_g__p2 xs0p_cbn__p3 gnd sg13_lv_nmos w=0.5u l=0.13u ng=1 m=1
Xxs0p_xm9 xs0p_cbn xs0p_g__p1 in0p__p1 gnd sg13_lv_nmos w=2u l=0.13u ng=1 m=1
Xxs0p_xm10 xs0p_g__p3 vdd__p3 xs0p_n10 gnd sg13_lv_nmos w=2u l=0.13u ng=1 m=1
Xxs0p_xm11 xs0p_n10__p1 t0b__p3 gnd__p31 gnd sg13_lv_nmos w=2u l=0.13u ng=1 m=1
Xxs0n_xms in0n__p0 xs0n_g top_n__p2 gnd sg13_lv_nmos w=6u l=0.13u ng=2 m=1
Xxs0n_cboot xs0n_cbp__p2 xs0n_cbn__p4 cap_cmim w=11.49u l=11.49u m=1
Xxs0n_xm1 xs0n_cbn__p1 t0b gnd__p28 gnd sg13_lv_nmos w=1u l=0.13u ng=1 m=1
Xxs0n_xm3 xs0n_cbp xs0n_g__p4 vdd__p1 xs0n_cbp sg13_lv_pmos w=1u l=0.13u ng=1 m=1
Xxs0n_xm8 xs0n_g__p5 xs0n_x__p2 xs0n_cbp__p1 xs0n_cbp sg13_lv_pmos w=2u l=0.13u ng=1 m=1
Xxs0n_xm4 xs0n_x__p3 t0__p1 vdd__p2 vdd sg13_lv_pmos w=0.5u l=0.13u ng=1 m=1
Xxs0n_xm5 xs0n_x t0 xs0n_cbn__p2 gnd sg13_lv_nmos w=1u l=0.13u ng=1 m=1
Xxs0n_xm7 xs0n_x__p1 xs0n_g__p2 xs0n_cbn__p3 gnd sg13_lv_nmos w=0.5u l=0.13u ng=1 m=1
Xxs0n_xm9 xs0n_cbn xs0n_g__p1 in0n__p1 gnd sg13_lv_nmos w=2u l=0.13u ng=1 m=1
Xxs0n_xm10 xs0n_g__p3 vdd__p0 xs0n_n10 gnd sg13_lv_nmos w=2u l=0.13u ng=1 m=1
Xxs0n_xm11 xs0n_n10__p1 t0b__p1 gnd__p29 gnd sg13_lv_nmos w=2u l=0.13u ng=1 m=1
Xxs1p_xms in1p__p0 xs1p_g top_p__p3 gnd sg13_lv_nmos w=6u l=0.13u ng=2 m=1
Xxs1p_cboot xs1p_cbp__p2 xs1p_cbn__p4 cap_cmim w=11.49u l=11.49u m=1
Xxs1p_xm1 xs1p_cbn__p1 t1b__p2 gnd__p34 gnd sg13_lv_nmos w=1u l=0.13u ng=1 m=1
Xxs1p_xm3 xs1p_cbp xs1p_g__p4 vdd__p10 xs1p_cbp sg13_lv_pmos w=1u l=0.13u ng=1 m=1
Xxs1p_xm8 xs1p_g__p5 xs1p_x__p2 xs1p_cbp__p1 xs1p_cbp sg13_lv_pmos w=2u l=0.13u ng=1 m=1
Xxs1p_xm4 xs1p_x__p3 t1__p3 vdd__p11 vdd sg13_lv_pmos w=0.5u l=0.13u ng=1 m=1
Xxs1p_xm5 xs1p_x t1__p2 xs1p_cbn__p2 gnd sg13_lv_nmos w=1u l=0.13u ng=1 m=1
Xxs1p_xm7 xs1p_x__p1 xs1p_g__p2 xs1p_cbn__p3 gnd sg13_lv_nmos w=0.5u l=0.13u ng=1 m=1
Xxs1p_xm9 xs1p_cbn xs1p_g__p1 in1p__p1 gnd sg13_lv_nmos w=2u l=0.13u ng=1 m=1
Xxs1p_xm10 xs1p_g__p3 vdd__p9 xs1p_n10 gnd sg13_lv_nmos w=2u l=0.13u ng=1 m=1
Xxs1p_xm11 xs1p_n10__p1 t1b__p3 gnd__p35 gnd sg13_lv_nmos w=2u l=0.13u ng=1 m=1
Xxs1n_xms in1n__p0 xs1n_g top_n__p3 gnd sg13_lv_nmos w=6u l=0.13u ng=2 m=1
Xxs1n_cboot xs1n_cbp__p2 xs1n_cbn__p4 cap_cmim w=11.49u l=11.49u m=1
Xxs1n_xm1 xs1n_cbn__p1 t1b gnd__p32 gnd sg13_lv_nmos w=1u l=0.13u ng=1 m=1
Xxs1n_xm3 xs1n_cbp xs1n_g__p4 vdd__p7 xs1n_cbp sg13_lv_pmos w=1u l=0.13u ng=1 m=1
Xxs1n_xm8 xs1n_g__p5 xs1n_x__p2 xs1n_cbp__p1 xs1n_cbp sg13_lv_pmos w=2u l=0.13u ng=1 m=1
Xxs1n_xm4 xs1n_x__p3 t1__p1 vdd__p8 vdd sg13_lv_pmos w=0.5u l=0.13u ng=1 m=1
Xxs1n_xm5 xs1n_x t1 xs1n_cbn__p2 gnd sg13_lv_nmos w=1u l=0.13u ng=1 m=1
Xxs1n_xm7 xs1n_x__p1 xs1n_g__p2 xs1n_cbn__p3 gnd sg13_lv_nmos w=0.5u l=0.13u ng=1 m=1
Xxs1n_xm9 xs1n_cbn xs1n_g__p1 in1n__p1 gnd sg13_lv_nmos w=2u l=0.13u ng=1 m=1
Xxs1n_xm10 xs1n_g__p3 vdd__p6 xs1n_n10 gnd sg13_lv_nmos w=2u l=0.13u ng=1 m=1
Xxs1n_xm11 xs1n_n10__p1 t1b__p1 gnd__p33 gnd sg13_lv_nmos w=2u l=0.13u ng=1 m=1
Xxpr1 rstb_n__p2 t0b__p9 vdd__p16 vdd sg13_lv_pmos w=1u l=0.13u ng=1 m=1
Xxpr2 rstb_n__p3 t1b__p9 vdd__p17 vdd sg13_lv_pmos w=1u l=0.13u ng=1 m=1
Xxnr1 rstb_n t0b__p6 nr gnd sg13_lv_nmos w=1u l=0.13u ng=1 m=1
Xxnr2 nr__p1 t1b__p6 gnd__p40 gnd sg13_lv_nmos w=1u l=0.13u ng=1 m=1
Xxpr3 rstb__p3 rstb_n__p4 vdd__p18 vdd sg13_lv_pmos w=1u l=0.13u ng=1 m=1
Xxnr3 rstb__p2 rstb_n__p1 gnd__p41 gnd sg13_lv_nmos w=0.5u l=0.13u ng=1 m=1
Xxlrp lsb_p rstb__p1 vrefl__p9 vrefl sg13_lv_pmos w=1u l=0.13u ng=1 m=1
Xxlrn lsb_n rstb vrefl__p8 vrefl sg13_lv_pmos w=1u l=0.13u ng=1 m=1
Xxdp12_xmp bp12 cp12__p0 vref__p5 vref sg13_lv_pmos w=2u l=0.13u ng=1 m=1
Xxdp12_xmn bp12__p1 cp12__p1 gnd__p13 gnd sg13_lv_nmos w=1u l=0.13u ng=1 m=1
Xxdp11_xmp bp11 cp11__p0 vref__p6 vref sg13_lv_pmos w=2u l=0.13u ng=1 m=1
Xxdp11_xmn bp11__p1 cp11__p1 gnd__p14 gnd sg13_lv_nmos w=1u l=0.13u ng=1 m=1
Xxdp10_xmp bp10 cp10__p0 vref__p7 vref sg13_lv_pmos w=2u l=0.13u ng=1 m=1
Xxdp10_xmn bp10__p1 cp10__p1 gnd__p15 gnd sg13_lv_nmos w=1u l=0.13u ng=1 m=1
Xxdp9_xmp bp9 cp9__p0 vref__p8 vref sg13_lv_pmos w=1u l=0.13u ng=1 m=1
Xxdp9_xmn bp9__p1 cp9__p1 gnd__p16 gnd sg13_lv_nmos w=0.5u l=0.13u ng=1 m=1
Xxdp8_xmp bp8 cp8__p0 vref__p9 vref sg13_lv_pmos w=1u l=0.13u ng=1 m=1
Xxdp8_xmn bp8__p1 cp8__p1 gnd__p17 gnd sg13_lv_nmos w=0.5u l=0.13u ng=1 m=1
Xxdp7_xmp bp7 cp7__p0 vrefl__p10 vrefl sg13_lv_pmos w=1u l=0.13u ng=1 m=1
Xxdp7_xmn bp7__p1 cp7__p1 gnd__p18 gnd sg13_lv_nmos w=0.5u l=0.13u ng=1 m=1
Xxdp6_xmp bp6 cp6__p0 vrefl__p11 vrefl sg13_lv_pmos w=1u l=0.13u ng=1 m=1
Xxdp6_xmn bp6__p1 cp6__p1 gnd__p19 gnd sg13_lv_nmos w=0.5u l=0.13u ng=1 m=1
Xxdp5_xmp bp5 cp5__p0 vrefl__p12 vrefl sg13_lv_pmos w=1u l=0.13u ng=1 m=1
Xxdp5_xmn bp5__p1 cp5__p1 gnd__p20 gnd sg13_lv_nmos w=0.5u l=0.13u ng=1 m=1
Xxdp4_xmp bp4 cp4__p0 vrefl__p13 vrefl sg13_lv_pmos w=1u l=0.13u ng=1 m=1
Xxdp4_xmn bp4__p1 cp4__p1 gnd__p21 gnd sg13_lv_nmos w=0.5u l=0.13u ng=1 m=1
Xxdp3_xmp bp3 cp3__p0 vrefl__p14 vrefl sg13_lv_pmos w=1u l=0.13u ng=1 m=1
Xxdp3_xmn bp3__p1 cp3__p1 gnd__p22 gnd sg13_lv_nmos w=0.5u l=0.13u ng=1 m=1
Xxdp2_xmp bp2 cp2__p0 vrefl__p15 vrefl sg13_lv_pmos w=1u l=0.13u ng=1 m=1
Xxdp2_xmn bp2__p1 cp2__p1 gnd__p23 gnd sg13_lv_nmos w=0.5u l=0.13u ng=1 m=1
Xxdp1_xmp bp1 cp1__p0 vrefl__p16 vrefl sg13_lv_pmos w=1u l=0.13u ng=1 m=1
Xxdp1_xmn bp1__p1 cp1__p1 gnd__p24 gnd sg13_lv_nmos w=0.5u l=0.13u ng=1 m=1
Xxdp0_xmp bp0 cp0__p0 vrefl__p17 vrefl sg13_lv_pmos w=1u l=0.13u ng=1 m=1
Xxdp0_xmn bp0__p1 cp0__p1 gnd__p25 gnd sg13_lv_nmos w=0.5u l=0.13u ng=1 m=1
Xxdn12_xmp bn12 cn12__p0 vref__p4 vref sg13_lv_pmos w=2u l=0.13u ng=1 m=1
Xxdn12_xmn bn12__p1 cn12__p1 gnd__p12 gnd sg13_lv_nmos w=1u l=0.13u ng=1 m=1
Xxdn11_xmp bn11 cn11__p0 vref__p3 vref sg13_lv_pmos w=2u l=0.13u ng=1 m=1
Xxdn11_xmn bn11__p1 cn11__p1 gnd__p11 gnd sg13_lv_nmos w=1u l=0.13u ng=1 m=1
Xxdn10_xmp bn10 cn10__p0 vref__p2 vref sg13_lv_pmos w=2u l=0.13u ng=1 m=1
Xxdn10_xmn bn10__p1 cn10__p1 gnd__p10 gnd sg13_lv_nmos w=1u l=0.13u ng=1 m=1
Xxdn9_xmp bn9 cn9__p0 vref__p1 vref sg13_lv_pmos w=1u l=0.13u ng=1 m=1
Xxdn9_xmn bn9__p1 cn9__p1 gnd__p9 gnd sg13_lv_nmos w=0.5u l=0.13u ng=1 m=1
Xxdn8_xmp bn8 cn8__p0 vref__p0 vref sg13_lv_pmos w=1u l=0.13u ng=1 m=1
Xxdn8_xmn bn8__p1 cn8__p1 gnd__p8 gnd sg13_lv_nmos w=0.5u l=0.13u ng=1 m=1
Xxdn7_xmp bn7 cn7__p0 vrefl__p7 vrefl sg13_lv_pmos w=1u l=0.13u ng=1 m=1
Xxdn7_xmn bn7__p1 cn7__p1 gnd__p7 gnd sg13_lv_nmos w=0.5u l=0.13u ng=1 m=1
Xxdn6_xmp bn6 cn6__p0 vrefl__p6 vrefl sg13_lv_pmos w=1u l=0.13u ng=1 m=1
Xxdn6_xmn bn6__p1 cn6__p1 gnd__p6 gnd sg13_lv_nmos w=0.5u l=0.13u ng=1 m=1
Xxdn5_xmp bn5 cn5__p0 vrefl__p5 vrefl sg13_lv_pmos w=1u l=0.13u ng=1 m=1
Xxdn5_xmn bn5__p1 cn5__p1 gnd__p5 gnd sg13_lv_nmos w=0.5u l=0.13u ng=1 m=1
Xxdn4_xmp bn4 cn4__p0 vrefl__p4 vrefl sg13_lv_pmos w=1u l=0.13u ng=1 m=1
Xxdn4_xmn bn4__p1 cn4__p1 gnd__p4 gnd sg13_lv_nmos w=0.5u l=0.13u ng=1 m=1
Xxdn3_xmp bn3 cn3__p0 vrefl__p3 vrefl sg13_lv_pmos w=1u l=0.13u ng=1 m=1
Xxdn3_xmn bn3__p1 cn3__p1 gnd__p3 gnd sg13_lv_nmos w=0.5u l=0.13u ng=1 m=1
Xxdn2_xmp bn2 cn2__p0 vrefl__p2 vrefl sg13_lv_pmos w=1u l=0.13u ng=1 m=1
Xxdn2_xmn bn2__p1 cn2__p1 gnd__p2 gnd sg13_lv_nmos w=0.5u l=0.13u ng=1 m=1
Xxdn1_xmp bn1 cn1__p0 vrefl__p1 vrefl sg13_lv_pmos w=1u l=0.13u ng=1 m=1
Xxdn1_xmn bn1__p1 cn1__p1 gnd__p1 gnd sg13_lv_nmos w=0.5u l=0.13u ng=1 m=1
Xxdn0_xmp bn0 cn0__p0 vrefl__p0 vrefl sg13_lv_pmos w=1u l=0.13u ng=1 m=1
Xxdn0_xmn bn0__p1 cn0__p1 gnd__p0 gnd sg13_lv_nmos w=0.5u l=0.13u ng=1 m=1
Xxc4_xs1_xmt1 xc4_xs1_tail0 clkb__p2 vdd__p28 vdd sg13_lv_pmos w=16u l=0.13u ng=4 m=1
Xxc4_xs1_xmtc xc4_xs1_tail__p2 vbp xc4_xs1_tail0__p1 vdd sg13_lv_pmos w=16u l=0.5u ng=4 m=1
Xxc4_xs1_xm1 xc4_dip top_p__p4 xc4_xs1_tail vdd sg13_lv_pmos w=48u l=0.3u ng=12 m=1
Xxc4_xs1_xm2 xc4_din top_n__p4 xc4_xs1_tail__p1 vdd sg13_lv_pmos w=48u l=0.3u ng=12 m=1
Xxc4_xci1 vdd__p23 xc4_dip vdd__p22 vdd sg13_lv_pmos w=80u l=4u ng=8 m=1
Xxc4_xci2 vdd__p25 xc4_din vdd__p24 vdd sg13_lv_pmos w=80u l=4u ng=8 m=1
Xxc4_xmr1 xc4_dip__p1 clkb__p0 gnd__p49 gnd sg13_lv_nmos w=20u l=0.13u ng=2 m=1
Xxc4_xmr2 xc4_din__p1 clkb__p1 gnd__p50 gnd sg13_lv_nmos w=20u l=0.13u ng=2 m=1
Xxc4_xmt2 xc4_lt clk__p0 gnd__p55 gnd sg13_lv_nmos w=4u l=0.13u ng=1 m=1
Xxc4_xmn1 op__p0 on__p0 xc4_lt__p1 gnd sg13_lv_nmos w=2u l=0.13u ng=1 m=1
Xxc4_xmn2 on__p1 op__p1 xc4_lt__p2 gnd sg13_lv_nmos w=2u l=0.13u ng=1 m=1
Xxc4_xmp1 op__p4 on__p4 vdd__p31 vdd sg13_lv_pmos w=2u l=0.13u ng=1 m=1
Xxc4_xmp2 on__p5 op__p5 vdd__p32 vdd sg13_lv_pmos w=2u l=0.13u ng=1 m=1
Xxc4_xmh1 op__p3 xc4_dip__p2 vdd__p29 vdd sg13_lv_pmos w=8u l=0.13u ng=2 m=1
Xxc4_xmh2 on__p3 xc4_din__p2 vdd__p30 vdd sg13_lv_pmos w=8u l=0.13u ng=2 m=1
Xxc4_xbp1 xc4_outpb__p1 op__p6 vdd__p33 vdd sg13_lv_pmos w=1u l=0.13u ng=1 m=1
Xxc4_xbn1 xc4_outpb op__p2 gnd__p56 gnd sg13_lv_nmos w=0.5u l=0.13u ng=1 m=1
Xxc4_xbp2 xc4_outnb__p1 on__p6 vdd__p34 vdd sg13_lv_pmos w=1u l=0.13u ng=1 m=1
Xxc4_xbn2 xc4_outnb on__p2 gnd__p57 gnd sg13_lv_nmos w=0.5u l=0.13u ng=1 m=1
Xxc5_xs1_xmt1 xc5_xs1_tail0 clkn__p2 gnd__p46 gnd sg13_lv_nmos w=8u l=0.13u ng=2 m=1
Xxc5_xs1_xmtc xc5_xs1_tail vbn xc5_xs1_tail0__p1 gnd sg13_lv_nmos w=4u l=0.5u ng=1 m=1
Xxc5_xs1_xm1 xc5_dip__p2 top_p xc5_xs1_tail__p1 gnd sg13_lv_nmos w=16u l=0.5u ng=4 m=1
Xxc5_xs1_xm2 xc5_din__p2 top_n xc5_xs1_tail__p2 gnd sg13_lv_nmos w=16u l=0.5u ng=4 m=1
Xxc5_xci1 gnd__p43 xc5_dip gnd__p42 gnd sg13_lv_nmos w=30u l=4u ng=4 m=1
Xxc5_xci2 gnd__p45 xc5_din gnd__p44 gnd sg13_lv_nmos w=30u l=4u ng=4 m=1
Xxc5_xmr1 xc5_dip clkn__p0 vdd__p19 vdd sg13_lv_pmos w=16u l=0.13u ng=2 m=1
Xxc5_xmr2 xc5_din clkn__p1 vdd__p20 vdd sg13_lv_pmos w=16u l=0.13u ng=2 m=1
Xxc5_xmt2 xc5_lt clknb__p0 vdd__p21 vdd sg13_lv_pmos w=8u l=0.13u ng=1 m=1
Xxc5_xmp1 onp__p4 onn__p4 xc5_lt__p1 vdd sg13_lv_pmos w=4u l=0.13u ng=1 m=1
Xxc5_xmp2 onn__p5 onp__p5 xc5_lt__p2 vdd sg13_lv_pmos w=4u l=0.13u ng=1 m=1
Xxc5_xmn1 onp__p1 onn__p1 gnd__p51 gnd sg13_lv_nmos w=1u l=0.13u ng=1 m=1
Xxc5_xmn2 onn__p2 onp__p2 gnd__p52 gnd sg13_lv_nmos w=1u l=0.13u ng=1 m=1
Xxc5_xmh1 onp__p0 xc5_dip__p1 gnd__p47 gnd sg13_lv_nmos w=8u l=0.13u ng=1 m=1
Xxc5_xmh2 onn__p0 xc5_din__p1 gnd__p48 gnd sg13_lv_nmos w=8u l=0.13u ng=1 m=1
Xxc5_xbp1 xc5_outpb__p1 onp__p6 vdd__p26 vdd sg13_lv_pmos w=1u l=0.13u ng=1 m=1
Xxc5_xbn1 xc5_outpb onp__p3 gnd__p53 gnd sg13_lv_nmos w=0.5u l=0.13u ng=1 m=1
Xxc5_xbp2 xc5_outnb__p1 onn__p6 vdd__p27 vdd sg13_lv_pmos w=1u l=0.13u ng=1 m=1
Xxc5_xbn2 xc5_outnb onn__p3 gnd__p54 gnd sg13_lv_nmos w=0.5u l=0.13u ng=1 m=1
Xxdacp_xc12_u0 top_p__p1 bp12__p2 cap_cmim w=3.78u l=3.78u m=16
Xxdacp_xc11_u0 top_p__p1 bp11__p2 cap_cmim w=3.78u l=3.78u m=8
Xxdacp_xc10_u0 top_p__p1 bp10__p2 cap_cmim w=3.78u l=3.78u m=4
Xxdacp_xc9_u0 top_p__p1 bp9__p2 cap_cmim w=3.78u l=3.78u m=2
Xxdacp_xc8_u0 top_p__p1 bp8__p2 cap_cmim w=3.78u l=3.78u m=1
Xxdacp_xcb top_p__p1 lsb_p__p1 cap_cmim w=4.23u l=4.23u m=1
Xxdacp_xc7_u0 lsb_p__p1 bp7__p2 cap_cmim w=3.78u l=3.78u m=64
Xxdacp_xc6_u0 lsb_p__p1 bp6__p2 cap_cmim w=3.78u l=3.78u m=32
Xxdacp_xc5_u0 lsb_p__p1 bp5__p2 cap_cmim w=3.78u l=3.78u m=16
Xxdacp_xc4_u0 lsb_p__p1 bp4__p2 cap_cmim w=3.78u l=3.78u m=8
Xxdacp_xc3_u0 lsb_p__p1 bp3__p2 cap_cmim w=3.78u l=3.78u m=4
Xxdacp_xc2_u0 lsb_p__p1 bp2__p2 cap_cmim w=3.78u l=3.78u m=2
Xxdacp_xc1_u0 lsb_p__p1 bp1__p2 cap_cmim w=3.78u l=3.78u m=1
Xxdacp_xc0 lsb_p__p1 bp0__p2 cap_cmim w=2.67u l=2.67u m=1
Xxdacn_xc12_u0 top_n__p1 bn12__p2 cap_cmim w=3.78u l=3.78u m=16
Xxdacn_xc11_u0 top_n__p1 bn11__p2 cap_cmim w=3.78u l=3.78u m=8
Xxdacn_xc10_u0 top_n__p1 bn10__p2 cap_cmim w=3.78u l=3.78u m=4
Xxdacn_xc9_u0 top_n__p1 bn9__p2 cap_cmim w=3.78u l=3.78u m=2
Xxdacn_xc8_u0 top_n__p1 bn8__p2 cap_cmim w=3.78u l=3.78u m=1
Xxdacn_xcb top_n__p1 lsb_n__p1 cap_cmim w=4.23u l=4.23u m=1
Xxdacn_xc7_u0 lsb_n__p1 bn7__p2 cap_cmim w=3.78u l=3.78u m=64
Xxdacn_xc6_u0 lsb_n__p1 bn6__p2 cap_cmim w=3.78u l=3.78u m=32
Xxdacn_xc5_u0 lsb_n__p1 bn5__p2 cap_cmim w=3.78u l=3.78u m=16
Xxdacn_xc4_u0 lsb_n__p1 bn4__p2 cap_cmim w=3.78u l=3.78u m=8
Xxdacn_xc3_u0 lsb_n__p1 bn3__p2 cap_cmim w=3.78u l=3.78u m=4
Xxdacn_xc2_u0 lsb_n__p1 bn2__p2 cap_cmim w=3.78u l=3.78u m=2
Xxdacn_xc1_u0 lsb_n__p1 bn1__p2 cap_cmim w=3.78u l=3.78u m=1
Xxdacn_xc0 lsb_n__p1 bn0__p2 cap_cmim w=2.67u l=2.67u m=1
Xxdmy_u0 gnd__p27 gnd__p27 cap_cmim w=3.78u l=3.78u m=82
Cld_xc4_outpb xc4_outpb gnd 3f
Cld_xc4_outnb xc4_outnb gnd 3f
Cld_xc5_outpb xc5_outpb gnd 3f
Cld_xc5_outnb xc5_outnb gnd 3f
Rw0 bn0 bn0__p1 30.5072
Rw1 bn0 bn0__p2 26.3744
Rw2 bn0__p1 bn0__p2 32.1711
Rw3 bn1 bn1__p1 30.9128
Rw4 bn1 bn1__p2 26.3943
Rw5 bn1__p1 bn1__p2 31.4474
Rw6 bn10 bn10__p1 39.3432
Rw7 bn10 bn10__p2 18.5632
Rw8 bn11 bn11__p1 70.36
Rw9 bn11 bn11__p2 21.1297
Rw10 bn11__p1 bn11__p2 70.2299
Rw11 bn12 bn12__p1 70.5049
Rw12 bn12 bn12__p2 21.1428
Rw13 bn12__p1 bn12__p2 70.5049
Rw14 bn2 bn2__p1 19.8494
Rw15 bn2 bn2__p2 18.7725
Rw16 bn2__p1 bn2__p2 10547.3
Rw17 bn3 bn3__p1 31.7277
Rw18 bn3 bn3__p2 26.1343
Rw19 bn3__p1 bn3__p2 32.3351
Rw20 bn4 bn4__p1 31.7277
Rw21 bn4 bn4__p2 26.1343
Rw22 bn4__p1 bn4__p2 32.3351
Rw23 bn5 bn5__p1 30.9128
Rw24 bn5 bn5__p2 26.3943
Rw25 bn5__p1 bn5__p2 31.4474
Rw26 bn6 bn6__p1 30.9128
Rw27 bn6 bn6__p2 26.3943
Rw28 bn6__p1 bn6__p2 31.4474
Rw29 bn7 bn7__p1 19.8494
Rw30 bn7 bn7__p2 18.7725
Rw31 bn7__p1 bn7__p2 10547.3
Rw32 bn8 bn8__p2 18.5632
Rw33 bn8__p1 bn8__p2 21.7312
Rw34 bn9 bn9__p1 69.7478
Rw35 bn9 bn9__p2 21.3604
Rw36 bn9__p1 bn9__p2 70.9542
Rw37 bp0 bp0__p1 73.63
Rw38 bp0 bp0__p2 21.2102
Rw39 bp0__p1 bp0__p2 75.0396
Rw40 bp1 bp1__p1 72.925
Rw41 bp1 bp1__p2 21.22
Rw42 bp1__p1 bp1__p2 74.1863
Rw43 bp10 bp10__p1 69.9965
Rw44 bp10 bp10__p2 21.3762
Rw45 bp10__p1 bp10__p2 71.0665
Rw46 bp11 bp11__p1 71.7074
Rw47 bp11 bp11__p2 21.0897
Rw48 bp11__p1 bp11__p2 71.7074
Rw49 bp12 bp12__p1 70.3916
Rw50 bp12 bp12__p2 21.1283
Rw51 bp12__p1 bp12__p2 70.2615
Rw52 bp2 bp2__p1 41.0573
Rw53 bp2 bp2__p2 18.7553
Rw54 bp2__p1 bp2__p2 21816.3
Rw55 bp3 bp3__p2 18.9152
Rw56 bp3__p1 bp3__p2 23.9792
Rw57 bp4 bp4__p1 73.383
Rw58 bp4 bp4__p2 21.2009
Rw59 bp4__p1 bp4__p2 74.6523
Rw60 bp5 bp5__p1 72.925
Rw61 bp5 bp5__p2 21.22
Rw62 bp5__p1 bp5__p2 74.1863
Rw63 bp6 bp6__p1 108.594
Rw64 bp6 bp6__p2 20.2787
Rw65 bp6__p1 bp6__p2 110.674
Rw66 bp7 bp7__p2 18.545
Rw67 bp7__p1 bp7__p2 41.541
Rw68 bp8 bp8__p1 70.5278
Rw69 bp8 bp8__p2 21.3441
Rw70 bp8__p1 bp8__p2 71.8781
Rw71 bp9 bp9__p1 69.7478
Rw72 bp9 bp9__p2 21.3604
Rw73 bp9__p1 bp9__p2 70.9542
Rw74 clk clk__p0 45.8439
Rw75 clkb clkb__p0 213.908
Rw76 clkb clkb__p2 84.0974
Rw77 clkb__p0 clkb__p1 0.72754
Rw78 clkb__p0 clkb__p2 84.3101
Rw79 clkn clkn__p2 50.983
Rw80 clkn__p0 clkn__p1 0.756645
Rw81 clkn__p0 clkn__p2 58.0436
Rw82 clkn__p1 clkn__p2 354.511
Rw83 clknb clknb__p0 33.078
Rw84 cn0 cn0__p0 119.277
Rw85 cn0 cn0__p1 125.794
Rw86 cn0__p0 cn0__p1 21.3175
Rw87 cn1 cn1__p0 113.211
Rw88 cn1 cn1__p1 128.382
Rw89 cn1__p0 cn1__p1 21.3517
Rw90 cn10 cn10__p0 47.8805
Rw91 cn10 cn10__p1 8917.65
Rw92 cn10__p0 cn10__p1 39.4941
Rw93 cn11 cn11__p0 174.29
Rw94 cn11 cn11__p1 206.251
Rw95 cn11__p0 cn11__p1 43.8732
Rw96 cn12 cn12__p0 111.59
Rw97 cn12 cn12__p1 356.14
Rw98 cn12__p0 cn12__p1 42.8693
Rw99 cn2 cn2__p0 85.617
Rw100 cn2 cn2__p1 266.479
Rw101 cn2__p0 cn2__p1 43.088
Rw102 cn3 cn3__p0 91.4068
Rw103 cn3 cn3__p1 265.781
Rw104 cn3__p0 cn3__p1 43.3698
Rw105 cn4 cn4__p0 92.8188
Rw106 cn4 cn4__p1 270.814
Rw107 cn4__p0 cn4__p1 43.2342
Rw108 cn5 cn5__p0 122.421
Rw109 cn5 cn5__p1 138.826
Rw110 cn5__p0 cn5__p1 21.2107
Rw111 cn6 cn6__p0 124.801
Rw112 cn6 cn6__p1 136.523
Rw113 cn6__p0 cn6__p1 21.2102
Rw114 cn7 cn7__p0 119.301
Rw115 cn7 cn7__p1 135.288
Rw116 cn7__p0 cn7__p1 21.2559
Rw117 cn8 cn8__p0 46.7307
Rw118 cn8 cn8__p1 5314.82
Rw119 cn8__p0 cn8__p1 39.4627
Rw120 cn9 cn9__p0 45.866
Rw121 cn9__p0 cn9__p1 39.2019
Rw122 cp0 cp0__p0 78.9856
Rw123 cp0 cp0__p1 264.577
Rw124 cp0__p0 cp0__p1 46.2364
Rw125 cp1 cp1__p0 84.399
Rw126 cp1 cp1__p1 266.127
Rw127 cp1__p0 cp1__p1 46.5643
Rw128 cp10 cp10__p0 48.858
Rw129 cp10 cp10__p1 4993.67
Rw130 cp10__p0 cp10__p1 21.7666
Rw131 cp11 cp11__p0 87.0417
Rw132 cp11 cp11__p1 269.796
Rw133 cp11__p0 cp11__p1 44.1261
Rw134 cp12 cp12__p0 149.483
Rw135 cp12 cp12__p1 189.669
Rw136 cp12__p0 cp12__p1 23.1332
Rw137 cp2 cp2__p0 61.3364
Rw138 cp2 cp2__p1 147494
Rw139 cp2__p0 cp2__p1 40.7633
Rw140 cp3 cp3__p0 128.315
Rw141 cp3 cp3__p1 450.801
Rw142 cp3__p0 cp3__p1 44.6919
Rw143 cp4 cp4__p0 116.254
Rw144 cp4 cp4__p1 346.768
Rw145 cp4__p0 cp4__p1 44.7666
Rw146 cp5 cp5__p0 52.2018
Rw147 cp5 cp5__p1 281.804
Rw148 cp5__p0 cp5__p1 71.3926
Rw149 cp6 cp6__p0 114.9
Rw150 cp6 cp6__p1 368.389
Rw151 cp6__p0 cp6__p1 44.667
Rw152 cp7 cp7__p0 144.313
Rw153 cp7 cp7__p1 170.541
Rw154 cp7__p0 cp7__p1 82.0497
Rw155 cp8 cp8__p0 199.362
Rw156 cp8 cp8__p1 199.018
Rw157 cp8__p0 cp8__p1 43.4388
Rw158 cp9 cp9__p0 47.9701
Rw159 cp9 cp9__p1 110867
Rw160 cp9__p0 cp9__p1 39.1818
Rw161 gnd__i7 gnd__i8 9
Rw162 gnd__i10 gnd__i11 9
Rw163 gnd__i14 gnd__i15 9
Rw164 gnd__i17 gnd__i18 9
Rw165 gnd__i20 gnd__i21 9
Rw166 gnd__i23 gnd__i24 9
Rw167 gnd__i29 gnd__i30 9
Rw168 gnd__i39 gnd__i40 9
Rw169 gnd__i42 gnd__i43 9
Rw170 gnd__i45 gnd__i46 9
Rw171 gnd__i48 gnd__i49 9
Rw172 gnd__i61 gnd__i62 9
Rw173 gnd__i63 gnd__i64 9
Rw174 gnd__i72 gnd__i73 9
Rw175 gnd__i75 gnd__i76 9
Rw176 gnd__i78 gnd__i79 9
Rw177 gnd__i81 gnd__i82 9
Rw178 gnd__i84 gnd__i85 9
Rw179 gnd__i92 gnd__i93 9
Rw180 gnd__i95 gnd__i96 9
Rw181 gnd__i135 gnd__i136 9
Rw182 gnd__i148 gnd__i149 9
Rw183 gnd__i152 gnd__i153 9
Rw184 gnd__i154 gnd__i155 9
Rw185 gnd__i157 gnd__i158 9
Rw186 gnd__i160 gnd__i161 9
Rw187 gnd__i164 gnd__i165 9
Rw188 gnd__i167 gnd__i168 9
Rw189 gnd__i170 gnd__i171 9
Rw190 gnd__i173 gnd__i174 9
Rw191 gnd__i176 gnd__i177 9
Rw192 gnd__i179 gnd__i180 9
Rw193 gnd__i182 gnd__i183 9
Rw194 gnd__i185 gnd__i186 9
Rw195 gnd__i188 gnd__i189 9
Rw196 gnd__i219 gnd__i220 9
Rw197 gnd__i223 gnd__i224 9
Rw198 gnd__i226 gnd__i227 9
Rw199 gnd__i229 gnd__i230 9
Rw200 gnd__i232 gnd__i233 9
Rw201 gnd__i235 gnd__i236 9
Rw202 gnd__i238 gnd__i239 9
Rw203 gnd__i241 gnd__i242 9
Rw204 gnd__i258 gnd__i259 9
Rw205 gnd__i70 gnd__i69 10.4585
Rw206 gnd__i55 gnd__i54 1.32
Rw207 gnd__i56 gnd__i55 4.02769
Rw208 gnd__i59 gnd__i58 1.32
Rw209 gnd__i60 gnd__i59 0.981538
Rw210 gnd__i65 gnd__i66 4.70462
Rw211 gnd__i63 gnd__i61 0.304615
Rw212 gnd__i63 gnd__i65 0.304615
Rw213 gnd__i60 gnd__i61 0.304615
Rw214 gnd__i262 gnd__i95 0.12692
Rw215 gnd__i95 gnd__p23 0.0306538
Rw216 gnd__i262 gnd__i99 0.0444966
Rw217 gnd__i99 gnd__p23 0.0159287
Rw218 gnd__i263 gnd__i29 0.12692
Rw219 gnd__i29 gnd__p1 0.0306538
Rw220 gnd__i263 gnd__i68 0.0444966
Rw221 gnd__i68 gnd__p1 0.0159287
Rw222 gnd__i264 gnd__i31 0.12692
Rw223 gnd__i31 gnd__p2 0.0306538
Rw224 gnd__i264 gnd__i7 0.0444966
Rw225 gnd__i7 gnd__p2 0.0159287
Rw226 gnd__i265 gnd__i32 0.12692
Rw227 gnd__i32 gnd__p3 0.0306538
Rw228 gnd__i265 gnd__i10 0.0444966
Rw229 gnd__i10 gnd__p3 0.0159287
Rw230 gnd__i266 gnd__i34 0.12692
Rw231 gnd__i34 gnd__p6 0.0306538
Rw232 gnd__i266 gnd__i14 0.0444966
Rw233 gnd__i14 gnd__p6 0.0159287
Rw234 gnd__i267 gnd__i35 0.12692
Rw235 gnd__i35 gnd__p7 0.0306538
Rw236 gnd__i267 gnd__i17 0.0444966
Rw237 gnd__i17 gnd__p7 0.0159287
Rw238 gnd__i268 gnd__i36 0.12692
Rw239 gnd__i36 gnd__p8 0.0306538
Rw240 gnd__i268 gnd__i20 0.0444966
Rw241 gnd__i20 gnd__p8 0.0159287
Rw242 gnd__i269 gnd__i37 0.12692
Rw243 gnd__i37 gnd__p9 0.0306538
Rw244 gnd__i269 gnd__i23 0.0444966
Rw245 gnd__i23 gnd__p9 0.0159287
Rw246 gnd__i270 gnd__i92 0.12692
Rw247 gnd__i92 gnd__p22 0.0306538
Rw248 gnd__i270 gnd__i98 0.0444966
Rw249 gnd__i98 gnd__p22 0.0159287
Rw250 gnd__i271 gnd__i91 0.12692
Rw251 gnd__i91 gnd__p21 0.0306538
Rw252 gnd__i271 gnd__i84 0.0444966
Rw253 gnd__i84 gnd__p21 0.0159287
Rw254 gnd__i272 gnd__i90 0.12692
Rw255 gnd__i90 gnd__p20 0.0306538
Rw256 gnd__i272 gnd__i81 0.0444966
Rw257 gnd__i81 gnd__p20 0.0159287
Rw258 gnd__i273 gnd__i89 0.12692
Rw259 gnd__i89 gnd__p19 0.0306538
Rw260 gnd__i273 gnd__i78 0.0444966
Rw261 gnd__i78 gnd__p19 0.0159287
Rw262 gnd__i274 gnd__i88 0.12692
Rw263 gnd__i88 gnd__p18 0.0306538
Rw264 gnd__i274 gnd__i75 0.0444966
Rw265 gnd__i75 gnd__p18 0.0159287
Rw266 gnd__i275 gnd__i87 0.12692
Rw267 gnd__i87 gnd__p16 0.0306538
Rw268 gnd__i275 gnd__i72 0.0444966
Rw269 gnd__i72 gnd__p16 0.0159287
Rw270 gnd__i276 gnd__i50 0.12692
Rw271 gnd__i50 gnd__p10 0.0306538
Rw272 gnd__i276 gnd__i39 0.0444966
Rw273 gnd__i39 gnd__p10 0.0159287
Rw274 gnd__i277 gnd__i51 0.12692
Rw275 gnd__i51 gnd__p11 0.0306538
Rw276 gnd__i277 gnd__i42 0.0444966
Rw277 gnd__i42 gnd__p11 0.0159287
Rw278 gnd__i278 gnd__i52 0.12692
Rw279 gnd__i52 gnd__p12 0.0306538
Rw280 gnd__i278 gnd__i45 0.0444966
Rw281 gnd__i45 gnd__p12 0.0159287
Rw282 gnd__i279 gnd__i53 0.12692
Rw283 gnd__i53 gnd__p14 0.0306538
Rw284 gnd__i279 gnd__i48 0.0444966
Rw285 gnd__i48 gnd__p14 0.0159287
Rw286 gnd__i280 gnd__i135 0.737994
Rw287 gnd__i62 gnd__i64 0.192997
Rw288 gnd__i126 gnd__i25 0.368997
Rw289 gnd__i25 gnd__i62 0.720997
Rw290 gnd__i281 gnd__i219 0.0171741
Rw291 gnd__i221 gnd__i281 0.196985
Rw292 gnd__i125 gnd__i121 0.118249
Rw293 gnd__i121 gnd__i283 0.82826
Rw294 gnd__i283 gnd__i200 0.236952
Rw295 gnd__i223 gnd__i133 0.185778
Rw296 gnd__i134 gnd__i226 0.185778
Rw297 gnd__i146 gnd__i131 0.0564431
Rw298 gnd__i147 gnd__i146 0.0874829
Rw299 gnd gnd__i205 0.00385
Rw300 gnd__i205 gnd__p59 0.715
Rw301 gnd__i203 gnd__p60 0.6446
Rw302 gnd__p60 gnd__i204 0.6974
Rw303 gnd__i204 gnd__p61 0.02145
Rw304 gnd__p61 gnd__i284 0.19855
Rw305 gnd__i284 gnd__p62 0.58905
Rw306 gnd__p62 gnd__i261 0.09295
Rw307 gnd__i261 gnd__p63 0.6259
Rw308 gnd__p63 gnd__i259 0.2761
Rw309 gnd__i259 gnd__i260 0.022
Rw310 gnd__p64 gnd__i218 0.2365
Rw311 gnd__i218 gnd__p65 0.48235
Rw312 gnd__i285 gnd__i284 0.132
Rw313 gnd__i285 gnd__i186 0.1925
Rw314 gnd__i201 gnd__i202 0.176
Rw315 gnd__i202 gnd__p26 0.176
Rw316 gnd__i97 gnd__p25 9
Rw317 gnd__i33 gnd__p5 9
Rw318 gnd__i100 gnd__i97 0.11
Rw319 gnd__i132 gnd__i100 9
Rw320 gnd__i131 gnd__i94 9
Rw321 gnd__i146 gnd__i94 9
Rw322 gnd__i96 gnd__i94 0.0488889
Rw323 gnd__i99 gnd__i96 9
Rw324 gnd__i147 gnd__i96 9
Rw325 gnd__i101 gnd__i26 9
Rw326 gnd__i110 gnd__i26 9
Rw327 gnd__i27 gnd__i26 0.0488889
Rw328 gnd__i102 gnd__i28 9
Rw329 gnd__i111 gnd__i28 9
Rw330 gnd__i30 gnd__i28 0.0488889
Rw331 gnd__i68 gnd__i30 9
Rw332 gnd__i103 gnd__i6 9
Rw333 gnd__i112 gnd__i6 9
Rw334 gnd__i8 gnd__i6 0.0488889
Rw335 gnd__i31 gnd__i8 9
Rw336 gnd__i104 gnd__i9 9
Rw337 gnd__i113 gnd__i9 9
Rw338 gnd__i11 gnd__i9 0.0488889
Rw339 gnd__i32 gnd__i11 9
Rw340 gnd__i130 gnd__i86 9
Rw341 gnd__i145 gnd__i86 9
Rw342 gnd__i93 gnd__i86 0.0488889
Rw343 gnd__i98 gnd__i93 9
Rw344 gnd__i106 gnd__i13 9
Rw345 gnd__i114 gnd__i13 9
Rw346 gnd__i15 gnd__i13 0.0488889
Rw347 gnd__i34 gnd__i15 9
Rw348 gnd__i107 gnd__i16 9
Rw349 gnd__i115 gnd__i16 9
Rw350 gnd__i18 gnd__i16 0.0488889
Rw351 gnd__i35 gnd__i18 9
Rw352 gnd__i108 gnd__i19 9
Rw353 gnd__i116 gnd__i19 9
Rw354 gnd__i21 gnd__i19 0.0488889
Rw355 gnd__i36 gnd__i21 9
Rw356 gnd__i109 gnd__i22 9
Rw357 gnd__i117 gnd__i22 9
Rw358 gnd__i24 gnd__i22 0.0488889
Rw359 gnd__i37 gnd__i24 9
Rw360 gnd__i129 gnd__i83 9
Rw361 gnd__i144 gnd__i83 9
Rw362 gnd__i85 gnd__i83 0.0488889
Rw363 gnd__i91 gnd__i85 9
Rw364 gnd__i128 gnd__i80 9
Rw365 gnd__i143 gnd__i80 9
Rw366 gnd__i82 gnd__i80 0.0488889
Rw367 gnd__i90 gnd__i82 9
Rw368 gnd__i139 gnd__i77 9
Rw369 gnd__i142 gnd__i77 9
Rw370 gnd__i79 gnd__i77 0.0488889
Rw371 gnd__i89 gnd__i79 9
Rw372 gnd__i138 gnd__i74 9
Rw373 gnd__i141 gnd__i74 9
Rw374 gnd__i76 gnd__i74 0.0488889
Rw375 gnd__i88 gnd__i76 9
Rw376 gnd__i137 gnd__i71 9
Rw377 gnd__i140 gnd__i71 9
Rw378 gnd__i73 gnd__i71 0.0488889
Rw379 gnd__i87 gnd__i73 9
Rw380 gnd__i12 gnd__i33 0.11
Rw381 gnd__i105 gnd__i12 9
Rw382 gnd__i118 gnd__i38 9
Rw383 gnd__i122 gnd__i38 9
Rw384 gnd__i40 gnd__i38 0.0488889
Rw385 gnd__i50 gnd__i40 9
Rw386 gnd__i119 gnd__i41 9
Rw387 gnd__i123 gnd__i41 9
Rw388 gnd__i43 gnd__i41 0.0488889
Rw389 gnd__i51 gnd__i43 9
Rw390 gnd__i120 gnd__i44 9
Rw391 gnd__i124 gnd__i44 9
Rw392 gnd__i46 gnd__i44 0.0488889
Rw393 gnd__i52 gnd__i46 9
Rw394 gnd__i49 gnd__i47 0.0488889
Rw395 gnd__i53 gnd__i49 9
Rw396 gnd__i121 gnd__i49 9
Rw397 gnd__i125 gnd__i49 9
Rw398 gnd__i221 gnd__i136 0.185635
Rw399 gnd__i260 gnd__i258 9
Rw400 gnd__i136 gnd__i258 0.521654
Rw401 gnd__i101 gnd__i110 0.0488889
Rw402 gnd__i27 gnd__i110 9
Rw403 gnd__i188 gnd__i101 0.371556
Rw404 gnd__i27 gnd__i101 9
Rw405 gnd__i152 gnd__i188 0.0488889
Rw406 gnd__i206 gnd__i152 0.0488889
Rw407 gnd__i102 gnd__i111 0.0488889
Rw408 gnd__i30 gnd__i111 9
Rw409 gnd__i190 gnd__i102 0.371556
Rw410 gnd__i30 gnd__i102 9
Rw411 gnd__i154 gnd__i190 0.0488889
Rw412 gnd__i156 gnd__i154 9
Rw413 gnd__i207 gnd__i154 0.0488889
Rw414 gnd__i103 gnd__i112 0.0488889
Rw415 gnd__i8 gnd__i112 9
Rw416 gnd__i191 gnd__i103 0.371556
Rw417 gnd__i8 gnd__i103 9
Rw418 gnd__i157 gnd__i191 0.0488889
Rw419 gnd__i159 gnd__i157 9
Rw420 gnd__i208 gnd__i157 0.0488889
Rw421 gnd__i104 gnd__i113 0.0488889
Rw422 gnd__i11 gnd__i113 9
Rw423 gnd__i192 gnd__i104 0.371556
Rw424 gnd__i11 gnd__i104 9
Rw425 gnd__i160 gnd__i192 0.0488889
Rw426 gnd__i162 gnd__i160 9
Rw427 gnd__i209 gnd__i160 0.0488889
Rw428 gnd__i106 gnd__i114 0.0488889
Rw429 gnd__i15 gnd__i114 9
Rw430 gnd__i193 gnd__i106 0.371556
Rw431 gnd__i15 gnd__i106 9
Rw432 gnd__i164 gnd__i193 0.0488889
Rw433 gnd__i166 gnd__i164 9
Rw434 gnd__i210 gnd__i164 0.0488889
Rw435 gnd__i107 gnd__i115 0.0488889
Rw436 gnd__i18 gnd__i115 9
Rw437 gnd__i194 gnd__i107 0.371556
Rw438 gnd__i18 gnd__i107 9
Rw439 gnd__i167 gnd__i194 0.0488889
Rw440 gnd__i169 gnd__i167 9
Rw441 gnd__i211 gnd__i167 0.0488889
Rw442 gnd__i108 gnd__i116 0.0488889
Rw443 gnd__i21 gnd__i116 9
Rw444 gnd__i195 gnd__i108 0.371556
Rw445 gnd__i21 gnd__i108 9
Rw446 gnd__i170 gnd__i195 0.0488889
Rw447 gnd__i172 gnd__i170 9
Rw448 gnd__i212 gnd__i170 0.0488889
Rw449 gnd__i109 gnd__i117 0.0488889
Rw450 gnd__i24 gnd__i117 9
Rw451 gnd__i196 gnd__i109 0.371556
Rw452 gnd__i24 gnd__i109 9
Rw453 gnd__i173 gnd__i196 0.0488889
Rw454 gnd__i175 gnd__i173 9
Rw455 gnd__i213 gnd__i173 0.0488889
Rw456 gnd__i118 gnd__i122 0.0488889
Rw457 gnd__i40 gnd__i122 9
Rw458 gnd__i197 gnd__i118 0.449778
Rw459 gnd__i40 gnd__i118 9
Rw460 gnd__i176 gnd__i197 0.0488889
Rw461 gnd__i178 gnd__i176 9
Rw462 gnd__i214 gnd__i176 0.0488889
Rw463 gnd__i119 gnd__i123 0.0488889
Rw464 gnd__i43 gnd__i123 9
Rw465 gnd__i198 gnd__i119 0.449778
Rw466 gnd__i43 gnd__i119 9
Rw467 gnd__i179 gnd__i198 0.0488889
Rw468 gnd__i181 gnd__i179 9
Rw469 gnd__i215 gnd__i179 0.0488889
Rw470 gnd__i120 gnd__i124 0.0488889
Rw471 gnd__i46 gnd__i124 9
Rw472 gnd__i199 gnd__i120 0.449778
Rw473 gnd__i46 gnd__i120 9
Rw474 gnd__i182 gnd__i199 0.0488889
Rw475 gnd__i184 gnd__i182 9
Rw476 gnd__i216 gnd__i182 0.0488889
Rw477 gnd__i185 gnd__i200 0.052291
Rw478 gnd__i187 gnd__i185 9
Rw479 gnd__i217 gnd__i185 0.0504461
Rw480 gnd__i137 gnd__i140 0.0488889
Rw481 gnd__i73 gnd__i140 9
Rw482 gnd__i133 gnd__i137 0.185778
Rw483 gnd__i73 gnd__i137 9
Rw484 gnd__i225 gnd__i223 9
Rw485 gnd__i248 gnd__i223 0.0488889
Rw486 gnd__i244 gnd__i248 0.0488889
Rw487 gnd__i138 gnd__i141 0.0488889
Rw488 gnd__i76 gnd__i141 9
Rw489 gnd__i134 gnd__i138 0.185778
Rw490 gnd__i76 gnd__i138 9
Rw491 gnd__i228 gnd__i226 9
Rw492 gnd__i249 gnd__i226 0.0488889
Rw493 gnd__i245 gnd__i249 0.0488889
Rw494 gnd__i139 gnd__i142 0.0488889
Rw495 gnd__i79 gnd__i142 9
Rw496 gnd__i229 gnd__i139 0.371556
Rw497 gnd__i79 gnd__i139 9
Rw498 gnd__i231 gnd__i229 9
Rw499 gnd__i250 gnd__i229 0.0488889
Rw500 gnd__i246 gnd__i250 0.0488889
Rw501 gnd__i128 gnd__i143 0.0488889
Rw502 gnd__i82 gnd__i143 9
Rw503 gnd__i232 gnd__i128 0.371556
Rw504 gnd__i82 gnd__i128 9
Rw505 gnd__i234 gnd__i232 9
Rw506 gnd__i251 gnd__i232 0.0488889
Rw507 gnd__i247 gnd__i251 0.0488889
Rw508 gnd__i129 gnd__i144 0.0488889
Rw509 gnd__i85 gnd__i144 9
Rw510 gnd__i235 gnd__i129 0.371556
Rw511 gnd__i85 gnd__i129 9
Rw512 gnd__i237 gnd__i235 9
Rw513 gnd__i252 gnd__i235 0.0488889
Rw514 gnd__i255 gnd__i252 0.0488889
Rw515 gnd__i130 gnd__i145 0.0488889
Rw516 gnd__i93 gnd__i145 9
Rw517 gnd__i238 gnd__i130 0.371556
Rw518 gnd__i93 gnd__i130 9
Rw519 gnd__i240 gnd__i238 9
Rw520 gnd__i253 gnd__i238 0.0488889
Rw521 gnd__i256 gnd__i253 0.0488889
Rw522 gnd__i241 gnd__i131 0.371556
Rw523 gnd__i96 gnd__i131 9
Rw524 gnd__i243 gnd__i241 9
Rw525 gnd__i254 gnd__i241 0.0488889
Rw526 gnd__i257 gnd__i254 0.0488889
Rw527 gnd__i151 gnd__i150 9
Rw528 gnd__i148 gnd__i150 0.0352
Rw529 gnd__i221 gnd__i220 9
Rw530 gnd__i222 gnd__i220 0.0352
Rw531 gnd__i136 gnd__i220 9
Rw532 gnd__i206 gnd__i189 9
Rw533 gnd__i153 gnd__i189 0.0275
Rw534 gnd__i152 gnd__i189 9
Rw535 gnd__i188 gnd__i153 9
Rw536 gnd__i155 gnd__i153 0.1485
Rw537 gnd__i206 gnd__i153 9
Rw538 gnd__i190 gnd__i155 9
Rw539 gnd__i207 gnd__i155 9
Rw540 gnd__i156 gnd__i155 0.0275
Rw541 gnd__i190 gnd__i156 9
Rw542 gnd__i158 gnd__i156 0.1485
Rw543 gnd__i207 gnd__i156 9
Rw544 gnd__i191 gnd__i158 9
Rw545 gnd__i208 gnd__i158 9
Rw546 gnd__i159 gnd__i158 0.0275
Rw547 gnd__i191 gnd__i159 9
Rw548 gnd__i161 gnd__i159 0.1485
Rw549 gnd__i208 gnd__i159 9
Rw550 gnd__i192 gnd__i161 9
Rw551 gnd__i209 gnd__i161 9
Rw552 gnd__i162 gnd__i161 0.0275
Rw553 gnd__i192 gnd__i162 9
Rw554 gnd__i163 gnd__i162 0.352
Rw555 gnd__i209 gnd__i162 9
Rw556 gnd__i165 gnd__i163 0.1485
Rw557 gnd__i193 gnd__i165 9
Rw558 gnd__i210 gnd__i165 9
Rw559 gnd__i166 gnd__i165 0.0275
Rw560 gnd__i193 gnd__i166 9
Rw561 gnd__i168 gnd__i166 0.1485
Rw562 gnd__i210 gnd__i166 9
Rw563 gnd__i194 gnd__i168 9
Rw564 gnd__i211 gnd__i168 9
Rw565 gnd__i169 gnd__i168 0.0275
Rw566 gnd__i194 gnd__i169 9
Rw567 gnd__i171 gnd__i169 0.1485
Rw568 gnd__i211 gnd__i169 9
Rw569 gnd__i195 gnd__i171 9
Rw570 gnd__i212 gnd__i171 9
Rw571 gnd__i172 gnd__i171 0.0275
Rw572 gnd__i195 gnd__i172 9
Rw573 gnd__i174 gnd__i172 0.1485
Rw574 gnd__i212 gnd__i172 9
Rw575 gnd__i196 gnd__i174 9
Rw576 gnd__i213 gnd__i174 9
Rw577 gnd__i175 gnd__i174 0.0275
Rw578 gnd__i196 gnd__i175 9
Rw579 gnd__i177 gnd__i175 0.1485
Rw580 gnd__i213 gnd__i175 9
Rw581 gnd__i197 gnd__i177 9
Rw582 gnd__i214 gnd__i177 9
Rw583 gnd__i178 gnd__i177 0.0275
Rw584 gnd__i197 gnd__i178 9
Rw585 gnd__i180 gnd__i178 0.1485
Rw586 gnd__i214 gnd__i178 9
Rw587 gnd__i198 gnd__i180 9
Rw588 gnd__i215 gnd__i180 9
Rw589 gnd__i181 gnd__i180 0.0275
Rw590 gnd__i198 gnd__i181 9
Rw591 gnd__i183 gnd__i181 0.1485
Rw592 gnd__i215 gnd__i181 9
Rw593 gnd__i199 gnd__i183 9
Rw594 gnd__i216 gnd__i183 9
Rw595 gnd__i184 gnd__i183 0.0275
Rw596 gnd__i199 gnd__i184 9
Rw597 gnd__i285 gnd__i184 0.132
Rw598 gnd__i216 gnd__i184 9
Rw599 gnd__i200 gnd__i186 9
Rw600 gnd__i217 gnd__i186 9
Rw601 gnd__i187 gnd__i186 0.0275
Rw602 gnd__i200 gnd__i187 9
Rw603 gnd__i224 gnd__i187 0.3245
Rw604 gnd__i217 gnd__i187 9
Rw605 gnd__i244 gnd__i224 9
Rw606 gnd__i248 gnd__i224 9
Rw607 gnd__i225 gnd__i224 0.0275
Rw608 gnd__i244 gnd__i225 9
Rw609 gnd__i227 gnd__i225 0.3245
Rw610 gnd__i248 gnd__i225 9
Rw611 gnd__i245 gnd__i227 9
Rw612 gnd__i249 gnd__i227 9
Rw613 gnd__i228 gnd__i227 0.0275
Rw614 gnd__i245 gnd__i228 9
Rw615 gnd__i230 gnd__i228 0.1485
Rw616 gnd__i249 gnd__i228 9
Rw617 gnd__i246 gnd__i230 9
Rw618 gnd__i250 gnd__i230 9
Rw619 gnd__i231 gnd__i230 0.0275
Rw620 gnd__i246 gnd__i231 9
Rw621 gnd__i233 gnd__i231 0.1485
Rw622 gnd__i250 gnd__i231 9
Rw623 gnd__i247 gnd__i233 9
Rw624 gnd__i251 gnd__i233 9
Rw625 gnd__i234 gnd__i233 0.0275
Rw626 gnd__i251 gnd__i234 9
Rw627 gnd__i236 gnd__i234 0.1485
Rw628 gnd__i247 gnd__i234 9
Rw629 gnd__i252 gnd__i236 9
Rw630 gnd__i255 gnd__i236 9
Rw631 gnd__i237 gnd__i236 0.0275
Rw632 gnd__i252 gnd__i237 9
Rw633 gnd__i239 gnd__i237 0.1485
Rw634 gnd__i255 gnd__i237 9
Rw635 gnd__i253 gnd__i239 9
Rw636 gnd__i256 gnd__i239 9
Rw637 gnd__i240 gnd__i239 0.0275
Rw638 gnd__i253 gnd__i240 9
Rw639 gnd__i242 gnd__i240 0.1485
Rw640 gnd__i256 gnd__i240 9
Rw641 gnd__i254 gnd__i242 9
Rw642 gnd__i257 gnd__i242 9
Rw643 gnd__i243 gnd__i242 0.0275
Rw644 gnd__i254 gnd__i243 9
Rw645 gnd__i257 gnd__i243 9
Rw646 gnd__i150 gnd__i149 9
Rw647 gnd__i151 gnd__i149 0.0352
Rw648 gnd__i1 gnd__p34 9.10676
Rw649 gnd__i2 gnd__p30 9.06632
Rw650 gnd__i3 gnd__p28 9.06632
Rw651 gnd__i4 gnd__p29 9.07441
Rw652 gnd__i5 gnd__p31 9.07441
Rw653 gnd__i6 gnd__i264 4.53823
Rw654 gnd__i9 gnd__i265 4.53823
Rw655 gnd__i12 gnd__p5 9.18301
Rw656 gnd__i13 gnd__i266 4.53823
Rw657 gnd__i16 gnd__i267 4.53823
Rw658 gnd__i19 gnd__i268 4.53823
Rw659 gnd__i22 gnd__i269 4.53823
Rw660 gnd__i25 gnd__p54 9.07441
Rw661 gnd__i26 gnd__p0 4.56519
Rw662 gnd__i27 gnd__p0 4.50634
Rw663 gnd__i28 gnd__i263 4.53823
Rw664 gnd__i38 gnd__i276 4.53823
Rw665 gnd__i41 gnd__i277 4.53823
Rw666 gnd__i44 gnd__i278 4.53823
Rw667 gnd__i47 gnd__i279 4.53823
Rw668 gnd__i55 gnd__i57 9.88
Rw669 gnd__i57 gnd__p38 9.10676
Rw670 gnd__i67 gnd__i66 10.32
Rw671 gnd__i71 gnd__i275 4.53823
Rw672 gnd__i74 gnd__i274 4.53823
Rw673 gnd__i77 gnd__i273 4.53823
Rw674 gnd__i80 gnd__i272 4.53823
Rw675 gnd__i83 gnd__i271 4.53823
Rw676 gnd__i86 gnd__i270 4.53823
Rw677 gnd__i94 gnd__i262 4.53823
Rw678 gnd__i100 gnd__p25 9.18301
Rw679 gnd__i105 gnd__i33 9.11
Rw680 gnd__i126 gnd__i282 9.73925
Rw681 gnd__i132 gnd__i97 9.11
Rw682 gnd__i201 gnd__i282 9.0179
Rw683 gnd__i222 gnd__i281 9.05721
Rw684 gnd__i67 gnd__p57 9.77841
Rw685 gnd__i33 gnd__p4 10.5828
Rw686 gnd__p36 gnd__i127 18.4183
Rw687 gnd__i57 gnd__p39 10.4068
Rw688 gnd__i65 gnd__i64 9.193
Rw689 gnd__i280 gnd__p47 10.135
Rw690 gnd__i280 gnd__p48 9.42641
Rw691 gnd__i135 gnd__p49 9.33776
Rw692 gnd__p44 gnd__i70 18.4814
Rw693 gnd__p15 gnd__i133 19.3728
Rw694 gnd__p17 gnd__i134 19.3728
Rw695 gnd__i148 gnd__i5 11.5062
Rw696 gnd__i283 gnd__i47 4.88373
Rw697 gnd__i151 gnd__p27 0.3872
Rw698 gnd gnd__i127 12.9781
Rw699 gnd__p59 gnd__i203 0.143
Rw700 gnd__p27 gnd__p26 19.4416
Rw701 gnd__i0 gnd__p32 18.9734
Rw702 gnd__i3 gnd__i4 21.8249
Rw703 gnd__p42 gnd__i70 31.6436
Rw704 gnd__i58 gnd__p51 20.2026
Rw705 gnd__p56 gnd__i66 36.5437
Rw706 gnd__p52 gnd__i58 36.919
Rw707 gnd__i125 gnd__p13 19.9694
Rw708 gnd__i127 gnd__i54 20.515
Rw709 gnd__p40 gnd__i56 36.9498
Rw710 gnd__p37 gnd__i54 37.1371
Rw711 gnd__i204 gnd__p43 27.8013
Rw712 gnd__p53 gnd__i59 36.7784
Rw713 gnd__i147 gnd__p24 18.8165
Rw714 gnd__i105 gnd__i163 3.89642
Rw715 gnd__i202 gnd__i282 9.08139
Rw716 gnd__i205 gnd__i60 27.5225
Rw717 gnd__p55 gnd__i126 10.1034
Rw718 gnd__p33 gnd__i0 19.7735
Rw719 gnd__i1 gnd__i218 31.3853
Rw720 gnd__i5 gnd__i2 38.7023
Rw721 gnd__p41 gnd__i56 38.1308
Rw722 gnd__i219 gnd__i69 24.5131
Rw723 gnd__i243 gnd__i132 4.24842
Rw724 gnd__i222 gnd__p50 27.5336
Rw725 gnd__p64 gnd__i260 0.489473
Rw726 gnd__p46 gnd__i69 36.8765
Rw727 gnd__i261 gnd__p45 27.986
Rw728 gnd__i2 gnd__i4 78.573
Rw729 gnd__i0 gnd__p65 117.533
Rw730 gnd__i3 gnd__i201 37.1062
Rw731 gnd__i203 gnd__i67 32.1376
Rw732 gnd__p35 gnd__i1 47.6434
Rw733 in0n in0n__p0 82.6931
Rw734 in0n in0n__p1 1227.08
Rw735 in0n__p0 in0n__p1 9.96983
Rw736 in0p in0p__p0 56.0628
Rw737 in0p in0p__p1 897.582
Rw738 in0p__p0 in0p__p1 9.95159
Rw739 in1n in1n__p0 39.2011
Rw740 in1n in1n__p1 611.146
Rw741 in1n__p0 in1n__p1 10.0607
Rw742 in1p in1p__p0 32.6056
Rw743 in1p in1p__p1 495.158
Rw744 in1p__p0 in1p__p1 10.1323
Rw745 lsb_n lsb_n__p1 19.536
Rw746 lsb_n lsb_n__p2 181.226
Rw747 lsb_n__p1 lsb_n__p2 184.36
Rw748 lsb_p lsb_p__p1 18.528
Rw749 lsb_p lsb_p__p2 144.514
Rw750 nr nr__p1 46.253
Rw751 on on__p0 3639.95
Rw752 on on__p1 3326.22
Rw753 on on__p2 781.288
Rw754 on on__p3 107.802
Rw755 on on__p4 123.815
Rw756 on on__p5 504.098
Rw757 on on__p6 571.955
Rw758 on__p0 on__p1 58.5448
Rw759 on__p0 on__p2 81.5711
Rw760 on__p0 on__p3 912.304
Rw761 on__p0 on__p4 1047.82
Rw762 on__p0 on__p5 661.584
Rw763 on__p0 on__p6 750.64
Rw764 on__p1 on__p2 74.5403
Rw765 on__p1 on__p3 833.67
Rw766 on__p1 on__p4 957.506
Rw767 on__p1 on__p5 604.56
Rw768 on__p1 on__p6 685.94
Rw769 on__p2 on__p3 195.819
Rw770 on__p2 on__p4 224.907
Rw771 on__p2 on__p5 142.004
Rw772 on__p2 on__p6 161.119
Rw773 on__p3 on__p4 27.9852
Rw774 on__p3 on__p5 126.345
Rw775 on__p3 on__p6 143.353
Rw776 on__p4 on__p5 145.113
Rw777 on__p4 on__p6 164.647
Rw778 on__p5 on__p6 80.7998
Rw779 onn onn__p0 447.627
Rw780 onn onn__p1 2855
Rw781 onn onn__p2 2783.32
Rw782 onn onn__p3 646.988
Rw783 onn onn__p4 388.804
Rw784 onn onn__p5 373.717
Rw785 onn onn__p6 75.3613
Rw786 onn__p0 onn__p1 4293.17
Rw787 onn__p0 onn__p2 4185.39
Rw788 onn__p0 onn__p3 972.901
Rw789 onn__p0 onn__p4 584.659
Rw790 onn__p0 onn__p5 561.972
Rw791 onn__p0 onn__p6 104.935
Rw792 onn__p1 onn__p2 58.2861
Rw793 onn__p1 onn__p3 76.9661
Rw794 onn__p1 onn__p4 509.747
Rw795 onn__p1 onn__p5 566.512
Rw796 onn__p1 onn__p6 722.787
Rw797 onn__p2 onn__p3 75.0339
Rw798 onn__p2 onn__p4 496.949
Rw799 onn__p2 onn__p5 552.29
Rw800 onn__p2 onn__p6 704.642
Rw801 onn__p3 onn__p4 115.517
Rw802 onn__p3 onn__p5 128.381
Rw803 onn__p3 onn__p6 163.795
Rw804 onn__p4 onn__p5 77.1497
Rw805 onn__p4 onn__p6 98.4318
Rw806 onn__p5 onn__p6 94.6122
Rw807 onp onp__p3 136.564
Rw808 onp onp__p4 171.79
Rw809 onp onp__p5 196.711
Rw810 onp__p0 onp__p5 261.417
Rw811 onp__p0 onp__p6 83.8305
Rw812 onp__p1 onp__p2 19.2467
Rw813 onp__p2 onp__p3 0.715378
Rw814 onp__p3 onp__p4 86.3558
Rw815 onp__p3 onp__p5 98.8832
Rw816 onp__p4 onp__p5 23.6139
Rw817 onp__p5 onp__p6 0.705438
Rw818 op op__p2 321.819
Rw819 op op__p3 107.43
Rw820 op op__p4 521.446
Rw821 op op__p5 602.952
Rw822 op__p0 op__p1 19.4601
Rw823 op__p1 op__p2 0.704
Rw824 op__p2 op__p3 63.9007
Rw825 op__p2 op__p4 310.163
Rw826 op__p2 op__p5 358.644
Rw827 op__p3 op__p4 82.7954
Rw828 op__p3 op__p5 95.7369
Rw829 op__p4 op__p5 23.5511
Rw830 op__p5 op__p6 0.704
Rw831 rstb rstb__p1 75.1695
Rw832 rstb rstb__p2 173.123
Rw833 rstb rstb__p3 143.056
Rw834 rstb__p1 rstb__p2 1076.35
Rw835 rstb__p1 rstb__p3 889.41
Rw836 rstb__p2 rstb__p3 22.003
Rw837 rstb_n rstb_n__p1 88.824
Rw838 rstb_n rstb_n__p3 101.63
Rw839 rstb_n rstb_n__p4 96.0304
Rw840 rstb_n__p1 rstb_n__p3 37.1031
Rw841 rstb_n__p1 rstb_n__p4 35.059
Rw842 rstb_n__p2 rstb_n__p3 0.6534
Rw843 rstb_n__p3 rstb_n__p4 30.359
Rw844 t0 t0__p1 61.1736
Rw845 t0 t0__p2 524.171
Rw846 t0 t0__p3 221.545
Rw847 t0 t0__p4 2404.38
Rw848 t0 t0__p5 1955.92
Rw849 t0__p1 t0__p2 191.093
Rw850 t0__p1 t0__p3 80.7669
Rw851 t0__p1 t0__p4 876.548
Rw852 t0__p1 t0__p5 713.054
Rw853 t0__p2 t0__p3 58.0329
Rw854 t0__p2 t0__p4 629.82
Rw855 t0__p2 t0__p5 512.346
Rw856 t0__p3 t0__p4 266.198
Rw857 t0__p3 t0__p5 216.547
Rw858 t0__p4 t0__p5 22.275
Rw859 t0b t0b__p1 22.217
Rw860 t0b t0b__p2 684.258
Rw861 t0b t0b__p3 690.866
Rw862 t0b t0b__p4 1456.78
Rw863 t0b t0b__p5 1588.32
Rw864 t0b t0b__p6 749.606
Rw865 t0b t0b__p7 1278.41
Rw866 t0b t0b__p8 1141.6
Rw867 t0b t0b__p9 625.272
Rw868 t0b__p1 t0b__p2 836.536
Rw869 t0b__p1 t0b__p3 844.615
Rw870 t0b__p1 t0b__p4 1780.98
Rw871 t0b__p1 t0b__p5 1941.79
Rw872 t0b__p1 t0b__p6 916.426
Rw873 t0b__p1 t0b__p7 1562.92
Rw874 t0b__p1 t0b__p8 1395.65
Rw875 t0b__p1 t0b__p9 764.423
Rw876 t0b__p2 t0b__p3 44.5935
Rw877 t0b__p2 t0b__p4 1650.72
Rw878 t0b__p2 t0b__p5 1799.78
Rw879 t0b__p2 t0b__p6 849.403
Rw880 t0b__p2 t0b__p7 1448.61
Rw881 t0b__p2 t0b__p8 1293.58
Rw882 t0b__p2 t0b__p9 708.517
Rw883 t0b__p3 t0b__p4 1666.66
Rw884 t0b__p3 t0b__p5 1817.16
Rw885 t0b__p3 t0b__p6 857.606
Rw886 t0b__p3 t0b__p7 1462.6
Rw887 t0b__p3 t0b__p8 1306.07
Rw888 t0b__p3 t0b__p9 715.359
Rw889 t0b__p4 t0b__p5 36.997
Rw890 t0b__p4 t0b__p6 310.823
Rw891 t0b__p4 t0b__p7 50.2178
Rw892 t0b__p4 t0b__p8 44.8434
Rw893 t0b__p4 t0b__p9 259.268
Rw894 t0b__p5 t0b__p6 338.889
Rw895 t0b__p5 t0b__p7 54.7523
Rw896 t0b__p5 t0b__p8 48.8926
Rw897 t0b__p5 t0b__p9 282.679
Rw898 t0b__p6 t0b__p7 272.766
Rw899 t0b__p6 t0b__p8 243.574
Rw900 t0b__p6 t0b__p9 25.4641
Rw901 t0b__p7 t0b__p8 39.3529
Rw902 t0b__p7 t0b__p9 227.524
Rw903 t0b__p8 t0b__p9 203.174
Rw904 t1 t1__p1 42.352
Rw905 t1__p1 t1__p2 75.4964
Rw906 t1__p1 t1__p3 30.0968
Rw907 t1__p1 t1__p4 815.866
Rw908 t1__p1 t1__p5 1010.95
Rw909 t1__p2 t1__p3 73.4475
Rw910 t1__p2 t1__p4 448.225
Rw911 t1__p2 t1__p5 555.403
Rw912 t1__p3 t1__p4 793.724
Rw913 t1__p3 t1__p5 983.516
Rw914 t1__p4 t1__p5 21.5172
Rw915 t1b t1b__p1 38.0261
Rw916 t1b t1b__p2 8.01964
Rw917 t1b t1b__p3 744.859
Rw918 t1b t1b__p5 1205.34
Rw919 t1b t1b__p6 402.674
Rw920 t1b t1b__p7 376.346
Rw921 t1b t1b__p8 322.534
Rw922 t1b t1b__p9 319.508
Rw923 t1b__p2 t1b__p3 41.2326
Rw924 t1b__p2 t1b__p5 12943.2
Rw925 t1b__p2 t1b__p6 4324.03
Rw926 t1b__p2 t1b__p7 4041.32
Rw927 t1b__p2 t1b__p8 3463.46
Rw928 t1b__p2 t1b__p9 3430.97
Rw929 t1b__p3 t1b__p6 401613
Rw930 t1b__p3 t1b__p7 375355
Rw931 t1b__p3 t1b__p8 321684
Rw932 t1b__p3 t1b__p9 318666
Rw933 t1b__p4 t1b__p5 1.26262
Rw934 t1b__p5 t1b__p6 68.905
Rw935 t1b__p5 t1b__p7 534.236
Rw936 t1b__p5 t1b__p8 457.847
Rw937 t1b__p5 t1b__p9 88.2376
Rw938 t1b__p6 t1b__p7 178.475
Rw939 t1b__p6 t1b__p8 152.956
Rw940 t1b__p6 t1b__p9 29.4781
Rw941 t1b__p7 t1b__p8 24.3938
Rw942 t1b__p7 t1b__p9 141.614
Rw943 t1b__p8 t1b__p9 121.365
Rw944 top_n top_n__p1 0.001
Rw945 top_n top_n__p2 0.001
Rw946 top_n__p1 top_n__p3 86.378
Rw947 top_n__p1 top_n__p4 92.5143
Rw948 top_n__p3 top_n__p4 49.7283
Rw949 top_p top_p__p1 0.001
Rw950 top_p top_p__p2 0.001
Rw951 top_p__p1 top_p__p3 31.4987
Rw952 top_p__p1 top_p__p4 78.6746
Rw953 top_p__p3 top_p__p4 154.812
Rw954 trk0 trk0__p0 193.087
Rw955 trk0 trk0__p1 162.475
Rw956 trk0__p0 trk0__p1 21.6899
Rw957 trk1 trk1__p1 90.2279
Rw958 trk1__p0 trk1__p1 19.7769
Rw959 vdd vdd__p0 376.714
Rw960 vdd vdd__p10 39269.7
Rw961 vdd vdd__p11 44021
Rw962 vdd vdd__p12 70.9644
Rw963 vdd vdd__p13 58.291
Rw964 vdd vdd__p14 58.9746
Rw965 vdd vdd__p15 27.2346
Rw966 vdd vdd__p16 60.6194
Rw967 vdd vdd__p17 50.1746
Rw968 vdd vdd__p18 66.9272
Rw969 vdd vdd__p19 2090.62
Rw970 vdd vdd__p2 289.579
Rw971 vdd vdd__p20 1878.11
Rw972 vdd vdd__p21 1805.31
Rw973 vdd vdd__p22 4175.44
Rw974 vdd vdd__p24 1735.42
Rw975 vdd vdd__p25 488704
Rw976 vdd vdd__p26 82.1222
Rw977 vdd vdd__p27 86.3291
Rw978 vdd vdd__p28 94.1592
Rw979 vdd vdd__p29 116.62
Rw980 vdd vdd__p3 848.539
Rw981 vdd vdd__p30 125.406
Rw982 vdd vdd__p31 135.55
Rw983 vdd vdd__p32 145.915
Rw984 vdd vdd__p33 155.336
Rw985 vdd vdd__p34 167.627
Rw986 vdd vdd__p36 9.51776
Rw987 vdd vdd__p37 38.2598
Rw988 vdd vdd__p38 68.8796
Rw989 vdd vdd__p4 3553.75
Rw990 vdd vdd__p5 784.482
Rw991 vdd vdd__p6 24020.9
Rw992 vdd vdd__p7 15800.1
Rw993 vdd vdd__p8 2306.76
Rw994 vdd vdd__p9 29869.1
Rw995 vdd__p0 vdd__p1 30.4213
Rw996 vdd__p0 vdd__p12 338.995
Rw997 vdd__p0 vdd__p13 5394.62
Rw998 vdd__p0 vdd__p14 6050.52
Rw999 vdd__p0 vdd__p15 7363.66
Rw1000 vdd__p0 vdd__p16 6960.47
Rw1001 vdd__p0 vdd__p17 26183.8
Rw1002 vdd__p0 vdd__p18 7684.74
Rw1003 vdd__p0 vdd__p19 240050
Rw1004 vdd__p0 vdd__p2 216.082
Rw1005 vdd__p0 vdd__p20 215650
Rw1006 vdd__p0 vdd__p21 207290
Rw1007 vdd__p0 vdd__p22 479435
Rw1008 vdd__p0 vdd__p24 199265
Rw1009 vdd__p0 vdd__p26 9429.47
Rw1010 vdd__p0 vdd__p27 9912.51
Rw1011 vdd__p0 vdd__p28 10811.6
Rw1012 vdd__p0 vdd__p29 13390.6
Rw1013 vdd__p0 vdd__p3 661.698
Rw1014 vdd__p0 vdd__p30 14399.4
Rw1015 vdd__p0 vdd__p31 15564.2
Rw1016 vdd__p0 vdd__p32 16754.4
Rw1017 vdd__p0 vdd__p33 17836.1
Rw1018 vdd__p0 vdd__p34 19247.3
Rw1019 vdd__p0 vdd__p36 1092.85
Rw1020 vdd__p0 vdd__p37 4393.08
Rw1021 vdd__p0 vdd__p38 7908.93
Rw1022 vdd__p0 vdd__p4 2771.25
Rw1023 vdd__p0 vdd__p5 611.746
Rw1024 vdd__p0 vdd__p8 264868
Rw1025 vdd__p10 vdd__p11 164.289
Rw1026 vdd__p10 vdd__p12 849404
Rw1027 vdd__p10 vdd__p13 697710
Rw1028 vdd__p10 vdd__p14 705892
Rw1029 vdd__p10 vdd__p15 767610
Rw1030 vdd__p10 vdd__p16 645645
Rw1031 vdd__p10 vdd__p18 567737
Rw1032 vdd__p10 vdd__p19 54790.1
Rw1033 vdd__p10 vdd__p20 49220.9
Rw1034 vdd__p10 vdd__p21 43688.9
Rw1035 vdd__p10 vdd__p22 492437
Rw1036 vdd__p10 vdd__p24 204669
Rw1037 vdd__p10 vdd__p26 447454
Rw1038 vdd__p10 vdd__p27 432781
Rw1039 vdd__p10 vdd__p28 422244
Rw1040 vdd__p10 vdd__p29 341527
Rw1041 vdd__p10 vdd__p30 326197
Rw1042 vdd__p10 vdd__p31 312294
Rw1043 vdd__p10 vdd__p32 296862
Rw1044 vdd__p10 vdd__p33 278149
Rw1045 vdd__p10 vdd__p34 263260
Rw1046 vdd__p10 vdd__p36 14947.8
Rw1047 vdd__p10 vdd__p37 3243.45
Rw1048 vdd__p10 vdd__p38 1666.9
Rw1049 vdd__p10 vdd__p6 813.556
Rw1050 vdd__p10 vdd__p7 535.128
Rw1051 vdd__p10 vdd__p8 292.768
Rw1052 vdd__p10 vdd__p9 62.4771
Rw1053 vdd__p11 vdd__p12 952173
Rw1054 vdd__p11 vdd__p13 782126
Rw1055 vdd__p11 vdd__p14 791298
Rw1056 vdd__p11 vdd__p15 860483
Rw1057 vdd__p11 vdd__p16 723762
Rw1058 vdd__p11 vdd__p18 636428
Rw1059 vdd__p11 vdd__p19 61419.2
Rw1060 vdd__p11 vdd__p20 55176.1
Rw1061 vdd__p11 vdd__p21 48974.9
Rw1062 vdd__p11 vdd__p22 552017
Rw1063 vdd__p11 vdd__p24 229432
Rw1064 vdd__p11 vdd__p26 501591
Rw1065 vdd__p11 vdd__p27 485144
Rw1066 vdd__p11 vdd__p28 473332
Rw1067 vdd__p11 vdd__p29 382849
Rw1068 vdd__p11 vdd__p30 365664
Rw1069 vdd__p11 vdd__p31 350079
Rw1070 vdd__p11 vdd__p32 332779
Rw1071 vdd__p11 vdd__p33 311802
Rw1072 vdd__p11 vdd__p34 295112
Rw1073 vdd__p11 vdd__p36 16756.3
Rw1074 vdd__p11 vdd__p37 3635.87
Rw1075 vdd__p11 vdd__p38 1868.58
Rw1076 vdd__p11 vdd__p6 911.989
Rw1077 vdd__p11 vdd__p7 599.873
Rw1078 vdd__p11 vdd__p8 328.19
Rw1079 vdd__p11 vdd__p9 124.961
Rw1080 vdd__p12 vdd__p13 1016.23
Rw1081 vdd__p12 vdd__p14 1139.78
Rw1082 vdd__p12 vdd__p15 1387.15
Rw1083 vdd__p12 vdd__p16 1311.2
Rw1084 vdd__p12 vdd__p17 4932.43
Rw1085 vdd__p12 vdd__p18 1447.63
Rw1086 vdd__p12 vdd__p19 45220
Rw1087 vdd__p12 vdd__p2 260.585
Rw1088 vdd__p12 vdd__p20 40623.6
Rw1089 vdd__p12 vdd__p21 39048.8
Rw1090 vdd__p12 vdd__p22 90314.8
Rw1091 vdd__p12 vdd__p24 37537.1
Rw1092 vdd__p12 vdd__p26 1776.3
Rw1093 vdd__p12 vdd__p27 1867.3
Rw1094 vdd__p12 vdd__p28 2036.66
Rw1095 vdd__p12 vdd__p29 2522.49
Rw1096 vdd__p12 vdd__p3 763.578
Rw1097 vdd__p12 vdd__p30 2712.52
Rw1098 vdd__p12 vdd__p31 2931.95
Rw1099 vdd__p12 vdd__p32 3156.15
Rw1100 vdd__p12 vdd__p33 3359.91
Rw1101 vdd__p12 vdd__p34 3625.77
Rw1102 vdd__p12 vdd__p36 205.869
Rw1103 vdd__p12 vdd__p37 827.558
Rw1104 vdd__p12 vdd__p38 1489.87
Rw1105 vdd__p12 vdd__p4 3197.93
Rw1106 vdd__p12 vdd__p5 705.935
Rw1107 vdd__p12 vdd__p6 519572
Rw1108 vdd__p12 vdd__p7 341755
Rw1109 vdd__p12 vdd__p8 49895.2
Rw1110 vdd__p12 vdd__p9 646067
Rw1111 vdd__p13 vdd__p14 936.231
Rw1112 vdd__p13 vdd__p15 1139.42
Rw1113 vdd__p13 vdd__p16 1077.03
Rw1114 vdd__p13 vdd__p17 4051.56
Rw1115 vdd__p13 vdd__p18 1189.1
Rw1116 vdd__p13 vdd__p19 37144.2
Rw1117 vdd__p13 vdd__p2 4146.84
Rw1118 vdd__p13 vdd__p20 33368.7
Rw1119 vdd__p13 vdd__p21 32075.1
Rw1120 vdd__p13 vdd__p22 74185.6
Rw1121 vdd__p13 vdd__p24 30833.4
Rw1122 vdd__p13 vdd__p26 1459.07
Rw1123 vdd__p13 vdd__p27 1533.82
Rw1124 vdd__p13 vdd__p28 1672.94
Rw1125 vdd__p13 vdd__p29 2072
Rw1126 vdd__p13 vdd__p3 12151.3
Rw1127 vdd__p13 vdd__p30 2228.1
Rw1128 vdd__p13 vdd__p31 2408.34
Rw1129 vdd__p13 vdd__p32 2592.5
Rw1130 vdd__p13 vdd__p33 2759.87
Rw1131 vdd__p13 vdd__p34 2978.25
Rw1132 vdd__p13 vdd__p36 169.103
Rw1133 vdd__p13 vdd__p37 679.766
Rw1134 vdd__p13 vdd__p38 1223.79
Rw1135 vdd__p13 vdd__p4 50890.5
Rw1136 vdd__p13 vdd__p5 11234
Rw1137 vdd__p13 vdd__p6 426782
Rw1138 vdd__p13 vdd__p7 280722
Rw1139 vdd__p13 vdd__p8 40984.5
Rw1140 vdd__p13 vdd__p9 530687
Rw1141 vdd__p14 vdd__p15 1152.78
Rw1142 vdd__p14 vdd__p16 1089.66
Rw1143 vdd__p14 vdd__p17 4099.07
Rw1144 vdd__p14 vdd__p18 1203.05
Rw1145 vdd__p14 vdd__p19 37579.8
Rw1146 vdd__p14 vdd__p2 4651.03
Rw1147 vdd__p14 vdd__p20 33760
Rw1148 vdd__p14 vdd__p21 32451.3
Rw1149 vdd__p14 vdd__p22 75055.6
Rw1150 vdd__p14 vdd__p24 31195
Rw1151 vdd__p14 vdd__p26 1476.19
Rw1152 vdd__p14 vdd__p27 1551.81
Rw1153 vdd__p14 vdd__p28 1692.56
Rw1154 vdd__p14 vdd__p29 2096.3
Rw1155 vdd__p14 vdd__p3 13628.7
Rw1156 vdd__p14 vdd__p30 2254.23
Rw1157 vdd__p14 vdd__p31 2436.58
Rw1158 vdd__p14 vdd__p32 2622.9
Rw1159 vdd__p14 vdd__p33 2792.24
Rw1160 vdd__p14 vdd__p34 3013.17
Rw1161 vdd__p14 vdd__p36 171.086
Rw1162 vdd__p14 vdd__p37 687.737
Rw1163 vdd__p14 vdd__p38 1238.14
Rw1164 vdd__p14 vdd__p4 57078
Rw1165 vdd__p14 vdd__p5 12599.8
Rw1166 vdd__p14 vdd__p6 431787
Rw1167 vdd__p14 vdd__p7 284014
Rw1168 vdd__p14 vdd__p8 41465.1
Rw1169 vdd__p14 vdd__p9 536910
Rw1170 vdd__p15 vdd__p16 1184.93
Rw1171 vdd__p15 vdd__p17 1892.96
Rw1172 vdd__p15 vdd__p18 1308.23
Rw1173 vdd__p15 vdd__p19 40865.5
Rw1174 vdd__p15 vdd__p2 5660.44
Rw1175 vdd__p15 vdd__p20 36711.7
Rw1176 vdd__p15 vdd__p21 35288.6
Rw1177 vdd__p15 vdd__p22 81617.8
Rw1178 vdd__p15 vdd__p24 33922.4
Rw1179 vdd__p15 vdd__p26 1605.25
Rw1180 vdd__p15 vdd__p27 1687.48
Rw1181 vdd__p15 vdd__p28 1840.54
Rw1182 vdd__p15 vdd__p29 2279.58
Rw1183 vdd__p15 vdd__p3 16586.5
Rw1184 vdd__p15 vdd__p30 2451.32
Rw1185 vdd__p15 vdd__p31 2649.62
Rw1186 vdd__p15 vdd__p32 2852.23
Rw1187 vdd__p15 vdd__p33 3036.37
Rw1188 vdd__p15 vdd__p34 3276.62
Rw1189 vdd__p15 vdd__p36 186.045
Rw1190 vdd__p15 vdd__p37 747.868
Rw1191 vdd__p15 vdd__p38 1346.4
Rw1192 vdd__p15 vdd__p4 69465.6
Rw1193 vdd__p15 vdd__p5 15334.4
Rw1194 vdd__p15 vdd__p6 469539
Rw1195 vdd__p15 vdd__p7 308846
Rw1196 vdd__p15 vdd__p8 45090.5
Rw1197 vdd__p15 vdd__p9 583854
Rw1198 vdd__p16 vdd__p17 4213.4
Rw1199 vdd__p16 vdd__p18 1100.37
Rw1200 vdd__p16 vdd__p19 34372.4
Rw1201 vdd__p16 vdd__p2 5350.51
Rw1202 vdd__p16 vdd__p20 30878.6
Rw1203 vdd__p16 vdd__p21 29681.6
Rw1204 vdd__p16 vdd__p22 68649.7
Rw1205 vdd__p16 vdd__p24 28532.5
Rw1206 vdd__p16 vdd__p26 1350.19
Rw1207 vdd__p16 vdd__p27 1419.36
Rw1208 vdd__p16 vdd__p28 1548.1
Rw1209 vdd__p16 vdd__p29 1917.38
Rw1210 vdd__p16 vdd__p3 15678.3
Rw1211 vdd__p16 vdd__p30 2061.83
Rw1212 vdd__p16 vdd__p31 2228.62
Rw1213 vdd__p16 vdd__p32 2399.04
Rw1214 vdd__p16 vdd__p33 2553.92
Rw1215 vdd__p16 vdd__p34 2756
Rw1216 vdd__p16 vdd__p36 156.484
Rw1217 vdd__p16 vdd__p37 629.04
Rw1218 vdd__p16 vdd__p38 1132.47
Rw1219 vdd__p16 vdd__p4 65662.1
Rw1220 vdd__p16 vdd__p5 14494.7
Rw1221 vdd__p16 vdd__p6 394934
Rw1222 vdd__p16 vdd__p7 259773
Rw1223 vdd__p16 vdd__p8 37926.1
Rw1224 vdd__p16 vdd__p9 491086
Rw1225 vdd__p17 vdd__p18 4651.82
Rw1226 vdd__p17 vdd__p19 145310
Rw1227 vdd__p17 vdd__p2 20127.4
Rw1228 vdd__p17 vdd__p20 130540
Rw1229 vdd__p17 vdd__p21 125479
Rw1230 vdd__p17 vdd__p22 290217
Rw1231 vdd__p17 vdd__p24 120622
Rw1232 vdd__p17 vdd__p26 5707.97
Rw1233 vdd__p17 vdd__p27 6000.36
Rw1234 vdd__p17 vdd__p28 6544.61
Rw1235 vdd__p17 vdd__p29 8105.76
Rw1236 vdd__p17 vdd__p3 58978.3
Rw1237 vdd__p17 vdd__p30 8716.42
Rw1238 vdd__p17 vdd__p31 9421.53
Rw1239 vdd__p17 vdd__p32 10142
Rw1240 vdd__p17 vdd__p33 10796.7
Rw1241 vdd__p17 vdd__p34 11651
Rw1242 vdd__p17 vdd__p36 661.539
Rw1243 vdd__p17 vdd__p37 2659.27
Rw1244 vdd__p17 vdd__p38 4787.53
Rw1245 vdd__p17 vdd__p4 247006
Rw1246 vdd__p17 vdd__p5 54526
Rw1247 vdd__p17 vdd__p8 160333
Rw1248 vdd__p18 vdd__p19 30224.8
Rw1249 vdd__p18 vdd__p2 5907.25
Rw1250 vdd__p18 vdd__p20 27152.6
Rw1251 vdd__p18 vdd__p21 26100
Rw1252 vdd__p18 vdd__p22 60365.9
Rw1253 vdd__p18 vdd__p24 25089.6
Rw1254 vdd__p18 vdd__p26 1187.27
Rw1255 vdd__p18 vdd__p27 1248.09
Rw1256 vdd__p18 vdd__p28 1361.3
Rw1257 vdd__p18 vdd__p29 1686.02
Rw1258 vdd__p18 vdd__p3 17309.7
Rw1259 vdd__p18 vdd__p30 1813.04
Rw1260 vdd__p18 vdd__p31 1959.7
Rw1261 vdd__p18 vdd__p32 2109.55
Rw1262 vdd__p18 vdd__p33 2245.75
Rw1263 vdd__p18 vdd__p34 2423.44
Rw1264 vdd__p18 vdd__p36 137.602
Rw1265 vdd__p18 vdd__p37 553.136
Rw1266 vdd__p18 vdd__p38 995.819
Rw1267 vdd__p18 vdd__p4 72494.5
Rw1268 vdd__p18 vdd__p5 16003
Rw1269 vdd__p18 vdd__p6 347279
Rw1270 vdd__p18 vdd__p7 228427
Rw1271 vdd__p18 vdd__p8 33349.7
Rw1272 vdd__p18 vdd__p9 431828
Rw1273 vdd__p19 vdd__p2 184526
Rw1274 vdd__p19 vdd__p20 25.1454
Rw1275 vdd__p19 vdd__p21 2518.81
Rw1276 vdd__p19 vdd__p22 26216.1
Rw1277 vdd__p19 vdd__p24 10896.1
Rw1278 vdd__p19 vdd__p26 23821.3
Rw1279 vdd__p19 vdd__p27 23040.1
Rw1280 vdd__p19 vdd__p28 22479.2
Rw1281 vdd__p19 vdd__p29 18182
Rw1282 vdd__p19 vdd__p3 540707
Rw1283 vdd__p19 vdd__p30 17365.9
Rw1284 vdd__p19 vdd__p31 16625.7
Rw1285 vdd__p19 vdd__p32 15804.1
Rw1286 vdd__p19 vdd__p33 14807.9
Rw1287 vdd__p19 vdd__p34 14015.3
Rw1288 vdd__p19 vdd__p36 795.78
Rw1289 vdd__p19 vdd__p37 172.673
Rw1290 vdd__p19 vdd__p38 96.1026
Rw1291 vdd__p19 vdd__p5 499889
Rw1292 vdd__p19 vdd__p6 33514.5
Rw1293 vdd__p19 vdd__p7 22044.6
Rw1294 vdd__p19 vdd__p8 3218.45
Rw1295 vdd__p19 vdd__p9 41674
Rw1296 vdd__p2 vdd__p20 165770
Rw1297 vdd__p2 vdd__p21 159344
Rw1298 vdd__p2 vdd__p22 368541
Rw1299 vdd__p2 vdd__p24 153175
Rw1300 vdd__p2 vdd__p26 7248.43
Rw1301 vdd__p2 vdd__p27 7619.74
Rw1302 vdd__p2 vdd__p28 8310.86
Rw1303 vdd__p2 vdd__p29 10293.3
Rw1304 vdd__p2 vdd__p3 508.647
Rw1305 vdd__p2 vdd__p30 11068.8
Rw1306 vdd__p2 vdd__p31 11964.2
Rw1307 vdd__p2 vdd__p32 12879.1
Rw1308 vdd__p2 vdd__p33 13710.6
Rw1309 vdd__p2 vdd__p34 14795.4
Rw1310 vdd__p2 vdd__p36 840.074
Rw1311 vdd__p2 vdd__p37 3376.96
Rw1312 vdd__p2 vdd__p38 6079.58
Rw1313 vdd__p2 vdd__p4 2130.26
Rw1314 vdd__p2 vdd__p5 470.249
Rw1315 vdd__p2 vdd__p8 203604
Rw1316 vdd__p20 vdd__p21 2262.78
Rw1317 vdd__p20 vdd__p22 23551.3
Rw1318 vdd__p20 vdd__p24 9788.51
Rw1319 vdd__p20 vdd__p26 21399.9
Rw1320 vdd__p20 vdd__p27 20698.2
Rw1321 vdd__p20 vdd__p28 20194.3
Rw1322 vdd__p20 vdd__p29 16333.9
Rw1323 vdd__p20 vdd__p3 485746
Rw1324 vdd__p20 vdd__p30 15600.7
Rw1325 vdd__p20 vdd__p31 14935.8
Rw1326 vdd__p20 vdd__p32 14197.7
Rw1327 vdd__p20 vdd__p33 13302.8
Rw1328 vdd__p20 vdd__p34 12590.7
Rw1329 vdd__p20 vdd__p36 714.892
Rw1330 vdd__p20 vdd__p37 155.121
Rw1331 vdd__p20 vdd__p38 86.3341
Rw1332 vdd__p20 vdd__p5 449077
Rw1333 vdd__p20 vdd__p6 30107.9
Rw1334 vdd__p20 vdd__p7 19803.9
Rw1335 vdd__p20 vdd__p8 2891.3
Rw1336 vdd__p20 vdd__p9 37438
Rw1337 vdd__p21 vdd__p22 22638.3
Rw1338 vdd__p21 vdd__p24 9409.06
Rw1339 vdd__p21 vdd__p26 20570.4
Rw1340 vdd__p21 vdd__p27 19895.8
Rw1341 vdd__p21 vdd__p28 19411.4
Rw1342 vdd__p21 vdd__p29 15700.7
Rw1343 vdd__p21 vdd__p3 466916
Rw1344 vdd__p21 vdd__p30 14996
Rw1345 vdd__p21 vdd__p31 14356.8
Rw1346 vdd__p21 vdd__p32 13647.3
Rw1347 vdd__p21 vdd__p33 12787.1
Rw1348 vdd__p21 vdd__p34 12102.6
Rw1349 vdd__p21 vdd__p36 687.18
Rw1350 vdd__p21 vdd__p37 149.108
Rw1351 vdd__p21 vdd__p38 23.9487
Rw1352 vdd__p21 vdd__p5 431668
Rw1353 vdd__p21 vdd__p6 26724.1
Rw1354 vdd__p21 vdd__p7 17578.1
Rw1355 vdd__p21 vdd__p8 2566.35
Rw1356 vdd__p21 vdd__p9 33230.4
Rw1357 vdd__p22 vdd__p23 38.5317
Rw1358 vdd__p22 vdd__p24 80.4662
Rw1359 vdd__p22 vdd__p25 22659.7
Rw1360 vdd__p22 vdd__p26 47576.5
Rw1361 vdd__p22 vdd__p27 46016.5
Rw1362 vdd__p22 vdd__p28 44896.1
Rw1363 vdd__p22 vdd__p29 36313.7
Rw1364 vdd__p22 vdd__p30 34683.7
Rw1365 vdd__p22 vdd__p31 33205.4
Rw1366 vdd__p22 vdd__p32 31564.5
Rw1367 vdd__p22 vdd__p33 29574.8
Rw1368 vdd__p22 vdd__p34 27991.8
Rw1369 vdd__p22 vdd__p36 1589.36
Rw1370 vdd__p22 vdd__p37 479.772
Rw1371 vdd__p22 vdd__p38 863.741
Rw1372 vdd__p22 vdd__p5 998392
Rw1373 vdd__p22 vdd__p6 301219
Rw1374 vdd__p22 vdd__p7 198131
Rw1375 vdd__p22 vdd__p8 28926.5
Rw1376 vdd__p22 vdd__p9 374554
Rw1377 vdd__p24 vdd__p25 38.6225
Rw1378 vdd__p24 vdd__p26 19774
Rw1379 vdd__p24 vdd__p27 19125.6
Rw1380 vdd__p24 vdd__p28 18659.9
Rw1381 vdd__p24 vdd__p29 15092.9
Rw1382 vdd__p24 vdd__p3 448840
Rw1383 vdd__p24 vdd__p30 14415.4
Rw1384 vdd__p24 vdd__p31 13801
Rw1385 vdd__p24 vdd__p32 13119
Rw1386 vdd__p24 vdd__p33 12292
Rw1387 vdd__p24 vdd__p34 11634.1
Rw1388 vdd__p24 vdd__p36 660.576
Rw1389 vdd__p24 vdd__p37 199.405
Rw1390 vdd__p24 vdd__p38 358.993
Rw1391 vdd__p24 vdd__p5 414957
Rw1392 vdd__p24 vdd__p6 125194
Rw1393 vdd__p24 vdd__p7 82348.1
Rw1394 vdd__p24 vdd__p8 12022.6
Rw1395 vdd__p24 vdd__p9 155674
Rw1396 vdd__p25 vdd__p36 186022
Rw1397 vdd__p25 vdd__p37 56153.7
Rw1398 vdd__p25 vdd__p38 101094
Rw1399 vdd__p26 vdd__p27 983.665
Rw1400 vdd__p26 vdd__p28 1072.89
Rw1401 vdd__p26 vdd__p29 1328.81
Rw1402 vdd__p26 vdd__p3 21239.7
Rw1403 vdd__p26 vdd__p30 1428.92
Rw1404 vdd__p26 vdd__p31 1544.51
Rw1405 vdd__p26 vdd__p32 1662.61
Rw1406 vdd__p26 vdd__p33 1769.96
Rw1407 vdd__p26 vdd__p34 1910
Rw1408 vdd__p26 vdd__p36 108.449
Rw1409 vdd__p26 vdd__p37 435.946
Rw1410 vdd__p26 vdd__p38 784.84
Rw1411 vdd__p26 vdd__p4 88953.6
Rw1412 vdd__p26 vdd__p5 19636.3
Rw1413 vdd__p26 vdd__p6 273703
Rw1414 vdd__p26 vdd__p7 180032
Rw1415 vdd__p26 vdd__p8 26284.1
Rw1416 vdd__p26 vdd__p9 340339
Rw1417 vdd__p27 vdd__p28 1037.7
Rw1418 vdd__p27 vdd__p29 1285.24
Rw1419 vdd__p27 vdd__p3 22327.7
Rw1420 vdd__p27 vdd__p30 1382.06
Rw1421 vdd__p27 vdd__p31 1493.87
Rw1422 vdd__p27 vdd__p32 1608.1
Rw1423 vdd__p27 vdd__p33 1711.92
Rw1424 vdd__p27 vdd__p34 1847.37
Rw1425 vdd__p27 vdd__p36 104.893
Rw1426 vdd__p27 vdd__p37 421.651
Rw1427 vdd__p27 vdd__p38 759.104
Rw1428 vdd__p27 vdd__p4 93510.4
Rw1429 vdd__p27 vdd__p5 20642.2
Rw1430 vdd__p27 vdd__p6 264728
Rw1431 vdd__p27 vdd__p7 174128
Rw1432 vdd__p27 vdd__p8 25422.2
Rw1433 vdd__p27 vdd__p9 329179
Rw1434 vdd__p28 vdd__p29 1253.95
Rw1435 vdd__p28 vdd__p3 24352.9
Rw1436 vdd__p28 vdd__p30 1348.41
Rw1437 vdd__p28 vdd__p31 1457.49
Rw1438 vdd__p28 vdd__p32 1568.94
Rw1439 vdd__p28 vdd__p33 1670.24
Rw1440 vdd__p28 vdd__p34 1802.39
Rw1441 vdd__p28 vdd__p36 102.339
Rw1442 vdd__p28 vdd__p37 411.385
Rw1443 vdd__p28 vdd__p38 740.622
Rw1444 vdd__p28 vdd__p4 101992
Rw1445 vdd__p28 vdd__p5 22514.5
Rw1446 vdd__p28 vdd__p6 258283
Rw1447 vdd__p28 vdd__p7 169889
Rw1448 vdd__p28 vdd__p8 24803.2
Rw1449 vdd__p28 vdd__p9 321164
Rw1450 vdd__p29 vdd__p3 30162
Rw1451 vdd__p29 vdd__p30 1090.65
Rw1452 vdd__p29 vdd__p31 1178.88
Rw1453 vdd__p29 vdd__p32 1269.02
Rw1454 vdd__p29 vdd__p33 1350.95
Rw1455 vdd__p29 vdd__p34 1457.84
Rw1456 vdd__p29 vdd__p36 82.7756
Rw1457 vdd__p29 vdd__p37 332.744
Rw1458 vdd__p29 vdd__p38 599.044
Rw1459 vdd__p29 vdd__p4 126321
Rw1460 vdd__p29 vdd__p5 27885.1
Rw1461 vdd__p29 vdd__p6 208909
Rw1462 vdd__p29 vdd__p7 137413
Rw1463 vdd__p29 vdd__p8 20061.8
Rw1464 vdd__p29 vdd__p9 259770
Rw1465 vdd__p3 vdd__p30 32434.3
Rw1466 vdd__p3 vdd__p31 35058.1
Rw1467 vdd__p3 vdd__p32 37738.8
Rw1468 vdd__p3 vdd__p33 40175.3
Rw1469 vdd__p3 vdd__p34 43354.2
Rw1470 vdd__p3 vdd__p36 2461.62
Rw1471 vdd__p3 vdd__p37 9895.32
Rw1472 vdd__p3 vdd__p38 17814.7
Rw1473 vdd__p3 vdd__p4 492.333
Rw1474 vdd__p3 vdd__p5 108.681
Rw1475 vdd__p3 vdd__p8 596609
Rw1476 vdd__p30 vdd__p31 1125.96
Rw1477 vdd__p30 vdd__p32 1212.06
Rw1478 vdd__p30 vdd__p33 1290.31
Rw1479 vdd__p30 vdd__p34 1392.41
Rw1480 vdd__p30 vdd__p36 79.0601
Rw1481 vdd__p30 vdd__p37 317.808
Rw1482 vdd__p30 vdd__p38 572.155
Rw1483 vdd__p30 vdd__p4 135838
Rw1484 vdd__p30 vdd__p5 29985.8
Rw1485 vdd__p30 vdd__p6 199532
Rw1486 vdd__p30 vdd__p7 131245
Rw1487 vdd__p30 vdd__p8 19161.3
Rw1488 vdd__p30 vdd__p9 248110
Rw1489 vdd__p31 vdd__p32 1160.4
Rw1490 vdd__p31 vdd__p33 1235.32
Rw1491 vdd__p31 vdd__p34 1333.06
Rw1492 vdd__p31 vdd__p36 75.6903
Rw1493 vdd__p31 vdd__p37 304.262
Rw1494 vdd__p31 vdd__p38 547.768
Rw1495 vdd__p31 vdd__p4 146826
Rw1496 vdd__p31 vdd__p5 32411.5
Rw1497 vdd__p31 vdd__p6 191027
Rw1498 vdd__p31 vdd__p7 125651
Rw1499 vdd__p31 vdd__p8 18344.6
Rw1500 vdd__p31 vdd__p9 237535
Rw1501 vdd__p32 vdd__p33 1174.27
Rw1502 vdd__p32 vdd__p34 1267.19
Rw1503 vdd__p32 vdd__p36 71.95
Rw1504 vdd__p32 vdd__p37 289.227
Rw1505 vdd__p32 vdd__p38 520.7
Rw1506 vdd__p32 vdd__p4 158053
Rw1507 vdd__p32 vdd__p5 34889.9
Rw1508 vdd__p32 vdd__p6 181587
Rw1509 vdd__p32 vdd__p7 119442
Rw1510 vdd__p32 vdd__p8 17438.1
Rw1511 vdd__p32 vdd__p9 225797
Rw1512 vdd__p33 vdd__p34 1187.31
Rw1513 vdd__p33 vdd__p36 67.4146
Rw1514 vdd__p33 vdd__p37 270.995
Rw1515 vdd__p33 vdd__p38 487.877
Rw1516 vdd__p33 vdd__p4 168258
Rw1517 vdd__p33 vdd__p5 37142.5
Rw1518 vdd__p33 vdd__p6 170141
Rw1519 vdd__p33 vdd__p7 111912
Rw1520 vdd__p33 vdd__p8 16338.9
Rw1521 vdd__p33 vdd__p9 211564
Rw1522 vdd__p34 vdd__p36 31.2177
Rw1523 vdd__p34 vdd__p37 256.49
Rw1524 vdd__p34 vdd__p38 461.762
Rw1525 vdd__p34 vdd__p4 181571
Rw1526 vdd__p34 vdd__p5 40081.3
Rw1527 vdd__p34 vdd__p6 161034
Rw1528 vdd__p34 vdd__p7 105922
Rw1529 vdd__p34 vdd__p8 15464.3
Rw1530 vdd__p34 vdd__p9 200239
Rw1531 vdd__p36 vdd__p37 14.5633
Rw1532 vdd__p36 vdd__p38 26.2186
Rw1533 vdd__p36 vdd__p4 10309.5
Rw1534 vdd__p36 vdd__p5 2275.8
Rw1535 vdd__p36 vdd__p6 9143.4
Rw1536 vdd__p36 vdd__p7 6014.2
Rw1537 vdd__p36 vdd__p8 878.053
Rw1538 vdd__p36 vdd__p9 11369.5
Rw1539 vdd__p37 vdd__p38 5.68905
Rw1540 vdd__p37 vdd__p4 41442.4
Rw1541 vdd__p37 vdd__p5 9148.31
Rw1542 vdd__p37 vdd__p6 1983.98
Rw1543 vdd__p37 vdd__p7 1304.99
Rw1544 vdd__p37 vdd__p8 190.525
Rw1545 vdd__p37 vdd__p9 2467.01
Rw1546 vdd__p38 vdd__p4 74609.4
Rw1547 vdd__p38 vdd__p5 16469.8
Rw1548 vdd__p38 vdd__p6 1019.63
Rw1549 vdd__p38 vdd__p7 670.674
Rw1550 vdd__p38 vdd__p8 97.9163
Rw1551 vdd__p38 vdd__p9 1267.87
Rw1552 vdd__p4 vdd__p5 62.0014
Rw1553 vdd__p5 vdd__p8 551570
Rw1554 vdd__p6 vdd__p7 69.3618
Rw1555 vdd__p6 vdd__p8 179.083
Rw1556 vdd__p6 vdd__p9 618.801
Rw1557 vdd__p7 vdd__p8 117.794
Rw1558 vdd__p7 vdd__p9 407.025
Rw1559 vdd__p8 vdd__p9 222.683
Rw1560 vref vref__p0 37.8501
Rw1561 vref vref__p1 36.462
Rw1562 vref vref__p11 36.7663
Rw1563 vref vref__p12 47.8742
Rw1564 vref vref__p2 34.0556
Rw1565 vref vref__p3 19.1317
Rw1566 vref vref__p4 39.0922
Rw1567 vref vref__p5 146.284
Rw1568 vref vref__p6 53.0763
Rw1569 vref vref__p7 188.985
Rw1570 vref vref__p8 63.294
Rw1571 vref vref__p9 65.7068
Rw1572 vref__p0 vref__p1 31.9297
Rw1573 vref__p0 vref__p11 53.8972
Rw1574 vref__p0 vref__p12 70.1805
Rw1575 vref__p0 vref__p2 39.3748
Rw1576 vref__p0 vref__p3 151.241
Rw1577 vref__p0 vref__p4 57.3067
Rw1578 vref__p0 vref__p5 214.444
Rw1579 vref__p0 vref__p6 77.8066
Rw1580 vref__p0 vref__p7 277.04
Rw1581 vref__p0 vref__p8 92.7851
Rw1582 vref__p0 vref__p9 96.322
Rw1583 vref__p1 vref__p11 51.9206
Rw1584 vref__p1 vref__p12 67.6068
Rw1585 vref__p1 vref__p2 37.9308
Rw1586 vref__p1 vref__p3 145.695
Rw1587 vref__p1 vref__p4 55.2051
Rw1588 vref__p1 vref__p5 206.579
Rw1589 vref__p1 vref__p6 74.9532
Rw1590 vref__p1 vref__p7 266.88
Rw1591 vref__p1 vref__p8 89.3824
Rw1592 vref__p1 vref__p9 92.7896
Rw1593 vref__p11 vref__p12 35.5995
Rw1594 vref__p11 vref__p2 48.494
Rw1595 vref__p11 vref__p3 141.005
Rw1596 vref__p11 vref__p4 37.6875
Rw1597 vref__p11 vref__p5 19.3163
Rw1598 vref__p11 vref__p6 39.4679
Rw1599 vref__p11 vref__p7 140.531
Rw1600 vref__p11 vref__p8 47.0658
Rw1601 vref__p11 vref__p9 48.86
Rw1602 vref__p12 vref__p2 63.145
Rw1603 vref__p12 vref__p3 183.605
Rw1604 vref__p12 vref__p4 49.0736
Rw1605 vref__p12 vref__p5 135.651
Rw1606 vref__p12 vref__p6 34.6862
Rw1607 vref__p12 vref__p7 18.9097
Rw1608 vref__p12 vref__p8 32.4965
Rw1609 vref__p12 vref__p9 33.7353
Rw1610 vref__p2 vref__p3 136.08
Rw1611 vref__p2 vref__p4 51.5617
Rw1612 vref__p2 vref__p5 192.946
Rw1613 vref__p2 vref__p6 70.0066
Rw1614 vref__p2 vref__p7 249.267
Rw1615 vref__p2 vref__p8 83.4835
Rw1616 vref__p2 vref__p9 86.6658
Rw1617 vref__p3 vref__p4 149.925
Rw1618 vref__p3 vref__p5 561.025
Rw1619 vref__p3 vref__p6 203.557
Rw1620 vref__p3 vref__p7 724.789
Rw1621 vref__p3 vref__p8 242.743
Rw1622 vref__p3 vref__p9 251.996
Rw1623 vref__p4 vref__p5 149.949
Rw1624 vref__p4 vref__p6 54.4061
Rw1625 vref__p4 vref__p7 193.72
Rw1626 vref__p4 vref__p8 64.8798
Rw1627 vref__p4 vref__p9 67.353
Rw1628 vref__p5 vref__p6 150.392
Rw1629 vref__p5 vref__p7 535.489
Rw1630 vref__p5 vref__p8 179.344
Rw1631 vref__p5 vref__p9 186.18
Rw1632 vref__p6 vref__p7 136.925
Rw1633 vref__p6 vref__p8 45.8584
Rw1634 vref__p6 vref__p9 47.6065
Rw1635 vref__p7 vref__p8 123.42
Rw1636 vref__p7 vref__p9 128.124
Rw1637 vref__p8 vref__p9 31.9637
Rw1638 vrefl vrefl__p0 36.1912
Rw1639 vrefl vrefl__p1 34.864
Rw1640 vrefl vrefl__p10 10873
Rw1641 vrefl vrefl__p11 10115.9
Rw1642 vrefl vrefl__p12 9688.32
Rw1643 vrefl vrefl__p13 11145.8
Rw1644 vrefl vrefl__p14 12654.8
Rw1645 vrefl vrefl__p15 14018.3
Rw1646 vrefl vrefl__p16 15067.5
Rw1647 vrefl vrefl__p17 15641.8
Rw1648 vrefl vrefl__p19 23.5375
Rw1649 vrefl vrefl__p2 32.4364
Rw1650 vrefl vrefl__p3 29.2813
Rw1651 vrefl vrefl__p4 34.6149
Rw1652 vrefl vrefl__p5 54.1611
Rw1653 vrefl vrefl__p6 29.6978
Rw1654 vrefl vrefl__p7 31.9204
Rw1655 vrefl vrefl__p8 33.1372
Rw1656 vrefl vrefl__p9 11286.9
Rw1657 vrefl__p0 vrefl__p1 28.5577
Rw1658 vrefl__p0 vrefl__p19 12228.9
Rw1659 vrefl__p0 vrefl__p2 33.8538
Rw1660 vrefl__p0 vrefl__p3 39.7034
Rw1661 vrefl__p0 vrefl__p4 371.992
Rw1662 vrefl__p0 vrefl__p5 105.073
Rw1663 vrefl__p0 vrefl__p6 57.614
Rw1664 vrefl__p0 vrefl__p7 61.9258
Rw1665 vrefl__p0 vrefl__p8 64.2864
Rw1666 vrefl__p1 vrefl__p19 11780.5
Rw1667 vrefl__p1 vrefl__p2 32.6123
Rw1668 vrefl__p1 vrefl__p3 38.2473
Rw1669 vrefl__p1 vrefl__p4 358.35
Rw1670 vrefl__p1 vrefl__p5 101.22
Rw1671 vrefl__p1 vrefl__p6 55.5011
Rw1672 vrefl__p1 vrefl__p7 59.6548
Rw1673 vrefl__p1 vrefl__p8 61.9288
Rw1674 vrefl__p10 vrefl__p11 34.923
Rw1675 vrefl__p10 vrefl__p12 155.608
Rw1676 vrefl__p10 vrefl__p13 47.5836
Rw1677 vrefl__p10 vrefl__p14 54.0259
Rw1678 vrefl__p10 vrefl__p15 59.8471
Rw1679 vrefl__p10 vrefl__p16 64.3261
Rw1680 vrefl__p10 vrefl__p17 66.7782
Rw1681 vrefl__p10 vrefl__p19 32.2863
Rw1682 vrefl__p10 vrefl__p9 30.1219
Rw1683 vrefl__p11 vrefl__p12 144.773
Rw1684 vrefl__p11 vrefl__p13 44.2704
Rw1685 vrefl__p11 vrefl__p14 50.264
Rw1686 vrefl__p11 vrefl__p15 55.6799
Rw1687 vrefl__p11 vrefl__p16 59.847
Rw1688 vrefl__p11 vrefl__p17 62.1284
Rw1689 vrefl__p11 vrefl__p19 30.0382
Rw1690 vrefl__p11 vrefl__p9 36.2525
Rw1691 vrefl__p12 vrefl__p13 149.347
Rw1692 vrefl__p12 vrefl__p14 169.567
Rw1693 vrefl__p12 vrefl__p15 187.838
Rw1694 vrefl__p12 vrefl__p16 201.896
Rw1695 vrefl__p12 vrefl__p17 209.592
Rw1696 vrefl__p12 vrefl__p19 28.7686
Rw1697 vrefl__p12 vrefl__p9 161.532
Rw1698 vrefl__p13 vrefl__p14 39.159
Rw1699 vrefl__p13 vrefl__p15 43.3783
Rw1700 vrefl__p13 vrefl__p16 46.6247
Rw1701 vrefl__p13 vrefl__p17 48.4021
Rw1702 vrefl__p13 vrefl__p19 33.0964
Rw1703 vrefl__p13 vrefl__p9 49.3951
Rw1704 vrefl__p14 vrefl__p15 37.0529
Rw1705 vrefl__p14 vrefl__p16 39.826
Rw1706 vrefl__p14 vrefl__p17 41.3441
Rw1707 vrefl__p14 vrefl__p19 37.5772
Rw1708 vrefl__p14 vrefl__p9 56.0826
Rw1709 vrefl__p15 vrefl__p16 33.6385
Rw1710 vrefl__p15 vrefl__p17 34.9208
Rw1711 vrefl__p15 vrefl__p19 41.6261
Rw1712 vrefl__p15 vrefl__p9 62.1254
Rw1713 vrefl__p16 vrefl__p17 29.2596
Rw1714 vrefl__p16 vrefl__p19 44.7414
Rw1715 vrefl__p16 vrefl__p9 66.7749
Rw1716 vrefl__p17 vrefl__p19 46.447
Rw1717 vrefl__p17 vrefl__p9 69.3204
Rw1718 vrefl__p19 vrefl__p2 10960.2
Rw1719 vrefl__p19 vrefl__p3 9894.09
Rw1720 vrefl__p19 vrefl__p4 11696.3
Rw1721 vrefl__p19 vrefl__p5 18300.9
Rw1722 vrefl__p19 vrefl__p6 10034.8
Rw1723 vrefl__p19 vrefl__p7 10785.8
Rw1724 vrefl__p19 vrefl__p8 11197
Rw1725 vrefl__p19 vrefl__p9 33.5155
Rw1726 vrefl__p2 vrefl__p3 35.5842
Rw1727 vrefl__p2 vrefl__p4 333.398
Rw1728 vrefl__p2 vrefl__p5 94.1716
Rw1729 vrefl__p2 vrefl__p6 51.6365
Rw1730 vrefl__p2 vrefl__p7 55.501
Rw1731 vrefl__p2 vrefl__p8 57.6167
Rw1732 vrefl__p3 vrefl__p4 300.968
Rw1733 vrefl__p3 vrefl__p5 85.0116
Rw1734 vrefl__p3 vrefl__p6 46.6139
Rw1735 vrefl__p3 vrefl__p7 50.1025
Rw1736 vrefl__p3 vrefl__p8 52.0124
Rw1737 vrefl__p4 vrefl__p5 556.696
Rw1738 vrefl__p4 vrefl__p6 305.25
Rw1739 vrefl__p4 vrefl__p7 328.094
Rw1740 vrefl__p4 vrefl__p8 340.601
Rw1741 vrefl__p5 vrefl__p6 70.567
Rw1742 vrefl__p5 vrefl__p7 75.8482
Rw1743 vrefl__p5 vrefl__p8 78.7396
Rw1744 vrefl__p6 vrefl__p7 32.6227
Rw1745 vrefl__p6 vrefl__p8 33.8663
Rw1746 vrefl__p7 vrefl__p8 28.5662
Rw1747 xc4_din xc4_din__p1 115.222
Rw1748 xc4_din xc4_din__p2 406.205
Rw1749 xc4_din__p1 xc4_din__p2 136.403
Rw1750 xc4_dip xc4_dip__p1 72.0874
Rw1751 xc4_dip xc4_dip__p2 775.964
Rw1752 xc4_dip__p1 xc4_dip__p2 124.578
Rw1753 xc4_lt xc4_lt__p1 10.8365
Rw1754 xc4_lt xc4_lt__p2 12.6193
Rw1755 xc4_lt__p1 xc4_lt__p2 120.796
Rw1756 xc4_outnb xc4_outnb__p1 47.718
Rw1757 xc4_outpb xc4_outpb__p1 47.4062
Rw1758 xc4_xs1_tail xc4_xs1_tail__p1 112.154
Rw1759 xc4_xs1_tail xc4_xs1_tail__p2 105.906
Rw1760 xc4_xs1_tail__p1 xc4_xs1_tail__p2 383.97
Rw1761 xc4_xs1_tail0 xc4_xs1_tail0__p1 29.2884
Rw1762 xc5_din xc5_din__p1 236.394
Rw1763 xc5_din xc5_din__p2 136.917
Rw1764 xc5_din__p1 xc5_din__p2 57.9583
Rw1765 xc5_dip xc5_dip__p1 234.494
Rw1766 xc5_dip xc5_dip__p2 140.863
Rw1767 xc5_dip__p1 xc5_dip__p2 56.9456
Rw1768 xc5_lt xc5_lt__p1 315.606
Rw1769 xc5_lt xc5_lt__p2 315.866
Rw1770 xc5_lt__p1 xc5_lt__p2 20.2819
Rw1771 xc5_outnb xc5_outnb__p1 44.3352
Rw1772 xc5_outpb xc5_outpb__p1 44.0234
Rw1773 xc5_xs1_tail xc5_xs1_tail__p1 59.2156
Rw1774 xc5_xs1_tail__p1 xc5_xs1_tail__p2 19.0185
Rw1775 xc5_xs1_tail0 xc5_xs1_tail0__p1 29.0295
Rw1776 xs0n_cbn xs0n_cbn__p1 15801.4
Rw1777 xs0n_cbn xs0n_cbn__p2 362712
Rw1778 xs0n_cbn xs0n_cbn__p3 284.604
Rw1779 xs0n_cbn xs0n_cbn__p4 157.434
Rw1780 xs0n_cbn__p1 xs0n_cbn__p2 9.85636
Rw1781 xs0n_cbn__p1 xs0n_cbn__p3 3091.89
Rw1782 xs0n_cbn__p1 xs0n_cbn__p4 19.7199
Rw1783 xs0n_cbn__p2 xs0n_cbn__p3 70972.4
Rw1784 xs0n_cbn__p2 xs0n_cbn__p4 452.659
Rw1785 xs0n_cbn__p3 xs0n_cbn__p4 30.8054
Rw1786 xs0n_cbp xs0n_cbp__p1 9.57598
Rw1787 xs0n_cbp xs0n_cbp__p2 59.1671
Rw1788 xs0n_cbp__p1 xs0n_cbp__p2 1243.71
Rw1789 xs0n_g xs0n_g__p1 0.67694
Rw1790 xs0n_g__p1 xs0n_g__p5 84.1638
Rw1791 xs0n_g__p2 xs0n_g__p3 75.6292
Rw1792 xs0n_g__p2 xs0n_g__p4 84.7178
Rw1793 xs0n_g__p2 xs0n_g__p5 266.254
Rw1794 xs0n_g__p3 xs0n_g__p4 25.0201
Rw1795 xs0n_g__p3 xs0n_g__p5 78.634
Rw1796 xs0n_g__p4 xs0n_g__p5 72.6725
Rw1797 xs0n_n10 xs0n_n10__p1 46.1685
Rw1798 xs0n_x xs0n_x__p1 1.05514
Rw1799 xs0n_x xs0n_x__p2 3.67554
Rw1800 xs0n_x__p1 xs0n_x__p2 11.8997
Rw1801 xs0n_x__p2 xs0n_x__p3 41.843
Rw1802 xs0p_cbn xs0p_cbn__p1 89.1016
Rw1803 xs0p_cbn xs0p_cbn__p2 2045.27
Rw1804 xs0p_cbn xs0p_cbn__p3 85.4362
Rw1805 xs0p_cbn xs0p_cbn__p4 105.884
Rw1806 xs0p_cbn__p1 xs0p_cbn__p2 9.87837
Rw1807 xs0p_cbn__p1 xs0p_cbn__p3 117.156
Rw1808 xs0p_cbn__p1 xs0p_cbn__p4 27.208
Rw1809 xs0p_cbn__p2 xs0p_cbn__p3 2689.24
Rw1810 xs0p_cbn__p2 xs0p_cbn__p4 624.542
Rw1811 xs0p_cbn__p3 xs0p_cbn__p4 139.223
Rw1812 xs0p_cbp xs0p_cbp__p1 9.5749
Rw1813 xs0p_cbp xs0p_cbp__p2 60.089
Rw1814 xs0p_cbp__p1 xs0p_cbp__p2 1263.09
Rw1815 xs0p_g xs0p_g__p1 0.6688
Rw1816 xs0p_g__p1 xs0p_g__p2 39.4008
Rw1817 xs0p_g__p2 xs0p_g__p3 107.711
Rw1818 xs0p_g__p2 xs0p_g__p4 101.67
Rw1819 xs0p_g__p2 xs0p_g__p5 68.2828
Rw1820 xs0p_g__p3 xs0p_g__p4 23.4195
Rw1821 xs0p_g__p3 xs0p_g__p5 96.2505
Rw1822 xs0p_g__p4 xs0p_g__p5 90.8525
Rw1823 xs0p_n10 xs0p_n10__p1 46.1685
Rw1824 xs0p_x xs0p_x__p1 1.00105
Rw1825 xs0p_x xs0p_x__p2 42.5398
Rw1826 xs0p_x xs0p_x__p3 126.923
Rw1827 xs0p_x__p1 xs0p_x__p2 60.1909
Rw1828 xs0p_x__p1 xs0p_x__p3 179.588
Rw1829 xs0p_x__p2 xs0p_x__p3 61.4978
Rw1830 xs1n_cbn xs1n_cbn__p3 33.8069
Rw1831 xs1n_cbn xs1n_cbn__p4 101.23
Rw1832 xs1n_cbn__p1 xs1n_cbn__p2 9.82459
Rw1833 xs1n_cbn__p1 xs1n_cbn__p4 18.8418
Rw1834 xs1n_cbn__p2 xs1n_cbn__p4 782.533
Rw1835 xs1n_cbn__p3 xs1n_cbn__p4 165.888
Rw1836 xs1n_cbp xs1n_cbp__p1 9.54422
Rw1837 xs1n_cbp xs1n_cbp__p2 58.8
Rw1838 xs1n_cbp__p1 xs1n_cbp__p2 1320.09
Rw1839 xs1n_g xs1n_g__p1 0.6347
Rw1840 xs1n_g__p1 xs1n_g__p2 20.2084
Rw1841 xs1n_g__p2 xs1n_g__p3 77.5801
Rw1842 xs1n_g__p2 xs1n_g__p4 86.5711
Rw1843 xs1n_g__p2 xs1n_g__p5 271.75
Rw1844 xs1n_g__p3 xs1n_g__p4 25.0669
Rw1845 xs1n_g__p3 xs1n_g__p5 78.6859
Rw1846 xs1n_g__p4 xs1n_g__p5 72.1918
Rw1847 xs1n_n10 xs1n_n10__p1 10.7757
Rw1848 xs1n_x xs1n_x__p1 76.3431
Rw1849 xs1n_x xs1n_x__p2 50.2907
Rw1850 xs1n_x xs1n_x__p3 90.9077
Rw1851 xs1n_x__p1 xs1n_x__p2 255.548
Rw1852 xs1n_x__p1 xs1n_x__p3 26.1992
Rw1853 xs1n_x__p2 xs1n_x__p3 304.301
Rw1854 xs1p_cbn xs1p_cbn__p1 90.6795
Rw1855 xs1p_cbn xs1p_cbn__p2 1917.8
Rw1856 xs1p_cbn xs1p_cbn__p3 36.2644
Rw1857 xs1p_cbn xs1p_cbn__p4 107.009
Rw1858 xs1p_cbn__p1 xs1p_cbn__p2 9.94467
Rw1859 xs1p_cbn__p1 xs1p_cbn__p3 161.481
Rw1860 xs1p_cbn__p1 xs1p_cbn__p4 26.5667
Rw1861 xs1p_cbn__p2 xs1p_cbn__p3 3415.2
Rw1862 xs1p_cbn__p2 xs1p_cbn__p4 561.866
Rw1863 xs1p_cbn__p3 xs1p_cbn__p4 190.561
Rw1864 xs1p_cbp xs1p_cbp__p1 9.54302
Rw1865 xs1p_cbp xs1p_cbp__p2 59.8889
Rw1866 xs1p_cbp__p1 xs1p_cbp__p2 1344.53
Rw1867 xs1p_g xs1p_g__p1 0.6347
Rw1868 xs1p_g__p1 xs1p_g__p2 25.125
Rw1869 xs1p_g__p1 xs1p_g__p3 227.953
Rw1870 xs1p_g__p1 xs1p_g__p4 205.162
Rw1871 xs1p_g__p1 xs1p_g__p5 131.341
Rw1872 xs1p_g__p2 xs1p_g__p3 181.331
Rw1873 xs1p_g__p2 xs1p_g__p4 163.201
Rw1874 xs1p_g__p2 xs1p_g__p5 104.479
Rw1875 xs1p_g__p3 xs1p_g__p4 24.2192
Rw1876 xs1p_g__p3 xs1p_g__p5 104.706
Rw1877 xs1p_g__p4 xs1p_g__p5 94.2374
Rw1878 xs1p_n10 xs1p_n10__p1 46.209
Rw1879 xs1p_x xs1p_x__p1 1.00105
Rw1880 xs1p_x xs1p_x__p2 42.5398
Rw1881 xs1p_x xs1p_x__p3 126.923
Rw1882 xs1p_x__p1 xs1p_x__p2 60.1909
Rw1883 xs1p_x__p1 xs1p_x__p3 179.588
Rw1884 xs1p_x__p2 xs1p_x__p3 61.4978
Cp0 bn0 bn1 2.453e-16
Cp1 bn0 bn10 4.539e-17
Cp2 bn0 bn11 4.486e-17
Cp3 bn0 bn12 6.037e-17
Cp4 bn0 bn2 7.057e-15
Cp5 bn0 bn3 2.247e-16
Cp6 bn0 bn4 2.663e-16
Cp7 bn0 bn5 1.004e-15
Cp8 bn0 bn6 9.647e-16
Cp9 bn0 bn7 1.72e-15
Cp10 bn0 bn8 4.759e-17
Cp11 bn0 bn9 4.682e-17
Cp12 bn0 bp11 1.837e-16
Cp13 bn0 bp12 6.813e-16
Cp14 bn0 cn0 6.999e-16
Cp15 bn0 cn1 2.046e-16
Cp16 bn0 cn10 4.723e-17
Cp17 bn0 cn11 4.944e-17
Cp18 bn0 cn12 5.082e-17
Cp19 bn0 cn2 1.58e-16
Cp20 bn0 cn3 1.863e-16
Cp21 bn0 cn4 1.463e-16
Cp22 bn0 cn5 6.454e-17
Cp23 bn0 cn6 1.559e-16
Cp24 bn0 cn7 7.723e-17
Cp25 bn0 cn8 1.526e-16
Cp26 bn0 cn9 7.977e-17
Cp27 bn0 cp10 4.285e-19
Cp28 bn0 cp11 5.485e-17
Cp29 bn0 cp12 9.435e-17
Cp30 bn0 gnd 3.035e-15
Cp31 bn0 lsb_n 2.271e-16
Cp32 bn0 on 1.888e-16
Cp33 bn0 op 1.13e-16
Cp34 bn0 vdd 3.864e-17
Cp35 bn0 vrefl 7.354e-16
Cp36 bn0 xc4_din 1.034e-16
Cp37 bn0 xc4_dip 1.654e-16
Cp38 bn0 xc4_outnb 5.524e-17
Cp39 bn0 xc4_outpb 2.678e-17
Cp40 bn1 bn10 7.366e-17
Cp41 bn1 bn11 5.327e-16
Cp42 bn1 bn12 5.054e-16
Cp43 bn1 bn2 1.025e-15
Cp44 bn1 bn3 8.078e-16
Cp45 bn1 bn4 5.045e-16
Cp46 bn1 bn5 1.047e-15
Cp47 bn1 bn6 1.975e-15
Cp48 bn1 bn7 1.573e-15
Cp49 bn1 bn8 5.488e-17
Cp50 bn1 bn9 5.508e-17
Cp51 bn1 bp12 1.302e-17
Cp52 bn1 cn0 6.511e-18
Cp53 bn1 cn1 5.659e-16
Cp54 bn1 cn10 6.124e-17
Cp55 bn1 cn11 1.302e-16
Cp56 bn1 cn12 1.224e-16
Cp57 bn1 cn2 8.994e-17
Cp58 bn1 cn3 5.156e-17
Cp59 bn1 cn4 6.843e-17
Cp60 bn1 cn5 7.204e-17
Cp61 bn1 cn6 5.111e-17
Cp62 bn1 cn7 5.104e-17
Cp63 bn1 cn8 5.131e-17
Cp64 bn1 cn9 5.539e-17
Cp65 bn1 cp12 1.831e-17
Cp66 bn1 gnd 2.097e-15
Cp67 bn1 lsb_n 4.428e-16
Cp68 bn1 on 9.922e-17
Cp69 bn1 op 1.501e-16
Cp70 bn1 vdd 2.915e-16
Cp71 bn1 vrefl 6.295e-16
Cp72 bn1 xc4_din 9.482e-17
Cp73 bn1 xc4_dip 1.403e-15
Cp74 bn1 xc4_outnb 5.479e-17
Cp75 bn1 xc4_outpb 2.967e-17
Cp76 bn10 bn11 2.088e-14
Cp77 bn10 bn12 5.857e-15
Cp78 bn10 bn2 3.845e-17
Cp79 bn10 bn3 3.845e-17
Cp80 bn10 bn4 3.845e-17
Cp81 bn10 bn5 4.892e-16
Cp82 bn10 bn6 2.085e-15
Cp83 bn10 bn7 2.301e-15
Cp84 bn10 bn8 1.114e-15
Cp85 bn10 bn9 1.299e-14
Cp86 bn10 bp0 4.911e-17
Cp87 bn10 bp1 4.662e-17
Cp88 bn10 bp10 2.248e-15
Cp89 bn10 bp11 5.365e-17
Cp90 bn10 bp12 3.882e-17
Cp91 bn10 bp2 4.145e-17
Cp92 bn10 bp3 3.846e-17
Cp93 bn10 bp4 3.882e-17
Cp94 bn10 bp5 3.882e-17
Cp95 bn10 bp6 3.882e-17
Cp96 bn10 bp7 3.882e-17
Cp97 bn10 bp8 2.021e-16
Cp98 bn10 bp9 7.85e-17
Cp99 bn10 clkb 2.703e-17
Cp100 bn10 clkn 3.691e-17
Cp101 bn10 cn0 3.24e-17
Cp102 bn10 cn1 3.852e-17
Cp103 bn10 cn10 5.553e-16
Cp104 bn10 cn11 7.476e-16
Cp105 bn10 cn12 4.036e-17
Cp106 bn10 cn2 3.24e-17
Cp107 bn10 cn3 3.977e-17
Cp108 bn10 cn4 3.24e-17
Cp109 bn10 cn5 4.026e-17
Cp110 bn10 cn6 5.504e-17
Cp111 bn10 cn7 1.244e-16
Cp112 bn10 cn8 1.073e-16
Cp113 bn10 cn9 3.425e-16
Cp114 bn10 cp0 4.691e-17
Cp115 bn10 cp1 4.747e-17
Cp116 bn10 cp10 3.799e-17
Cp117 bn10 cp11 3.799e-17
Cp118 bn10 cp12 3.799e-17
Cp119 bn10 cp2 4.117e-17
Cp120 bn10 cp3 4.691e-17
Cp121 bn10 cp4 4.009e-17
Cp122 bn10 cp5 4.037e-17
Cp123 bn10 cp6 3.357e-17
Cp124 bn10 cp7 4.009e-17
Cp125 bn10 cp8 6.571e-17
Cp126 bn10 cp9 3.799e-17
Cp127 bn10 gnd 4.662e-15
Cp128 bn10 lsb_n 6.709e-16
Cp129 bn10 lsb_p 2.444e-16
Cp130 bn10 on 3.713e-17
Cp131 bn10 onn 5.73e-19
Cp132 bn10 onp 1.628e-19
Cp133 bn10 op 3.311e-17
Cp134 bn10 rstb 1.456e-16
Cp135 bn10 vdd 3.565e-17
Cp136 bn10 vref 1.201e-15
Cp137 bn10 xc4_din 1.058e-16
Cp138 bn10 xc4_dip 2.133e-16
Cp139 bn11 bn12 3.436e-14
Cp140 bn11 bn2 3.792e-17
Cp141 bn11 bn3 3.792e-17
Cp142 bn11 bn4 3.792e-17
Cp143 bn11 bn5 6.931e-17
Cp144 bn11 bn6 2.96e-15
Cp145 bn11 bn7 3.34e-15
Cp146 bn11 bn8 5.258e-16
Cp147 bn11 bn9 5.975e-16
Cp148 bn11 bp0 9.649e-17
Cp149 bn11 bp1 3.792e-17
Cp150 bn11 bp10 5.724e-16
Cp151 bn11 bp11 4.597e-15
Cp152 bn11 bp12 2.96e-16
Cp153 bn11 bp2 3.275e-17
Cp154 bn11 bp3 3.846e-17
Cp155 bn11 bp4 4.971e-17
Cp156 bn11 bp5 4.698e-16
Cp157 bn11 bp6 4.754e-16
Cp158 bn11 bp7 5.071e-17
Cp159 bn11 bp8 1.873e-16
Cp160 bn11 bp9 2.237e-16
Cp161 bn11 clkb 3.549e-17
Cp162 bn11 clkn 4.079e-17
Cp163 bn11 cn0 2.596e-17
Cp164 bn11 cn1 3.186e-17
Cp165 bn11 cn10 2.678e-16
Cp166 bn11 cn11 4.527e-16
Cp167 bn11 cn12 6.907e-16
Cp168 bn11 cn2 2.574e-17
Cp169 bn11 cn3 6.985e-17
Cp170 bn11 cn4 2.559e-17
Cp171 bn11 cn5 1.153e-16
Cp172 bn11 cn6 3.278e-17
Cp173 bn11 cn7 6.503e-17
Cp174 bn11 cn8 4.726e-17
Cp175 bn11 cn9 8.05e-16
Cp176 bn11 cp0 3.255e-17
Cp177 bn11 cp1 1e-16
Cp178 bn11 cp10 1.165e-16
Cp179 bn11 cp11 5.647e-17
Cp180 bn11 cp12 4.002e-17
Cp181 bn11 cp2 2.965e-17
Cp182 bn11 cp3 3.255e-17
Cp183 bn11 cp4 2.615e-17
Cp184 bn11 cp5 1.137e-16
Cp185 bn11 cp6 3.357e-17
Cp186 bn11 cp7 2.574e-17
Cp187 bn11 cp8 3.919e-17
Cp188 bn11 cp9 8e-17
Cp189 bn11 gnd 5.453e-15
Cp190 bn11 lsb_n 6.01e-16
Cp191 bn11 lsb_p 3.851e-17
Cp192 bn11 on 3.186e-17
Cp193 bn11 onn 4.615e-17
Cp194 bn11 onp 1.156e-16
Cp195 bn11 op 3.351e-17
Cp196 bn11 rstb 1.185e-16
Cp197 bn11 t1 8.586e-19
Cp198 bn11 vdd 2.406e-17
Cp199 bn11 vref 9.161e-16
Cp200 bn11 xc4_din 1.075e-16
Cp201 bn11 xc4_dip 7.097e-17
Cp202 bn12 bn2 3.882e-17
Cp203 bn12 bn3 3.882e-17
Cp204 bn12 bn4 3.882e-17
Cp205 bn12 bn5 4.317e-17
Cp206 bn12 bn6 5.074e-15
Cp207 bn12 bn7 5.504e-15
Cp208 bn12 bn8 1.243e-15
Cp209 bn12 bn9 3.1e-15
Cp210 bn12 bp0 4.93e-16
Cp211 bn12 bp1 4.199e-16
Cp212 bn12 bp10 3.477e-16
Cp213 bn12 bp11 5.513e-16
Cp214 bn12 bp12 1.022e-14
Cp215 bn12 bp2 4.482e-17
Cp216 bn12 bp3 3.104e-16
Cp217 bn12 bp4 5.713e-16
Cp218 bn12 bp5 8.047e-17
Cp219 bn12 bp6 7.773e-17
Cp220 bn12 bp7 5.569e-16
Cp221 bn12 bp8 8.083e-16
Cp222 bn12 bp9 8.831e-16
Cp223 bn12 clkb 4.943e-17
Cp224 bn12 clkn 8.507e-17
Cp225 bn12 cn0 7.86e-17
Cp226 bn12 cn1 8.131e-17
Cp227 bn12 cn10 3.03e-16
Cp228 bn12 cn11 2.568e-16
Cp229 bn12 cn12 9.765e-16
Cp230 bn12 cn2 7.649e-17
Cp231 bn12 cn3 9.572e-17
Cp232 bn12 cn4 8.256e-17
Cp233 bn12 cn5 9.749e-17
Cp234 bn12 cn6 1.172e-16
Cp235 bn12 cn7 9.73e-17
Cp236 bn12 cn8 1.096e-16
Cp237 bn12 cn9 1.029e-16
Cp238 bn12 cp0 9.851e-17
Cp239 bn12 cp1 5.38e-17
Cp240 bn12 cp10 4.202e-17
Cp241 bn12 cp11 9.82e-17
Cp242 bn12 cp12 1.905e-16
Cp243 bn12 cp2 2.965e-17
Cp244 bn12 cp3 5.39e-17
Cp245 bn12 cp4 5.891e-17
Cp246 bn12 cp5 8.432e-17
Cp247 bn12 cp6 3.357e-17
Cp248 bn12 cp7 4.395e-17
Cp249 bn12 cp8 1.152e-16
Cp250 bn12 cp9 7.393e-17
Cp251 bn12 gnd 7.737e-15
Cp252 bn12 lsb_n 1.732e-14
Cp253 bn12 lsb_p 3.336e-16
Cp254 bn12 on 4.877e-17
Cp255 bn12 onn 1.464e-16
Cp256 bn12 onp 1.053e-16
Cp257 bn12 op 7.339e-17
Cp258 bn12 rstb 1.523e-16
Cp259 bn12 t1 1.363e-16
Cp260 top_n gnd 1.311e-17
Cp260x bn12 gnd 1.311e-17
Cp261 bn12 vdd 3.283e-17
Cp262 bn12 vref 1.374e-15
Cp263 bn12 xc4_din 1.372e-16
Cp264 bn12 xc4_dip 8.934e-17
Cp265 bn2 bn3 1.443e-14
Cp266 bn2 bn4 4.306e-16
Cp267 bn2 bn5 3.373e-15
Cp268 bn2 bn6 1.876e-15
Cp269 bn2 bn7 2.699e-15
Cp270 bn2 bn8 4.065e-17
Cp271 bn2 bn9 3.988e-17
Cp272 bn2 bp0 5.211e-16
Cp273 bn2 bp1 4.677e-16
Cp274 bn2 bp10 4.595e-17
Cp275 bn2 bp11 4.598e-17
Cp276 bn2 bp12 3.024e-17
Cp277 bn2 bp2 5.659e-17
Cp278 bn2 bp3 4.685e-17
Cp279 bn2 bp4 4.632e-17
Cp280 bn2 bp5 4.632e-17
Cp281 bn2 bp6 4.632e-17
Cp282 bn2 bp7 4.632e-17
Cp283 bn2 bp8 4.776e-17
Cp284 bn2 bp9 4.542e-17
Cp285 bn2 clkn 4.928e-17
Cp286 bn2 cn0 5.865e-17
Cp287 bn2 cn1 8.908e-17
Cp288 bn2 cn10 3.688e-17
Cp289 bn2 cn11 3.799e-17
Cp290 bn2 cn12 3.799e-17
Cp291 bn2 cn2 7.964e-16
Cp292 bn2 cn3 9.587e-17
Cp293 bn2 cn4 1.481e-16
Cp294 bn2 cn5 4.362e-17
Cp295 bn2 cn6 4.949e-17
Cp296 bn2 cn7 3.324e-17
Cp297 bn2 cn8 5.241e-17
Cp298 bn2 cn9 7.828e-17
Cp299 bn2 cp0 8.862e-17
Cp300 bn2 cp1 1.283e-17
Cp301 bn2 cp10 5.037e-17
Cp302 bn2 cp11 5.037e-17
Cp303 bn2 cp12 3.799e-17
Cp304 bn2 cp2 4.202e-17
Cp305 bn2 cp3 6.625e-17
Cp306 bn2 cp4 3.633e-17
Cp307 bn2 cp5 6.404e-17
Cp308 bn2 cp6 4.594e-17
Cp309 bn2 cp7 2.188e-17
Cp310 bn2 cp8 5.994e-17
Cp311 bn2 cp9 5.152e-17
Cp312 bn2 gnd 3.076e-15
Cp313 bn2 lsb_n 1.58e-16
Cp314 bn2 lsb_p 4.776e-17
Cp315 bn2 on 7.043e-17
Cp316 bn2 op 4.766e-16
Cp317 bn2 vdd 1.187e-16
Cp318 bn2 vrefl 6.626e-16
Cp319 bn2 xc4_din 9.636e-17
Cp320 bn2 xc4_dip 3.764e-16
Cp321 bn2 xc4_outnb 5.815e-17
Cp322 bn2 xc4_outpb 9.793e-17
Cp323 bn3 bn4 2.36e-14
Cp324 bn3 bn5 5.931e-15
Cp325 bn3 bn6 3.468e-15
Cp326 bn3 bn7 3.98e-15
Cp327 bn3 bn8 4.065e-17
Cp328 bn3 bn9 3.988e-17
Cp329 bn3 bp0 4.399e-17
Cp330 bn3 bp1 3.601e-17
Cp331 bn3 bp10 3.845e-17
Cp332 bn3 bp11 3.849e-17
Cp333 bn3 bp12 3.024e-17
Cp334 bn3 bp2 3.845e-17
Cp335 bn3 bp3 3.935e-17
Cp336 bn3 bp4 3.882e-17
Cp337 bn3 bp5 3.882e-17
Cp338 bn3 bp6 7.995e-17
Cp339 bn3 bp7 6.755e-16
Cp340 bn3 bp8 4.026e-17
Cp341 bn3 bp9 3.792e-17
Cp342 bn3 clkb 5.08e-17
Cp343 bn3 clkn 3.691e-17
Cp344 bn3 cn0 4.451e-17
Cp345 bn3 cn1 3.204e-17
Cp346 bn3 cn10 3.799e-17
Cp347 bn3 cn11 3.799e-17
Cp348 bn3 cn12 3.799e-17
Cp349 bn3 cn2 3.105e-17
Cp350 bn3 cn3 3.707e-16
Cp351 bn3 cn4 9.648e-17
Cp352 bn3 cn5 1.326e-16
Cp353 bn3 cn6 7.178e-17
Cp354 bn3 cn7 8.295e-17
Cp355 bn3 cn8 4.549e-17
Cp356 bn3 cn9 4.77e-17
Cp357 bn3 cp0 4.554e-17
Cp358 bn3 cp1 4.61e-17
Cp359 bn3 cp10 3.799e-17
Cp360 bn3 cp11 3.799e-17
Cp361 bn3 cp12 3.799e-17
Cp362 bn3 cp2 2.965e-17
Cp363 bn3 cp3 3.255e-17
Cp364 bn3 cp4 3.873e-17
Cp365 bn3 cp5 6.085e-17
Cp366 bn3 cp6 3.357e-17
Cp367 bn3 cp7 3.873e-17
Cp368 bn3 cp8 7.027e-17
Cp369 bn3 cp9 3.882e-17
Cp370 bn3 gnd 4.36e-15
Cp371 bn3 lsb_n 2.123e-16
Cp372 bn3 lsb_p 3.398e-16
Cp373 bn3 on 3.309e-17
Cp374 bn3 onn 1.263e-16
Cp375 bn3 onp 4.881e-17
Cp376 bn3 op 4.92e-17
Cp377 bn3 vdd 2.704e-16
Cp378 bn3 vrefl 1.328e-15
Cp379 bn3 xc4_din 1.142e-16
Cp380 bn3 xc4_dip 5.338e-16
Cp381 bn3 xc4_outnb 1.24e-16
Cp382 bn3 xc4_outpb 2.503e-19
Cp383 bn4 bn5 3.789e-14
Cp384 bn4 bn6 5.494e-15
Cp385 bn4 bn7 5.631e-15
Cp386 bn4 bn8 5.675e-16
Cp387 bn4 bn9 2.682e-16
Cp388 bn4 bp0 3.777e-17
Cp389 bn4 bp1 3.601e-17
Cp390 bn4 bp10 4.598e-17
Cp391 bn4 bp11 3.849e-17
Cp392 bn4 bp12 3.024e-17
Cp393 bn4 bp2 3.845e-17
Cp394 bn4 bp3 3.181e-16
Cp395 bn4 bp4 6.238e-16
Cp396 bn4 bp5 8.256e-17
Cp397 bn4 bp6 3.882e-17
Cp398 bn4 bp7 2.969e-17
Cp399 bn4 bp8 5.161e-16
Cp400 bn4 bp9 4.129e-16
Cp401 bn4 clkb 2.574e-17
Cp402 bn4 clkn 8.91e-17
Cp403 bn4 cn0 2.584e-17
Cp404 bn4 cn1 3.186e-17
Cp405 bn4 cn10 3.814e-17
Cp406 bn4 cn11 3.799e-17
Cp407 bn4 cn12 3.799e-17
Cp408 bn4 cn2 2.574e-17
Cp409 bn4 cn3 4.96e-17
Cp410 bn4 cn4 9.092e-16
Cp411 bn4 cn5 3.374e-16
Cp412 bn4 cn6 1.202e-16
Cp413 bn4 cn7 9.688e-17
Cp414 bn4 cn8 7.052e-17
Cp415 bn4 cn9 4.278e-17
Cp416 bn4 cp0 3.255e-17
Cp417 bn4 cp1 4.302e-17
Cp418 bn4 cp10 3.799e-17
Cp419 bn4 cp11 3.799e-17
Cp420 bn4 cp12 3.799e-17
Cp421 bn4 cp2 2.95e-17
Cp422 bn4 cp3 3.255e-17
Cp423 bn4 cp4 2.574e-17
Cp424 bn4 cp5 8.995e-17
Cp425 bn4 cp6 3.357e-17
Cp426 bn4 cp7 2.574e-17
Cp427 bn4 cp8 1.351e-16
Cp428 bn4 cp9 7.738e-17
Cp429 bn4 gnd 5.011e-15
Cp430 bn4 lsb_n 1.892e-16
Cp431 bn4 lsb_p 4.213e-17
Cp432 bn4 on 3.208e-17
Cp433 bn4 onn 4.626e-17
Cp434 bn4 onp 6.263e-17
Cp435 bn4 op 6.074e-17
Cp436 bn4 t1 1.29e-16
Cp437 bn4 vdd 5.538e-16
Cp438 bn4 vrefl 1.647e-15
Cp439 bn4 xc4_din 1.179e-16
Cp440 bn4 xc4_dip 5.195e-16
Cp441 bn4 xc4_outnb 4.343e-19
Cp442 bn5 bn6 1.211e-14
Cp443 bn5 bn7 1.739e-14
Cp444 bn5 bn8 1.194e-16
Cp445 bn5 bn9 3.529e-16
Cp446 bn5 bp0 9.703e-17
Cp447 bn5 bp1 9.466e-17
Cp448 bn5 bp10 5.215e-16
Cp449 bn5 bp11 2.356e-16
Cp450 bn5 bp12 4.034e-17
Cp451 bn5 bp2 5.141e-16
Cp452 bn5 bp3 2.481e-16
Cp453 bn5 bp4 4.992e-17
Cp454 bn5 bp5 4.665e-16
Cp455 bn5 bp6 4.717e-16
Cp456 bn5 bp7 5.137e-17
Cp457 bn5 bp8 9.334e-17
Cp458 bn5 bp9 1.033e-16
Cp459 bn5 clk 7.569e-18
Cp460 bn5 clkb 6.456e-17
Cp461 bn5 clkn 6.954e-17
Cp462 bn5 cn0 3.822e-17
Cp463 bn5 cn1 6.616e-17
Cp464 bn5 cn10 1.734e-16
Cp465 bn5 cn11 7.658e-17
Cp466 bn5 cn12 5.037e-17
Cp467 bn5 cn2 3.831e-17
Cp468 bn5 cn3 1.231e-16
Cp469 bn5 cn4 4.336e-17
Cp470 bn5 cn5 1.825e-15
Cp471 bn5 cn6 2.053e-16
Cp472 bn5 cn7 1.404e-16
Cp473 bn5 cn8 9.134e-17
Cp474 bn5 cn9 1.413e-16
Cp475 bn5 cp0 5.325e-17
Cp476 bn5 cp1 1.173e-16
Cp477 bn5 cp10 1.342e-16
Cp478 bn5 cp11 7.347e-17
Cp479 bn5 cp12 5.121e-17
Cp480 bn5 cp2 9.662e-17
Cp481 bn5 cp3 7.458e-17
Cp482 bn5 cp4 3.84e-17
Cp483 bn5 cp5 1.403e-16
Cp484 bn5 cp6 1.044e-16
Cp485 bn5 cp7 3.812e-17
Cp486 bn5 cp8 1.258e-16
Cp487 bn5 cp9 1.077e-16
Cp488 bn5 gnd 9.751e-15
Cp489 bn5 lsb_n 5.019e-16
Cp490 bn5 lsb_p 2.473e-16
Cp491 bn5 on 1.06e-16
Cp492 bn5 onn 5.083e-17
Cp493 bn5 onp 1.248e-16
Cp494 bn5 op 9.692e-17
Cp495 bn5 rstb 9.677e-17
Cp496 bn5 t0 1.963e-19
Cp497 bn5 t0b 2.401e-19
Cp498 bn5 t1 6.825e-17
Cp499 bn5 t1b 1.836e-17
Cp500 top_n gnd 1.26e-19
Cp500x bn5 gnd 1.26e-19
Cp501 top_p gnd 7.569e-18
Cp501x bn5 gnd 7.569e-18
Cp502 bn5 trk0 4.044e-19
Cp503 bn5 trk1 5.208e-19
Cp504 bn5 vdd 5.102e-16
Cp505 bn5 vrefl 5.513e-16
Cp506 bn5 xc4_din 1.143e-16
Cp507 bn5 xc4_dip 5.319e-16
Cp508 bn5 xs1n_cbp 2.091e-19
Cp509 bn5 xs1n_n10 4.667e-19
Cp510 bn6 bn7 1.162e-14
Cp511 bn6 bn8 7.425e-16
Cp512 bn6 bn9 1.986e-15
Cp513 bn6 bp0 6.733e-16
Cp514 bn6 bp1 5.426e-16
Cp515 bn6 bp10 6.568e-16
Cp516 bn6 bp11 5.943e-16
Cp517 bn6 bp12 8.08e-16
Cp518 bn6 bp2 6.364e-16
Cp519 bn6 bp3 6.091e-16
Cp520 bn6 bp4 9.209e-16
Cp521 bn6 bp5 5.852e-16
Cp522 bn6 bp6 5.901e-16
Cp523 bn6 bp7 8.532e-16
Cp524 bn6 bp8 6.868e-16
Cp525 bn6 bp9 5.326e-16
Cp526 bn6 clk 7.569e-18
Cp527 bn6 clkb 1.395e-16
Cp528 bn6 clkn 1.56e-16
Cp529 bn6 cn0 3e-16
Cp530 bn6 cn1 4.152e-16
Cp531 bn6 cn10 3.495e-16
Cp532 bn6 cn11 2.639e-16
Cp533 bn6 cn12 1.851e-16
Cp534 bn6 cn2 3.435e-16
Cp535 bn6 cn3 3.628e-16
Cp536 bn6 cn4 3.307e-16
Cp537 bn6 cn5 3.958e-16
Cp538 bn6 cn6 8.153e-16
Cp539 bn6 cn7 2.93e-16
Cp540 bn6 cn8 1.672e-16
Cp541 bn6 cn9 2.734e-16
Cp542 bn6 cp0 1.639e-16
Cp543 bn6 cp1 1.732e-16
Cp544 bn6 cp10 1.861e-16
Cp545 bn6 cp11 1.79e-16
Cp546 bn6 cp12 1.645e-16
Cp547 bn6 cp2 1.352e-16
Cp548 bn6 cp3 1.235e-16
Cp549 bn6 cp4 9.672e-17
Cp550 bn6 cp5 2.369e-16
Cp551 bn6 cp6 1.42e-16
Cp552 bn6 cp7 7.653e-17
Cp553 bn6 cp8 2.158e-16
Cp554 bn6 cp9 1.705e-16
Cp555 bn6 gnd 2.73e-14
Cp556 bn6 lsb_n 1.742e-15
Cp557 bn6 lsb_p 6.53e-16
Cp558 bn6 on 3.577e-16
Cp559 bn6 onn 2.28e-16
Cp560 bn6 onp 2.5e-16
Cp561 bn6 op 2.118e-16
Cp562 bn6 rstb 4.527e-17
Cp563 bn6 t0 8.975e-19
Cp564 bn6 t0b 2.481e-18
Cp565 bn6 t1 1.864e-16
Cp566 bn6 t1b 1.928e-17
Cp567 top_n gnd 5.775e-18
Cp567x bn6 gnd 5.775e-18
Cp568 top_p gnd 7.569e-18
Cp568x bn6 gnd 7.569e-18
Cp569 bn6 trk0 4.557e-18
Cp570 bn6 trk1 7.17e-18
Cp571 bn6 vdd 1.577e-15
Cp572 bn6 vrefl 6.353e-16
Cp573 bn6 xc4_din 1.501e-16
Cp574 bn6 xc4_dip 3.304e-15
Cp575 bn7 bn8 3.58e-15
Cp576 bn7 bn9 2.056e-15
Cp577 bn7 bp0 1.24e-15
Cp578 bn7 bp1 1.033e-15
Cp579 bn7 bp10 1.198e-15
Cp580 bn7 bp11 1.112e-15
Cp581 bn7 bp12 1.388e-15
Cp582 bn7 bp2 1.174e-15
Cp583 bn7 bp3 1.155e-15
Cp584 bn7 bp4 1.523e-15
Cp585 bn7 bp5 1.108e-15
Cp586 bn7 bp6 1.116e-15
Cp587 bn7 bp7 1.453e-15
Cp588 bn7 bp8 1.256e-15
Cp589 bn7 bp9 1.016e-15
Cp590 bn7 clk 1.514e-17
Cp591 bn7 clkb 1.932e-16
Cp592 bn7 clkn 2.968e-16
Cp593 bn7 cn0 2.1e-16
Cp594 bn7 cn1 2.665e-16
Cp595 bn7 cn10 4.922e-16
Cp596 bn7 cn11 5.986e-16
Cp597 bn7 cn12 5.864e-16
Cp598 bn7 cn2 2.02e-16
Cp599 bn7 cn3 3.388e-16
Cp600 bn7 cn4 2.175e-16
Cp601 bn7 cn5 8.568e-16
Cp602 bn7 cn6 6.237e-16
Cp603 bn7 cn7 1.22e-15
Cp604 bn7 cn8 4.569e-16
Cp605 bn7 cn9 3.934e-16
Cp606 bn7 cp0 3.77e-16
Cp607 bn7 cp1 4.741e-16
Cp608 bn7 cp10 7.535e-16
Cp609 bn7 cp11 7.434e-16
Cp610 bn7 cp12 5.889e-16
Cp611 bn7 cp2 2.732e-16
Cp612 bn7 cp3 3.583e-16
Cp613 bn7 cp4 3.382e-16
Cp614 bn7 cp5 5.315e-16
Cp615 bn7 cp6 3.16e-16
Cp616 bn7 cp7 2.845e-16
Cp617 bn7 cp8 1.416e-15
Cp618 bn7 cp9 8.345e-16
Cp619 bn7 gnd 4.051e-14
Cp620 bn7 lsb_n 2.047e-15
Cp621 bn7 lsb_p 1.14e-15
Cp622 bn7 on 2.889e-16
Cp623 bn7 onn 3.559e-16
Cp624 bn7 onp 4.138e-16
Cp625 bn7 op 3.355e-16
Cp626 bn7 rstb 1.962e-16
Cp627 bn7 t0 1.197e-18
Cp628 bn7 t0b 1.463e-18
Cp629 bn7 t1 3.733e-16
Cp630 bn7 t1b 2.377e-16
Cp631 top_n gnd 6.005e-18
Cp631x bn7 gnd 6.005e-18
Cp632 top_p gnd 2.464e-17
Cp632x bn7 gnd 2.464e-17
Cp633 bn7 trk0 2.035e-18
Cp634 bn7 trk1 2.608e-18
Cp635 bn7 vdd 2.506e-15
Cp636 bn7 vrefl 6.66e-16
Cp637 bn7 xc4_din 4.1e-15
Cp638 bn7 xc4_dip 6.687e-16
Cp639 bn7 xc4_xs1_tail 1.743e-17
Cp640 bn7 xc5_lt 7.318e-18
Cp641 bn7 xs1n_n10 1.382e-19
Cp642 bn8 bn9 4.395e-15
Cp643 bn8 bp12 6.613e-18
Cp644 bn8 clk 7.094e-18
Cp645 bn8 clkb 4.923e-17
Cp646 bn8 cn0 4.614e-17
Cp647 bn8 cn1 5.227e-17
Cp648 bn8 cn10 8.197e-19
Cp649 bn8 cn2 4.614e-17
Cp650 bn8 cn3 5.352e-17
Cp651 bn8 cn4 4.614e-17
Cp652 bn8 cn5 3.528e-16
Cp653 bn8 cn6 3.084e-16
Cp654 bn8 cn7 1.45e-16
Cp655 bn8 cn8 5.802e-16
Cp656 bn8 cn9 1.728e-16
Cp657 bn8 gnd 5.397e-15
Cp658 bn8 lsb_n 5.426e-16
Cp659 bn8 lsb_p 1.027e-15
Cp660 bn8 on 5.087e-17
Cp661 bn8 onn 6.003e-17
Cp662 bn8 onp 6.201e-17
Cp663 bn8 op 4.686e-17
Cp664 bn8 rstb 9.158e-16
Cp665 bn8 t0 1e-18
Cp666 bn8 t0b 1.223e-18
Cp667 top_n gnd 2.126e-16
Cp667x bn8 gnd 2.126e-16
Cp668 top_p gnd 3.132e-18
Cp668x bn8 gnd 3.132e-18
Cp669 bn8 trk0 1.631e-18
Cp670 bn8 trk1 2.088e-18
Cp671 bn8 vdd 1.827e-16
Cp672 bn8 vref 3.502e-16
Cp673 bn8 vrefl 1.895e-16
Cp674 bn8 xc4_din 8.254e-16
Cp675 bn8 xc4_dip 4.618e-16
Cp676 bn9 bp1 5.089e-17
Cp677 bn9 bp10 6.415e-17
Cp678 bn9 bp11 4.808e-17
Cp679 bn9 bp12 4.742e-17
Cp680 bn9 bp2 5.494e-16
Cp681 bn9 bp3 2.762e-16
Cp682 bn9 bp4 4.742e-17
Cp683 bn9 bp5 4.742e-17
Cp684 bn9 bp6 4.742e-17
Cp685 bn9 bp7 4.742e-17
Cp686 bn9 bp8 9.705e-17
Cp687 bn9 bp9 1.172e-15
Cp688 bn9 clkn 6.582e-17
Cp689 bn9 cn0 7.304e-19
Cp690 bn9 cn1 2.58e-17
Cp691 bn9 cn10 1.084e-16
Cp692 bn9 cn11 5.226e-17
Cp693 bn9 cn12 5.218e-17
Cp694 bn9 cn2 1.56e-18
Cp695 bn9 cn3 4.839e-19
Cp696 bn9 cn4 1.056e-18
Cp697 bn9 cn5 8.139e-16
Cp698 bn9 cn6 8.331e-16
Cp699 bn9 cn7 5.971e-16
Cp700 bn9 cn8 6.651e-16
Cp701 bn9 cn9 8.238e-16
Cp702 bn9 cp0 8.434e-18
Cp703 bn9 cp10 5.218e-17
Cp704 bn9 cp11 5.218e-17
Cp705 bn9 cp12 5.218e-17
Cp706 bn9 cp2 7.664e-17
Cp707 bn9 cp3 3.224e-17
Cp708 bn9 cp5 5.456e-17
Cp709 bn9 cp6 1.056e-16
Cp710 bn9 cp8 5.343e-17
Cp711 bn9 cp9 5.218e-17
Cp712 bn9 gnd 4.08e-15
Cp713 bn9 lsb_n 1.612e-16
Cp714 bn9 lsb_p 4.886e-17
Cp715 bn9 on 8.05e-17
Cp716 bn9 op 9.24e-17
Cp717 bn9 rstb 1.926e-16
Cp718 bn9 vdd 6.036e-17
Cp719 bn9 vref 4.532e-16
Cp720 bn9 vrefl 5.574e-18
Cp721 bn9 xc4_din 1.019e-15
Cp722 bn9 xc4_dip 2.2e-16
Cp723 bp0 bp1 2.176e-15
Cp724 bp0 bp10 4.444e-17
Cp725 bp0 bp11 9.649e-17
Cp726 bp0 bp12 5.005e-16
Cp727 bp0 bp2 1.931e-15
Cp728 bp0 bp3 9.685e-16
Cp729 bp0 bp4 5.15e-16
Cp730 bp0 bp5 7.398e-16
Cp731 bp0 bp6 1.791e-15
Cp732 bp0 bp7 8.897e-16
Cp733 bp0 bp8 5.138e-17
Cp734 bp0 clkn 9.272e-17
Cp735 bp0 cn11 8.507e-19
Cp736 bp0 cn12 4.673e-18
Cp737 bp0 cp0 5.667e-16
Cp738 bp0 cp1 9.623e-16
Cp739 bp0 cp10 6.66e-17
Cp740 bp0 cp11 1.338e-16
Cp741 bp0 cp12 7.987e-17
Cp742 bp0 cp2 9.767e-17
Cp743 bp0 cp3 8.787e-16
Cp744 bp0 cp4 5.172e-16
Cp745 bp0 cp5 6.102e-17
Cp746 bp0 cp6 8.668e-16
Cp747 bp0 cp7 6.408e-16
Cp748 bp0 cp8 6.292e-17
Cp749 bp0 cp9 6.361e-17
Cp750 bp0 gnd 4.67e-15
Cp751 bp0 lsb_n 4.735e-17
Cp752 bp0 lsb_p 5.029e-17
Cp753 bp0 vdd 1.84e-16
Cp754 bp0 vrefl 3.83e-16
Cp755 bp0 xc4_din 6.965e-17
Cp756 bp0 xc4_dip 7.224e-17
Cp757 bp1 bp10 4.195e-17
Cp758 bp1 bp11 3.792e-17
Cp759 bp1 bp12 4.274e-16
Cp760 bp1 bp2 8.653e-15
Cp761 bp1 bp3 2.409e-16
Cp762 bp1 bp4 2.976e-16
Cp763 bp1 bp5 1.348e-15
Cp764 bp1 bp6 1.206e-15
Cp765 bp1 bp7 2.271e-15
Cp766 bp1 bp8 4.889e-17
Cp767 bp1 bp9 5.089e-17
Cp768 bp1 clkn 8.396e-17
Cp769 bp1 cn10 9.992e-19
Cp770 bp1 cn11 5.902e-17
Cp771 bp1 cn12 1.33e-16
Cp772 bp1 cp0 2.92e-16
Cp773 bp1 cp1 3.892e-16
Cp774 bp1 cp10 4.944e-17
Cp775 bp1 cp11 4.985e-17
Cp776 bp1 cp12 6.752e-17
Cp777 bp1 cp2 1.312e-16
Cp778 bp1 cp3 3.25e-16
Cp779 bp1 cp4 1.852e-15
Cp780 bp1 cp5 6.046e-17
Cp781 bp1 cp6 1.993e-16
Cp782 bp1 cp7 1.563e-16
Cp783 bp1 cp8 5.203e-17
Cp784 bp1 cp9 4.944e-17
Cp785 bp1 gnd 3.767e-15
Cp786 bp1 lsb_n 4.486e-17
Cp787 bp1 lsb_p 4.095e-17
Cp788 bp1 vdd 2.609e-17
Cp789 bp1 vrefl 8.62e-16
Cp790 bp1 xc4_din 7.27e-17
Cp791 bp1 xc4_dip 6.744e-17
Cp792 bp10 bp11 2.059e-14
Cp793 bp10 bp12 5.803e-15
Cp794 bp10 bp2 3.679e-17
Cp795 bp10 bp3 3.846e-17
Cp796 bp10 bp4 3.882e-17
Cp797 bp10 bp5 3.882e-17
Cp798 bp10 bp6 1.262e-15
Cp799 bp10 bp7 1.234e-15
Cp800 bp10 bp8 1.221e-15
Cp801 bp10 bp9 1.414e-14
Cp802 bp10 clkb 2.703e-17
Cp803 bp10 clkn 3.691e-17
Cp804 bp10 cn0 3.916e-17
Cp805 bp10 cn1 4.529e-17
Cp806 bp10 cn10 3.764e-17
Cp807 bp10 cn11 4.574e-16
Cp808 bp10 cn12 2.705e-16
Cp809 bp10 cn2 3.916e-17
Cp810 bp10 cn3 4.654e-17
Cp811 bp10 cn4 3.916e-17
Cp812 bp10 cn5 4.026e-17
Cp813 bp10 cn6 5.813e-17
Cp814 bp10 cn7 3.307e-17
Cp815 bp10 cn8 7.255e-17
Cp816 bp10 cn9 3.811e-17
Cp817 bp10 cp0 3.921e-17
Cp818 bp10 cp1 3.977e-17
Cp819 bp10 cp10 7.559e-16
Cp820 bp10 cp11 3.169e-16
Cp821 bp10 cp12 3.21e-16
Cp822 bp10 cp2 3.491e-17
Cp823 bp10 cp3 3.921e-17
Cp824 bp10 cp4 3.24e-17
Cp825 bp10 cp5 4.037e-17
Cp826 bp10 cp6 3.357e-17
Cp827 bp10 cp7 3.24e-17
Cp828 bp10 cp8 6.397e-17
Cp829 bp10 cp9 6.629e-16
Cp830 bp10 gnd 4.23e-15
Cp831 bp10 lsb_n 6.515e-17
Cp832 bp10 lsb_p 5.368e-16
Cp833 bp10 on 4.262e-17
Cp834 bp10 onn 5.73e-19
Cp835 bp10 onp 1.628e-19
Cp836 bp10 op 3.311e-17
Cp837 bp10 rstb 1.197e-16
Cp838 bp10 vdd 8.428e-17
Cp839 bp10 vref 9.805e-16
Cp840 bp10 xc4_din 2.697e-16
Cp841 bp10 xc4_dip 9.682e-17
Cp842 bp11 bp12 3.369e-14
Cp843 bp11 bp2 3.275e-17
Cp844 bp11 bp3 3.846e-17
Cp845 bp11 bp4 4.971e-17
Cp846 bp11 bp5 4.698e-16
Cp847 bp11 bp6 2.927e-15
Cp848 bp11 bp7 2.409e-15
Cp849 bp11 bp8 5.255e-16
Cp850 bp11 bp9 7.243e-16
Cp851 bp11 clkb 3.948e-17
Cp852 bp11 clkn 4.071e-17
Cp853 bp11 cn0 2.596e-17
Cp854 bp11 cn1 3.186e-17
Cp855 bp11 cn10 1.362e-16
Cp856 bp11 cn11 5.456e-16
Cp857 bp11 cn12 6.099e-16
Cp858 bp11 cn2 2.574e-17
Cp859 bp11 cn3 6.985e-17
Cp860 bp11 cn4 2.559e-17
Cp861 bp11 cn5 1.153e-16
Cp862 bp11 cn6 3.257e-17
Cp863 bp11 cn7 5.819e-17
Cp864 bp11 cn8 3.924e-17
Cp865 bp11 cn9 6.146e-17
Cp866 bp11 cp0 3.255e-17
Cp867 bp11 cp1 1e-16
Cp868 bp11 cp10 2.085e-16
Cp869 bp11 cp11 1.097e-15
Cp870 bp11 cp12 2.974e-16
Cp871 bp11 cp2 2.965e-17
Cp872 bp11 cp3 3.255e-17
Cp873 bp11 cp4 2.615e-17
Cp874 bp11 cp5 1.137e-16
Cp875 bp11 cp6 3.357e-17
Cp876 bp11 cp7 2.574e-17
Cp877 bp11 cp8 3.919e-17
Cp878 bp11 cp9 9.305e-17
Cp879 bp11 gnd 5.348e-15
Cp880 bp11 lsb_n 7.699e-17
Cp881 bp11 lsb_p 6.188e-16
Cp882 bp11 on 3.186e-17
Cp883 bp11 onn 5.014e-17
Cp884 bp11 onp 1.196e-16
Cp885 bp11 op 3.353e-17
Cp886 bp11 rstb 1.212e-16
Cp887 bp11 t1 8.586e-19
Cp888 bp11 vdd 7.028e-17
Cp889 bp11 vref 1.499e-15
Cp890 bp11 xc4_din 3.177e-16
Cp891 bp11 xc4_dip 8.922e-17
Cp892 bp12 bp2 5.232e-17
Cp893 bp12 bp3 3.179e-16
Cp894 bp12 bp4 5.788e-16
Cp895 bp12 bp5 8.797e-17
Cp896 bp12 bp6 5.777e-15
Cp897 bp12 bp7 5.302e-15
Cp898 bp12 bp8 1.224e-15
Cp899 bp12 bp9 3.168e-15
Cp900 bp12 clkb 3.573e-17
Cp901 bp12 clkn 9.732e-17
Cp902 bp12 cn0 6.518e-17
Cp903 bp12 cn1 6.798e-17
Cp904 bp12 cn10 7.958e-16
Cp905 bp12 cn11 1.473e-15
Cp906 bp12 cn12 7.712e-16
Cp907 bp12 cn2 6.307e-17
Cp908 bp12 cn3 8.235e-17
Cp909 bp12 cn4 6.868e-17
Cp910 bp12 cn5 8.45e-17
Cp911 bp12 cn6 1.026e-16
Cp912 bp12 cn7 8.447e-17
Cp913 bp12 cn8 1.145e-16
Cp914 bp12 cn9 9.801e-17
Cp915 bp12 cp0 1.108e-16
Cp916 bp12 cp1 6.612e-17
Cp917 bp12 cp10 4.303e-17
Cp918 bp12 cp11 2.788e-16
Cp919 bp12 cp12 4.822e-16
Cp920 bp12 cp2 4.202e-17
Cp921 bp12 cp3 6.619e-17
Cp922 bp12 cp4 7.123e-17
Cp923 bp12 cp5 9.67e-17
Cp924 bp12 cp6 4.594e-17
Cp925 bp12 cp7 5.633e-17
Cp926 bp12 cp8 1.2e-16
Cp927 bp12 cp9 7.75e-17
Cp928 bp12 gnd 7.439e-15
Cp929 bp12 lsb_n 1.036e-16
Cp930 bp12 lsb_p 1.762e-14
Cp931 bp12 on 3.55e-17
Cp932 bp12 onn 1.317e-16
Cp933 bp12 onp 9.16e-17
Cp934 bp12 op 6.04e-17
Cp935 bp12 rstb 1.013e-16
Cp936 bp12 t1 1.955e-16
Cp937 top_p gnd 1.311e-17
Cp937x bp12 gnd 1.311e-17
Cp938 bp12 vdd 3.976e-17
Cp939 bp12 vref 1.124e-15
Cp940 bp12 xc4_din 1.638e-16
Cp941 bp12 xc4_dip 7.1e-17
Cp942 bp2 bp3 1.424e-14
Cp943 bp2 bp4 4.471e-16
Cp944 bp2 bp5 3.429e-15
Cp945 bp2 bp6 1.844e-15
Cp946 bp2 bp7 2.839e-15
Cp947 bp2 bp8 4.942e-17
Cp948 bp2 bp9 5.494e-16
Cp949 bp2 clkn 7.422e-17
Cp950 bp2 cn0 5.517e-17
Cp951 bp2 cn1 8.264e-17
Cp952 bp2 cn10 5.034e-17
Cp953 bp2 cn11 5.037e-17
Cp954 bp2 cn12 3.799e-17
Cp955 bp2 cn2 7.934e-17
Cp956 bp2 cn3 5.602e-17
Cp957 bp2 cn4 8.511e-17
Cp958 bp2 cn5 5.264e-17
Cp959 bp2 cn6 4.49e-17
Cp960 bp2 cn7 4.526e-17
Cp961 bp2 cn8 5.162e-17
Cp962 bp2 cn9 5.037e-17
Cp963 bp2 cp0 8.49e-17
Cp964 bp2 cp1 1.523e-16
Cp965 bp2 cp10 3.799e-17
Cp966 bp2 cp11 3.799e-17
Cp967 bp2 cp12 3.799e-17
Cp968 bp2 cp2 1.282e-15
Cp969 bp2 cp3 5.301e-16
Cp970 bp2 cp4 6.551e-16
Cp971 bp2 cp5 5.881e-16
Cp972 bp2 cp6 5.483e-16
Cp973 bp2 cp7 1.198e-15
Cp974 bp2 cp8 3.029e-16
Cp975 bp2 cp9 3.799e-17
Cp976 bp2 gnd 4.036e-15
Cp977 bp2 lsb_n 4.539e-17
Cp978 bp2 lsb_p 5.725e-17
Cp979 bp2 on 4.835e-17
Cp980 bp2 op 4.588e-17
Cp981 bp2 vdd 3.423e-17
Cp982 bp2 vrefl 7.407e-16
Cp983 bp2 xc4_din 1.277e-16
Cp984 bp2 xc4_dip 4.366e-17
Cp985 bp3 bp4 2.418e-14
Cp986 bp3 bp5 6.295e-15
Cp987 bp3 bp6 3.567e-15
Cp988 bp3 bp7 4.6e-15
Cp989 bp3 bp8 4.629e-17
Cp990 bp3 bp9 2.676e-16
Cp991 bp3 clkb 4.943e-17
Cp992 bp3 clkn 7.937e-16
Cp993 bp3 cn0 3.873e-17
Cp994 bp3 cn1 3.186e-17
Cp995 bp3 cn10 3.799e-17
Cp996 bp3 cn11 3.799e-17
Cp997 bp3 cn12 3.799e-17
Cp998 bp3 cn2 2.574e-17
Cp999 bp3 cn3 4.61e-17
Cp1000 bp3 cn4 2.559e-17
Cp1001 bp3 cn5 4.837e-17
Cp1002 bp3 cn6 1.114e-16
Cp1003 bp3 cn7 9.071e-17
Cp1004 bp3 cn8 4.171e-17
Cp1005 bp3 cn9 3.799e-17
Cp1006 bp3 cp0 3.921e-17
Cp1007 bp3 cp1 4.747e-17
Cp1008 bp3 cp10 3.799e-17
Cp1009 bp3 cp11 3.799e-17
Cp1010 bp3 cp12 3.799e-17
Cp1011 bp3 cp2 9.386e-17
Cp1012 bp3 cp3 1.192e-16
Cp1013 bp3 cp4 5.619e-17
Cp1014 bp3 cp5 3.13e-16
Cp1015 bp3 cp6 7.335e-16
Cp1016 bp3 cp7 4.734e-16
Cp1017 bp3 cp8 1.923e-16
Cp1018 bp3 cp9 3.799e-17
Cp1019 bp3 gnd 6.017e-15
Cp1020 bp3 lsb_n 4.629e-17
Cp1021 bp3 lsb_p 1.228e-16
Cp1022 bp3 on 3.186e-17
Cp1023 bp3 onn 1.246e-16
Cp1024 bp3 onp 4.881e-17
Cp1025 bp3 op 3.311e-17
Cp1026 bp3 rstb 1.641e-17
Cp1027 bp3 vdd 1.354e-16
Cp1028 bp3 vrefl 7.93e-16
Cp1029 bp3 xc4_din 7.487e-16
Cp1030 bp3 xc4_dip 1.658e-15
Cp1031 bp4 bp5 4.039e-14
Cp1032 bp4 bp6 5.815e-15
Cp1033 bp4 bp7 5.671e-15
Cp1034 bp4 bp8 4.576e-17
Cp1035 bp4 bp9 3.882e-17
Cp1036 bp4 clkb 2.574e-17
Cp1037 bp4 clkn 2.124e-16
Cp1038 bp4 cn0 2.574e-17
Cp1039 bp4 cn1 3.186e-17
Cp1040 bp4 cn10 4.026e-17
Cp1041 bp4 cn11 3.799e-17
Cp1042 bp4 cn12 3.833e-17
Cp1043 bp4 cn2 2.574e-17
Cp1044 bp4 cn3 3.631e-17
Cp1045 bp4 cn4 2.653e-17
Cp1046 bp4 cn5 8.043e-17
Cp1047 bp4 cn6 3.257e-17
Cp1048 bp4 cn7 3.289e-17
Cp1049 bp4 cn8 1.185e-16
Cp1050 bp4 cn9 1.032e-16
Cp1051 bp4 cp0 3.255e-17
Cp1052 bp4 cp1 4.302e-17
Cp1053 bp4 cp10 3.943e-17
Cp1054 bp4 cp11 5.458e-17
Cp1055 bp4 cp12 3.44e-16
Cp1056 bp4 cp2 3.03e-17
Cp1057 bp4 cp3 6.54e-17
Cp1058 bp4 cp4 2.604e-16
Cp1059 bp4 cp5 3.385e-16
Cp1060 bp4 cp6 2.929e-16
Cp1061 bp4 cp7 5.007e-17
Cp1062 bp4 cp8 7.381e-16
Cp1063 bp4 cp9 8.697e-17
Cp1064 bp4 gnd 6.093e-15
Cp1065 bp4 lsb_n 4.576e-17
Cp1066 bp4 lsb_p 1.152e-16
Cp1067 bp4 on 3.261e-17
Cp1068 bp4 onn 4.553e-17
Cp1069 bp4 onp 6.156e-17
Cp1070 bp4 op 6.288e-17
Cp1071 bp4 rstb 7.091e-17
Cp1072 bp4 vdd 6.167e-17
Cp1073 bp4 vref 1.474e-19
Cp1074 bp4 vrefl 2.169e-15
Cp1075 bp4 xc4_din 2.862e-16
Cp1076 bp4 xc4_dip 7.074e-17
Cp1077 bp5 bp6 1.273e-14
Cp1078 bp5 bp7 1.788e-14
Cp1079 bp5 bp8 7.048e-17
Cp1080 bp5 bp9 3.882e-17
Cp1081 bp5 clk 4.012e-18
Cp1082 bp5 clkb 6.274e-17
Cp1083 bp5 clkn 7.585e-17
Cp1084 bp5 cn0 3.827e-17
Cp1085 bp5 cn1 6.813e-17
Cp1086 bp5 cn10 1.472e-16
Cp1087 bp5 cn11 8.756e-17
Cp1088 bp5 cn12 5.82e-17
Cp1089 bp5 cn2 3.984e-17
Cp1090 bp5 cn3 8.495e-17
Cp1091 bp5 cn4 3.836e-17
Cp1092 bp5 cn5 1.373e-16
Cp1093 bp5 cn6 7.42e-17
Cp1094 bp5 cn7 7.261e-17
Cp1095 bp5 cn8 8.724e-17
Cp1096 bp5 cn9 7.571e-17
Cp1097 bp5 cp0 5.456e-17
Cp1098 bp5 cp1 1.191e-16
Cp1099 bp5 cp10 1.536e-16
Cp1100 bp5 cp11 1.57e-16
Cp1101 bp5 cp12 4.146e-16
Cp1102 bp5 cp2 9.691e-17
Cp1103 bp5 cp3 7.262e-17
Cp1104 bp5 cp4 1.772e-16
Cp1105 bp5 cp5 1.567e-15
Cp1106 bp5 cp6 1.043e-15
Cp1107 bp5 cp7 1.015e-16
Cp1108 bp5 cp8 4.488e-16
Cp1109 bp5 cp9 1.414e-16
Cp1110 bp5 gnd 1.101e-14
Cp1111 bp5 lsb_n 4.576e-17
Cp1112 bp5 lsb_p 8.33e-17
Cp1113 bp5 on 1.106e-16
Cp1114 bp5 onn 4.9e-17
Cp1115 bp5 onp 1.23e-16
Cp1116 bp5 op 1.051e-16
Cp1117 bp5 rstb 5.902e-18
Cp1118 top_p gnd 3.138e-19
Cp1118x bp5 gnd 3.138e-19
Cp1119 bp5 vdd 1.059e-16
Cp1120 bp5 vref 2.932e-19
Cp1121 bp5 vrefl 6.887e-16
Cp1122 bp5 xc4_din 3.252e-16
Cp1123 bp5 xc4_dip 5.801e-17
Cp1124 bp5 xs0p_x 1.022e-19
Cp1125 bp5 xs1p_n10 1.9e-18
Cp1126 bp6 bp7 1.438e-14
Cp1127 bp6 bp8 8.036e-16
Cp1128 bp6 bp9 6.632e-16
Cp1129 bp6 clk 4.012e-18
Cp1130 bp6 clkb 1.072e-16
Cp1131 bp6 clkn 1.558e-16
Cp1132 bp6 cn0 1.253e-16
Cp1133 bp6 cn1 1.518e-16
Cp1134 bp6 cn10 2.085e-16
Cp1135 bp6 cn11 1.949e-16
Cp1136 bp6 cn12 2.127e-16
Cp1137 bp6 cn2 1.43e-16
Cp1138 bp6 cn3 1.887e-16
Cp1139 bp6 cn4 1.522e-16
Cp1140 bp6 cn5 2.523e-16
Cp1141 bp6 cn6 2.426e-16
Cp1142 bp6 cn7 1.844e-16
Cp1143 bp6 cn8 2.333e-16
Cp1144 bp6 cn9 1.962e-16
Cp1145 bp6 cp0 1.635e-16
Cp1146 bp6 cp1 1.732e-16
Cp1147 bp6 cp10 3.013e-16
Cp1148 bp6 cp11 7.204e-16
Cp1149 bp6 cp12 7.486e-16
Cp1150 bp6 cp2 1.35e-16
Cp1151 bp6 cp3 1.231e-16
Cp1152 bp6 cp4 9.672e-17
Cp1153 bp6 cp5 4.044e-16
Cp1154 bp6 cp6 3.642e-16
Cp1155 bp6 cp7 7.662e-17
Cp1156 bp6 cp8 6.988e-16
Cp1157 bp6 cp9 2.175e-16
Cp1158 bp6 gnd 3.039e-14
Cp1159 bp6 lsb_n 4.586e-17
Cp1160 bp6 lsb_p 4.01e-16
Cp1161 bp6 on 1.957e-16
Cp1162 bp6 onn 1.947e-16
Cp1163 bp6 onp 2.15e-16
Cp1164 bp6 op 1.943e-16
Cp1165 bp6 rstb 5.843e-17
Cp1166 bp6 t1 1.561e-16
Cp1167 bp6 t1b 7.354e-18
Cp1168 top_p gnd 1.027e-17
Cp1168x bp6 gnd 1.027e-17
Cp1169 bp6 vdd 1.251e-16
Cp1170 bp6 vref 2.287e-17
Cp1171 bp6 vrefl 1.232e-15
Cp1172 bp6 xc4_din 3.598e-16
Cp1173 bp6 xc4_dip 1.416e-15
Cp1174 bp7 bp8 1.69e-15
Cp1175 bp7 bp9 7.844e-16
Cp1176 bp7 clk 8.025e-18
Cp1177 bp7 clkb 1.951e-16
Cp1178 bp7 clkn 3.449e-16
Cp1179 bp7 cn0 2.167e-16
Cp1180 bp7 cn1 2.747e-16
Cp1181 bp7 cn10 3.874e-16
Cp1182 bp7 cn11 3.673e-16
Cp1183 bp7 cn12 3.878e-16
Cp1184 bp7 cn2 2.082e-16
Cp1185 bp7 cn3 3.431e-16
Cp1186 bp7 cn4 2.241e-16
Cp1187 bp7 cn5 4.733e-16
Cp1188 bp7 cn6 3.813e-16
Cp1189 bp7 cn7 3.364e-16
Cp1190 bp7 cn8 4.336e-16
Cp1191 bp7 cn9 3.624e-16
Cp1192 bp7 cp0 3.322e-16
Cp1193 bp7 cp1 3.582e-16
Cp1194 bp7 cp10 6.989e-16
Cp1195 bp7 cp11 5.201e-16
Cp1196 bp7 cp12 8.795e-16
Cp1197 bp7 cp2 2.592e-16
Cp1198 bp7 cp3 3.117e-16
Cp1199 bp7 cp4 2.087e-16
Cp1200 bp7 cp5 4.376e-16
Cp1201 bp7 cp6 4.91e-16
Cp1202 bp7 cp7 3.794e-16
Cp1203 bp7 cp8 5.77e-16
Cp1204 bp7 cp9 5.04e-16
Cp1205 bp7 gnd 4.671e-14
Cp1206 bp7 lsb_n 4.576e-17
Cp1207 bp7 lsb_p 3.374e-15
Cp1208 bp7 on 2.98e-16
Cp1209 bp7 onn 3.589e-16
Cp1210 bp7 onp 4.161e-16
Cp1211 bp7 op 3.542e-16
Cp1212 bp7 rstb 8.07e-17
Cp1213 top_p gnd 4.329e-18
Cp1213x bp7 gnd 4.329e-18
Cp1214 bp7 trk0 7.076e-19
Cp1215 bp7 trk1 2.391e-18
Cp1216 bp7 vdd 3.938e-16
Cp1217 bp7 vref 7.834e-17
Cp1218 bp7 vrefl 3.225e-16
Cp1219 bp7 xc4_din 3.63e-16
Cp1220 bp7 xc4_dip 9.804e-16
Cp1221 bp7 xs1p_cbp 2.091e-19
Cp1222 bp7 xs1p_g 5.339e-19
Cp1223 bp8 bp9 4.589e-15
Cp1224 bp8 clkn 4.836e-17
Cp1225 bp8 cn12 7.083e-16
Cp1226 bp8 cp0 5.067e-17
Cp1227 bp8 cp1 5.123e-17
Cp1228 bp8 cp10 5.802e-16
Cp1229 bp8 cp11 8.411e-17
Cp1230 bp8 cp12 2.714e-16
Cp1231 bp8 cp2 4.637e-17
Cp1232 bp8 cp3 5.067e-17
Cp1233 bp8 cp4 4.385e-17
Cp1234 bp8 cp5 5.182e-17
Cp1235 bp8 cp6 3.526e-16
Cp1236 bp8 cp7 4.453e-17
Cp1237 bp8 cp8 5.144e-16
Cp1238 bp8 cp9 4.001e-16
Cp1239 bp8 gnd 4.704e-15
Cp1240 bp8 lsb_n 2.353e-15
Cp1241 bp8 lsb_p 2.318e-16
Cp1242 bp8 rstb 8.463e-17
Cp1243 bp8 t1 1.695e-16
Cp1244 bp8 t1b 1.617e-17
Cp1245 top_n gnd 3.779e-18
Cp1245x bp8 gnd 3.779e-18
Cp1246 top_p gnd 2.171e-16
Cp1246x bp8 gnd 2.171e-16
Cp1247 bp8 vdd 1.068e-16
Cp1248 bp8 vref 4.59e-16
Cp1249 bp8 vrefl 5.572e-18
Cp1250 bp8 xc4_din 3.598e-16
Cp1251 bp8 xc4_dip 1.04e-16
Cp1252 bp9 clkn 5.169e-17
Cp1253 bp9 cn0 7.304e-19
Cp1254 bp9 cn1 2.58e-17
Cp1255 bp9 cn10 5.037e-17
Cp1256 bp9 cn11 5.071e-17
Cp1257 bp9 cn12 2.572e-16
Cp1258 bp9 cn2 1.56e-18
Cp1259 bp9 cn3 4.839e-19
Cp1260 bp9 cn4 1.056e-18
Cp1261 bp9 cn5 5.701e-17
Cp1262 bp9 cn6 4.607e-17
Cp1263 bp9 cn7 4.587e-17
Cp1264 bp9 cn8 5.162e-17
Cp1265 bp9 cn9 5.037e-17
Cp1266 bp9 cp0 8.434e-18
Cp1267 bp9 cp10 4.067e-16
Cp1268 bp9 cp11 1.488e-16
Cp1269 bp9 cp12 1.063e-15
Cp1270 bp9 cp2 7.359e-17
Cp1271 bp9 cp3 3.224e-17
Cp1272 bp9 cp5 4.037e-17
Cp1273 bp9 cp6 9.143e-17
Cp1274 bp9 cp8 2.244e-16
Cp1275 bp9 cp9 1.334e-15
Cp1276 bp9 gnd 3.408e-15
Cp1277 bp9 lsb_n 5.488e-16
Cp1278 bp9 lsb_p 1.564e-16
Cp1279 bp9 on 8.306e-17
Cp1280 bp9 op 1.054e-16
Cp1281 bp9 rstb 8.618e-17
Cp1282 bp9 vdd 8.488e-17
Cp1283 bp9 vref 8.308e-16
Cp1284 bp9 xc4_din 2.513e-16
Cp1285 bp9 xc4_dip 6.788e-17
Cp1286 clk gnd 1.252e-14
Cp1287 clk lsb_n 4.87e-17
Cp1288 clk lsb_p 2.181e-16
Cp1289 clk on 1.957e-17
Cp1290 clk onn 2.443e-17
Cp1291 clk onp 1.896e-17
Cp1292 clk op 1.77e-18
Cp1293 clk t0 1.383e-15
Cp1294 clk t0b 2.279e-16
Cp1295 top_n gnd 6.524e-17
Cp1295x clk gnd 6.524e-17
Cp1296 top_p gnd 1.36e-16
Cp1296x clk gnd 1.36e-16
Cp1297 clk trk0 2.718e-16
Cp1298 clk trk1 1.286e-16
Cp1299 clk vdd 1.034e-15
Cp1300 clk xc4_lt 4.907e-17
Cp1301 clk xc5_outnb 8.973e-17
Cp1302 clk xc5_outpb 3.739e-17
Cp1303 clk xs0n_cbn 2.987e-17
Cp1304 clk xs0n_g 4.481e-16
Cp1305 clk xs0n_x 3.276e-17
Cp1306 clk xs0p_cbn 2.574e-16
Cp1307 clk xs0p_cbp 3.641e-18
Cp1308 clk xs0p_g 2.53e-17
Cp1309 clk xs0p_x 3.719e-17
Cp1310 clkb clkn 4.161e-17
Cp1311 clkb cp7 2.172e-19
Cp1312 clkb gnd 4.309e-14
Cp1313 clkb lsb_n 6.145e-17
Cp1314 clkb lsb_p 9.846e-17
Cp1315 clkb on 1.727e-16
Cp1316 clkb onn 4.892e-17
Cp1317 clkb onp 1.286e-18
Cp1318 clkb op 1.111e-16
Cp1319 clkb rstb 6.083e-17
Cp1320 clkb t1 5.753e-17
Cp1321 clkb t1b 5.95e-17
Cp1322 top_p gnd 9.308e-17
Cp1322x clkb gnd 9.308e-17
Cp1323 clkb vbp 1.024e-16
Cp1324 clkb vdd 1.104e-14
Cp1325 clkb vref 5.27e-16
Cp1326 clkb vrefl 3.46e-16
Cp1327 clkb xc4_din 2.738e-16
Cp1328 clkb xc4_dip 5.604e-16
Cp1329 clkb xc4_outnb 5.61e-17
Cp1330 clkb xc4_outpb 5.537e-17
Cp1331 clkb xc4_xs1_tail 1.146e-16
Cp1332 clkb xc4_xs1_tail0 4.477e-16
Cp1333 clkb xc5_din 1.099e-16
Cp1334 clkb xc5_dip 5.332e-17
Cp1335 clkb xc5_lt 5.323e-17
Cp1336 clkb xc5_outnb 2.1e-17
Cp1337 clkb xc5_outpb 3.02e-19
Cp1338 clkb xc5_xs1_tail 5.555e-17
Cp1339 clkn clknb 6.38e-17
Cp1340 clkn cp0 3.492e-17
Cp1341 clkn cp1 4.981e-17
Cp1342 clkn cp2 1.146e-16
Cp1343 clkn cp3 2.69e-16
Cp1344 clkn cp4 1.136e-16
Cp1345 clkn cp5 4.746e-16
Cp1346 clkn cp6 2.135e-15
Cp1347 clkn cp7 1.04e-16
Cp1348 clkn cp8 7.701e-17
Cp1349 clkn gnd 2.808e-14
Cp1350 clkn lsb_n 4.836e-17
Cp1351 clkn lsb_p 7.313e-19
Cp1352 clkn onn 4.168e-17
Cp1353 clkn onp 3.467e-17
Cp1354 clkn t1 6.32e-17
Cp1355 clkn t1b 5.135e-17
Cp1356 top_n gnd 2.498e-16
Cp1356x clkn gnd 2.498e-16
Cp1357 top_p gnd 2.914e-17
Cp1357x clkn gnd 2.914e-17
Cp1358 clkn vbn 1.462e-16
Cp1359 clkn vbp 1.614e-18
Cp1360 clkn vdd 1.072e-15
Cp1361 clkn vrefl 4.036e-16
Cp1362 clkn xc4_din 7.13e-16
Cp1363 clkn xc4_dip 2.371e-16
Cp1364 clkn xc4_xs1_tail 6.147e-17
Cp1365 clkn xc5_din 7.635e-16
Cp1366 clkn xc5_dip 5.178e-16
Cp1367 clkn xc5_lt 3.823e-16
Cp1368 clkn xc5_xs1_tail 1.794e-17
Cp1369 clkn xc5_xs1_tail0 2.326e-16
Cp1370 clknb gnd 1.994e-14
Cp1371 clknb in1n 5.961e-17
Cp1372 clknb in1p 3.286e-15
Cp1373 clknb t1 3.214e-16
Cp1374 clknb t1b 1.697e-18
Cp1375 top_n gnd 2.254e-18
Cp1375x clknb gnd 2.254e-18
Cp1376 top_p gnd 5.743e-19
Cp1376x clknb gnd 5.743e-19
Cp1377 clknb vdd 1.009e-15
Cp1378 clknb xc5_din 8.613e-19
Cp1379 clknb xc5_dip 2.296e-19
Cp1380 clknb xc5_lt 5.603e-16
Cp1381 clknb xs1n_cbn 2.489e-16
Cp1382 clknb xs1n_cbp 5.709e-19
Cp1383 clknb xs1n_g 1.164e-17
Cp1384 clknb xs1n_n10 1.382e-18
Cp1385 clknb xs1n_x 9.997e-17
Cp1386 clknb xs1p_cbn 2.255e-16
Cp1387 clknb xs1p_cbp 6.856e-18
Cp1388 clknb xs1p_g 4.543e-17
Cp1389 clknb xs1p_n10 1.74e-18
Cp1390 clknb xs1p_x 8.19e-17
Cp1391 cn0 cn1 2.27e-16
Cp1392 cn0 cn2 3.685e-17
Cp1393 cn0 cn3 9.643e-15
Cp1394 cn0 cn4 9.334e-15
Cp1395 cn0 gnd 2.966e-15
Cp1396 cn0 lsb_n 6.82e-17
Cp1397 cn0 lsb_p 3.812e-17
Cp1398 cn0 on 1.416e-16
Cp1399 cn0 op 4.996e-17
Cp1400 cn0 vdd 7.656e-18
Cp1401 cn0 vrefl 5.271e-17
Cp1402 cn0 xc4_din 4.316e-17
Cp1403 cn0 xc4_dip 7.752e-17
Cp1404 cn0 xc4_outnb 4.378e-17
Cp1405 cn0 xc4_outpb 6.236e-17
Cp1406 cn1 cn2 8.348e-15
Cp1407 cn1 cn3 1.128e-16
Cp1408 cn1 cn4 1.045e-15
Cp1409 cn1 gnd 3.702e-15
Cp1410 cn1 lsb_n 7.917e-17
Cp1411 cn1 lsb_p 4.424e-17
Cp1412 cn1 on 1.788e-15
Cp1413 cn1 op 6.066e-16
Cp1414 cn1 vdd 1.363e-16
Cp1415 cn1 vrefl 9.066e-17
Cp1416 cn1 xc4_din 6.771e-16
Cp1417 cn1 xc4_dip 2.576e-16
Cp1418 cn1 xc4_outnb 4.282e-17
Cp1419 cn1 xc4_outpb 7.411e-17
Cp1420 cn10 cn11 2.742e-15
Cp1421 cn10 cn12 1.199e-16
Cp1422 cn10 cn5 1.115e-19
Cp1423 cn10 cn6 1.645e-17
Cp1424 cn10 cn7 7.015e-16
Cp1425 cn10 cn8 2.538e-16
Cp1426 cn10 cn9 2.032e-15
Cp1427 cn10 cp12 1.061e-16
Cp1428 cn10 gnd 6.094e-15
Cp1429 cn10 lsb_n 5.037e-17
Cp1430 cn10 lsb_p 5.034e-17
Cp1431 cn10 rstb 1.375e-16
Cp1432 cn10 vdd 8.127e-17
Cp1433 cn10 vref 1.343e-15
Cp1434 cn10 xc4_din 6.256e-17
Cp1435 cn10 xc4_dip 7.099e-17
Cp1436 cn11 cn12 1.986e-15
Cp1437 cn11 cn7 3.132e-18
Cp1438 cn11 cn8 2.667e-19
Cp1439 cn11 cn9 1.306e-16
Cp1440 cn11 cp10 9.939e-17
Cp1441 cn11 cp11 3.866e-16
Cp1442 cn11 cp12 2.141e-17
Cp1443 cn11 cp9 5.147e-19
Cp1444 cn11 gnd 5.653e-15
Cp1445 cn11 lsb_n 5.037e-17
Cp1446 cn11 lsb_p 5.037e-17
Cp1447 cn11 rstb 1.135e-16
Cp1448 cn11 vdd 5.383e-17
Cp1449 cn11 vref 2.497e-15
Cp1450 cn11 xc4_din 6.076e-16
Cp1451 cn11 xc4_dip 5.196e-16
Cp1452 cn12 cn9 2.754e-18
Cp1453 cn12 cp10 1.313e-16
Cp1454 cn12 cp11 1.644e-15
Cp1455 cn12 cp12 3.393e-15
Cp1456 cn12 cp6 1.115e-19
Cp1457 cn12 cp8 1.113e-16
Cp1458 cn12 cp9 1.387e-16
Cp1459 cn12 gnd 5.64e-15
Cp1460 cn12 lsb_n 5.037e-17
Cp1461 cn12 lsb_p 5.037e-17
Cp1462 cn12 rstb 1.245e-16
Cp1463 cn12 vdd 1.705e-16
Cp1464 cn12 vref 1.643e-15
Cp1465 cn12 vrefl 2.02e-18
Cp1466 cn12 xc4_din 4.692e-16
Cp1467 cn12 xc4_dip 8.066e-16
Cp1468 cn2 cn3 7.991e-16
Cp1469 cn2 cn4 8.021e-15
Cp1470 cn2 gnd 3.081e-15
Cp1471 cn2 lsb_n 7.209e-17
Cp1472 cn2 lsb_p 3.812e-17
Cp1473 cn2 on 1.085e-16
Cp1474 cn2 op 7.824e-16
Cp1475 cn2 vdd 4.646e-17
Cp1476 cn2 vrefl 9.855e-16
Cp1477 cn2 xc4_din 4.726e-17
Cp1478 cn2 xc4_dip 5.158e-16
Cp1479 cn2 xc4_outnb 2.028e-16
Cp1480 cn2 xc4_outpb 3.35e-16
Cp1481 cn3 cn4 1.519e-15
Cp1482 cn3 cn5 1.2e-19
Cp1483 cn3 gnd 5.996e-15
Cp1484 cn3 lsb_n 7.319e-17
Cp1485 cn3 lsb_p 4.549e-17
Cp1486 cn3 on 1.639e-16
Cp1487 cn3 op 2.202e-16
Cp1488 cn3 vdd 4.642e-18
Cp1489 cn3 vrefl 3.866e-16
Cp1490 cn3 xc4_din 4.071e-17
Cp1491 cn3 xc4_dip 7.196e-17
Cp1492 cn3 xc4_outnb 2.813e-15
Cp1493 cn3 xc4_outpb 3.511e-18
Cp1494 cn4 cn5 7.168e-16
Cp1495 cn4 cn6 5.597e-18
Cp1496 cn4 gnd 3.849e-15
Cp1497 cn4 lsb_n 7.611e-17
Cp1498 cn4 lsb_p 3.796e-17
Cp1499 cn4 on 6.82e-16
Cp1500 cn4 op 1.058e-16
Cp1501 cn4 rstb 3.622e-17
Cp1502 cn4 vdd 1.67e-17
Cp1503 cn4 vrefl 1.134e-15
Cp1504 cn4 xc4_din 4.123e-17
Cp1505 cn4 xc4_dip 6.342e-16
Cp1506 cn4 xc4_outnb 2.12e-17
Cp1507 cn4 xc4_outpb 4.74e-19
Cp1508 cn5 cn6 3.645e-16
Cp1509 cn5 cn7 3.022e-15
Cp1510 cn5 cn8 8.239e-17
Cp1511 cn5 cn9 3.239e-17
Cp1512 cn5 gnd 5.982e-15
Cp1513 cn5 lsb_n 1.378e-15
Cp1514 cn5 lsb_p 5.264e-17
Cp1515 cn5 on 5.948e-18
Cp1516 cn5 rstb 3.612e-16
Cp1517 cn5 vdd 6.457e-16
Cp1518 cn5 vref 4.192e-16
Cp1519 cn5 vrefl 1.516e-15
Cp1520 cn5 xc4_din 1.758e-16
Cp1521 cn5 xc4_dip 9.002e-16
Cp1522 cn5 xc4_outnb 1.024e-19
Cp1523 cn6 cn7 9.118e-15
Cp1524 cn6 cn8 2.141e-15
Cp1525 cn6 cn9 9.16e-17
Cp1526 cn6 gnd 5.316e-15
Cp1527 cn6 lsb_n 5.531e-17
Cp1528 cn6 lsb_p 4.49e-17
Cp1529 cn6 on 2.166e-18
Cp1530 cn6 rstb 3.436e-16
Cp1531 cn6 vdd 2.138e-16
Cp1532 cn6 vref 1.703e-16
Cp1533 cn6 vrefl 1.815e-16
Cp1534 cn6 xc4_din 5.19e-17
Cp1535 cn6 xc4_dip 9.647e-16
Cp1536 cn7 cn8 3.349e-16
Cp1537 cn7 cn9 9.845e-16
Cp1538 cn7 gnd 4.386e-15
Cp1539 cn7 lsb_n 3.326e-17
Cp1540 cn7 lsb_p 4.526e-17
Cp1541 cn7 rstb 6.551e-16
Cp1542 cn7 vdd 1.1e-16
Cp1543 cn7 vref 4.466e-16
Cp1544 cn7 vrefl 1.645e-16
Cp1545 cn7 xc4_din 5.461e-17
Cp1546 cn7 xc4_dip 3.569e-16
Cp1547 cn8 cn9 2.416e-15
Cp1548 cn8 gnd 5.91e-15
Cp1549 cn8 lsb_n 8.545e-17
Cp1550 cn8 lsb_p 5.162e-17
Cp1551 cn8 rstb 8.455e-16
Cp1552 cn8 vdd 1.182e-16
Cp1553 cn8 vref 4.038e-16
Cp1554 cn8 vrefl 1.107e-17
Cp1555 cn8 xc4_din 9.391e-17
Cp1556 cn8 xc4_dip 7.24e-16
Cp1557 cn9 gnd 5.261e-15
Cp1558 cn9 lsb_n 5.037e-17
Cp1559 cn9 lsb_p 5.037e-17
Cp1560 cn9 rstb 1.965e-16
Cp1561 cn9 vdd 1.835e-16
Cp1562 cn9 vref 1.328e-15
Cp1563 cn9 vrefl 4.221e-19
Cp1564 cn9 xc4_din 5.622e-17
Cp1565 cn9 xc4_dip 2.147e-16
Cp1566 cp0 cp1 4.597e-16
Cp1567 cp0 cp2 9.359e-16
Cp1568 cp0 cp3 1.094e-15
Cp1569 cp0 cp4 1.914e-15
Cp1570 cp0 cp6 1.176e-15
Cp1571 cp0 cp7 8.111e-15
Cp1572 cp0 gnd 4.407e-15
Cp1573 cp0 lsb_n 4.401e-17
Cp1574 cp0 lsb_p 4.249e-17
Cp1575 cp0 vdd 2.314e-16
Cp1576 cp0 vrefl 1.799e-16
Cp1577 cp0 xc4_din 6.126e-17
Cp1578 cp0 xc4_dip 4.008e-17
Cp1579 cp1 cp2 1.293e-15
Cp1580 cp1 cp3 8.961e-16
Cp1581 cp1 cp4 8.481e-15
Cp1582 cp1 cp6 5.708e-17
Cp1583 cp1 cp7 1.604e-15
Cp1584 cp1 gnd 5.633e-15
Cp1585 cp1 lsb_n 4.457e-17
Cp1586 cp1 lsb_p 4.051e-17
Cp1587 cp1 vdd 2.355e-16
Cp1588 cp1 vrefl 3.965e-16
Cp1589 cp1 xc4_din 6.217e-17
Cp1590 cp1 xc4_dip 8.463e-16
Cp1591 cp10 cp11 3.281e-15
Cp1592 cp10 cp12 2.917e-16
Cp1593 cp10 cp6 3.838e-18
Cp1594 cp10 cp7 3.438e-18
Cp1595 cp10 cp8 2.492e-16
Cp1596 cp10 cp9 3.056e-15
Cp1597 cp10 gnd 6.044e-15
Cp1598 cp10 lsb_n 5.037e-17
Cp1599 cp10 lsb_p 7.327e-17
Cp1600 cp10 rstb 1.364e-16
Cp1601 cp10 vdd 2.497e-16
Cp1602 cp10 vref 1.121e-15
Cp1603 cp10 vrefl 1.845e-17
Cp1604 cp10 xc4_din 8.497e-16
Cp1605 cp10 xc4_dip 4.48e-17
Cp1606 cp11 cp12 3.548e-15
Cp1607 cp11 cp8 8.336e-17
Cp1608 cp11 cp9 1.641e-16
Cp1609 cp11 gnd 4.885e-15
Cp1610 cp11 lsb_n 5.037e-17
Cp1611 cp11 lsb_p 5.849e-17
Cp1612 cp11 rstb 5.342e-17
Cp1613 cp11 vdd 3.11e-16
Cp1614 cp11 vref 1.496e-15
Cp1615 cp11 vrefl 1.963e-17
Cp1616 cp11 xc4_din 7.991e-16
Cp1617 cp11 xc4_dip 4.317e-17
Cp1618 cp12 cp5 5.497e-18
Cp1619 cp12 cp6 6.701e-17
Cp1620 cp12 cp7 2.003e-19
Cp1621 cp12 cp8 5.596e-17
Cp1622 cp12 cp9 3.336e-16
Cp1623 cp12 gnd 6.209e-15
Cp1624 cp12 lsb_n 5.037e-17
Cp1625 cp12 lsb_p 6.318e-17
Cp1626 cp12 rstb 2.046e-16
Cp1627 cp12 vdd 2.284e-16
Cp1628 cp12 vref 1.084e-15
Cp1629 cp12 vrefl 1.802e-16
Cp1630 cp12 xc4_din 7.133e-16
Cp1631 cp12 xc4_dip 7.57e-17
Cp1632 cp2 cp3 7.16e-15
Cp1633 cp2 cp4 3.864e-16
Cp1634 cp2 cp5 3.508e-18
Cp1635 cp2 cp6 2.861e-15
Cp1636 cp2 cp7 2.034e-16
Cp1637 cp2 cp8 4.199e-19
Cp1638 cp2 gnd 4.03e-15
Cp1639 cp2 lsb_n 4.111e-17
Cp1640 cp2 lsb_p 4.07e-17
Cp1641 cp2 vdd 4.408e-17
Cp1642 cp2 vrefl 6.375e-16
Cp1643 cp2 xc4_din 1.897e-16
Cp1644 cp2 xc4_dip 5.649e-17
Cp1645 cp3 cp4 8.552e-16
Cp1646 cp3 cp5 2.174e-17
Cp1647 cp3 cp6 5.142e-16
Cp1648 cp3 cp7 3.062e-16
Cp1649 cp3 cp8 6.013e-19
Cp1650 cp3 gnd 7.354e-15
Cp1651 cp3 lsb_n 4.401e-17
Cp1652 cp3 lsb_p 2.709e-16
Cp1653 cp3 vdd 1.189e-16
Cp1654 cp3 vrefl 1.543e-15
Cp1655 cp3 xc4_din 7.385e-17
Cp1656 cp3 xc4_dip 4.515e-17
Cp1657 cp4 cp5 5.904e-16
Cp1658 cp4 cp6 8.034e-17
Cp1659 cp4 cp7 8.345e-15
Cp1660 cp4 cp8 1.009e-15
Cp1661 cp4 gnd 4.594e-15
Cp1662 cp4 lsb_n 3.719e-17
Cp1663 cp4 lsb_p 1.415e-16
Cp1664 cp4 rstb 1.727e-19
Cp1665 cp4 vdd 9.553e-17
Cp1666 cp4 vrefl 4.892e-16
Cp1667 cp4 xc4_din 5.493e-17
Cp1668 cp4 xc4_dip 1.153e-16
Cp1669 cp5 cp6 1.102e-15
Cp1670 cp5 cp7 1.757e-16
Cp1671 cp5 cp8 2.17e-15
Cp1672 cp5 gnd 6.323e-15
Cp1673 cp5 lsb_n 5.182e-17
Cp1674 cp5 lsb_p 1.983e-16
Cp1675 cp5 rstb 1.355e-19
Cp1676 cp5 vdd 3.096e-16
Cp1677 cp5 vrefl 9.039e-16
Cp1678 cp5 xc4_din 9.23e-16
Cp1679 cp5 xc4_dip 4.249e-17
Cp1680 cp6 cp7 3.645e-15
Cp1681 cp6 cp8 1.913e-15
Cp1682 cp6 cp9 5.599e-18
Cp1683 cp6 gnd 4.844e-15
Cp1684 cp6 lsb_n 4.502e-17
Cp1685 cp6 lsb_p 1.226e-16
Cp1686 cp6 rstb 4.674e-19
Cp1687 cp6 vdd 4.234e-16
Cp1688 cp6 vref 2.514e-18
Cp1689 cp6 vrefl 4.943e-16
Cp1690 cp6 xc4_din 5.664e-16
Cp1691 cp6 xc4_dip 1.164e-15
Cp1692 cp7 cp8 9.754e-17
Cp1693 cp7 cp9 8.795e-18
Cp1694 cp7 gnd 8.681e-15
Cp1695 cp7 lsb_n 3.719e-17
Cp1696 cp7 lsb_p 2.376e-15
Cp1697 cp7 rstb 1.467e-17
Cp1698 cp7 vdd 9.598e-17
Cp1699 cp7 vref 1.432e-17
Cp1700 cp7 vrefl 4.803e-16
Cp1701 cp7 xc4_din 5.835e-17
Cp1702 cp7 xc4_dip 3.542e-17
Cp1703 cp8 cp9 1.219e-15
Cp1704 cp8 gnd 7.278e-15
Cp1705 cp8 lsb_n 5.157e-17
Cp1706 cp8 lsb_p 1.898e-16
Cp1707 cp8 rstb 1.183e-17
Cp1708 cp8 vdd 7.119e-16
Cp1709 cp8 vref 2.995e-16
Cp1710 cp8 vrefl 1.554e-15
Cp1711 cp8 xc4_din 1.023e-15
Cp1712 cp8 xc4_dip 6.852e-16
Cp1713 cp9 gnd 4.66e-15
Cp1714 cp9 lsb_n 5.037e-17
Cp1715 cp9 lsb_p 6.562e-17
Cp1716 cp9 rstb 6.47e-17
Cp1717 cp9 vdd 4.971e-16
Cp1718 cp9 vref 8.659e-16
Cp1719 cp9 xc4_din 1.889e-15
Cp1720 cp9 xc4_dip 4.903e-17
Cp1721 gnd in0n 4.05e-15
Cp1722 gnd in0p 2.809e-15
Cp1723 gnd in1n 2.582e-15
Cp1724 gnd in1p 1.613e-15
Cp1725 gnd lsb_n 1.202e-14
Cp1726 gnd lsb_p 1.351e-14
Cp1727 gnd nr 9.124e-16
Cp1728 gnd on 1.228e-14
Cp1729 gnd onn 1.77e-14
Cp1730 gnd onp 1.542e-14
Cp1731 gnd op 1.055e-14
Cp1732 gnd rstb 7.179e-15
Cp1733 gnd rstb_n 2.403e-15
Cp1734 gnd t0 1.007e-14
Cp1735 gnd t0b 1.143e-14
Cp1736 gnd t1 2.304e-14
Cp1737 gnd t1b 1.596e-14
Cp1738 gnd top_n 1.784e-14
Cp1739 gnd top_p 2.051e-14
Cp1740 gnd trk0 7.724e-15
Cp1741 gnd trk1 5.964e-15
Cp1742 gnd vbn 1.391e-15
Cp1743 gnd vbp 8.183e-15
Cp1744 gnd vdd 9.527e-14
Cp1745 gnd vref 2.078e-14
Cp1746 gnd vrefl 2.317e-14
Cp1747 gnd xc4_din 5.005e-14
Cp1748 gnd xc4_dip 5.564e-14
Cp1749 gnd xc4_lt 1.843e-15
Cp1750 gnd xc4_outnb 2.581e-15
Cp1751 gnd xc4_outpb 2.901e-15
Cp1752 gnd xc4_xs1_tail 1.113e-14
Cp1753 gnd xc4_xs1_tail0 2.214e-15
Cp1754 gnd xc5_din 2.442e-14
Cp1755 gnd xc5_dip 2.552e-14
Cp1756 gnd xc5_lt 1.055e-14
Cp1757 gnd xc5_outnb 2.33e-15
Cp1758 gnd xc5_outpb 2.044e-15
Cp1759 gnd xc5_xs1_tail 3.707e-15
Cp1760 gnd xc5_xs1_tail0 2.545e-15
Cp1761 gnd xs0n_cbn 5.202e-15
Cp1762 gnd xs0n_cbp 1.827e-15
Cp1763 gnd xs0n_g 7.468e-15
Cp1764 gnd xs0n_n10 1.123e-15
Cp1765 gnd xs0n_x 2.729e-15
Cp1766 gnd xs0p_cbn 6.033e-15
Cp1767 gnd xs0p_cbp 2.221e-15
Cp1768 gnd xs0p_g 3.974e-15
Cp1769 gnd xs0p_n10 1.243e-15
Cp1770 gnd xs0p_x 1.807e-15
Cp1771 gnd xs1n_cbn 9.833e-15
Cp1772 gnd xs1n_cbp 1.693e-15
Cp1773 gnd xs1n_g 5.662e-15
Cp1774 gnd xs1n_n10 1.366e-15
Cp1775 gnd xs1n_x 3.496e-15
Cp1776 gnd xs1p_cbn 6.432e-15
Cp1777 gnd xs1p_cbp 2.012e-15
Cp1778 gnd xs1p_g 5.813e-15
Cp1779 gnd xs1p_n10 1.237e-15
Cp1780 gnd xs1p_x 2.411e-15
Cp1781 in0n in0p 3.34e-16
Cp1782 in0n lsb_n 5.662e-16
Cp1783 in0n t0 8.913e-16
Cp1784 in0n t0b 9.937e-17
Cp1785 top_n gnd 1.907e-15
Cp1785x in0n gnd 1.907e-15
Cp1786 top_p gnd 8.394e-17
Cp1786x in0n gnd 8.394e-17
Cp1787 in0n trk0 1.816e-18
Cp1788 in0n vdd 6.796e-16
Cp1789 in0n xs0n_cbn 6.538e-15
Cp1790 in0n xs0n_cbp 3.182e-17
Cp1791 in0n xs0n_g 1.211e-15
Cp1792 in0n xs0n_n10 7.714e-17
Cp1793 in0n xs0n_x 1.752e-16
Cp1794 in0n xs0p_g 3.017e-18
Cp1795 in0p lsb_n 1.066e-17
Cp1796 in0p t0 7.137e-16
Cp1797 in0p t0b 1.225e-15
Cp1798 top_n gnd 9.412e-16
Cp1798x in0p gnd 9.412e-16
Cp1799 top_p gnd 9.937e-16
Cp1799x in0p gnd 9.937e-16
Cp1800 in0p vdd 1.272e-15
Cp1801 in0p xs0n_cbn 3.757e-15
Cp1802 in0p xs0n_cbp 1.72e-16
Cp1803 in0p xs0n_g 8.866e-16
Cp1804 in0p xs0n_n10 2.941e-17
Cp1805 in0p xs0n_x 7.212e-16
Cp1806 in0p xs0p_cbn 2.685e-16
Cp1807 in0p xs0p_g 4.494e-16
Cp1808 in1n in1p 2.487e-16
Cp1809 in1n t1 7.498e-16
Cp1810 in1n t1b 2.89e-17
Cp1811 top_n gnd 1.222e-15
Cp1811x in1n gnd 1.222e-15
Cp1812 top_p gnd 1.83e-18
Cp1812x in1n gnd 1.83e-18
Cp1813 in1n vdd 1.837e-15
Cp1814 in1n xs1n_cbn 6.356e-16
Cp1815 in1n xs1n_cbp 3.758e-18
Cp1816 in1n xs1n_g 2.369e-16
Cp1817 in1n xs1n_n10 2.939e-19
Cp1818 in1n xs1n_x 1.416e-15
Cp1819 in1p t1 2.238e-15
Cp1820 in1p t1b 3.078e-17
Cp1821 top_n gnd 1.549e-16
Cp1821x in1p gnd 1.549e-16
Cp1822 top_p gnd 8.345e-16
Cp1822x in1p gnd 8.345e-16
Cp1823 in1p vdd 5.364e-16
Cp1824 in1p xs1n_cbn 1.811e-15
Cp1825 in1p xs1n_cbp 3.817e-19
Cp1826 in1p xs1n_g 2.411e-18
Cp1827 in1p xs1n_x 1.571e-18
Cp1828 in1p xs1p_cbn 4.344e-16
Cp1829 in1p xs1p_cbp 4.815e-18
Cp1830 in1p xs1p_g 2.813e-16
Cp1831 in1p xs1p_n10 1.014e-18
Cp1832 in1p xs1p_x 1.622e-17
Cp1833 lsb_n lsb_p 1.834e-15
Cp1834 lsb_n on 1.001e-16
Cp1835 lsb_n onn 7.685e-17
Cp1836 lsb_n onp 7.998e-17
Cp1837 lsb_n op 6.983e-16
Cp1838 lsb_n rstb 3.135e-17
Cp1839 lsb_n t0 6.495e-17
Cp1840 lsb_n t0b 1.075e-15
Cp1841 lsb_n t1 8.725e-17
Cp1842 lsb_n t1b 2.224e-17
Cp1843 top_n gnd 5.62e-16
Cp1843x lsb_n gnd 5.62e-16
Cp1844 top_p gnd 2.098e-17
Cp1844x lsb_n gnd 2.098e-17
Cp1845 lsb_n trk0 1.103e-15
Cp1846 lsb_n trk1 8.844e-17
Cp1847 lsb_n vdd 4.076e-15
Cp1848 lsb_n vref 5.674e-18
Cp1849 lsb_n vrefl 1.089e-15
Cp1850 lsb_n xc4_din 2.825e-15
Cp1851 lsb_n xc4_dip 7.9e-16
Cp1852 lsb_n xc4_lt 2.744e-19
Cp1853 lsb_n xs0n_cbn 1.466e-15
Cp1854 lsb_n xs0n_cbp 4.955e-18
Cp1855 lsb_n xs0n_g 6.464e-17
Cp1856 lsb_n xs0n_n10 3.329e-18
Cp1857 lsb_n xs0n_x 1.227e-17
Cp1858 lsb_p on 2.408e-16
Cp1859 lsb_p onn 3.352e-16
Cp1860 lsb_p onp 9.949e-16
Cp1861 lsb_p op 1.577e-16
Cp1862 lsb_p rstb 1.368e-15
Cp1863 lsb_p t0 1.52e-16
Cp1864 lsb_p t0b 3.754e-17
Cp1865 lsb_p t1b 2.172e-19
Cp1866 top_n gnd 1.324e-17
Cp1866x lsb_p gnd 1.324e-17
Cp1867 top_p gnd 5.453e-16
Cp1867x lsb_p gnd 5.453e-16
Cp1868 lsb_p trk0 1.233e-16
Cp1869 lsb_p trk1 5.883e-15
Cp1870 lsb_p vbp 5.212e-17
Cp1871 lsb_p vdd 1.54e-14
Cp1872 lsb_p vref 4.897e-16
Cp1873 lsb_p vrefl 1.38e-15
Cp1874 lsb_p xc4_din 3.753e-16
Cp1875 lsb_p xc4_dip 5.622e-17
Cp1876 lsb_p xc4_lt 7.933e-19
Cp1877 lsb_p xc4_outnb 6.583e-17
Cp1878 lsb_p xc4_outpb 5.157e-17
Cp1879 lsb_p xc4_xs1_tail 1.138e-14
Cp1880 lsb_p xc4_xs1_tail0 3.712e-18
Cp1881 lsb_p xc5_din 2.921e-18
Cp1882 lsb_p xc5_dip 2.484e-18
Cp1883 lsb_p xc5_lt 3.498e-18
Cp1884 lsb_p xc5_outnb 4.947e-17
Cp1885 lsb_p xc5_outpb 4.073e-16
Cp1886 lsb_p xs0n_cbn 2.233e-19
Cp1887 lsb_p xs0n_g 2.233e-19
Cp1888 lsb_p xs0n_x 2.233e-19
Cp1889 lsb_p xs0p_cbn 6.983e-17
Cp1890 lsb_p xs0p_g 1.447e-16
Cp1891 lsb_p xs0p_x 1.537e-16
Cp1892 nr rstb 1.182e-17
Cp1893 nr rstb_n 6.318e-16
Cp1894 nr t0b 2.276e-16
Cp1895 nr t1 1.254e-16
Cp1896 nr t1b 2.176e-16
Cp1897 nr trk1 1.142e-19
Cp1898 nr vdd 2.353e-17
Cp1899 on onn 6.654e-17
Cp1900 on onp 6.543e-16
Cp1901 on op 8.226e-15
Cp1902 on rstb 2.104e-18
Cp1903 on t0 7.125e-19
Cp1904 on t0b 1.278e-16
Cp1905 on trk1 2.531e-18
Cp1906 on vbp 9.659e-19
Cp1907 on vdd 2.533e-15
Cp1908 on vrefl 2.942e-16
Cp1909 on xc4_din 2.391e-15
Cp1910 on xc4_dip 1.171e-15
Cp1911 on xc4_lt 4.143e-16
Cp1912 on xc4_outnb 9.365e-16
Cp1913 on xc4_outpb 4.481e-16
Cp1914 on xc4_xs1_tail 1.684e-17
Cp1915 on xc4_xs1_tail0 1.266e-17
Cp1916 on xc5_lt 1.838e-18
Cp1917 on xc5_outnb 1.835e-16
Cp1918 on xc5_outpb 3.898e-16
Cp1919 onn onp 1.773e-14
Cp1920 onn op 1.077e-16
Cp1921 onn rstb 4.822e-15
Cp1922 onn rstb_n 1.482e-18
Cp1923 onn t0 4.727e-16
Cp1924 onn t0b 1.434e-16
Cp1925 onn t1 6.985e-18
Cp1926 onn t1b 7.896e-18
Cp1927 onn trk0 2.245e-18
Cp1928 onn trk1 2.065e-16
Cp1929 onn vbp 5.791e-17
Cp1930 onn vdd 4.499e-15
Cp1931 onn vref 5.575e-16
Cp1932 onn vrefl 3.362e-16
Cp1933 onn xc4_din 5.478e-19
Cp1934 onn xc4_dip 1.32e-17
Cp1935 onn xc4_outnb 6.35e-17
Cp1936 onn xc4_outpb 5.73e-17
Cp1937 onn xc4_xs1_tail 3.292e-15
Cp1938 onn xc4_xs1_tail0 6.488e-18
Cp1939 onn xc5_din 1.136e-16
Cp1940 onn xc5_dip 5.5e-18
Cp1941 onn xc5_lt 9.508e-16
Cp1942 onn xc5_outnb 1.299e-15
Cp1943 onn xc5_outpb 3.125e-16
Cp1944 onn xc5_xs1_tail 5.335e-18
Cp1945 onn xc5_xs1_tail0 1.458e-18
Cp1946 onp op 1.96e-15
Cp1947 onp rstb 3.066e-16
Cp1948 onp t0 1.22e-16
Cp1949 onp t0b 7.331e-17
Cp1950 onp t1 8.538e-17
Cp1951 onp t1b 8.29e-17
Cp1952 onp trk0 2.036e-18
Cp1953 onp trk1 2.168e-16
Cp1954 onp vbp 5.753e-17
Cp1955 onp vdd 1.36e-15
Cp1956 onp vref 4.524e-16
Cp1957 onp vrefl 3.012e-16
Cp1958 onp xc4_din 4.395e-19
Cp1959 onp xc4_dip 4.395e-19
Cp1960 onp xc4_lt 2.588e-18
Cp1961 onp xc4_outnb 6.41e-17
Cp1962 onp xc4_outpb 5.938e-17
Cp1963 onp xc4_xs1_tail 1.338e-18
Cp1964 onp xc4_xs1_tail0 9.829e-19
Cp1965 onp xc5_din 1.524e-17
Cp1966 onp xc5_dip 1.097e-16
Cp1967 onp xc5_lt 1.624e-14
Cp1968 onp xc5_outnb 4.305e-16
Cp1969 onp xc5_outpb 4.199e-16
Cp1970 onp xc5_xs1_tail 8.542e-18
Cp1971 onp xc5_xs1_tail0 3.158e-18
Cp1972 op rstb 5.781e-17
Cp1973 op t0 7.196e-19
Cp1974 op t0b 9.837e-17
Cp1975 op t1 7.725e-17
Cp1976 op t1b 7.159e-17
Cp1977 op vbp 4.066e-18
Cp1978 op vdd 3.153e-15
Cp1979 op vrefl 3.741e-17
Cp1980 op xc4_din 1.887e-15
Cp1981 op xc4_dip 2.439e-15
Cp1982 op xc4_lt 6.648e-16
Cp1983 op xc4_outnb 4.674e-17
Cp1984 op xc4_outpb 5.327e-16
Cp1985 op xc4_xs1_tail 6.656e-17
Cp1986 op xc4_xs1_tail0 9.605e-19
Cp1987 op xc5_lt 6.404e-17
Cp1988 op xc5_outnb 2.288e-15
Cp1989 op xc5_outpb 1.255e-16
Cp1990 rstb rstb_n 2.025e-16
Cp1991 rstb t0b 1.024e-19
Cp1992 rstb t1 8.057e-17
Cp1993 rstb t1b 1.591e-16
Cp1994 rstb vbp 5.843e-17
Cp1995 rstb vdd 1.698e-15
Cp1996 rstb vref 1.914e-16
Cp1997 rstb vrefl 1.139e-15
Cp1998 rstb xc4_din 5.923e-16
Cp1999 rstb xc4_dip 3.798e-16
Cp2000 rstb xc4_outnb 3.319e-19
Cp2001 rstb xc4_outpb 1.49e-19
Cp2002 rstb xc4_xs1_tail 3.343e-15
Cp2003 rstb xc4_xs1_tail0 1.764e-18
Cp2004 rstb xc5_lt 2.109e-16
Cp2005 rstb_n t0b 3.104e-16
Cp2006 rstb_n t1 6.331e-16
Cp2007 rstb_n t1b 4.379e-16
Cp2008 rstb_n vdd 9.028e-16
Cp2009 t0 t0b 6.107e-15
Cp2010 t0 t1 9.198e-18
Cp2011 t0 t1b 3.664e-18
Cp2012 top_n gnd 2.697e-16
Cp2012x t0 gnd 2.697e-16
Cp2013 top_p gnd 1.041e-15
Cp2013x t0 gnd 1.041e-15
Cp2014 t0 trk0 1.207e-15
Cp2015 t0 trk1 8.425e-16
Cp2016 t0 vdd 2.757e-15
Cp2017 t0 xc4_lt 1.09e-16
Cp2018 t0 xc5_outnb 5.566e-17
Cp2019 t0 xc5_outpb 7.044e-16
Cp2020 t0 xs0n_cbn 9.471e-16
Cp2021 t0 xs0n_cbp 5.56e-16
Cp2022 t0 xs0n_g 2.132e-15
Cp2023 t0 xs0n_n10 1.011e-16
Cp2024 t0 xs0n_x 4.538e-16
Cp2025 t0 xs0p_cbn 4.305e-16
Cp2026 t0 xs0p_cbp 6.276e-18
Cp2027 t0 xs0p_g 5.561e-16
Cp2028 t0 xs0p_n10 7.942e-19
Cp2029 t0 xs0p_x 1.112e-16
Cp2030 t0b t1 5.179e-16
Cp2031 t0b t1b 1.093e-15
Cp2032 top_n gnd 1.3e-16
Cp2032x t0b gnd 1.3e-16
Cp2033 top_p gnd 3.933e-16
Cp2033x t0b gnd 3.933e-16
Cp2034 t0b trk0 5.685e-15
Cp2035 t0b trk1 1.79e-16
Cp2036 t0b vdd 3.566e-15
Cp2037 t0b xc4_lt 1.736e-16
Cp2038 t0b xc5_outnb 5.515e-17
Cp2039 t0b xc5_outpb 6.113e-17
Cp2040 t0b xs0n_cbn 1.372e-15
Cp2041 t0b xs0n_cbp 1.46e-18
Cp2042 t0b xs0n_g 3.856e-16
Cp2043 t0b xs0n_n10 2.875e-17
Cp2044 t0b xs0n_x 1.393e-17
Cp2045 t0b xs0p_cbn 1.191e-15
Cp2046 t0b xs0p_cbp 4.185e-18
Cp2047 t0b xs0p_g 1.157e-16
Cp2048 t0b xs0p_n10 3.409e-17
Cp2049 t0b xs0p_x 1.597e-16
Cp2050 t1 t1b 9.565e-15
Cp2051 top_n gnd 2.28e-16
Cp2051x t1 gnd 2.28e-16
Cp2052 top_p gnd 1.024e-16
Cp2052x t1 gnd 1.024e-16
Cp2053 t1 trk1 1.763e-18
Cp2054 t1 vbn 8.624e-18
Cp2055 t1 vbp 2.247e-16
Cp2056 t1 vdd 4.829e-15
Cp2057 t1 vref 7.769e-16
Cp2058 t1 vrefl 7.42e-16
Cp2059 t1 xc4_din 6.353e-17
Cp2060 t1 xc4_dip 2.606e-16
Cp2061 t1 xc4_xs1_tail 3.632e-16
Cp2062 t1 xc5_din 2.101e-15
Cp2063 t1 xc5_dip 1.369e-15
Cp2064 t1 xc5_lt 6.424e-17
Cp2065 t1 xc5_xs1_tail 1.994e-15
Cp2066 t1 xc5_xs1_tail0 7.98e-17
Cp2067 t1 xs1n_cbn 2.004e-15
Cp2068 t1 xs1n_cbp 1.974e-17
Cp2069 t1 xs1n_g 6.242e-16
Cp2070 t1 xs1n_n10 8.606e-18
Cp2071 t1 xs1n_x 2.033e-15
Cp2072 t1 xs1p_cbn 4.213e-16
Cp2073 t1 xs1p_cbp 5.443e-18
Cp2074 t1 xs1p_g 9.433e-17
Cp2075 t1 xs1p_n10 6.71e-19
Cp2076 t1 xs1p_x 1.228e-16
Cp2077 top_n gnd 9.051e-17
Cp2077x t1b gnd 9.051e-17
Cp2078 top_p gnd 5.366e-16
Cp2078x t1b gnd 5.366e-16
Cp2079 t1b trk1 2.231e-16
Cp2080 t1b vbn 2.99e-19
Cp2081 t1b vbp 7.268e-17
Cp2082 t1b vdd 3.374e-15
Cp2083 t1b vref 7.027e-16
Cp2084 t1b vrefl 4.679e-16
Cp2085 t1b xc4_din 6.403e-17
Cp2086 t1b xc4_dip 1.578e-16
Cp2087 t1b xc4_xs1_tail 1.386e-16
Cp2088 t1b xc4_xs1_tail0 4.514e-19
Cp2089 t1b xc5_din 3.335e-16
Cp2090 t1b xc5_dip 2.961e-16
Cp2091 t1b xc5_lt 1.029e-14
Cp2092 t1b xc5_xs1_tail 6.522e-16
Cp2093 t1b xc5_xs1_tail0 1.243e-17
Cp2094 t1b xs1n_cbn 1.155e-15
Cp2095 t1b xs1n_cbp 3.598e-17
Cp2096 t1b xs1n_g 4.785e-16
Cp2097 t1b xs1n_n10 8.081e-17
Cp2098 t1b xs1n_x 3.449e-16
Cp2099 t1b xs1p_cbn 1.887e-16
Cp2100 t1b xs1p_cbp 2.263e-18
Cp2101 t1b xs1p_g 7.393e-18
Cp2102 t1b xs1p_n10 3.485e-17
Cp2103 t1b xs1p_x 2.025e-17
Cp2104 top_n top_p 1.916e-15
Cp2105 top_n gnd 1.93e-18
Cp2105x trk0 gnd 1.93e-18
Cp2106 top_n gnd 5.04e-19
Cp2106x trk1 gnd 5.04e-19
Cp2107 top_n gnd 1.675e-15
Cp2107x vdd gnd 1.675e-15
Cp2108 top_n gnd 1.359e-15
Cp2108x xc4_din gnd 1.359e-15
Cp2109 top_n gnd 1.179e-16
Cp2109x xc4_dip gnd 1.179e-16
Cp2110 top_n gnd 1.272e-15
Cp2110x xc4_xs1_tail gnd 1.272e-15
Cp2111 top_n gnd 7.057e-16
Cp2111x xc5_din gnd 7.057e-16
Cp2112 top_n gnd 4.656e-16
Cp2112x xc5_dip gnd 4.656e-16
Cp2113 top_n gnd 9.134e-16
Cp2113x xc5_lt gnd 9.134e-16
Cp2114 top_n gnd 9.626e-16
Cp2114x xc5_xs1_tail gnd 9.626e-16
Cp2115 top_n gnd 1.555e-15
Cp2115x xs0n_cbn gnd 1.555e-15
Cp2116 top_n gnd 8.067e-18
Cp2116x xs0n_cbp gnd 8.067e-18
Cp2117 top_n gnd 2.909e-16
Cp2117x xs0n_g gnd 2.909e-16
Cp2118 top_n gnd 1.065e-18
Cp2118x xs0n_n10 gnd 1.065e-18
Cp2119 top_n gnd 8.369e-17
Cp2119x xs0n_x gnd 8.369e-17
Cp2120 top_n gnd 7.595e-19
Cp2120x xs0p_g gnd 7.595e-19
Cp2121 top_n gnd 1.79e-15
Cp2121x xs1n_cbn gnd 1.79e-15
Cp2122 top_n gnd 1.988e-16
Cp2122x xs1n_cbp gnd 1.988e-16
Cp2123 top_n gnd 4.086e-16
Cp2123x xs1n_g gnd 4.086e-16
Cp2124 top_n gnd 4.448e-17
Cp2124x xs1n_n10 gnd 4.448e-17
Cp2125 top_n gnd 3.301e-16
Cp2125x xs1n_x gnd 3.301e-16
Cp2126 top_n gnd 3.946e-18
Cp2126x xs1p_cbn gnd 3.946e-18
Cp2127 top_n gnd 6.158e-17
Cp2127x xs1p_g gnd 6.158e-17
Cp2128 top_p gnd 7.485e-18
Cp2128x trk0 gnd 7.485e-18
Cp2129 top_p gnd 3.851e-18
Cp2129x trk1 gnd 3.851e-18
Cp2130 top_p gnd 1.119e-15
Cp2130x vdd gnd 1.119e-15
Cp2131 top_p gnd 1.285e-15
Cp2131x xc4_din gnd 1.285e-15
Cp2132 top_p gnd 1.564e-15
Cp2132x xc4_dip gnd 1.564e-15
Cp2133 top_p gnd 1.266e-15
Cp2133x xc4_xs1_tail gnd 1.266e-15
Cp2134 top_p gnd 3.875e-16
Cp2134x xc5_din gnd 3.875e-16
Cp2135 top_p gnd 1.979e-15
Cp2135x xc5_dip gnd 1.979e-15
Cp2136 top_p gnd 4.685e-16
Cp2136x xc5_lt gnd 4.685e-16
Cp2137 top_p gnd 1.169e-15
Cp2137x xc5_xs1_tail gnd 1.169e-15
Cp2138 top_p gnd 1.551e-16
Cp2138x xs0n_cbn gnd 1.551e-16
Cp2139 top_p gnd 1.791e-16
Cp2139x xs0n_g gnd 1.791e-16
Cp2140 top_p gnd 1.052e-16
Cp2140x xs0n_x gnd 1.052e-16
Cp2141 top_p gnd 3.598e-16
Cp2141x xs0p_cbn gnd 3.598e-16
Cp2142 top_p gnd 6.702e-16
Cp2142x xs0p_g gnd 6.702e-16
Cp2143 top_p gnd 2.125e-18
Cp2143x xs0p_n10 gnd 2.125e-18
Cp2144 top_p gnd 5.36e-18
Cp2144x xs0p_x gnd 5.36e-18
Cp2145 top_p gnd 4.291e-16
Cp2145x xs1n_cbn gnd 4.291e-16
Cp2146 top_p gnd 9.952e-18
Cp2146x xs1n_cbp gnd 9.952e-18
Cp2147 top_p gnd 3.987e-16
Cp2147x xs1n_g gnd 3.987e-16
Cp2148 top_p gnd 4.825e-17
Cp2148x xs1n_n10 gnd 4.825e-17
Cp2149 top_p gnd 1.854e-17
Cp2149x xs1p_cbn gnd 1.854e-17
Cp2150 top_p gnd 1.053e-16
Cp2150x xs1p_g gnd 1.053e-16
Cp2151 trk0 trk1 9.442e-15
Cp2152 trk0 vdd 4.764e-15
Cp2153 trk0 xc4_lt 1.036e-18
Cp2154 trk0 xs0n_cbn 3.728e-19
Cp2155 trk0 xs0n_g 8.557e-18
Cp2156 trk0 xs0n_x 3.728e-19
Cp2157 trk0 xs0p_cbn 3.862e-16
Cp2158 trk0 xs0p_cbp 6.527e-18
Cp2159 trk0 xs0p_g 9.49e-18
Cp2160 trk0 xs0p_n10 1.171e-18
Cp2161 trk0 xs0p_x 9.368e-17
Cp2162 trk1 vdd 3.295e-15
Cp2163 trk1 xc4_lt 1.522e-18
Cp2164 trk1 xc5_outnb 7.709e-18
Cp2165 trk1 xc5_outpb 1.794e-16
Cp2166 trk1 xs0n_cbn 2.846e-19
Cp2167 trk1 xs0n_g 2.846e-19
Cp2168 trk1 xs0n_x 2.846e-19
Cp2169 trk1 xs0p_cbn 3.872e-16
Cp2170 trk1 xs0p_cbp 8.365e-18
Cp2171 trk1 xs0p_g 5.329e-16
Cp2172 trk1 xs0p_n10 1.822e-18
Cp2173 trk1 xs0p_x 2.311e-16
Cp2174 vbn vbp 1.187e-16
Cp2175 vbn vrefl 4.987e-18
Cp2176 vbn xc5_din 2.014e-17
Cp2177 vbn xc5_dip 5.308e-17
Cp2178 vbn xc5_lt 1.178e-19
Cp2179 vbn xc5_xs1_tail 1.086e-16
Cp2180 vbn xc5_xs1_tail0 5.563e-16
Cp2181 vbp vdd 6.58e-16
Cp2182 vbp vref 4.899e-16
Cp2183 vbp vrefl 8.124e-15
Cp2184 vbp xc4_dip 5.043e-17
Cp2185 vbp xc4_xs1_tail 1.107e-15
Cp2186 vbp xc4_xs1_tail0 1.044e-15
Cp2187 vbp xc5_din 2.141e-17
Cp2188 vbp xc5_dip 1.283e-16
Cp2189 vbp xc5_lt 6.407e-17
Cp2190 vbp xc5_outnb 1.859e-18
Cp2191 vbp xc5_xs1_tail 6.185e-19
Cp2192 vbp xc5_xs1_tail0 2.468e-18
Cp2193 vdd vref 2.517e-15
Cp2194 vdd vrefl 2.248e-15
Cp2195 vdd xc4_din 1.611e-14
Cp2196 vdd xc4_dip 1.636e-14
Cp2197 vdd xc4_lt 2.483e-17
Cp2198 vdd xc4_outnb 2.193e-16
Cp2199 vdd xc4_outpb 3.04e-16
Cp2200 vdd xc4_xs1_tail 2.919e-15
Cp2201 vdd xc4_xs1_tail0 2.612e-15
Cp2202 vdd xc5_din 3.262e-15
Cp2203 vdd xc5_dip 2.7e-15
Cp2204 vdd xc5_lt 2.703e-15
Cp2205 vdd xc5_outnb 4.233e-16
Cp2206 vdd xc5_outpb 3.793e-16
Cp2207 vdd xc5_xs1_tail 3.004e-16
Cp2208 vdd xs0n_cbn 2.97e-15
Cp2209 vdd xs0n_cbp 2.836e-16
Cp2210 vdd xs0n_g 1.879e-15
Cp2211 vdd xs0n_n10 1.858e-16
Cp2212 vdd xs0n_x 5.182e-16
Cp2213 vdd xs0p_cbn 2.529e-15
Cp2214 vdd xs0p_cbp 5.395e-16
Cp2215 vdd xs0p_g 1.377e-15
Cp2216 vdd xs0p_n10 1.246e-16
Cp2217 vdd xs0p_x 7.328e-16
Cp2218 vdd xs1n_cbn 1.625e-15
Cp2219 vdd xs1n_cbp 3.93e-16
Cp2220 vdd xs1n_g 1.636e-15
Cp2221 vdd xs1n_n10 1.361e-16
Cp2222 vdd xs1n_x 1.156e-15
Cp2223 vdd xs1p_cbn 8.656e-16
Cp2224 vdd xs1p_cbp 2.681e-16
Cp2225 vdd xs1p_g 7.831e-16
Cp2226 vdd xs1p_n10 2.237e-16
Cp2227 vdd xs1p_x 3.319e-16
Cp2228 vref vrefl 1.176e-15
Cp2229 vref xc4_din 9.557e-17
Cp2230 vref xc4_dip 1.283e-15
Cp2231 vref xc4_xs1_tail 5.575e-16
Cp2232 vref xc5_din 6.23e-16
Cp2233 vref xc5_dip 1.458e-15
Cp2234 vref xc5_lt 5.577e-16
Cp2235 vrefl xc4_din 1.099e-15
Cp2236 vrefl xc4_dip 9.305e-16
Cp2237 vrefl xc4_outnb 3.123e-16
Cp2238 vrefl xc4_outpb 7.324e-18
Cp2239 vrefl xc4_xs1_tail 3.344e-16
Cp2240 vrefl xc5_din 1.87e-15
Cp2241 vrefl xc5_dip 6.184e-16
Cp2242 vrefl xc5_lt 3.712e-16
Cp2243 xc4_din xc4_dip 4.289e-15
Cp2244 xc4_din xc4_outnb 4.033e-17
Cp2245 xc4_din xc4_outpb 5.331e-17
Cp2246 xc4_din xc4_xs1_tail 8.358e-15
Cp2247 xc4_din xc5_din 6.356e-18
Cp2248 xc4_din xc5_dip 3.887e-18
Cp2249 xc4_din xc5_lt 4.196e-16
Cp2250 xc4_din xc5_xs1_tail 3.679e-18
Cp2251 xc4_dip xc4_outnb 5.1e-17
Cp2252 xc4_dip xc4_outpb 6.067e-17
Cp2253 xc4_dip xc4_xs1_tail 3.991e-15
Cp2254 xc4_dip xc4_xs1_tail0 3.059e-18
Cp2255 xc4_dip xc5_din 2.747e-16
Cp2256 xc4_dip xc5_dip 4.007e-16
Cp2257 xc4_dip xc5_lt 2.73e-16
Cp2258 xc4_dip xc5_xs1_tail 3.481e-16
Cp2259 xc4_lt xc4_outnb 4.937e-19
Cp2260 xc4_lt xc4_outpb 7.066e-19
Cp2261 xc4_lt xc5_outnb 1.67e-17
Cp2262 xc4_lt xc5_outpb 4.361e-17
Cp2263 xc4_outnb xc4_outpb 4.558e-15
Cp2264 xc4_outnb xc5_outnb 1.973e-17
Cp2265 xc4_outnb xc5_outpb 1.879e-17
Cp2266 xc4_outpb xc4_xs1_tail 1.818e-19
Cp2267 xc4_outpb xc5_outnb 1.838e-16
Cp2268 xc4_outpb xc5_outpb 1.059e-15
Cp2269 xc4_xs1_tail xc4_xs1_tail0 8.479e-16
Cp2270 xc4_xs1_tail xc5_din 1.427e-17
Cp2271 xc4_xs1_tail xc5_dip 2.445e-17
Cp2272 xc4_xs1_tail xc5_lt 5.233e-15
Cp2273 xc4_xs1_tail xc5_xs1_tail 1.735e-17
Cp2274 xc4_xs1_tail xc5_xs1_tail0 6.861e-19
Cp2275 xc4_xs1_tail0 xc5_lt 6.861e-19
Cp2276 xc4_xs1_tail0 xc5_outnb 8.383e-18
Cp2277 xc5_din xc5_dip 1.482e-14
Cp2278 xc5_din xc5_lt 2.312e-16
Cp2279 xc5_din xc5_xs1_tail 8.434e-16
Cp2280 xc5_din xc5_xs1_tail0 7.447e-17
Cp2281 xc5_dip xc5_lt 1.56e-16
Cp2282 xc5_dip xc5_xs1_tail 1.026e-15
Cp2283 xc5_dip xc5_xs1_tail0 6.945e-17
Cp2284 xc5_lt xc5_outpb 4.064e-18
Cp2285 xc5_lt xc5_xs1_tail 2.363e-18
Cp2286 xc5_lt xc5_xs1_tail0 2.503e-18
Cp2287 xc5_outnb xc5_outpb 2.953e-15
Cp2288 xc5_xs1_tail xc5_xs1_tail0 2.161e-16
Cp2289 xs0n_cbn xs0n_cbp 4.102e-16
Cp2290 xs0n_cbn xs0n_g 1.769e-15
Cp2291 xs0n_cbn xs0n_n10 4.791e-16
Cp2292 xs0n_cbn xs0n_x 1.864e-15
Cp2293 xs0n_cbn xs0p_cbn 1.436e-18
Cp2294 xs0n_cbn xs0p_g 2.276e-18
Cp2295 xs0n_cbp xs0n_g 5.786e-16
Cp2296 xs0n_cbp xs0n_n10 3.664e-17
Cp2297 xs0n_cbp xs0n_x 5.02e-16
Cp2298 xs0n_cbp xs0p_g 1.907e-17
Cp2299 xs0n_g xs0n_n10 5.309e-16
Cp2300 xs0n_g xs0n_x 2.793e-15
Cp2301 xs0n_g xs0p_cbn 3.366e-17
Cp2302 xs0n_g xs0p_g 5.983e-16
Cp2303 xs0n_n10 xs0n_x 1.369e-16
Cp2304 xs0n_x xs0p_cbn 1.897e-17
Cp2305 xs0n_x xs0p_g 2.286e-16
Cp2306 xs0p_cbn xs0p_cbp 1.016e-15
Cp2307 xs0p_cbn xs0p_g 1.667e-15
Cp2308 xs0p_cbn xs0p_n10 6.446e-16
Cp2309 xs0p_cbn xs0p_x 1.19e-15
Cp2310 xs0p_cbp xs0p_g 6.429e-16
Cp2311 xs0p_cbp xs0p_n10 7.432e-17
Cp2312 xs0p_cbp xs0p_x 6.845e-16
Cp2313 xs0p_g xs0p_n10 5.012e-16
Cp2314 xs0p_g xs0p_x 1.548e-15
Cp2315 xs0p_n10 xs0p_x 2.417e-17
Cp2316 xs1n_cbn xs1n_cbp 9.411e-16
Cp2317 xs1n_cbn xs1n_g 2.667e-15
Cp2318 xs1n_cbn xs1n_n10 1.732e-16
Cp2319 xs1n_cbn xs1n_x 2.203e-15
Cp2320 xs1n_cbn xs1p_cbn 1.793e-17
Cp2321 xs1n_cbn xs1p_g 4.686e-16
Cp2322 xs1n_cbp xs1n_g 5.749e-16
Cp2323 xs1n_cbp xs1n_n10 1.307e-16
Cp2324 xs1n_cbp xs1n_x 5.325e-16
Cp2325 xs1n_cbp xs1p_g 4.192e-18
Cp2326 xs1n_g xs1n_n10 5.673e-16
Cp2327 xs1n_g xs1n_x 4.762e-16
Cp2328 xs1n_g xs1p_g 1.514e-17
Cp2329 xs1n_n10 xs1n_x 1.563e-16
Cp2330 xs1n_x xs1p_g 2.437e-19
Cp2331 xs1p_cbn xs1p_cbp 1.178e-15
Cp2332 xs1p_cbn xs1p_g 1.879e-15
Cp2333 xs1p_cbn xs1p_n10 6.624e-16
Cp2334 xs1p_cbn xs1p_x 1.235e-15
Cp2335 xs1p_cbp xs1p_g 5.832e-16
Cp2336 xs1p_cbp xs1p_n10 7.825e-17
Cp2337 xs1p_cbp xs1p_x 7.121e-16
Cp2338 xs1p_g xs1p_n10 5.182e-16
Cp2339 xs1p_g xs1p_x 1.821e-15
Cp2340 xs1p_n10 xs1p_x 2.483e-17
Cbal0 lsb_n gnd 27.4687f
Cbal1 xc4_din gnd 1.56911f
Cbal2 xc5_din gnd 0.762332f
Cbal3 on gnd 2.0796f
Cbal4 onn gnd 4.18755f
Rlev0 vdd__p22 vdd 5
Rlev1 vdd__p23 vdd 5
Rlev2 vdd__p24 vdd 5
Rlev3 vdd__p25 vdd 5
.ends
.subckt r1_adc_lay adc_hold is_smp clk adc_start adc_sel adc_valid_a adc_raw_a_0 adc_raw_a_1 adc_raw_a_2 adc_raw_a_3 adc_raw_a_4 adc_raw_a_5 adc_raw_a_6 adc_raw_a_7 adc_raw_a_8 adc_raw_a_9 adc_raw_a_10 adc_raw_a_11 adc_raw_a_12 adc_raw_a_13 adc_valid_b adc_raw_b_0 adc_raw_b_1 adc_raw_b_2 adc_raw_b_3 adc_raw_b_4 adc_raw_b_5 adc_raw_b_6 adc_raw_b_7 adc_raw_b_8 adc_raw_b_9 adc_raw_b_10 adc_raw_b_11 adc_raw_b_12 adc_raw_b_13 por_n ain_sin_p ain_sin_n ain_cos_p ain_cos_n vcm2 ibias ain_isa_p ain_isa_n ain_isb_p ain_isb_n vcm vdda vdd vss vref_in topap topan topbp topbn sar_clka sar_clkab sar_clkb sar_clkbb sar_clkna sar_clknab sar_clknb sar_clknbb sar_cna0 sar_cna1 sar_cna10 sar_cna11 sar_cna12 sar_cna2 sar_cna3 sar_cna4 sar_cna5 sar_cna6 sar_cna7 sar_cna8 sar_cna9 sar_cnb0 sar_cnb1 sar_cnb10 sar_cnb11 sar_cnb12 sar_cnb2 sar_cnb3 sar_cnb4 sar_cnb5 sar_cnb6 sar_cnb7 sar_cnb8 sar_cnb9 sar_cpa0 sar_cpa1 sar_cpa10 sar_cpa11 sar_cpa12 sar_cpa2 sar_cpa3 sar_cpa4 sar_cpa5 sar_cpa6 sar_cpa7 sar_cpa8 sar_cpa9 sar_cpb0 sar_cpb1 sar_cpb10 sar_cpb11 sar_cpb12 sar_cpb2 sar_cpb3 sar_cpb4 sar_cpb5 sar_cpb6 sar_cpb7 sar_cpb8 sar_cpb9 sar_oan sar_oann sar_oanp sar_oap sar_obn sar_obnn sar_obnp sar_obp sar_trka0 sar_trka1 sar_trkb0 sar_trkb1 sar_mclk
Xxckg_xpd0 xckg_d0__p1 clk vdd__p2 vdd sg13_lv_pmos w=1u l=0.5u ng=1 m=1
Xxckg_xnd0 xckg_d0 clk vss__p9 vss sg13_lv_nmos w=0.5u l=0.5u ng=1 m=1
Xxckg_cd0 xckg_d0__p2 vss__p16 cap_cmim w=2.53u l=2.53u m=1
Xxckg_xpd1 xckg_d1__p1 xckg_d0 vdd__p3 vdd sg13_lv_pmos w=1u l=0.5u ng=1 m=1
Xxckg_xnd1 xckg_d1 xckg_d0 vss__p10 vss sg13_lv_nmos w=0.5u l=0.5u ng=1 m=1
Xxckg_cd1 xckg_d1__p2 vss__p17 cap_cmim w=2.53u l=2.53u m=1
Xxckg_xpd2 xckg_d2__p1 xckg_d1 vdd__p4 vdd sg13_lv_pmos w=1u l=0.5u ng=1 m=1
Xxckg_xnd2 xckg_d2 xckg_d1 vss__p11 vss sg13_lv_nmos w=0.5u l=0.5u ng=1 m=1
Xxckg_cd2 xckg_d2__p2 vss__p18 cap_cmim w=2.53u l=2.53u m=1
Xxckg_xpd3 xckg_d3__p1 xckg_d2 vdd__p5 vdd sg13_lv_pmos w=1u l=0.5u ng=1 m=1
Xxckg_xnd3 xckg_d3 xckg_d2 vss__p12 vss sg13_lv_nmos w=0.5u l=0.5u ng=1 m=1
Xxckg_cd3 xckg_d3__p2 vss__p19 cap_cmim w=2.53u l=2.53u m=1
Xxckg_xpd4 xckg_x__p2 xckg_d3 vdd__p6 vdd sg13_lv_pmos w=1u l=0.5u ng=1 m=1
Xxckg_xnd4 xckg_x xckg_d3 vss__p13 vss sg13_lv_nmos w=0.5u l=0.5u ng=1 m=1
Xxckg_cd4 xckg_x__p4 vss__p20 cap_cmim w=2.53u l=2.53u m=1
Xxckg_xpa sar_mclk__p2 clk__p1 vdd__p7 vdd sg13_lv_pmos w=2u l=0.13u ng=1 m=1
Xxckg_xpb sar_mclk__p3 xckg_x__p3 vdd__p8 vdd sg13_lv_pmos w=2u l=0.13u ng=1 m=1
Xxckg_xna sar_mclk__p0 clk__p0 xckg_nn vss sg13_lv_nmos w=2u l=0.13u ng=1 m=1
Xxckg_xnb xckg_nn__p1 xckg_x__p1 vss__p14 vss sg13_lv_nmos w=2u l=0.13u ng=1 m=1
Xxckg_xpi mclkb__p1 sar_mclk__p4 vdd__p9 vdd sg13_lv_pmos w=2u l=0.13u ng=1 m=1
Xxckg_xni mclkb sar_mclk__p1 vss__p15 vss sg13_lv_nmos w=1u l=0.13u ng=1 m=1
Xxcbias_xmbd vbp__p1 vbp vdd__p1 vdd sg13_lv_pmos w=0.8u l=0.5u ng=1 m=1
Xxcbias_xrb_g0 vbp xcbias_xrb_s1 vss rppd w=1u l=40u m=1 b=0
Xxcbias_xrb_g1 xcbias_xrb_s1 xcbias_xrb_s2 vss rppd w=1u l=40u m=1 b=0
Xxcbias_xrb_g2 xcbias_xrb_s2 xcbias_xrb_s3 vss rppd w=1u l=40u m=1 b=0
Xxcbias_xrb_g3 xcbias_xrb_s3 vss__p7 vss rppd w=1u l=40u m=1 b=0
Xxcbiasn_xmbd vbn__p1 vbn vss__p8 vss sg13_lv_nmos w=0.2u l=0.5u ng=1 m=1
Xxcbiasn_xrb_g0 vdd__p0 xcbiasn_xrb_s1 vss rppd w=1u l=40u m=1 b=0
Xxcbiasn_xrb_g1 xcbiasn_xrb_s1 xcbiasn_xrb_s2 vss rppd w=1u l=40u m=1 b=0
Xxcbiasn_xrb_g2 xcbiasn_xrb_s2 xcbiasn_xrb_s3 vss rppd w=1u l=40u m=1 b=0
Xxcbiasn_xrb_g3 xcbiasn_xrb_s3 vbn vss rppd w=1u l=40u m=1 b=0
Xxref_xmb0 ibias__p0 ibias vss__p5 vss sg13_hv_nmos w=2u l=1u ng=1 m=1
Xxref_xmt xref_ntl ibias vss__p6 vss sg13_hv_nmos w=2u l=8u ng=1 m=1
Xxref_xm1 xref_na vref_in xref_ntl__p1 vss sg13_hv_nmos w=10u l=1u ng=2 m=1
Xxref_xm2 xref_ng vref xref_ntl__p2 vss sg13_hv_nmos w=10u l=1u ng=2 m=1
Xxref_xm3 xref_na__p1 xref_na vdda__p5 vdda sg13_hv_pmos w=4u l=1u ng=1 m=1
Xxref_xm4 xref_ng__p1 xref_na vdda__p6 vdda sg13_hv_pmos w=4u l=1u ng=1 m=1
Xxref_xcg_u0 vss xref_ng__p2 cap_cmim w=26.32u l=95u m=1
Xxref_xmsf_s0 vdda__p1 xref_ng vref vss sg13_hv_nmos w=80u l=0.45u ng=32 m=1
Xxref_xmsf_s1 vdda__p2 xref_ng vref__p5 vss sg13_hv_nmos w=80u l=0.45u ng=32 m=1
Xxref_xmsf_s2 vdda__p3 xref_ng vref__p6 vss sg13_hv_nmos w=80u l=0.45u ng=32 m=1
Xxref_xmsf_s3 vdda__p4 xref_ng vref__p7 vss sg13_hv_nmos w=80u l=0.45u ng=32 m=1
Xxref_xmib_s0 vref__p0 ibias vss__p0 vss sg13_hv_nmos w=80u l=1u ng=40 m=1
Xxref_xmib_s1 vref__p1 ibias vss__p1 vss sg13_hv_nmos w=80u l=1u ng=40 m=1
Xxref_xmib_s2 vref__p2 ibias vss__p2 vss sg13_hv_nmos w=80u l=1u ng=40 m=1
Xxref_xmib_s3 vref__p3 ibias vss__p3 vss sg13_hv_nmos w=80u l=1u ng=40 m=1
Xxref_xcd_u0 vss vref__p8 cap_cmim w=51.58u l=95u m=1
Xxref_xcd_u1 vss vref__p9 cap_cmim w=51.58u l=95u m=1
Xxref_xcd_u2 vss vref__p10 cap_cmim w=51.58u l=95u m=1
Xxref_xcd_u3 vss vref__p11 cap_cmim w=51.58u l=95u m=1
Xxref_xmsfl_s0 vdda__p0 xref_ng vrefl vss sg13_hv_nmos w=80u l=0.45u ng=32 m=1
Xxref_xmibl_s0 vrefl__p0 ibias vss__p4 vss sg13_hv_nmos w=80u l=1u ng=40 m=1
Xxref_xcdl_u0 vss vrefl__p2 cap_cmim w=51.58u l=95u m=1
Xxref_xcdl_u1 vss vrefl__p3 cap_cmim w=51.58u l=95u m=1
Xxfilt_xcf_u0 vss vref_in__p1 cap_cmim w=37.36u l=90u m=1
Xxfilt_xcf_u1 vss vref_in__p2 cap_cmim w=37.36u l=90u m=1
Xslice_a ain_sin_p__p1 ain_sin_n__p1 ain_isa_p__p1 ain_isa_n__p1 sar_trka0__p1 sar_trka1__p1 sar_cpa0__p1 sar_cpa1__p1 sar_cpa2__p1 sar_cpa3__p1 sar_cpa4__p1 sar_cpa5__p1 sar_cpa6__p1 sar_cpa7__p1 sar_cpa8__p1 sar_cpa9__p1 sar_cpa10__p1 sar_cpa11__p1 sar_cpa12__p1 sar_cna0__p1 sar_cna1__p1 sar_cna2__p1 sar_cna3__p1 sar_cna4__p1 sar_cna5__p1 sar_cna6__p1 sar_cna7__p1 sar_cna8__p1 sar_cna9__p1 sar_cna10__p1 sar_cna11__p1 sar_cna12__p1 sar_clka__p1 sar_clkab__p1 sar_clkna__p1 sar_clknab__p1 sar_oap__p1 sar_oan__p1 sar_oanp__p1 sar_oann__p1 vbp__p2 vbn__p2 vref__p12 vref__p13 vref__p14 vrefl__p4 vrefl__p5 topap topan vdd__p12 vdd__p13 vdd__p14 vdd__p15 xslice_a_gnd_nc0 vss__p23 xslice_a_gnd_nc2 vss__p24 xslice_a_gnd_nc4 vss__p25 xslice_a_gnd_nc6 vss__p26 r1_adc_slice_post
Xslice_b ain_cos_p__p1 ain_cos_n__p1 ain_isb_p__p1 ain_isb_n__p1 sar_trkb0__p1 sar_trkb1__p1 sar_cpb0__p1 sar_cpb1__p1 sar_cpb2__p1 sar_cpb3__p1 sar_cpb4__p1 sar_cpb5__p1 sar_cpb6__p1 sar_cpb7__p1 sar_cpb8__p1 sar_cpb9__p1 sar_cpb10__p1 sar_cpb11__p1 sar_cpb12__p1 sar_cnb0__p1 sar_cnb1__p1 sar_cnb2__p1 sar_cnb3__p1 sar_cnb4__p1 sar_cnb5__p1 sar_cnb6__p1 sar_cnb7__p1 sar_cnb8__p1 sar_cnb9__p1 sar_cnb10__p1 sar_cnb11__p1 sar_cnb12__p1 sar_clkb__p1 sar_clkbb__p1 sar_clknb__p1 sar_clknbb__p1 sar_obp__p1 sar_obn__p1 sar_obnp__p1 sar_obnn__p1 vbp__p3 vbn__p3 vref__p15 vref__p16 vref__p17 vrefl__p6 vrefl__p7 topbp topbn vdd__p16 vdd__p17 vdd__p18 vdd__p19 vss__p27 xslice_b_gnd_nc1 vss__p28 xslice_b_gnd_nc3 vss__p29 xslice_b_gnd_nc5 vss__p30 xslice_b_gnd_nc7 r1_adc_slice_post
Rt0 ain_cos_n ain_cos_n__p1 126.828
Rt1 ain_cos_p ain_cos_p__p1 128.647
Rt2 ain_isa_n ain_isa_n__p1 127.972
Rt3 ain_isa_p ain_isa_p__p1 129.791
Rt4 ain_isb_n ain_isb_n__p1 0.198
Rt5 ain_isb_p ain_isb_p__p1 0.198
Rt6 ain_sin_n ain_sin_n__p1 0.308
Rt7 ain_sin_p ain_sin_p__p1 0.308
Rt8 clk clk__p0 141.519
Rt9 clk clk__p1 195.072
Rt10 clk__p0 clk__p1 49.582
Rt11 ibias ibias__p0 200.561
Rt12 mclkb mclkb__p1 43.3194
Rt13 sar_clka sar_clka__p1 12.3244
Rt14 sar_clkab sar_clkab__p1 12.3303
Rt15 sar_clkb sar_clkb__p1 12.498
Rt16 sar_clkbb sar_clkbb__p1 12.3244
Rt17 sar_clkna sar_clkna__p1 12.3244
Rt18 sar_clknab sar_clknab__p1 12.322
Rt19 sar_clknb sar_clknb__p1 12.3303
Rt20 sar_clknbb sar_clknbb__p1 12.3303
Rt21 sar_cna0 sar_cna0__p1 12.3244
Rt22 sar_cna1 sar_cna1__p1 12.3303
Rt23 sar_cna10 sar_cna10__p1 12.3244
Rt24 sar_cna11 sar_cna11__p1 12.3244
Rt25 sar_cna12 sar_cna12__p1 12.322
Rt26 sar_cna2 sar_cna2__p1 12.3303
Rt27 sar_cna3 sar_cna3__p1 12.3244
Rt28 sar_cna4 sar_cna4__p1 12.3303
Rt29 sar_cna5 sar_cna5__p1 12.3303
Rt30 sar_cna6 sar_cna6__p1 12.3244
Rt31 sar_cna7 sar_cna7__p1 12.3303
Rt32 sar_cna8 sar_cna8__p1 12.3244
Rt33 sar_cna9 sar_cna9__p1 12.322
Rt34 sar_cnb0 sar_cnb0__p1 12.498
Rt35 sar_cnb1 sar_cnb1__p1 12.322
Rt36 sar_cnb10 sar_cnb10__p1 12.498
Rt37 sar_cnb11 sar_cnb11__p1 12.3303
Rt38 sar_cnb12 sar_cnb12__p1 12.3303
Rt39 sar_cnb2 sar_cnb2__p1 12.3244
Rt40 sar_cnb3 sar_cnb3__p1 12.498
Rt41 sar_cnb4 sar_cnb4__p1 12.322
Rt42 sar_cnb5 sar_cnb5__p1 12.3244
Rt43 sar_cnb6 sar_cnb6__p1 12.498
Rt44 sar_cnb7 sar_cnb7__p1 12.322
Rt45 sar_cnb8 sar_cnb8__p1 12.3303
Rt46 sar_cnb9 sar_cnb9__p1 12.3303
Rt47 sar_cpa0 sar_cpa0__p1 12.3303
Rt48 sar_cpa1 sar_cpa1__p1 12.3244
Rt49 sar_cpa10 sar_cpa10__p1 12.322
Rt50 sar_cpa11 sar_cpa11__p1 12.3244
Rt51 sar_cpa12 sar_cpa12__p1 12.3244
Rt52 sar_cpa2 sar_cpa2__p1 12.3303
Rt53 sar_cpa3 sar_cpa3__p1 12.7425
Rt54 sar_cpa4 sar_cpa4__p1 12.3244
Rt55 sar_cpa5 sar_cpa5__p1 12.3303
Rt56 sar_cpa6 sar_cpa6__p1 12.3303
Rt57 sar_cpa7 sar_cpa7__p1 12.3244
Rt58 sar_cpa8 sar_cpa8__p1 12.3244
Rt59 sar_cpa9 sar_cpa9__p1 12.3244
Rt60 sar_cpb0 sar_cpb0__p1 12.322
Rt61 sar_cpb1 sar_cpb1__p1 12.498
Rt62 sar_cpb10 sar_cpb10__p1 12.3303
Rt63 sar_cpb11 sar_cpb11__p1 12.3303
Rt64 sar_cpb12 sar_cpb12__p1 12.498
Rt65 sar_cpb2 sar_cpb2__p1 12.3244
Rt66 sar_cpb3 sar_cpb3__p1 12.759
Rt67 sar_cpb4 sar_cpb4__p1 12.498
Rt68 sar_cpb5 sar_cpb5__p1 12.3244
Rt69 sar_cpb6 sar_cpb6__p1 12.322
Rt70 sar_cpb7 sar_cpb7__p1 12.498
Rt71 sar_cpb8 sar_cpb8__p1 12.3303
Rt72 sar_cpb9 sar_cpb9__p1 12.498
Rt73 sar_mclk sar_mclk__p0 170.374
Rt74 sar_mclk sar_mclk__p1 196.812
Rt75 sar_mclk sar_mclk__p2 307.715
Rt76 sar_mclk sar_mclk__p4 333.321
Rt77 sar_mclk__p0 sar_mclk__p1 70.5716
Rt78 sar_mclk__p0 sar_mclk__p2 110.338
Rt79 sar_mclk__p0 sar_mclk__p4 119.52
Rt80 sar_mclk__p1 sar_mclk__p2 101.952
Rt81 sar_mclk__p1 sar_mclk__p4 110.436
Rt82 sar_mclk__p2 sar_mclk__p3 0.6204
Rt83 sar_mclk__p2 sar_mclk__p4 64.7625
Rt84 sar_oan sar_oan__p1 12.3244
Rt85 sar_oann sar_oann__p1 12.3303
Rt86 sar_oanp sar_oanp__p1 12.3244
Rt87 sar_oap sar_oap__p1 12.322
Rt88 sar_obn sar_obn__p1 12.5344
Rt89 sar_obnn sar_obnn__p1 12.322
Rt90 sar_obnp sar_obnp__p1 12.498
Rt91 sar_obp sar_obp__p1 12.3303
Rt92 sar_trka0 sar_trka0__p1 12.3303
Rt93 sar_trka1 sar_trka1__p1 12.3303
Rt94 sar_trkb0 sar_trkb0__p1 12.3244
Rt95 sar_trkb1 sar_trkb1__p1 12.322
Rt96 vbn vbn__p1 68.8436
Rt97 vbn vbn__p2 240.016
Rt98 vbn vbn__p3 784.574
Rt99 vbn__p1 vbn__p2 217.489
Rt100 vbn__p1 vbn__p3 710.938
Rt101 vbn__p2 vbn__p3 168.032
Rt102 vbp vbp__p1 73.6975
Rt103 vbp vbp__p2 245.763
Rt104 vbp vbp__p3 1260.46
Rt105 vbp__p1 vbp__p2 195.517
Rt106 vbp__p1 vbp__p3 1002.76
Rt107 vbp__p2 vbp__p3 154.24
Rt108 vdd vdd__p0 34389.1
Rt109 vdd vdd__p1 40943
Rt110 vdd vdd__p11 68132.9
Rt111 vdd vdd__p12 82.2115
Rt112 vdd vdd__p13 11.0679
Rt113 vdd vdd__p14 29.2479
Rt114 vdd vdd__p15 437.715
Rt115 vdd vdd__p16 3424.56
Rt116 vdd vdd__p17 42939.2
Rt117 vdd vdd__p18 786782
Rt118 vdd__p0 vdd__p1 119.607
Rt119 vdd__p0 vdd__p12 99.6158
Rt120 vdd__p0 vdd__p13 288.609
Rt121 vdd__p0 vdd__p14 7716.14
Rt122 vdd__p0 vdd__p15 115478
Rt123 vdd__p0 vdd__p16 903464
Rt124 vdd__p1 vdd__p12 118.601
Rt125 vdd__p1 vdd__p13 343.612
Rt126 vdd__p1 vdd__p14 9186.68
Rt127 vdd__p1 vdd__p15 137485
Rt128 vdd__p11 vdd__p12 42970.9
Rt129 vdd__p11 vdd__p13 5785.07
Rt130 vdd__p11 vdd__p14 90.208
Rt131 vdd__p11 vdd__p15 12.7553
Rt132 vdd__p11 vdd__p16 14.0525
Rt133 vdd__p11 vdd__p17 160.888
Rt134 vdd__p11 vdd__p18 2947.98
Rt135 vdd__p11 vdd__p19 40686.4
Rt136 vdd__p11 vdd__p2 463.671
Rt137 vdd__p11 vdd__p3 424.895
Rt138 vdd__p11 vdd__p4 361.688
Rt139 vdd__p11 vdd__p5 291.702
Rt140 vdd__p11 vdd__p6 227.058
Rt141 vdd__p11 vdd__p7 29.9714
Rt142 vdd__p11 vdd__p8 158.698
Rt143 vdd__p11 vdd__p9 29.2186
Rt144 vdd__p12 vdd__p13 0.697261
Rt145 vdd__p12 vdd__p14 18.4464
Rt146 vdd__p12 vdd__p15 276.063
Rt147 vdd__p12 vdd__p16 2159.85
Rt148 vdd__p12 vdd__p17 27081.4
Rt149 vdd__p12 vdd__p18 496217
Rt150 vdd__p13 vdd__p14 2.48339
Rt151 vdd__p13 vdd__p15 37.1657
Rt152 vdd__p13 vdd__p16 290.775
Rt153 vdd__p13 vdd__p17 3645.91
Rt154 vdd__p13 vdd__p18 66804.5
Rt155 vdd__p13 vdd__p19 922000
Rt156 vdd__p13 vdd__p6 939934
Rt157 vdd__p13 vdd__p7 180555
Rt158 vdd__p13 vdd__p8 656946
Rt159 vdd__p13 vdd__p9 176021
Rt160 vdd__p14 vdd__p15 0.527112
Rt161 vdd__p14 vdd__p16 4.53412
Rt162 vdd__p14 vdd__p17 56.8516
Rt163 vdd__p14 vdd__p18 1041.7
Rt164 vdd__p14 vdd__p19 14377
Rt165 vdd__p14 vdd__p2 29930
Rt166 vdd__p14 vdd__p3 27427
Rt167 vdd__p14 vdd__p4 23347
Rt168 vdd__p14 vdd__p5 18829.3
Rt169 vdd__p14 vdd__p6 14656.6
Rt170 vdd__p14 vdd__p7 2815.45
Rt171 vdd__p14 vdd__p8 10243.9
Rt172 vdd__p14 vdd__p9 2744.73
Rt173 vdd__p15 vdd__p16 0.372867
Rt174 vdd__p15 vdd__p17 7.12045
Rt175 vdd__p15 vdd__p18 130.469
Rt176 vdd__p15 vdd__p19 1800.66
Rt177 vdd__p15 vdd__p2 4232.07
Rt178 vdd__p15 vdd__p3 3878.14
Rt179 vdd__p15 vdd__p4 3301.24
Rt180 vdd__p15 vdd__p5 2662.45
Rt181 vdd__p15 vdd__p6 2072.43
Rt182 vdd__p15 vdd__p7 398.102
Rt183 vdd__p15 vdd__p8 1448.48
Rt184 vdd__p15 vdd__p9 388.103
Rt185 vdd__p16 vdd__p17 0.804871
Rt186 vdd__p16 vdd__p18 14.9541
Rt187 vdd__p16 vdd__p19 206.388
Rt188 vdd__p16 vdd__p2 4662.44
Rt189 vdd__p16 vdd__p3 4272.53
Rt190 vdd__p16 vdd__p4 3636.95
Rt191 vdd__p16 vdd__p5 2933.2
Rt192 vdd__p16 vdd__p6 2283.19
Rt193 vdd__p16 vdd__p7 438.586
Rt194 vdd__p16 vdd__p8 1595.78
Rt195 vdd__p16 vdd__p9 427.57
Rt196 vdd__p17 vdd__p18 2.61782
Rt197 vdd__p17 vdd__p19 36.1298
Rt198 vdd__p17 vdd__p2 53380.8
Rt199 vdd__p17 vdd__p3 48916.6
Rt200 vdd__p17 vdd__p4 41639.9
Rt201 vdd__p17 vdd__p5 33582.6
Rt202 vdd__p17 vdd__p6 26140.5
Rt203 vdd__p17 vdd__p7 5021.42
Rt204 vdd__p17 vdd__p8 18270.3
Rt205 vdd__p17 vdd__p9 4895.3
Rt206 vdd__p18 vdd__p19 0.487307
Rt207 vdd__p18 vdd__p2 978105
Rt208 vdd__p18 vdd__p3 896307
Rt209 vdd__p18 vdd__p4 762974
Rt210 vdd__p18 vdd__p5 615339
Rt211 vdd__p18 vdd__p6 478976
Rt212 vdd__p18 vdd__p7 92008.3
Rt213 vdd__p18 vdd__p8 334770
Rt214 vdd__p18 vdd__p9 89697.3
Rt215 vdd__p2 vdd__p3 88.2674
Rt216 vdd__p2 vdd__p4 114.618
Rt217 vdd__p2 vdd__p5 144.634
Rt218 vdd__p2 vdd__p6 174.434
Rt219 vdd__p2 vdd__p7 14471.4
Rt220 vdd__p2 vdd__p8 225.153
Rt221 vdd__p2 vdd__p9 14108
Rt222 vdd__p3 vdd__p4 105.033
Rt223 vdd__p3 vdd__p5 132.538
Rt224 vdd__p3 vdd__p6 159.846
Rt225 vdd__p3 vdd__p7 13261.2
Rt226 vdd__p3 vdd__p8 206.324
Rt227 vdd__p3 vdd__p9 12928.1
Rt228 vdd__p4 vdd__p5 112.822
Rt229 vdd__p4 vdd__p6 136.068
Rt230 vdd__p4 vdd__p7 11288.5
Rt231 vdd__p4 vdd__p8 175.631
Rt232 vdd__p4 vdd__p9 11005
Rt233 vdd__p5 vdd__p6 109.739
Rt234 vdd__p5 vdd__p7 9104.19
Rt235 vdd__p5 vdd__p8 141.647
Rt236 vdd__p5 vdd__p9 8875.52
Rt237 vdd__p6 vdd__p7 7086.64
Rt238 vdd__p6 vdd__p8 110.257
Rt239 vdd__p6 vdd__p9 6908.64
Rt240 vdd__p7 vdd__p8 4953.05
Rt241 vdd__p7 vdd__p9 574.85
Rt242 vdd__p8 vdd__p9 4828.65
Rt243 vdda vdda__p1 41.3489
Rt244 vdda vdda__p2 278.578
Rt245 vdda vdda__p3 56.012
Rt246 vdda vdda__p5 261.48
Rt247 vdda vdda__p6 203.591
Rt248 vdda__p0 vdda__p3 62.8025
Rt249 vdda__p0 vdda__p4 67.5999
Rt250 vdda__p1 vdda__p2 1202.37
Rt251 vdda__p1 vdda__p3 241.754
Rt252 vdda__p1 vdda__p5 1128.58
Rt253 vdda__p1 vdda__p6 878.722
Rt254 vdda__p2 vdda__p3 256.165
Rt255 vdda__p2 vdda__p5 63.6193
Rt256 vdda__p2 vdda__p6 79.0683
Rt257 vdda__p3 vdda__p4 23.0314
Rt258 vdda__p3 vdda__p5 240.442
Rt259 vdda__p3 vdda__p6 187.211
Rt260 vdda__p5 vdda__p6 74.2153
Rt261 vref vref__p0 114.65
Rt262 vref vref__p1 6.10169
Rt263 vref vref__p10 186.142
Rt264 vref vref__p11 8271.36
Rt265 vref vref__p12 1487.93
Rt266 vref vref__p13 808.459
Rt267 vref vref__p14 372.871
Rt268 vref vref__p15 1459.54
Rt269 vref vref__p16 3157.02
Rt270 vref vref__p17 5801
Rt271 vref vref__p2 370.329
Rt272 vref vref__p3 10248.9
Rt273 vref vref__p5 428.96
Rt274 vref vref__p6 1135.72
Rt275 vref vref__p7 3138.93
Rt276 vref vref__p8 2223.31
Rt277 vref vref__p9 50.9452
Rt278 vref__p0 vref__p1 5.08178
Rt279 vref__p0 vref__p10 1372.92
Rt280 vref__p0 vref__p11 61005.8
Rt281 vref__p0 vref__p12 11330.2
Rt282 vref__p0 vref__p13 6156.32
Rt283 vref__p0 vref__p14 2839.43
Rt284 vref__p0 vref__p15 10764.9
Rt285 vref__p0 vref__p16 23284.7
Rt286 vref__p0 vref__p17 42785.5
Rt287 vref__p0 vref__p2 2151.06
Rt288 vref__p0 vref__p3 74645.3
Rt289 vref__p0 vref__p5 1782.68
Rt290 vref__p0 vref__p6 6979.82
Rt291 vref__p0 vref__p7 23027.9
Rt292 vref__p0 vref__p8 16928.7
Rt293 vref__p0 vref__p9 387.793
Rt294 vref__p1 vref__p10 27.2286
Rt295 vref__p1 vref__p11 1209.68
Rt296 vref__p1 vref__p12 366.189
Rt297 vref__p1 vref__p13 199.066
Rt298 vref__p1 vref__p14 91.8501
Rt299 vref__p1 vref__p15 213.441
Rt300 vref__p1 vref__p16 461.684
Rt301 vref__p1 vref__p17 848.354
Rt302 vref__p1 vref__p2 8.38761
Rt303 vref__p1 vref__p3 1193.26
Rt304 vref__p1 vref__p5 6.38445
Rt305 vref__p1 vref__p6 32.923
Rt306 vref__p1 vref__p7 414.228
Rt307 vref__p1 vref__p8 546.455
Rt308 vref__p1 vref__p9 12.4499
Rt309 vref__p10 vref__p11 1.96723
Rt310 vref__p10 vref__p12 390.352
Rt311 vref__p10 vref__p13 212.377
Rt312 vref__p10 vref__p14 98.0606
Rt313 vref__p10 vref__p15 1.88326
Rt314 vref__p10 vref__p16 2.58285
Rt315 vref__p10 vref__p17 2.96452
Rt316 vref__p10 vref__p2 13.5031
Rt317 vref__p10 vref__p3 151.839
Rt318 vref__p10 vref__p5 105.826
Rt319 vref__p10 vref__p6 71.6163
Rt320 vref__p10 vref__p7 45.7002
Rt321 vref__p10 vref__p8 581.257
Rt322 vref__p10 vref__p9 13.1189
Rt323 vref__p11 vref__p12 17345.9
Rt324 vref__p11 vref__p13 9437.27
Rt325 vref__p11 vref__p14 4357.47
Rt326 vref__p11 vref__p15 11.7242
Rt327 vref__p11 vref__p16 6.70636
Rt328 vref__p11 vref__p17 3.30899
Rt329 vref__p11 vref__p2 588.996
Rt330 vref__p11 vref__p3 6559.22
Rt331 vref__p11 vref__p5 4701.78
Rt332 vref__p11 vref__p6 3179.28
Rt333 vref__p11 vref__p7 1973.95
Rt334 vref__p11 vref__p8 25829
Rt335 vref__p11 vref__p9 582.958
Rt336 vref__p12 vref__p13 2.76051
Rt337 vref__p12 vref__p14 5.69068
Rt338 vref__p12 vref__p15 3060.82
Rt339 vref__p12 vref__p16 6620.62
Rt340 vref__p12 vref__p17 12165.3
Rt341 vref__p12 vref__p2 961.871
Rt342 vref__p12 vref__p3 21690.6
Rt343 vref__p12 vref__p5 2025.57
Rt344 vref__p12 vref__p6 2781.47
Rt345 vref__p12 vref__p7 6608.37
Rt346 vref__p12 vref__p8 3.41549
Rt347 vref__p12 vref__p9 2.8795
Rt348 vref__p13 vref__p14 2.76481
Rt349 vref__p13 vref__p15 1665.29
Rt350 vref__p13 vref__p16 3602.05
Rt351 vref__p13 vref__p17 6618.72
Rt352 vref__p13 vref__p2 523.306
Rt353 vref__p13 vref__p3 11801.1
Rt354 vref__p13 vref__p5 1101.86
Rt355 vref__p13 vref__p6 1513.26
Rt356 vref__p13 vref__p7 3595.37
Rt357 vref__p13 vref__p8 6.9687
Rt358 vref__p13 vref__p9 2.56608
Rt359 vref__p14 vref__p15 768.912
Rt360 vref__p14 vref__p16 1663.17
Rt361 vref__p14 vref__p17 3056.06
Rt362 vref__p14 vref__p2 241.621
Rt363 vref__p14 vref__p3 5448.89
Rt364 vref__p14 vref__p5 508.693
Rt365 vref__p14 vref__p6 698.702
Rt366 vref__p14 vref__p7 1660.09
Rt367 vref__p14 vref__p8 12.1708
Rt368 vref__p14 vref__p9 1.86726
Rt369 vref__p15 vref__p16 2.76621
Rt370 vref__p15 vref__p17 5.68373
Rt371 vref__p15 vref__p2 103.213
Rt372 vref__p15 vref__p3 1145.31
Rt373 vref__p15 vref__p5 829.619
Rt374 vref__p15 vref__p6 560.804
Rt375 vref__p15 vref__p7 344.658
Rt376 vref__p15 vref__p8 4557.75
Rt377 vref__p15 vref__p9 102.868
Rt378 vref__p16 vref__p17 2.75986
Rt379 vref__p16 vref__p2 223.556
Rt380 vref__p16 vref__p3 2482.45
Rt381 vref__p16 vref__p5 1794.5
Rt382 vref__p16 vref__p6 1213.12
Rt383 vref__p16 vref__p7 747.047
Rt384 vref__p16 vref__p8 9858.5
Rt385 vref__p16 vref__p9 222.505
Rt386 vref__p17 vref__p2 411.407
Rt387 vref__p17 vref__p3 4571.97
Rt388 vref__p17 vref__p5 3297.42
Rt389 vref__p17 vref__p6 2229.27
Rt390 vref__p17 vref__p7 1375.86
Rt391 vref__p17 vref__p8 18114.9
Rt392 vref__p17 vref__p9 408.851
Rt393 vref__p2 vref__p3 5.49374
Rt394 vref__p2 vref__p5 65.7993
Rt395 vref__p2 vref__p6 7.45703
Rt396 vref__p2 vref__p7 6.5906
Rt397 vref__p2 vref__p8 1432.38
Rt398 vref__p2 vref__p9 32.3382
Rt399 vref__p3 vref__p5 5279.01
Rt400 vref__p3 vref__p6 2064.28
Rt401 vref__p3 vref__p7 48.2546
Rt402 vref__p3 vref__p8 32298.7
Rt403 vref__p3 vref__p9 728.99
Rt404 vref__p5 vref__p6 244.984
Rt405 vref__p5 vref__p7 1709.1
Rt406 vref__p5 vref__p8 3017.46
Rt407 vref__p5 vref__p9 68.2281
Rt408 vref__p6 vref__p7 871.249
Rt409 vref__p6 vref__p8 4142.06
Rt410 vref__p6 vref__p9 93.5132
Rt411 vref__p7 vref__p8 9840.28
Rt412 vref__p7 vref__p9 222.096
Rt413 vref__p8 vref__p9 1.94076
Rt414 vref_in vref_in__p1 0.001
Rt415 vref_in vref_in__p2 0.001
Rt416 vrefl vrefl__p0 31.2586
Rt417 vrefl vrefl__p2 93.437
Rt418 vrefl vrefl__p3 7.18444
Rt419 vrefl vrefl__p4 7325.4
Rt420 vrefl vrefl__p5 4916.21
Rt421 vrefl vrefl__p6 359.98
Rt422 vrefl vrefl__p7 574.557
Rt423 vrefl__p0 vrefl__p2 18.0283
Rt424 vrefl__p0 vrefl__p3 12.5916
Rt425 vrefl__p0 vrefl__p4 63.5642
Rt426 vrefl__p0 vrefl__p5 72.9525
Rt427 vrefl__p0 vrefl__p6 631.93
Rt428 vrefl__p0 vrefl__p7 1009.16
Rt429 vrefl__p2 vrefl__p3 2.16812
Rt430 vrefl__p2 vrefl__p4 8.30061
Rt431 vrefl__p2 vrefl__p5 5.37046
Rt432 vrefl__p2 vrefl__p6 117.734
Rt433 vrefl__p2 vrefl__p7 192.433
Rt434 vrefl__p3 vrefl__p4 211.164
Rt435 vrefl__p3 vrefl__p5 128.531
Rt436 vrefl__p3 vrefl__p6 5.07096
Rt437 vrefl__p3 vrefl__p7 7.53987
Rt438 vrefl__p4 vrefl__p5 31.8717
Rt439 vrefl__p4 vrefl__p6 11315.9
Rt440 vrefl__p4 vrefl__p7 18493.5
Rt441 vrefl__p5 vrefl__p6 6889.67
Rt442 vrefl__p5 vrefl__p7 11261.9
Rt443 vrefl__p6 vrefl__p7 32.2289
Rt444 vss vss__p0 34.9503
Rt445 vss vss__p1 372.756
Rt446 vss vss__p10 18233.6
Rt447 vss vss__p11 33061.6
Rt448 vss vss__p12 32281.5
Rt449 vss vss__p13 55884.9
Rt450 vss vss__p14 78141.4
Rt451 vss vss__p15 250270
Rt452 vss vss__p16 358.209
Rt453 vss vss__p17 3653.28
Rt454 vss vss__p18 96113.9
Rt455 vss vss__p19 74114.8
Rt456 vss vss__p2 152.168
Rt457 vss vss__p20 138679
Rt458 vss vss__p22 0.001
Rt459 vss vss__p23 2
Rt460 vss vss__p24 2
Rt461 vss vss__p25 2
Rt462 vss vss__p26 2
Rt463 vss vss__p27 2
Rt464 vss vss__p28 2
Rt465 vss vss__p29 2
Rt466 vss vss__p3 89.0698
Rt467 vss vss__p30 2
Rt468 vss vss__p4 1076.06
Rt469 vss vss__p5 1332.84
Rt470 vss vss__p6 1752.7
Rt471 vss vss__p7 37.7353
Rt472 vss vss__p8 41.2417
Rt473 vss vss__p9 13512
Rt474 vss__p0 vss__p1 169.257
Rt475 vss__p0 vss__p10 782087
Rt476 vss__p0 vss__p16 15364.5
Rt477 vss__p0 vss__p17 156699
Rt478 vss__p0 vss__p2 6656.8
Rt479 vss__p0 vss__p3 3896.48
Rt480 vss__p0 vss__p4 488.606
Rt481 vss__p0 vss__p5 605.203
Rt482 vss__p0 vss__p6 795.845
Rt483 vss__p0 vss__p7 445.256
Rt484 vss__p0 vss__p8 490.044
Rt485 vss__p0 vss__p9 579567
Rt486 vss__p1 vss__p16 163868
Rt487 vss__p1 vss__p2 70997
Rt488 vss__p1 vss__p3 41557.2
Rt489 vss__p1 vss__p4 340.811
Rt490 vss__p1 vss__p5 422.139
Rt491 vss__p1 vss__p6 555.115
Rt492 vss__p1 vss__p7 4748.8
Rt493 vss__p1 vss__p8 5226.48
Rt494 vss__p10 vss__p11 184.446
Rt495 vss__p10 vss__p12 176.62
Rt496 vss__p10 vss__p13 307.671
Rt497 vss__p10 vss__p14 433.768
Rt498 vss__p10 vss__p15 1374.05
Rt499 vss__p10 vss__p16 139.567
Rt500 vss__p10 vss__p17 158.772
Rt501 vss__p10 vss__p18 555.994
Rt502 vss__p10 vss__p19 420.703
Rt503 vss__p10 vss__p2 352658
Rt504 vss__p10 vss__p20 808.124
Rt505 vss__p10 vss__p3 206424
Rt506 vss__p10 vss__p7 729352
Rt507 vss__p10 vss__p8 877308
Rt508 vss__p10 vss__p9 116.749
Rt509 vss__p11 vss__p12 195.406
Rt510 vss__p11 vss__p13 338.903
Rt511 vss__p11 vss__p14 475.02
Rt512 vss__p11 vss__p15 1516.48
Rt513 vss__p11 vss__p16 178.921
Rt514 vss__p11 vss__p17 29.8046
Rt515 vss__p11 vss__p18 591.254
Rt516 vss__p11 vss__p19 453.468
Rt517 vss__p11 vss__p2 639448
Rt518 vss__p11 vss__p20 854.867
Rt519 vss__p11 vss__p3 374293
Rt520 vss__p11 vss__p9 216.223
Rt521 vss__p12 vss__p13 190.25
Rt522 vss__p12 vss__p14 268.323
Rt523 vss__p12 vss__p15 849.545
Rt524 vss__p12 vss__p16 238.363
Rt525 vss__p12 vss__p17 142.029
Rt526 vss__p12 vss__p18 344.585
Rt527 vss__p12 vss__p19 260.506
Rt528 vss__p12 vss__p2 624361
Rt529 vss__p12 vss__p20 501.021
Rt530 vss__p12 vss__p3 365462
Rt531 vss__p12 vss__p9 207.081
Rt532 vss__p13 vss__p14 258.166
Rt533 vss__p13 vss__p15 860.032
Rt534 vss__p13 vss__p16 369.321
Rt535 vss__p13 vss__p17 80.5843
Rt536 vss__p13 vss__p18 42.4547
Rt537 vss__p13 vss__p19 227.381
Rt538 vss__p13 vss__p20 393.238
Rt539 vss__p13 vss__p3 632678
Rt540 vss__p13 vss__p9 360.715
Rt541 vss__p14 vss__p15 564.732
Rt542 vss__p14 vss__p16 453.74
Rt543 vss__p14 vss__p17 59.7988
Rt544 vss__p14 vss__p18 294.155
Rt545 vss__p14 vss__p19 55.3288
Rt546 vss__p14 vss__p20 194.885
Rt547 vss__p14 vss__p3 884646
Rt548 vss__p14 vss__p9 508.519
Rt549 vss__p15 vss__p16 1734.54
Rt550 vss__p15 vss__p17 513.739
Rt551 vss__p15 vss__p18 1398.8
Rt552 vss__p15 vss__p19 33.7794
Rt553 vss__p15 vss__p20 860.442
Rt554 vss__p15 vss__p9 1610.98
Rt555 vss__p16 vss__p17 1.54041
Rt556 vss__p16 vss__p18 350.696
Rt557 vss__p16 vss__p19 325.248
Rt558 vss__p16 vss__p2 6928.16
Rt559 vss__p16 vss__p20 475.339
Rt560 vss__p16 vss__p3 4055.32
Rt561 vss__p16 vss__p4 473049
Rt562 vss__p16 vss__p5 585932
Rt563 vss__p16 vss__p6 770504
Rt564 vss__p16 vss__p7 14328.5
Rt565 vss__p16 vss__p8 17235.2
Rt566 vss__p16 vss__p9 104.892
Rt567 vss__p17 vss__p18 22.3758
Rt568 vss__p17 vss__p19 25.21
Rt569 vss__p17 vss__p2 70658.6
Rt570 vss__p17 vss__p20 28.8059
Rt571 vss__p17 vss__p3 41359.2
Rt572 vss__p17 vss__p7 146133
Rt573 vss__p17 vss__p8 175777
Rt574 vss__p17 vss__p9 176.386
Rt575 vss__p18 vss__p19 169.03
Rt576 vss__p18 vss__p20 217.768
Rt577 vss__p18 vss__p9 651.585
Rt578 vss__p19 vss__p20 98.6071
Rt579 vss__p19 vss__p3 839061
Rt580 vss__p19 vss__p9 493.112
Rt581 vss__p2 vss__p3 63.5786
Rt582 vss__p2 vss__p4 204952
Rt583 vss__p2 vss__p5 253860
Rt584 vss__p2 vss__p6 333827
Rt585 vss__p2 vss__p7 6636.18
Rt586 vss__p2 vss__p8 7704.98
Rt587 vss__p2 vss__p9 261338
Rt588 vss__p20 vss__p9 947.006
Rt589 vss__p3 vss__p4 119966
Rt590 vss__p3 vss__p5 148594
Rt591 vss__p3 vss__p6 195402
Rt592 vss__p3 vss__p7 3884.41
Rt593 vss__p3 vss__p8 4510.02
Rt594 vss__p3 vss__p9 152971
Rt595 vss__p4 vss__p5 99.6258
Rt596 vss__p4 vss__p6 131.008
Rt597 vss__p4 vss__p7 13708.7
Rt598 vss__p4 vss__p8 15087.7
Rt599 vss__p5 vss__p6 57.9371
Rt600 vss__p5 vss__p7 16980
Rt601 vss__p5 vss__p8 18688
Rt602 vss__p6 vss__p7 22328.8
Rt603 vss__p6 vss__p8 24574.9
Rt604 vss__p7 vss__p8 217.113
Rt605 vss__p7 vss__p9 540488
Rt606 vss__p8 vss__p9 650130
Rt607 xckg_d0 xckg_d0__p1 158.064
Rt608 xckg_d0 xckg_d0__p2 32.5
Rt609 xckg_d0__p1 xckg_d0__p2 72.9819
Rt610 xckg_d1 xckg_d1__p1 160.822
Rt611 xckg_d1 xckg_d1__p2 33.3377
Rt612 xckg_d1__p1 xckg_d1__p2 71.7995
Rt613 xckg_d2 xckg_d2__p1 253.776
Rt614 xckg_d2 xckg_d2__p2 56.8495
Rt615 xckg_d2__p1 xckg_d2__p2 62.5432
Rt616 xckg_d3 xckg_d3__p1 116.773
Rt617 xckg_d3 xckg_d3__p2 66.8961
Rt618 xckg_d3__p1 xckg_d3__p2 71.2846
Rt619 xckg_nn xckg_nn__p1 46.1928
Rt620 xckg_x xckg_x__p1 101.928
Rt621 xckg_x xckg_x__p2 247.825
Rt622 xckg_x xckg_x__p3 173.816
Rt623 xckg_x xckg_x__p4 124.476
Rt624 xckg_x__p1 xckg_x__p2 156.926
Rt625 xckg_x__p1 xckg_x__p3 110.063
Rt626 xckg_x__p1 xckg_x__p4 78.82
Rt627 xckg_x__p2 xckg_x__p3 94.6454
Rt628 xckg_x__p2 xckg_x__p4 142.468
Rt629 xckg_x__p3 xckg_x__p4 99.922
Rt630 xref_na xref_na__p1 77.984
Rt631 xref_ng xref_ng__p1 1225.95
Rt632 xref_ng xref_ng__p2 132.884
Rt633 xref_ng__p1 xref_ng__p2 31.5508
Rt634 xref_ntl xref_ntl__p1 60.2546
Rt635 xref_ntl__p1 xref_ntl__p2 19.318
Cq0 ain_cos_n ain_cos_p 2.707e-14
Cq1 ain_cos_n ain_isa_n 3.445e-17
Cq2 ain_cos_n ain_isa_p 4.604e-17
Cq3 ain_cos_n ibias 1.097e-16
Cq4 ain_cos_n sar_clka 2.933e-17
Cq5 ain_cos_n sar_clkab 2.933e-17
Cq6 ain_cos_n sar_clkna 2.933e-17
Cq7 ain_cos_n sar_clknab 2.946e-17
Cq8 ain_cos_n sar_cna0 4.649e-17
Cq9 ain_cos_n sar_cna1 4.481e-17
Cq10 ain_cos_n sar_cna10 4.578e-17
Cq11 ain_cos_n sar_cna11 4.578e-17
Cq12 ain_cos_n sar_cna12 4.578e-17
Cq13 ain_cos_n sar_cna2 3.756e-17
Cq14 ain_cos_n sar_cna3 3.984e-17
Cq15 ain_cos_n sar_cna4 4.481e-17
Cq16 ain_cos_n sar_cna5 4.481e-17
Cq17 ain_cos_n sar_cna6 4.537e-17
Cq18 ain_cos_n sar_cna7 4.802e-17
Cq19 ain_cos_n sar_cna8 4.746e-17
Cq20 ain_cos_n sar_cna9 4.578e-17
Cq21 ain_cos_n sar_cpa0 4.649e-17
Cq22 ain_cos_n sar_cpa1 4.537e-17
Cq23 ain_cos_n sar_cpa10 4.578e-17
Cq24 ain_cos_n sar_cpa11 4.578e-17
Cq25 ain_cos_n sar_cpa12 4.578e-17
Cq26 ain_cos_n sar_cpa2 4.337e-17
Cq27 ain_cos_n sar_cpa3 3.579e-17
Cq28 ain_cos_n sar_cpa4 4.337e-17
Cq29 ain_cos_n sar_cpa5 4.634e-17
Cq30 ain_cos_n sar_cpa6 4.481e-17
Cq31 ain_cos_n sar_cpa7 4.649e-17
Cq32 ain_cos_n sar_cpa8 4.746e-17
Cq33 ain_cos_n sar_cpa9 4.578e-17
Cq34 ain_cos_n sar_oan 4.184e-17
Cq35 ain_cos_n sar_oann 4.384e-17
Cq36 ain_cos_n sar_oanp 4.649e-17
Cq37 ain_cos_n sar_oap 3.459e-17
Cq38 ain_cos_n sar_trka0 5.23e-17
Cq39 ain_cos_n sar_trka1 4.808e-17
Cq40 ain_cos_n sar_trkb0 1.443e-17
Cq41 ain_cos_n vdd 3.063e-15
Cq42 ain_cos_n vss 3.507e-14
Cq43 ain_cos_n xckg_d0 4.043e-19
Cq44 ain_cos_n xckg_d1 7.338e-19
Cq45 ain_cos_n xckg_d2 8.525e-19
Cq46 ain_cos_n xckg_d3 1.362e-18
Cq47 ain_cos_n xckg_x 2.674e-17
Cq48 ain_cos_p ain_isa_n 3.424e-17
Cq49 ain_cos_p ain_isa_p 4.84e-17
Cq50 ain_cos_p ibias 2.317e-16
Cq51 ain_cos_p sar_clka 2.933e-17
Cq52 ain_cos_p sar_clkab 2.933e-17
Cq53 ain_cos_p sar_clkna 2.933e-17
Cq54 ain_cos_p sar_clknab 2.951e-17
Cq55 ain_cos_p sar_cna0 4.649e-17
Cq56 ain_cos_p sar_cna1 4.481e-17
Cq57 ain_cos_p sar_cna10 4.578e-17
Cq58 ain_cos_p sar_cna11 4.578e-17
Cq59 ain_cos_p sar_cna12 4.578e-17
Cq60 ain_cos_p sar_cna2 3.756e-17
Cq61 ain_cos_p sar_cna3 3.984e-17
Cq62 ain_cos_p sar_cna4 4.481e-17
Cq63 ain_cos_p sar_cna5 4.481e-17
Cq64 ain_cos_p sar_cna6 4.537e-17
Cq65 ain_cos_p sar_cna7 4.802e-17
Cq66 ain_cos_p sar_cna8 4.746e-17
Cq67 ain_cos_p sar_cna9 4.578e-17
Cq68 ain_cos_p sar_cpa0 4.649e-17
Cq69 ain_cos_p sar_cpa1 4.537e-17
Cq70 ain_cos_p sar_cpa10 4.578e-17
Cq71 ain_cos_p sar_cpa11 4.578e-17
Cq72 ain_cos_p sar_cpa12 4.578e-17
Cq73 ain_cos_p sar_cpa2 4.337e-17
Cq74 ain_cos_p sar_cpa3 3.788e-17
Cq75 ain_cos_p sar_cpa4 4.337e-17
Cq76 ain_cos_p sar_cpa5 4.634e-17
Cq77 ain_cos_p sar_cpa6 4.481e-17
Cq78 ain_cos_p sar_cpa7 4.649e-17
Cq79 ain_cos_p sar_cpa8 4.746e-17
Cq80 ain_cos_p sar_cpa9 4.578e-17
Cq81 ain_cos_p sar_oan 4.184e-17
Cq82 ain_cos_p sar_oann 4.384e-17
Cq83 ain_cos_p sar_oanp 4.649e-17
Cq84 ain_cos_p sar_oap 3.459e-17
Cq85 ain_cos_p sar_trka0 5.315e-17
Cq86 ain_cos_p sar_trka1 4.808e-17
Cq87 ain_cos_p sar_trkb0 4.662e-19
Cq88 ain_cos_p vdd 2.211e-15
Cq89 ain_cos_p vss 3.544e-14
Cq90 ain_cos_p xckg_d3 3.348e-19
Cq91 ain_cos_p xckg_x 2.003e-17
Cq92 ain_isa_n ain_isa_p 2.783e-14
Cq93 ain_isa_n ain_isb_n 6.15e-17
Cq94 ain_isa_n ain_isb_p 6.417e-17
Cq95 ain_isa_n sar_clkb 4.864e-17
Cq96 ain_isa_n sar_clkbb 4.746e-17
Cq97 ain_isa_n sar_clknab 9.415e-19
Cq98 ain_isa_n sar_clknb 4.184e-17
Cq99 ain_isa_n sar_clknbb 2.965e-17
Cq100 ain_isa_n sar_cnb0 4.649e-17
Cq101 ain_isa_n sar_cnb1 4.481e-17
Cq102 ain_isa_n sar_cnb10 4.578e-17
Cq103 ain_isa_n sar_cnb11 4.578e-17
Cq104 ain_isa_n sar_cnb12 4.578e-17
Cq105 ain_isa_n sar_cnb2 3.756e-17
Cq106 ain_isa_n sar_cnb3 3.984e-17
Cq107 ain_isa_n sar_cnb4 4.481e-17
Cq108 ain_isa_n sar_cnb5 4.481e-17
Cq109 ain_isa_n sar_cnb6 4.537e-17
Cq110 ain_isa_n sar_cnb7 4.802e-17
Cq111 ain_isa_n sar_cnb8 4.746e-17
Cq112 ain_isa_n sar_cnb9 4.578e-17
Cq113 ain_isa_n sar_cpb0 4.649e-17
Cq114 ain_isa_n sar_cpb1 4.537e-17
Cq115 ain_isa_n sar_cpb10 4.578e-17
Cq116 ain_isa_n sar_cpb11 4.578e-17
Cq117 ain_isa_n sar_cpb12 4.578e-17
Cq118 ain_isa_n sar_cpb2 4.537e-17
Cq119 ain_isa_n sar_cpb3 4.024e-17
Cq120 ain_isa_n sar_cpb4 4.337e-17
Cq121 ain_isa_n sar_cpb5 4.634e-17
Cq122 ain_isa_n sar_cpb6 4.481e-17
Cq123 ain_isa_n sar_cpb7 4.649e-17
Cq124 ain_isa_n sar_cpb8 4.746e-17
Cq125 ain_isa_n sar_cpb9 4.578e-17
Cq126 ain_isa_n sar_obn 4.184e-17
Cq127 ain_isa_n sar_obnn 4.481e-17
Cq128 ain_isa_n sar_obnp 4.649e-17
Cq129 ain_isa_n sar_obp 3.459e-17
Cq130 ain_isa_n sar_trkb0 4.883e-17
Cq131 ain_isa_n sar_trkb1 4.833e-17
Cq132 ain_isa_n vdd 8.828e-17
Cq133 ain_isa_n vss 3.302e-14
Cq134 ain_isa_p ain_isb_n 7.645e-17
Cq135 ain_isa_p ain_isb_p 7.912e-17
Cq136 ain_isa_p sar_clkb 4.864e-17
Cq137 ain_isa_p sar_clkbb 4.746e-17
Cq138 ain_isa_p sar_clknab 7.019e-19
Cq139 ain_isa_p sar_clknb 4.184e-17
Cq140 ain_isa_p sar_clknbb 3.499e-17
Cq141 ain_isa_p sar_cnb0 4.649e-17
Cq142 ain_isa_p sar_cnb1 4.481e-17
Cq143 ain_isa_p sar_cnb10 4.578e-17
Cq144 ain_isa_p sar_cnb11 4.578e-17
Cq145 ain_isa_p sar_cnb12 4.578e-17
Cq146 ain_isa_p sar_cnb2 3.756e-17
Cq147 ain_isa_p sar_cnb3 3.984e-17
Cq148 ain_isa_p sar_cnb4 4.481e-17
Cq149 ain_isa_p sar_cnb5 4.481e-17
Cq150 ain_isa_p sar_cnb6 4.537e-17
Cq151 ain_isa_p sar_cnb7 4.802e-17
Cq152 ain_isa_p sar_cnb8 4.746e-17
Cq153 ain_isa_p sar_cnb9 4.578e-17
Cq154 ain_isa_p sar_cpb0 4.649e-17
Cq155 ain_isa_p sar_cpb1 4.537e-17
Cq156 ain_isa_p sar_cpb10 4.578e-17
Cq157 ain_isa_p sar_cpb11 4.578e-17
Cq158 ain_isa_p sar_cpb12 4.578e-17
Cq159 ain_isa_p sar_cpb2 4.537e-17
Cq160 ain_isa_p sar_cpb3 4.047e-17
Cq161 ain_isa_p sar_cpb4 4.337e-17
Cq162 ain_isa_p sar_cpb5 4.634e-17
Cq163 ain_isa_p sar_cpb6 4.481e-17
Cq164 ain_isa_p sar_cpb7 4.649e-17
Cq165 ain_isa_p sar_cpb8 4.746e-17
Cq166 ain_isa_p sar_cpb9 4.578e-17
Cq167 ain_isa_p sar_mclk 2.531e-18
Cq168 ain_isa_p sar_obn 4.184e-17
Cq169 ain_isa_p sar_obnn 4.481e-17
Cq170 ain_isa_p sar_obnp 4.649e-17
Cq171 ain_isa_p sar_obp 3.459e-17
Cq172 ain_isa_p sar_trkb0 5.684e-17
Cq173 ain_isa_p sar_trkb1 4.833e-17
Cq174 ain_isa_p vdd 1.13e-16
Cq175 ain_isa_p vss 3.362e-14
Cq176 ain_isb_n ain_isb_p 7.431e-17
Cq177 ain_isb_n vss 9.265e-16
Cq178 ain_isb_p vss 8.611e-16
Cq179 ain_sin_n ain_sin_p 8.625e-17
Cq180 ain_sin_n ibias 9.686e-17
Cq181 ain_sin_n vss 7.977e-16
Cq182 ain_sin_p ibias 9.686e-17
Cq183 ain_sin_p vss 7.924e-16
Cq184 clk mclkb 1.252e-18
Cq185 clk sar_clka 3.704e-17
Cq186 clk sar_clkab 2.773e-17
Cq187 clk sar_clkna 3.212e-17
Cq188 clk sar_clknab 4.043e-18
Cq189 clk sar_cna0 4.953e-17
Cq190 clk sar_cna1 4.301e-17
Cq191 clk sar_cna10 4.59e-17
Cq192 clk sar_cna11 4.59e-17
Cq193 clk sar_cna12 4.443e-17
Cq194 clk sar_cna2 3.644e-17
Cq195 clk sar_cna3 3.581e-17
Cq196 clk sar_cna4 4.301e-17
Cq197 clk sar_cna5 4.301e-17
Cq198 clk sar_cna6 4.534e-17
Cq199 clk sar_cna7 5.255e-17
Cq200 clk sar_cna8 5.168e-17
Cq201 clk sar_cna9 4.443e-17
Cq202 clk sar_cpa0 4.489e-17
Cq203 clk sar_cpa1 4.592e-17
Cq204 clk sar_cpa10 4.443e-17
Cq205 clk sar_cpa11 4.59e-17
Cq206 clk sar_cpa12 4.59e-17
Cq207 clk sar_cpa2 4.223e-17
Cq208 clk sar_cpa3 3.127e-17
Cq209 clk sar_cpa4 4.339e-17
Cq210 clk sar_cpa5 4.676e-17
Cq211 clk sar_cpa6 4.301e-17
Cq212 clk sar_cpa7 4.953e-17
Cq213 clk sar_cpa8 5.168e-17
Cq214 clk sar_cpa9 4.59e-17
Cq215 clk sar_mclk 4.18e-16
Cq216 clk sar_oan 3.87e-17
Cq217 clk sar_oann 4.086e-17
Cq218 clk sar_oanp 4.931e-17
Cq219 clk sar_oap 3.067e-17
Cq220 clk sar_trka0 6.343e-17
Cq221 clk sar_trka1 5.755e-17
Cq222 clk vdd 1.554e-15
Cq223 clk vss 2.921e-14
Cq224 clk xckg_d0 3.206e-16
Cq225 clk xckg_d1 1.883e-16
Cq226 clk xckg_d2 1.491e-16
Cq227 clk xckg_d3 2.541e-16
Cq228 clk xckg_nn 2.492e-17
Cq229 clk xckg_x 3.281e-16
Cq230 ibias sar_trka0 1.287e-17
Cq231 ibias vbn 2.266e-15
Cq232 ibias vbp 6.102e-17
Cq233 ibias vdd 4.502e-15
Cq234 ibias vdda 2.216e-16
Cq235 ibias vref 4.11e-14
Cq236 ibias vref_in 9.847e-15
Cq237 ibias vrefl 1.687e-14
Cq238 ibias vss 1.681e-13
Cq239 ibias xref_ng 2.101e-15
Cq240 ibias xref_ntl 1.737e-16
Cq241 mclkb sar_clknab 4.044e-17
Cq242 mclkb sar_mclk 2.778e-16
Cq243 mclkb sar_trkb0 2.442e-18
Cq244 mclkb vdd 1.741e-15
Cq245 mclkb vss 5.564e-15
Cq246 mclkb xckg_d0 1.25e-15
Cq247 mclkb xckg_d1 2.7e-16
Cq248 mclkb xckg_d2 2.182e-16
Cq249 mclkb xckg_d3 1.483e-17
Cq250 mclkb xckg_nn 2.576e-17
Cq251 mclkb xckg_x 1.907e-17
Cq252 sar_clka sar_trka1 4.996e-17
Cq253 sar_clka vdd 5.939e-18
Cq254 sar_clka vss 4.415e-15
Cq255 sar_clkab sar_mclk 3.485e-17
Cq256 sar_clkab sar_oann 9.641e-17
Cq257 sar_clkab vdd 5.391e-18
Cq258 sar_clkab vss 4.557e-15
Cq259 sar_clkb sar_trkb1 1.541e-16
Cq260 sar_clkb vdd 9.721e-18
Cq261 sar_clkb vss 1.963e-15
Cq262 sar_clkbb sar_obnn 3.064e-16
Cq263 sar_clkbb sar_obnp 3.919e-19
Cq264 sar_clkbb vdd 6.807e-18
Cq265 sar_clkbb vss 1.715e-15
Cq266 sar_clkna sar_cpa2 1.689e-16
Cq267 sar_clkna sar_cpa3 7.355e-16
Cq268 sar_clkna sar_cpa4 1.185e-17
Cq269 sar_clkna sar_mclk 3.502e-17
Cq270 sar_clkna vdd 5.939e-18
Cq271 sar_clkna vss 3.965e-15
Cq272 sar_clknab sar_mclk 1.264e-16
Cq273 sar_clknab vdd 1.914e-16
Cq274 sar_clknab vss 4.193e-15
Cq275 sar_clknab xckg_x 7.189e-17
Cq276 sar_clknb sar_cpb1 2.496e-19
Cq277 sar_clknb sar_cpb2 4.387e-16
Cq278 sar_clknb sar_cpb3 1.131e-15
Cq279 sar_clknb sar_cpb4 6.245e-19
Cq280 sar_clknb sar_cpb5 4.845e-18
Cq281 sar_clknb vdd 6.26e-18
Cq282 sar_clknb vss 1.056e-15
Cq283 sar_clknbb vss 4.526e-15
Cq284 sar_cna0 sar_cna1 4.187e-16
Cq285 sar_cna0 sar_mclk 5.35e-17
Cq286 sar_cna0 vdd 5.939e-18
Cq287 sar_cna0 vss 2e-15
Cq288 sar_cna1 sar_cna2 3.064e-16
Cq289 sar_cna1 sar_mclk 5.151e-17
Cq290 sar_cna1 vdd 5.391e-18
Cq291 sar_cna1 vss 1.682e-15
Cq292 sar_cna10 sar_cna11 2.981e-16
Cq293 sar_cna10 sar_cna9 3.064e-16
Cq294 sar_cna10 sar_mclk 5.273e-17
Cq295 sar_cna10 vdd 5.939e-18
Cq296 sar_cna10 vss 1.797e-15
Cq297 sar_cna11 sar_cna12 3.064e-16
Cq298 sar_cna11 sar_mclk 5.273e-17
Cq299 sar_cna11 vdd 5.939e-18
Cq300 sar_cna11 vss 1.797e-15
Cq301 sar_cna12 sar_cpa12 3.064e-16
Cq302 sar_cna12 sar_mclk 5.238e-17
Cq303 sar_cna12 vdd 4.844e-18
Cq304 sar_cna12 vss 1.756e-15
Cq305 sar_cna2 sar_mclk 4.37e-17
Cq306 sar_cna2 sar_oap 2.214e-15
Cq307 sar_cna2 vdd 5.391e-18
Cq308 sar_cna2 vss 1.347e-15
Cq309 sar_cna3 sar_mclk 4.634e-17
Cq310 sar_cna3 sar_oan 8.01e-16
Cq311 sar_cna3 sar_oap 7.036e-16
Cq312 sar_cna3 vdd 5.939e-18
Cq313 sar_cna3 vss 1.328e-15
Cq314 sar_cna4 sar_cna5 3.064e-16
Cq315 sar_cna4 sar_mclk 5.151e-17
Cq316 sar_cna4 sar_oan 4.187e-16
Cq317 sar_cna4 vdd 5.391e-18
Cq318 sar_cna4 vss 1.682e-15
Cq319 sar_cna5 sar_cna6 4.187e-16
Cq320 sar_cna5 sar_mclk 5.151e-17
Cq321 sar_cna5 vdd 5.391e-18
Cq322 sar_cna5 vss 1.682e-15
Cq323 sar_cna6 sar_cna7 2.361e-16
Cq324 sar_cna6 sar_mclk 5.229e-17
Cq325 sar_cna6 vdd 5.939e-18
Cq326 sar_cna6 vss 1.777e-15
Cq327 sar_cna7 sar_mclk 5.497e-17
Cq328 sar_cna7 vdd 5.391e-18
Cq329 sar_cna7 vss 2.151e-15
Cq330 sar_cna8 sar_cna9 3.064e-16
Cq331 sar_cna8 sar_mclk 5.454e-17
Cq332 sar_cna8 vdd 5.939e-18
Cq333 sar_cna8 vss 2.09e-15
Cq334 sar_cna9 sar_mclk 5.238e-17
Cq335 sar_cna9 vdd 4.844e-18
Cq336 sar_cna9 vss 1.756e-15
Cq337 sar_cnb0 sar_cnb1 4.047e-16
Cq338 sar_cnb0 sar_cnb2 3.919e-19
Cq339 sar_cnb0 sar_cnb3 3.99e-18
Cq340 sar_cnb0 sar_obp 2.496e-19
Cq341 sar_cnb0 vdd 8.551e-18
Cq342 sar_cnb0 vss 1.677e-15
Cq343 sar_cnb1 sar_cnb2 3.064e-16
Cq344 sar_cnb1 sar_cnb3 2.688e-19
Cq345 sar_cnb1 vdd 5.712e-18
Cq346 sar_cnb1 vss 1.327e-15
Cq347 sar_cnb10 sar_cnb11 2.978e-16
Cq348 sar_cnb10 sar_cnb12 2.496e-19
Cq349 sar_cnb10 sar_cnb8 2.496e-19
Cq350 sar_cnb10 sar_cnb9 2.879e-16
Cq351 sar_cnb10 vdd 8.551e-18
Cq352 sar_cnb10 vss 1.483e-15
Cq353 sar_cnb11 sar_cnb12 3.064e-16
Cq354 sar_cnb11 sar_cnb9 5.494e-18
Cq355 sar_cnb11 sar_cpb12 2.496e-19
Cq356 sar_cnb11 vdd 6.26e-18
Cq357 sar_cnb11 vss 1.418e-15
Cq358 sar_cnb12 sar_cpb11 5.494e-18
Cq359 sar_cnb12 sar_cpb12 2.978e-16
Cq360 sar_cnb12 vdd 6.26e-18
Cq361 sar_cnb12 vss 1.418e-15
Cq362 sar_cnb2 sar_cnb3 1.939e-18
Cq363 sar_cnb2 sar_obp 2.249e-15
Cq364 sar_cnb2 vdd 6.807e-18
Cq365 sar_cnb2 vss 1.063e-15
Cq366 sar_cnb3 sar_cnb4 5.334e-19
Cq367 sar_cnb3 sar_cnb5 1.521e-19
Cq368 sar_cnb3 sar_obn 7.769e-16
Cq369 sar_cnb3 sar_obp 6.642e-16
Cq370 sar_cnb3 vdd 9.721e-18
Cq371 sar_cnb3 vss 1.11e-15
Cq372 sar_cnb4 sar_cnb5 3.064e-16
Cq373 sar_cnb4 sar_cnb6 2.688e-19
Cq374 sar_cnb4 sar_obn 4.558e-16
Cq375 sar_cnb4 vdd 5.712e-18
Cq376 sar_cnb4 vss 1.294e-15
Cq377 sar_cnb5 sar_cnb6 3.976e-16
Cq378 sar_cnb5 sar_cnb7 5.494e-18
Cq379 sar_cnb5 vdd 6.807e-18
Cq380 sar_cnb5 vss 1.363e-15
Cq381 sar_cnb6 sar_cnb7 2.371e-16
Cq382 sar_cnb6 sar_obn 1.389e-19
Cq383 sar_cnb6 vdd 9.721e-18
Cq384 sar_cnb6 vss 1.495e-15
Cq385 sar_cnb7 vdd 5.712e-18
Cq386 sar_cnb7 vss 1.754e-15
Cq387 sar_cnb8 sar_cnb9 3.064e-16
Cq388 sar_cnb8 vdd 6.26e-18
Cq389 sar_cnb8 vss 1.7e-15
Cq390 sar_cnb9 vdd 6.26e-18
Cq391 sar_cnb9 vss 1.427e-15
Cq392 sar_cpa0 sar_cpa1 4.187e-16
Cq393 sar_cpa0 sar_mclk 4.832e-17
Cq394 sar_cpa0 vdd 5.391e-18
Cq395 sar_cpa0 vss 2.217e-15
Cq396 sar_cpa0 xckg_d0 3.136e-18
Cq397 sar_cpa1 sar_cpa2 2.361e-16
Cq398 sar_cpa1 sar_cpa3 1.221e-19
Cq399 sar_cpa1 sar_mclk 5.229e-17
Cq400 sar_cpa1 vdd 5.939e-18
Cq401 sar_cpa1 vss 1.785e-15
Cq402 sar_cpa1 xckg_d0 1.203e-18
Cq403 sar_cpa10 sar_cpa11 3.064e-16
Cq404 sar_cpa10 sar_cpa9 3.064e-16
Cq405 sar_cpa10 sar_mclk 5.238e-17
Cq406 sar_cpa10 vdd 4.844e-18
Cq407 sar_cpa10 vss 1.756e-15
Cq408 sar_cpa11 sar_cpa12 2.981e-16
Cq409 sar_cpa11 sar_mclk 5.273e-17
Cq410 sar_cpa11 vdd 5.939e-18
Cq411 sar_cpa11 vss 1.797e-15
Cq412 sar_cpa12 sar_mclk 5.273e-17
Cq413 sar_cpa12 vdd 5.939e-18
Cq414 sar_cpa12 vss 1.797e-15
Cq415 sar_cpa2 sar_cpa3 6.567e-19
Cq416 sar_cpa2 sar_mclk 4.997e-17
Cq417 sar_cpa2 vdd 5.391e-18
Cq418 sar_cpa2 vss 2.126e-15
Cq419 sar_cpa3 sar_cpa4 6.012e-16
Cq420 sar_cpa3 sar_cpa5 3.174e-19
Cq421 sar_cpa3 sar_mclk 4.094e-17
Cq422 sar_cpa3 vdd 8.305e-18
Cq423 sar_cpa3 vss 2.792e-15
Cq424 sar_cpa4 sar_cpa5 2.361e-16
Cq425 sar_cpa4 sar_mclk 5.014e-17
Cq426 sar_cpa4 vdd 5.939e-18
Cq427 sar_cpa4 vss 1.697e-15
Cq428 sar_cpa5 sar_cpa6 3.064e-16
Cq429 sar_cpa5 sar_mclk 5.316e-17
Cq430 sar_cpa5 vdd 5.391e-18
Cq431 sar_cpa5 vss 1.851e-15
Cq432 sar_cpa6 sar_cpa7 4.187e-16
Cq433 sar_cpa6 sar_mclk 5.151e-17
Cq434 sar_cpa6 vdd 5.391e-18
Cq435 sar_cpa6 vss 1.682e-15
Cq436 sar_cpa7 sar_mclk 5.35e-17
Cq437 sar_cpa7 vdd 5.939e-18
Cq438 sar_cpa7 vss 2e-15
Cq439 sar_cpa8 sar_cpa9 2.981e-16
Cq440 sar_cpa8 sar_mclk 5.454e-17
Cq441 sar_cpa8 vdd 5.939e-18
Cq442 sar_cpa8 vss 2.097e-15
Cq443 sar_cpa9 sar_mclk 5.273e-17
Cq444 sar_cpa9 vdd 5.939e-18
Cq445 sar_cpa9 vss 1.797e-15
Cq446 sar_cpb0 sar_cpb1 4.047e-16
Cq447 sar_cpb0 sar_cpb2 5.494e-18
Cq448 sar_cpb0 vdd 5.712e-18
Cq449 sar_cpb0 vss 1.612e-15
Cq450 sar_cpb1 sar_cpb2 2.289e-16
Cq451 sar_cpb1 sar_cpb3 4.295e-18
Cq452 sar_cpb1 vdd 8.551e-18
Cq453 sar_cpb1 vss 1.468e-15
Cq454 sar_cpb10 sar_cpb11 3.064e-16
Cq455 sar_cpb10 sar_cpb12 2.496e-19
Cq456 sar_cpb10 sar_cpb8 5.494e-18
Cq457 sar_cpb10 sar_cpb9 2.978e-16
Cq458 sar_cpb10 vdd 6.26e-18
Cq459 sar_cpb10 vss 1.418e-15
Cq460 sar_cpb11 sar_cpb12 2.879e-16
Cq461 sar_cpb11 sar_cpb9 2.496e-19
Cq462 sar_cpb11 vdd 6.26e-18
Cq463 sar_cpb11 vss 1.427e-15
Cq464 sar_cpb12 vdd 8.551e-18
Cq465 sar_cpb12 vss 1.483e-15
Cq466 sar_cpb2 sar_cpb3 7.915e-19
Cq467 sar_cpb2 vdd 6.807e-18
Cq468 sar_cpb2 vss 1.411e-15
Cq469 sar_cpb3 sar_cpb4 6.208e-16
Cq470 sar_cpb3 sar_cpb5 2.003e-19
Cq471 sar_cpb3 vdd 8.626e-18
Cq472 sar_cpb3 vss 1.109e-15
Cq473 sar_cpb4 sar_cpb5 2.289e-16
Cq474 sar_cpb4 vdd 8.551e-18
Cq475 sar_cpb4 vss 1.383e-15
Cq476 sar_cpb5 sar_cpb6 3.064e-16
Cq477 sar_cpb5 sar_cpb7 3.919e-19
Cq478 sar_cpb5 vdd 6.807e-18
Cq479 sar_cpb5 vss 1.507e-15
Cq480 sar_cpb6 sar_cpb7 4.047e-16
Cq481 sar_cpb6 vdd 5.712e-18
Cq482 sar_cpb6 vss 1.327e-15
Cq483 sar_cpb7 vdd 8.551e-18
Cq484 sar_cpb7 vss 1.678e-15
Cq485 sar_cpb8 sar_cpb9 2.879e-16
Cq486 sar_cpb8 vdd 6.26e-18
Cq487 sar_cpb8 vss 1.715e-15
Cq488 sar_cpb9 vdd 8.551e-18
Cq489 sar_cpb9 vss 1.484e-15
Cq490 sar_mclk sar_oan 4.849e-17
Cq491 sar_mclk sar_oann 5.047e-17
Cq492 sar_mclk sar_oanp 5.344e-17
Cq493 sar_mclk sar_oap 4.033e-17
Cq494 sar_mclk vdd 9.835e-16
Cq495 sar_mclk vss 5.569e-14
Cq496 sar_mclk xckg_d0 2.428e-16
Cq497 sar_mclk xckg_d1 2.372e-16
Cq498 sar_mclk xckg_d2 3.312e-16
Cq499 sar_mclk xckg_d3 2.272e-16
Cq500 sar_mclk xckg_nn 3.925e-16
Cq501 sar_mclk xckg_x 2.915e-16
Cq502 sar_oan vdd 5.939e-18
Cq503 sar_oan vss 1.46e-15
Cq504 sar_oann sar_oanp 4.187e-16
Cq505 sar_oann vdd 5.391e-18
Cq506 sar_oann vss 1.911e-15
Cq507 sar_oanp vdd 5.939e-18
Cq508 sar_oanp vss 2.018e-15
Cq509 sar_oap vdd 4.844e-18
Cq510 sar_oap vss 1.109e-15
Cq511 sar_obn sar_obp 1.052e-17
Cq512 sar_obn vdd 8.116e-18
Cq513 sar_obn vss 1.165e-15
Cq514 sar_obnn sar_obnp 4.047e-16
Cq515 sar_obnn vdd 5.712e-18
Cq516 sar_obnn vss 1.327e-15
Cq517 sar_obnp vdd 8.551e-18
Cq518 sar_obnp vss 1.678e-15
Cq519 sar_obp vdd 6.26e-18
Cq520 sar_obp vss 8.685e-16
Cq521 sar_trka0 sar_trka1 1.399e-16
Cq522 sar_trka0 vss 2.19e-15
Cq523 sar_trka1 vss 2.16e-15
Cq524 sar_trkb0 sar_trkb1 1.399e-16
Cq525 sar_trkb0 vdd 9.908e-17
Cq526 sar_trkb0 vss 1.928e-15
Cq527 sar_trkb1 vdd 5.712e-18
Cq528 sar_trkb1 vss 1.802e-15
Cq529 vbn vbp 2.899e-14
Cq530 vbn vdd 2.028e-15
Cq531 vbn vdda 5.091e-17
Cq532 vbn vref 1.786e-14
Cq533 vbn vref_in 4.127e-15
Cq534 vbn vrefl 2.52e-14
Cq535 vbn vss 1.155e-14
Cq536 vbn xref_na 7.746e-19
Cq537 vbn xref_ng 1.886e-15
Cq538 vbp vdd 1.803e-15
Cq539 vbp vdda 8.761e-15
Cq540 vbp vref 1.878e-14
Cq541 vbp vref_in 4.205e-15
Cq542 vbp vrefl 1.08e-14
Cq543 vbp vss 1.857e-14
Cq544 vbp xref_na 9.789e-18
Cq545 vbp xref_ng 2.371e-15
Cq546 vdd vdda 5.954e-16
Cq547 vdd vref 1.718e-13
Cq548 vdd vref_in 4.013e-14
Cq549 vdd vrefl 5.877e-14
Cq550 vdd vss 1.157e-13
Cq551 vdd xckg_d0 2.688e-16
Cq552 vdd xckg_d1 2.766e-16
Cq553 vdd xckg_d2 3.357e-16
Cq554 vdd xckg_d3 4.504e-16
Cq555 vdd xckg_nn 2.848e-18
Cq556 vdd xckg_x 4.879e-16
Cq557 vdd xref_ng 2.468e-14
Cq558 vdda vref 4.398e-14
Cq559 vdda vref_in 3.223e-16
Cq560 vdda vrefl 2.519e-14
Cq561 vdda vss 3.507e-14
Cq562 vdda xref_na 1.249e-15
Cq563 vdda xref_ng 2.299e-14
Cq564 vdda xref_ntl 9.96e-18
Cq565 vref vref_in 4.54e-14
Cq566 vref vrefl 1.67e-13
Cq567 vref vss 3.743e-13
Cq568 vref xref_na 1.322e-16
Cq569 vref xref_ng 4.971e-14
Cq570 vref xref_ntl 1.685e-15
Cq571 vref_in vrefl 3.08e-14
Cq572 vref_in vss 9.388e-14
Cq573 vref_in xref_na 4.042e-16
Cq574 vref_in xref_ng 3.421e-15
Cq575 vref_in xref_ntl 1.606e-15
Cq576 vrefl vss 1.926e-13
Cq577 vrefl xref_na 1.039e-16
Cq578 vrefl xref_ng 3.178e-14
Cq579 vrefl xref_ntl 2.185e-15
Cq580 vss xckg_d0 5.11e-15
Cq581 vss xckg_d1 4.339e-15
Cq582 vss xckg_d2 6.346e-15
Cq583 vss xckg_d3 8.13e-15
Cq584 vss xckg_nn 1.937e-15
Cq585 vss xckg_x 6.625e-15
Cq586 vss xref_na 4.437e-15
Cq587 vss xref_ng 8.769e-14
Cq588 vss xref_ntl 3.71e-15
Cq589 xckg_d0 xckg_d1 3.909e-15
Cq590 xckg_d0 xckg_d2 1.218e-15
Cq591 xckg_d0 xckg_d3 1.494e-17
Cq592 xckg_d0 xckg_nn 5.565e-16
Cq593 xckg_d0 xckg_x 4.057e-17
Cq594 xckg_d1 xckg_d2 3.755e-15
Cq595 xckg_d1 xckg_d3 3.433e-17
Cq596 xckg_d1 xckg_nn 6.939e-18
Cq597 xckg_d1 xckg_x 1.218e-17
Cq598 xckg_d2 xckg_d3 6.227e-16
Cq599 xckg_d2 xckg_nn 1.283e-16
Cq600 xckg_d2 xckg_x 1.227e-16
Cq601 xckg_d3 xckg_nn 3.139e-18
Cq602 xckg_d3 xckg_x 4.209e-15
Cq603 xckg_nn xckg_x 6.716e-17
Cq604 xref_na xref_ng 2.554e-15
Cq605 xref_na xref_ntl 2.584e-16
Cq606 xref_ng xref_ntl 2.12e-15
.ends
.subckt r1_adc_lay_pr adc_hold is_smp clk adc_start adc_sel adc_valid_a adc_raw_a_0 adc_raw_a_1 adc_raw_a_2 adc_raw_a_3 adc_raw_a_4 adc_raw_a_5 adc_raw_a_6 adc_raw_a_7 adc_raw_a_8 adc_raw_a_9 adc_raw_a_10 adc_raw_a_11 adc_raw_a_12 adc_raw_a_13 adc_valid_b adc_raw_b_0 adc_raw_b_1 adc_raw_b_2 adc_raw_b_3 adc_raw_b_4 adc_raw_b_5 adc_raw_b_6 adc_raw_b_7 adc_raw_b_8 adc_raw_b_9 adc_raw_b_10 adc_raw_b_11 adc_raw_b_12 adc_raw_b_13 por_n ain_sin_p ain_sin_n ain_cos_p ain_cos_n vcm2 ibias ain_isa_p ain_isa_n ain_isb_p ain_isb_n vcm vdda vdd vss vref_in topap topan topbp topbn sar_clka sar_clkab sar_clkb sar_clkbb sar_clkna sar_clknab sar_clknb sar_clknbb sar_cna0 sar_cna1 sar_cna10 sar_cna11 sar_cna12 sar_cna2 sar_cna3 sar_cna4 sar_cna5 sar_cna6 sar_cna7 sar_cna8 sar_cna9 sar_cnb0 sar_cnb1 sar_cnb10 sar_cnb11 sar_cnb12 sar_cnb2 sar_cnb3 sar_cnb4 sar_cnb5 sar_cnb6 sar_cnb7 sar_cnb8 sar_cnb9 sar_cpa0 sar_cpa1 sar_cpa10 sar_cpa11 sar_cpa12 sar_cpa2 sar_cpa3 sar_cpa4 sar_cpa5 sar_cpa6 sar_cpa7 sar_cpa8 sar_cpa9 sar_cpb0 sar_cpb1 sar_cpb10 sar_cpb11 sar_cpb12 sar_cpb2 sar_cpb3 sar_cpb4 sar_cpb5 sar_cpb6 sar_cpb7 sar_cpb8 sar_cpb9 sar_oan sar_oann sar_oanp sar_oap sar_obn sar_obnn sar_obnp sar_obp sar_trka0 sar_trka1 sar_trkb0 sar_trkb1 sar_mclk vref vrefl
Xxckg_xpd0 xckg_d0__p1 clk vdd__p2 vdd sg13_lv_pmos w=1u l=0.5u ng=1 m=1
Xxckg_xnd0 xckg_d0 clk vss__p9 vss sg13_lv_nmos w=0.5u l=0.5u ng=1 m=1
Xxckg_cd0 xckg_d0__p2 vss__p16 cap_cmim w=2.53u l=2.53u m=1
Xxckg_xpd1 xckg_d1__p1 xckg_d0 vdd__p3 vdd sg13_lv_pmos w=1u l=0.5u ng=1 m=1
Xxckg_xnd1 xckg_d1 xckg_d0 vss__p10 vss sg13_lv_nmos w=0.5u l=0.5u ng=1 m=1
Xxckg_cd1 xckg_d1__p2 vss__p17 cap_cmim w=2.53u l=2.53u m=1
Xxckg_xpd2 xckg_d2__p1 xckg_d1 vdd__p4 vdd sg13_lv_pmos w=1u l=0.5u ng=1 m=1
Xxckg_xnd2 xckg_d2 xckg_d1 vss__p11 vss sg13_lv_nmos w=0.5u l=0.5u ng=1 m=1
Xxckg_cd2 xckg_d2__p2 vss__p18 cap_cmim w=2.53u l=2.53u m=1
Xxckg_xpd3 xckg_d3__p1 xckg_d2 vdd__p5 vdd sg13_lv_pmos w=1u l=0.5u ng=1 m=1
Xxckg_xnd3 xckg_d3 xckg_d2 vss__p12 vss sg13_lv_nmos w=0.5u l=0.5u ng=1 m=1
Xxckg_cd3 xckg_d3__p2 vss__p19 cap_cmim w=2.53u l=2.53u m=1
Xxckg_xpd4 xckg_x__p2 xckg_d3 vdd__p6 vdd sg13_lv_pmos w=1u l=0.5u ng=1 m=1
Xxckg_xnd4 xckg_x xckg_d3 vss__p13 vss sg13_lv_nmos w=0.5u l=0.5u ng=1 m=1
Xxckg_cd4 xckg_x__p4 vss__p20 cap_cmim w=2.53u l=2.53u m=1
Xxckg_xpa sar_mclk__p2 clk__p1 vdd__p7 vdd sg13_lv_pmos w=2u l=0.13u ng=1 m=1
Xxckg_xpb sar_mclk__p3 xckg_x__p3 vdd__p8 vdd sg13_lv_pmos w=2u l=0.13u ng=1 m=1
Xxckg_xna sar_mclk__p0 clk__p0 xckg_nn vss sg13_lv_nmos w=2u l=0.13u ng=1 m=1
Xxckg_xnb xckg_nn__p1 xckg_x__p1 vss__p14 vss sg13_lv_nmos w=2u l=0.13u ng=1 m=1
Xxckg_xpi mclkb__p1 sar_mclk__p4 vdd__p9 vdd sg13_lv_pmos w=2u l=0.13u ng=1 m=1
Xxckg_xni mclkb sar_mclk__p1 vss__p15 vss sg13_lv_nmos w=1u l=0.13u ng=1 m=1
Xxcbias_xmbd vbp__p1 vbp vdd__p1 vdd sg13_lv_pmos w=0.8u l=0.5u ng=1 m=1
Xxcbias_xrb_g0 vbp xcbias_xrb_s1 vss rppd w=1u l=40u m=1 b=0
Xxcbias_xrb_g1 xcbias_xrb_s1 xcbias_xrb_s2 vss rppd w=1u l=40u m=1 b=0
Xxcbias_xrb_g2 xcbias_xrb_s2 xcbias_xrb_s3 vss rppd w=1u l=40u m=1 b=0
Xxcbias_xrb_g3 xcbias_xrb_s3 vss__p7 vss rppd w=1u l=40u m=1 b=0
Xxcbiasn_xmbd vbn__p1 vbn vss__p8 vss sg13_lv_nmos w=0.2u l=0.5u ng=1 m=1
Xxcbiasn_xrb_g0 vdd__p0 xcbiasn_xrb_s1 vss rppd w=1u l=40u m=1 b=0
Xxcbiasn_xrb_g1 xcbiasn_xrb_s1 xcbiasn_xrb_s2 vss rppd w=1u l=40u m=1 b=0
Xxcbiasn_xrb_g2 xcbiasn_xrb_s2 xcbiasn_xrb_s3 vss rppd w=1u l=40u m=1 b=0
Xxcbiasn_xrb_g3 xcbiasn_xrb_s3 vbn vss rppd w=1u l=40u m=1 b=0
Xxref_xmb0 ibias__p0 ibias vss__p5 vss sg13_hv_nmos w=2u l=1u ng=1 m=1
Xxref_xmt xref_ntl ibias vss__p6 vss sg13_hv_nmos w=2u l=8u ng=1 m=1
Xxref_xm1 xref_na vref_in xref_ntl__p1 vss sg13_hv_nmos w=10u l=1u ng=2 m=1
Xxref_xm2 xref_ng vref xref_ntl__p2 vss sg13_hv_nmos w=10u l=1u ng=2 m=1
Xxref_xm3 xref_na__p1 xref_na vdda__p5 vdda sg13_hv_pmos w=4u l=1u ng=1 m=1
Xxref_xm4 xref_ng__p1 xref_na vdda__p6 vdda sg13_hv_pmos w=4u l=1u ng=1 m=1
Xxref_xcg_u0 vss xref_ng__p2 cap_cmim w=26.32u l=95u m=1
Xxref_xmsf_s0 vdda__p1 xref_ng vref vss sg13_hv_nmos w=80u l=0.45u ng=32 m=1
Xxref_xmsf_s1 vdda__p2 xref_ng vref__p5 vss sg13_hv_nmos w=80u l=0.45u ng=32 m=1
Xxref_xmsf_s2 vdda__p3 xref_ng vref__p6 vss sg13_hv_nmos w=80u l=0.45u ng=32 m=1
Xxref_xmsf_s3 vdda__p4 xref_ng vref__p7 vss sg13_hv_nmos w=80u l=0.45u ng=32 m=1
Xxref_xmib_s0 vref__p0 ibias vss__p0 vss sg13_hv_nmos w=80u l=1u ng=40 m=1
Xxref_xmib_s1 vref__p1 ibias vss__p1 vss sg13_hv_nmos w=80u l=1u ng=40 m=1
Xxref_xmib_s2 vref__p2 ibias vss__p2 vss sg13_hv_nmos w=80u l=1u ng=40 m=1
Xxref_xmib_s3 vref__p3 ibias vss__p3 vss sg13_hv_nmos w=80u l=1u ng=40 m=1
Xxref_xcd_u0 vss vref__p8 cap_cmim w=51.58u l=95u m=1
Xxref_xcd_u1 vss vref__p9 cap_cmim w=51.58u l=95u m=1
Xxref_xcd_u2 vss vref__p10 cap_cmim w=51.58u l=95u m=1
Xxref_xcd_u3 vss vref__p11 cap_cmim w=51.58u l=95u m=1
Xxref_xmsfl_s0 vdda__p0 xref_ng vrefl vss sg13_hv_nmos w=80u l=0.45u ng=32 m=1
Xxref_xmibl_s0 vrefl__p0 ibias vss__p4 vss sg13_hv_nmos w=80u l=1u ng=40 m=1
Xxref_xcdl_u0 vss vrefl__p2 cap_cmim w=51.58u l=95u m=1
Xxref_xcdl_u1 vss vrefl__p3 cap_cmim w=51.58u l=95u m=1
Xxfilt_xcf_u0 vss vref_in__p1 cap_cmim w=37.36u l=90u m=1
Xxfilt_xcf_u1 vss vref_in__p2 cap_cmim w=37.36u l=90u m=1
Xslice_a ain_sin_p__p1 ain_sin_n__p1 ain_isa_p__p1 ain_isa_n__p1 sar_trka0__p1 sar_trka1__p1 sar_cpa0__p1 sar_cpa1__p1 sar_cpa2__p1 sar_cpa3__p1 sar_cpa4__p1 sar_cpa5__p1 sar_cpa6__p1 sar_cpa7__p1 sar_cpa8__p1 sar_cpa9__p1 sar_cpa10__p1 sar_cpa11__p1 sar_cpa12__p1 sar_cna0__p1 sar_cna1__p1 sar_cna2__p1 sar_cna3__p1 sar_cna4__p1 sar_cna5__p1 sar_cna6__p1 sar_cna7__p1 sar_cna8__p1 sar_cna9__p1 sar_cna10__p1 sar_cna11__p1 sar_cna12__p1 sar_clka__p1 sar_clkab__p1 sar_clkna__p1 sar_clknab__p1 sar_oap__p1 sar_oan__p1 sar_oanp__p1 sar_oann__p1 vbp__p2 vbn__p2 vref__p12 vref__p13 vref__p14 vrefl__p4 vrefl__p5 topap topan vdd__p12 vdd__p13 vdd__p14 vdd__p15 xslice_a_gnd_nc0 vss__p23 xslice_a_gnd_nc2 vss__p24 xslice_a_gnd_nc4 vss__p25 xslice_a_gnd_nc6 vss__p26 r1_adc_slice_post
Xslice_b ain_cos_p__p1 ain_cos_n__p1 ain_isb_p__p1 ain_isb_n__p1 sar_trkb0__p1 sar_trkb1__p1 sar_cpb0__p1 sar_cpb1__p1 sar_cpb2__p1 sar_cpb3__p1 sar_cpb4__p1 sar_cpb5__p1 sar_cpb6__p1 sar_cpb7__p1 sar_cpb8__p1 sar_cpb9__p1 sar_cpb10__p1 sar_cpb11__p1 sar_cpb12__p1 sar_cnb0__p1 sar_cnb1__p1 sar_cnb2__p1 sar_cnb3__p1 sar_cnb4__p1 sar_cnb5__p1 sar_cnb6__p1 sar_cnb7__p1 sar_cnb8__p1 sar_cnb9__p1 sar_cnb10__p1 sar_cnb11__p1 sar_cnb12__p1 sar_clkb__p1 sar_clkbb__p1 sar_clknb__p1 sar_clknbb__p1 sar_obp__p1 sar_obn__p1 sar_obnp__p1 sar_obnn__p1 vbp__p3 vbn__p3 vref__p15 vref__p16 vref__p17 vrefl__p6 vrefl__p7 topbp topbn vdd__p16 vdd__p17 vdd__p18 vdd__p19 vss__p27 xslice_b_gnd_nc1 vss__p28 xslice_b_gnd_nc3 vss__p29 xslice_b_gnd_nc5 vss__p30 xslice_b_gnd_nc7 r1_adc_slice_post
Rt0 ain_cos_n ain_cos_n__p1 126.828
Rt1 ain_cos_p ain_cos_p__p1 128.647
Rt2 ain_isa_n ain_isa_n__p1 127.972
Rt3 ain_isa_p ain_isa_p__p1 129.791
Rt4 ain_isb_n ain_isb_n__p1 0.198
Rt5 ain_isb_p ain_isb_p__p1 0.198
Rt6 ain_sin_n ain_sin_n__p1 0.308
Rt7 ain_sin_p ain_sin_p__p1 0.308
Rt8 clk clk__p0 141.519
Rt9 clk clk__p1 195.072
Rt10 clk__p0 clk__p1 49.582
Rt11 ibias ibias__p0 200.561
Rt12 mclkb mclkb__p1 43.3194
Rt13 sar_clka sar_clka__p1 12.3244
Rt14 sar_clkab sar_clkab__p1 12.3303
Rt15 sar_clkb sar_clkb__p1 12.498
Rt16 sar_clkbb sar_clkbb__p1 12.3244
Rt17 sar_clkna sar_clkna__p1 12.3244
Rt18 sar_clknab sar_clknab__p1 12.322
Rt19 sar_clknb sar_clknb__p1 12.3303
Rt20 sar_clknbb sar_clknbb__p1 12.3303
Rt21 sar_cna0 sar_cna0__p1 12.3244
Rt22 sar_cna1 sar_cna1__p1 12.3303
Rt23 sar_cna10 sar_cna10__p1 12.3244
Rt24 sar_cna11 sar_cna11__p1 12.3244
Rt25 sar_cna12 sar_cna12__p1 12.322
Rt26 sar_cna2 sar_cna2__p1 12.3303
Rt27 sar_cna3 sar_cna3__p1 12.3244
Rt28 sar_cna4 sar_cna4__p1 12.3303
Rt29 sar_cna5 sar_cna5__p1 12.3303
Rt30 sar_cna6 sar_cna6__p1 12.3244
Rt31 sar_cna7 sar_cna7__p1 12.3303
Rt32 sar_cna8 sar_cna8__p1 12.3244
Rt33 sar_cna9 sar_cna9__p1 12.322
Rt34 sar_cnb0 sar_cnb0__p1 12.498
Rt35 sar_cnb1 sar_cnb1__p1 12.322
Rt36 sar_cnb10 sar_cnb10__p1 12.498
Rt37 sar_cnb11 sar_cnb11__p1 12.3303
Rt38 sar_cnb12 sar_cnb12__p1 12.3303
Rt39 sar_cnb2 sar_cnb2__p1 12.3244
Rt40 sar_cnb3 sar_cnb3__p1 12.498
Rt41 sar_cnb4 sar_cnb4__p1 12.322
Rt42 sar_cnb5 sar_cnb5__p1 12.3244
Rt43 sar_cnb6 sar_cnb6__p1 12.498
Rt44 sar_cnb7 sar_cnb7__p1 12.322
Rt45 sar_cnb8 sar_cnb8__p1 12.3303
Rt46 sar_cnb9 sar_cnb9__p1 12.3303
Rt47 sar_cpa0 sar_cpa0__p1 12.3303
Rt48 sar_cpa1 sar_cpa1__p1 12.3244
Rt49 sar_cpa10 sar_cpa10__p1 12.322
Rt50 sar_cpa11 sar_cpa11__p1 12.3244
Rt51 sar_cpa12 sar_cpa12__p1 12.3244
Rt52 sar_cpa2 sar_cpa2__p1 12.3303
Rt53 sar_cpa3 sar_cpa3__p1 12.7425
Rt54 sar_cpa4 sar_cpa4__p1 12.3244
Rt55 sar_cpa5 sar_cpa5__p1 12.3303
Rt56 sar_cpa6 sar_cpa6__p1 12.3303
Rt57 sar_cpa7 sar_cpa7__p1 12.3244
Rt58 sar_cpa8 sar_cpa8__p1 12.3244
Rt59 sar_cpa9 sar_cpa9__p1 12.3244
Rt60 sar_cpb0 sar_cpb0__p1 12.322
Rt61 sar_cpb1 sar_cpb1__p1 12.498
Rt62 sar_cpb10 sar_cpb10__p1 12.3303
Rt63 sar_cpb11 sar_cpb11__p1 12.3303
Rt64 sar_cpb12 sar_cpb12__p1 12.498
Rt65 sar_cpb2 sar_cpb2__p1 12.3244
Rt66 sar_cpb3 sar_cpb3__p1 12.759
Rt67 sar_cpb4 sar_cpb4__p1 12.498
Rt68 sar_cpb5 sar_cpb5__p1 12.3244
Rt69 sar_cpb6 sar_cpb6__p1 12.322
Rt70 sar_cpb7 sar_cpb7__p1 12.498
Rt71 sar_cpb8 sar_cpb8__p1 12.3303
Rt72 sar_cpb9 sar_cpb9__p1 12.498
Rt73 sar_mclk sar_mclk__p0 170.374
Rt74 sar_mclk sar_mclk__p1 196.812
Rt75 sar_mclk sar_mclk__p2 307.715
Rt76 sar_mclk sar_mclk__p4 333.321
Rt77 sar_mclk__p0 sar_mclk__p1 70.5716
Rt78 sar_mclk__p0 sar_mclk__p2 110.338
Rt79 sar_mclk__p0 sar_mclk__p4 119.52
Rt80 sar_mclk__p1 sar_mclk__p2 101.952
Rt81 sar_mclk__p1 sar_mclk__p4 110.436
Rt82 sar_mclk__p2 sar_mclk__p3 0.6204
Rt83 sar_mclk__p2 sar_mclk__p4 64.7625
Rt84 sar_oan sar_oan__p1 12.3244
Rt85 sar_oann sar_oann__p1 12.3303
Rt86 sar_oanp sar_oanp__p1 12.3244
Rt87 sar_oap sar_oap__p1 12.322
Rt88 sar_obn sar_obn__p1 12.5344
Rt89 sar_obnn sar_obnn__p1 12.322
Rt90 sar_obnp sar_obnp__p1 12.498
Rt91 sar_obp sar_obp__p1 12.3303
Rt92 sar_trka0 sar_trka0__p1 12.3303
Rt93 sar_trka1 sar_trka1__p1 12.3303
Rt94 sar_trkb0 sar_trkb0__p1 12.3244
Rt95 sar_trkb1 sar_trkb1__p1 12.322
Rt96 vbn vbn__p1 68.8436
Rt97 vbn vbn__p2 240.016
Rt98 vbn vbn__p3 784.574
Rt99 vbn__p1 vbn__p2 217.489
Rt100 vbn__p1 vbn__p3 710.938
Rt101 vbn__p2 vbn__p3 168.032
Rt102 vbp vbp__p1 73.6975
Rt103 vbp vbp__p2 245.763
Rt104 vbp vbp__p3 1260.46
Rt105 vbp__p1 vbp__p2 195.517
Rt106 vbp__p1 vbp__p3 1002.76
Rt107 vbp__p2 vbp__p3 154.24
Rt108 vdd vdd__p0 34389.1
Rt109 vdd vdd__p1 40943
Rt110 vdd vdd__p11 68132.9
Rt111 vdd vdd__p12 82.2115
Rt112 vdd vdd__p13 11.0679
Rt113 vdd vdd__p14 29.2479
Rt114 vdd vdd__p15 437.715
Rt115 vdd vdd__p16 3424.56
Rt116 vdd vdd__p17 42939.2
Rt117 vdd vdd__p18 786782
Rt118 vdd__p0 vdd__p1 119.607
Rt119 vdd__p0 vdd__p12 99.6158
Rt120 vdd__p0 vdd__p13 288.609
Rt121 vdd__p0 vdd__p14 7716.14
Rt122 vdd__p0 vdd__p15 115478
Rt123 vdd__p0 vdd__p16 903464
Rt124 vdd__p1 vdd__p12 118.601
Rt125 vdd__p1 vdd__p13 343.612
Rt126 vdd__p1 vdd__p14 9186.68
Rt127 vdd__p1 vdd__p15 137485
Rt128 vdd__p11 vdd__p12 42970.9
Rt129 vdd__p11 vdd__p13 5785.07
Rt130 vdd__p11 vdd__p14 90.208
Rt131 vdd__p11 vdd__p15 12.7553
Rt132 vdd__p11 vdd__p16 14.0525
Rt133 vdd__p11 vdd__p17 160.888
Rt134 vdd__p11 vdd__p18 2947.98
Rt135 vdd__p11 vdd__p19 40686.4
Rt136 vdd__p11 vdd__p2 463.671
Rt137 vdd__p11 vdd__p3 424.895
Rt138 vdd__p11 vdd__p4 361.688
Rt139 vdd__p11 vdd__p5 291.702
Rt140 vdd__p11 vdd__p6 227.058
Rt141 vdd__p11 vdd__p7 29.9714
Rt142 vdd__p11 vdd__p8 158.698
Rt143 vdd__p11 vdd__p9 29.2186
Rt144 vdd__p12 vdd__p13 0.697261
Rt145 vdd__p12 vdd__p14 18.4464
Rt146 vdd__p12 vdd__p15 276.063
Rt147 vdd__p12 vdd__p16 2159.85
Rt148 vdd__p12 vdd__p17 27081.4
Rt149 vdd__p12 vdd__p18 496217
Rt150 vdd__p13 vdd__p14 2.48339
Rt151 vdd__p13 vdd__p15 37.1657
Rt152 vdd__p13 vdd__p16 290.775
Rt153 vdd__p13 vdd__p17 3645.91
Rt154 vdd__p13 vdd__p18 66804.5
Rt155 vdd__p13 vdd__p19 922000
Rt156 vdd__p13 vdd__p6 939934
Rt157 vdd__p13 vdd__p7 180555
Rt158 vdd__p13 vdd__p8 656946
Rt159 vdd__p13 vdd__p9 176021
Rt160 vdd__p14 vdd__p15 0.527112
Rt161 vdd__p14 vdd__p16 4.53412
Rt162 vdd__p14 vdd__p17 56.8516
Rt163 vdd__p14 vdd__p18 1041.7
Rt164 vdd__p14 vdd__p19 14377
Rt165 vdd__p14 vdd__p2 29930
Rt166 vdd__p14 vdd__p3 27427
Rt167 vdd__p14 vdd__p4 23347
Rt168 vdd__p14 vdd__p5 18829.3
Rt169 vdd__p14 vdd__p6 14656.6
Rt170 vdd__p14 vdd__p7 2815.45
Rt171 vdd__p14 vdd__p8 10243.9
Rt172 vdd__p14 vdd__p9 2744.73
Rt173 vdd__p15 vdd__p16 0.372867
Rt174 vdd__p15 vdd__p17 7.12045
Rt175 vdd__p15 vdd__p18 130.469
Rt176 vdd__p15 vdd__p19 1800.66
Rt177 vdd__p15 vdd__p2 4232.07
Rt178 vdd__p15 vdd__p3 3878.14
Rt179 vdd__p15 vdd__p4 3301.24
Rt180 vdd__p15 vdd__p5 2662.45
Rt181 vdd__p15 vdd__p6 2072.43
Rt182 vdd__p15 vdd__p7 398.102
Rt183 vdd__p15 vdd__p8 1448.48
Rt184 vdd__p15 vdd__p9 388.103
Rt185 vdd__p16 vdd__p17 0.804871
Rt186 vdd__p16 vdd__p18 14.9541
Rt187 vdd__p16 vdd__p19 206.388
Rt188 vdd__p16 vdd__p2 4662.44
Rt189 vdd__p16 vdd__p3 4272.53
Rt190 vdd__p16 vdd__p4 3636.95
Rt191 vdd__p16 vdd__p5 2933.2
Rt192 vdd__p16 vdd__p6 2283.19
Rt193 vdd__p16 vdd__p7 438.586
Rt194 vdd__p16 vdd__p8 1595.78
Rt195 vdd__p16 vdd__p9 427.57
Rt196 vdd__p17 vdd__p18 2.61782
Rt197 vdd__p17 vdd__p19 36.1298
Rt198 vdd__p17 vdd__p2 53380.8
Rt199 vdd__p17 vdd__p3 48916.6
Rt200 vdd__p17 vdd__p4 41639.9
Rt201 vdd__p17 vdd__p5 33582.6
Rt202 vdd__p17 vdd__p6 26140.5
Rt203 vdd__p17 vdd__p7 5021.42
Rt204 vdd__p17 vdd__p8 18270.3
Rt205 vdd__p17 vdd__p9 4895.3
Rt206 vdd__p18 vdd__p19 0.487307
Rt207 vdd__p18 vdd__p2 978105
Rt208 vdd__p18 vdd__p3 896307
Rt209 vdd__p18 vdd__p4 762974
Rt210 vdd__p18 vdd__p5 615339
Rt211 vdd__p18 vdd__p6 478976
Rt212 vdd__p18 vdd__p7 92008.3
Rt213 vdd__p18 vdd__p8 334770
Rt214 vdd__p18 vdd__p9 89697.3
Rt215 vdd__p2 vdd__p3 88.2674
Rt216 vdd__p2 vdd__p4 114.618
Rt217 vdd__p2 vdd__p5 144.634
Rt218 vdd__p2 vdd__p6 174.434
Rt219 vdd__p2 vdd__p7 14471.4
Rt220 vdd__p2 vdd__p8 225.153
Rt221 vdd__p2 vdd__p9 14108
Rt222 vdd__p3 vdd__p4 105.033
Rt223 vdd__p3 vdd__p5 132.538
Rt224 vdd__p3 vdd__p6 159.846
Rt225 vdd__p3 vdd__p7 13261.2
Rt226 vdd__p3 vdd__p8 206.324
Rt227 vdd__p3 vdd__p9 12928.1
Rt228 vdd__p4 vdd__p5 112.822
Rt229 vdd__p4 vdd__p6 136.068
Rt230 vdd__p4 vdd__p7 11288.5
Rt231 vdd__p4 vdd__p8 175.631
Rt232 vdd__p4 vdd__p9 11005
Rt233 vdd__p5 vdd__p6 109.739
Rt234 vdd__p5 vdd__p7 9104.19
Rt235 vdd__p5 vdd__p8 141.647
Rt236 vdd__p5 vdd__p9 8875.52
Rt237 vdd__p6 vdd__p7 7086.64
Rt238 vdd__p6 vdd__p8 110.257
Rt239 vdd__p6 vdd__p9 6908.64
Rt240 vdd__p7 vdd__p8 4953.05
Rt241 vdd__p7 vdd__p9 574.85
Rt242 vdd__p8 vdd__p9 4828.65
Rt243 vdda vdda__p1 41.3489
Rt244 vdda vdda__p2 278.578
Rt245 vdda vdda__p3 56.012
Rt246 vdda vdda__p5 261.48
Rt247 vdda vdda__p6 203.591
Rt248 vdda__p0 vdda__p3 62.8025
Rt249 vdda__p0 vdda__p4 67.5999
Rt250 vdda__p1 vdda__p2 1202.37
Rt251 vdda__p1 vdda__p3 241.754
Rt252 vdda__p1 vdda__p5 1128.58
Rt253 vdda__p1 vdda__p6 878.722
Rt254 vdda__p2 vdda__p3 256.165
Rt255 vdda__p2 vdda__p5 63.6193
Rt256 vdda__p2 vdda__p6 79.0683
Rt257 vdda__p3 vdda__p4 23.0314
Rt258 vdda__p3 vdda__p5 240.442
Rt259 vdda__p3 vdda__p6 187.211
Rt260 vdda__p5 vdda__p6 74.2153
Rt261 vref vref__p0 114.65
Rt262 vref vref__p1 6.10169
Rt263 vref vref__p10 186.142
Rt264 vref vref__p11 8271.36
Rt265 vref vref__p12 1487.93
Rt266 vref vref__p13 808.459
Rt267 vref vref__p14 372.871
Rt268 vref vref__p15 1459.54
Rt269 vref vref__p16 3157.02
Rt270 vref vref__p17 5801
Rt271 vref vref__p2 370.329
Rt272 vref vref__p3 10248.9
Rt273 vref vref__p5 428.96
Rt274 vref vref__p6 1135.72
Rt275 vref vref__p7 3138.93
Rt276 vref vref__p8 2223.31
Rt277 vref vref__p9 50.9452
Rt278 vref__p0 vref__p1 5.08178
Rt279 vref__p0 vref__p10 1372.92
Rt280 vref__p0 vref__p11 61005.8
Rt281 vref__p0 vref__p12 11330.2
Rt282 vref__p0 vref__p13 6156.32
Rt283 vref__p0 vref__p14 2839.43
Rt284 vref__p0 vref__p15 10764.9
Rt285 vref__p0 vref__p16 23284.7
Rt286 vref__p0 vref__p17 42785.5
Rt287 vref__p0 vref__p2 2151.06
Rt288 vref__p0 vref__p3 74645.3
Rt289 vref__p0 vref__p5 1782.68
Rt290 vref__p0 vref__p6 6979.82
Rt291 vref__p0 vref__p7 23027.9
Rt292 vref__p0 vref__p8 16928.7
Rt293 vref__p0 vref__p9 387.793
Rt294 vref__p1 vref__p10 27.2286
Rt295 vref__p1 vref__p11 1209.68
Rt296 vref__p1 vref__p12 366.189
Rt297 vref__p1 vref__p13 199.066
Rt298 vref__p1 vref__p14 91.8501
Rt299 vref__p1 vref__p15 213.441
Rt300 vref__p1 vref__p16 461.684
Rt301 vref__p1 vref__p17 848.354
Rt302 vref__p1 vref__p2 8.38761
Rt303 vref__p1 vref__p3 1193.26
Rt304 vref__p1 vref__p5 6.38445
Rt305 vref__p1 vref__p6 32.923
Rt306 vref__p1 vref__p7 414.228
Rt307 vref__p1 vref__p8 546.455
Rt308 vref__p1 vref__p9 12.4499
Rt309 vref__p10 vref__p11 1.96723
Rt310 vref__p10 vref__p12 390.352
Rt311 vref__p10 vref__p13 212.377
Rt312 vref__p10 vref__p14 98.0606
Rt313 vref__p10 vref__p15 1.88326
Rt314 vref__p10 vref__p16 2.58285
Rt315 vref__p10 vref__p17 2.96452
Rt316 vref__p10 vref__p2 13.5031
Rt317 vref__p10 vref__p3 151.839
Rt318 vref__p10 vref__p5 105.826
Rt319 vref__p10 vref__p6 71.6163
Rt320 vref__p10 vref__p7 45.7002
Rt321 vref__p10 vref__p8 581.257
Rt322 vref__p10 vref__p9 13.1189
Rt323 vref__p11 vref__p12 17345.9
Rt324 vref__p11 vref__p13 9437.27
Rt325 vref__p11 vref__p14 4357.47
Rt326 vref__p11 vref__p15 11.7242
Rt327 vref__p11 vref__p16 6.70636
Rt328 vref__p11 vref__p17 3.30899
Rt329 vref__p11 vref__p2 588.996
Rt330 vref__p11 vref__p3 6559.22
Rt331 vref__p11 vref__p5 4701.78
Rt332 vref__p11 vref__p6 3179.28
Rt333 vref__p11 vref__p7 1973.95
Rt334 vref__p11 vref__p8 25829
Rt335 vref__p11 vref__p9 582.958
Rt336 vref__p12 vref__p13 2.76051
Rt337 vref__p12 vref__p14 5.69068
Rt338 vref__p12 vref__p15 3060.82
Rt339 vref__p12 vref__p16 6620.62
Rt340 vref__p12 vref__p17 12165.3
Rt341 vref__p12 vref__p2 961.871
Rt342 vref__p12 vref__p3 21690.6
Rt343 vref__p12 vref__p5 2025.57
Rt344 vref__p12 vref__p6 2781.47
Rt345 vref__p12 vref__p7 6608.37
Rt346 vref__p12 vref__p8 3.41549
Rt347 vref__p12 vref__p9 2.8795
Rt348 vref__p13 vref__p14 2.76481
Rt349 vref__p13 vref__p15 1665.29
Rt350 vref__p13 vref__p16 3602.05
Rt351 vref__p13 vref__p17 6618.72
Rt352 vref__p13 vref__p2 523.306
Rt353 vref__p13 vref__p3 11801.1
Rt354 vref__p13 vref__p5 1101.86
Rt355 vref__p13 vref__p6 1513.26
Rt356 vref__p13 vref__p7 3595.37
Rt357 vref__p13 vref__p8 6.9687
Rt358 vref__p13 vref__p9 2.56608
Rt359 vref__p14 vref__p15 768.912
Rt360 vref__p14 vref__p16 1663.17
Rt361 vref__p14 vref__p17 3056.06
Rt362 vref__p14 vref__p2 241.621
Rt363 vref__p14 vref__p3 5448.89
Rt364 vref__p14 vref__p5 508.693
Rt365 vref__p14 vref__p6 698.702
Rt366 vref__p14 vref__p7 1660.09
Rt367 vref__p14 vref__p8 12.1708
Rt368 vref__p14 vref__p9 1.86726
Rt369 vref__p15 vref__p16 2.76621
Rt370 vref__p15 vref__p17 5.68373
Rt371 vref__p15 vref__p2 103.213
Rt372 vref__p15 vref__p3 1145.31
Rt373 vref__p15 vref__p5 829.619
Rt374 vref__p15 vref__p6 560.804
Rt375 vref__p15 vref__p7 344.658
Rt376 vref__p15 vref__p8 4557.75
Rt377 vref__p15 vref__p9 102.868
Rt378 vref__p16 vref__p17 2.75986
Rt379 vref__p16 vref__p2 223.556
Rt380 vref__p16 vref__p3 2482.45
Rt381 vref__p16 vref__p5 1794.5
Rt382 vref__p16 vref__p6 1213.12
Rt383 vref__p16 vref__p7 747.047
Rt384 vref__p16 vref__p8 9858.5
Rt385 vref__p16 vref__p9 222.505
Rt386 vref__p17 vref__p2 411.407
Rt387 vref__p17 vref__p3 4571.97
Rt388 vref__p17 vref__p5 3297.42
Rt389 vref__p17 vref__p6 2229.27
Rt390 vref__p17 vref__p7 1375.86
Rt391 vref__p17 vref__p8 18114.9
Rt392 vref__p17 vref__p9 408.851
Rt393 vref__p2 vref__p3 5.49374
Rt394 vref__p2 vref__p5 65.7993
Rt395 vref__p2 vref__p6 7.45703
Rt396 vref__p2 vref__p7 6.5906
Rt397 vref__p2 vref__p8 1432.38
Rt398 vref__p2 vref__p9 32.3382
Rt399 vref__p3 vref__p5 5279.01
Rt400 vref__p3 vref__p6 2064.28
Rt401 vref__p3 vref__p7 48.2546
Rt402 vref__p3 vref__p8 32298.7
Rt403 vref__p3 vref__p9 728.99
Rt404 vref__p5 vref__p6 244.984
Rt405 vref__p5 vref__p7 1709.1
Rt406 vref__p5 vref__p8 3017.46
Rt407 vref__p5 vref__p9 68.2281
Rt408 vref__p6 vref__p7 871.249
Rt409 vref__p6 vref__p8 4142.06
Rt410 vref__p6 vref__p9 93.5132
Rt411 vref__p7 vref__p8 9840.28
Rt412 vref__p7 vref__p9 222.096
Rt413 vref__p8 vref__p9 1.94076
Rt414 vref_in vref_in__p1 0.001
Rt415 vref_in vref_in__p2 0.001
Rt416 vrefl vrefl__p0 31.2586
Rt417 vrefl vrefl__p2 93.437
Rt418 vrefl vrefl__p3 7.18444
Rt419 vrefl vrefl__p4 7325.4
Rt420 vrefl vrefl__p5 4916.21
Rt421 vrefl vrefl__p6 359.98
Rt422 vrefl vrefl__p7 574.557
Rt423 vrefl__p0 vrefl__p2 18.0283
Rt424 vrefl__p0 vrefl__p3 12.5916
Rt425 vrefl__p0 vrefl__p4 63.5642
Rt426 vrefl__p0 vrefl__p5 72.9525
Rt427 vrefl__p0 vrefl__p6 631.93
Rt428 vrefl__p0 vrefl__p7 1009.16
Rt429 vrefl__p2 vrefl__p3 2.16812
Rt430 vrefl__p2 vrefl__p4 8.30061
Rt431 vrefl__p2 vrefl__p5 5.37046
Rt432 vrefl__p2 vrefl__p6 117.734
Rt433 vrefl__p2 vrefl__p7 192.433
Rt434 vrefl__p3 vrefl__p4 211.164
Rt435 vrefl__p3 vrefl__p5 128.531
Rt436 vrefl__p3 vrefl__p6 5.07096
Rt437 vrefl__p3 vrefl__p7 7.53987
Rt438 vrefl__p4 vrefl__p5 31.8717
Rt439 vrefl__p4 vrefl__p6 11315.9
Rt440 vrefl__p4 vrefl__p7 18493.5
Rt441 vrefl__p5 vrefl__p6 6889.67
Rt442 vrefl__p5 vrefl__p7 11261.9
Rt443 vrefl__p6 vrefl__p7 32.2289
Rt444 vss vss__p0 34.9503
Rt445 vss vss__p1 372.756
Rt446 vss vss__p10 18233.6
Rt447 vss vss__p11 33061.6
Rt448 vss vss__p12 32281.5
Rt449 vss vss__p13 55884.9
Rt450 vss vss__p14 78141.4
Rt451 vss vss__p15 250270
Rt452 vss vss__p16 358.209
Rt453 vss vss__p17 3653.28
Rt454 vss vss__p18 96113.9
Rt455 vss vss__p19 74114.8
Rt456 vss vss__p2 152.168
Rt457 vss vss__p20 138679
Rt458 vss vss__p22 0.001
Rt459 vss vss__p23 2
Rt460 vss vss__p24 2
Rt461 vss vss__p25 2
Rt462 vss vss__p26 2
Rt463 vss vss__p27 2
Rt464 vss vss__p28 2
Rt465 vss vss__p29 2
Rt466 vss vss__p3 89.0698
Rt467 vss vss__p30 2
Rt468 vss vss__p4 1076.06
Rt469 vss vss__p5 1332.84
Rt470 vss vss__p6 1752.7
Rt471 vss vss__p7 37.7353
Rt472 vss vss__p8 41.2417
Rt473 vss vss__p9 13512
Rt474 vss__p0 vss__p1 169.257
Rt475 vss__p0 vss__p10 782087
Rt476 vss__p0 vss__p16 15364.5
Rt477 vss__p0 vss__p17 156699
Rt478 vss__p0 vss__p2 6656.8
Rt479 vss__p0 vss__p3 3896.48
Rt480 vss__p0 vss__p4 488.606
Rt481 vss__p0 vss__p5 605.203
Rt482 vss__p0 vss__p6 795.845
Rt483 vss__p0 vss__p7 445.256
Rt484 vss__p0 vss__p8 490.044
Rt485 vss__p0 vss__p9 579567
Rt486 vss__p1 vss__p16 163868
Rt487 vss__p1 vss__p2 70997
Rt488 vss__p1 vss__p3 41557.2
Rt489 vss__p1 vss__p4 340.811
Rt490 vss__p1 vss__p5 422.139
Rt491 vss__p1 vss__p6 555.115
Rt492 vss__p1 vss__p7 4748.8
Rt493 vss__p1 vss__p8 5226.48
Rt494 vss__p10 vss__p11 184.446
Rt495 vss__p10 vss__p12 176.62
Rt496 vss__p10 vss__p13 307.671
Rt497 vss__p10 vss__p14 433.768
Rt498 vss__p10 vss__p15 1374.05
Rt499 vss__p10 vss__p16 139.567
Rt500 vss__p10 vss__p17 158.772
Rt501 vss__p10 vss__p18 555.994
Rt502 vss__p10 vss__p19 420.703
Rt503 vss__p10 vss__p2 352658
Rt504 vss__p10 vss__p20 808.124
Rt505 vss__p10 vss__p3 206424
Rt506 vss__p10 vss__p7 729352
Rt507 vss__p10 vss__p8 877308
Rt508 vss__p10 vss__p9 116.749
Rt509 vss__p11 vss__p12 195.406
Rt510 vss__p11 vss__p13 338.903
Rt511 vss__p11 vss__p14 475.02
Rt512 vss__p11 vss__p15 1516.48
Rt513 vss__p11 vss__p16 178.921
Rt514 vss__p11 vss__p17 29.8046
Rt515 vss__p11 vss__p18 591.254
Rt516 vss__p11 vss__p19 453.468
Rt517 vss__p11 vss__p2 639448
Rt518 vss__p11 vss__p20 854.867
Rt519 vss__p11 vss__p3 374293
Rt520 vss__p11 vss__p9 216.223
Rt521 vss__p12 vss__p13 190.25
Rt522 vss__p12 vss__p14 268.323
Rt523 vss__p12 vss__p15 849.545
Rt524 vss__p12 vss__p16 238.363
Rt525 vss__p12 vss__p17 142.029
Rt526 vss__p12 vss__p18 344.585
Rt527 vss__p12 vss__p19 260.506
Rt528 vss__p12 vss__p2 624361
Rt529 vss__p12 vss__p20 501.021
Rt530 vss__p12 vss__p3 365462
Rt531 vss__p12 vss__p9 207.081
Rt532 vss__p13 vss__p14 258.166
Rt533 vss__p13 vss__p15 860.032
Rt534 vss__p13 vss__p16 369.321
Rt535 vss__p13 vss__p17 80.5843
Rt536 vss__p13 vss__p18 42.4547
Rt537 vss__p13 vss__p19 227.381
Rt538 vss__p13 vss__p20 393.238
Rt539 vss__p13 vss__p3 632678
Rt540 vss__p13 vss__p9 360.715
Rt541 vss__p14 vss__p15 564.732
Rt542 vss__p14 vss__p16 453.74
Rt543 vss__p14 vss__p17 59.7988
Rt544 vss__p14 vss__p18 294.155
Rt545 vss__p14 vss__p19 55.3288
Rt546 vss__p14 vss__p20 194.885
Rt547 vss__p14 vss__p3 884646
Rt548 vss__p14 vss__p9 508.519
Rt549 vss__p15 vss__p16 1734.54
Rt550 vss__p15 vss__p17 513.739
Rt551 vss__p15 vss__p18 1398.8
Rt552 vss__p15 vss__p19 33.7794
Rt553 vss__p15 vss__p20 860.442
Rt554 vss__p15 vss__p9 1610.98
Rt555 vss__p16 vss__p17 1.54041
Rt556 vss__p16 vss__p18 350.696
Rt557 vss__p16 vss__p19 325.248
Rt558 vss__p16 vss__p2 6928.16
Rt559 vss__p16 vss__p20 475.339
Rt560 vss__p16 vss__p3 4055.32
Rt561 vss__p16 vss__p4 473049
Rt562 vss__p16 vss__p5 585932
Rt563 vss__p16 vss__p6 770504
Rt564 vss__p16 vss__p7 14328.5
Rt565 vss__p16 vss__p8 17235.2
Rt566 vss__p16 vss__p9 104.892
Rt567 vss__p17 vss__p18 22.3758
Rt568 vss__p17 vss__p19 25.21
Rt569 vss__p17 vss__p2 70658.6
Rt570 vss__p17 vss__p20 28.8059
Rt571 vss__p17 vss__p3 41359.2
Rt572 vss__p17 vss__p7 146133
Rt573 vss__p17 vss__p8 175777
Rt574 vss__p17 vss__p9 176.386
Rt575 vss__p18 vss__p19 169.03
Rt576 vss__p18 vss__p20 217.768
Rt577 vss__p18 vss__p9 651.585
Rt578 vss__p19 vss__p20 98.6071
Rt579 vss__p19 vss__p3 839061
Rt580 vss__p19 vss__p9 493.112
Rt581 vss__p2 vss__p3 63.5786
Rt582 vss__p2 vss__p4 204952
Rt583 vss__p2 vss__p5 253860
Rt584 vss__p2 vss__p6 333827
Rt585 vss__p2 vss__p7 6636.18
Rt586 vss__p2 vss__p8 7704.98
Rt587 vss__p2 vss__p9 261338
Rt588 vss__p20 vss__p9 947.006
Rt589 vss__p3 vss__p4 119966
Rt590 vss__p3 vss__p5 148594
Rt591 vss__p3 vss__p6 195402
Rt592 vss__p3 vss__p7 3884.41
Rt593 vss__p3 vss__p8 4510.02
Rt594 vss__p3 vss__p9 152971
Rt595 vss__p4 vss__p5 99.6258
Rt596 vss__p4 vss__p6 131.008
Rt597 vss__p4 vss__p7 13708.7
Rt598 vss__p4 vss__p8 15087.7
Rt599 vss__p5 vss__p6 57.9371
Rt600 vss__p5 vss__p7 16980
Rt601 vss__p5 vss__p8 18688
Rt602 vss__p6 vss__p7 22328.8
Rt603 vss__p6 vss__p8 24574.9
Rt604 vss__p7 vss__p8 217.113
Rt605 vss__p7 vss__p9 540488
Rt606 vss__p8 vss__p9 650130
Rt607 xckg_d0 xckg_d0__p1 158.064
Rt608 xckg_d0 xckg_d0__p2 32.5
Rt609 xckg_d0__p1 xckg_d0__p2 72.9819
Rt610 xckg_d1 xckg_d1__p1 160.822
Rt611 xckg_d1 xckg_d1__p2 33.3377
Rt612 xckg_d1__p1 xckg_d1__p2 71.7995
Rt613 xckg_d2 xckg_d2__p1 253.776
Rt614 xckg_d2 xckg_d2__p2 56.8495
Rt615 xckg_d2__p1 xckg_d2__p2 62.5432
Rt616 xckg_d3 xckg_d3__p1 116.773
Rt617 xckg_d3 xckg_d3__p2 66.8961
Rt618 xckg_d3__p1 xckg_d3__p2 71.2846
Rt619 xckg_nn xckg_nn__p1 46.1928
Rt620 xckg_x xckg_x__p1 101.928
Rt621 xckg_x xckg_x__p2 247.825
Rt622 xckg_x xckg_x__p3 173.816
Rt623 xckg_x xckg_x__p4 124.476
Rt624 xckg_x__p1 xckg_x__p2 156.926
Rt625 xckg_x__p1 xckg_x__p3 110.063
Rt626 xckg_x__p1 xckg_x__p4 78.82
Rt627 xckg_x__p2 xckg_x__p3 94.6454
Rt628 xckg_x__p2 xckg_x__p4 142.468
Rt629 xckg_x__p3 xckg_x__p4 99.922
Rt630 xref_na xref_na__p1 77.984
Rt631 xref_ng xref_ng__p1 1225.95
Rt632 xref_ng xref_ng__p2 132.884
Rt633 xref_ng__p1 xref_ng__p2 31.5508
Rt634 xref_ntl xref_ntl__p1 60.2546
Rt635 xref_ntl__p1 xref_ntl__p2 19.318
Cq0 ain_cos_n ain_cos_p 2.707e-14
Cq1 ain_cos_n ain_isa_n 3.445e-17
Cq2 ain_cos_n ain_isa_p 4.604e-17
Cq3 ain_cos_n ibias 1.097e-16
Cq4 ain_cos_n sar_clka 2.933e-17
Cq5 ain_cos_n sar_clkab 2.933e-17
Cq6 ain_cos_n sar_clkna 2.933e-17
Cq7 ain_cos_n sar_clknab 2.946e-17
Cq8 ain_cos_n sar_cna0 4.649e-17
Cq9 ain_cos_n sar_cna1 4.481e-17
Cq10 ain_cos_n sar_cna10 4.578e-17
Cq11 ain_cos_n sar_cna11 4.578e-17
Cq12 ain_cos_n sar_cna12 4.578e-17
Cq13 ain_cos_n sar_cna2 3.756e-17
Cq14 ain_cos_n sar_cna3 3.984e-17
Cq15 ain_cos_n sar_cna4 4.481e-17
Cq16 ain_cos_n sar_cna5 4.481e-17
Cq17 ain_cos_n sar_cna6 4.537e-17
Cq18 ain_cos_n sar_cna7 4.802e-17
Cq19 ain_cos_n sar_cna8 4.746e-17
Cq20 ain_cos_n sar_cna9 4.578e-17
Cq21 ain_cos_n sar_cpa0 4.649e-17
Cq22 ain_cos_n sar_cpa1 4.537e-17
Cq23 ain_cos_n sar_cpa10 4.578e-17
Cq24 ain_cos_n sar_cpa11 4.578e-17
Cq25 ain_cos_n sar_cpa12 4.578e-17
Cq26 ain_cos_n sar_cpa2 4.337e-17
Cq27 ain_cos_n sar_cpa3 3.579e-17
Cq28 ain_cos_n sar_cpa4 4.337e-17
Cq29 ain_cos_n sar_cpa5 4.634e-17
Cq30 ain_cos_n sar_cpa6 4.481e-17
Cq31 ain_cos_n sar_cpa7 4.649e-17
Cq32 ain_cos_n sar_cpa8 4.746e-17
Cq33 ain_cos_n sar_cpa9 4.578e-17
Cq34 ain_cos_n sar_oan 4.184e-17
Cq35 ain_cos_n sar_oann 4.384e-17
Cq36 ain_cos_n sar_oanp 4.649e-17
Cq37 ain_cos_n sar_oap 3.459e-17
Cq38 ain_cos_n sar_trka0 5.23e-17
Cq39 ain_cos_n sar_trka1 4.808e-17
Cq40 ain_cos_n sar_trkb0 1.443e-17
Cq41 ain_cos_n vdd 3.063e-15
Cq42 ain_cos_n vss 3.507e-14
Cq43 ain_cos_n xckg_d0 4.043e-19
Cq44 ain_cos_n xckg_d1 7.338e-19
Cq45 ain_cos_n xckg_d2 8.525e-19
Cq46 ain_cos_n xckg_d3 1.362e-18
Cq47 ain_cos_n xckg_x 2.674e-17
Cq48 ain_cos_p ain_isa_n 3.424e-17
Cq49 ain_cos_p ain_isa_p 4.84e-17
Cq50 ain_cos_p ibias 2.317e-16
Cq51 ain_cos_p sar_clka 2.933e-17
Cq52 ain_cos_p sar_clkab 2.933e-17
Cq53 ain_cos_p sar_clkna 2.933e-17
Cq54 ain_cos_p sar_clknab 2.951e-17
Cq55 ain_cos_p sar_cna0 4.649e-17
Cq56 ain_cos_p sar_cna1 4.481e-17
Cq57 ain_cos_p sar_cna10 4.578e-17
Cq58 ain_cos_p sar_cna11 4.578e-17
Cq59 ain_cos_p sar_cna12 4.578e-17
Cq60 ain_cos_p sar_cna2 3.756e-17
Cq61 ain_cos_p sar_cna3 3.984e-17
Cq62 ain_cos_p sar_cna4 4.481e-17
Cq63 ain_cos_p sar_cna5 4.481e-17
Cq64 ain_cos_p sar_cna6 4.537e-17
Cq65 ain_cos_p sar_cna7 4.802e-17
Cq66 ain_cos_p sar_cna8 4.746e-17
Cq67 ain_cos_p sar_cna9 4.578e-17
Cq68 ain_cos_p sar_cpa0 4.649e-17
Cq69 ain_cos_p sar_cpa1 4.537e-17
Cq70 ain_cos_p sar_cpa10 4.578e-17
Cq71 ain_cos_p sar_cpa11 4.578e-17
Cq72 ain_cos_p sar_cpa12 4.578e-17
Cq73 ain_cos_p sar_cpa2 4.337e-17
Cq74 ain_cos_p sar_cpa3 3.788e-17
Cq75 ain_cos_p sar_cpa4 4.337e-17
Cq76 ain_cos_p sar_cpa5 4.634e-17
Cq77 ain_cos_p sar_cpa6 4.481e-17
Cq78 ain_cos_p sar_cpa7 4.649e-17
Cq79 ain_cos_p sar_cpa8 4.746e-17
Cq80 ain_cos_p sar_cpa9 4.578e-17
Cq81 ain_cos_p sar_oan 4.184e-17
Cq82 ain_cos_p sar_oann 4.384e-17
Cq83 ain_cos_p sar_oanp 4.649e-17
Cq84 ain_cos_p sar_oap 3.459e-17
Cq85 ain_cos_p sar_trka0 5.315e-17
Cq86 ain_cos_p sar_trka1 4.808e-17
Cq87 ain_cos_p sar_trkb0 4.662e-19
Cq88 ain_cos_p vdd 2.211e-15
Cq89 ain_cos_p vss 3.544e-14
Cq90 ain_cos_p xckg_d3 3.348e-19
Cq91 ain_cos_p xckg_x 2.003e-17
Cq92 ain_isa_n ain_isa_p 2.783e-14
Cq93 ain_isa_n ain_isb_n 6.15e-17
Cq94 ain_isa_n ain_isb_p 6.417e-17
Cq95 ain_isa_n sar_clkb 4.864e-17
Cq96 ain_isa_n sar_clkbb 4.746e-17
Cq97 ain_isa_n sar_clknab 9.415e-19
Cq98 ain_isa_n sar_clknb 4.184e-17
Cq99 ain_isa_n sar_clknbb 2.965e-17
Cq100 ain_isa_n sar_cnb0 4.649e-17
Cq101 ain_isa_n sar_cnb1 4.481e-17
Cq102 ain_isa_n sar_cnb10 4.578e-17
Cq103 ain_isa_n sar_cnb11 4.578e-17
Cq104 ain_isa_n sar_cnb12 4.578e-17
Cq105 ain_isa_n sar_cnb2 3.756e-17
Cq106 ain_isa_n sar_cnb3 3.984e-17
Cq107 ain_isa_n sar_cnb4 4.481e-17
Cq108 ain_isa_n sar_cnb5 4.481e-17
Cq109 ain_isa_n sar_cnb6 4.537e-17
Cq110 ain_isa_n sar_cnb7 4.802e-17
Cq111 ain_isa_n sar_cnb8 4.746e-17
Cq112 ain_isa_n sar_cnb9 4.578e-17
Cq113 ain_isa_n sar_cpb0 4.649e-17
Cq114 ain_isa_n sar_cpb1 4.537e-17
Cq115 ain_isa_n sar_cpb10 4.578e-17
Cq116 ain_isa_n sar_cpb11 4.578e-17
Cq117 ain_isa_n sar_cpb12 4.578e-17
Cq118 ain_isa_n sar_cpb2 4.537e-17
Cq119 ain_isa_n sar_cpb3 4.024e-17
Cq120 ain_isa_n sar_cpb4 4.337e-17
Cq121 ain_isa_n sar_cpb5 4.634e-17
Cq122 ain_isa_n sar_cpb6 4.481e-17
Cq123 ain_isa_n sar_cpb7 4.649e-17
Cq124 ain_isa_n sar_cpb8 4.746e-17
Cq125 ain_isa_n sar_cpb9 4.578e-17
Cq126 ain_isa_n sar_obn 4.184e-17
Cq127 ain_isa_n sar_obnn 4.481e-17
Cq128 ain_isa_n sar_obnp 4.649e-17
Cq129 ain_isa_n sar_obp 3.459e-17
Cq130 ain_isa_n sar_trkb0 4.883e-17
Cq131 ain_isa_n sar_trkb1 4.833e-17
Cq132 ain_isa_n vdd 8.828e-17
Cq133 ain_isa_n vss 3.302e-14
Cq134 ain_isa_p ain_isb_n 7.645e-17
Cq135 ain_isa_p ain_isb_p 7.912e-17
Cq136 ain_isa_p sar_clkb 4.864e-17
Cq137 ain_isa_p sar_clkbb 4.746e-17
Cq138 ain_isa_p sar_clknab 7.019e-19
Cq139 ain_isa_p sar_clknb 4.184e-17
Cq140 ain_isa_p sar_clknbb 3.499e-17
Cq141 ain_isa_p sar_cnb0 4.649e-17
Cq142 ain_isa_p sar_cnb1 4.481e-17
Cq143 ain_isa_p sar_cnb10 4.578e-17
Cq144 ain_isa_p sar_cnb11 4.578e-17
Cq145 ain_isa_p sar_cnb12 4.578e-17
Cq146 ain_isa_p sar_cnb2 3.756e-17
Cq147 ain_isa_p sar_cnb3 3.984e-17
Cq148 ain_isa_p sar_cnb4 4.481e-17
Cq149 ain_isa_p sar_cnb5 4.481e-17
Cq150 ain_isa_p sar_cnb6 4.537e-17
Cq151 ain_isa_p sar_cnb7 4.802e-17
Cq152 ain_isa_p sar_cnb8 4.746e-17
Cq153 ain_isa_p sar_cnb9 4.578e-17
Cq154 ain_isa_p sar_cpb0 4.649e-17
Cq155 ain_isa_p sar_cpb1 4.537e-17
Cq156 ain_isa_p sar_cpb10 4.578e-17
Cq157 ain_isa_p sar_cpb11 4.578e-17
Cq158 ain_isa_p sar_cpb12 4.578e-17
Cq159 ain_isa_p sar_cpb2 4.537e-17
Cq160 ain_isa_p sar_cpb3 4.047e-17
Cq161 ain_isa_p sar_cpb4 4.337e-17
Cq162 ain_isa_p sar_cpb5 4.634e-17
Cq163 ain_isa_p sar_cpb6 4.481e-17
Cq164 ain_isa_p sar_cpb7 4.649e-17
Cq165 ain_isa_p sar_cpb8 4.746e-17
Cq166 ain_isa_p sar_cpb9 4.578e-17
Cq167 ain_isa_p sar_mclk 2.531e-18
Cq168 ain_isa_p sar_obn 4.184e-17
Cq169 ain_isa_p sar_obnn 4.481e-17
Cq170 ain_isa_p sar_obnp 4.649e-17
Cq171 ain_isa_p sar_obp 3.459e-17
Cq172 ain_isa_p sar_trkb0 5.684e-17
Cq173 ain_isa_p sar_trkb1 4.833e-17
Cq174 ain_isa_p vdd 1.13e-16
Cq175 ain_isa_p vss 3.362e-14
Cq176 ain_isb_n ain_isb_p 7.431e-17
Cq177 ain_isb_n vss 9.265e-16
Cq178 ain_isb_p vss 8.611e-16
Cq179 ain_sin_n ain_sin_p 8.625e-17
Cq180 ain_sin_n ibias 9.686e-17
Cq181 ain_sin_n vss 7.977e-16
Cq182 ain_sin_p ibias 9.686e-17
Cq183 ain_sin_p vss 7.924e-16
Cq184 clk mclkb 1.252e-18
Cq185 clk sar_clka 3.704e-17
Cq186 clk sar_clkab 2.773e-17
Cq187 clk sar_clkna 3.212e-17
Cq188 clk sar_clknab 4.043e-18
Cq189 clk sar_cna0 4.953e-17
Cq190 clk sar_cna1 4.301e-17
Cq191 clk sar_cna10 4.59e-17
Cq192 clk sar_cna11 4.59e-17
Cq193 clk sar_cna12 4.443e-17
Cq194 clk sar_cna2 3.644e-17
Cq195 clk sar_cna3 3.581e-17
Cq196 clk sar_cna4 4.301e-17
Cq197 clk sar_cna5 4.301e-17
Cq198 clk sar_cna6 4.534e-17
Cq199 clk sar_cna7 5.255e-17
Cq200 clk sar_cna8 5.168e-17
Cq201 clk sar_cna9 4.443e-17
Cq202 clk sar_cpa0 4.489e-17
Cq203 clk sar_cpa1 4.592e-17
Cq204 clk sar_cpa10 4.443e-17
Cq205 clk sar_cpa11 4.59e-17
Cq206 clk sar_cpa12 4.59e-17
Cq207 clk sar_cpa2 4.223e-17
Cq208 clk sar_cpa3 3.127e-17
Cq209 clk sar_cpa4 4.339e-17
Cq210 clk sar_cpa5 4.676e-17
Cq211 clk sar_cpa6 4.301e-17
Cq212 clk sar_cpa7 4.953e-17
Cq213 clk sar_cpa8 5.168e-17
Cq214 clk sar_cpa9 4.59e-17
Cq215 clk sar_mclk 4.18e-16
Cq216 clk sar_oan 3.87e-17
Cq217 clk sar_oann 4.086e-17
Cq218 clk sar_oanp 4.931e-17
Cq219 clk sar_oap 3.067e-17
Cq220 clk sar_trka0 6.343e-17
Cq221 clk sar_trka1 5.755e-17
Cq222 clk vdd 1.554e-15
Cq223 clk vss 2.921e-14
Cq224 clk xckg_d0 3.206e-16
Cq225 clk xckg_d1 1.883e-16
Cq226 clk xckg_d2 1.491e-16
Cq227 clk xckg_d3 2.541e-16
Cq228 clk xckg_nn 2.492e-17
Cq229 clk xckg_x 3.281e-16
Cq230 ibias sar_trka0 1.287e-17
Cq231 ibias vbn 2.266e-15
Cq232 ibias vbp 6.102e-17
Cq233 ibias vdd 4.502e-15
Cq234 ibias vdda 2.216e-16
Cq235 ibias vref 4.11e-14
Cq236 ibias vref_in 9.847e-15
Cq237 ibias vrefl 1.687e-14
Cq238 ibias vss 1.681e-13
Cq239 ibias xref_ng 2.101e-15
Cq240 ibias xref_ntl 1.737e-16
Cq241 mclkb sar_clknab 4.044e-17
Cq242 mclkb sar_mclk 2.778e-16
Cq243 mclkb sar_trkb0 2.442e-18
Cq244 mclkb vdd 1.741e-15
Cq245 mclkb vss 5.564e-15
Cq246 mclkb xckg_d0 1.25e-15
Cq247 mclkb xckg_d1 2.7e-16
Cq248 mclkb xckg_d2 2.182e-16
Cq249 mclkb xckg_d3 1.483e-17
Cq250 mclkb xckg_nn 2.576e-17
Cq251 mclkb xckg_x 1.907e-17
Cq252 sar_clka sar_trka1 4.996e-17
Cq253 sar_clka vdd 5.939e-18
Cq254 sar_clka vss 4.415e-15
Cq255 sar_clkab sar_mclk 3.485e-17
Cq256 sar_clkab sar_oann 9.641e-17
Cq257 sar_clkab vdd 5.391e-18
Cq258 sar_clkab vss 4.557e-15
Cq259 sar_clkb sar_trkb1 1.541e-16
Cq260 sar_clkb vdd 9.721e-18
Cq261 sar_clkb vss 1.963e-15
Cq262 sar_clkbb sar_obnn 3.064e-16
Cq263 sar_clkbb sar_obnp 3.919e-19
Cq264 sar_clkbb vdd 6.807e-18
Cq265 sar_clkbb vss 1.715e-15
Cq266 sar_clkna sar_cpa2 1.689e-16
Cq267 sar_clkna sar_cpa3 7.355e-16
Cq268 sar_clkna sar_cpa4 1.185e-17
Cq269 sar_clkna sar_mclk 3.502e-17
Cq270 sar_clkna vdd 5.939e-18
Cq271 sar_clkna vss 3.965e-15
Cq272 sar_clknab sar_mclk 1.264e-16
Cq273 sar_clknab vdd 1.914e-16
Cq274 sar_clknab vss 4.193e-15
Cq275 sar_clknab xckg_x 7.189e-17
Cq276 sar_clknb sar_cpb1 2.496e-19
Cq277 sar_clknb sar_cpb2 4.387e-16
Cq278 sar_clknb sar_cpb3 1.131e-15
Cq279 sar_clknb sar_cpb4 6.245e-19
Cq280 sar_clknb sar_cpb5 4.845e-18
Cq281 sar_clknb vdd 6.26e-18
Cq282 sar_clknb vss 1.056e-15
Cq283 sar_clknbb vss 4.526e-15
Cq284 sar_cna0 sar_cna1 4.187e-16
Cq285 sar_cna0 sar_mclk 5.35e-17
Cq286 sar_cna0 vdd 5.939e-18
Cq287 sar_cna0 vss 2e-15
Cq288 sar_cna1 sar_cna2 3.064e-16
Cq289 sar_cna1 sar_mclk 5.151e-17
Cq290 sar_cna1 vdd 5.391e-18
Cq291 sar_cna1 vss 1.682e-15
Cq292 sar_cna10 sar_cna11 2.981e-16
Cq293 sar_cna10 sar_cna9 3.064e-16
Cq294 sar_cna10 sar_mclk 5.273e-17
Cq295 sar_cna10 vdd 5.939e-18
Cq296 sar_cna10 vss 1.797e-15
Cq297 sar_cna11 sar_cna12 3.064e-16
Cq298 sar_cna11 sar_mclk 5.273e-17
Cq299 sar_cna11 vdd 5.939e-18
Cq300 sar_cna11 vss 1.797e-15
Cq301 sar_cna12 sar_cpa12 3.064e-16
Cq302 sar_cna12 sar_mclk 5.238e-17
Cq303 sar_cna12 vdd 4.844e-18
Cq304 sar_cna12 vss 1.756e-15
Cq305 sar_cna2 sar_mclk 4.37e-17
Cq306 sar_cna2 sar_oap 2.214e-15
Cq307 sar_cna2 vdd 5.391e-18
Cq308 sar_cna2 vss 1.347e-15
Cq309 sar_cna3 sar_mclk 4.634e-17
Cq310 sar_cna3 sar_oan 8.01e-16
Cq311 sar_cna3 sar_oap 7.036e-16
Cq312 sar_cna3 vdd 5.939e-18
Cq313 sar_cna3 vss 1.328e-15
Cq314 sar_cna4 sar_cna5 3.064e-16
Cq315 sar_cna4 sar_mclk 5.151e-17
Cq316 sar_cna4 sar_oan 4.187e-16
Cq317 sar_cna4 vdd 5.391e-18
Cq318 sar_cna4 vss 1.682e-15
Cq319 sar_cna5 sar_cna6 4.187e-16
Cq320 sar_cna5 sar_mclk 5.151e-17
Cq321 sar_cna5 vdd 5.391e-18
Cq322 sar_cna5 vss 1.682e-15
Cq323 sar_cna6 sar_cna7 2.361e-16
Cq324 sar_cna6 sar_mclk 5.229e-17
Cq325 sar_cna6 vdd 5.939e-18
Cq326 sar_cna6 vss 1.777e-15
Cq327 sar_cna7 sar_mclk 5.497e-17
Cq328 sar_cna7 vdd 5.391e-18
Cq329 sar_cna7 vss 2.151e-15
Cq330 sar_cna8 sar_cna9 3.064e-16
Cq331 sar_cna8 sar_mclk 5.454e-17
Cq332 sar_cna8 vdd 5.939e-18
Cq333 sar_cna8 vss 2.09e-15
Cq334 sar_cna9 sar_mclk 5.238e-17
Cq335 sar_cna9 vdd 4.844e-18
Cq336 sar_cna9 vss 1.756e-15
Cq337 sar_cnb0 sar_cnb1 4.047e-16
Cq338 sar_cnb0 sar_cnb2 3.919e-19
Cq339 sar_cnb0 sar_cnb3 3.99e-18
Cq340 sar_cnb0 sar_obp 2.496e-19
Cq341 sar_cnb0 vdd 8.551e-18
Cq342 sar_cnb0 vss 1.677e-15
Cq343 sar_cnb1 sar_cnb2 3.064e-16
Cq344 sar_cnb1 sar_cnb3 2.688e-19
Cq345 sar_cnb1 vdd 5.712e-18
Cq346 sar_cnb1 vss 1.327e-15
Cq347 sar_cnb10 sar_cnb11 2.978e-16
Cq348 sar_cnb10 sar_cnb12 2.496e-19
Cq349 sar_cnb10 sar_cnb8 2.496e-19
Cq350 sar_cnb10 sar_cnb9 2.879e-16
Cq351 sar_cnb10 vdd 8.551e-18
Cq352 sar_cnb10 vss 1.483e-15
Cq353 sar_cnb11 sar_cnb12 3.064e-16
Cq354 sar_cnb11 sar_cnb9 5.494e-18
Cq355 sar_cnb11 sar_cpb12 2.496e-19
Cq356 sar_cnb11 vdd 6.26e-18
Cq357 sar_cnb11 vss 1.418e-15
Cq358 sar_cnb12 sar_cpb11 5.494e-18
Cq359 sar_cnb12 sar_cpb12 2.978e-16
Cq360 sar_cnb12 vdd 6.26e-18
Cq361 sar_cnb12 vss 1.418e-15
Cq362 sar_cnb2 sar_cnb3 1.939e-18
Cq363 sar_cnb2 sar_obp 2.249e-15
Cq364 sar_cnb2 vdd 6.807e-18
Cq365 sar_cnb2 vss 1.063e-15
Cq366 sar_cnb3 sar_cnb4 5.334e-19
Cq367 sar_cnb3 sar_cnb5 1.521e-19
Cq368 sar_cnb3 sar_obn 7.769e-16
Cq369 sar_cnb3 sar_obp 6.642e-16
Cq370 sar_cnb3 vdd 9.721e-18
Cq371 sar_cnb3 vss 1.11e-15
Cq372 sar_cnb4 sar_cnb5 3.064e-16
Cq373 sar_cnb4 sar_cnb6 2.688e-19
Cq374 sar_cnb4 sar_obn 4.558e-16
Cq375 sar_cnb4 vdd 5.712e-18
Cq376 sar_cnb4 vss 1.294e-15
Cq377 sar_cnb5 sar_cnb6 3.976e-16
Cq378 sar_cnb5 sar_cnb7 5.494e-18
Cq379 sar_cnb5 vdd 6.807e-18
Cq380 sar_cnb5 vss 1.363e-15
Cq381 sar_cnb6 sar_cnb7 2.371e-16
Cq382 sar_cnb6 sar_obn 1.389e-19
Cq383 sar_cnb6 vdd 9.721e-18
Cq384 sar_cnb6 vss 1.495e-15
Cq385 sar_cnb7 vdd 5.712e-18
Cq386 sar_cnb7 vss 1.754e-15
Cq387 sar_cnb8 sar_cnb9 3.064e-16
Cq388 sar_cnb8 vdd 6.26e-18
Cq389 sar_cnb8 vss 1.7e-15
Cq390 sar_cnb9 vdd 6.26e-18
Cq391 sar_cnb9 vss 1.427e-15
Cq392 sar_cpa0 sar_cpa1 4.187e-16
Cq393 sar_cpa0 sar_mclk 4.832e-17
Cq394 sar_cpa0 vdd 5.391e-18
Cq395 sar_cpa0 vss 2.217e-15
Cq396 sar_cpa0 xckg_d0 3.136e-18
Cq397 sar_cpa1 sar_cpa2 2.361e-16
Cq398 sar_cpa1 sar_cpa3 1.221e-19
Cq399 sar_cpa1 sar_mclk 5.229e-17
Cq400 sar_cpa1 vdd 5.939e-18
Cq401 sar_cpa1 vss 1.785e-15
Cq402 sar_cpa1 xckg_d0 1.203e-18
Cq403 sar_cpa10 sar_cpa11 3.064e-16
Cq404 sar_cpa10 sar_cpa9 3.064e-16
Cq405 sar_cpa10 sar_mclk 5.238e-17
Cq406 sar_cpa10 vdd 4.844e-18
Cq407 sar_cpa10 vss 1.756e-15
Cq408 sar_cpa11 sar_cpa12 2.981e-16
Cq409 sar_cpa11 sar_mclk 5.273e-17
Cq410 sar_cpa11 vdd 5.939e-18
Cq411 sar_cpa11 vss 1.797e-15
Cq412 sar_cpa12 sar_mclk 5.273e-17
Cq413 sar_cpa12 vdd 5.939e-18
Cq414 sar_cpa12 vss 1.797e-15
Cq415 sar_cpa2 sar_cpa3 6.567e-19
Cq416 sar_cpa2 sar_mclk 4.997e-17
Cq417 sar_cpa2 vdd 5.391e-18
Cq418 sar_cpa2 vss 2.126e-15
Cq419 sar_cpa3 sar_cpa4 6.012e-16
Cq420 sar_cpa3 sar_cpa5 3.174e-19
Cq421 sar_cpa3 sar_mclk 4.094e-17
Cq422 sar_cpa3 vdd 8.305e-18
Cq423 sar_cpa3 vss 2.792e-15
Cq424 sar_cpa4 sar_cpa5 2.361e-16
Cq425 sar_cpa4 sar_mclk 5.014e-17
Cq426 sar_cpa4 vdd 5.939e-18
Cq427 sar_cpa4 vss 1.697e-15
Cq428 sar_cpa5 sar_cpa6 3.064e-16
Cq429 sar_cpa5 sar_mclk 5.316e-17
Cq430 sar_cpa5 vdd 5.391e-18
Cq431 sar_cpa5 vss 1.851e-15
Cq432 sar_cpa6 sar_cpa7 4.187e-16
Cq433 sar_cpa6 sar_mclk 5.151e-17
Cq434 sar_cpa6 vdd 5.391e-18
Cq435 sar_cpa6 vss 1.682e-15
Cq436 sar_cpa7 sar_mclk 5.35e-17
Cq437 sar_cpa7 vdd 5.939e-18
Cq438 sar_cpa7 vss 2e-15
Cq439 sar_cpa8 sar_cpa9 2.981e-16
Cq440 sar_cpa8 sar_mclk 5.454e-17
Cq441 sar_cpa8 vdd 5.939e-18
Cq442 sar_cpa8 vss 2.097e-15
Cq443 sar_cpa9 sar_mclk 5.273e-17
Cq444 sar_cpa9 vdd 5.939e-18
Cq445 sar_cpa9 vss 1.797e-15
Cq446 sar_cpb0 sar_cpb1 4.047e-16
Cq447 sar_cpb0 sar_cpb2 5.494e-18
Cq448 sar_cpb0 vdd 5.712e-18
Cq449 sar_cpb0 vss 1.612e-15
Cq450 sar_cpb1 sar_cpb2 2.289e-16
Cq451 sar_cpb1 sar_cpb3 4.295e-18
Cq452 sar_cpb1 vdd 8.551e-18
Cq453 sar_cpb1 vss 1.468e-15
Cq454 sar_cpb10 sar_cpb11 3.064e-16
Cq455 sar_cpb10 sar_cpb12 2.496e-19
Cq456 sar_cpb10 sar_cpb8 5.494e-18
Cq457 sar_cpb10 sar_cpb9 2.978e-16
Cq458 sar_cpb10 vdd 6.26e-18
Cq459 sar_cpb10 vss 1.418e-15
Cq460 sar_cpb11 sar_cpb12 2.879e-16
Cq461 sar_cpb11 sar_cpb9 2.496e-19
Cq462 sar_cpb11 vdd 6.26e-18
Cq463 sar_cpb11 vss 1.427e-15
Cq464 sar_cpb12 vdd 8.551e-18
Cq465 sar_cpb12 vss 1.483e-15
Cq466 sar_cpb2 sar_cpb3 7.915e-19
Cq467 sar_cpb2 vdd 6.807e-18
Cq468 sar_cpb2 vss 1.411e-15
Cq469 sar_cpb3 sar_cpb4 6.208e-16
Cq470 sar_cpb3 sar_cpb5 2.003e-19
Cq471 sar_cpb3 vdd 8.626e-18
Cq472 sar_cpb3 vss 1.109e-15
Cq473 sar_cpb4 sar_cpb5 2.289e-16
Cq474 sar_cpb4 vdd 8.551e-18
Cq475 sar_cpb4 vss 1.383e-15
Cq476 sar_cpb5 sar_cpb6 3.064e-16
Cq477 sar_cpb5 sar_cpb7 3.919e-19
Cq478 sar_cpb5 vdd 6.807e-18
Cq479 sar_cpb5 vss 1.507e-15
Cq480 sar_cpb6 sar_cpb7 4.047e-16
Cq481 sar_cpb6 vdd 5.712e-18
Cq482 sar_cpb6 vss 1.327e-15
Cq483 sar_cpb7 vdd 8.551e-18
Cq484 sar_cpb7 vss 1.678e-15
Cq485 sar_cpb8 sar_cpb9 2.879e-16
Cq486 sar_cpb8 vdd 6.26e-18
Cq487 sar_cpb8 vss 1.715e-15
Cq488 sar_cpb9 vdd 8.551e-18
Cq489 sar_cpb9 vss 1.484e-15
Cq490 sar_mclk sar_oan 4.849e-17
Cq491 sar_mclk sar_oann 5.047e-17
Cq492 sar_mclk sar_oanp 5.344e-17
Cq493 sar_mclk sar_oap 4.033e-17
Cq494 sar_mclk vdd 9.835e-16
Cq495 sar_mclk vss 5.569e-14
Cq496 sar_mclk xckg_d0 2.428e-16
Cq497 sar_mclk xckg_d1 2.372e-16
Cq498 sar_mclk xckg_d2 3.312e-16
Cq499 sar_mclk xckg_d3 2.272e-16
Cq500 sar_mclk xckg_nn 3.925e-16
Cq501 sar_mclk xckg_x 2.915e-16
Cq502 sar_oan vdd 5.939e-18
Cq503 sar_oan vss 1.46e-15
Cq504 sar_oann sar_oanp 4.187e-16
Cq505 sar_oann vdd 5.391e-18
Cq506 sar_oann vss 1.911e-15
Cq507 sar_oanp vdd 5.939e-18
Cq508 sar_oanp vss 2.018e-15
Cq509 sar_oap vdd 4.844e-18
Cq510 sar_oap vss 1.109e-15
Cq511 sar_obn sar_obp 1.052e-17
Cq512 sar_obn vdd 8.116e-18
Cq513 sar_obn vss 1.165e-15
Cq514 sar_obnn sar_obnp 4.047e-16
Cq515 sar_obnn vdd 5.712e-18
Cq516 sar_obnn vss 1.327e-15
Cq517 sar_obnp vdd 8.551e-18
Cq518 sar_obnp vss 1.678e-15
Cq519 sar_obp vdd 6.26e-18
Cq520 sar_obp vss 8.685e-16
Cq521 sar_trka0 sar_trka1 1.399e-16
Cq522 sar_trka0 vss 2.19e-15
Cq523 sar_trka1 vss 2.16e-15
Cq524 sar_trkb0 sar_trkb1 1.399e-16
Cq525 sar_trkb0 vdd 9.908e-17
Cq526 sar_trkb0 vss 1.928e-15
Cq527 sar_trkb1 vdd 5.712e-18
Cq528 sar_trkb1 vss 1.802e-15
Cq529 vbn vbp 2.899e-14
Cq530 vbn vdd 2.028e-15
Cq531 vbn vdda 5.091e-17
Cq532 vbn vref 1.786e-14
Cq533 vbn vref_in 4.127e-15
Cq534 vbn vrefl 2.52e-14
Cq535 vbn vss 1.155e-14
Cq536 vbn xref_na 7.746e-19
Cq537 vbn xref_ng 1.886e-15
Cq538 vbp vdd 1.803e-15
Cq539 vbp vdda 8.761e-15
Cq540 vbp vref 1.878e-14
Cq541 vbp vref_in 4.205e-15
Cq542 vbp vrefl 1.08e-14
Cq543 vbp vss 1.857e-14
Cq544 vbp xref_na 9.789e-18
Cq545 vbp xref_ng 2.371e-15
Cq546 vdd vdda 5.954e-16
Cq547 vdd vref 1.718e-13
Cq548 vdd vref_in 4.013e-14
Cq549 vdd vrefl 5.877e-14
Cq550 vdd vss 1.157e-13
Cq551 vdd xckg_d0 2.688e-16
Cq552 vdd xckg_d1 2.766e-16
Cq553 vdd xckg_d2 3.357e-16
Cq554 vdd xckg_d3 4.504e-16
Cq555 vdd xckg_nn 2.848e-18
Cq556 vdd xckg_x 4.879e-16
Cq557 vdd xref_ng 2.468e-14
Cq558 vdda vref 4.398e-14
Cq559 vdda vref_in 3.223e-16
Cq560 vdda vrefl 2.519e-14
Cq561 vdda vss 3.507e-14
Cq562 vdda xref_na 1.249e-15
Cq563 vdda xref_ng 2.299e-14
Cq564 vdda xref_ntl 9.96e-18
Cq565 vref vref_in 4.54e-14
Cq566 vref vrefl 1.67e-13
Cq567 vref vss 3.743e-13
Cq568 vref xref_na 1.322e-16
Cq569 vref xref_ng 4.971e-14
Cq570 vref xref_ntl 1.685e-15
Cq571 vref_in vrefl 3.08e-14
Cq572 vref_in vss 9.388e-14
Cq573 vref_in xref_na 4.042e-16
Cq574 vref_in xref_ng 3.421e-15
Cq575 vref_in xref_ntl 1.606e-15
Cq576 vrefl vss 1.926e-13
Cq577 vrefl xref_na 1.039e-16
Cq578 vrefl xref_ng 3.178e-14
Cq579 vrefl xref_ntl 2.185e-15
Cq580 vss xckg_d0 5.11e-15
Cq581 vss xckg_d1 4.339e-15
Cq582 vss xckg_d2 6.346e-15
Cq583 vss xckg_d3 8.13e-15
Cq584 vss xckg_nn 1.937e-15
Cq585 vss xckg_x 6.625e-15
Cq586 vss xref_na 4.437e-15
Cq587 vss xref_ng 8.769e-14
Cq588 vss xref_ntl 3.71e-15
Cq589 xckg_d0 xckg_d1 3.909e-15
Cq590 xckg_d0 xckg_d2 1.218e-15
Cq591 xckg_d0 xckg_d3 1.494e-17
Cq592 xckg_d0 xckg_nn 5.565e-16
Cq593 xckg_d0 xckg_x 4.057e-17
Cq594 xckg_d1 xckg_d2 3.755e-15
Cq595 xckg_d1 xckg_d3 3.433e-17
Cq596 xckg_d1 xckg_nn 6.939e-18
Cq597 xckg_d1 xckg_x 1.218e-17
Cq598 xckg_d2 xckg_d3 6.227e-16
Cq599 xckg_d2 xckg_nn 1.283e-16
Cq600 xckg_d2 xckg_x 1.227e-16
Cq601 xckg_d3 xckg_nn 3.139e-18
Cq602 xckg_d3 xckg_x 4.209e-15
Cq603 xckg_nn xckg_x 6.716e-17
Cq604 xref_na xref_ng 2.554e-15
Cq605 xref_na xref_ntl 2.584e-16
Cq606 xref_ng xref_ntl 2.12e-15
.ends
.subckt r1_adc_lay_sar adc_hold is_smp clk adc_start adc_sel adc_valid_a adc_raw_a_0 adc_raw_a_1 adc_raw_a_2 adc_raw_a_3 adc_raw_a_4 adc_raw_a_5 adc_raw_a_6 adc_raw_a_7 adc_raw_a_8 adc_raw_a_9 adc_raw_a_10 adc_raw_a_11 adc_raw_a_12 adc_raw_a_13 adc_valid_b adc_raw_b_0 adc_raw_b_1 adc_raw_b_2 adc_raw_b_3 adc_raw_b_4 adc_raw_b_5 adc_raw_b_6 adc_raw_b_7 adc_raw_b_8 adc_raw_b_9 adc_raw_b_10 adc_raw_b_11 adc_raw_b_12 adc_raw_b_13 por_n ain_sin_p ain_sin_n ain_cos_p ain_cos_n vcm2 ibias ain_isa_p ain_isa_n ain_isb_p ain_isb_n vcm vdda vdd vss vref_in topap topan topbp topbn sar_clka sar_clkab sar_clkb sar_clkbb sar_clkna sar_clknab sar_clknb sar_clknbb sar_cna0 sar_cna1 sar_cna10 sar_cna11 sar_cna12 sar_cna2 sar_cna3 sar_cna4 sar_cna5 sar_cna6 sar_cna7 sar_cna8 sar_cna9 sar_cnb0 sar_cnb1 sar_cnb10 sar_cnb11 sar_cnb12 sar_cnb2 sar_cnb3 sar_cnb4 sar_cnb5 sar_cnb6 sar_cnb7 sar_cnb8 sar_cnb9 sar_cpa0 sar_cpa1 sar_cpa10 sar_cpa11 sar_cpa12 sar_cpa2 sar_cpa3 sar_cpa4 sar_cpa5 sar_cpa6 sar_cpa7 sar_cpa8 sar_cpa9 sar_cpb0 sar_cpb1 sar_cpb10 sar_cpb11 sar_cpb12 sar_cpb2 sar_cpb3 sar_cpb4 sar_cpb5 sar_cpb6 sar_cpb7 sar_cpb8 sar_cpb9 sar_oan sar_oann sar_oanp sar_oap sar_obn sar_obnn sar_obnp sar_obp sar_trka0 sar_trka1 sar_trkb0 sar_trkb1 sar_mclk vref vrefl vdd_sar vss_sar
Rsar_vdd vdd_sar vdd__p11 1m
Rsar_vss vss_sar vss__p22 1m
Xxckg_xpd0 xckg_d0__p1 clk vdd__p2 vdd sg13_lv_pmos w=1u l=0.5u ng=1 m=1
Xxckg_xnd0 xckg_d0 clk vss__p9 vss sg13_lv_nmos w=0.5u l=0.5u ng=1 m=1
Xxckg_cd0 xckg_d0__p2 vss__p16 cap_cmim w=2.53u l=2.53u m=1
Xxckg_xpd1 xckg_d1__p1 xckg_d0 vdd__p3 vdd sg13_lv_pmos w=1u l=0.5u ng=1 m=1
Xxckg_xnd1 xckg_d1 xckg_d0 vss__p10 vss sg13_lv_nmos w=0.5u l=0.5u ng=1 m=1
Xxckg_cd1 xckg_d1__p2 vss__p17 cap_cmim w=2.53u l=2.53u m=1
Xxckg_xpd2 xckg_d2__p1 xckg_d1 vdd__p4 vdd sg13_lv_pmos w=1u l=0.5u ng=1 m=1
Xxckg_xnd2 xckg_d2 xckg_d1 vss__p11 vss sg13_lv_nmos w=0.5u l=0.5u ng=1 m=1
Xxckg_cd2 xckg_d2__p2 vss__p18 cap_cmim w=2.53u l=2.53u m=1
Xxckg_xpd3 xckg_d3__p1 xckg_d2 vdd__p5 vdd sg13_lv_pmos w=1u l=0.5u ng=1 m=1
Xxckg_xnd3 xckg_d3 xckg_d2 vss__p12 vss sg13_lv_nmos w=0.5u l=0.5u ng=1 m=1
Xxckg_cd3 xckg_d3__p2 vss__p19 cap_cmim w=2.53u l=2.53u m=1
Xxckg_xpd4 xckg_x__p2 xckg_d3 vdd__p6 vdd sg13_lv_pmos w=1u l=0.5u ng=1 m=1
Xxckg_xnd4 xckg_x xckg_d3 vss__p13 vss sg13_lv_nmos w=0.5u l=0.5u ng=1 m=1
Xxckg_cd4 xckg_x__p4 vss__p20 cap_cmim w=2.53u l=2.53u m=1
Xxckg_xpa sar_mclk__p2 clk__p1 vdd__p7 vdd sg13_lv_pmos w=2u l=0.13u ng=1 m=1
Xxckg_xpb sar_mclk__p3 xckg_x__p3 vdd__p8 vdd sg13_lv_pmos w=2u l=0.13u ng=1 m=1
Xxckg_xna sar_mclk__p0 clk__p0 xckg_nn vss sg13_lv_nmos w=2u l=0.13u ng=1 m=1
Xxckg_xnb xckg_nn__p1 xckg_x__p1 vss__p14 vss sg13_lv_nmos w=2u l=0.13u ng=1 m=1
Xxckg_xpi mclkb__p1 sar_mclk__p4 vdd__p9 vdd sg13_lv_pmos w=2u l=0.13u ng=1 m=1
Xxckg_xni mclkb sar_mclk__p1 vss__p15 vss sg13_lv_nmos w=1u l=0.13u ng=1 m=1
Xxcbias_xmbd vbp__p1 vbp vdd__p1 vdd sg13_lv_pmos w=0.8u l=0.5u ng=1 m=1
Xxcbias_xrb_g0 vbp xcbias_xrb_s1 vss rppd w=1u l=40u m=1 b=0
Xxcbias_xrb_g1 xcbias_xrb_s1 xcbias_xrb_s2 vss rppd w=1u l=40u m=1 b=0
Xxcbias_xrb_g2 xcbias_xrb_s2 xcbias_xrb_s3 vss rppd w=1u l=40u m=1 b=0
Xxcbias_xrb_g3 xcbias_xrb_s3 vss__p7 vss rppd w=1u l=40u m=1 b=0
Xxcbiasn_xmbd vbn__p1 vbn vss__p8 vss sg13_lv_nmos w=0.2u l=0.5u ng=1 m=1
Xxcbiasn_xrb_g0 vdd__p0 xcbiasn_xrb_s1 vss rppd w=1u l=40u m=1 b=0
Xxcbiasn_xrb_g1 xcbiasn_xrb_s1 xcbiasn_xrb_s2 vss rppd w=1u l=40u m=1 b=0
Xxcbiasn_xrb_g2 xcbiasn_xrb_s2 xcbiasn_xrb_s3 vss rppd w=1u l=40u m=1 b=0
Xxcbiasn_xrb_g3 xcbiasn_xrb_s3 vbn vss rppd w=1u l=40u m=1 b=0
Xxref_xmb0 ibias__p0 ibias vss__p5 vss sg13_hv_nmos w=2u l=1u ng=1 m=1
Xxref_xmt xref_ntl ibias vss__p6 vss sg13_hv_nmos w=2u l=8u ng=1 m=1
Xxref_xm1 xref_na vref_in xref_ntl__p1 vss sg13_hv_nmos w=10u l=1u ng=2 m=1
Xxref_xm2 xref_ng vref xref_ntl__p2 vss sg13_hv_nmos w=10u l=1u ng=2 m=1
Xxref_xm3 xref_na__p1 xref_na vdda__p5 vdda sg13_hv_pmos w=4u l=1u ng=1 m=1
Xxref_xm4 xref_ng__p1 xref_na vdda__p6 vdda sg13_hv_pmos w=4u l=1u ng=1 m=1
Xxref_xcg_u0 vss xref_ng__p2 cap_cmim w=26.32u l=95u m=1
Xxref_xmsf_s0 vdda__p1 xref_ng vref vss sg13_hv_nmos w=80u l=0.45u ng=32 m=1
Xxref_xmsf_s1 vdda__p2 xref_ng vref__p5 vss sg13_hv_nmos w=80u l=0.45u ng=32 m=1
Xxref_xmsf_s2 vdda__p3 xref_ng vref__p6 vss sg13_hv_nmos w=80u l=0.45u ng=32 m=1
Xxref_xmsf_s3 vdda__p4 xref_ng vref__p7 vss sg13_hv_nmos w=80u l=0.45u ng=32 m=1
Xxref_xmib_s0 vref__p0 ibias vss__p0 vss sg13_hv_nmos w=80u l=1u ng=40 m=1
Xxref_xmib_s1 vref__p1 ibias vss__p1 vss sg13_hv_nmos w=80u l=1u ng=40 m=1
Xxref_xmib_s2 vref__p2 ibias vss__p2 vss sg13_hv_nmos w=80u l=1u ng=40 m=1
Xxref_xmib_s3 vref__p3 ibias vss__p3 vss sg13_hv_nmos w=80u l=1u ng=40 m=1
Xxref_xcd_u0 vss vref__p8 cap_cmim w=51.58u l=95u m=1
Xxref_xcd_u1 vss vref__p9 cap_cmim w=51.58u l=95u m=1
Xxref_xcd_u2 vss vref__p10 cap_cmim w=51.58u l=95u m=1
Xxref_xcd_u3 vss vref__p11 cap_cmim w=51.58u l=95u m=1
Xxref_xmsfl_s0 vdda__p0 xref_ng vrefl vss sg13_hv_nmos w=80u l=0.45u ng=32 m=1
Xxref_xmibl_s0 vrefl__p0 ibias vss__p4 vss sg13_hv_nmos w=80u l=1u ng=40 m=1
Xxref_xcdl_u0 vss vrefl__p2 cap_cmim w=51.58u l=95u m=1
Xxref_xcdl_u1 vss vrefl__p3 cap_cmim w=51.58u l=95u m=1
Xxfilt_xcf_u0 vss vref_in__p1 cap_cmim w=37.36u l=90u m=1
Xxfilt_xcf_u1 vss vref_in__p2 cap_cmim w=37.36u l=90u m=1
Xslice_a ain_sin_p__p1 ain_sin_n__p1 ain_isa_p__p1 ain_isa_n__p1 sar_trka0__p1 sar_trka1__p1 sar_cpa0__p1 sar_cpa1__p1 sar_cpa2__p1 sar_cpa3__p1 sar_cpa4__p1 sar_cpa5__p1 sar_cpa6__p1 sar_cpa7__p1 sar_cpa8__p1 sar_cpa9__p1 sar_cpa10__p1 sar_cpa11__p1 sar_cpa12__p1 sar_cna0__p1 sar_cna1__p1 sar_cna2__p1 sar_cna3__p1 sar_cna4__p1 sar_cna5__p1 sar_cna6__p1 sar_cna7__p1 sar_cna8__p1 sar_cna9__p1 sar_cna10__p1 sar_cna11__p1 sar_cna12__p1 sar_clka__p1 sar_clkab__p1 sar_clkna__p1 sar_clknab__p1 sar_oap__p1 sar_oan__p1 sar_oanp__p1 sar_oann__p1 vbp__p2 vbn__p2 vref__p12 vref__p13 vref__p14 vrefl__p4 vrefl__p5 topap topan vdd__p12 vdd__p13 vdd__p14 vdd__p15 xslice_a_gnd_nc0 vss__p23 xslice_a_gnd_nc2 vss__p24 xslice_a_gnd_nc4 vss__p25 xslice_a_gnd_nc6 vss__p26 r1_adc_slice_post
Xslice_b ain_cos_p__p1 ain_cos_n__p1 ain_isb_p__p1 ain_isb_n__p1 sar_trkb0__p1 sar_trkb1__p1 sar_cpb0__p1 sar_cpb1__p1 sar_cpb2__p1 sar_cpb3__p1 sar_cpb4__p1 sar_cpb5__p1 sar_cpb6__p1 sar_cpb7__p1 sar_cpb8__p1 sar_cpb9__p1 sar_cpb10__p1 sar_cpb11__p1 sar_cpb12__p1 sar_cnb0__p1 sar_cnb1__p1 sar_cnb2__p1 sar_cnb3__p1 sar_cnb4__p1 sar_cnb5__p1 sar_cnb6__p1 sar_cnb7__p1 sar_cnb8__p1 sar_cnb9__p1 sar_cnb10__p1 sar_cnb11__p1 sar_cnb12__p1 sar_clkb__p1 sar_clkbb__p1 sar_clknb__p1 sar_clknbb__p1 sar_obp__p1 sar_obn__p1 sar_obnp__p1 sar_obnn__p1 vbp__p3 vbn__p3 vref__p15 vref__p16 vref__p17 vrefl__p6 vrefl__p7 topbp topbn vdd__p16 vdd__p17 vdd__p18 vdd__p19 vss__p27 xslice_b_gnd_nc1 vss__p28 xslice_b_gnd_nc3 vss__p29 xslice_b_gnd_nc5 vss__p30 xslice_b_gnd_nc7 r1_adc_slice_post
Rt0 ain_cos_n ain_cos_n__p1 126.828
Rt1 ain_cos_p ain_cos_p__p1 128.647
Rt2 ain_isa_n ain_isa_n__p1 127.972
Rt3 ain_isa_p ain_isa_p__p1 129.791
Rt4 ain_isb_n ain_isb_n__p1 0.198
Rt5 ain_isb_p ain_isb_p__p1 0.198
Rt6 ain_sin_n ain_sin_n__p1 0.308
Rt7 ain_sin_p ain_sin_p__p1 0.308
Rt8 clk clk__p0 141.519
Rt9 clk clk__p1 195.072
Rt10 clk__p0 clk__p1 49.582
Rt11 ibias ibias__p0 200.561
Rt12 mclkb mclkb__p1 43.3194
Rt13 sar_clka sar_clka__p1 12.3244
Rt14 sar_clkab sar_clkab__p1 12.3303
Rt15 sar_clkb sar_clkb__p1 12.498
Rt16 sar_clkbb sar_clkbb__p1 12.3244
Rt17 sar_clkna sar_clkna__p1 12.3244
Rt18 sar_clknab sar_clknab__p1 12.322
Rt19 sar_clknb sar_clknb__p1 12.3303
Rt20 sar_clknbb sar_clknbb__p1 12.3303
Rt21 sar_cna0 sar_cna0__p1 12.3244
Rt22 sar_cna1 sar_cna1__p1 12.3303
Rt23 sar_cna10 sar_cna10__p1 12.3244
Rt24 sar_cna11 sar_cna11__p1 12.3244
Rt25 sar_cna12 sar_cna12__p1 12.322
Rt26 sar_cna2 sar_cna2__p1 12.3303
Rt27 sar_cna3 sar_cna3__p1 12.3244
Rt28 sar_cna4 sar_cna4__p1 12.3303
Rt29 sar_cna5 sar_cna5__p1 12.3303
Rt30 sar_cna6 sar_cna6__p1 12.3244
Rt31 sar_cna7 sar_cna7__p1 12.3303
Rt32 sar_cna8 sar_cna8__p1 12.3244
Rt33 sar_cna9 sar_cna9__p1 12.322
Rt34 sar_cnb0 sar_cnb0__p1 12.498
Rt35 sar_cnb1 sar_cnb1__p1 12.322
Rt36 sar_cnb10 sar_cnb10__p1 12.498
Rt37 sar_cnb11 sar_cnb11__p1 12.3303
Rt38 sar_cnb12 sar_cnb12__p1 12.3303
Rt39 sar_cnb2 sar_cnb2__p1 12.3244
Rt40 sar_cnb3 sar_cnb3__p1 12.498
Rt41 sar_cnb4 sar_cnb4__p1 12.322
Rt42 sar_cnb5 sar_cnb5__p1 12.3244
Rt43 sar_cnb6 sar_cnb6__p1 12.498
Rt44 sar_cnb7 sar_cnb7__p1 12.322
Rt45 sar_cnb8 sar_cnb8__p1 12.3303
Rt46 sar_cnb9 sar_cnb9__p1 12.3303
Rt47 sar_cpa0 sar_cpa0__p1 12.3303
Rt48 sar_cpa1 sar_cpa1__p1 12.3244
Rt49 sar_cpa10 sar_cpa10__p1 12.322
Rt50 sar_cpa11 sar_cpa11__p1 12.3244
Rt51 sar_cpa12 sar_cpa12__p1 12.3244
Rt52 sar_cpa2 sar_cpa2__p1 12.3303
Rt53 sar_cpa3 sar_cpa3__p1 12.7425
Rt54 sar_cpa4 sar_cpa4__p1 12.3244
Rt55 sar_cpa5 sar_cpa5__p1 12.3303
Rt56 sar_cpa6 sar_cpa6__p1 12.3303
Rt57 sar_cpa7 sar_cpa7__p1 12.3244
Rt58 sar_cpa8 sar_cpa8__p1 12.3244
Rt59 sar_cpa9 sar_cpa9__p1 12.3244
Rt60 sar_cpb0 sar_cpb0__p1 12.322
Rt61 sar_cpb1 sar_cpb1__p1 12.498
Rt62 sar_cpb10 sar_cpb10__p1 12.3303
Rt63 sar_cpb11 sar_cpb11__p1 12.3303
Rt64 sar_cpb12 sar_cpb12__p1 12.498
Rt65 sar_cpb2 sar_cpb2__p1 12.3244
Rt66 sar_cpb3 sar_cpb3__p1 12.759
Rt67 sar_cpb4 sar_cpb4__p1 12.498
Rt68 sar_cpb5 sar_cpb5__p1 12.3244
Rt69 sar_cpb6 sar_cpb6__p1 12.322
Rt70 sar_cpb7 sar_cpb7__p1 12.498
Rt71 sar_cpb8 sar_cpb8__p1 12.3303
Rt72 sar_cpb9 sar_cpb9__p1 12.498
Rt73 sar_mclk sar_mclk__p0 170.374
Rt74 sar_mclk sar_mclk__p1 196.812
Rt75 sar_mclk sar_mclk__p2 307.715
Rt76 sar_mclk sar_mclk__p4 333.321
Rt77 sar_mclk__p0 sar_mclk__p1 70.5716
Rt78 sar_mclk__p0 sar_mclk__p2 110.338
Rt79 sar_mclk__p0 sar_mclk__p4 119.52
Rt80 sar_mclk__p1 sar_mclk__p2 101.952
Rt81 sar_mclk__p1 sar_mclk__p4 110.436
Rt82 sar_mclk__p2 sar_mclk__p3 0.6204
Rt83 sar_mclk__p2 sar_mclk__p4 64.7625
Rt84 sar_oan sar_oan__p1 12.3244
Rt85 sar_oann sar_oann__p1 12.3303
Rt86 sar_oanp sar_oanp__p1 12.3244
Rt87 sar_oap sar_oap__p1 12.322
Rt88 sar_obn sar_obn__p1 12.5344
Rt89 sar_obnn sar_obnn__p1 12.322
Rt90 sar_obnp sar_obnp__p1 12.498
Rt91 sar_obp sar_obp__p1 12.3303
Rt92 sar_trka0 sar_trka0__p1 12.3303
Rt93 sar_trka1 sar_trka1__p1 12.3303
Rt94 sar_trkb0 sar_trkb0__p1 12.3244
Rt95 sar_trkb1 sar_trkb1__p1 12.322
Rt96 vbn vbn__p1 68.8436
Rt97 vbn vbn__p2 240.016
Rt98 vbn vbn__p3 784.574
Rt99 vbn__p1 vbn__p2 217.489
Rt100 vbn__p1 vbn__p3 710.938
Rt101 vbn__p2 vbn__p3 168.032
Rt102 vbp vbp__p1 73.6975
Rt103 vbp vbp__p2 245.763
Rt104 vbp vbp__p3 1260.46
Rt105 vbp__p1 vbp__p2 195.517
Rt106 vbp__p1 vbp__p3 1002.76
Rt107 vbp__p2 vbp__p3 154.24
Rt108 vdd vdd__p0 34389.1
Rt109 vdd vdd__p1 40943
Rt110 vdd vdd__p11 68132.9
Rt111 vdd vdd__p12 82.2115
Rt112 vdd vdd__p13 11.0679
Rt113 vdd vdd__p14 29.2479
Rt114 vdd vdd__p15 437.715
Rt115 vdd vdd__p16 3424.56
Rt116 vdd vdd__p17 42939.2
Rt117 vdd vdd__p18 786782
Rt118 vdd__p0 vdd__p1 119.607
Rt119 vdd__p0 vdd__p12 99.6158
Rt120 vdd__p0 vdd__p13 288.609
Rt121 vdd__p0 vdd__p14 7716.14
Rt122 vdd__p0 vdd__p15 115478
Rt123 vdd__p0 vdd__p16 903464
Rt124 vdd__p1 vdd__p12 118.601
Rt125 vdd__p1 vdd__p13 343.612
Rt126 vdd__p1 vdd__p14 9186.68
Rt127 vdd__p1 vdd__p15 137485
Rt128 vdd__p11 vdd__p12 42970.9
Rt129 vdd__p11 vdd__p13 5785.07
Rt130 vdd__p11 vdd__p14 90.208
Rt131 vdd__p11 vdd__p15 12.7553
Rt132 vdd__p11 vdd__p16 14.0525
Rt133 vdd__p11 vdd__p17 160.888
Rt134 vdd__p11 vdd__p18 2947.98
Rt135 vdd__p11 vdd__p19 40686.4
Rt136 vdd__p11 vdd__p2 463.671
Rt137 vdd__p11 vdd__p3 424.895
Rt138 vdd__p11 vdd__p4 361.688
Rt139 vdd__p11 vdd__p5 291.702
Rt140 vdd__p11 vdd__p6 227.058
Rt141 vdd__p11 vdd__p7 29.9714
Rt142 vdd__p11 vdd__p8 158.698
Rt143 vdd__p11 vdd__p9 29.2186
Rt144 vdd__p12 vdd__p13 0.697261
Rt145 vdd__p12 vdd__p14 18.4464
Rt146 vdd__p12 vdd__p15 276.063
Rt147 vdd__p12 vdd__p16 2159.85
Rt148 vdd__p12 vdd__p17 27081.4
Rt149 vdd__p12 vdd__p18 496217
Rt150 vdd__p13 vdd__p14 2.48339
Rt151 vdd__p13 vdd__p15 37.1657
Rt152 vdd__p13 vdd__p16 290.775
Rt153 vdd__p13 vdd__p17 3645.91
Rt154 vdd__p13 vdd__p18 66804.5
Rt155 vdd__p13 vdd__p19 922000
Rt156 vdd__p13 vdd__p6 939934
Rt157 vdd__p13 vdd__p7 180555
Rt158 vdd__p13 vdd__p8 656946
Rt159 vdd__p13 vdd__p9 176021
Rt160 vdd__p14 vdd__p15 0.527112
Rt161 vdd__p14 vdd__p16 4.53412
Rt162 vdd__p14 vdd__p17 56.8516
Rt163 vdd__p14 vdd__p18 1041.7
Rt164 vdd__p14 vdd__p19 14377
Rt165 vdd__p14 vdd__p2 29930
Rt166 vdd__p14 vdd__p3 27427
Rt167 vdd__p14 vdd__p4 23347
Rt168 vdd__p14 vdd__p5 18829.3
Rt169 vdd__p14 vdd__p6 14656.6
Rt170 vdd__p14 vdd__p7 2815.45
Rt171 vdd__p14 vdd__p8 10243.9
Rt172 vdd__p14 vdd__p9 2744.73
Rt173 vdd__p15 vdd__p16 0.372867
Rt174 vdd__p15 vdd__p17 7.12045
Rt175 vdd__p15 vdd__p18 130.469
Rt176 vdd__p15 vdd__p19 1800.66
Rt177 vdd__p15 vdd__p2 4232.07
Rt178 vdd__p15 vdd__p3 3878.14
Rt179 vdd__p15 vdd__p4 3301.24
Rt180 vdd__p15 vdd__p5 2662.45
Rt181 vdd__p15 vdd__p6 2072.43
Rt182 vdd__p15 vdd__p7 398.102
Rt183 vdd__p15 vdd__p8 1448.48
Rt184 vdd__p15 vdd__p9 388.103
Rt185 vdd__p16 vdd__p17 0.804871
Rt186 vdd__p16 vdd__p18 14.9541
Rt187 vdd__p16 vdd__p19 206.388
Rt188 vdd__p16 vdd__p2 4662.44
Rt189 vdd__p16 vdd__p3 4272.53
Rt190 vdd__p16 vdd__p4 3636.95
Rt191 vdd__p16 vdd__p5 2933.2
Rt192 vdd__p16 vdd__p6 2283.19
Rt193 vdd__p16 vdd__p7 438.586
Rt194 vdd__p16 vdd__p8 1595.78
Rt195 vdd__p16 vdd__p9 427.57
Rt196 vdd__p17 vdd__p18 2.61782
Rt197 vdd__p17 vdd__p19 36.1298
Rt198 vdd__p17 vdd__p2 53380.8
Rt199 vdd__p17 vdd__p3 48916.6
Rt200 vdd__p17 vdd__p4 41639.9
Rt201 vdd__p17 vdd__p5 33582.6
Rt202 vdd__p17 vdd__p6 26140.5
Rt203 vdd__p17 vdd__p7 5021.42
Rt204 vdd__p17 vdd__p8 18270.3
Rt205 vdd__p17 vdd__p9 4895.3
Rt206 vdd__p18 vdd__p19 0.487307
Rt207 vdd__p18 vdd__p2 978105
Rt208 vdd__p18 vdd__p3 896307
Rt209 vdd__p18 vdd__p4 762974
Rt210 vdd__p18 vdd__p5 615339
Rt211 vdd__p18 vdd__p6 478976
Rt212 vdd__p18 vdd__p7 92008.3
Rt213 vdd__p18 vdd__p8 334770
Rt214 vdd__p18 vdd__p9 89697.3
Rt215 vdd__p2 vdd__p3 88.2674
Rt216 vdd__p2 vdd__p4 114.618
Rt217 vdd__p2 vdd__p5 144.634
Rt218 vdd__p2 vdd__p6 174.434
Rt219 vdd__p2 vdd__p7 14471.4
Rt220 vdd__p2 vdd__p8 225.153
Rt221 vdd__p2 vdd__p9 14108
Rt222 vdd__p3 vdd__p4 105.033
Rt223 vdd__p3 vdd__p5 132.538
Rt224 vdd__p3 vdd__p6 159.846
Rt225 vdd__p3 vdd__p7 13261.2
Rt226 vdd__p3 vdd__p8 206.324
Rt227 vdd__p3 vdd__p9 12928.1
Rt228 vdd__p4 vdd__p5 112.822
Rt229 vdd__p4 vdd__p6 136.068
Rt230 vdd__p4 vdd__p7 11288.5
Rt231 vdd__p4 vdd__p8 175.631
Rt232 vdd__p4 vdd__p9 11005
Rt233 vdd__p5 vdd__p6 109.739
Rt234 vdd__p5 vdd__p7 9104.19
Rt235 vdd__p5 vdd__p8 141.647
Rt236 vdd__p5 vdd__p9 8875.52
Rt237 vdd__p6 vdd__p7 7086.64
Rt238 vdd__p6 vdd__p8 110.257
Rt239 vdd__p6 vdd__p9 6908.64
Rt240 vdd__p7 vdd__p8 4953.05
Rt241 vdd__p7 vdd__p9 574.85
Rt242 vdd__p8 vdd__p9 4828.65
Rt243 vdda vdda__p1 41.3489
Rt244 vdda vdda__p2 278.578
Rt245 vdda vdda__p3 56.012
Rt246 vdda vdda__p5 261.48
Rt247 vdda vdda__p6 203.591
Rt248 vdda__p0 vdda__p3 62.8025
Rt249 vdda__p0 vdda__p4 67.5999
Rt250 vdda__p1 vdda__p2 1202.37
Rt251 vdda__p1 vdda__p3 241.754
Rt252 vdda__p1 vdda__p5 1128.58
Rt253 vdda__p1 vdda__p6 878.722
Rt254 vdda__p2 vdda__p3 256.165
Rt255 vdda__p2 vdda__p5 63.6193
Rt256 vdda__p2 vdda__p6 79.0683
Rt257 vdda__p3 vdda__p4 23.0314
Rt258 vdda__p3 vdda__p5 240.442
Rt259 vdda__p3 vdda__p6 187.211
Rt260 vdda__p5 vdda__p6 74.2153
Rt261 vref vref__p0 114.65
Rt262 vref vref__p1 6.10169
Rt263 vref vref__p10 186.142
Rt264 vref vref__p11 8271.36
Rt265 vref vref__p12 1487.93
Rt266 vref vref__p13 808.459
Rt267 vref vref__p14 372.871
Rt268 vref vref__p15 1459.54
Rt269 vref vref__p16 3157.02
Rt270 vref vref__p17 5801
Rt271 vref vref__p2 370.329
Rt272 vref vref__p3 10248.9
Rt273 vref vref__p5 428.96
Rt274 vref vref__p6 1135.72
Rt275 vref vref__p7 3138.93
Rt276 vref vref__p8 2223.31
Rt277 vref vref__p9 50.9452
Rt278 vref__p0 vref__p1 5.08178
Rt279 vref__p0 vref__p10 1372.92
Rt280 vref__p0 vref__p11 61005.8
Rt281 vref__p0 vref__p12 11330.2
Rt282 vref__p0 vref__p13 6156.32
Rt283 vref__p0 vref__p14 2839.43
Rt284 vref__p0 vref__p15 10764.9
Rt285 vref__p0 vref__p16 23284.7
Rt286 vref__p0 vref__p17 42785.5
Rt287 vref__p0 vref__p2 2151.06
Rt288 vref__p0 vref__p3 74645.3
Rt289 vref__p0 vref__p5 1782.68
Rt290 vref__p0 vref__p6 6979.82
Rt291 vref__p0 vref__p7 23027.9
Rt292 vref__p0 vref__p8 16928.7
Rt293 vref__p0 vref__p9 387.793
Rt294 vref__p1 vref__p10 27.2286
Rt295 vref__p1 vref__p11 1209.68
Rt296 vref__p1 vref__p12 366.189
Rt297 vref__p1 vref__p13 199.066
Rt298 vref__p1 vref__p14 91.8501
Rt299 vref__p1 vref__p15 213.441
Rt300 vref__p1 vref__p16 461.684
Rt301 vref__p1 vref__p17 848.354
Rt302 vref__p1 vref__p2 8.38761
Rt303 vref__p1 vref__p3 1193.26
Rt304 vref__p1 vref__p5 6.38445
Rt305 vref__p1 vref__p6 32.923
Rt306 vref__p1 vref__p7 414.228
Rt307 vref__p1 vref__p8 546.455
Rt308 vref__p1 vref__p9 12.4499
Rt309 vref__p10 vref__p11 1.96723
Rt310 vref__p10 vref__p12 390.352
Rt311 vref__p10 vref__p13 212.377
Rt312 vref__p10 vref__p14 98.0606
Rt313 vref__p10 vref__p15 1.88326
Rt314 vref__p10 vref__p16 2.58285
Rt315 vref__p10 vref__p17 2.96452
Rt316 vref__p10 vref__p2 13.5031
Rt317 vref__p10 vref__p3 151.839
Rt318 vref__p10 vref__p5 105.826
Rt319 vref__p10 vref__p6 71.6163
Rt320 vref__p10 vref__p7 45.7002
Rt321 vref__p10 vref__p8 581.257
Rt322 vref__p10 vref__p9 13.1189
Rt323 vref__p11 vref__p12 17345.9
Rt324 vref__p11 vref__p13 9437.27
Rt325 vref__p11 vref__p14 4357.47
Rt326 vref__p11 vref__p15 11.7242
Rt327 vref__p11 vref__p16 6.70636
Rt328 vref__p11 vref__p17 3.30899
Rt329 vref__p11 vref__p2 588.996
Rt330 vref__p11 vref__p3 6559.22
Rt331 vref__p11 vref__p5 4701.78
Rt332 vref__p11 vref__p6 3179.28
Rt333 vref__p11 vref__p7 1973.95
Rt334 vref__p11 vref__p8 25829
Rt335 vref__p11 vref__p9 582.958
Rt336 vref__p12 vref__p13 2.76051
Rt337 vref__p12 vref__p14 5.69068
Rt338 vref__p12 vref__p15 3060.82
Rt339 vref__p12 vref__p16 6620.62
Rt340 vref__p12 vref__p17 12165.3
Rt341 vref__p12 vref__p2 961.871
Rt342 vref__p12 vref__p3 21690.6
Rt343 vref__p12 vref__p5 2025.57
Rt344 vref__p12 vref__p6 2781.47
Rt345 vref__p12 vref__p7 6608.37
Rt346 vref__p12 vref__p8 3.41549
Rt347 vref__p12 vref__p9 2.8795
Rt348 vref__p13 vref__p14 2.76481
Rt349 vref__p13 vref__p15 1665.29
Rt350 vref__p13 vref__p16 3602.05
Rt351 vref__p13 vref__p17 6618.72
Rt352 vref__p13 vref__p2 523.306
Rt353 vref__p13 vref__p3 11801.1
Rt354 vref__p13 vref__p5 1101.86
Rt355 vref__p13 vref__p6 1513.26
Rt356 vref__p13 vref__p7 3595.37
Rt357 vref__p13 vref__p8 6.9687
Rt358 vref__p13 vref__p9 2.56608
Rt359 vref__p14 vref__p15 768.912
Rt360 vref__p14 vref__p16 1663.17
Rt361 vref__p14 vref__p17 3056.06
Rt362 vref__p14 vref__p2 241.621
Rt363 vref__p14 vref__p3 5448.89
Rt364 vref__p14 vref__p5 508.693
Rt365 vref__p14 vref__p6 698.702
Rt366 vref__p14 vref__p7 1660.09
Rt367 vref__p14 vref__p8 12.1708
Rt368 vref__p14 vref__p9 1.86726
Rt369 vref__p15 vref__p16 2.76621
Rt370 vref__p15 vref__p17 5.68373
Rt371 vref__p15 vref__p2 103.213
Rt372 vref__p15 vref__p3 1145.31
Rt373 vref__p15 vref__p5 829.619
Rt374 vref__p15 vref__p6 560.804
Rt375 vref__p15 vref__p7 344.658
Rt376 vref__p15 vref__p8 4557.75
Rt377 vref__p15 vref__p9 102.868
Rt378 vref__p16 vref__p17 2.75986
Rt379 vref__p16 vref__p2 223.556
Rt380 vref__p16 vref__p3 2482.45
Rt381 vref__p16 vref__p5 1794.5
Rt382 vref__p16 vref__p6 1213.12
Rt383 vref__p16 vref__p7 747.047
Rt384 vref__p16 vref__p8 9858.5
Rt385 vref__p16 vref__p9 222.505
Rt386 vref__p17 vref__p2 411.407
Rt387 vref__p17 vref__p3 4571.97
Rt388 vref__p17 vref__p5 3297.42
Rt389 vref__p17 vref__p6 2229.27
Rt390 vref__p17 vref__p7 1375.86
Rt391 vref__p17 vref__p8 18114.9
Rt392 vref__p17 vref__p9 408.851
Rt393 vref__p2 vref__p3 5.49374
Rt394 vref__p2 vref__p5 65.7993
Rt395 vref__p2 vref__p6 7.45703
Rt396 vref__p2 vref__p7 6.5906
Rt397 vref__p2 vref__p8 1432.38
Rt398 vref__p2 vref__p9 32.3382
Rt399 vref__p3 vref__p5 5279.01
Rt400 vref__p3 vref__p6 2064.28
Rt401 vref__p3 vref__p7 48.2546
Rt402 vref__p3 vref__p8 32298.7
Rt403 vref__p3 vref__p9 728.99
Rt404 vref__p5 vref__p6 244.984
Rt405 vref__p5 vref__p7 1709.1
Rt406 vref__p5 vref__p8 3017.46
Rt407 vref__p5 vref__p9 68.2281
Rt408 vref__p6 vref__p7 871.249
Rt409 vref__p6 vref__p8 4142.06
Rt410 vref__p6 vref__p9 93.5132
Rt411 vref__p7 vref__p8 9840.28
Rt412 vref__p7 vref__p9 222.096
Rt413 vref__p8 vref__p9 1.94076
Rt414 vref_in vref_in__p1 0.001
Rt415 vref_in vref_in__p2 0.001
Rt416 vrefl vrefl__p0 31.2586
Rt417 vrefl vrefl__p2 93.437
Rt418 vrefl vrefl__p3 7.18444
Rt419 vrefl vrefl__p4 7325.4
Rt420 vrefl vrefl__p5 4916.21
Rt421 vrefl vrefl__p6 359.98
Rt422 vrefl vrefl__p7 574.557
Rt423 vrefl__p0 vrefl__p2 18.0283
Rt424 vrefl__p0 vrefl__p3 12.5916
Rt425 vrefl__p0 vrefl__p4 63.5642
Rt426 vrefl__p0 vrefl__p5 72.9525
Rt427 vrefl__p0 vrefl__p6 631.93
Rt428 vrefl__p0 vrefl__p7 1009.16
Rt429 vrefl__p2 vrefl__p3 2.16812
Rt430 vrefl__p2 vrefl__p4 8.30061
Rt431 vrefl__p2 vrefl__p5 5.37046
Rt432 vrefl__p2 vrefl__p6 117.734
Rt433 vrefl__p2 vrefl__p7 192.433
Rt434 vrefl__p3 vrefl__p4 211.164
Rt435 vrefl__p3 vrefl__p5 128.531
Rt436 vrefl__p3 vrefl__p6 5.07096
Rt437 vrefl__p3 vrefl__p7 7.53987
Rt438 vrefl__p4 vrefl__p5 31.8717
Rt439 vrefl__p4 vrefl__p6 11315.9
Rt440 vrefl__p4 vrefl__p7 18493.5
Rt441 vrefl__p5 vrefl__p6 6889.67
Rt442 vrefl__p5 vrefl__p7 11261.9
Rt443 vrefl__p6 vrefl__p7 32.2289
Rt444 vss vss__p0 34.9503
Rt445 vss vss__p1 372.756
Rt446 vss vss__p10 18233.6
Rt447 vss vss__p11 33061.6
Rt448 vss vss__p12 32281.5
Rt449 vss vss__p13 55884.9
Rt450 vss vss__p14 78141.4
Rt451 vss vss__p15 250270
Rt452 vss vss__p16 358.209
Rt453 vss vss__p17 3653.28
Rt454 vss vss__p18 96113.9
Rt455 vss vss__p19 74114.8
Rt456 vss vss__p2 152.168
Rt457 vss vss__p20 138679
Rt458 vss vss__p22 0.001
Rt459 vss vss__p23 2
Rt460 vss vss__p24 2
Rt461 vss vss__p25 2
Rt462 vss vss__p26 2
Rt463 vss vss__p27 2
Rt464 vss vss__p28 2
Rt465 vss vss__p29 2
Rt466 vss vss__p3 89.0698
Rt467 vss vss__p30 2
Rt468 vss vss__p4 1076.06
Rt469 vss vss__p5 1332.84
Rt470 vss vss__p6 1752.7
Rt471 vss vss__p7 37.7353
Rt472 vss vss__p8 41.2417
Rt473 vss vss__p9 13512
Rt474 vss__p0 vss__p1 169.257
Rt475 vss__p0 vss__p10 782087
Rt476 vss__p0 vss__p16 15364.5
Rt477 vss__p0 vss__p17 156699
Rt478 vss__p0 vss__p2 6656.8
Rt479 vss__p0 vss__p3 3896.48
Rt480 vss__p0 vss__p4 488.606
Rt481 vss__p0 vss__p5 605.203
Rt482 vss__p0 vss__p6 795.845
Rt483 vss__p0 vss__p7 445.256
Rt484 vss__p0 vss__p8 490.044
Rt485 vss__p0 vss__p9 579567
Rt486 vss__p1 vss__p16 163868
Rt487 vss__p1 vss__p2 70997
Rt488 vss__p1 vss__p3 41557.2
Rt489 vss__p1 vss__p4 340.811
Rt490 vss__p1 vss__p5 422.139
Rt491 vss__p1 vss__p6 555.115
Rt492 vss__p1 vss__p7 4748.8
Rt493 vss__p1 vss__p8 5226.48
Rt494 vss__p10 vss__p11 184.446
Rt495 vss__p10 vss__p12 176.62
Rt496 vss__p10 vss__p13 307.671
Rt497 vss__p10 vss__p14 433.768
Rt498 vss__p10 vss__p15 1374.05
Rt499 vss__p10 vss__p16 139.567
Rt500 vss__p10 vss__p17 158.772
Rt501 vss__p10 vss__p18 555.994
Rt502 vss__p10 vss__p19 420.703
Rt503 vss__p10 vss__p2 352658
Rt504 vss__p10 vss__p20 808.124
Rt505 vss__p10 vss__p3 206424
Rt506 vss__p10 vss__p7 729352
Rt507 vss__p10 vss__p8 877308
Rt508 vss__p10 vss__p9 116.749
Rt509 vss__p11 vss__p12 195.406
Rt510 vss__p11 vss__p13 338.903
Rt511 vss__p11 vss__p14 475.02
Rt512 vss__p11 vss__p15 1516.48
Rt513 vss__p11 vss__p16 178.921
Rt514 vss__p11 vss__p17 29.8046
Rt515 vss__p11 vss__p18 591.254
Rt516 vss__p11 vss__p19 453.468
Rt517 vss__p11 vss__p2 639448
Rt518 vss__p11 vss__p20 854.867
Rt519 vss__p11 vss__p3 374293
Rt520 vss__p11 vss__p9 216.223
Rt521 vss__p12 vss__p13 190.25
Rt522 vss__p12 vss__p14 268.323
Rt523 vss__p12 vss__p15 849.545
Rt524 vss__p12 vss__p16 238.363
Rt525 vss__p12 vss__p17 142.029
Rt526 vss__p12 vss__p18 344.585
Rt527 vss__p12 vss__p19 260.506
Rt528 vss__p12 vss__p2 624361
Rt529 vss__p12 vss__p20 501.021
Rt530 vss__p12 vss__p3 365462
Rt531 vss__p12 vss__p9 207.081
Rt532 vss__p13 vss__p14 258.166
Rt533 vss__p13 vss__p15 860.032
Rt534 vss__p13 vss__p16 369.321
Rt535 vss__p13 vss__p17 80.5843
Rt536 vss__p13 vss__p18 42.4547
Rt537 vss__p13 vss__p19 227.381
Rt538 vss__p13 vss__p20 393.238
Rt539 vss__p13 vss__p3 632678
Rt540 vss__p13 vss__p9 360.715
Rt541 vss__p14 vss__p15 564.732
Rt542 vss__p14 vss__p16 453.74
Rt543 vss__p14 vss__p17 59.7988
Rt544 vss__p14 vss__p18 294.155
Rt545 vss__p14 vss__p19 55.3288
Rt546 vss__p14 vss__p20 194.885
Rt547 vss__p14 vss__p3 884646
Rt548 vss__p14 vss__p9 508.519
Rt549 vss__p15 vss__p16 1734.54
Rt550 vss__p15 vss__p17 513.739
Rt551 vss__p15 vss__p18 1398.8
Rt552 vss__p15 vss__p19 33.7794
Rt553 vss__p15 vss__p20 860.442
Rt554 vss__p15 vss__p9 1610.98
Rt555 vss__p16 vss__p17 1.54041
Rt556 vss__p16 vss__p18 350.696
Rt557 vss__p16 vss__p19 325.248
Rt558 vss__p16 vss__p2 6928.16
Rt559 vss__p16 vss__p20 475.339
Rt560 vss__p16 vss__p3 4055.32
Rt561 vss__p16 vss__p4 473049
Rt562 vss__p16 vss__p5 585932
Rt563 vss__p16 vss__p6 770504
Rt564 vss__p16 vss__p7 14328.5
Rt565 vss__p16 vss__p8 17235.2
Rt566 vss__p16 vss__p9 104.892
Rt567 vss__p17 vss__p18 22.3758
Rt568 vss__p17 vss__p19 25.21
Rt569 vss__p17 vss__p2 70658.6
Rt570 vss__p17 vss__p20 28.8059
Rt571 vss__p17 vss__p3 41359.2
Rt572 vss__p17 vss__p7 146133
Rt573 vss__p17 vss__p8 175777
Rt574 vss__p17 vss__p9 176.386
Rt575 vss__p18 vss__p19 169.03
Rt576 vss__p18 vss__p20 217.768
Rt577 vss__p18 vss__p9 651.585
Rt578 vss__p19 vss__p20 98.6071
Rt579 vss__p19 vss__p3 839061
Rt580 vss__p19 vss__p9 493.112
Rt581 vss__p2 vss__p3 63.5786
Rt582 vss__p2 vss__p4 204952
Rt583 vss__p2 vss__p5 253860
Rt584 vss__p2 vss__p6 333827
Rt585 vss__p2 vss__p7 6636.18
Rt586 vss__p2 vss__p8 7704.98
Rt587 vss__p2 vss__p9 261338
Rt588 vss__p20 vss__p9 947.006
Rt589 vss__p3 vss__p4 119966
Rt590 vss__p3 vss__p5 148594
Rt591 vss__p3 vss__p6 195402
Rt592 vss__p3 vss__p7 3884.41
Rt593 vss__p3 vss__p8 4510.02
Rt594 vss__p3 vss__p9 152971
Rt595 vss__p4 vss__p5 99.6258
Rt596 vss__p4 vss__p6 131.008
Rt597 vss__p4 vss__p7 13708.7
Rt598 vss__p4 vss__p8 15087.7
Rt599 vss__p5 vss__p6 57.9371
Rt600 vss__p5 vss__p7 16980
Rt601 vss__p5 vss__p8 18688
Rt602 vss__p6 vss__p7 22328.8
Rt603 vss__p6 vss__p8 24574.9
Rt604 vss__p7 vss__p8 217.113
Rt605 vss__p7 vss__p9 540488
Rt606 vss__p8 vss__p9 650130
Rt607 xckg_d0 xckg_d0__p1 158.064
Rt608 xckg_d0 xckg_d0__p2 32.5
Rt609 xckg_d0__p1 xckg_d0__p2 72.9819
Rt610 xckg_d1 xckg_d1__p1 160.822
Rt611 xckg_d1 xckg_d1__p2 33.3377
Rt612 xckg_d1__p1 xckg_d1__p2 71.7995
Rt613 xckg_d2 xckg_d2__p1 253.776
Rt614 xckg_d2 xckg_d2__p2 56.8495
Rt615 xckg_d2__p1 xckg_d2__p2 62.5432
Rt616 xckg_d3 xckg_d3__p1 116.773
Rt617 xckg_d3 xckg_d3__p2 66.8961
Rt618 xckg_d3__p1 xckg_d3__p2 71.2846
Rt619 xckg_nn xckg_nn__p1 46.1928
Rt620 xckg_x xckg_x__p1 101.928
Rt621 xckg_x xckg_x__p2 247.825
Rt622 xckg_x xckg_x__p3 173.816
Rt623 xckg_x xckg_x__p4 124.476
Rt624 xckg_x__p1 xckg_x__p2 156.926
Rt625 xckg_x__p1 xckg_x__p3 110.063
Rt626 xckg_x__p1 xckg_x__p4 78.82
Rt627 xckg_x__p2 xckg_x__p3 94.6454
Rt628 xckg_x__p2 xckg_x__p4 142.468
Rt629 xckg_x__p3 xckg_x__p4 99.922
Rt630 xref_na xref_na__p1 77.984
Rt631 xref_ng xref_ng__p1 1225.95
Rt632 xref_ng xref_ng__p2 132.884
Rt633 xref_ng__p1 xref_ng__p2 31.5508
Rt634 xref_ntl xref_ntl__p1 60.2546
Rt635 xref_ntl__p1 xref_ntl__p2 19.318
Cq0 ain_cos_n ain_cos_p 2.707e-14
Cq1 ain_cos_n ain_isa_n 3.445e-17
Cq2 ain_cos_n ain_isa_p 4.604e-17
Cq3 ain_cos_n ibias 1.097e-16
Cq4 ain_cos_n sar_clka 2.933e-17
Cq5 ain_cos_n sar_clkab 2.933e-17
Cq6 ain_cos_n sar_clkna 2.933e-17
Cq7 ain_cos_n sar_clknab 2.946e-17
Cq8 ain_cos_n sar_cna0 4.649e-17
Cq9 ain_cos_n sar_cna1 4.481e-17
Cq10 ain_cos_n sar_cna10 4.578e-17
Cq11 ain_cos_n sar_cna11 4.578e-17
Cq12 ain_cos_n sar_cna12 4.578e-17
Cq13 ain_cos_n sar_cna2 3.756e-17
Cq14 ain_cos_n sar_cna3 3.984e-17
Cq15 ain_cos_n sar_cna4 4.481e-17
Cq16 ain_cos_n sar_cna5 4.481e-17
Cq17 ain_cos_n sar_cna6 4.537e-17
Cq18 ain_cos_n sar_cna7 4.802e-17
Cq19 ain_cos_n sar_cna8 4.746e-17
Cq20 ain_cos_n sar_cna9 4.578e-17
Cq21 ain_cos_n sar_cpa0 4.649e-17
Cq22 ain_cos_n sar_cpa1 4.537e-17
Cq23 ain_cos_n sar_cpa10 4.578e-17
Cq24 ain_cos_n sar_cpa11 4.578e-17
Cq25 ain_cos_n sar_cpa12 4.578e-17
Cq26 ain_cos_n sar_cpa2 4.337e-17
Cq27 ain_cos_n sar_cpa3 3.579e-17
Cq28 ain_cos_n sar_cpa4 4.337e-17
Cq29 ain_cos_n sar_cpa5 4.634e-17
Cq30 ain_cos_n sar_cpa6 4.481e-17
Cq31 ain_cos_n sar_cpa7 4.649e-17
Cq32 ain_cos_n sar_cpa8 4.746e-17
Cq33 ain_cos_n sar_cpa9 4.578e-17
Cq34 ain_cos_n sar_oan 4.184e-17
Cq35 ain_cos_n sar_oann 4.384e-17
Cq36 ain_cos_n sar_oanp 4.649e-17
Cq37 ain_cos_n sar_oap 3.459e-17
Cq38 ain_cos_n sar_trka0 5.23e-17
Cq39 ain_cos_n sar_trka1 4.808e-17
Cq40 ain_cos_n sar_trkb0 1.443e-17
Cq41 ain_cos_n vdd 3.063e-15
Cq42 ain_cos_n vss 3.507e-14
Cq43 ain_cos_n xckg_d0 4.043e-19
Cq44 ain_cos_n xckg_d1 7.338e-19
Cq45 ain_cos_n xckg_d2 8.525e-19
Cq46 ain_cos_n xckg_d3 1.362e-18
Cq47 ain_cos_n xckg_x 2.674e-17
Cq48 ain_cos_p ain_isa_n 3.424e-17
Cq49 ain_cos_p ain_isa_p 4.84e-17
Cq50 ain_cos_p ibias 2.317e-16
Cq51 ain_cos_p sar_clka 2.933e-17
Cq52 ain_cos_p sar_clkab 2.933e-17
Cq53 ain_cos_p sar_clkna 2.933e-17
Cq54 ain_cos_p sar_clknab 2.951e-17
Cq55 ain_cos_p sar_cna0 4.649e-17
Cq56 ain_cos_p sar_cna1 4.481e-17
Cq57 ain_cos_p sar_cna10 4.578e-17
Cq58 ain_cos_p sar_cna11 4.578e-17
Cq59 ain_cos_p sar_cna12 4.578e-17
Cq60 ain_cos_p sar_cna2 3.756e-17
Cq61 ain_cos_p sar_cna3 3.984e-17
Cq62 ain_cos_p sar_cna4 4.481e-17
Cq63 ain_cos_p sar_cna5 4.481e-17
Cq64 ain_cos_p sar_cna6 4.537e-17
Cq65 ain_cos_p sar_cna7 4.802e-17
Cq66 ain_cos_p sar_cna8 4.746e-17
Cq67 ain_cos_p sar_cna9 4.578e-17
Cq68 ain_cos_p sar_cpa0 4.649e-17
Cq69 ain_cos_p sar_cpa1 4.537e-17
Cq70 ain_cos_p sar_cpa10 4.578e-17
Cq71 ain_cos_p sar_cpa11 4.578e-17
Cq72 ain_cos_p sar_cpa12 4.578e-17
Cq73 ain_cos_p sar_cpa2 4.337e-17
Cq74 ain_cos_p sar_cpa3 3.788e-17
Cq75 ain_cos_p sar_cpa4 4.337e-17
Cq76 ain_cos_p sar_cpa5 4.634e-17
Cq77 ain_cos_p sar_cpa6 4.481e-17
Cq78 ain_cos_p sar_cpa7 4.649e-17
Cq79 ain_cos_p sar_cpa8 4.746e-17
Cq80 ain_cos_p sar_cpa9 4.578e-17
Cq81 ain_cos_p sar_oan 4.184e-17
Cq82 ain_cos_p sar_oann 4.384e-17
Cq83 ain_cos_p sar_oanp 4.649e-17
Cq84 ain_cos_p sar_oap 3.459e-17
Cq85 ain_cos_p sar_trka0 5.315e-17
Cq86 ain_cos_p sar_trka1 4.808e-17
Cq87 ain_cos_p sar_trkb0 4.662e-19
Cq88 ain_cos_p vdd 2.211e-15
Cq89 ain_cos_p vss 3.544e-14
Cq90 ain_cos_p xckg_d3 3.348e-19
Cq91 ain_cos_p xckg_x 2.003e-17
Cq92 ain_isa_n ain_isa_p 2.783e-14
Cq93 ain_isa_n ain_isb_n 6.15e-17
Cq94 ain_isa_n ain_isb_p 6.417e-17
Cq95 ain_isa_n sar_clkb 4.864e-17
Cq96 ain_isa_n sar_clkbb 4.746e-17
Cq97 ain_isa_n sar_clknab 9.415e-19
Cq98 ain_isa_n sar_clknb 4.184e-17
Cq99 ain_isa_n sar_clknbb 2.965e-17
Cq100 ain_isa_n sar_cnb0 4.649e-17
Cq101 ain_isa_n sar_cnb1 4.481e-17
Cq102 ain_isa_n sar_cnb10 4.578e-17
Cq103 ain_isa_n sar_cnb11 4.578e-17
Cq104 ain_isa_n sar_cnb12 4.578e-17
Cq105 ain_isa_n sar_cnb2 3.756e-17
Cq106 ain_isa_n sar_cnb3 3.984e-17
Cq107 ain_isa_n sar_cnb4 4.481e-17
Cq108 ain_isa_n sar_cnb5 4.481e-17
Cq109 ain_isa_n sar_cnb6 4.537e-17
Cq110 ain_isa_n sar_cnb7 4.802e-17
Cq111 ain_isa_n sar_cnb8 4.746e-17
Cq112 ain_isa_n sar_cnb9 4.578e-17
Cq113 ain_isa_n sar_cpb0 4.649e-17
Cq114 ain_isa_n sar_cpb1 4.537e-17
Cq115 ain_isa_n sar_cpb10 4.578e-17
Cq116 ain_isa_n sar_cpb11 4.578e-17
Cq117 ain_isa_n sar_cpb12 4.578e-17
Cq118 ain_isa_n sar_cpb2 4.537e-17
Cq119 ain_isa_n sar_cpb3 4.024e-17
Cq120 ain_isa_n sar_cpb4 4.337e-17
Cq121 ain_isa_n sar_cpb5 4.634e-17
Cq122 ain_isa_n sar_cpb6 4.481e-17
Cq123 ain_isa_n sar_cpb7 4.649e-17
Cq124 ain_isa_n sar_cpb8 4.746e-17
Cq125 ain_isa_n sar_cpb9 4.578e-17
Cq126 ain_isa_n sar_obn 4.184e-17
Cq127 ain_isa_n sar_obnn 4.481e-17
Cq128 ain_isa_n sar_obnp 4.649e-17
Cq129 ain_isa_n sar_obp 3.459e-17
Cq130 ain_isa_n sar_trkb0 4.883e-17
Cq131 ain_isa_n sar_trkb1 4.833e-17
Cq132 ain_isa_n vdd 8.828e-17
Cq133 ain_isa_n vss 3.302e-14
Cq134 ain_isa_p ain_isb_n 7.645e-17
Cq135 ain_isa_p ain_isb_p 7.912e-17
Cq136 ain_isa_p sar_clkb 4.864e-17
Cq137 ain_isa_p sar_clkbb 4.746e-17
Cq138 ain_isa_p sar_clknab 7.019e-19
Cq139 ain_isa_p sar_clknb 4.184e-17
Cq140 ain_isa_p sar_clknbb 3.499e-17
Cq141 ain_isa_p sar_cnb0 4.649e-17
Cq142 ain_isa_p sar_cnb1 4.481e-17
Cq143 ain_isa_p sar_cnb10 4.578e-17
Cq144 ain_isa_p sar_cnb11 4.578e-17
Cq145 ain_isa_p sar_cnb12 4.578e-17
Cq146 ain_isa_p sar_cnb2 3.756e-17
Cq147 ain_isa_p sar_cnb3 3.984e-17
Cq148 ain_isa_p sar_cnb4 4.481e-17
Cq149 ain_isa_p sar_cnb5 4.481e-17
Cq150 ain_isa_p sar_cnb6 4.537e-17
Cq151 ain_isa_p sar_cnb7 4.802e-17
Cq152 ain_isa_p sar_cnb8 4.746e-17
Cq153 ain_isa_p sar_cnb9 4.578e-17
Cq154 ain_isa_p sar_cpb0 4.649e-17
Cq155 ain_isa_p sar_cpb1 4.537e-17
Cq156 ain_isa_p sar_cpb10 4.578e-17
Cq157 ain_isa_p sar_cpb11 4.578e-17
Cq158 ain_isa_p sar_cpb12 4.578e-17
Cq159 ain_isa_p sar_cpb2 4.537e-17
Cq160 ain_isa_p sar_cpb3 4.047e-17
Cq161 ain_isa_p sar_cpb4 4.337e-17
Cq162 ain_isa_p sar_cpb5 4.634e-17
Cq163 ain_isa_p sar_cpb6 4.481e-17
Cq164 ain_isa_p sar_cpb7 4.649e-17
Cq165 ain_isa_p sar_cpb8 4.746e-17
Cq166 ain_isa_p sar_cpb9 4.578e-17
Cq167 ain_isa_p sar_mclk 2.531e-18
Cq168 ain_isa_p sar_obn 4.184e-17
Cq169 ain_isa_p sar_obnn 4.481e-17
Cq170 ain_isa_p sar_obnp 4.649e-17
Cq171 ain_isa_p sar_obp 3.459e-17
Cq172 ain_isa_p sar_trkb0 5.684e-17
Cq173 ain_isa_p sar_trkb1 4.833e-17
Cq174 ain_isa_p vdd 1.13e-16
Cq175 ain_isa_p vss 3.362e-14
Cq176 ain_isb_n ain_isb_p 7.431e-17
Cq177 ain_isb_n vss 9.265e-16
Cq178 ain_isb_p vss 8.611e-16
Cq179 ain_sin_n ain_sin_p 8.625e-17
Cq180 ain_sin_n ibias 9.686e-17
Cq181 ain_sin_n vss 7.977e-16
Cq182 ain_sin_p ibias 9.686e-17
Cq183 ain_sin_p vss 7.924e-16
Cq184 clk mclkb 1.252e-18
Cq185 clk sar_clka 3.704e-17
Cq186 clk sar_clkab 2.773e-17
Cq187 clk sar_clkna 3.212e-17
Cq188 clk sar_clknab 4.043e-18
Cq189 clk sar_cna0 4.953e-17
Cq190 clk sar_cna1 4.301e-17
Cq191 clk sar_cna10 4.59e-17
Cq192 clk sar_cna11 4.59e-17
Cq193 clk sar_cna12 4.443e-17
Cq194 clk sar_cna2 3.644e-17
Cq195 clk sar_cna3 3.581e-17
Cq196 clk sar_cna4 4.301e-17
Cq197 clk sar_cna5 4.301e-17
Cq198 clk sar_cna6 4.534e-17
Cq199 clk sar_cna7 5.255e-17
Cq200 clk sar_cna8 5.168e-17
Cq201 clk sar_cna9 4.443e-17
Cq202 clk sar_cpa0 4.489e-17
Cq203 clk sar_cpa1 4.592e-17
Cq204 clk sar_cpa10 4.443e-17
Cq205 clk sar_cpa11 4.59e-17
Cq206 clk sar_cpa12 4.59e-17
Cq207 clk sar_cpa2 4.223e-17
Cq208 clk sar_cpa3 3.127e-17
Cq209 clk sar_cpa4 4.339e-17
Cq210 clk sar_cpa5 4.676e-17
Cq211 clk sar_cpa6 4.301e-17
Cq212 clk sar_cpa7 4.953e-17
Cq213 clk sar_cpa8 5.168e-17
Cq214 clk sar_cpa9 4.59e-17
Cq215 clk sar_mclk 4.18e-16
Cq216 clk sar_oan 3.87e-17
Cq217 clk sar_oann 4.086e-17
Cq218 clk sar_oanp 4.931e-17
Cq219 clk sar_oap 3.067e-17
Cq220 clk sar_trka0 6.343e-17
Cq221 clk sar_trka1 5.755e-17
Cq222 clk vdd 1.554e-15
Cq223 clk vss 2.921e-14
Cq224 clk xckg_d0 3.206e-16
Cq225 clk xckg_d1 1.883e-16
Cq226 clk xckg_d2 1.491e-16
Cq227 clk xckg_d3 2.541e-16
Cq228 clk xckg_nn 2.492e-17
Cq229 clk xckg_x 3.281e-16
Cq230 ibias sar_trka0 1.287e-17
Cq231 ibias vbn 2.266e-15
Cq232 ibias vbp 6.102e-17
Cq233 ibias vdd 4.502e-15
Cq234 ibias vdda 2.216e-16
Cq235 ibias vref 4.11e-14
Cq236 ibias vref_in 9.847e-15
Cq237 ibias vrefl 1.687e-14
Cq238 ibias vss 1.681e-13
Cq239 ibias xref_ng 2.101e-15
Cq240 ibias xref_ntl 1.737e-16
Cq241 mclkb sar_clknab 4.044e-17
Cq242 mclkb sar_mclk 2.778e-16
Cq243 mclkb sar_trkb0 2.442e-18
Cq244 mclkb vdd 1.741e-15
Cq245 mclkb vss 5.564e-15
Cq246 mclkb xckg_d0 1.25e-15
Cq247 mclkb xckg_d1 2.7e-16
Cq248 mclkb xckg_d2 2.182e-16
Cq249 mclkb xckg_d3 1.483e-17
Cq250 mclkb xckg_nn 2.576e-17
Cq251 mclkb xckg_x 1.907e-17
Cq252 sar_clka sar_trka1 4.996e-17
Cq253 sar_clka vdd 5.939e-18
Cq254 sar_clka vss 4.415e-15
Cq255 sar_clkab sar_mclk 3.485e-17
Cq256 sar_clkab sar_oann 9.641e-17
Cq257 sar_clkab vdd 5.391e-18
Cq258 sar_clkab vss 4.557e-15
Cq259 sar_clkb sar_trkb1 1.541e-16
Cq260 sar_clkb vdd 9.721e-18
Cq261 sar_clkb vss 1.963e-15
Cq262 sar_clkbb sar_obnn 3.064e-16
Cq263 sar_clkbb sar_obnp 3.919e-19
Cq264 sar_clkbb vdd 6.807e-18
Cq265 sar_clkbb vss 1.715e-15
Cq266 sar_clkna sar_cpa2 1.689e-16
Cq267 sar_clkna sar_cpa3 7.355e-16
Cq268 sar_clkna sar_cpa4 1.185e-17
Cq269 sar_clkna sar_mclk 3.502e-17
Cq270 sar_clkna vdd 5.939e-18
Cq271 sar_clkna vss 3.965e-15
Cq272 sar_clknab sar_mclk 1.264e-16
Cq273 sar_clknab vdd 1.914e-16
Cq274 sar_clknab vss 4.193e-15
Cq275 sar_clknab xckg_x 7.189e-17
Cq276 sar_clknb sar_cpb1 2.496e-19
Cq277 sar_clknb sar_cpb2 4.387e-16
Cq278 sar_clknb sar_cpb3 1.131e-15
Cq279 sar_clknb sar_cpb4 6.245e-19
Cq280 sar_clknb sar_cpb5 4.845e-18
Cq281 sar_clknb vdd 6.26e-18
Cq282 sar_clknb vss 1.056e-15
Cq283 sar_clknbb vss 4.526e-15
Cq284 sar_cna0 sar_cna1 4.187e-16
Cq285 sar_cna0 sar_mclk 5.35e-17
Cq286 sar_cna0 vdd 5.939e-18
Cq287 sar_cna0 vss 2e-15
Cq288 sar_cna1 sar_cna2 3.064e-16
Cq289 sar_cna1 sar_mclk 5.151e-17
Cq290 sar_cna1 vdd 5.391e-18
Cq291 sar_cna1 vss 1.682e-15
Cq292 sar_cna10 sar_cna11 2.981e-16
Cq293 sar_cna10 sar_cna9 3.064e-16
Cq294 sar_cna10 sar_mclk 5.273e-17
Cq295 sar_cna10 vdd 5.939e-18
Cq296 sar_cna10 vss 1.797e-15
Cq297 sar_cna11 sar_cna12 3.064e-16
Cq298 sar_cna11 sar_mclk 5.273e-17
Cq299 sar_cna11 vdd 5.939e-18
Cq300 sar_cna11 vss 1.797e-15
Cq301 sar_cna12 sar_cpa12 3.064e-16
Cq302 sar_cna12 sar_mclk 5.238e-17
Cq303 sar_cna12 vdd 4.844e-18
Cq304 sar_cna12 vss 1.756e-15
Cq305 sar_cna2 sar_mclk 4.37e-17
Cq306 sar_cna2 sar_oap 2.214e-15
Cq307 sar_cna2 vdd 5.391e-18
Cq308 sar_cna2 vss 1.347e-15
Cq309 sar_cna3 sar_mclk 4.634e-17
Cq310 sar_cna3 sar_oan 8.01e-16
Cq311 sar_cna3 sar_oap 7.036e-16
Cq312 sar_cna3 vdd 5.939e-18
Cq313 sar_cna3 vss 1.328e-15
Cq314 sar_cna4 sar_cna5 3.064e-16
Cq315 sar_cna4 sar_mclk 5.151e-17
Cq316 sar_cna4 sar_oan 4.187e-16
Cq317 sar_cna4 vdd 5.391e-18
Cq318 sar_cna4 vss 1.682e-15
Cq319 sar_cna5 sar_cna6 4.187e-16
Cq320 sar_cna5 sar_mclk 5.151e-17
Cq321 sar_cna5 vdd 5.391e-18
Cq322 sar_cna5 vss 1.682e-15
Cq323 sar_cna6 sar_cna7 2.361e-16
Cq324 sar_cna6 sar_mclk 5.229e-17
Cq325 sar_cna6 vdd 5.939e-18
Cq326 sar_cna6 vss 1.777e-15
Cq327 sar_cna7 sar_mclk 5.497e-17
Cq328 sar_cna7 vdd 5.391e-18
Cq329 sar_cna7 vss 2.151e-15
Cq330 sar_cna8 sar_cna9 3.064e-16
Cq331 sar_cna8 sar_mclk 5.454e-17
Cq332 sar_cna8 vdd 5.939e-18
Cq333 sar_cna8 vss 2.09e-15
Cq334 sar_cna9 sar_mclk 5.238e-17
Cq335 sar_cna9 vdd 4.844e-18
Cq336 sar_cna9 vss 1.756e-15
Cq337 sar_cnb0 sar_cnb1 4.047e-16
Cq338 sar_cnb0 sar_cnb2 3.919e-19
Cq339 sar_cnb0 sar_cnb3 3.99e-18
Cq340 sar_cnb0 sar_obp 2.496e-19
Cq341 sar_cnb0 vdd 8.551e-18
Cq342 sar_cnb0 vss 1.677e-15
Cq343 sar_cnb1 sar_cnb2 3.064e-16
Cq344 sar_cnb1 sar_cnb3 2.688e-19
Cq345 sar_cnb1 vdd 5.712e-18
Cq346 sar_cnb1 vss 1.327e-15
Cq347 sar_cnb10 sar_cnb11 2.978e-16
Cq348 sar_cnb10 sar_cnb12 2.496e-19
Cq349 sar_cnb10 sar_cnb8 2.496e-19
Cq350 sar_cnb10 sar_cnb9 2.879e-16
Cq351 sar_cnb10 vdd 8.551e-18
Cq352 sar_cnb10 vss 1.483e-15
Cq353 sar_cnb11 sar_cnb12 3.064e-16
Cq354 sar_cnb11 sar_cnb9 5.494e-18
Cq355 sar_cnb11 sar_cpb12 2.496e-19
Cq356 sar_cnb11 vdd 6.26e-18
Cq357 sar_cnb11 vss 1.418e-15
Cq358 sar_cnb12 sar_cpb11 5.494e-18
Cq359 sar_cnb12 sar_cpb12 2.978e-16
Cq360 sar_cnb12 vdd 6.26e-18
Cq361 sar_cnb12 vss 1.418e-15
Cq362 sar_cnb2 sar_cnb3 1.939e-18
Cq363 sar_cnb2 sar_obp 2.249e-15
Cq364 sar_cnb2 vdd 6.807e-18
Cq365 sar_cnb2 vss 1.063e-15
Cq366 sar_cnb3 sar_cnb4 5.334e-19
Cq367 sar_cnb3 sar_cnb5 1.521e-19
Cq368 sar_cnb3 sar_obn 7.769e-16
Cq369 sar_cnb3 sar_obp 6.642e-16
Cq370 sar_cnb3 vdd 9.721e-18
Cq371 sar_cnb3 vss 1.11e-15
Cq372 sar_cnb4 sar_cnb5 3.064e-16
Cq373 sar_cnb4 sar_cnb6 2.688e-19
Cq374 sar_cnb4 sar_obn 4.558e-16
Cq375 sar_cnb4 vdd 5.712e-18
Cq376 sar_cnb4 vss 1.294e-15
Cq377 sar_cnb5 sar_cnb6 3.976e-16
Cq378 sar_cnb5 sar_cnb7 5.494e-18
Cq379 sar_cnb5 vdd 6.807e-18
Cq380 sar_cnb5 vss 1.363e-15
Cq381 sar_cnb6 sar_cnb7 2.371e-16
Cq382 sar_cnb6 sar_obn 1.389e-19
Cq383 sar_cnb6 vdd 9.721e-18
Cq384 sar_cnb6 vss 1.495e-15
Cq385 sar_cnb7 vdd 5.712e-18
Cq386 sar_cnb7 vss 1.754e-15
Cq387 sar_cnb8 sar_cnb9 3.064e-16
Cq388 sar_cnb8 vdd 6.26e-18
Cq389 sar_cnb8 vss 1.7e-15
Cq390 sar_cnb9 vdd 6.26e-18
Cq391 sar_cnb9 vss 1.427e-15
Cq392 sar_cpa0 sar_cpa1 4.187e-16
Cq393 sar_cpa0 sar_mclk 4.832e-17
Cq394 sar_cpa0 vdd 5.391e-18
Cq395 sar_cpa0 vss 2.217e-15
Cq396 sar_cpa0 xckg_d0 3.136e-18
Cq397 sar_cpa1 sar_cpa2 2.361e-16
Cq398 sar_cpa1 sar_cpa3 1.221e-19
Cq399 sar_cpa1 sar_mclk 5.229e-17
Cq400 sar_cpa1 vdd 5.939e-18
Cq401 sar_cpa1 vss 1.785e-15
Cq402 sar_cpa1 xckg_d0 1.203e-18
Cq403 sar_cpa10 sar_cpa11 3.064e-16
Cq404 sar_cpa10 sar_cpa9 3.064e-16
Cq405 sar_cpa10 sar_mclk 5.238e-17
Cq406 sar_cpa10 vdd 4.844e-18
Cq407 sar_cpa10 vss 1.756e-15
Cq408 sar_cpa11 sar_cpa12 2.981e-16
Cq409 sar_cpa11 sar_mclk 5.273e-17
Cq410 sar_cpa11 vdd 5.939e-18
Cq411 sar_cpa11 vss 1.797e-15
Cq412 sar_cpa12 sar_mclk 5.273e-17
Cq413 sar_cpa12 vdd 5.939e-18
Cq414 sar_cpa12 vss 1.797e-15
Cq415 sar_cpa2 sar_cpa3 6.567e-19
Cq416 sar_cpa2 sar_mclk 4.997e-17
Cq417 sar_cpa2 vdd 5.391e-18
Cq418 sar_cpa2 vss 2.126e-15
Cq419 sar_cpa3 sar_cpa4 6.012e-16
Cq420 sar_cpa3 sar_cpa5 3.174e-19
Cq421 sar_cpa3 sar_mclk 4.094e-17
Cq422 sar_cpa3 vdd 8.305e-18
Cq423 sar_cpa3 vss 2.792e-15
Cq424 sar_cpa4 sar_cpa5 2.361e-16
Cq425 sar_cpa4 sar_mclk 5.014e-17
Cq426 sar_cpa4 vdd 5.939e-18
Cq427 sar_cpa4 vss 1.697e-15
Cq428 sar_cpa5 sar_cpa6 3.064e-16
Cq429 sar_cpa5 sar_mclk 5.316e-17
Cq430 sar_cpa5 vdd 5.391e-18
Cq431 sar_cpa5 vss 1.851e-15
Cq432 sar_cpa6 sar_cpa7 4.187e-16
Cq433 sar_cpa6 sar_mclk 5.151e-17
Cq434 sar_cpa6 vdd 5.391e-18
Cq435 sar_cpa6 vss 1.682e-15
Cq436 sar_cpa7 sar_mclk 5.35e-17
Cq437 sar_cpa7 vdd 5.939e-18
Cq438 sar_cpa7 vss 2e-15
Cq439 sar_cpa8 sar_cpa9 2.981e-16
Cq440 sar_cpa8 sar_mclk 5.454e-17
Cq441 sar_cpa8 vdd 5.939e-18
Cq442 sar_cpa8 vss 2.097e-15
Cq443 sar_cpa9 sar_mclk 5.273e-17
Cq444 sar_cpa9 vdd 5.939e-18
Cq445 sar_cpa9 vss 1.797e-15
Cq446 sar_cpb0 sar_cpb1 4.047e-16
Cq447 sar_cpb0 sar_cpb2 5.494e-18
Cq448 sar_cpb0 vdd 5.712e-18
Cq449 sar_cpb0 vss 1.612e-15
Cq450 sar_cpb1 sar_cpb2 2.289e-16
Cq451 sar_cpb1 sar_cpb3 4.295e-18
Cq452 sar_cpb1 vdd 8.551e-18
Cq453 sar_cpb1 vss 1.468e-15
Cq454 sar_cpb10 sar_cpb11 3.064e-16
Cq455 sar_cpb10 sar_cpb12 2.496e-19
Cq456 sar_cpb10 sar_cpb8 5.494e-18
Cq457 sar_cpb10 sar_cpb9 2.978e-16
Cq458 sar_cpb10 vdd 6.26e-18
Cq459 sar_cpb10 vss 1.418e-15
Cq460 sar_cpb11 sar_cpb12 2.879e-16
Cq461 sar_cpb11 sar_cpb9 2.496e-19
Cq462 sar_cpb11 vdd 6.26e-18
Cq463 sar_cpb11 vss 1.427e-15
Cq464 sar_cpb12 vdd 8.551e-18
Cq465 sar_cpb12 vss 1.483e-15
Cq466 sar_cpb2 sar_cpb3 7.915e-19
Cq467 sar_cpb2 vdd 6.807e-18
Cq468 sar_cpb2 vss 1.411e-15
Cq469 sar_cpb3 sar_cpb4 6.208e-16
Cq470 sar_cpb3 sar_cpb5 2.003e-19
Cq471 sar_cpb3 vdd 8.626e-18
Cq472 sar_cpb3 vss 1.109e-15
Cq473 sar_cpb4 sar_cpb5 2.289e-16
Cq474 sar_cpb4 vdd 8.551e-18
Cq475 sar_cpb4 vss 1.383e-15
Cq476 sar_cpb5 sar_cpb6 3.064e-16
Cq477 sar_cpb5 sar_cpb7 3.919e-19
Cq478 sar_cpb5 vdd 6.807e-18
Cq479 sar_cpb5 vss 1.507e-15
Cq480 sar_cpb6 sar_cpb7 4.047e-16
Cq481 sar_cpb6 vdd 5.712e-18
Cq482 sar_cpb6 vss 1.327e-15
Cq483 sar_cpb7 vdd 8.551e-18
Cq484 sar_cpb7 vss 1.678e-15
Cq485 sar_cpb8 sar_cpb9 2.879e-16
Cq486 sar_cpb8 vdd 6.26e-18
Cq487 sar_cpb8 vss 1.715e-15
Cq488 sar_cpb9 vdd 8.551e-18
Cq489 sar_cpb9 vss 1.484e-15
Cq490 sar_mclk sar_oan 4.849e-17
Cq491 sar_mclk sar_oann 5.047e-17
Cq492 sar_mclk sar_oanp 5.344e-17
Cq493 sar_mclk sar_oap 4.033e-17
Cq494 sar_mclk vdd 9.835e-16
Cq495 sar_mclk vss 5.569e-14
Cq496 sar_mclk xckg_d0 2.428e-16
Cq497 sar_mclk xckg_d1 2.372e-16
Cq498 sar_mclk xckg_d2 3.312e-16
Cq499 sar_mclk xckg_d3 2.272e-16
Cq500 sar_mclk xckg_nn 3.925e-16
Cq501 sar_mclk xckg_x 2.915e-16
Cq502 sar_oan vdd 5.939e-18
Cq503 sar_oan vss 1.46e-15
Cq504 sar_oann sar_oanp 4.187e-16
Cq505 sar_oann vdd 5.391e-18
Cq506 sar_oann vss 1.911e-15
Cq507 sar_oanp vdd 5.939e-18
Cq508 sar_oanp vss 2.018e-15
Cq509 sar_oap vdd 4.844e-18
Cq510 sar_oap vss 1.109e-15
Cq511 sar_obn sar_obp 1.052e-17
Cq512 sar_obn vdd 8.116e-18
Cq513 sar_obn vss 1.165e-15
Cq514 sar_obnn sar_obnp 4.047e-16
Cq515 sar_obnn vdd 5.712e-18
Cq516 sar_obnn vss 1.327e-15
Cq517 sar_obnp vdd 8.551e-18
Cq518 sar_obnp vss 1.678e-15
Cq519 sar_obp vdd 6.26e-18
Cq520 sar_obp vss 8.685e-16
Cq521 sar_trka0 sar_trka1 1.399e-16
Cq522 sar_trka0 vss 2.19e-15
Cq523 sar_trka1 vss 2.16e-15
Cq524 sar_trkb0 sar_trkb1 1.399e-16
Cq525 sar_trkb0 vdd 9.908e-17
Cq526 sar_trkb0 vss 1.928e-15
Cq527 sar_trkb1 vdd 5.712e-18
Cq528 sar_trkb1 vss 1.802e-15
Cq529 vbn vbp 2.899e-14
Cq530 vbn vdd 2.028e-15
Cq531 vbn vdda 5.091e-17
Cq532 vbn vref 1.786e-14
Cq533 vbn vref_in 4.127e-15
Cq534 vbn vrefl 2.52e-14
Cq535 vbn vss 1.155e-14
Cq536 vbn xref_na 7.746e-19
Cq537 vbn xref_ng 1.886e-15
Cq538 vbp vdd 1.803e-15
Cq539 vbp vdda 8.761e-15
Cq540 vbp vref 1.878e-14
Cq541 vbp vref_in 4.205e-15
Cq542 vbp vrefl 1.08e-14
Cq543 vbp vss 1.857e-14
Cq544 vbp xref_na 9.789e-18
Cq545 vbp xref_ng 2.371e-15
Cq546 vdd vdda 5.954e-16
Cq547 vdd vref 1.718e-13
Cq548 vdd vref_in 4.013e-14
Cq549 vdd vrefl 5.877e-14
Cq550 vdd vss 1.157e-13
Cq551 vdd xckg_d0 2.688e-16
Cq552 vdd xckg_d1 2.766e-16
Cq553 vdd xckg_d2 3.357e-16
Cq554 vdd xckg_d3 4.504e-16
Cq555 vdd xckg_nn 2.848e-18
Cq556 vdd xckg_x 4.879e-16
Cq557 vdd xref_ng 2.468e-14
Cq558 vdda vref 4.398e-14
Cq559 vdda vref_in 3.223e-16
Cq560 vdda vrefl 2.519e-14
Cq561 vdda vss 3.507e-14
Cq562 vdda xref_na 1.249e-15
Cq563 vdda xref_ng 2.299e-14
Cq564 vdda xref_ntl 9.96e-18
Cq565 vref vref_in 4.54e-14
Cq566 vref vrefl 1.67e-13
Cq567 vref vss 3.743e-13
Cq568 vref xref_na 1.322e-16
Cq569 vref xref_ng 4.971e-14
Cq570 vref xref_ntl 1.685e-15
Cq571 vref_in vrefl 3.08e-14
Cq572 vref_in vss 9.388e-14
Cq573 vref_in xref_na 4.042e-16
Cq574 vref_in xref_ng 3.421e-15
Cq575 vref_in xref_ntl 1.606e-15
Cq576 vrefl vss 1.926e-13
Cq577 vrefl xref_na 1.039e-16
Cq578 vrefl xref_ng 3.178e-14
Cq579 vrefl xref_ntl 2.185e-15
Cq580 vss xckg_d0 5.11e-15
Cq581 vss xckg_d1 4.339e-15
Cq582 vss xckg_d2 6.346e-15
Cq583 vss xckg_d3 8.13e-15
Cq584 vss xckg_nn 1.937e-15
Cq585 vss xckg_x 6.625e-15
Cq586 vss xref_na 4.437e-15
Cq587 vss xref_ng 8.769e-14
Cq588 vss xref_ntl 3.71e-15
Cq589 xckg_d0 xckg_d1 3.909e-15
Cq590 xckg_d0 xckg_d2 1.218e-15
Cq591 xckg_d0 xckg_d3 1.494e-17
Cq592 xckg_d0 xckg_nn 5.565e-16
Cq593 xckg_d0 xckg_x 4.057e-17
Cq594 xckg_d1 xckg_d2 3.755e-15
Cq595 xckg_d1 xckg_d3 3.433e-17
Cq596 xckg_d1 xckg_nn 6.939e-18
Cq597 xckg_d1 xckg_x 1.218e-17
Cq598 xckg_d2 xckg_d3 6.227e-16
Cq599 xckg_d2 xckg_nn 1.283e-16
Cq600 xckg_d2 xckg_x 1.227e-16
Cq601 xckg_d3 xckg_nn 3.139e-18
Cq602 xckg_d3 xckg_x 4.209e-15
Cq603 xckg_nn xckg_x 6.716e-17
Cq604 xref_na xref_ng 2.554e-15
Cq605 xref_na xref_ntl 2.584e-16
Cq606 xref_ng xref_ntl 2.12e-15
.ends
