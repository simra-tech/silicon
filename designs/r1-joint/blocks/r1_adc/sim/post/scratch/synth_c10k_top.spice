* synthetic parasitics (make_synth_pex.py, seed 7): 2000 C, 0 RC ladders of 10
C0 vbp mclkb 0.0743f
C1 vrefl xref_na 0.154f
C2 vrefl clk 0.0749f
C3 xckg_d3 VSUBS 0.221f
C4 vdd VSUBS 0.251f
C5 vrefl VSUBS 0.209f
C6 xckg_d1 VSUBS 0.491f
C7 xcbias_xrb_s1 xckg_d2 0.384f
C8 xref_ntl xckg_nn 0.121f
C9 vbn VSUBS 0.155f
C10 xckg_nn VSUBS 0.0806f
C11 xref_ng xcbias_xrb_s2 0.127f
C12 vdda VSUBS 0.0414f
C13 xckg_d2 vref 0.192f
C14 xref_na VSUBS 0.0741f
C15 xckg_nn vref 0.408f
C16 sar_mclk xckg_x 0.17f
C17 vdd xcbiasn_xrb_s1 0.0397f
C18 ibias VSUBS 0.117f
C19 clk xref_na 0.329f
C20 xcbias_xrb_s3 xcbias_xrb_s1 0.118f
C21 vbn VSUBS 0.0664f
C22 clk xckg_d3 0.145f
C23 xcbias_xrb_s3 VSUBS 0.0819f
C24 vref_in vrefl 0.187f
C25 xckg_d2 xref_ng 0.347f
C26 mclkb VSUBS 0.155f
C27 xckg_d0 xref_na 0.0252f
C28 xckg_d2 VSUBS 0.0622f
C29 sar_mclk VSUBS 0.175f
C30 vbp VSUBS 0.271f
C31 xref_ng VSUBS 0.0398f
C32 vdd ibias 0.0798f
C33 xcbiasn_xrb_s3 xcbiasn_xrb_s2 0.362f
C34 vref VSUBS 0.197f
C35 xcbiasn_xrb_s1 xckg_d0 0.047f
C36 xcbias_xrb_s1 VSUBS 0.204f
C37 ibias xcbiasn_xrb_s2 0.128f
C38 vref_in VSUBS 0.204f
C39 xcbiasn_xrb_s3 VSUBS 0.0481f
C40 xref_ntl VSUBS 0.55f
C41 xckg_d2 VSUBS 0.121f
C42 clk VSUBS 0.123f
C43 xref_na VSUBS 0.0639f
C44 xckg_d1 xckg_nn 0.184f
C45 ibias vdd 0.316f
C46 xckg_d1 xcbiasn_xrb_s1 0.0158f
C47 xref_ntl VSUBS 0.123f
C48 vdd VSUBS 0.103f
C49 xcbiasn_xrb_s3 xcbias_xrb_s3 0.167f
C50 xckg_nn VSUBS 0.055f
C51 xckg_d2 VSUBS 0.0599f
C52 xcbias_xrb_s3 VSUBS 0.054f
C53 xref_ntl VSUBS 0.305f
C54 xref_ntl xcbias_xrb_s1 0.101f
C55 xckg_d2 VSUBS 0.206f
C56 vref xckg_x 0.0887f
C57 xcbiasn_xrb_s2 xckg_d1 1.01f
C58 xckg_x VSUBS 0.112f
C59 vrefl clk 0.0356f
C60 vref_in clk 0.19f
C61 xckg_d2 VSUBS 0.0503f
C62 xckg_d0 VSUBS 0.205f
C63 vrefl xcbias_xrb_s1 0.135f
C64 vbp VSUBS 0.0503f
C65 xref_ng VSUBS 0.0226f
C66 vrefl VSUBS 0.554f
C67 xckg_x xckg_d1 0.555f
C68 vdda xckg_d0 0.216f
C69 xref_ng vref_in 0.119f
C70 vref_in vbn 0.0584f
C71 vref VSUBS 0.22f
C72 xcbias_xrb_s2 VSUBS 0.132f
C73 vss VSUBS 0.209f
C74 vdda VSUBS 0.19f
C75 xckg_d1 VSUBS 0.0486f
C76 vdda VSUBS 0.185f
C77 vrefl xckg_d3 0.471f
C78 vss VSUBS 0.087f
C79 xcbias_xrb_s1 xcbias_xrb_s1 0.299f
C80 clk VSUBS 0.0422f
C81 xcbiasn_xrb_s1 VSUBS 0.396f
C82 vbp VSUBS 0.219f
C83 vbn xckg_x 0.0892f
C84 xckg_d0 vrefl 0.151f
C85 ibias VSUBS 0.162f
C86 vref VSUBS 0.597f
C87 xckg_d0 VSUBS 0.233f
C88 vdd vref 0.933f
C89 vbn VSUBS 0.263f
C90 mclkb VSUBS 0.3f
C91 xcbias_xrb_s3 VSUBS 0.0578f
C92 vref VSUBS 0.0745f
C93 xcbias_xrb_s2 VSUBS 0.0847f
C94 vref VSUBS 0.183f
C95 vbn VSUBS 0.179f
C96 vbp VSUBS 0.146f
C97 vref VSUBS 0.362f
C98 xckg_d1 VSUBS 0.119f
C99 vref_in VSUBS 0.355f
C100 xcbias_xrb_s3 xckg_x 0.251f
C101 xckg_nn VSUBS 0.103f
C102 sar_mclk VSUBS 0.0497f
C103 vdd vref 0.323f
C104 vref_in VSUBS 0.183f
C105 xref_na VSUBS 0.145f
C106 vbn xckg_nn 0.104f
C107 xckg_d1 VSUBS 0.129f
C108 vrefl VSUBS 0.0564f
C109 xckg_d2 VSUBS 0.0623f
C110 xckg_nn VSUBS 0.135f
C111 sar_mclk VSUBS 0.175f
C112 vss vbn 0.0884f
C113 clk vrefl 0.6f
C114 xckg_d2 VSUBS 0.157f
C115 xckg_d1 VSUBS 0.14f
C116 xckg_d0 xcbias_xrb_s1 0.102f
C117 xcbias_xrb_s3 VSUBS 0.116f
C118 vdd VSUBS 0.0566f
C119 sar_mclk xcbias_xrb_s3 0.476f
C120 vref VSUBS 0.0955f
C121 xcbiasn_xrb_s1 vdd 0.221f
C122 sar_mclk VSUBS 0.0424f
C123 xckg_d3 VSUBS 0.0818f
C124 xref_ng xckg_nn 0.0605f
C125 xref_ng xcbiasn_xrb_s1 0.0289f
C126 xcbias_xrb_s2 vbp 0.16f
C127 xref_na xckg_nn 0.178f
C128 xckg_d2 VSUBS 0.631f
C129 xcbiasn_xrb_s3 VSUBS 0.0712f
C130 xcbiasn_xrb_s1 xcbias_xrb_s2 0.0689f
C131 xckg_d0 VSUBS 0.0566f
C132 xcbias_xrb_s3 vdd 0.0574f
C133 xckg_d2 xckg_x 0.0859f
C134 vdd VSUBS 0.301f
C135 sar_mclk xckg_d3 0.083f
C136 vss VSUBS 0.144f
C137 xcbiasn_xrb_s1 xckg_d3 0.649f
C138 xckg_d3 VSUBS 0.605f
C139 vbn xckg_x 0.0305f
C140 ibias mclkb 0.236f
C141 xckg_d1 VSUBS 0.0613f
C142 xckg_d3 vdd 0.0168f
C143 vref_in VSUBS 0.133f
C144 xckg_x VSUBS 0.605f
C145 sar_mclk VSUBS 0.109f
C146 xcbiasn_xrb_s3 VSUBS 0.494f
C147 sar_mclk VSUBS 0.0376f
C148 vdda VSUBS 0.114f
C149 mclkb VSUBS 0.172f
C150 vss VSUBS 0.182f
C151 xckg_d3 vbp 0.201f
C152 xref_na VSUBS 0.185f
C153 xcbiasn_xrb_s2 VSUBS 0.152f
C154 xref_ng VSUBS 0.509f
C155 mclkb VSUBS 0.0421f
C156 xcbias_xrb_s3 vref_in 0.349f
C157 vss VSUBS 0.0947f
C158 xckg_d2 xckg_nn 0.104f
C159 xref_ntl VSUBS 1.11f
C160 xcbiasn_xrb_s3 ibias 0.102f
C161 ibias VSUBS 1.42f
C162 xckg_d0 VSUBS 0.0167f
C163 xcbias_xrb_s1 VSUBS 0.0748f
C164 vrefl VSUBS 0.173f
C165 vdda sar_mclk 0.2f
C166 xcbias_xrb_s3 VSUBS 0.495f
C167 vrefl vbp 0.188f
C168 xcbias_xrb_s2 VSUBS 0.0893f
C169 xckg_d1 VSUBS 0.177f
C170 xckg_d1 VSUBS 0.151f
C171 vref xckg_d3 0.224f
C172 mclkb VSUBS 0.107f
C173 vref_in VSUBS 0.158f
C174 vbp VSUBS 0.229f
C175 vdd VSUBS 0.0383f
C176 xcbias_xrb_s2 xckg_x 0.0797f
C177 vref VSUBS 0.142f
C178 vref VSUBS 0.12f
C179 sar_mclk VSUBS 0.238f
C180 vdd VSUBS 0.317f
C181 xckg_d1 VSUBS 0.15f
C182 xref_na xref_ng 0.182f
C183 xckg_d0 VSUBS 0.315f
C184 vref VSUBS 0.42f
C185 vbp xref_ntl 0.107f
C186 vdda VSUBS 0.102f
C187 xcbias_xrb_s1 VSUBS 0.166f
C188 vdda VSUBS 0.0736f
C189 xcbias_xrb_s2 vdda 0.333f
C190 sar_mclk VSUBS 0.287f
C191 vref_in VSUBS 0.0432f
C192 vref_in ibias 0.172f
C193 ibias VSUBS 0.126f
C194 ibias VSUBS 0.0934f
C195 mclkb VSUBS 0.291f
C196 xref_ntl VSUBS 0.0315f
C197 xckg_d0 VSUBS 0.591f
C198 xckg_d1 VSUBS 0.293f
C199 xcbias_xrb_s2 xcbias_xrb_s1 0.333f
C200 xcbiasn_xrb_s2 xcbias_xrb_s3 0.0818f
C201 xcbiasn_xrb_s2 xcbias_xrb_s3 0.0412f
C202 sar_mclk VSUBS 0.0773f
C203 xcbias_xrb_s3 xckg_d1 0.137f
C204 xckg_d2 VSUBS 0.36f
C205 xcbiasn_xrb_s2 VSUBS 0.0591f
C206 vss xckg_d0 0.48f
C207 xckg_d3 VSUBS 0.378f
C208 xcbiasn_xrb_s2 clk 0.25f
C209 sar_mclk VSUBS 0.376f
C210 vdda VSUBS 0.316f
C211 xref_na VSUBS 0.077f
C212 xref_ntl VSUBS 0.0285f
C213 vbp xref_ng 0.0272f
C214 mclkb vdd 0.301f
C215 xckg_d1 xckg_nn 0.0973f
C216 xckg_d2 xcbias_xrb_s2 0.156f
C217 xcbiasn_xrb_s2 xcbiasn_xrb_s1 0.0563f
C218 xckg_d0 xckg_d0 0.91f
C219 xckg_d0 xckg_d1 0.269f
C220 vref_in VSUBS 0.082f
C221 xcbiasn_xrb_s1 VSUBS 0.0687f
C222 xcbiasn_xrb_s2 xref_na 0.175f
C223 mclkb clk 0.115f
C224 xckg_nn VSUBS 0.163f
C225 xref_ng vbn 0.315f
C226 vbn VSUBS 0.164f
C227 xref_ntl xcbias_xrb_s2 0.146f
C228 mclkb xckg_nn 0.0471f
C229 vdd VSUBS 0.151f
C230 xcbias_xrb_s3 vbn 0.412f
C231 xcbias_xrb_s2 VSUBS 0.127f
C232 xckg_d2 VSUBS 0.236f
C233 vdda VSUBS 0.164f
C234 xcbias_xrb_s1 VSUBS 0.293f
C235 vref sar_mclk 0.174f
C236 vss xcbias_xrb_s1 0.132f
C237 vbp xcbias_xrb_s1 0.0732f
C238 ibias sar_mclk 0.339f
C239 xcbiasn_xrb_s3 xckg_d0 0.117f
C240 xckg_d1 VSUBS 0.137f
C241 xref_ng VSUBS 0.049f
C242 xckg_d2 xcbias_xrb_s3 0.584f
C243 vref_in VSUBS 0.058f
C244 xcbiasn_xrb_s2 VSUBS 0.201f
C245 clk VSUBS 0.247f
C246 vdd VSUBS 0.209f
C247 vbp VSUBS 0.225f
C248 xckg_d1 xckg_d0 0.161f
C249 xcbias_xrb_s1 vbp 0.118f
C250 xcbias_xrb_s1 VSUBS 0.121f
C251 vbp vdda 0.0954f
C252 xcbias_xrb_s2 VSUBS 0.589f
C253 vbp VSUBS 0.285f
C254 xckg_x VSUBS 0.193f
C255 vbp VSUBS 0.0576f
C256 vrefl VSUBS 0.0356f
C257 xref_na VSUBS 0.135f
C258 xcbiasn_xrb_s1 VSUBS 0.0773f
C259 ibias VSUBS 0.124f
C260 xckg_nn VSUBS 0.15f
C261 clk xcbias_xrb_s1 0.0672f
C262 vrefl VSUBS 0.115f
C263 xckg_d0 VSUBS 0.267f
C264 vref VSUBS 0.18f
C265 xckg_x VSUBS 0.0736f
C266 vref VSUBS 0.278f
C267 vbp VSUBS 0.103f
C268 xckg_x clk 0.0799f
C269 xckg_nn VSUBS 0.106f
C270 xref_na VSUBS 0.0493f
C271 xref_na vdda 0.246f
C272 clk xref_na 0.392f
C273 vbp VSUBS 0.159f
C274 xcbias_xrb_s3 VSUBS 0.145f
C275 xref_na vref 0.188f
C276 sar_mclk VSUBS 0.116f
C277 vss vbp 0.396f
C278 ibias xcbiasn_xrb_s2 0.128f
C279 ibias sar_mclk 0.103f
C280 xcbiasn_xrb_s1 vref 0.0515f
C281 xckg_d2 VSUBS 0.0413f
C282 xckg_d3 VSUBS 0.195f
C283 xref_ng VSUBS 0.0574f
C284 sar_mclk VSUBS 0.144f
C285 mclkb VSUBS 0.0132f
C286 xcbias_xrb_s3 VSUBS 0.0774f
C287 xckg_d0 xcbias_xrb_s2 0.128f
C288 xref_ng VSUBS 0.131f
C289 vrefl VSUBS 0.0872f
C290 xckg_nn VSUBS 0.305f
C291 vbp VSUBS 0.0537f
C292 xcbiasn_xrb_s3 vbp 0.336f
C293 vref vrefl 0.268f
C294 xref_ntl xckg_nn 0.105f
C295 xcbiasn_xrb_s1 VSUBS 0.162f
C296 xcbias_xrb_s1 ibias 0.258f
C297 xckg_d3 VSUBS 0.158f
C298 sar_mclk xcbias_xrb_s3 0.21f
C299 xref_ng xckg_d2 0.403f
C300 xckg_d1 vbp 0.173f
C301 vbn VSUBS 0.0533f
C302 xcbiasn_xrb_s1 VSUBS 0.432f
C303 ibias xcbias_xrb_s2 0.0442f
C304 xckg_x ibias 0.39f
C305 vrefl VSUBS 0.0433f
C306 vref VSUBS 0.0465f
C307 xckg_d1 vref 0.178f
C308 sar_mclk VSUBS 0.263f
C309 vbn VSUBS 0.746f
C310 xckg_d3 VSUBS 0.233f
C311 vrefl xckg_d0 0.183f
C312 xckg_nn VSUBS 0.0732f
C313 vbp xref_ng 0.0657f
C314 vref_in vdda 0.185f
C315 vbn VSUBS 0.0555f
C316 vbn VSUBS 0.0736f
C317 xref_na mclkb 0.416f
C318 vbp VSUBS 0.0594f
C319 xckg_d0 xcbias_xrb_s2 0.495f
C320 sar_mclk VSUBS 0.0561f
C321 vbn VSUBS 0.0581f
C322 sar_mclk VSUBS 0.0835f
C323 sar_mclk VSUBS 0.153f
C324 vss xckg_nn 0.19f
C325 vref_in VSUBS 0.153f
C326 xckg_d0 VSUBS 0.0519f
C327 vdda VSUBS 0.103f
C328 xref_na VSUBS 0.161f
C329 xref_ng xcbias_xrb_s3 0.323f
C330 xcbiasn_xrb_s1 xckg_d1 0.0573f
C331 xcbiasn_xrb_s2 VSUBS 0.156f
C332 sar_mclk VSUBS 0.422f
C333 xref_na VSUBS 0.304f
C334 vdda clk 0.19f
C335 xref_ntl VSUBS 0.382f
C336 vref_in xcbiasn_xrb_s2 0.0286f
C337 xcbiasn_xrb_s2 ibias 0.182f
C338 xckg_d3 VSUBS 0.344f
C339 xckg_d1 xcbias_xrb_s1 0.108f
C340 xckg_d0 vbn 0.0969f
C341 vbn xckg_d2 0.362f
C342 xckg_d1 VSUBS 0.215f
C343 xckg_nn VSUBS 0.228f
C344 xckg_d1 VSUBS 0.0804f
C345 xckg_nn xckg_d0 0.113f
C346 xckg_d0 clk 0.0659f
C347 vdd VSUBS 0.165f
C348 vref_in VSUBS 0.0502f
C349 vref xckg_d2 0.0705f
C350 vref VSUBS 0.00795f
C351 xckg_d3 VSUBS 0.115f
C352 xckg_nn VSUBS 0.039f
C353 vbn VSUBS 0.439f
C354 xcbias_xrb_s2 VSUBS 0.234f
C355 xckg_d1 VSUBS 0.212f
C356 xcbiasn_xrb_s1 VSUBS 0.0837f
C357 sar_mclk VSUBS 0.104f
C358 vref_in VSUBS 0.0235f
C359 clk VSUBS 0.0728f
C360 vref_in ibias 0.157f
C361 xref_ntl vrefl 0.0313f
C362 vrefl VSUBS 0.518f
C363 vdd VSUBS 0.0893f
C364 vdd vref_in 0.344f
C365 xcbias_xrb_s2 xckg_x 0.094f
C366 xcbias_xrb_s3 VSUBS 0.409f
C367 vref VSUBS 0.153f
C368 clk VSUBS 0.104f
C369 xcbiasn_xrb_s2 vref 0.155f
C370 mclkb xckg_d2 0.395f
C371 xcbias_xrb_s1 xckg_nn 0.0857f
C372 xckg_d0 vdda 0.22f
C373 xcbias_xrb_s3 VSUBS 0.0545f
C374 mclkb xcbias_xrb_s1 0.194f
C375 xckg_d0 VSUBS 0.0372f
C376 xckg_x VSUBS 0.091f
C377 xcbias_xrb_s1 xckg_nn 0.0739f
C378 xref_ntl VSUBS 0.326f
C379 vref_in VSUBS 0.262f
C380 vbp VSUBS 0.505f
C381 vdd VSUBS 1.63f
C382 xcbias_xrb_s2 VSUBS 0.238f
C383 vss VSUBS 0.228f
C384 xref_ng VSUBS 0.0473f
C385 xckg_d2 xref_ntl 0.0425f
C386 xref_ng xcbias_xrb_s1 0.353f
C387 xref_ng VSUBS 0.176f
C388 vss VSUBS 0.204f
C389 vdd VSUBS 0.0442f
C390 vref VSUBS 0.154f
C391 xref_na VSUBS 0.183f
C392 xcbiasn_xrb_s3 VSUBS 0.116f
C393 xckg_d1 xckg_nn 0.133f
C394 xcbiasn_xrb_s1 VSUBS 0.228f
C395 xcbias_xrb_s3 VSUBS 0.0864f
C396 vref_in VSUBS 0.0288f
C397 vdd xckg_nn 0.0251f
C398 xckg_d1 VSUBS 0.0334f
C399 xcbias_xrb_s1 VSUBS 0.139f
C400 xref_na xcbias_xrb_s2 0.421f
C401 mclkb VSUBS 0.0805f
C402 xckg_d1 VSUBS 0.0378f
C403 vref VSUBS 0.223f
C404 sar_mclk VSUBS 0.0759f
C405 xckg_d2 VSUBS 0.0474f
C406 xcbias_xrb_s2 VSUBS 0.101f
C407 xcbias_xrb_s2 VSUBS 0.447f
C408 xref_na VSUBS 0.179f
C409 vdd VSUBS 0.141f
C410 xcbiasn_xrb_s2 VSUBS 0.0438f
C411 xref_ng vdda 0.304f
C412 vdd VSUBS 0.195f
C413 xcbiasn_xrb_s1 VSUBS 0.491f
C414 xcbiasn_xrb_s3 VSUBS 0.115f
C415 xckg_d2 VSUBS 0.0922f
C416 xref_na VSUBS 0.131f
C417 vbn VSUBS 0.168f
C418 clk VSUBS 0.0849f
C419 clk VSUBS 0.124f
C420 vref VSUBS 0.476f
C421 xckg_x vref 0.34f
C422 vbp xckg_d3 0.307f
C423 xckg_nn VSUBS 0.265f
C424 xckg_nn sar_mclk 0.259f
C425 clk sar_mclk 0.0876f
C426 xcbiasn_xrb_s2 VSUBS 0.0673f
C427 ibias xckg_d2 0.22f
C428 vbp VSUBS 0.143f
C429 vdda VSUBS 0.131f
C430 vrefl VSUBS 0.558f
C431 xcbiasn_xrb_s1 VSUBS 0.155f
C432 xckg_d2 VSUBS 0.0941f
C433 xckg_d0 VSUBS 0.0935f
C434 vdda VSUBS 0.505f
C435 ibias VSUBS 0.204f
C436 xref_ntl VSUBS 0.399f
C437 xckg_nn VSUBS 0.34f
C438 vbp VSUBS 0.724f
C439 xcbiasn_xrb_s1 VSUBS 0.641f
C440 vbn xcbias_xrb_s1 0.0873f
C441 mclkb xcbiasn_xrb_s2 0.0939f
C442 ibias VSUBS 0.095f
C443 vref xcbias_xrb_s1 0.287f
C444 xcbiasn_xrb_s2 VSUBS 0.0643f
C445 vrefl VSUBS 0.757f
C446 xckg_d0 VSUBS 0.172f
C447 vrefl VSUBS 0.195f
C448 xckg_d0 VSUBS 0.0631f
C449 xckg_d1 VSUBS 0.0437f
C450 ibias ibias 0.273f
C451 vbn VSUBS 0.101f
C452 mclkb VSUBS 0.124f
C453 xcbias_xrb_s3 VSUBS 0.0258f
C454 xcbias_xrb_s2 VSUBS 0.245f
C455 vbn xckg_d3 0.389f
C456 xckg_d0 VSUBS 0.368f
C457 xcbias_xrb_s3 VSUBS 0.0968f
C458 xckg_d3 VSUBS 0.3f
C459 clk VSUBS 0.0482f
C460 xref_na VSUBS 0.0769f
C461 xref_ntl VSUBS 0.0412f
C462 xckg_d3 xckg_d0 0.0749f
C463 xcbias_xrb_s3 VSUBS 0.06f
C464 xref_ng VSUBS 0.378f
C465 clk xckg_d1 0.219f
C466 xcbiasn_xrb_s2 VSUBS 0.168f
C467 xref_na VSUBS 0.0468f
C468 mclkb VSUBS 0.115f
C469 vrefl xref_ng 0.224f
C470 sar_mclk xcbiasn_xrb_s1 0.0413f
C471 xcbiasn_xrb_s2 vdda 0.0979f
C472 vbn VSUBS 0.181f
C473 vbn VSUBS 0.0577f
C474 xcbias_xrb_s1 VSUBS 0.187f
C475 vss VSUBS 0.316f
C476 xcbiasn_xrb_s1 VSUBS 0.0314f
C477 xcbias_xrb_s3 VSUBS 0.189f
C478 vdd VSUBS 0.38f
C479 vrefl VSUBS 0.354f
C480 vdda VSUBS 0.0475f
C481 vdd VSUBS 0.0989f
C482 vdd vdda 0.655f
C483 xckg_nn vbn 0.0844f
C484 xref_na VSUBS 0.179f
C485 xcbiasn_xrb_s1 vbn 0.208f
C486 vss VSUBS 0.29f
C487 vbn VSUBS 0.53f
C488 vdd xckg_d2 0.0527f
C489 xckg_nn VSUBS 0.0874f
C490 vss vdda 0.103f
C491 xref_na VSUBS 0.196f
C492 xckg_d0 VSUBS 0.167f
C493 xckg_d2 xref_na 0.0838f
C494 xcbias_xrb_s2 VSUBS 0.343f
C495 vrefl VSUBS 0.0353f
C496 xcbias_xrb_s2 xcbiasn_xrb_s3 0.0901f
C497 xcbias_xrb_s2 VSUBS 0.108f
C498 clk VSUBS 0.0838f
C499 vbn vbp 0.123f
C500 vss VSUBS 0.122f
C501 xckg_d2 xcbiasn_xrb_s1 0.282f
C502 xcbiasn_xrb_s2 vbp 0.378f
C503 xref_na VSUBS 0.217f
C504 xcbiasn_xrb_s1 VSUBS 0.133f
C505 xckg_nn vbn 0.0289f
C506 xckg_d1 xref_ntl 0.15f
C507 vbn mclkb 0.158f
C508 xckg_d1 xcbiasn_xrb_s3 0.171f
C509 xckg_d0 VSUBS 0.0144f
C510 xref_ntl vbn 0.427f
C511 ibias VSUBS 0.0457f
C512 vbn vdda 0.119f
C513 xckg_d3 VSUBS 0.0337f
C514 xcbias_xrb_s1 VSUBS 0.0669f
C515 vdd xckg_d0 0.302f
C516 vdda VSUBS 0.133f
C517 xcbias_xrb_s1 VSUBS 0.104f
C518 vbn VSUBS 0.0492f
C519 xcbias_xrb_s1 VSUBS 0.0558f
C520 xckg_d3 xcbias_xrb_s1 0.039f
C521 vdd VSUBS 0.704f
C522 xcbiasn_xrb_s2 VSUBS 0.441f
C523 xref_ng VSUBS 0.264f
C524 xcbias_xrb_s3 vbp 0.306f
C525 clk VSUBS 0.179f
C526 xckg_d2 VSUBS 0.218f
C527 xcbiasn_xrb_s3 xckg_x 0.396f
C528 ibias xref_ng 0.0865f
C529 xcbiasn_xrb_s1 xcbiasn_xrb_s2 0.617f
C530 xref_ng xref_ntl 0.216f
C531 xckg_d3 xcbiasn_xrb_s1 0.222f
C532 vdd VSUBS 0.11f
C533 xckg_d3 xckg_x 0.202f
C534 xcbias_xrb_s1 VSUBS 0.147f
C535 xcbias_xrb_s2 VSUBS 0.374f
C536 xckg_d1 VSUBS 0.117f
C537 xref_ntl VSUBS 0.247f
C538 ibias xckg_d2 0.22f
C539 xckg_d3 VSUBS 0.126f
C540 vbn VSUBS 0.193f
C541 xref_ng VSUBS 0.133f
C542 xckg_x VSUBS 0.796f
C543 xref_ng VSUBS 0.319f
C544 vbn xckg_d0 0.146f
C545 xcbiasn_xrb_s2 VSUBS 0.0527f
C546 xckg_d3 VSUBS 0.136f
C547 vdd VSUBS 0.224f
C548 vref_in VSUBS 0.218f
C549 xcbiasn_xrb_s1 VSUBS 0.702f
C550 xcbiasn_xrb_s2 VSUBS 0.19f
C551 vbn VSUBS 0.0718f
C552 xckg_x VSUBS 0.0368f
C553 vdd vref 0.189f
C554 xckg_d2 VSUBS 0.255f
C555 vref VSUBS 0.0797f
C556 sar_mclk VSUBS 0.213f
C557 xckg_d1 xckg_x 0.16f
C558 xcbiasn_xrb_s1 VSUBS 0.163f
C559 vss xckg_d1 0.276f
C560 xcbiasn_xrb_s1 VSUBS 0.049f
C561 xref_ng VSUBS 0.161f
C562 xcbiasn_xrb_s1 VSUBS 0.412f
C563 xcbiasn_xrb_s2 VSUBS 0.901f
C564 xckg_d0 VSUBS 0.0267f
C565 xckg_nn VSUBS 0.11f
C566 xcbias_xrb_s3 xref_na 0.132f
C567 xckg_d0 vref_in 0.348f
C568 vbn VSUBS 0.529f
C569 vbp VSUBS 0.0893f
C570 xckg_x xckg_d0 0.021f
C571 vdd vdd 0.0818f
C572 clk VSUBS 0.254f
C573 xcbias_xrb_s1 VSUBS 0.0852f
C574 xckg_d1 VSUBS 0.142f
C575 xckg_d3 clk 0.0774f
C576 xckg_d3 xref_ng 0.128f
C577 xckg_x VSUBS 0.0722f
C578 vdda sar_mclk 0.258f
C579 vbp xcbias_xrb_s1 0.23f
C580 xcbias_xrb_s2 VSUBS 0.162f
C581 vbn VSUBS 0.0207f
C582 xcbiasn_xrb_s1 VSUBS 0.711f
C583 xref_ng VSUBS 0.136f
C584 xref_ntl VSUBS 0.337f
C585 vrefl xref_ntl 0.264f
C586 xckg_d1 VSUBS 0.23f
C587 vref_in VSUBS 0.2f
C588 xcbiasn_xrb_s3 VSUBS 0.432f
C589 xcbias_xrb_s2 VSUBS 0.0812f
C590 vbp vrefl 0.0544f
C591 vss vdda 0.132f
C592 xcbias_xrb_s2 VSUBS 0.0564f
C593 mclkb VSUBS 0.0815f
C594 vref_in xcbias_xrb_s3 0.449f
C595 xckg_d2 VSUBS 0.217f
C596 xckg_d1 xref_ng 0.758f
C597 vrefl VSUBS 0.377f
C598 vref_in vdd 0.027f
C599 ibias xcbiasn_xrb_s3 0.0444f
C600 sar_mclk VSUBS 0.058f
C601 clk VSUBS 0.136f
C602 xcbiasn_xrb_s1 xcbias_xrb_s1 0.0392f
C603 xcbias_xrb_s3 vbp 0.571f
C604 xcbias_xrb_s2 vbn 0.0897f
C605 xref_ng vdda 0.199f
C606 xcbias_xrb_s1 mclkb 0.1f
C607 vss xcbias_xrb_s3 0.187f
C608 vbp xcbiasn_xrb_s1 0.17f
C609 xref_ng VSUBS 0.195f
C610 vrefl VSUBS 0.0649f
C611 mclkb VSUBS 0.659f
C612 xref_ng VSUBS 0.348f
C613 vrefl VSUBS 0.159f
C614 vrefl xckg_x 0.362f
C615 xcbiasn_xrb_s3 VSUBS 0.382f
C616 vref_in mclkb 0.0798f
C617 sar_mclk VSUBS 0.195f
C618 vref xcbiasn_xrb_s1 0.0516f
C619 clk xcbiasn_xrb_s3 0.272f
C620 vref VSUBS 0.141f
C621 vdda xcbias_xrb_s2 0.0544f
C622 vdd xcbiasn_xrb_s2 2.45f
C623 mclkb VSUBS 0.12f
C624 ibias vbp 0.274f
C625 sar_mclk VSUBS 0.262f
C626 vdd VSUBS 1.27f
C627 vrefl VSUBS 0.167f
C628 vref_in xref_ntl 0.163f
C629 vss xckg_d0 0.211f
C630 xckg_d0 VSUBS 0.192f
C631 xckg_nn VSUBS 0.214f
C632 clk vref_in 0.253f
C633 xckg_d2 xckg_d2 0.132f
C634 xckg_d3 VSUBS 0.165f
C635 ibias VSUBS 0.247f
C636 vdda mclkb 0.0196f
C637 xcbias_xrb_s3 VSUBS 0.124f
C638 sar_mclk VSUBS 0.0848f
C639 vss xckg_d3 0.158f
C640 xcbias_xrb_s1 xckg_x 0.245f
C641 vbn VSUBS 0.103f
C642 ibias VSUBS 0.063f
C643 vss VSUBS 0.238f
C644 vbn VSUBS 0.179f
C645 xcbias_xrb_s2 vbn 0.208f
C646 xref_na vdda 0.269f
C647 vbp VSUBS 0.194f
C648 xcbias_xrb_s3 ibias 0.058f
C649 xcbiasn_xrb_s3 VSUBS 0.386f
C650 xref_ntl xref_ntl 0.258f
C651 vbp xcbiasn_xrb_s3 0.0312f
C652 xref_ng VSUBS 0.157f
C653 xref_ntl ibias 0.0607f
C654 xckg_x VSUBS 0.202f
C655 clk VSUBS 0.0664f
C656 vbp xckg_d0 0.111f
C657 xcbias_xrb_s3 VSUBS 0.204f
C658 xckg_d1 VSUBS 0.0289f
C659 xckg_d2 VSUBS 0.0435f
C660 xcbiasn_xrb_s2 VSUBS 0.671f
C661 xckg_x VSUBS 0.176f
C662 mclkb VSUBS 0.0816f
C663 xckg_d3 clk 0.141f
C664 xref_na vbp 0.0678f
C665 vbp VSUBS 0.341f
C666 xcbias_xrb_s2 VSUBS 0.118f
C667 vrefl VSUBS 0.607f
C668 vss VSUBS 0.435f
C669 mclkb VSUBS 0.089f
C670 vref_in vrefl 1.08f
C671 xref_ntl VSUBS 0.354f
C672 sar_mclk VSUBS 0.161f
C673 vref clk 0.617f
C674 vref_in xcbiasn_xrb_s2 0.0869f
C675 xref_ntl xcbiasn_xrb_s1 0.172f
C676 xckg_d2 xcbias_xrb_s3 0.0575f
C677 xckg_d3 VSUBS 0.16f
C678 clk vrefl 0.171f
C679 xckg_d1 VSUBS 0.161f
C680 vref_in VSUBS 0.0349f
C681 vref VSUBS 0.0464f
C682 xckg_x xcbias_xrb_s2 0.805f
C683 mclkb VSUBS 0.29f
C684 xckg_x VSUBS 0.206f
C685 vbn VSUBS 0.15f
C686 xckg_d3 VSUBS 0.152f
C687 vdda vbn 0.325f
C688 sar_mclk xcbias_xrb_s2 0.702f
C689 xckg_x VSUBS 0.121f
C690 xckg_d2 VSUBS 0.234f
C691 vdda xcbiasn_xrb_s1 0.0471f
C692 vrefl VSUBS 0.0383f
C693 vbn xcbias_xrb_s3 0.139f
C694 vdd VSUBS 1.05f
C695 mclkb xcbiasn_xrb_s1 0.316f
C696 xcbias_xrb_s2 VSUBS 0.166f
C697 xref_ntl VSUBS 0.164f
C698 xref_ntl VSUBS 0.65f
C699 xckg_d0 VSUBS 0.0752f
C700 mclkb VSUBS 0.349f
C701 vss VSUBS 0.192f
C702 mclkb xckg_nn 0.186f
C703 vdd VSUBS 0.0534f
C704 xref_ntl xcbias_xrb_s2 0.627f
C705 xckg_nn VSUBS 0.185f
C706 vdd vref_in 0.0967f
C707 mclkb VSUBS 0.381f
C708 vbn VSUBS 0.166f
C709 ibias VSUBS 0.272f
C710 xckg_x VSUBS 0.437f
C711 xcbiasn_xrb_s1 VSUBS 0.152f
C712 xckg_d3 VSUBS 0.323f
C713 xcbiasn_xrb_s1 VSUBS 0.086f
C714 xckg_d1 xckg_x 0.244f
C715 xref_ng VSUBS 0.174f
C716 xckg_d3 xcbias_xrb_s3 0.245f
C717 mclkb vrefl 0.0464f
C718 ibias sar_mclk 0.112f
C719 vdd VSUBS 0.459f
C720 xckg_d2 VSUBS 0.163f
C721 vref_in VSUBS 0.125f
C722 xckg_d0 mclkb 0.104f
C723 vdda VSUBS 0.0701f
C724 xref_ntl VSUBS 0.699f
C725 xcbias_xrb_s2 vrefl 0.318f
C726 xcbias_xrb_s2 VSUBS 0.143f
C727 mclkb VSUBS 0.28f
C728 vdd xcbias_xrb_s1 0.46f
C729 xckg_d0 VSUBS 0.0994f
C730 xref_na VSUBS 0.132f
C731 xcbias_xrb_s3 VSUBS 0.173f
C732 xckg_x VSUBS 0.0283f
C733 vref_in VSUBS 0.0684f
C734 xref_ng VSUBS 0.328f
C735 sar_mclk VSUBS 0.0354f
C736 xcbiasn_xrb_s2 clk 0.157f
C737 xcbiasn_xrb_s2 VSUBS 0.427f
C738 xckg_d3 VSUBS 0.171f
C739 clk VSUBS 0.174f
C740 xcbiasn_xrb_s1 VSUBS 0.0439f
C741 xcbias_xrb_s2 VSUBS 0.0962f
C742 xckg_d3 VSUBS 0.0569f
C743 sar_mclk VSUBS 0.102f
C744 clk VSUBS 0.0941f
C745 xckg_d0 VSUBS 0.311f
C746 vdda VSUBS 0.559f
C747 xcbias_xrb_s2 VSUBS 0.265f
C748 vdd VSUBS 0.0452f
C749 xref_ntl VSUBS 0.238f
C750 xcbias_xrb_s3 VSUBS 0.205f
C751 vbp xckg_d0 0.173f
C752 vrefl vdd 0.0632f
C753 xckg_nn xcbiasn_xrb_s1 0.191f
C754 xckg_d1 VSUBS 0.107f
C755 xcbiasn_xrb_s1 VSUBS 0.057f
C756 vdd VSUBS 0.233f
C757 vbn VSUBS 0.131f
C758 vref_in VSUBS 0.17f
C759 xckg_d0 VSUBS 0.256f
C760 xref_ng xcbiasn_xrb_s2 0.0576f
C761 xcbiasn_xrb_s1 VSUBS 0.0223f
C762 xckg_d1 xcbiasn_xrb_s1 0.389f
C763 vdda VSUBS 0.124f
C764 vref_in xcbias_xrb_s3 0.38f
C765 xckg_nn VSUBS 0.0825f
C766 vdd mclkb 0.176f
C767 vrefl VSUBS 0.416f
C768 xref_ng VSUBS 0.0676f
C769 xckg_d0 xcbiasn_xrb_s3 0.247f
C770 xckg_x xcbiasn_xrb_s3 0.488f
C771 clk VSUBS 0.147f
C772 vdd VSUBS 0.105f
C773 clk vdd 0.245f
C774 xcbias_xrb_s2 vdd 0.17f
C775 vrefl VSUBS 0.0978f
C776 xref_na VSUBS 0.287f
C777 xckg_d3 VSUBS 0.112f
C778 vbn VSUBS 0.24f
C779 ibias VSUBS 0.287f
C780 xref_ng VSUBS 0.355f
C781 xckg_d3 xref_na 0.045f
C782 xckg_d0 VSUBS 0.111f
C783 xckg_nn VSUBS 0.616f
C784 xcbias_xrb_s1 xckg_d2 0.136f
C785 xcbiasn_xrb_s3 VSUBS 0.0789f
C786 xcbias_xrb_s2 VSUBS 0.105f
C787 vdda xckg_d1 0.749f
C788 ibias VSUBS 0.406f
C789 xcbias_xrb_s3 xcbiasn_xrb_s1 0.0793f
C790 xcbiasn_xrb_s2 VSUBS 0.167f
C791 clk VSUBS 0.304f
C792 xckg_d2 VSUBS 0.492f
C793 vdda VSUBS 0.131f
C794 xref_ntl VSUBS 0.234f
C795 xcbiasn_xrb_s2 VSUBS 0.165f
C796 mclkb xckg_nn 0.163f
C797 vbn VSUBS 0.066f
C798 clk VSUBS 0.127f
C799 vdd VSUBS 0.676f
C800 xref_ng VSUBS 0.195f
C801 vbn xcbiasn_xrb_s1 0.233f
C802 xref_ng xcbiasn_xrb_s2 0.554f
C803 xcbiasn_xrb_s1 VSUBS 0.827f
C804 xckg_nn xref_ntl 0.134f
C805 xckg_d3 VSUBS 0.0495f
C806 xckg_d3 VSUBS 0.0977f
C807 xcbiasn_xrb_s2 ibias 0.0326f
C808 xcbias_xrb_s3 VSUBS 0.187f
C809 vdda VSUBS 0.105f
C810 vref_in VSUBS 0.146f
C811 xref_ng VSUBS 0.338f
C812 vdd VSUBS 0.206f
C813 vref VSUBS 0.153f
C814 vdd VSUBS 0.145f
C815 xcbiasn_xrb_s2 vref 0.0598f
C816 clk xckg_d0 0.306f
C817 clk VSUBS 0.264f
C818 xckg_d2 xcbiasn_xrb_s3 0.371f
C819 clk vdda 0.363f
C820 xcbiasn_xrb_s2 xckg_d2 0.346f
C821 vref xref_ntl 0.158f
C822 vref_in VSUBS 0.298f
C823 xcbiasn_xrb_s2 VSUBS 0.117f
C824 xckg_nn VSUBS 0.31f
C825 vbn sar_mclk 0.264f
C826 xcbias_xrb_s2 ibias 0.101f
C827 vbn xcbiasn_xrb_s1 0.198f
C828 xcbiasn_xrb_s3 VSUBS 0.608f
C829 mclkb clk 0.147f
C830 vbp xckg_nn 0.172f
C831 xcbiasn_xrb_s2 vref_in 0.191f
C832 xref_ng xref_ng 0.146f
C833 xref_ntl xckg_d2 0.0646f
C834 xref_na VSUBS 0.201f
C835 vbn xref_ng 0.188f
C836 mclkb xcbiasn_xrb_s1 0.0461f
C837 xckg_d3 xckg_d3 0.114f
C838 xckg_d0 VSUBS 0.243f
C839 mclkb xckg_x 0.17f
C840 vrefl VSUBS 0.295f
C841 xcbiasn_xrb_s1 VSUBS 0.126f
C842 xcbiasn_xrb_s3 vbn 0.192f
C843 vrefl VSUBS 0.0669f
C844 vdd xref_na 0.121f
C845 xref_ntl VSUBS 0.152f
C846 vdd VSUBS 0.141f
C847 sar_mclk vdd 0.21f
C848 vbn VSUBS 0.0552f
C849 vss VSUBS 0.105f
C850 xckg_d0 vdd 0.0396f
C851 xref_ng VSUBS 0.472f
C852 vref_in VSUBS 0.151f
C853 vdda vbn 0.297f
C854 xcbiasn_xrb_s3 clk 0.269f
C855 xckg_x xckg_d0 0.146f
C856 xckg_x xckg_x 0.0635f
C857 sar_mclk sar_mclk 0.235f
C858 xref_ntl VSUBS 0.0581f
C859 xcbias_xrb_s3 vbn 0.16f
C860 ibias vdda 0.118f
C861 vrefl xckg_nn 0.0404f
C862 mclkb VSUBS 0.0167f
C863 sar_mclk xcbiasn_xrb_s2 0.0812f
C864 vrefl VSUBS 0.246f
C865 xckg_d0 sar_mclk 0.391f
C866 xcbiasn_xrb_s2 xcbias_xrb_s2 0.0583f
C867 xckg_d1 VSUBS 0.117f
C868 xcbias_xrb_s2 VSUBS 0.328f
C869 xcbiasn_xrb_s2 VSUBS 0.486f
C870 xckg_d2 vref_in 0.161f
C871 xckg_d1 vdda 0.179f
C872 xckg_nn VSUBS 0.155f
C873 vbn VSUBS 0.137f
C874 xcbias_xrb_s3 xcbias_xrb_s3 0.0466f
C875 xcbias_xrb_s3 vdda 0.514f
C876 vdd xckg_d0 0.173f
C877 clk VSUBS 0.195f
C878 xckg_d0 xcbias_xrb_s2 0.412f
C879 vss vdda 0.15f
C880 xref_na VSUBS 0.275f
C881 xckg_d3 VSUBS 0.0319f
C882 xref_ng VSUBS 0.281f
C883 xcbias_xrb_s3 VSUBS 1.08f
C884 sar_mclk VSUBS 0.0341f
C885 xcbias_xrb_s2 xcbiasn_xrb_s3 0.0282f
C886 xref_ng VSUBS 0.57f
C887 vref_in VSUBS 0.101f
C888 vbp VSUBS 0.148f
C889 xcbiasn_xrb_s1 VSUBS 0.0864f
C890 xckg_x xckg_d3 0.0546f
C891 xref_na vdda 1.62f
C892 xckg_nn VSUBS 0.204f
C893 xref_na ibias 0.113f
C894 clk xckg_d0 0.577f
C895 xref_ng VSUBS 0.267f
C896 xcbias_xrb_s2 VSUBS 0.139f
C897 xckg_d3 VSUBS 0.0709f
C898 xref_ntl VSUBS 0.59f
C899 clk xcbias_xrb_s1 0.0491f
C900 xref_ntl VSUBS 0.0901f
C901 xcbias_xrb_s3 vdda 0.0702f
C902 vdda VSUBS 0.0267f
C903 xckg_d2 VSUBS 0.0885f
C904 vdd VSUBS 0.0473f
C905 ibias xckg_x 0.0784f
C906 ibias xckg_d3 0.158f
C907 xckg_d2 VSUBS 0.349f
C908 vss VSUBS 0.111f
C909 xref_ntl VSUBS 0.202f
C910 vdda vbp 0.157f
C911 xckg_d0 VSUBS 0.157f
C912 xcbiasn_xrb_s3 clk 0.414f
C913 xckg_d2 xckg_nn 0.415f
C914 xckg_d3 VSUBS 0.446f
C915 xref_na xcbias_xrb_s1 0.129f
C916 vbp VSUBS 0.303f
C917 clk vbn 0.0566f
C918 vref VSUBS 0.92f
C919 xckg_d1 VSUBS 0.0846f
C920 xcbiasn_xrb_s3 vdd 0.249f
C921 xref_ntl VSUBS 0.124f
C922 xckg_d1 VSUBS 0.095f
C923 mclkb VSUBS 0.0204f
C924 xckg_d2 VSUBS 0.0453f
C925 vdda VSUBS 0.287f
C926 sar_mclk mclkb 0.161f
C927 xcbias_xrb_s2 vref 0.31f
C928 xckg_d2 VSUBS 0.77f
C929 clk xref_ng 0.0702f
C930 xref_ntl VSUBS 0.137f
C931 xcbiasn_xrb_s2 VSUBS 0.0506f
C932 xcbias_xrb_s1 vref_in 0.546f
C933 xcbias_xrb_s2 vdd 0.326f
C934 xckg_nn VSUBS 0.27f
C935 xcbiasn_xrb_s1 VSUBS 0.147f
C936 mclkb VSUBS 0.153f
C937 vdd VSUBS 0.24f
C938 xref_na xcbias_xrb_s3 0.161f
C939 xref_ng clk 0.119f
C940 xckg_d3 sar_mclk 0.414f
C941 xckg_d3 VSUBS 0.194f
C942 xcbias_xrb_s3 VSUBS 0.222f
C943 xcbiasn_xrb_s1 VSUBS 0.203f
C944 vdda clk 0.306f
C945 ibias vbn 0.243f
C946 vrefl xckg_d2 0.0538f
C947 xckg_d1 xcbiasn_xrb_s1 0.0458f
C948 xckg_d3 vdda 0.119f
C949 sar_mclk vref_in 0.0685f
C950 xcbiasn_xrb_s1 xcbias_xrb_s1 0.0795f
C951 xckg_nn VSUBS 0.544f
C952 clk VSUBS 0.182f
C953 sar_mclk VSUBS 0.0495f
C954 xckg_d3 VSUBS 0.315f
C955 sar_mclk xckg_d3 0.0319f
C956 mclkb VSUBS 0.105f
C957 xcbiasn_xrb_s1 xcbiasn_xrb_s2 0.0352f
C958 mclkb VSUBS 0.0374f
C959 xckg_d1 VSUBS 0.179f
C960 xcbias_xrb_s1 VSUBS 0.115f
C961 xref_ntl VSUBS 0.0404f
C962 vbp VSUBS 0.243f
C963 xcbiasn_xrb_s3 xref_ng 0.152f
C964 xcbias_xrb_s2 VSUBS 0.21f
C965 xcbiasn_xrb_s2 VSUBS 0.175f
C966 vbn xcbiasn_xrb_s3 0.0871f
C967 xcbiasn_xrb_s2 VSUBS 0.0682f
C968 xref_ng vbp 0.223f
C969 xckg_d1 VSUBS 0.177f
C970 xcbias_xrb_s1 VSUBS 0.11f
C971 vbn ibias 0.235f
C972 xcbias_xrb_s2 VSUBS 0.046f
C973 xref_ntl VSUBS 0.334f
C974 vref xref_na 0.284f
C975 xckg_x VSUBS 0.0204f
C976 vref ibias 0.17f
C977 clk xcbias_xrb_s2 0.22f
C978 xcbiasn_xrb_s2 VSUBS 0.316f
C979 vdda xcbiasn_xrb_s2 0.0823f
C980 mclkb VSUBS 0.261f
C981 xcbias_xrb_s1 mclkb 0.647f
C982 xckg_d2 VSUBS 0.175f
C983 xref_na xckg_x 0.0975f
C984 xcbiasn_xrb_s1 xcbiasn_xrb_s3 0.346f
C985 xckg_d2 VSUBS 0.148f
C986 xref_na mclkb 0.092f
C987 ibias VSUBS 0.116f
C988 xckg_nn xcbiasn_xrb_s2 0.222f
C989 vbn VSUBS 0.0477f
C990 xcbiasn_xrb_s2 VSUBS 0.171f
C991 vbp xref_ng 0.0347f
C992 clk VSUBS 0.123f
C993 ibias VSUBS 0.159f
C994 vref mclkb 0.0475f
C995 vdd VSUBS 0.0576f
C996 xckg_d3 xckg_d0 0.102f
C997 xref_ng clk 0.0959f
C998 xcbiasn_xrb_s3 VSUBS 0.0368f
C999 xref_ng xckg_d3 0.583f
C1000 xcbias_xrb_s2 VSUBS 0.189f
C1001 xref_na VSUBS 0.0581f
C1002 xckg_x VSUBS 0.233f
C1003 xckg_x VSUBS 0.471f
C1004 vss xckg_d2 0.0472f
C1005 clk VSUBS 0.193f
C1006 vdd VSUBS 0.319f
C1007 xref_na VSUBS 0.142f
C1008 xcbiasn_xrb_s1 VSUBS 0.0766f
C1009 xckg_d2 VSUBS 0.192f
C1010 xcbiasn_xrb_s3 VSUBS 0.108f
C1011 xref_ng VSUBS 0.327f
C1012 xckg_d1 vbn 0.342f
C1013 vbp xckg_d0 0.058f
C1014 vss vdd 0.104f
C1015 xcbias_xrb_s3 sar_mclk 0.751f
C1016 xckg_nn VSUBS 0.639f
C1017 xckg_d3 VSUBS 0.104f
C1018 ibias VSUBS 0.182f
C1019 vref_in VSUBS 0.453f
C1020 vref_in VSUBS 0.199f
C1021 xcbiasn_xrb_s1 vrefl 0.348f
C1022 xcbiasn_xrb_s3 vbn 0.081f
C1023 xcbias_xrb_s1 vbp 0.194f
C1024 xckg_d2 xckg_x 0.106f
C1025 vref_in xref_ng 0.145f
C1026 xcbias_xrb_s2 VSUBS 0.116f
C1027 ibias xref_na 0.0508f
C1028 vbp VSUBS 0.0399f
C1029 vrefl vbn 0.263f
C1030 vref VSUBS 0.305f
C1031 xcbias_xrb_s2 xref_ng 0.264f
C1032 vdda VSUBS 0.0774f
C1033 xckg_d1 VSUBS 0.164f
C1034 vrefl vbn 0.0768f
C1035 xckg_x xckg_nn 0.0866f
C1036 vss VSUBS 0.084f
C1037 xcbiasn_xrb_s2 VSUBS 0.067f
C1038 xcbias_xrb_s2 vrefl 0.126f
C1039 xckg_x xref_ntl 0.0481f
C1040 vss xckg_d2 0.217f
C1041 xcbias_xrb_s3 VSUBS 0.0328f
C1042 xcbias_xrb_s2 VSUBS 0.0963f
C1043 xckg_x vref_in 0.24f
C1044 xref_ng xref_ntl 0.612f
C1045 xref_na VSUBS 0.0935f
C1046 xckg_d1 vref 0.113f
C1047 xckg_nn VSUBS 0.201f
C1048 xref_ntl xcbiasn_xrb_s1 0.443f
C1049 vrefl xckg_d3 0.109f
C1050 vbp xref_ng 0.39f
C1051 xckg_d1 VSUBS 0.478f
C1052 xcbiasn_xrb_s2 xckg_d2 0.169f
C1053 xref_ng VSUBS 0.259f
C1054 vref ibias 0.179f
C1055 xckg_nn VSUBS 0.0909f
C1056 vdd VSUBS 0.428f
C1057 xckg_x xcbiasn_xrb_s1 0.172f
C1058 xref_ng VSUBS 0.157f
C1059 xckg_d2 VSUBS 0.234f
C1060 vrefl VSUBS 0.913f
C1061 vref_in VSUBS 0.177f
C1062 xref_ntl VSUBS 1.03f
C1063 ibias xcbiasn_xrb_s1 0.274f
C1064 xcbiasn_xrb_s2 VSUBS 0.0493f
C1065 xckg_d1 VSUBS 0.161f
C1066 xckg_nn xckg_nn 1.16f
C1067 xcbiasn_xrb_s1 VSUBS 0.517f
C1068 vbn VSUBS 0.308f
C1069 xcbias_xrb_s1 sar_mclk 0.249f
C1070 xcbiasn_xrb_s2 vbn 0.241f
C1071 xckg_nn clk 0.0983f
C1072 xcbiasn_xrb_s3 VSUBS 0.111f
C1073 xcbias_xrb_s3 vbn 0.198f
C1074 vdd VSUBS 0.141f
C1075 vref_in xcbias_xrb_s1 0.107f
C1076 xcbiasn_xrb_s1 VSUBS 0.069f
C1077 vbn VSUBS 0.117f
C1078 xckg_d3 VSUBS 0.236f
C1079 vdda xckg_nn 0.174f
C1080 vref xcbias_xrb_s2 0.04f
C1081 vref xref_ntl 0.261f
C1082 vdd VSUBS 0.638f
C1083 xref_na VSUBS 0.14f
C1084 xcbias_xrb_s3 VSUBS 0.188f
C1085 xcbias_xrb_s1 vdda 0.538f
C1086 vss VSUBS 0.143f
C1087 vrefl xckg_d1 0.0781f
C1088 vbn xckg_nn 0.134f
C1089 vbn vdda 0.236f
C1090 vbn vbn 0.336f
C1091 xcbias_xrb_s3 VSUBS 0.0753f
C1092 xckg_nn VSUBS 0.411f
C1093 xckg_d1 VSUBS 0.191f
C1094 vss VSUBS 0.0677f
C1095 xckg_d3 VSUBS 0.0231f
C1096 vbp VSUBS 0.0858f
C1097 xcbiasn_xrb_s1 vbn 0.0839f
C1098 vrefl xref_ng 0.0918f
C1099 xcbias_xrb_s2 vbp 0.0534f
C1100 sar_mclk VSUBS 0.0975f
C1101 xcbiasn_xrb_s3 vref_in 0.257f
C1102 xckg_nn xcbiasn_xrb_s1 0.0785f
C1103 xcbiasn_xrb_s2 clk 0.0429f
C1104 xckg_d0 xcbias_xrb_s2 0.424f
C1105 vdd VSUBS 0.0865f
C1106 mclkb VSUBS 0.154f
C1107 vref_in ibias 0.105f
C1108 xckg_d1 sar_mclk 0.0398f
C1109 vdda xcbiasn_xrb_s3 0.106f
C1110 vrefl VSUBS 0.102f
C1111 xcbiasn_xrb_s2 VSUBS 0.364f
C1112 xckg_d0 xckg_nn 0.0889f
C1113 xref_na vref 0.25f
C1114 xcbiasn_xrb_s2 xckg_d3 0.0419f
C1115 ibias vdda 0.0914f
C1116 xckg_x VSUBS 0.157f
C1117 xref_na xckg_d0 0.0359f
C1118 vss vbn 0.775f
C1119 vbn VSUBS 0.202f
C1120 xcbiasn_xrb_s1 VSUBS 0.0927f
C1121 xcbiasn_xrb_s3 vbn 0.0616f
C1122 xref_na VSUBS 0.0708f
C1123 xckg_d2 VSUBS 0.17f
C1124 vdda VSUBS 0.317f
C1125 vbp vref_in 0.186f
C1126 sar_mclk VSUBS 0.125f
C1127 xcbias_xrb_s2 xcbias_xrb_s1 0.187f
C1128 vrefl VSUBS 0.563f
C1129 xcbiasn_xrb_s1 VSUBS 0.349f
C1130 xckg_x xcbiasn_xrb_s2 0.25f
C1131 clk xcbiasn_xrb_s2 0.071f
C1132 xcbiasn_xrb_s2 VSUBS 0.135f
C1133 vss VSUBS 0.113f
C1134 mclkb VSUBS 0.117f
C1135 vbp VSUBS 0.125f
C1136 vbn VSUBS 0.344f
C1137 xcbiasn_xrb_s2 VSUBS 0.159f
C1138 vbp VSUBS 0.709f
C1139 xcbias_xrb_s1 VSUBS 0.278f
C1140 vbp VSUBS 0.0603f
C1141 xckg_d3 VSUBS 0.619f
C1142 xref_na xckg_d2 0.189f
C1143 ibias vbp 0.182f
C1144 xckg_d2 clk 0.486f
C1145 vss sar_mclk 0.441f
C1146 mclkb VSUBS 0.11f
C1147 vref VSUBS 0.0905f
C1148 xcbias_xrb_s1 VSUBS 0.181f
C1149 vbn VSUBS 0.111f
C1150 xckg_d3 xcbias_xrb_s2 0.551f
C1151 xckg_nn VSUBS 0.138f
C1152 xref_ntl xcbias_xrb_s2 0.0405f
C1153 xref_ntl xckg_d0 0.134f
C1154 xref_ntl VSUBS 0.177f
C1155 vref_in VSUBS 0.714f
C1156 ibias VSUBS 0.363f
C1157 xcbiasn_xrb_s2 VSUBS 0.185f
C1158 xcbias_xrb_s2 xckg_d0 0.128f
C1159 mclkb VSUBS 0.351f
C1160 ibias vbn 0.0783f
C1161 sar_mclk xref_na 0.436f
C1162 xckg_d0 VSUBS 0.0398f
C1163 vrefl mclkb 0.23f
C1164 vss VSUBS 0.0816f
C1165 xcbiasn_xrb_s2 VSUBS 0.2f
C1166 xref_na VSUBS 0.0983f
C1167 vdd VSUBS 0.0778f
C1168 mclkb VSUBS 0.122f
C1169 sar_mclk VSUBS 0.0545f
C1170 xcbiasn_xrb_s3 VSUBS 0.561f
C1171 vbn VSUBS 0.166f
C1172 xref_ng VSUBS 0.544f
C1173 xcbias_xrb_s3 xcbias_xrb_s2 0.15f
C1174 vdda VSUBS 0.227f
C1175 xref_ng vrefl 0.151f
C1176 vdda VSUBS 0.0896f
C1177 vss xcbias_xrb_s2 0.146f
C1178 vref xref_ng 0.483f
C1179 clk VSUBS 0.487f
C1180 vref VSUBS 0.0743f
C1181 vrefl xcbias_xrb_s3 0.0911f
C1182 xckg_d1 xref_na 0.0206f
C1183 vbn VSUBS 0.116f
C1184 xcbiasn_xrb_s3 VSUBS 0.15f
C1185 ibias VSUBS 0.105f
C1186 clk VSUBS 0.144f
C1187 ibias VSUBS 0.0456f
C1188 xcbias_xrb_s2 xref_na 0.128f
C1189 xref_ntl xref_ng 0.303f
C1190 xref_ntl VSUBS 0.131f
C1191 sar_mclk VSUBS 0.75f
C1192 xcbiasn_xrb_s1 clk 0.12f
C1193 ibias xckg_d1 0.239f
C1194 vrefl vbn 0.561f
C1195 xref_ng VSUBS 0.311f
C1196 xcbias_xrb_s3 VSUBS 0.274f
C1197 vss VSUBS 0.164f
C1198 xcbias_xrb_s1 xcbiasn_xrb_s3 0.0877f
C1199 vrefl xckg_d2 0.079f
C1200 vrefl VSUBS 0.0764f
C1201 xcbiasn_xrb_s2 xref_na 0.0516f
C1202 vbn VSUBS 0.287f
C1203 vdd sar_mclk 0.0821f
C1204 xcbias_xrb_s3 VSUBS 0.141f
C1205 xckg_d1 VSUBS 0.142f
C1206 ibias clk 0.136f
C1207 mclkb VSUBS 0.211f
C1208 clk xckg_nn 0.0722f
C1209 vss xcbiasn_xrb_s3 0.794f
C1210 mclkb xref_ntl 0.224f
C1211 vdd VSUBS 0.214f
C1212 vss xref_ntl 0.237f
C1213 xref_na xcbiasn_xrb_s1 0.101f
C1214 xckg_d2 VSUBS 0.252f
C1215 xcbiasn_xrb_s2 VSUBS 0.314f
C1216 xckg_d1 VSUBS 0.129f
C1217 xcbias_xrb_s1 VSUBS 0.194f
C1218 vbp VSUBS 0.62f
C1219 ibias vbp 0.0716f
C1220 xckg_x VSUBS 0.0966f
C1221 vss VSUBS 0.203f
C1222 xckg_d3 vdd 0.0313f
C1223 xcbiasn_xrb_s3 VSUBS 0.0656f
C1224 xcbiasn_xrb_s1 sar_mclk 0.181f
C1225 xref_ng VSUBS 0.289f
C1226 vbn VSUBS 0.0606f
C1227 xcbiasn_xrb_s1 vbp 0.336f
C1228 xckg_nn VSUBS 0.266f
C1229 xcbias_xrb_s2 VSUBS 0.0866f
C1230 clk VSUBS 0.183f
C1231 xref_ntl VSUBS 0.423f
C1232 mclkb VSUBS 0.253f
C1233 xcbias_xrb_s1 VSUBS 0.158f
C1234 vss VSUBS 0.283f
C1235 clk VSUBS 1.25f
C1236 xcbias_xrb_s1 VSUBS 0.314f
C1237 xref_ntl VSUBS 0.228f
C1238 xckg_d3 xref_na 0.373f
C1239 xref_ntl xcbias_xrb_s1 0.113f
C1240 mclkb VSUBS 0.495f
C1241 sar_mclk VSUBS 0.0244f
C1242 vss xref_na 0.0368f
C1243 xcbias_xrb_s2 xckg_nn 0.461f
C1244 vdda vbp 0.258f
C1245 xcbias_xrb_s1 xcbiasn_xrb_s2 0.1f
C1246 xcbias_xrb_s2 VSUBS 0.341f
C1247 xckg_x VSUBS 0.115f
C1248 xcbiasn_xrb_s3 VSUBS 0.148f
C1249 vdda VSUBS 0.0733f
C1250 xref_ng VSUBS 0.229f
C1251 vrefl vbp 0.338f
C1252 vbp VSUBS 0.248f
C1253 xref_na xckg_nn 0.0277f
C1254 xckg_d1 VSUBS 0.116f
C1255 xckg_d2 xckg_d3 0.112f
C1256 vref_in VSUBS 0.195f
C1257 vref VSUBS 0.477f
C1258 vref_in VSUBS 0.109f
C1259 xckg_d2 VSUBS 0.0449f
C1260 vdd VSUBS 0.271f
C1261 xcbias_xrb_s3 VSUBS 0.226f
C1262 xcbias_xrb_s2 VSUBS 0.167f
C1263 xcbias_xrb_s1 VSUBS 0.214f
C1264 vbn xref_ntl 0.185f
C1265 sar_mclk VSUBS 0.333f
C1266 xcbiasn_xrb_s1 VSUBS 0.186f
C1267 clk xcbias_xrb_s2 0.299f
C1268 xcbiasn_xrb_s3 xckg_d2 0.166f
C1269 xref_ng VSUBS 0.175f
C1270 clk mclkb 0.0496f
C1271 vrefl VSUBS 0.0879f
C1272 vbn xckg_d0 0.194f
C1273 xckg_d2 VSUBS 0.182f
C1274 xcbiasn_xrb_s2 clk 0.179f
C1275 xckg_d0 xckg_nn 0.112f
C1276 xckg_d2 VSUBS 0.266f
C1277 xckg_d1 VSUBS 0.386f
C1278 xref_ng VSUBS 0.116f
C1279 vref VSUBS 0.144f
C1280 xcbiasn_xrb_s3 VSUBS 0.0895f
C1281 xckg_d2 vref_in 0.158f
C1282 mclkb xckg_nn 0.25f
C1283 xckg_d3 VSUBS 0.112f
C1284 xref_ntl VSUBS 0.0412f
C1285 clk VSUBS 0.272f
C1286 xref_na xckg_x 0.0779f
C1287 xckg_d3 vbp 0.386f
C1288 xckg_d2 VSUBS 0.159f
C1289 xcbias_xrb_s1 vbn 0.0303f
C1290 xcbias_xrb_s2 VSUBS 0.183f
C1291 xcbias_xrb_s1 VSUBS 0.216f
C1292 xckg_x VSUBS 0.163f
C1293 xcbias_xrb_s2 VSUBS 0.089f
C1294 xcbiasn_xrb_s2 VSUBS 0.0703f
C1295 xckg_d3 VSUBS 0.0797f
C1296 vdda xref_na 0.24f
C1297 xref_na VSUBS 0.0413f
C1298 vrefl vdda 0.269f
C1299 xref_na xcbias_xrb_s2 0.0748f
C1300 xref_ng VSUBS 0.0636f
C1301 vdd VSUBS 0.159f
C1302 vbn xcbiasn_xrb_s1 0.132f
C1303 xckg_d2 xcbias_xrb_s2 0.0885f
C1304 xref_ntl xref_na 0.162f
C1305 vdd clk 0.273f
C1306 clk VSUBS 0.0692f
C1307 xcbiasn_xrb_s1 vbp 0.0905f
C1308 xcbias_xrb_s2 vref_in 0.25f
C1309 xckg_d1 VSUBS 0.122f
C1310 vbp VSUBS 0.0443f
C1311 xcbiasn_xrb_s2 xcbiasn_xrb_s3 0.0701f
C1312 xckg_d1 VSUBS 0.422f
C1313 ibias xcbiasn_xrb_s1 0.919f
C1314 xcbias_xrb_s2 VSUBS 0.163f
C1315 xcbiasn_xrb_s2 VSUBS 0.415f
C1316 vrefl xcbias_xrb_s1 0.436f
C1317 xckg_d1 vref_in 0.0592f
C1318 vrefl VSUBS 0.156f
C1319 xckg_d1 vref 0.0755f
C1320 vss VSUBS 0.113f
C1321 xcbias_xrb_s1 VSUBS 0.0196f
C1322 xckg_x VSUBS 0.0411f
C1323 xckg_d3 sar_mclk 0.0867f
C1324 xckg_d2 VSUBS 0.0605f
C1325 xckg_d0 VSUBS 0.08f
C1326 ibias xcbias_xrb_s1 0.25f
C1327 xckg_d3 xckg_nn 0.202f
C1328 xref_na VSUBS 0.395f
C1329 xckg_d3 VSUBS 0.0715f
C1330 vdd xcbiasn_xrb_s2 0.0647f
C1331 vbp xcbias_xrb_s3 0.196f
C1332 vbp VSUBS 0.129f
C1333 xckg_d3 VSUBS 0.0604f
C1334 xref_na VSUBS 0.226f
C1335 clk vdda 0.202f
C1336 ibias VSUBS 0.221f
C1337 xref_ng VSUBS 0.0398f
C1338 sar_mclk clk 0.2f
C1339 sar_mclk xckg_x 0.122f
C1340 xref_ng sar_mclk 0.202f
C1341 xckg_d0 VSUBS 0.188f
C1342 xref_ng VSUBS 0.101f
C1343 vdda xref_na 0.187f
C1344 xcbiasn_xrb_s3 xcbiasn_xrb_s3 0.106f
C1345 xcbias_xrb_s1 xckg_nn 0.0559f
C1346 xcbias_xrb_s1 VSUBS 0.335f
C1347 xckg_d0 xcbiasn_xrb_s1 0.493f
C1348 vbp VSUBS 0.167f
C1349 vdda VSUBS 0.1f
C1350 ibias VSUBS 0.0703f
C1351 xckg_nn xref_ng 0.102f
C1352 xckg_x VSUBS 0.221f
C1353 sar_mclk VSUBS 0.448f
C1354 vdd vdda 0.244f
C1355 sar_mclk mclkb 0.121f
C1356 xckg_x VSUBS 0.0535f
C1357 sar_mclk xcbias_xrb_s2 0.204f
C1358 sar_mclk VSUBS 0.539f
C1359 vref_in xcbias_xrb_s2 0.3f
C1360 xcbias_xrb_s3 VSUBS 0.0888f
C1361 xckg_d0 vdd 0.1f
C1362 vref VSUBS 0.0888f
C1363 sar_mclk VSUBS 0.0556f
C1364 xcbias_xrb_s2 xref_na 0.859f
C1365 vrefl VSUBS 0.197f
C1366 vdd VSUBS 0.783f
C1367 xckg_d1 ibias 0.409f
C1368 xref_na VSUBS 0.0687f
C1369 sar_mclk VSUBS 0.231f
C1370 vref_in VSUBS 0.0579f
C1371 vrefl VSUBS 0.376f
C1372 xckg_d3 VSUBS 0.6f
C1373 xref_ng xcbias_xrb_s3 0.119f
C1374 xckg_nn VSUBS 0.137f
C1375 xref_ng ibias 0.137f
C1376 mclkb VSUBS 0.446f
C1377 vbp VSUBS 0.328f
C1378 xcbias_xrb_s3 VSUBS 0.476f
C1379 vdda VSUBS 0.329f
C1380 xckg_d3 xckg_x 0.0537f
C1381 xcbiasn_xrb_s2 VSUBS 0.114f
C1382 xckg_nn clk 0.391f
C1383 clk VSUBS 0.389f
C1384 xckg_nn VSUBS 0.13f
C1385 ibias VSUBS 0.102f
C1386 vref_in xcbiasn_xrb_s1 0.0681f
C1387 xcbias_xrb_s3 VSUBS 0.0616f
C1388 xref_ng vrefl 0.19f
C1389 xcbiasn_xrb_s3 VSUBS 0.14f
C1390 vss sar_mclk 0.212f
C1391 xcbias_xrb_s2 xckg_d2 0.442f
C1392 xcbiasn_xrb_s1 VSUBS 0.338f
C1393 xckg_d3 mclkb 0.102f
C1394 xcbias_xrb_s3 xref_na 0.209f
C1395 xcbiasn_xrb_s2 VSUBS 0.572f
C1396 vbp xckg_nn 0.175f
C1397 vdda xckg_nn 0.296f
C1398 xckg_x VSUBS 0.231f
C1399 mclkb VSUBS 0.0698f
C1400 xckg_d2 VSUBS 0.16f
C1401 xcbias_xrb_s1 vref_in 0.177f
C1402 xcbias_xrb_s1 VSUBS 0.153f
C1403 xcbiasn_xrb_s1 VSUBS 0.201f
C1404 xref_ng VSUBS 0.062f
C1405 xcbiasn_xrb_s3 sar_mclk 0.18f
C1406 vdd VSUBS 0.0618f
C1407 clk VSUBS 0.397f
C1408 vdda VSUBS 0.0483f
C1409 vrefl VSUBS 0.337f
C1410 xcbiasn_xrb_s1 VSUBS 0.0925f
C1411 clk xckg_nn 0.0337f
C1412 xcbiasn_xrb_s2 VSUBS 0.278f
C1413 vref_in VSUBS 0.192f
C1414 xcbias_xrb_s3 VSUBS 0.43f
C1415 vrefl vbp 0.099f
C1416 sar_mclk xckg_d2 0.733f
C1417 mclkb VSUBS 0.0519f
C1418 clk VSUBS 0.0937f
C1419 xckg_x ibias 0.0738f
C1420 vdda xcbiasn_xrb_s2 0.132f
C1421 xckg_x VSUBS 0.118f
C1422 xref_ntl VSUBS 0.121f
C1423 clk VSUBS 0.168f
C1424 vref clk 0.0746f
C1425 ibias VSUBS 0.179f
C1426 xcbiasn_xrb_s3 xckg_nn 0.11f
C1427 vrefl VSUBS 0.413f
C1428 xcbiasn_xrb_s3 xckg_x 0.0477f
C1429 ibias VSUBS 0.313f
C1430 clk xcbiasn_xrb_s2 0.12f
C1431 sar_mclk VSUBS 0.174f
C1432 xckg_d3 xckg_d2 0.14f
C1433 xref_ntl xcbias_xrb_s1 0.138f
C1434 xcbiasn_xrb_s2 VSUBS 0.116f
C1435 vref_in VSUBS 0.0475f
C1436 sar_mclk xckg_nn 0.169f
C1437 vdda xckg_d3 0.0725f
C1438 xref_na ibias 0.0461f
C1439 xckg_d2 VSUBS 0.48f
C1440 xref_ng VSUBS 0.718f
C1441 mclkb VSUBS 0.228f
C1442 vss VSUBS 0.109f
C1443 xref_ng xcbias_xrb_s3 0.0631f
C1444 xckg_x VSUBS 0.141f
C1445 xckg_d0 xckg_nn 0.157f
C1446 ibias xref_ntl 0.439f
C1447 xcbias_xrb_s1 mclkb 0.157f
C1448 xcbias_xrb_s1 xref_na 0.271f
C1449 sar_mclk VSUBS 0.113f
C1450 vdd xckg_x 0.314f
C1451 vrefl VSUBS 0.324f
C1452 xcbias_xrb_s2 xcbias_xrb_s1 0.148f
C1453 vrefl VSUBS 0.094f
C1454 mclkb VSUBS 0.0964f
C1455 xckg_nn VSUBS 0.0841f
C1456 vbn mclkb 0.414f
C1457 vref sar_mclk 0.125f
C1458 xref_na VSUBS 0.16f
C1459 xref_ng VSUBS 0.255f
C1460 vbn xcbiasn_xrb_s3 0.0237f
C1461 xref_ntl VSUBS 0.256f
C1462 vrefl mclkb 0.399f
C1463 vref xcbias_xrb_s1 0.114f
C1464 xckg_d1 VSUBS 0.0936f
C1465 vref VSUBS 0.157f
C1466 xcbiasn_xrb_s3 xcbiasn_xrb_s3 0.0171f
C1467 xcbias_xrb_s3 clk 0.127f
C1468 xcbias_xrb_s2 vrefl 0.168f
C1469 vrefl xckg_d0 0.367f
C1470 vref vbp 0.353f
C1471 xckg_x VSUBS 0.192f
C1472 mclkb xcbiasn_xrb_s1 0.149f
C1473 sar_mclk xcbiasn_xrb_s2 0.314f
C1474 xcbias_xrb_s1 VSUBS 0.0857f
C1475 vref_in vdd 0.133f
C1476 xcbiasn_xrb_s2 xckg_nn 0.0251f
C1477 xref_na VSUBS 0.109f
C1478 xcbias_xrb_s2 vrefl 0.231f
C1479 xckg_d3 VSUBS 0.637f
C1480 vref_in VSUBS 0.318f
C1481 vref xcbiasn_xrb_s2 0.118f
C1482 clk vbn 0.0739f
C1483 vref VSUBS 0.241f
C1484 mclkb VSUBS 0.0488f
C1485 xcbiasn_xrb_s1 vdda 0.0514f
C1486 xcbias_xrb_s2 VSUBS 0.166f
C1487 xckg_d0 VSUBS 0.54f
C1488 xcbias_xrb_s3 VSUBS 0.304f
C1489 vref_in xcbias_xrb_s1 0.0927f
C1490 xckg_d0 VSUBS 0.0788f
C1491 xcbias_xrb_s1 VSUBS 0.0316f
C1492 xcbiasn_xrb_s1 VSUBS 0.0578f
C1493 vbp VSUBS 0.441f
C1494 clk VSUBS 0.428f
C1495 xcbiasn_xrb_s3 VSUBS 0.298f
C1496 xckg_d3 vrefl 0.225f
C1497 vref_in xcbias_xrb_s2 0.178f
C1498 xckg_d1 VSUBS 0.0858f
C1499 vbn VSUBS 0.0729f
C1500 vdda VSUBS 0.69f
C1501 vrefl VSUBS 0.496f
C1502 xckg_d2 xckg_nn 0.105f
C1503 vref_in VSUBS 0.0822f
C1504 xcbiasn_xrb_s2 VSUBS 0.376f
C1505 xcbiasn_xrb_s1 VSUBS 0.513f
C1506 xckg_d2 ibias 0.14f
C1507 vss VSUBS 0.203f
C1508 xcbias_xrb_s2 VSUBS 0.343f
C1509 xref_na VSUBS 0.133f
C1510 clk VSUBS 0.22f
C1511 xckg_nn xckg_d0 0.614f
C1512 xcbiasn_xrb_s2 xckg_d1 0.0284f
C1513 xckg_x xref_na 0.0681f
C1514 vdd VSUBS 0.0547f
C1515 xcbias_xrb_s1 VSUBS 0.189f
C1516 vref VSUBS 0.239f
C1517 vss VSUBS 0.25f
C1518 vdd VSUBS 0.243f
C1519 vss vref_in 0.0606f
C1520 xcbias_xrb_s1 VSUBS 0.132f
C1521 vdd VSUBS 0.287f
C1522 xcbiasn_xrb_s3 xref_na 0.537f
C1523 vrefl vref_in 0.0972f
C1524 vbn VSUBS 0.824f
C1525 xcbiasn_xrb_s1 VSUBS 0.423f
C1526 xckg_x vbn 0.0774f
C1527 xckg_d3 VSUBS 0.344f
C1528 xckg_d2 xcbiasn_xrb_s1 0.118f
C1529 clk VSUBS 0.246f
C1530 xcbias_xrb_s3 sar_mclk 0.29f
C1531 sar_mclk VSUBS 0.057f
C1532 vbn VSUBS 0.338f
C1533 xcbias_xrb_s3 xckg_x 0.0392f
C1534 xref_ntl VSUBS 0.308f
C1535 xcbiasn_xrb_s3 VSUBS 0.391f
C1536 xckg_d2 VSUBS 0.0885f
C1537 vbp VSUBS 0.156f
C1538 vdda vrefl 0.0628f
C1539 xcbiasn_xrb_s1 xref_na 0.716f
C1540 vbn VSUBS 0.142f
C1541 xckg_d3 VSUBS 0.187f
C1542 xref_ng VSUBS 0.255f
C1543 xckg_d0 VSUBS 0.0931f
C1544 clk VSUBS 0.184f
C1545 xckg_d1 xckg_x 0.24f
C1546 vref_in VSUBS 0.0245f
C1547 xcbias_xrb_s2 VSUBS 0.0817f
C1548 vbn VSUBS 0.202f
C1549 xcbias_xrb_s1 VSUBS 0.107f
C1550 clk VSUBS 0.38f
C1551 xcbias_xrb_s1 mclkb 0.0643f
C1552 clk vbn 0.0678f
C1553 vbp xckg_d2 0.133f
C1554 xckg_nn xckg_d2 0.196f
C1555 xckg_d2 VSUBS 0.43f
C1556 vbn VSUBS 0.187f
C1557 vbp vrefl 0.113f
C1558 xckg_x VSUBS 0.117f
C1559 xcbiasn_xrb_s1 VSUBS 0.156f
C1560 xcbias_xrb_s2 VSUBS 0.364f
C1561 xcbiasn_xrb_s3 VSUBS 0.113f
C1562 mclkb xcbias_xrb_s2 0.229f
C1563 xckg_nn VSUBS 0.0684f
C1564 xckg_d1 xref_ng 0.0572f
C1565 xckg_d1 VSUBS 0.671f
C1566 xckg_d2 VSUBS 0.296f
C1567 xcbias_xrb_s1 VSUBS 0.0299f
C1568 vdd VSUBS 0.334f
C1569 vss xckg_nn 0.0674f
C1570 vdda vrefl 0.142f
C1571 xref_na vrefl 0.261f
C1572 xckg_d2 VSUBS 0.0657f
C1573 xcbias_xrb_s3 vref 0.169f
C1574 vref vbn 0.211f
C1575 xckg_d3 VSUBS 0.0681f
C1576 vrefl VSUBS 0.174f
C1577 xcbiasn_xrb_s1 ibias 0.422f
C1578 xckg_d2 vbn 0.163f
C1579 vdda xcbiasn_xrb_s2 0.596f
C1580 xcbiasn_xrb_s2 VSUBS 0.186f
C1581 vdda VSUBS 0.0536f
C1582 xcbias_xrb_s3 VSUBS 0.211f
C1583 xcbiasn_xrb_s2 VSUBS 0.207f
C1584 vbn VSUBS 0.0629f
C1585 vbn xcbiasn_xrb_s1 0.0375f
C1586 xckg_nn VSUBS 0.122f
C1587 vbp VSUBS 0.266f
C1588 vref_in xcbias_xrb_s1 0.116f
C1589 xcbiasn_xrb_s1 xckg_d0 0.148f
C1590 xcbias_xrb_s2 VSUBS 0.509f
C1591 xckg_d1 VSUBS 0.256f
C1592 xref_ng xckg_d0 0.249f
C1593 xckg_d3 VSUBS 0.17f
C1594 xcbiasn_xrb_s1 VSUBS 0.228f
C1595 sar_mclk VSUBS 0.129f
C1596 vbn VSUBS 0.352f
C1597 vbn xckg_x 0.0819f
C1598 xckg_d0 VSUBS 0.0575f
C1599 xref_na VSUBS 0.107f
C1600 xcbiasn_xrb_s3 VSUBS 0.0648f
C1601 xref_na VSUBS 0.0726f
C1602 sar_mclk vdd 0.0753f
C1603 xckg_d3 VSUBS 0.121f
C1604 xckg_nn VSUBS 0.219f
C1605 xcbiasn_xrb_s3 clk 0.638f
C1606 vref_in vbn 0.0512f
C1607 xckg_d3 VSUBS 0.142f
C1608 mclkb VSUBS 0.156f
C1609 vdda VSUBS 0.625f
C1610 xref_ntl VSUBS 0.182f
C1611 xckg_d3 VSUBS 0.0949f
C1612 xckg_d0 VSUBS 0.081f
C1613 vbn VSUBS 0.101f
C1614 vbp xckg_d0 0.187f
C1615 xcbiasn_xrb_s3 VSUBS 0.117f
C1616 ibias VSUBS 0.0527f
C1617 xcbiasn_xrb_s2 xckg_d1 0.42f
C1618 vdd VSUBS 0.188f
C1619 xckg_nn xref_na 0.127f
C1620 xref_ntl VSUBS 0.115f
C1621 vss VSUBS 0.261f
C1622 xref_ng VSUBS 0.0918f
C1623 xcbiasn_xrb_s1 xckg_d2 0.0843f
C1624 vref xref_na 0.0303f
C1625 xcbias_xrb_s3 VSUBS 0.206f
C1626 vss xref_ntl 0.11f
C1627 clk vbn 0.177f
C1628 vref VSUBS 0.434f
C1629 xckg_x VSUBS 0.0693f
C1630 vref_in VSUBS 0.045f
C1631 xckg_d3 vrefl 0.33f
C1632 clk VSUBS 0.079f
C1633 xref_ntl xckg_x 0.165f
C1634 xref_na VSUBS 0.0683f
C1635 xckg_d0 xcbiasn_xrb_s2 0.0708f
C1636 xcbiasn_xrb_s3 VSUBS 0.113f
C1637 vref xckg_d1 0.157f
C1638 ibias vdd 0.234f
C1639 xckg_x vbp 0.13f
C1640 clk VSUBS 0.482f
C1641 xcbias_xrb_s2 vref_in 0.222f
C1642 xckg_d1 VSUBS 0.215f
C1643 vss VSUBS 0.107f
C1644 xcbiasn_xrb_s3 xcbiasn_xrb_s3 0.0813f
C1645 sar_mclk VSUBS 0.389f
C1646 xref_na VSUBS 0.112f
C1647 xckg_d0 VSUBS 0.434f
C1648 xckg_d1 VSUBS 0.326f
C1649 vref_in VSUBS 0.198f
C1650 xckg_nn sar_mclk 0.0767f
C1651 xcbiasn_xrb_s1 clk 0.0578f
C1652 xcbiasn_xrb_s3 xckg_d0 0.169f
C1653 xckg_nn xckg_d3 0.0466f
C1654 xcbiasn_xrb_s2 VSUBS 0.266f
C1655 xref_ntl xref_ntl 0.483f
C1656 xcbias_xrb_s2 VSUBS 0.154f
C1657 xckg_nn xcbiasn_xrb_s2 0.346f
C1658 vrefl VSUBS 0.143f
C1659 xckg_d1 VSUBS 0.128f
C1660 vbp VSUBS 0.328f
C1661 vbp clk 0.0597f
C1662 vdd VSUBS 0.175f
C1663 xcbiasn_xrb_s2 xckg_d3 0.412f
C1664 vdd VSUBS 0.215f
C1665 vref_in xcbiasn_xrb_s1 0.109f
C1666 vss VSUBS 0.355f
C1667 mclkb VSUBS 1.42f
C1668 vrefl xcbias_xrb_s2 0.129f
C1669 xckg_d0 VSUBS 0.207f
C1670 xcbiasn_xrb_s1 VSUBS 0.24f
C1671 xcbias_xrb_s3 VSUBS 0.14f
C1672 xref_ng VSUBS 0.185f
C1673 xref_ng xcbiasn_xrb_s1 0.15f
C1674 xckg_d0 VSUBS 0.228f
C1675 xckg_nn VSUBS 0.358f
C1676 vbn xckg_d1 0.149f
C1677 sar_mclk VSUBS 0.255f
C1678 xckg_nn VSUBS 0.0799f
C1679 xckg_d3 VSUBS 0.289f
C1680 sar_mclk VSUBS 0.171f
C1681 vrefl VSUBS 0.166f
C1682 xref_ng VSUBS 0.403f
C1683 xckg_nn vrefl 0.536f
C1684 xcbiasn_xrb_s3 clk 0.229f
C1685 xckg_d3 VSUBS 0.12f
C1686 xckg_d2 VSUBS 0.0603f
C1687 ibias xckg_d3 0.0978f
C1688 xcbias_xrb_s3 ibias 0.432f
C1689 xcbias_xrb_s3 VSUBS 0.202f
C1690 vref_in xckg_nn 0.543f
C1691 xref_ng VSUBS 0.192f
C1692 xref_ng VSUBS 0.264f
C1693 xref_na VSUBS 0.142f
C1694 xckg_d3 VSUBS 0.0714f
C1695 xref_na ibias 0.18f
C1696 vdda vref_in 0.252f
C1697 xckg_nn VSUBS 0.161f
C1698 vrefl xref_na 0.205f
C1699 mclkb VSUBS 0.695f
C1700 xcbias_xrb_s1 xcbiasn_xrb_s1 0.0862f
C1701 vbn VSUBS 0.398f
C1702 xref_ng xref_ntl 0.189f
C1703 vbp VSUBS 0.221f
C1704 xckg_d1 VSUBS 0.138f
C1705 mclkb VSUBS 0.118f
C1706 vrefl VSUBS 0.424f
C1707 xckg_d1 VSUBS 0.384f
C1708 sar_mclk ibias 0.151f
C1709 clk xcbiasn_xrb_s1 0.107f
C1710 xref_ntl xcbiasn_xrb_s1 0.103f
C1711 vdda vref 0.0989f
C1712 xckg_d0 VSUBS 0.497f
C1713 xckg_d3 VSUBS 0.143f
C1714 ibias VSUBS 0.0665f
C1715 vbn VSUBS 0.151f
C1716 xref_ntl vref_in 0.0402f
C1717 xckg_x VSUBS 0.296f
C1718 xref_ng VSUBS 0.0404f
C1719 xcbiasn_xrb_s3 xckg_d3 0.321f
C1720 vref VSUBS 0.188f
C1721 vref_in VSUBS 0.0636f
C1722 xcbiasn_xrb_s1 VSUBS 0.0389f
C1723 xcbiasn_xrb_s3 VSUBS 0.411f
C1724 vref_in vrefl 0.164f
C1725 xref_na VSUBS 0.171f
C1726 vref_in VSUBS 0.076f
C1727 vss VSUBS 0.217f
C1728 vbp xcbiasn_xrb_s1 0.242f
C1729 xcbias_xrb_s1 vrefl 0.48f
C1730 vss VSUBS 0.0916f
C1731 clk VSUBS 0.342f
C1732 xref_ntl xref_ntl 0.172f
C1733 clk VSUBS 0.557f
C1734 mclkb VSUBS 0.0782f
C1735 ibias vref 0.158f
C1736 xckg_nn VSUBS 0.0797f
C1737 xckg_d1 vref 0.084f
C1738 xckg_d2 VSUBS 0.0908f
C1739 xref_ng xcbiasn_xrb_s3 0.129f
C1740 vdda sar_mclk 0.02f
C1741 vbn VSUBS 0.381f
C1742 xcbias_xrb_s2 VSUBS 0.216f
C1743 xcbiasn_xrb_s1 VSUBS 0.0527f
C1744 vbn VSUBS 0.041f
C1745 xckg_d1 VSUBS 0.219f
C1746 xckg_d1 clk 0.198f
C1747 mclkb mclkb 0.161f
C1748 vref VSUBS 0.0778f
C1749 vbn VSUBS 0.0423f
C1750 xcbias_xrb_s3 VSUBS 0.437f
C1751 xckg_d1 VSUBS 0.13f
C1752 ibias xckg_d2 0.0524f
C1753 xref_na VSUBS 0.0587f
C1754 sar_mclk xckg_d2 0.227f
C1755 vbn VSUBS 0.218f
C1756 vbp VSUBS 0.598f
C1757 xckg_nn mclkb 0.0497f
C1758 vbn xref_ng 0.124f
C1759 sar_mclk xckg_d2 0.0826f
C1760 vref VSUBS 0.209f
C1761 vref_in VSUBS 0.265f
C1762 xckg_d1 VSUBS 0.158f
C1763 sar_mclk sar_mclk 0.123f
C1764 xckg_d1 VSUBS 0.109f
C1765 xref_ng xcbiasn_xrb_s2 0.0672f
C1766 vref VSUBS 0.092f
C1767 xckg_d0 VSUBS 0.13f
C1768 xcbiasn_xrb_s1 xckg_x 0.364f
C1769 vss VSUBS 0.202f
C1770 xckg_d3 VSUBS 0.487f
C1771 vref xcbias_xrb_s1 0.106f
C1772 xckg_d2 VSUBS 0.171f
C1773 sar_mclk xckg_d2 0.228f
C1774 vss VSUBS 0.0789f
C1775 vbp VSUBS 0.0379f
C1776 vbp VSUBS 0.203f
C1777 xcbiasn_xrb_s3 VSUBS 0.103f
C1778 vdd VSUBS 0.125f
C1779 xckg_d1 VSUBS 0.306f
C1780 vss VSUBS 0.477f
C1781 xref_na xref_ng 0.328f
C1782 xcbias_xrb_s3 VSUBS 0.502f
C1783 xcbiasn_xrb_s1 xckg_d1 0.327f
C1784 xref_ntl VSUBS 0.11f
C1785 xckg_d3 VSUBS 0.198f
C1786 xref_ntl xckg_nn 0.531f
C1787 xckg_d3 VSUBS 0.494f
C1788 xcbias_xrb_s1 xref_ng 0.133f
C1789 vdd VSUBS 0.129f
C1790 xckg_x VSUBS 0.529f
C1791 clk VSUBS 0.155f
C1792 ibias xcbiasn_xrb_s2 0.259f
C1793 clk VSUBS 0.152f
C1794 xckg_d3 xref_ng 0.0804f
C1795 xcbias_xrb_s2 VSUBS 0.0571f
C1796 vref VSUBS 0.041f
C1797 vss xckg_d3 0.13f
C1798 vbp vbn 0.0702f
C1799 xckg_x xref_na 0.0417f
C1800 vdda vdda 0.14f
C1801 xckg_d0 vbp 0.159f
C1802 xref_na VSUBS 0.102f
C1803 vdda VSUBS 0.0869f
C1804 vref_in VSUBS 0.214f
C1805 vrefl VSUBS 0.717f
C1806 xcbias_xrb_s3 VSUBS 0.0296f
C1807 vdda xcbiasn_xrb_s3 0.501f
C1808 sar_mclk VSUBS 0.21f
C1809 xref_na xcbiasn_xrb_s2 0.707f
C1810 xckg_d0 clk 0.0905f
C1811 xcbias_xrb_s1 VSUBS 0.347f
C1812 vdd sar_mclk 0.258f
C1813 xref_na vref_in 0.581f
C1814 xcbias_xrb_s3 xcbias_xrb_s3 0.223f
C1815 xcbias_xrb_s3 xckg_nn 0.258f
C1816 xcbiasn_xrb_s2 VSUBS 0.512f
C1817 clk vref_in 0.287f
C1818 xckg_d0 xref_na 0.0843f
C1819 xckg_d1 VSUBS 0.197f
C1820 xckg_d3 VSUBS 0.112f
C1821 vdd VSUBS 0.0497f
C1822 xckg_nn xcbiasn_xrb_s3 0.0841f
C1823 vdd VSUBS 0.295f
C1824 vdd xcbiasn_xrb_s2 0.137f
C1825 vdda VSUBS 0.233f
C1826 vdda VSUBS 0.195f
C1827 xckg_d2 VSUBS 0.491f
C1828 xref_na xckg_x 0.244f
C1829 xckg_nn xckg_d1 0.224f
C1830 vdd xckg_x 0.0861f
C1831 xcbiasn_xrb_s2 VSUBS 0.256f
C1832 xcbias_xrb_s2 vref 0.158f
C1833 vbp mclkb 0.212f
C1834 xref_na VSUBS 0.254f
C1835 xref_na VSUBS 0.232f
C1836 xcbiasn_xrb_s3 vref 0.195f
C1837 vrefl VSUBS 0.0449f
C1838 ibias VSUBS 0.0485f
C1839 xckg_d2 VSUBS 0.144f
C1840 vbn xcbias_xrb_s2 0.372f
C1841 xcbias_xrb_s3 VSUBS 0.145f
C1842 vrefl VSUBS 0.186f
C1843 xref_ntl xcbiasn_xrb_s3 0.1f
C1844 xckg_d3 VSUBS 0.0982f
C1845 vdd xckg_x 0.14f
C1846 xcbiasn_xrb_s3 xckg_d1 0.475f
C1847 xref_na VSUBS 0.135f
C1848 sar_mclk VSUBS 0.204f
C1849 vref_in vref 0.176f
C1850 ibias VSUBS 0.611f
C1851 xckg_d2 xref_na 0.147f
C1852 vref_in VSUBS 0.15f
C1853 xckg_nn vref 0.403f
C1854 xref_ng xref_ng 0.058f
C1855 xckg_d2 VSUBS 0.0453f
C1856 xcbias_xrb_s3 xcbiasn_xrb_s3 0.253f
C1857 vbn VSUBS 0.485f
C1858 xcbiasn_xrb_s3 VSUBS 0.242f
C1859 xcbias_xrb_s3 xckg_d1 0.0212f
C1860 vref_in VSUBS 0.302f
C1861 vdda VSUBS 0.125f
C1862 xcbias_xrb_s2 VSUBS 0.217f
C1863 xckg_d0 xckg_d2 0.439f
C1864 xref_na xckg_d1 0.0444f
C1865 vref xref_ntl 0.0539f
C1866 xckg_nn VSUBS 0.303f
C1867 vdda VSUBS 0.171f
C1868 sar_mclk VSUBS 0.042f
C1869 vss VSUBS 0.215f
C1870 mclkb xref_na 0.0239f
C1871 xcbiasn_xrb_s2 VSUBS 0.0793f
C1872 vdd VSUBS 0.204f
C1873 clk VSUBS 0.0577f
C1874 xref_na VSUBS 0.267f
C1875 xcbias_xrb_s1 xref_ng 0.0547f
C1876 sar_mclk xckg_x 0.555f
C1877 vbn mclkb 0.194f
C1878 vref VSUBS 0.0975f
C1879 xcbiasn_xrb_s2 VSUBS 0.0916f
C1880 xckg_d3 clk 0.191f
C1881 vrefl VSUBS 0.0695f
C1882 xcbiasn_xrb_s3 VSUBS 0.0823f
C1883 vss xckg_d1 0.227f
C1884 vdda xckg_x 0.21f
C1885 xcbiasn_xrb_s1 xcbiasn_xrb_s1 0.358f
C1886 vref mclkb 0.139f
C1887 xckg_d3 VSUBS 0.156f
C1888 xcbiasn_xrb_s3 VSUBS 0.0287f
C1889 vbn VSUBS 0.382f
C1890 xckg_d2 vdda 0.458f
C1891 mclkb xcbiasn_xrb_s3 0.317f
C1892 vdd VSUBS 0.385f
C1893 xckg_nn VSUBS 0.126f
C1894 xcbiasn_xrb_s3 VSUBS 0.153f
C1895 xcbiasn_xrb_s3 VSUBS 0.0419f
C1896 xref_na vref 0.182f
C1897 vdd VSUBS 0.0469f
C1898 vss VSUBS 0.0959f
C1899 xref_ng vrefl 0.293f
C1900 xcbiasn_xrb_s3 VSUBS 0.254f
C1901 xref_ng xref_ntl 0.0709f
C1902 vbp xcbias_xrb_s1 0.16f
C1903 vbp VSUBS 0.115f
C1904 sar_mclk VSUBS 0.0982f
C1905 vrefl xckg_d0 0.18f
C1906 xckg_d2 VSUBS 0.164f
C1907 vbn VSUBS 0.338f
C1908 vdda VSUBS 0.421f
C1909 sar_mclk VSUBS 0.52f
C1910 xcbias_xrb_s1 xcbias_xrb_s2 0.237f
C1911 xref_na xckg_d3 0.13f
C1912 xref_ntl xcbias_xrb_s1 0.101f
C1913 xcbias_xrb_s3 VSUBS 0.165f
C1914 vbn VSUBS 0.181f
C1915 xckg_x VSUBS 0.0635f
C1916 xckg_d0 VSUBS 0.21f
C1917 xckg_nn VSUBS 0.0722f
C1918 xref_ng VSUBS 0.0181f
C1919 xckg_d0 xckg_d3 0.541f
C1920 xcbias_xrb_s3 xref_ntl 0.0487f
C1921 sar_mclk xcbias_xrb_s2 0.114f
C1922 xckg_d1 vrefl 0.173f
C1923 xcbias_xrb_s2 VSUBS 0.351f
C1924 xcbias_xrb_s1 VSUBS 0.265f
C1925 xckg_nn VSUBS 0.21f
C1926 vdda VSUBS 0.084f
C1927 xcbiasn_xrb_s2 VSUBS 0.0368f
C1928 vref_in VSUBS 0.417f
C1929 xref_na VSUBS 0.416f
C1930 vbn VSUBS 0.131f
C1931 xref_ng VSUBS 0.227f
C1932 xckg_x VSUBS 0.154f
C1933 xcbias_xrb_s2 VSUBS 0.115f
C1934 xckg_d2 VSUBS 0.134f
C1935 xcbiasn_xrb_s3 VSUBS 0.368f
C1936 xref_ntl xckg_d3 0.251f
C1937 xref_ntl xref_ntl 0.122f
C1938 xckg_nn VSUBS 0.174f
C1939 xckg_d3 VSUBS 0.081f
C1940 vbp VSUBS 0.18f
C1941 xref_na xckg_d2 0.0276f
C1942 xcbiasn_xrb_s1 VSUBS 0.108f
C1943 vdda xcbiasn_xrb_s3 0.152f
C1944 xckg_x VSUBS 0.0417f
C1945 xcbiasn_xrb_s3 VSUBS 0.115f
C1946 mclkb VSUBS 0.0607f
C1947 vref_in VSUBS 0.149f
C1948 xref_ng mclkb 0.151f
C1949 vbn VSUBS 0.346f
C1950 xcbiasn_xrb_s2 VSUBS 0.0972f
C1951 vss xref_na 0.11f
C1952 xcbias_xrb_s1 vrefl 0.406f
C1953 xckg_x xckg_d2 0.488f
C1954 vbn VSUBS 0.314f
C1955 vdda VSUBS 0.176f
C1956 clk xcbiasn_xrb_s3 0.263f
C1957 xcbias_xrb_s1 VSUBS 0.198f
C1958 sar_mclk vbp 0.239f
C1959 xckg_d1 VSUBS 0.0651f
C1960 vdda VSUBS 0.431f
C1961 vdda VSUBS 0.252f
C1962 vbn clk 0.126f
C1963 xckg_x VSUBS 0.121f
C1964 xcbiasn_xrb_s1 xref_na 0.0829f
C1965 xckg_x VSUBS 0.0272f
C1966 mclkb vrefl 0.102f
C1967 vss vref 0.0584f
C1968 xckg_nn VSUBS 0.183f
C1969 xcbiasn_xrb_s1 xckg_d3 0.257f
C1970 xref_ng vbp 0.0372f
C1971 xref_na VSUBS 0.166f
C1972 xref_ng xcbias_xrb_s3 0.218f
C1973 xref_ntl VSUBS 0.0605f
C1974 xcbias_xrb_s2 xckg_d3 0.252f
C1975 xcbias_xrb_s2 VSUBS 0.261f
C1976 xckg_d3 VSUBS 0.274f
C1977 xcbias_xrb_s1 xcbiasn_xrb_s1 0.485f
C1978 xcbiasn_xrb_s2 VSUBS 0.24f
C1979 xcbiasn_xrb_s3 VSUBS 0.572f
C1980 xcbias_xrb_s3 VSUBS 0.268f
C1981 vref_in xcbias_xrb_s3 0.164f
C1982 mclkb xckg_d0 0.116f
C1983 vss VSUBS 0.224f
C1984 xref_ntl VSUBS 0.233f
C1985 mclkb vbn 0.104f
C1986 mclkb xckg_d1 0.244f
C1987 vref_in VSUBS 0.127f
C1988 xcbias_xrb_s3 VSUBS 0.0631f
C1989 vdda xcbiasn_xrb_s2 0.0549f
C1990 clk xckg_d2 0.134f
C1991 xref_ntl xcbiasn_xrb_s2 0.129f
C1992 vbp VSUBS 0.199f
C1993 xref_ntl VSUBS 0.145f
C1994 vbp VSUBS 0.0567f
C1995 xckg_nn xckg_d0 0.11f
C1996 vref_in xcbias_xrb_s2 0.785f
C1997 xcbiasn_xrb_s1 VSUBS 0.121f
C1998 mclkb VSUBS 0.147f
C1999 vref_in VSUBS 0.113f
