* r1_adc layout-mapped simulation netlist, written by sim/post/make_sim_netlist.py (do not edit)
* devices: layout/r1_adc_netlist.py (sha256 a04d6f2b237aafa1), netlist of record schematic/r1_adc_r5.spice (sha256 340c0e6a17ecec3a)
* decap shapes: layout/r1_adc_decap.json
* parasitics: {"slice": "sim/post/scratch/synth_rc_slice.spice", "top": "sim/post/scratch/synth_rc_top.spice"}
* identical parallel devices merged into m = count (552 -> 179 slice, 56 -> 45 top devices; exact for net-name parasitics; --no-merge writes every drawn device)
* requires cornerMOSlv/hv.lib, cornerCAP.lib, cornerRES.lib
.subckt r1_adc_slice_lay in0p in0n in1p in1n trk0 trk1 cp0 cp1 cp2 cp3 cp4 cp5 cp6 cp7 cp8 cp9 cp10 cp11 cp12 cn0 cn1 cn2 cn3 cn4 cn5 cn6 cn7 cn8 cn9 cn10 cn11 cn12 clk clkb clkn clknb op on onp onn vbp vbn vref vrefl top_p top_n vdd gnd
Xxpt0a t0b trk0 vdd vdd sg13_lv_pmos w=2u l=0.13u ng=1 m=1
Xxnt0a t0b trk0 gnd gnd sg13_lv_nmos w=1u l=0.13u ng=1 m=1
Xxpt0b t0 t0b vdd vdd sg13_lv_pmos w=4u l=0.13u ng=1 m=1
Xxnt0b t0 t0b gnd gnd sg13_lv_nmos w=2u l=0.13u ng=1 m=1
Xxpt1a t1b trk1 vdd vdd sg13_lv_pmos w=2u l=0.13u ng=1 m=1
Xxnt1a t1b trk1 gnd gnd sg13_lv_nmos w=1u l=0.13u ng=1 m=1
Xxpt1b t1 t1b vdd vdd sg13_lv_pmos w=4u l=0.13u ng=1 m=1
Xxnt1b t1 t1b gnd gnd sg13_lv_nmos w=2u l=0.13u ng=1 m=1
Xxs0p_xms in0p xs0p_g top_p gnd sg13_lv_nmos w=6u l=0.13u ng=2 m=1
Xxs0p_cboot xs0p_cbp xs0p_cbn cap_cmim w=11.49u l=11.49u m=1
Xxs0p_xm1 xs0p_cbn t0b gnd gnd sg13_lv_nmos w=1u l=0.13u ng=1 m=1
Xxs0p_xm3 xs0p_cbp xs0p_g vdd xs0p_cbp sg13_lv_pmos w=1u l=0.13u ng=1 m=1
Xxs0p_xm8 xs0p_g xs0p_x xs0p_cbp xs0p_cbp sg13_lv_pmos w=2u l=0.13u ng=1 m=1
Xxs0p_xm4 xs0p_x t0 vdd vdd sg13_lv_pmos w=0.5u l=0.13u ng=1 m=1
Xxs0p_xm5 xs0p_x t0 xs0p_cbn gnd sg13_lv_nmos w=1u l=0.13u ng=1 m=1
Xxs0p_xm7 xs0p_x xs0p_g xs0p_cbn gnd sg13_lv_nmos w=0.5u l=0.13u ng=1 m=1
Xxs0p_xm9 xs0p_cbn xs0p_g in0p gnd sg13_lv_nmos w=2u l=0.13u ng=1 m=1
Xxs0p_xm10 xs0p_g vdd xs0p_n10 gnd sg13_lv_nmos w=2u l=0.13u ng=1 m=1
Xxs0p_xm11 xs0p_n10 t0b gnd gnd sg13_lv_nmos w=2u l=0.13u ng=1 m=1
Xxs0n_xms in0n xs0n_g top_n gnd sg13_lv_nmos w=6u l=0.13u ng=2 m=1
Xxs0n_cboot xs0n_cbp xs0n_cbn cap_cmim w=11.49u l=11.49u m=1
Xxs0n_xm1 xs0n_cbn t0b gnd gnd sg13_lv_nmos w=1u l=0.13u ng=1 m=1
Xxs0n_xm3 xs0n_cbp xs0n_g vdd xs0n_cbp sg13_lv_pmos w=1u l=0.13u ng=1 m=1
Xxs0n_xm8 xs0n_g xs0n_x xs0n_cbp xs0n_cbp sg13_lv_pmos w=2u l=0.13u ng=1 m=1
Xxs0n_xm4 xs0n_x t0 vdd vdd sg13_lv_pmos w=0.5u l=0.13u ng=1 m=1
Xxs0n_xm5 xs0n_x t0 xs0n_cbn gnd sg13_lv_nmos w=1u l=0.13u ng=1 m=1
Xxs0n_xm7 xs0n_x xs0n_g xs0n_cbn gnd sg13_lv_nmos w=0.5u l=0.13u ng=1 m=1
Xxs0n_xm9 xs0n_cbn xs0n_g in0n gnd sg13_lv_nmos w=2u l=0.13u ng=1 m=1
Xxs0n_xm10 xs0n_g vdd xs0n_n10 gnd sg13_lv_nmos w=2u l=0.13u ng=1 m=1
Xxs0n_xm11 xs0n_n10 t0b gnd gnd sg13_lv_nmos w=2u l=0.13u ng=1 m=1
Xxs1p_xms in1p xs1p_g top_p gnd sg13_lv_nmos w=6u l=0.13u ng=2 m=1
Xxs1p_cboot xs1p_cbp xs1p_cbn cap_cmim w=11.49u l=11.49u m=1
Xxs1p_xm1 xs1p_cbn t1b gnd gnd sg13_lv_nmos w=1u l=0.13u ng=1 m=1
Xxs1p_xm3 xs1p_cbp xs1p_g vdd xs1p_cbp sg13_lv_pmos w=1u l=0.13u ng=1 m=1
Xxs1p_xm8 xs1p_g xs1p_x xs1p_cbp xs1p_cbp sg13_lv_pmos w=2u l=0.13u ng=1 m=1
Xxs1p_xm4 xs1p_x t1 vdd vdd sg13_lv_pmos w=0.5u l=0.13u ng=1 m=1
Xxs1p_xm5 xs1p_x t1 xs1p_cbn gnd sg13_lv_nmos w=1u l=0.13u ng=1 m=1
Xxs1p_xm7 xs1p_x xs1p_g xs1p_cbn gnd sg13_lv_nmos w=0.5u l=0.13u ng=1 m=1
Xxs1p_xm9 xs1p_cbn xs1p_g in1p gnd sg13_lv_nmos w=2u l=0.13u ng=1 m=1
Xxs1p_xm10 xs1p_g vdd xs1p_n10 gnd sg13_lv_nmos w=2u l=0.13u ng=1 m=1
Xxs1p_xm11 xs1p_n10 t1b gnd gnd sg13_lv_nmos w=2u l=0.13u ng=1 m=1
Xxs1n_xms in1n xs1n_g top_n gnd sg13_lv_nmos w=6u l=0.13u ng=2 m=1
Xxs1n_cboot xs1n_cbp xs1n_cbn cap_cmim w=11.49u l=11.49u m=1
Xxs1n_xm1 xs1n_cbn t1b gnd gnd sg13_lv_nmos w=1u l=0.13u ng=1 m=1
Xxs1n_xm3 xs1n_cbp xs1n_g vdd xs1n_cbp sg13_lv_pmos w=1u l=0.13u ng=1 m=1
Xxs1n_xm8 xs1n_g xs1n_x xs1n_cbp xs1n_cbp sg13_lv_pmos w=2u l=0.13u ng=1 m=1
Xxs1n_xm4 xs1n_x t1 vdd vdd sg13_lv_pmos w=0.5u l=0.13u ng=1 m=1
Xxs1n_xm5 xs1n_x t1 xs1n_cbn gnd sg13_lv_nmos w=1u l=0.13u ng=1 m=1
Xxs1n_xm7 xs1n_x xs1n_g xs1n_cbn gnd sg13_lv_nmos w=0.5u l=0.13u ng=1 m=1
Xxs1n_xm9 xs1n_cbn xs1n_g in1n gnd sg13_lv_nmos w=2u l=0.13u ng=1 m=1
Xxs1n_xm10 xs1n_g vdd xs1n_n10 gnd sg13_lv_nmos w=2u l=0.13u ng=1 m=1
Xxs1n_xm11 xs1n_n10 t1b gnd gnd sg13_lv_nmos w=2u l=0.13u ng=1 m=1
Xxpr1 rstb_n t0b vdd vdd sg13_lv_pmos w=1u l=0.13u ng=1 m=1
Xxpr2 rstb_n t1b vdd vdd sg13_lv_pmos w=1u l=0.13u ng=1 m=1
Xxnr1 rstb_n t0b nr gnd sg13_lv_nmos w=1u l=0.13u ng=1 m=1
Xxnr2 nr t1b gnd gnd sg13_lv_nmos w=1u l=0.13u ng=1 m=1
Xxpr3 rstb rstb_n vdd vdd sg13_lv_pmos w=1u l=0.13u ng=1 m=1
Xxnr3 rstb rstb_n gnd gnd sg13_lv_nmos w=0.5u l=0.13u ng=1 m=1
Xxlrp lsb_p rstb vrefl vrefl sg13_lv_pmos w=1u l=0.13u ng=1 m=1
Xxlrn lsb_n rstb vrefl vrefl sg13_lv_pmos w=1u l=0.13u ng=1 m=1
Xxdp12_xmp bp12 cp12 vref vref sg13_lv_pmos w=2u l=0.13u ng=1 m=1
Xxdp12_xmn bp12 cp12 gnd gnd sg13_lv_nmos w=1u l=0.13u ng=1 m=1
Xxdp11_xmp bp11 cp11 vref vref sg13_lv_pmos w=2u l=0.13u ng=1 m=1
Xxdp11_xmn bp11 cp11 gnd gnd sg13_lv_nmos w=1u l=0.13u ng=1 m=1
Xxdp10_xmp bp10 cp10 vref vref sg13_lv_pmos w=2u l=0.13u ng=1 m=1
Xxdp10_xmn bp10 cp10 gnd gnd sg13_lv_nmos w=1u l=0.13u ng=1 m=1
Xxdp9_xmp bp9 cp9 vref vref sg13_lv_pmos w=1u l=0.13u ng=1 m=1
Xxdp9_xmn bp9 cp9 gnd gnd sg13_lv_nmos w=0.5u l=0.13u ng=1 m=1
Xxdp8_xmp bp8 cp8 vref vref sg13_lv_pmos w=1u l=0.13u ng=1 m=1
Xxdp8_xmn bp8 cp8 gnd gnd sg13_lv_nmos w=0.5u l=0.13u ng=1 m=1
Xxdp7_xmp bp7 cp7 vrefl vrefl sg13_lv_pmos w=1u l=0.13u ng=1 m=1
Xxdp7_xmn bp7 cp7 gnd gnd sg13_lv_nmos w=0.5u l=0.13u ng=1 m=1
Xxdp6_xmp bp6 cp6 vrefl vrefl sg13_lv_pmos w=1u l=0.13u ng=1 m=1
Xxdp6_xmn bp6 cp6 gnd gnd sg13_lv_nmos w=0.5u l=0.13u ng=1 m=1
Xxdp5_xmp bp5 cp5 vrefl vrefl sg13_lv_pmos w=1u l=0.13u ng=1 m=1
Xxdp5_xmn bp5 cp5 gnd gnd sg13_lv_nmos w=0.5u l=0.13u ng=1 m=1
Xxdp4_xmp bp4 cp4 vrefl vrefl sg13_lv_pmos w=1u l=0.13u ng=1 m=1
Xxdp4_xmn bp4 cp4 gnd gnd sg13_lv_nmos w=0.5u l=0.13u ng=1 m=1
Xxdp3_xmp bp3 cp3 vrefl vrefl sg13_lv_pmos w=1u l=0.13u ng=1 m=1
Xxdp3_xmn bp3 cp3 gnd gnd sg13_lv_nmos w=0.5u l=0.13u ng=1 m=1
Xxdp2_xmp bp2 cp2 vrefl vrefl sg13_lv_pmos w=1u l=0.13u ng=1 m=1
Xxdp2_xmn bp2 cp2 gnd gnd sg13_lv_nmos w=0.5u l=0.13u ng=1 m=1
Xxdp1_xmp bp1 cp1 vrefl vrefl sg13_lv_pmos w=1u l=0.13u ng=1 m=1
Xxdp1_xmn bp1 cp1 gnd gnd sg13_lv_nmos w=0.5u l=0.13u ng=1 m=1
Xxdp0_xmp bp0 cp0 vrefl vrefl sg13_lv_pmos w=1u l=0.13u ng=1 m=1
Xxdp0_xmn bp0 cp0 gnd gnd sg13_lv_nmos w=0.5u l=0.13u ng=1 m=1
Xxdn12_xmp bn12 cn12 vref vref sg13_lv_pmos w=2u l=0.13u ng=1 m=1
Xxdn12_xmn bn12 cn12 gnd gnd sg13_lv_nmos w=1u l=0.13u ng=1 m=1
Xxdn11_xmp bn11 cn11 vref vref sg13_lv_pmos w=2u l=0.13u ng=1 m=1
Xxdn11_xmn bn11 cn11 gnd gnd sg13_lv_nmos w=1u l=0.13u ng=1 m=1
Xxdn10_xmp bn10 cn10 vref vref sg13_lv_pmos w=2u l=0.13u ng=1 m=1
Xxdn10_xmn bn10 cn10 gnd gnd sg13_lv_nmos w=1u l=0.13u ng=1 m=1
Xxdn9_xmp bn9 cn9 vref vref sg13_lv_pmos w=1u l=0.13u ng=1 m=1
Xxdn9_xmn bn9 cn9 gnd gnd sg13_lv_nmos w=0.5u l=0.13u ng=1 m=1
Xxdn8_xmp bn8 cn8 vref vref sg13_lv_pmos w=1u l=0.13u ng=1 m=1
Xxdn8_xmn bn8 cn8 gnd gnd sg13_lv_nmos w=0.5u l=0.13u ng=1 m=1
Xxdn7_xmp bn7 cn7 vrefl vrefl sg13_lv_pmos w=1u l=0.13u ng=1 m=1
Xxdn7_xmn bn7 cn7 gnd gnd sg13_lv_nmos w=0.5u l=0.13u ng=1 m=1
Xxdn6_xmp bn6 cn6 vrefl vrefl sg13_lv_pmos w=1u l=0.13u ng=1 m=1
Xxdn6_xmn bn6 cn6 gnd gnd sg13_lv_nmos w=0.5u l=0.13u ng=1 m=1
Xxdn5_xmp bn5 cn5 vrefl vrefl sg13_lv_pmos w=1u l=0.13u ng=1 m=1
Xxdn5_xmn bn5 cn5 gnd gnd sg13_lv_nmos w=0.5u l=0.13u ng=1 m=1
Xxdn4_xmp bn4 cn4 vrefl vrefl sg13_lv_pmos w=1u l=0.13u ng=1 m=1
Xxdn4_xmn bn4 cn4 gnd gnd sg13_lv_nmos w=0.5u l=0.13u ng=1 m=1
Xxdn3_xmp bn3 cn3 vrefl vrefl sg13_lv_pmos w=1u l=0.13u ng=1 m=1
Xxdn3_xmn bn3 cn3 gnd gnd sg13_lv_nmos w=0.5u l=0.13u ng=1 m=1
Xxdn2_xmp bn2 cn2 vrefl vrefl sg13_lv_pmos w=1u l=0.13u ng=1 m=1
Xxdn2_xmn bn2 cn2 gnd gnd sg13_lv_nmos w=0.5u l=0.13u ng=1 m=1
Xxdn1_xmp bn1 cn1 vrefl vrefl sg13_lv_pmos w=1u l=0.13u ng=1 m=1
Xxdn1_xmn bn1 cn1 gnd gnd sg13_lv_nmos w=0.5u l=0.13u ng=1 m=1
Xxdn0_xmp bn0 cn0 vrefl vrefl sg13_lv_pmos w=1u l=0.13u ng=1 m=1
Xxdn0_xmn bn0 cn0 gnd gnd sg13_lv_nmos w=0.5u l=0.13u ng=1 m=1
Xxc4_xs1_xmt1 xc4_xs1_tail0 clkb vdd vdd sg13_lv_pmos w=16u l=0.13u ng=4 m=1
Xxc4_xs1_xmtc xc4_xs1_tail vbp xc4_xs1_tail0 vdd sg13_lv_pmos w=16u l=0.5u ng=2 m=1
Xxc4_xs1_xm1 xc4_dip top_p xc4_xs1_tail vdd sg13_lv_pmos w=48u l=0.3u ng=12 m=1
Xxc4_xs1_xm2 xc4_din top_n xc4_xs1_tail vdd sg13_lv_pmos w=48u l=0.3u ng=12 m=1
Xxc4_xci1 vdd xc4_dip vdd vdd sg13_lv_pmos w=80u l=4u ng=4 m=1
Xxc4_xci2 vdd xc4_din vdd vdd sg13_lv_pmos w=80u l=4u ng=4 m=1
Xxc4_xmr1 xc4_dip clkb gnd gnd sg13_lv_nmos w=20u l=0.13u ng=1 m=1
Xxc4_xmr2 xc4_din clkb gnd gnd sg13_lv_nmos w=20u l=0.13u ng=1 m=1
Xxc4_xmt2 xc4_lt clk gnd gnd sg13_lv_nmos w=4u l=0.13u ng=1 m=1
Xxc4_xmn1 op on xc4_lt gnd sg13_lv_nmos w=2u l=0.13u ng=1 m=1
Xxc4_xmn2 on op xc4_lt gnd sg13_lv_nmos w=2u l=0.13u ng=1 m=1
Xxc4_xmp1 op on vdd vdd sg13_lv_pmos w=2u l=0.13u ng=1 m=1
Xxc4_xmp2 on op vdd vdd sg13_lv_pmos w=2u l=0.13u ng=1 m=1
Xxc4_xmh1 op xc4_dip vdd vdd sg13_lv_pmos w=8u l=0.13u ng=2 m=1
Xxc4_xmh2 on xc4_din vdd vdd sg13_lv_pmos w=8u l=0.13u ng=2 m=1
Xxc4_xbp1 xc4_outpb op vdd vdd sg13_lv_pmos w=1u l=0.13u ng=1 m=1
Xxc4_xbn1 xc4_outpb op gnd gnd sg13_lv_nmos w=0.5u l=0.13u ng=1 m=1
Xxc4_xbp2 xc4_outnb on vdd vdd sg13_lv_pmos w=1u l=0.13u ng=1 m=1
Xxc4_xbn2 xc4_outnb on gnd gnd sg13_lv_nmos w=0.5u l=0.13u ng=1 m=1
Xxc5_xs1_xmt1 xc5_xs1_tail0 clkn gnd gnd sg13_lv_nmos w=8u l=0.13u ng=2 m=1
Xxc5_xs1_xmtc xc5_xs1_tail vbn xc5_xs1_tail0 gnd sg13_lv_nmos w=4u l=0.5u ng=1 m=1
Xxc5_xs1_xm1 xc5_dip top_p xc5_xs1_tail gnd sg13_lv_nmos w=16u l=0.5u ng=4 m=1
Xxc5_xs1_xm2 xc5_din top_n xc5_xs1_tail gnd sg13_lv_nmos w=16u l=0.5u ng=4 m=1
Xxc5_xci1 gnd xc5_dip gnd gnd sg13_lv_nmos w=30u l=4u ng=2 m=1
Xxc5_xci2 gnd xc5_din gnd gnd sg13_lv_nmos w=30u l=4u ng=2 m=1
Xxc5_xmr1 xc5_dip clkn vdd vdd sg13_lv_pmos w=16u l=0.13u ng=1 m=1
Xxc5_xmr2 xc5_din clkn vdd vdd sg13_lv_pmos w=16u l=0.13u ng=1 m=1
Xxc5_xmt2 xc5_lt clknb vdd vdd sg13_lv_pmos w=8u l=0.13u ng=1 m=1
Xxc5_xmp1 onp onn xc5_lt vdd sg13_lv_pmos w=4u l=0.13u ng=1 m=1
Xxc5_xmp2 onn onp xc5_lt vdd sg13_lv_pmos w=4u l=0.13u ng=1 m=1
Xxc5_xmn1 onp onn gnd gnd sg13_lv_nmos w=1u l=0.13u ng=1 m=1
Xxc5_xmn2 onn onp gnd gnd sg13_lv_nmos w=1u l=0.13u ng=1 m=1
Xxc5_xmh1 onp xc5_dip gnd gnd sg13_lv_nmos w=8u l=0.13u ng=1 m=1
Xxc5_xmh2 onn xc5_din gnd gnd sg13_lv_nmos w=8u l=0.13u ng=1 m=1
Xxc5_xbp1 xc5_outpb onp vdd vdd sg13_lv_pmos w=1u l=0.13u ng=1 m=1
Xxc5_xbn1 xc5_outpb onp gnd gnd sg13_lv_nmos w=0.5u l=0.13u ng=1 m=1
Xxc5_xbp2 xc5_outnb onn vdd vdd sg13_lv_pmos w=1u l=0.13u ng=1 m=1
Xxc5_xbn2 xc5_outnb onn gnd gnd sg13_lv_nmos w=0.5u l=0.13u ng=1 m=1
Xxdacp_xc12_u0 top_p bp12 cap_cmim w=3.78u l=3.78u m=16
Xxdacp_xc11_u0 top_p bp11 cap_cmim w=3.78u l=3.78u m=8
Xxdacp_xc10_u0 top_p bp10 cap_cmim w=3.78u l=3.78u m=4
Xxdacp_xc9_u0 top_p bp9 cap_cmim w=3.78u l=3.78u m=2
Xxdacp_xc8_u0 top_p bp8 cap_cmim w=3.78u l=3.78u m=1
Xxdacp_xcb top_p lsb_p cap_cmim w=4.23u l=4.23u m=1
Xxdacp_xc7_u0 lsb_p bp7 cap_cmim w=3.78u l=3.78u m=64
Xxdacp_xc6_u0 lsb_p bp6 cap_cmim w=3.78u l=3.78u m=32
Xxdacp_xc5_u0 lsb_p bp5 cap_cmim w=3.78u l=3.78u m=16
Xxdacp_xc4_u0 lsb_p bp4 cap_cmim w=3.78u l=3.78u m=8
Xxdacp_xc3_u0 lsb_p bp3 cap_cmim w=3.78u l=3.78u m=4
Xxdacp_xc2_u0 lsb_p bp2 cap_cmim w=3.78u l=3.78u m=2
Xxdacp_xc1_u0 lsb_p bp1 cap_cmim w=3.78u l=3.78u m=1
Xxdacp_xc0 lsb_p bp0 cap_cmim w=2.67u l=2.67u m=1
Xxdacn_xc12_u0 top_n bn12 cap_cmim w=3.78u l=3.78u m=16
Xxdacn_xc11_u0 top_n bn11 cap_cmim w=3.78u l=3.78u m=8
Xxdacn_xc10_u0 top_n bn10 cap_cmim w=3.78u l=3.78u m=4
Xxdacn_xc9_u0 top_n bn9 cap_cmim w=3.78u l=3.78u m=2
Xxdacn_xc8_u0 top_n bn8 cap_cmim w=3.78u l=3.78u m=1
Xxdacn_xcb top_n lsb_n cap_cmim w=4.23u l=4.23u m=1
Xxdacn_xc7_u0 lsb_n bn7 cap_cmim w=3.78u l=3.78u m=64
Xxdacn_xc6_u0 lsb_n bn6 cap_cmim w=3.78u l=3.78u m=32
Xxdacn_xc5_u0 lsb_n bn5 cap_cmim w=3.78u l=3.78u m=16
Xxdacn_xc4_u0 lsb_n bn4 cap_cmim w=3.78u l=3.78u m=8
Xxdacn_xc3_u0 lsb_n bn3 cap_cmim w=3.78u l=3.78u m=4
Xxdacn_xc2_u0 lsb_n bn2 cap_cmim w=3.78u l=3.78u m=2
Xxdacn_xc1_u0 lsb_n bn1 cap_cmim w=3.78u l=3.78u m=1
Xxdacn_xc0 lsb_n bn0 cap_cmim w=2.67u l=2.67u m=1
Xxdmy_u0 gnd gnd cap_cmim w=3.78u l=3.78u m=82
* not drawn: comparator output loads (SAR flip-flop input model), ideal as in the netlist of record
Cld_xc4_outpb xc4_outpb gnd 3f
Cld_xc4_outnb xc4_outnb gnd 3f
Cld_xc5_outpb xc5_outpb gnd 3f
Cld_xc5_outnb xc5_outnb gnd 3f
* parasitics, scope slice_a: 3010 C (9.587e-13 F total), 1500 R, 1500 internal nodes
Cps0 bn0 bn3 3.9e-17
Cps1 bn0 bn6 2.5e-16
Cps2 bn0 bp8 2.41e-16
Cps3 bn0 clkn 1.49e-16
Cps4 bn0 cn1 7.93e-17
Cps5 bn0 cn2 4.61e-17
Cps6 bn0 cn6 2.57e-16
Cps7 bn0 cp1 3.18e-16
Cps8 bn0 cp2 4.45e-17
Cps9 bn0 cp4 9.16e-17
Cps10 bn0 gnd 4.1316e-15
Cps11 bn0 in0p 6.28e-17
Cps12 bn0 in1p 1.24e-16
Cps13 bn0 on 4.86e-17
Cps14 bn0 rstb_n 3.39e-17
Cps15 bn0 vbn 2.83e-16
Cps16 bn0 vbp 2.11e-16
Cps17 bn0 vref 1.32e-16
Cps18 bn0 xc4_din 4.33e-17
Cps19 bn0 xc4_dip 1.05e-16
Cps20 bn0 xc4_xs1_tail0 3.93e-16
Cps21 bn0 xc5_xs1_tail0 1.3e-16
Cps22 bn0 xs0n_x 2.95e-16
Cps23 bn0 xs0p_cbn 1.31e-16
Cps24 bn0 xs0p_n10 5.43e-17
Cps25 bn0 xs1n_cbp 5.49e-17
Cps26 bn0 xs1n_g 2.63e-16
Cps27 bn0 xs1n_x 1.38e-16
Cps28 bn0 xs1p_n10 1.99e-16
Cps29 bn1 bn3 1.15e-16
Cps30 bn1 bn6 2.69e-17
Cps31 bn1 bp1 6.13e-16
Cps32 bn1 bp11 1.34e-16
Cps33 bn1 cp11 6.41e-17
Cps34 bn1 cp12 3.09e-16
Cps35 bn1 cp6 5.49e-17
Cps36 bn1 cp9 2.674e-16
Cps37 bn1 gnd 4.1925e-15
Cps38 bn1 onp 7.33e-17
Cps39 bn1 rstb 8.58e-17
Cps40 bn1 rstb_n 2.69e-17
Cps41 bn1 t0 1.69e-16
Cps42 bn1 t1 1.45e-16
Cps43 bn1 vrefl 3.66e-16
Cps44 bn1 xc4_outnb 6.04e-17
Cps45 bn1 xs0n_cbp 1.7e-16
Cps46 bn1 xs0p_x 1.54e-15
Cps47 bn1 xs1n_g 1.84e-16
Cps48 bn10 bn12 4.16e-17
Cps49 bn10 bn2 7.29e-17
Cps50 bn10 bn4 1.75e-16
Cps51 bn10 bn6 3.42e-16
Cps52 bn10 bp1 1.41e-16
Cps53 bn10 bp11 2.91e-16
Cps54 bn10 bp8 1.219e-16
Cps55 bn10 cn1 1.37e-16
Cps56 bn10 cn6 2.39e-16
Cps57 bn10 cp0 2.88e-16
Cps58 bn10 cp11 2.56e-16
Cps59 bn10 cp2 2.06e-16
Cps60 bn10 gnd 5.307e-15
Cps61 bn10 in1n 6.7e-17
Cps62 bn10 onp 1.156e-15
Cps63 bn10 xc4_xs1_tail 6.5e-17
Cps64 bn10 xc4_xs1_tail0 2.87e-16
Cps65 bn10 xc5_din 2.3e-16
Cps66 bn10 xc5_xs1_tail 1.05e-16
Cps67 bn10 xs0p_g 2.45e-16
Cps68 bn10 xs1n_cbn 6.76e-16
Cps69 bn10 xs1n_cbp 2.27e-16
Cps70 bn10 xs1p_cbp 2.49e-16
Cps71 bn11 bn12 1.46e-16
Cps72 bn11 bn2 4.05e-16
Cps73 bn11 bn3 5.84e-17
Cps74 bn11 bn6 5.4e-16
Cps75 bn11 bn8 9.51e-17
Cps76 bn11 bp11 5.35e-16
Cps77 bn11 cn11 4.19e-16
Cps78 bn11 cn6 1.56e-16
Cps79 bn11 cp1 1.16e-16
Cps80 bn11 cp10 2.03e-16
Cps81 bn11 gnd 3.6993e-15
Cps82 bn11 lsb_n 1.49e-16
Cps83 bn11 lsb_p 1.93e-16
Cps84 bn11 onn 1.24e-16
Cps85 bn11 t0b 1.53e-16
Cps86 bn11 top_n 7.89e-16
Cps87 bn11 xc4_din 1.74e-16
Cps88 bn11 xc4_outnb 1.13e-16
Cps89 bn11 xc4_outpb 3.18e-17
Cps90 bn11 xc5_dip 2.73e-16
Cps91 bn11 xc5_lt 2.26e-16
Cps92 bn11 xs0n_cbp 3.37e-17
Cps93 bn11 xs0n_g 3.72e-17
Cps94 bn11 xs0p_cbn 2e-16
Cps95 bn11 xs1n_g 1.18e-15
Cps96 bn11 xs1n_n10 9.02e-17
Cps97 bn12 bn3 1.94e-16
Cps98 bn12 bn6 7e-16
Cps99 bn12 bn7 1.24e-16
Cps100 bn12 bn9 6.72e-17
Cps101 bn12 bp5 1.85e-16
Cps102 bn12 bp9 3.9e-16
Cps103 bn12 cn0 5.36e-17
Cps104 bn12 cn1 3.23e-16
Cps105 bn12 cn12 6.67e-16
Cps106 bn12 cn2 1.02e-16
Cps107 bn12 cn5 1.083e-16
Cps108 bn12 cn6 1.26e-16
Cps109 bn12 cp0 7.63e-17
Cps110 bn12 cp11 1.64e-16
Cps111 bn12 cp12 1.47e-16
Cps112 bn12 cp2 4e-16
Cps113 bn12 gnd 4.4616e-15
Cps114 bn12 in1n 3.01e-16
Cps115 bn12 lsb_p 5.78e-17
Cps116 bn12 onn 2.55e-17
Cps117 bn12 t0 3.4e-16
Cps118 bn12 t0b 9.92e-17
Cps119 bn12 t1b 2.16e-16
Cps120 bn12 top_p 1.49e-16
Cps121 bn12 trk0 1.66e-16
Cps122 bn12 vbn 3.1e-16
Cps123 bn12 vref 1.43e-16
Cps124 bn12 xc4_lt 2.51e-17
Cps125 bn12 xc4_outpb 4.71e-16
Cps126 bn12 xs1p_n10 2.208e-16
Cps127 bn2 bn5 4.15e-17
Cps128 bn2 bn9 1.77e-16
Cps129 bn2 bp5 1.961e-15
Cps130 bn2 bp6 1.11e-16
Cps131 bn2 clkb 1.69e-16
Cps132 bn2 clknb 2.839e-16
Cps133 bn2 cn3 1.55e-16
Cps134 bn2 cn5 3.6e-16
Cps135 bn2 cn7 2.58e-16
Cps136 bn2 cn9 1.33e-16
Cps137 bn2 cp11 1.28e-16
Cps138 bn2 cp12 1.03e-16
Cps139 bn2 cp3 1.34e-16
Cps140 bn2 cp6 5.72e-17
Cps141 bn2 gnd 3.9874e-15
Cps142 bn2 in1n 4.42e-16
Cps143 bn2 in1p 9.76e-16
Cps144 bn2 rstb_n 2.2e-16
Cps145 bn2 t0 6.8e-16
Cps146 bn2 xc4_xs1_tail0 2.94e-16
Cps147 bn2 xc5_lt 2.81e-16
Cps148 bn2 xc5_xs1_tail 1.14e-16
Cps149 bn2 xs0p_g 8.87e-17
Cps150 bn2 xs1n_cbn 3.2e-16
Cps151 bn2 xs1p_g 2.03e-16
Cps152 bn3 bn4 6.97e-17
Cps153 bn3 bn5 2.02e-16
Cps154 bn3 bp5 4.03e-16
Cps155 bn3 bp9 1.12e-16
Cps156 bn3 cn1 1.54e-16
Cps157 bn3 cp10 1.5e-16
Cps158 bn3 cp11 1.63e-16
Cps159 bn3 cp7 1.26e-16
Cps160 bn3 gnd 4.5155e-15
Cps161 bn3 in0n 7.04e-16
Cps162 bn3 t1b 3.17e-16
Cps163 bn3 vrefl 7.23e-17
Cps164 bn3 xc5_outpb 3.067e-16
Cps165 bn3 xs0n_cbp 4.43e-16
Cps166 bn3 xs0p_x 1.442e-16
Cps167 bn3 xs1n_cbn 3.85e-17
Cps168 bn3 xs1n_g 1.55e-16
Cps169 bn4 bn6 4.81e-17
Cps170 bn4 bn7 5.85e-17
Cps171 bn4 bp1 1.57e-17
Cps172 bn4 bp3 7.49e-17
Cps173 bn4 bp5 1.33e-16
Cps174 bn4 bp7 1.77e-16
Cps175 bn4 clk 6.02e-17
Cps176 bn4 cn12 1.92e-16
Cps177 bn4 cn4 4.1e-17
Cps178 bn4 cn7 2.35e-16
Cps179 bn4 cn9 2.58e-16
Cps180 bn4 cp1 1.21e-16
Cps181 bn4 cp2 1.34e-16
Cps182 bn4 cp4 6.61e-16
Cps183 bn4 cp6 4.52e-16
Cps184 bn4 gnd 4.6206e-15
Cps185 bn4 lsb_p 7e-17
Cps186 bn4 nr 1.21e-16
Cps187 bn4 onp 4.74e-16
Cps188 bn4 t1b 5.22e-16
Cps189 bn4 top_n 1.97e-16
Cps190 bn4 vbn 1.33e-16
Cps191 bn4 vbp 5.6e-17
Cps192 bn4 vdd 2e-16
Cps193 bn4 vref 2.37e-16
Cps194 bn4 xc4_din 1.2e-16
Cps195 bn4 xc4_xs1_tail 1.73e-16
Cps196 bn4 xc5_din 1.23e-16
Cps197 bn4 xc5_xs1_tail0 3.08e-16
Cps198 bn4 xs0n_n10 8.5e-17
Cps199 bn4 xs1n_n10 2.91e-16
Cps200 bn4 xs1n_x 1.2e-16
Cps201 bn5 bn9 1.01e-16
Cps202 bn5 bp1 3.57e-17
Cps203 bn5 bp12 1.35e-16
Cps204 bn5 bp2 4.4e-17
Cps205 bn5 bp5 1.31e-16
Cps206 bn5 clkb 6.48e-17
Cps207 bn5 clkn 5.62e-17
Cps208 bn5 clknb 2.54e-16
Cps209 bn5 cn1 4.28e-16
Cps210 bn5 cn2 1.62e-16
Cps211 bn5 cn3 1.53e-16
Cps212 bn5 cn8 1.49e-16
Cps213 bn5 cp0 9.27e-17
Cps214 bn5 cp12 5.73e-17
Cps215 bn5 cp2 6.15e-17
Cps216 bn5 cp4 4.67e-17
Cps217 bn5 cp8 1.37e-16
Cps218 bn5 gnd 3.9136e-15
Cps219 bn5 lsb_n 1.04e-16
Cps220 bn5 rstb 4.38e-16
Cps221 bn5 t0 3.38e-16
Cps222 bn5 t1b 2.147e-16
Cps223 bn5 top_n 1.23e-16
Cps224 bn5 top_p 2.97e-16
Cps225 bn5 vdd 9.55e-17
Cps226 bn5 xc4_din 4.32e-16
Cps227 bn5 xc5_outnb 4.26e-17
Cps228 bn5 xs0n_cbn 8.66e-16
Cps229 bn5 xs0n_n10 1.21e-16
Cps230 bn5 xs0n_x 7.6e-17
Cps231 bn5 xs0p_n10 1.7e-16
Cps232 bn5 xs1p_cbn 1.97e-16
Cps233 bn5 xs1p_g 1.79e-16
Cps234 bn6 bp0 2.23e-16
Cps235 bn6 bp12 9.13e-17
Cps236 bn6 bp7 1.27e-16
Cps237 bn6 clk 8.93e-17
Cps238 bn6 clkb 5.35e-17
Cps239 bn6 cn12 8.12e-17
Cps240 bn6 cp10 5.56e-16
Cps241 bn6 gnd 3.0537e-15
Cps242 bn6 in1p 6.3e-16
Cps243 bn6 lsb_n 2.41e-16
Cps244 bn6 vbn 1.13e-16
Cps245 bn6 xs0p_cbp 1.14e-16
Cps246 bn6 xs0p_n10 3.13e-16
Cps247 bn6 xs1n_cbn 1.57e-16
Cps248 bn6 xs1n_n10 7.78e-17
Cps249 bn6 xs1p_cbn 2.8e-16
Cps250 bn6 xs1p_g 7.67e-17
Cps251 bn7 bn9 1.59e-16
Cps252 bn7 bp2 2.28e-16
Cps253 bn7 bp5 4.55e-17
Cps254 bn7 bp6 4.33e-16
Cps255 bn7 bp9 4.85e-16
Cps256 bn7 clkb 5.59e-17
Cps257 bn7 clkn 6.21e-17
Cps258 bn7 cn8 2.89e-16
Cps259 bn7 cp11 3.01e-16
Cps260 bn7 cp2 9.32e-17
Cps261 bn7 gnd 5.9042e-15
Cps262 bn7 in1p 1.3e-16
Cps263 bn7 onn 5.97e-16
Cps264 bn7 trk0 3.14e-16
Cps265 bn7 vbp 9.02e-17
Cps266 bn7 vdd 1.56e-16
Cps267 bn7 xc4_outpb 1.03e-16
Cps268 bn7 xs0p_g 5.17e-17
Cps269 bn7 xs0p_x 3.15e-16
Cps270 bn8 bp1 7.23e-17
Cps271 bn8 bp9 1.69e-16
Cps272 bn8 cn12 2.46e-17
Cps273 bn8 cn2 3.776e-16
Cps274 bn8 cn4 2.1e-16
Cps275 bn8 cn5 7.98e-17
Cps276 bn8 cn6 1.32e-16
Cps277 bn8 cp7 3.78e-17
Cps278 bn8 cp8 1.78e-16
Cps279 bn8 gnd 3.8692e-15
Cps280 bn8 in1p 1.86e-16
Cps281 bn8 trk1 8.81e-17
Cps282 bn8 xc4_outpb 2.63e-16
Cps283 bn8 xs0n_cbn 1.67e-16
Cps284 bn8 xs0p_n10 1.94e-16
Cps285 bn8 xs1n_cbn 1.75e-16
Cps286 bn8 xs1p_n10 1.6e-16
Cps287 bn9 bp5 4.1e-17
Cps288 bn9 bp7 4.78e-17
Cps289 bn9 clk 4.38e-16
Cps290 bn9 cn6 2.18e-16
Cps291 bn9 cn7 9.89e-17
Cps292 bn9 cp1 6.79e-17
Cps293 bn9 cp12 2.52e-17
Cps294 bn9 cp4 2.77e-16
Cps295 bn9 cp8 5.59e-16
Cps296 bn9 cp9 1.74e-16
Cps297 bn9 gnd 4.1949e-15
Cps298 bn9 in1p 6.85e-17
Cps299 bn9 lsb_p 2.65e-17
Cps300 bn9 rstb_n 2.09e-16
Cps301 bn9 xc4_dip 4.3e-16
Cps302 bn9 xc4_outnb 2.45e-16
Cps303 bn9 xs0n_cbp 1.37e-16
Cps304 bn9 xs1n_g 1.77e-17
Cps305 bn9 xs1p_n10 1.98e-16
Cps306 bp0 bp11 7.18e-17
Cps307 bp0 bp9 1.49e-16
Cps308 bp0 cn7 2.6e-17
Cps309 bp0 cn9 2.26e-16
Cps310 bp0 cp3 1.04e-16
Cps311 bp0 gnd 3.555e-15
Cps312 bp0 in1n 2.17e-16
Cps313 bp0 nr 1.55e-16
Cps314 bp0 rstb_n 1.03e-16
Cps315 bp0 t0b 7.08e-16
Cps316 bp0 top_n 6.24e-17
Cps317 bp0 trk1 4.07e-17
Cps318 bp0 vrefl 1.87e-16
Cps319 bp0 xc4_outnb 8.05e-17
Cps320 bp0 xc4_xs1_tail 2.44e-16
Cps321 bp0 xc4_xs1_tail0 2.45e-16
Cps322 bp0 xc5_xs1_tail 3.59e-16
Cps323 bp0 xs0p_g 1.659e-16
Cps324 bp0 xs0p_n10 2.23e-17
Cps325 bp0 xs1n_g 2e-16
Cps326 bp0 xs1n_n10 9.11e-17
Cps327 bp0 xs1p_x 1.1e-16
Cps328 bp1 bp5 2.09e-16
Cps329 bp1 clkn 2.84e-16
Cps330 bp1 cn12 1.55e-16
Cps331 bp1 cn3 1.29e-16
Cps332 bp1 cn4 9.29e-17
Cps333 bp1 cn6 1.59e-16
Cps334 bp1 cp12 1.97e-16
Cps335 bp1 cp3 9.94e-17
Cps336 bp1 gnd 5.8343e-15
Cps337 bp1 rstb_n 3.14e-16
Cps338 bp1 t0 7.94e-17
Cps339 bp1 top_n 2.96e-16
Cps340 bp1 trk0 9.86e-17
Cps341 bp1 vdd 3.27e-16
Cps342 bp1 vref 4.21e-16
Cps343 bp1 xc4_lt 8.73e-17
Cps344 bp1 xc4_outnb 1.3e-16
Cps345 bp1 xc5_dip 5.61e-17
Cps346 bp1 xs0n_g 2.02e-16
Cps347 bp1 xs1n_g 3.56e-17
Cps348 bp1 xs1p_cbp 1.15e-16
Cps349 bp1 xs1p_x 8.75e-17
Cps350 bp10 bp4 2.1e-16
Cps351 bp10 cn10 1.945e-16
Cps352 bp10 cn11 6.31e-17
Cps353 bp10 cn2 1.31e-16
Cps354 bp10 cn7 7.44e-17
Cps355 bp10 cp3 9.15e-17
Cps356 bp10 cp6 2.59e-16
Cps357 bp10 cp7 5.36e-17
Cps358 bp10 cp8 2.83e-16
Cps359 bp10 gnd 3.4333e-15
Cps360 bp10 in0p 4.14e-16
Cps361 bp10 lsb_p 5.76e-17
Cps362 bp10 on 1.3e-16
Cps363 bp10 rstb 2.12e-16
Cps364 bp10 t0b 4.38e-16
Cps365 bp10 t1 9.92e-17
Cps366 bp10 top_p 6.81e-17
Cps367 bp10 vref 4.46e-16
Cps368 bp10 xc5_xs1_tail0 2.91e-16
Cps369 bp11 clkb 7.99e-17
Cps370 bp11 cn0 2.43e-16
Cps371 bp11 cn10 5.07e-17
Cps372 bp11 cn2 3.25e-16
Cps373 bp11 cn3 1.5e-16
Cps374 bp11 cn5 2.18e-16
Cps375 bp11 cp10 2.62e-16
Cps376 bp11 gnd 3.3743e-15
Cps377 bp11 in0n 1.07e-16
Cps378 bp11 in1n 1.27e-16
Cps379 bp11 lsb_p 6.71e-17
Cps380 bp11 top_p 3.85e-17
Cps381 bp11 vref 4.91e-17
Cps382 bp11 vrefl 1.94e-16
Cps383 bp11 xc4_din 1.31e-16
Cps384 bp11 xc4_outpb 1.34e-16
Cps385 bp11 xc5_din 3.35e-16
Cps386 bp11 xc5_dip 1.11e-16
Cps387 bp11 xs0n_x 2.28e-16
Cps388 bp11 xs1p_cbp 7.21e-17
Cps389 bp12 bp3 4.49e-17
Cps390 bp12 bp6 6.46e-17
Cps391 bp12 bp9 6.16e-16
Cps392 bp12 cn10 3.9e-16
Cps393 bp12 cn8 4.35e-17
Cps394 bp12 cp7 1.6e-16
Cps395 bp12 cp9 3.96e-16
Cps396 bp12 gnd 4.917e-15
Cps397 bp12 top_n 3.2e-16
Cps398 bp12 trk1 1.27e-16
Cps399 bp12 vbp 1.94e-16
Cps400 bp12 vdd 6.2e-16
Cps401 bp12 vref 7.34e-17
Cps402 bp12 vrefl 2.4e-16
Cps403 bp12 xc4_lt 1.68e-16
Cps404 bp12 xc5_din 7.79e-17
Cps405 bp12 xs1n_cbn 3.36e-16
Cps406 bp12 xs1n_cbp 2.83e-16
Cps407 bp12 xs1n_n10 2.16e-16
Cps408 bp2 bp5 5.93e-17
Cps409 bp2 bp8 1.18e-16
Cps410 bp2 clknb 9.44e-16
Cps411 bp2 cn1 8.85e-17
Cps412 bp2 cn11 5.29e-17
Cps413 bp2 cn8 7.28e-17
Cps414 bp2 cp3 4.9e-16
Cps415 bp2 cp4 1.28e-16
Cps416 bp2 gnd 3.4652e-15
Cps417 bp2 in1p 1.17e-16
Cps418 bp2 t0b 3.55e-16
Cps419 bp2 t1 2.55e-16
Cps420 bp2 top_n 2.27e-16
Cps421 bp2 top_p 4.15e-16
Cps422 bp2 trk0 3.12e-16
Cps423 bp2 trk1 2.73e-16
Cps424 bp2 xs1p_n10 4.5e-16
Cps425 bp3 bp8 3.63e-16
Cps426 bp3 cn1 2.45e-16
Cps427 bp3 cn12 1.77e-16
Cps428 bp3 cn3 3.78e-16
Cps429 bp3 cn4 7.12e-17
Cps430 bp3 cn6 2.18e-16
Cps431 bp3 cp1 1.41e-16
Cps432 bp3 cp10 1.91e-16
Cps433 bp3 cp11 7.63e-16
Cps434 bp3 cp2 2.537e-16
Cps435 bp3 cp3 1.51e-16
Cps436 bp3 cp8 6.74e-17
Cps437 bp3 gnd 5.99e-15
Cps438 bp3 in1n 1.59e-16
Cps439 bp3 lsb_n 2.84e-16
Cps440 bp3 nr 1.35e-16
Cps441 bp3 t0 3.12e-16
Cps442 bp3 top_n 3.81e-16
Cps443 bp3 top_p 1.75e-16
Cps444 bp3 vbp 3.1e-16
Cps445 bp3 vdd 8.95e-17
Cps446 bp3 xc4_xs1_tail0 2.11e-16
Cps447 bp3 xc5_din 5.84e-17
Cps448 bp3 xc5_xs1_tail0 4.81e-16
Cps449 bp3 xs0n_cbp 2.79e-17
Cps450 bp3 xs0p_cbn 8.25e-16
Cps451 bp3 xs0p_n10 5.71e-17
Cps452 bp3 xs1n_g 6.34e-16
Cps453 bp3 xs1p_g 3.284e-16
Cps454 bp4 clknb 4.27e-16
Cps455 bp4 cn3 2.61e-16
Cps456 bp4 cp0 4.71e-16
Cps457 bp4 cp12 3.72e-17
Cps458 bp4 cp6 7.53e-17
Cps459 bp4 cp9 4.5e-16
Cps460 bp4 gnd 3.5925e-15
Cps461 bp4 in1n 1.0644e-15
Cps462 bp4 rstb 8.2e-16
Cps463 bp4 trk0 2.38e-16
Cps464 bp4 vrefl 2.65e-16
Cps465 bp4 xc4_dip 1.77e-16
Cps466 bp4 xs1p_cbp 2.25e-16
Cps467 bp4 xs1p_n10 1.49e-16
Cps468 bp5 bp6 2.46e-17
Cps469 bp5 bp8 1.75e-16
Cps470 bp5 cn1 2.13e-16
Cps471 bp5 cn12 1.4e-16
Cps472 bp5 cn4 5.06e-17
Cps473 bp5 cn9 3.32e-16
Cps474 bp5 cp11 2.7e-16
Cps475 bp5 cp3 8.19e-17
Cps476 bp5 cp4 1.8e-16
Cps477 bp5 gnd 4.3373e-15
Cps478 bp5 onn 1.99e-16
Cps479 bp5 rstb_n 1.37e-16
Cps480 bp5 t0b 5.039e-16
Cps481 bp5 top_n 4.9e-17
Cps482 bp5 vbn 8.88e-17
Cps483 bp5 vbp 3.21e-16
Cps484 bp5 xc4_dip 1.4e-16
Cps485 bp5 xc4_outpb 2.6e-16
Cps486 bp5 xc5_lt 2.91e-16
Cps487 bp5 xc5_outpb 8.49e-17
Cps488 bp5 xs0n_g 2.683e-16
Cps489 bp5 xs0p_cbn 1.04e-16
Cps490 bp5 xs1n_g 2.42e-17
Cps491 bp5 xs1n_n10 7.157e-16
Cps492 bp5 xs1p_cbn 4.007e-16
Cps493 bp5 xs1p_n10 2.9e-17
Cps494 bp6 clkn 1.83e-16
Cps495 bp6 clknb 8.44e-16
Cps496 bp6 cn1 7.76e-16
Cps497 bp6 cn2 8.04e-17
Cps498 bp6 cn3 6.66e-17
Cps499 bp6 cn6 9.19e-16
Cps500 bp6 cn8 7.33e-17
Cps501 bp6 cn9 6.034e-16
Cps502 bp6 cp0 4.86e-17
Cps503 bp6 cp2 3.13e-16
Cps504 bp6 gnd 4.4586e-15
Cps505 bp6 in1n 1.96e-16
Cps506 bp6 onp 1.03e-16
Cps507 bp6 rstb_n 4.44e-16
Cps508 bp6 t1 1.08e-16
Cps509 bp6 t1b 2.35e-16
Cps510 bp6 top_p 5.3e-17
Cps511 bp6 vbn 4.44e-17
Cps512 bp6 xc4_din 1.38e-16
Cps513 bp6 xc4_outnb 1.08e-16
Cps514 bp6 xc5_xs1_tail0 2e-16
Cps515 bp6 xs0n_cbn 4.48e-17
Cps516 bp6 xs0n_cbp 2.11e-16
Cps517 bp6 xs1n_n10 5.32e-16
Cps518 bp7 clknb 7.19e-17
Cps519 bp7 cn12 5.36e-16
Cps520 bp7 cn4 4.2e-16
Cps521 bp7 cn9 5.29e-16
Cps522 bp7 cp10 2.92e-17
Cps523 bp7 cp4 1.11e-16
Cps524 bp7 cp8 3.76e-16
Cps525 bp7 cp9 1.43e-16
Cps526 bp7 gnd 3.3209e-15
Cps527 bp7 op 1.83e-16
Cps528 bp7 rstb 3.68e-16
Cps529 bp7 rstb_n 7.21e-17
Cps530 bp7 t1b 2.57e-16
Cps531 bp7 top_n 8.85e-17
Cps532 bp7 vbp 5.99e-17
Cps533 bp7 vrefl 1.5e-16
Cps534 bp7 xc5_dip 3.047e-16
Cps535 bp7 xc5_lt 1.77e-16
Cps536 bp7 xc5_xs1_tail 2.2e-16
Cps537 bp7 xc5_xs1_tail0 8.05e-17
Cps538 bp7 xs0n_cbn 7.09e-17
Cps539 bp7 xs0n_g 1.33e-16
Cps540 bp7 xs0p_n10 2.95e-16
Cps541 bp7 xs1n_n10 7.92e-17
Cps542 bp7 xs1p_cbp 5.74e-16
Cps543 bp8 cp1 1.45e-16
Cps544 bp8 cp3 2.52e-17
Cps545 bp8 gnd 7.0133e-15
Cps546 bp8 lsb_n 8.02e-17
Cps547 bp8 on 2.58e-16
Cps548 bp8 op 5.8e-17
Cps549 bp8 t0 7.9e-17
Cps550 bp8 t1b 1.63e-16
Cps551 bp8 vbp 8.09e-16
Cps552 bp8 xc4_outpb 3.16e-16
Cps553 bp8 xc4_xs1_tail0 2.34e-16
Cps554 bp8 xc5_outnb 2.27e-16
Cps555 bp8 xs0n_g 1.66e-16
Cps556 bp8 xs0n_x 2.21e-16
Cps557 bp8 xs0p_cbn 1.55e-16
Cps558 bp8 xs0p_n10 1.08e-16
Cps559 bp8 xs0p_x 6.96e-17
Cps560 bp8 xs1n_cbp 5.99e-17
Cps561 bp8 xs1n_x 1.09e-16
Cps562 bp8 xs1p_cbn 1.54e-16
Cps563 bp9 clkb 5.38e-17
Cps564 bp9 clknb 2.04e-16
Cps565 bp9 cn1 5.22e-16
Cps566 bp9 cn10 4.02e-16
Cps567 bp9 cp1 1.99e-16
Cps568 bp9 cp11 1.03e-15
Cps569 bp9 cp4 8.43e-17
Cps570 bp9 cp5 1.34e-16
Cps571 bp9 cp7 5.1e-16
Cps572 bp9 gnd 4.9209e-15
Cps573 bp9 in0p 5.29e-17
Cps574 bp9 on 4.013e-16
Cps575 bp9 onn 2.77e-16
Cps576 bp9 vbn 4.209e-16
Cps577 bp9 xc5_outpb 2.18e-16
Cps578 bp9 xs0p_cbn 2.93e-16
Cps579 bp9 xs0p_g 4.9e-16
Cps580 bp9 xs1n_cbn 2.48e-16
Cps581 bp9 xs1p_cbn 1.21e-16
Cps582 clk clkn 1.77e-16
Cps583 clk cn0 2.09e-16
Cps584 clk cn4 1.51e-16
Cps585 clk cn5 4.96e-17
Cps586 clk cn7 5.46e-17
Cps587 clk cn8 1.47e-16
Cps588 clk cp5 8.58e-17
Cps589 clk cp7 9.07e-17
Cps590 clk gnd 4.9871e-15
Cps591 clk t1b 2.8e-16
Cps592 clk vdd 8.59e-17
Cps593 clk xc4_din 1.18e-16
Cps594 clk xc5_dip 1.43e-16
Cps595 clk xc5_xs1_tail0 1.62e-16
Cps596 clk xs0n_cbn 6.24e-16
Cps597 clk xs0n_cbp 4.38e-16
Cps598 clk xs0n_n10 1.21e-15
Cps599 clk xs0p_cbn 2.88e-16
Cps600 clk xs0p_cbp 1.97e-16
Cps601 clk xs0p_n10 1.411e-16
Cps602 clk xs1n_x 2.02e-16
Cps603 clk xs1p_x 1.31e-16
Cps604 clkb cn2 1.65e-16
Cps605 clkb cn3 7.27e-16
Cps606 clkb cp10 2.98e-16
Cps607 clkb cp2 2.7e-17
Cps608 clkb cp6 2.33e-16
Cps609 clkb gnd 3.2805e-15
Cps610 clkb in1n 1.61e-16
Cps611 clkb in1p 1.21e-16
Cps612 clkb rstb 2.12e-16
Cps613 clkb top_n 2.38e-17
Cps614 clkb xc4_lt 5.95e-17
Cps615 clkb xc4_outpb 8.2e-17
Cps616 clkb xs0n_cbn 3.855e-16
Cps617 clkb xs0p_cbn 2.842e-16
Cps618 clkb xs0p_cbp 4.39e-16
Cps619 clkb xs0p_x 1.82e-16
Cps620 clkb xs1n_n10 2.17e-16
Cps621 clkb xs1p_cbn 2e-16
Cps622 clkb xs1p_n10 2.18e-16
Cps623 clkn cn0 1.39e-16
Cps624 clkn cn7 3.64e-16
Cps625 clkn cp1 3.1e-16
Cps626 clkn cp5 2.86e-16
Cps627 clkn cp7 9.36e-17
Cps628 clkn gnd 4.6967e-15
Cps629 clkn in0p 1.34e-16
Cps630 clkn in1n 5.05e-16
Cps631 clkn lsb_p 6.81e-17
Cps632 clkn t0 1.39e-16
Cps633 clkn trk1 4.71e-16
Cps634 clkn xc5_outnb 3.68e-16
Cps635 clkn xs1n_cbn 7.62e-17
Cps636 clkn xs1p_g 5.46e-17
Cps637 clknb cn8 3.5e-16
Cps638 clknb cp11 1.55e-16
Cps639 clknb cp12 4.932e-16
Cps640 clknb cp4 2.85e-16
Cps641 clknb cp5 9.48e-17
Cps642 clknb gnd 3.4653e-15
Cps643 clknb on 2.28e-16
Cps644 clknb rstb_n 1.58e-16
Cps645 clknb top_p 2.88e-16
Cps646 clknb vbn 9.214e-16
Cps647 clknb xc4_outnb 3.86e-16
Cps648 clknb xc4_xs1_tail 1.65e-16
Cps649 clknb xc5_lt 9.34e-17
Cps650 clknb xs0p_cbp 1.32e-16
Cps651 clknb xs1n_cbn 2.035e-16
Cps652 clknb xs1p_cbn 1.991e-16
Cps653 cn0 cn1 1.03e-16
Cps654 cn0 cn12 9.09e-17
Cps655 cn0 cn2 1.79e-16
Cps656 cn0 cn6 6.82e-17
Cps657 cn0 cp10 7.06e-17
Cps658 cn0 cp2 4.35e-16
Cps659 cn0 cp8 3.33e-16
Cps660 cn0 cp9 6.02e-17
Cps661 cn0 gnd 3.9017e-15
Cps662 cn0 onn 5.21e-16
Cps663 cn0 t0 4.88e-16
Cps664 cn0 t1b 6.6e-17
Cps665 cn0 trk0 2.57e-16
Cps666 cn0 trk1 6.79e-17
Cps667 cn0 vbn 5.8e-17
Cps668 cn0 xc4_outnb 2.18e-16
Cps669 cn0 xc4_xs1_tail 1.36e-16
Cps670 cn0 xc5_dip 6.77e-17
Cps671 cn0 xc5_lt 6.68e-16
Cps672 cn0 xc5_outpb 7.26e-17
Cps673 cn0 xs0n_cbn 5.52e-17
Cps674 cn0 xs0n_cbp 1.18e-16
Cps675 cn0 xs0n_n10 2.71e-16
Cps676 cn0 xs1n_n10 3.6e-17
Cps677 cn1 cn10 4.7e-16
Cps678 cn1 cn2 1.13e-16
Cps679 cn1 cn7 7.19e-17
Cps680 cn1 cp0 1.32e-16
Cps681 cn1 cp10 1.07e-16
Cps682 cn1 cp9 4.98e-16
Cps683 cn1 gnd 3.8134e-15
Cps684 cn1 in1n 1.18e-16
Cps685 cn1 lsb_n 1.43e-16
Cps686 cn1 t0 1.69e-16
Cps687 cn1 t1 2.06e-16
Cps688 cn1 trk0 1e-16
Cps689 cn1 xc4_dip 2.81e-16
Cps690 cn1 xc4_outpb 3.49e-16
Cps691 cn1 xc5_lt 5.91e-16
Cps692 cn1 xc5_outnb 8.27e-17
Cps693 cn1 xc5_xs1_tail 3.196e-16
Cps694 cn1 xs0p_cbp 2.57e-17
Cps695 cn1 xs1n_cbn 8.06e-16
Cps696 cn1 xs1n_n10 3.84e-16
Cps697 cn1 xs1p_cbn 7.32e-17
Cps698 cn1 xs1p_x 1.08e-16
Cps699 cn10 cn11 2.78e-16
Cps700 cn10 cn12 1.42e-16
Cps701 cn10 cn3 1.01e-15
Cps702 cn10 cn6 1.01e-16
Cps703 cn10 gnd 4.1968e-15
Cps704 cn10 in1n 5.06e-16
Cps705 cn10 on 2.84e-16
Cps706 cn10 rstb 2.54e-16
Cps707 cn10 t0b 2.65e-16
Cps708 cn10 t1 1.9e-16
Cps709 cn10 top_p 1.83e-16
Cps710 cn10 xc5_xs1_tail 2.76e-16
Cps711 cn10 xc5_xs1_tail0 6.76e-16
Cps712 cn10 xs0p_g 1.716e-16
Cps713 cn11 cn3 3.06e-16
Cps714 cn11 cn6 6.15e-17
Cps715 cn11 cp12 1.35e-16
Cps716 cn11 cp4 9.32e-17
Cps717 cn11 gnd 6.4771e-15
Cps718 cn11 t0 2.21e-16
Cps719 cn11 t1 6.69e-17
Cps720 cn11 vbn 1.1144e-15
Cps721 cn11 xs0n_g 3.91e-16
Cps722 cn11 xs0p_n10 3.21e-16
Cps723 cn11 xs1n_n10 6.39e-17
Cps724 cn11 xs1n_x 1.62e-16
Cps725 cn12 cn2 5.78e-17
Cps726 cn12 cn8 1.8e-16
Cps727 cn12 cp11 1.58e-16
Cps728 cn12 gnd 5.159e-15
Cps729 cn12 in0n 2.923e-16
Cps730 cn12 in1p 8.29e-17
Cps731 cn12 lsb_n 9.72e-17
Cps732 cn12 t0 1.11e-16
Cps733 cn12 vbp 1.8e-16
Cps734 cn12 xc4_dip 2.19e-16
Cps735 cn12 xc4_xs1_tail0 9.42e-17
Cps736 cn12 xc5_dip 2e-16
Cps737 cn12 xs0p_cbp 2.55e-16
Cps738 cn12 xs1n_cbn 4.11e-16
Cps739 cn12 xs1p_n10 4.33e-16
Cps740 cn2 cn4 5.76e-17
Cps741 cn2 cn6 2.48e-16
Cps742 cn2 cn7 1.02e-16
Cps743 cn2 cp1 3.454e-16
Cps744 cn2 cp3 2.2e-16
Cps745 cn2 cp4 6.35e-17
Cps746 cn2 cp6 5.44e-17
Cps747 cn2 gnd 5.3074e-15
Cps748 cn2 lsb_n 5.08e-17
Cps749 cn2 t1 1.9e-16
Cps750 cn2 trk1 1.58e-16
Cps751 cn2 xc4_outnb 1.15e-16
Cps752 cn2 xc5_xs1_tail 2.18e-16
Cps753 cn2 xc5_xs1_tail0 5.09e-16
Cps754 cn2 xs0n_cbp 5.17e-17
Cps755 cn3 cn5 6.6e-16
Cps756 cn3 cn7 4.42e-16
Cps757 cn3 cn9 3.54e-16
Cps758 cn3 cp11 5.4e-17
Cps759 cn3 cp2 5.28e-17
Cps760 cn3 cp5 1.17e-16
Cps761 cn3 cp6 1.27e-16
Cps762 cn3 gnd 4e-15
Cps763 cn3 lsb_n 1.67e-16
Cps764 cn3 onp 8.66e-17
Cps765 cn3 op 2.33e-16
Cps766 cn3 rstb_n 6.85e-17
Cps767 cn3 t0b 4.39e-16
Cps768 cn3 t1 1.781e-16
Cps769 cn3 t1b 8.7e-17
Cps770 cn3 top_n 1.56e-16
Cps771 cn3 xc4_dip 1.67e-16
Cps772 cn3 xc4_outpb 3.32e-17
Cps773 cn3 xc5_dip 6.92e-16
Cps774 cn3 xs0n_cbn 4.19e-17
Cps775 cn3 xs0n_n10 1.26e-16
Cps776 cn3 xs1p_n10 4.28e-17
Cps777 cn4 cn9 1.93e-16
Cps778 cn4 cp0 2.26e-17
Cps779 cn4 cp7 1.47e-16
Cps780 cn4 cp9 1.27e-16
Cps781 cn4 gnd 4.4344e-15
Cps782 cn4 in0n 6.98e-17
Cps783 cn4 lsb_n 4.23e-17
Cps784 cn4 lsb_p 1.72e-16
Cps785 cn4 t0 1.44e-16
Cps786 cn4 t0b 1.43e-16
Cps787 cn4 trk1 2.15e-16
Cps788 cn4 vbp 8.36e-17
Cps789 cn4 vref 2.08e-16
Cps790 cn4 xc5_din 2.7e-16
Cps791 cn4 xs0n_cbp 2.18e-16
Cps792 cn4 xs0n_n10 7.21e-17
Cps793 cn4 xs0p_g 2.52e-16
Cps794 cn4 xs1n_g 3.11e-16
Cps795 cn4 xs1p_cbp 4.663e-16
Cps796 cn5 cp1 2.3e-16
Cps797 cn5 cp12 1.731e-16
Cps798 cn5 cp9 2.33e-17
Cps799 cn5 gnd 3.6579e-15
Cps800 cn5 in0n 2.95e-17
Cps801 cn5 lsb_p 1.08e-16
Cps802 cn5 on 5.94e-16
Cps803 cn5 op 4.7e-16
Cps804 cn5 rstb_n 1.65e-16
Cps805 cn5 top_p 1.23e-16
Cps806 cn5 vref 6.44e-17
Cps807 cn5 xc4_din 2.66e-16
Cps808 cn5 xc4_lt 1.17e-16
Cps809 cn5 xc4_outnb 4e-16
Cps810 cn5 xs1n_cbn 2.76e-16
Cps811 cn5 xs1n_cbp 9.54e-17
Cps812 cn5 xs1p_n10 1.18e-16
Cps813 cn6 cp0 1.29e-16
Cps814 cn6 cp12 6.87e-16
Cps815 cn6 cp2 3.644e-16
Cps816 cn6 cp5 2.98e-16
Cps817 cn6 gnd 4.0809e-15
Cps818 cn6 t1b 1.32e-16
Cps819 cn6 top_p 4.12e-17
Cps820 cn6 vrefl 4.412e-16
Cps821 cn6 xc4_xs1_tail0 3.4e-17
Cps822 cn6 xc5_din 8.71e-17
Cps823 cn6 xs0n_cbp 4.68e-17
Cps824 cn6 xs1n_cbn 1.5e-16
Cps825 cn6 xs1n_g 1.54e-16
Cps826 cn6 xs1p_cbn 1.13e-15
Cps827 cn7 cn8 5.94e-17
Cps828 cn7 cn9 3.51e-16
Cps829 cn7 cp7 5.08e-16
Cps830 cn7 cp8 2.6e-17
Cps831 cn7 gnd 3.3592e-15
Cps832 cn7 in0p 1.28e-16
Cps833 cn7 in1p 3.68e-16
Cps834 cn7 lsb_n 6.89e-17
Cps835 cn7 nr 1.04e-16
Cps836 cn7 onp 2.73e-16
Cps837 cn7 t1b 8.23e-17
Cps838 cn7 xc4_outpb 2.33e-16
Cps839 cn7 xs1n_cbp 6.95e-17
Cps840 cn7 xs1n_g 1.38e-16
Cps841 cn8 cn9 4.76e-17
Cps842 cn8 cp12 1.4e-16
Cps843 cn8 cp2 2.82e-16
Cps844 cn8 cp4 2.2e-16
Cps845 cn8 cp9 3.932e-16
Cps846 cn8 gnd 3.8223e-15
Cps847 cn8 in0n 2.56e-16
Cps848 cn8 on 3.4e-16
Cps849 cn8 op 5.43e-17
Cps850 cn8 trk0 2.26e-16
Cps851 cn8 vbp 3.88e-16
Cps852 cn8 xc4_outpb 1.05e-16
Cps853 cn8 xc5_lt 5.92e-16
Cps854 cn8 xs1p_cbn 6e-17
Cps855 cn9 cp0 2.92e-16
Cps856 cn9 cp1 3.47e-17
Cps857 cn9 gnd 6.2315e-15
Cps858 cn9 on 2.79e-16
Cps859 cn9 onp 3.13e-17
Cps860 cn9 t1b 3.82e-16
Cps861 cn9 vbn 6.75e-17
Cps862 cn9 vrefl 1.45e-16
Cps863 cn9 xc4_outnb 1.22e-16
Cps864 cn9 xc4_xs1_tail0 7.76e-17
Cps865 cn9 xc5_xs1_tail 1.54e-16
Cps866 cn9 xs1p_g 2.21e-16
Cps867 cn9 xs1p_n10 9.01e-17
Cps868 cp0 cp5 5.53e-16
Cps869 cp0 cp7 7.03e-17
Cps870 cp0 cp8 1.65e-16
Cps871 cp0 gnd 3.3224e-15
Cps872 cp0 in1n 1.97e-16
Cps873 cp0 nr 5.47e-17
Cps874 cp0 rstb 2.02e-16
Cps875 cp0 rstb_n 3.613e-16
Cps876 cp0 top_n 4.04e-17
Cps877 cp0 trk0 2.43e-16
Cps878 cp0 vbp 7.18e-17
Cps879 cp0 xc4_lt 5.16e-17
Cps880 cp0 xc4_xs1_tail0 1.82e-16
Cps881 cp0 xc5_outnb 1.31e-16
Cps882 cp0 xc5_xs1_tail 3.24e-16
Cps883 cp0 xs0p_g 2.38e-16
Cps884 cp1 cp2 1.13e-16
Cps885 cp1 gnd 4.2681e-15
Cps886 cp1 t1b 9.08e-16
Cps887 cp1 top_n 1.69e-16
Cps888 cp1 trk0 2.05e-16
Cps889 cp1 vbn 7.57e-17
Cps890 cp1 xc4_dip 1.11e-16
Cps891 cp1 xc4_xs1_tail0 1.37e-16
Cps892 cp1 xc5_lt 2.37e-16
Cps893 cp1 xc5_xs1_tail 4.75e-16
Cps894 cp1 xs0p_g 1.53e-16
Cps895 cp1 xs0p_x 4.81e-16
Cps896 cp1 xs1n_cbp 6.91e-16
Cps897 cp1 xs1p_n10 3.25e-16
Cps898 cp1 xs1p_x 1.17e-16
Cps899 cp10 gnd 6.2979e-15
Cps900 cp10 in0p 7.11e-16
Cps901 cp10 lsb_n 5.08e-16
Cps902 cp10 lsb_p 3.94e-16
Cps903 cp10 trk0 1.74e-16
Cps904 cp10 xc5_outnb 2.29e-16
Cps905 cp10 xc5_outpb 2.57e-16
Cps906 cp10 xc5_xs1_tail 3.44e-17
Cps907 cp10 xs0n_cbp 7.31e-17
Cps908 cp10 xs1n_cbp 7.598e-16
Cps909 cp10 xs1p_cbn 2.672e-16
Cps910 cp10 xs1p_g 4.82e-16
Cps911 cp11 cp8 1.63e-16
Cps912 cp11 gnd 3.1422e-15
Cps913 cp11 lsb_p 8.04e-17
Cps914 cp11 t0 1.47e-16
Cps915 cp11 top_n 4.79e-16
Cps916 cp11 top_p 1.05e-16
Cps917 cp11 vdd 1.64e-16
Cps918 cp11 vref 2.89e-17
Cps919 cp11 vrefl 4.32e-17
Cps920 cp11 xc4_lt 6.02e-17
Cps921 cp11 xc4_xs1_tail0 1.39e-16
Cps922 cp11 xs0p_cbn 4.01e-17
Cps923 cp11 xs1n_g 6.33e-16
Cps924 cp11 xs1p_cbn 3.3e-17
Cps925 cp12 cp8 3.41e-16
Cps926 cp12 gnd 6.7601e-15
Cps927 cp12 lsb_p 3.393e-16
Cps928 cp12 onn 1.22e-16
Cps929 cp12 top_n 4.3e-17
Cps930 cp12 trk0 3.82e-16
Cps931 cp12 xc4_dip 2.28e-16
Cps932 cp12 xc4_outpb 4.49e-16
Cps933 cp12 xc4_xs1_tail 8.01e-17
Cps934 cp12 xc4_xs1_tail0 6.09e-17
Cps935 cp12 xc5_outpb 1.06e-16
Cps936 cp12 xs0p_cbp 1.06e-16
Cps937 cp12 xs1n_cbp 2.09e-16
Cps938 cp12 xs1n_g 1.48e-16
Cps939 cp12 xs1n_n10 2.52e-16
Cps940 cp12 xs1p_g 4.41e-16
Cps941 cp2 cp8 1.19e-16
Cps942 cp2 gnd 4.5463e-15
Cps943 cp2 in0n 2.47e-16
Cps944 cp2 onn 4.52e-17
Cps945 cp2 t0b 5.603e-16
Cps946 cp2 t1 1.18e-16
Cps947 cp2 top_n 1.04e-16
Cps948 cp2 top_p 3.53e-17
Cps949 cp2 xs0n_n10 6.64e-17
Cps950 cp2 xs0n_x 2.19e-16
Cps951 cp2 xs0p_x 8.7e-17
Cps952 cp2 xs1n_cbn 9.68e-17
Cps953 cp2 xs1n_cbp 1.95e-16
Cps954 cp2 xs1n_g 1.66e-16
Cps955 cp2 xs1n_n10 1.62e-16
Cps956 cp2 xs1n_x 3.4e-16
Cps957 cp2 xs1p_n10 1.95e-16
Cps958 cp3 cp9 1.735e-16
Cps959 cp3 gnd 2.742e-15
Cps960 cp3 in0p 3.88e-16
Cps961 cp3 nr 1.65e-16
Cps962 cp3 on 3.7e-16
Cps963 cp3 onp 8.96e-17
Cps964 cp3 t0 2.43e-16
Cps965 cp3 t0b 1.58e-16
Cps966 cp3 t1 2.47e-16
Cps967 cp3 vbn 5.43e-16
Cps968 cp3 vrefl 5.65e-17
Cps969 cp3 xc5_dip 4.742e-16
Cps970 cp3 xs0n_cbn 1.395e-16
Cps971 cp4 gnd 3.9878e-15
Cps972 cp4 in0n 5.3e-17
Cps973 cp4 in1p 1.83e-16
Cps974 cp4 lsb_n 2.62e-16
Cps975 cp4 lsb_p 1.6e-16
Cps976 cp4 rstb 1.97e-16
Cps977 cp4 trk1 2.09e-16
Cps978 cp4 xc5_din 8.15e-17
Cps979 cp4 xs0p_n10 3.59e-16
Cps980 cp4 xs1n_cbn 1.64e-16
Cps981 cp4 xs1n_g 3.74e-17
Cps982 cp5 cp7 1.91e-16
Cps983 cp5 gnd 3.6154e-15
Cps984 cp5 rstb_n 7.98e-17
Cps985 cp5 vbp 5.67e-17
Cps986 cp5 vref 3.03e-16
Cps987 cp5 xc4_din 4.59e-16
Cps988 cp5 xc5_din 5.26e-17
Cps989 cp5 xc5_lt 6.76e-17
Cps990 cp5 xs0n_n10 1.6e-16
Cps991 cp5 xs0n_x 2.97e-16
Cps992 cp5 xs0p_n10 1.2e-16
Cps993 cp5 xs1n_x 1.39e-16
Cps994 cp6 cp9 1.69e-16
Cps995 cp6 gnd 5.1503e-15
Cps996 cp6 in0n 1.3e-16
Cps997 cp6 in1n 1.12e-16
Cps998 cp6 onn 2.7e-16
Cps999 cp6 op 2.46e-16
Cps1000 cp6 t1 1.57e-16
Cps1001 cp6 t1b 2.8e-16
Cps1002 cp6 top_n 1.62e-16
Cps1003 cp6 trk1 1.24e-16
Cps1004 cp6 vbp 1.57e-16
Cps1005 cp6 vref 5.266e-16
Cps1006 cp6 xc4_din 6.88e-17
Cps1007 cp6 xc4_lt 1.58e-16
Cps1008 cp6 xc4_outpb 4.47e-16
Cps1009 cp6 xc4_xs1_tail0 1.03e-16
Cps1010 cp6 xc5_din 4.76e-16
Cps1011 cp6 xc5_outnb 1.48e-16
Cps1012 cp6 xs0n_cbn 5.48e-17
Cps1013 cp6 xs0n_g 1.05e-16
Cps1014 cp6 xs1p_g 4.81e-17
Cps1015 cp7 cp8 1.49e-16
Cps1016 cp7 gnd 5.4779e-15
Cps1017 cp7 lsb_p 1.55e-16
Cps1018 cp7 nr 1.87e-16
Cps1019 cp7 op 1.88e-16
Cps1020 cp7 t0b 2.56e-16
Cps1021 cp7 t1 7.82e-17
Cps1022 cp7 top_n 1.4e-16
Cps1023 cp7 top_p 2.79e-16
Cps1024 cp7 vdd 1.04e-16
Cps1025 cp7 vref 1.41e-16
Cps1026 cp7 xc5_din 1.35e-16
Cps1027 cp7 xc5_xs1_tail0 6.41e-16
Cps1028 cp7 xs0n_cbn 9.86e-17
Cps1029 cp7 xs0n_cbp 2.11e-16
Cps1030 cp7 xs0n_g 1.03e-16
Cps1031 cp7 xs0p_cbn 1.69e-16
Cps1032 cp7 xs0p_cbp 2.23e-16
Cps1033 cp7 xs1n_x 3.33e-16
Cps1034 cp7 xs1p_cbp 7.13e-17
Cps1035 cp8 gnd 2.7575e-15
Cps1036 cp8 in1n 3.99e-16
Cps1037 cp8 nr 1.17e-16
Cps1038 cp8 t1 5.24e-17
Cps1039 cp8 t1b 1.463e-16
Cps1040 cp8 top_n 7.44e-17
Cps1041 cp8 top_p 7.44e-17
Cps1042 cp8 vdd 2.29e-16
Cps1043 cp8 xc4_lt 2.33e-16
Cps1044 cp8 xc4_outpb 6.44e-16
Cps1045 cp8 xc4_xs1_tail0 2.52e-16
Cps1046 cp8 xc5_xs1_tail0 2.46e-16
Cps1047 cp8 xs0p_cbn 2.526e-16
Cps1048 cp8 xs1n_cbn 5.67e-16
Cps1049 cp8 xs1n_x 8.57e-16
Cps1050 cp8 xs1p_g 2.79e-16
Cps1051 cp8 xs1p_n10 1.99e-16
Cps1052 cp9 gnd 4.5818e-15
Cps1053 cp9 in0p 8.76e-17
Cps1054 cp9 lsb_n 2.429e-16
Cps1055 cp9 onp 1.02e-16
Cps1056 cp9 rstb_n 8.594e-16
Cps1057 cp9 vrefl 7.02e-17
Cps1058 cp9 xc4_dip 1.26e-16
Cps1059 cp9 xc4_outnb 1.9e-16
Cps1060 cp9 xc4_outpb 1.86e-16
Cps1061 cp9 xc5_din 6.55e-17
Cps1062 cp9 xc5_lt 1.45e-16
Cps1063 cp9 xc5_outpb 5.6e-16
Cps1064 cp9 xs0n_cbn 6.88e-17
Cps1065 cp9 xs0n_g 6.45e-16
Cps1066 cp9 xs0n_n10 8.97e-17
Cps1067 cp9 xs0p_n10 3.87e-16
Cps1068 cp9 xs1n_cbp 2.75e-16
Cps1069 cp9 xs1n_n10 9.94e-17
Cps1070 gnd in0n 4.3791e-15
Cps1071 gnd in0p 2.8182e-15
Cps1072 gnd in1n 3.5398e-15
Cps1073 gnd in1p 3.5702e-15
Cps1074 gnd lsb_n 4.6963e-15
Cps1075 gnd lsb_p 4.2887e-15
Cps1076 gnd nr 5.659e-15
Cps1077 gnd on 3.3755e-15
Cps1078 gnd onn 6.3007e-15
Cps1079 gnd onp 4.7652e-15
Cps1080 gnd op 3.6843e-15
Cps1081 gnd px_lad0_0 1e-16
Cps1082 gnd px_lad0_1 1e-16
Cps1083 gnd px_lad0_2 1e-16
Cps1084 gnd px_lad0_3 1e-16
Cps1085 gnd px_lad0_4 1e-16
Cps1086 gnd px_lad0_5 1e-16
Cps1087 gnd px_lad0_6 1e-16
Cps1088 gnd px_lad0_7 1e-16
Cps1089 gnd px_lad0_8 1e-16
Cps1090 gnd px_lad0_9 1e-16
Cps1091 gnd px_lad100_0 1e-16
Cps1092 gnd px_lad100_1 1e-16
Cps1093 gnd px_lad100_2 1e-16
Cps1094 gnd px_lad100_3 1e-16
Cps1095 gnd px_lad100_4 1e-16
Cps1096 gnd px_lad100_5 1e-16
Cps1097 gnd px_lad100_6 1e-16
Cps1098 gnd px_lad100_7 1e-16
Cps1099 gnd px_lad100_8 1e-16
Cps1100 gnd px_lad100_9 1e-16
Cps1101 gnd px_lad101_0 1e-16
Cps1102 gnd px_lad101_1 1e-16
Cps1103 gnd px_lad101_2 1e-16
Cps1104 gnd px_lad101_3 1e-16
Cps1105 gnd px_lad101_4 1e-16
Cps1106 gnd px_lad101_5 1e-16
Cps1107 gnd px_lad101_6 1e-16
Cps1108 gnd px_lad101_7 1e-16
Cps1109 gnd px_lad101_8 1e-16
Cps1110 gnd px_lad101_9 1e-16
Cps1111 gnd px_lad102_0 1e-16
Cps1112 gnd px_lad102_1 1e-16
Cps1113 gnd px_lad102_2 1e-16
Cps1114 gnd px_lad102_3 1e-16
Cps1115 gnd px_lad102_4 1e-16
Cps1116 gnd px_lad102_5 1e-16
Cps1117 gnd px_lad102_6 1e-16
Cps1118 gnd px_lad102_7 1e-16
Cps1119 gnd px_lad102_8 1e-16
Cps1120 gnd px_lad102_9 1e-16
Cps1121 gnd px_lad103_0 1e-16
Cps1122 gnd px_lad103_1 1e-16
Cps1123 gnd px_lad103_2 1e-16
Cps1124 gnd px_lad103_3 1e-16
Cps1125 gnd px_lad103_4 1e-16
Cps1126 gnd px_lad103_5 1e-16
Cps1127 gnd px_lad103_6 1e-16
Cps1128 gnd px_lad103_7 1e-16
Cps1129 gnd px_lad103_8 1e-16
Cps1130 gnd px_lad103_9 1e-16
Cps1131 gnd px_lad104_0 1e-16
Cps1132 gnd px_lad104_1 1e-16
Cps1133 gnd px_lad104_2 1e-16
Cps1134 gnd px_lad104_3 1e-16
Cps1135 gnd px_lad104_4 1e-16
Cps1136 gnd px_lad104_5 1e-16
Cps1137 gnd px_lad104_6 1e-16
Cps1138 gnd px_lad104_7 1e-16
Cps1139 gnd px_lad104_8 1e-16
Cps1140 gnd px_lad104_9 1e-16
Cps1141 gnd px_lad105_0 1e-16
Cps1142 gnd px_lad105_1 1e-16
Cps1143 gnd px_lad105_2 1e-16
Cps1144 gnd px_lad105_3 1e-16
Cps1145 gnd px_lad105_4 1e-16
Cps1146 gnd px_lad105_5 1e-16
Cps1147 gnd px_lad105_6 1e-16
Cps1148 gnd px_lad105_7 1e-16
Cps1149 gnd px_lad105_8 1e-16
Cps1150 gnd px_lad105_9 1e-16
Cps1151 gnd px_lad106_0 1e-16
Cps1152 gnd px_lad106_1 1e-16
Cps1153 gnd px_lad106_2 1e-16
Cps1154 gnd px_lad106_3 1e-16
Cps1155 gnd px_lad106_4 1e-16
Cps1156 gnd px_lad106_5 1e-16
Cps1157 gnd px_lad106_6 1e-16
Cps1158 gnd px_lad106_7 1e-16
Cps1159 gnd px_lad106_8 1e-16
Cps1160 gnd px_lad106_9 1e-16
Cps1161 gnd px_lad107_0 1e-16
Cps1162 gnd px_lad107_1 1e-16
Cps1163 gnd px_lad107_2 1e-16
Cps1164 gnd px_lad107_3 1e-16
Cps1165 gnd px_lad107_4 1e-16
Cps1166 gnd px_lad107_5 1e-16
Cps1167 gnd px_lad107_6 1e-16
Cps1168 gnd px_lad107_7 1e-16
Cps1169 gnd px_lad107_8 1e-16
Cps1170 gnd px_lad107_9 1e-16
Cps1171 gnd px_lad108_0 1e-16
Cps1172 gnd px_lad108_1 1e-16
Cps1173 gnd px_lad108_2 1e-16
Cps1174 gnd px_lad108_3 1e-16
Cps1175 gnd px_lad108_4 1e-16
Cps1176 gnd px_lad108_5 1e-16
Cps1177 gnd px_lad108_6 1e-16
Cps1178 gnd px_lad108_7 1e-16
Cps1179 gnd px_lad108_8 1e-16
Cps1180 gnd px_lad108_9 1e-16
Cps1181 gnd px_lad109_0 1e-16
Cps1182 gnd px_lad109_1 1e-16
Cps1183 gnd px_lad109_2 1e-16
Cps1184 gnd px_lad109_3 1e-16
Cps1185 gnd px_lad109_4 1e-16
Cps1186 gnd px_lad109_5 1e-16
Cps1187 gnd px_lad109_6 1e-16
Cps1188 gnd px_lad109_7 1e-16
Cps1189 gnd px_lad109_8 1e-16
Cps1190 gnd px_lad109_9 1e-16
Cps1191 gnd px_lad10_0 1e-16
Cps1192 gnd px_lad10_1 1e-16
Cps1193 gnd px_lad10_2 1e-16
Cps1194 gnd px_lad10_3 1e-16
Cps1195 gnd px_lad10_4 1e-16
Cps1196 gnd px_lad10_5 1e-16
Cps1197 gnd px_lad10_6 1e-16
Cps1198 gnd px_lad10_7 1e-16
Cps1199 gnd px_lad10_8 1e-16
Cps1200 gnd px_lad10_9 1e-16
Cps1201 gnd px_lad110_0 1e-16
Cps1202 gnd px_lad110_1 1e-16
Cps1203 gnd px_lad110_2 1e-16
Cps1204 gnd px_lad110_3 1e-16
Cps1205 gnd px_lad110_4 1e-16
Cps1206 gnd px_lad110_5 1e-16
Cps1207 gnd px_lad110_6 1e-16
Cps1208 gnd px_lad110_7 1e-16
Cps1209 gnd px_lad110_8 1e-16
Cps1210 gnd px_lad110_9 1e-16
Cps1211 gnd px_lad111_0 1e-16
Cps1212 gnd px_lad111_1 1e-16
Cps1213 gnd px_lad111_2 1e-16
Cps1214 gnd px_lad111_3 1e-16
Cps1215 gnd px_lad111_4 1e-16
Cps1216 gnd px_lad111_5 1e-16
Cps1217 gnd px_lad111_6 1e-16
Cps1218 gnd px_lad111_7 1e-16
Cps1219 gnd px_lad111_8 1e-16
Cps1220 gnd px_lad111_9 1e-16
Cps1221 gnd px_lad112_0 1e-16
Cps1222 gnd px_lad112_1 1e-16
Cps1223 gnd px_lad112_2 1e-16
Cps1224 gnd px_lad112_3 1e-16
Cps1225 gnd px_lad112_4 1e-16
Cps1226 gnd px_lad112_5 1e-16
Cps1227 gnd px_lad112_6 1e-16
Cps1228 gnd px_lad112_7 1e-16
Cps1229 gnd px_lad112_8 1e-16
Cps1230 gnd px_lad112_9 1e-16
Cps1231 gnd px_lad113_0 1e-16
Cps1232 gnd px_lad113_1 1e-16
Cps1233 gnd px_lad113_2 1e-16
Cps1234 gnd px_lad113_3 1e-16
Cps1235 gnd px_lad113_4 1e-16
Cps1236 gnd px_lad113_5 1e-16
Cps1237 gnd px_lad113_6 1e-16
Cps1238 gnd px_lad113_7 1e-16
Cps1239 gnd px_lad113_8 1e-16
Cps1240 gnd px_lad113_9 1e-16
Cps1241 gnd px_lad114_0 1e-16
Cps1242 gnd px_lad114_1 1e-16
Cps1243 gnd px_lad114_2 1e-16
Cps1244 gnd px_lad114_3 1e-16
Cps1245 gnd px_lad114_4 1e-16
Cps1246 gnd px_lad114_5 1e-16
Cps1247 gnd px_lad114_6 1e-16
Cps1248 gnd px_lad114_7 1e-16
Cps1249 gnd px_lad114_8 1e-16
Cps1250 gnd px_lad114_9 1e-16
Cps1251 gnd px_lad115_0 1e-16
Cps1252 gnd px_lad115_1 1e-16
Cps1253 gnd px_lad115_2 1e-16
Cps1254 gnd px_lad115_3 1e-16
Cps1255 gnd px_lad115_4 1e-16
Cps1256 gnd px_lad115_5 1e-16
Cps1257 gnd px_lad115_6 1e-16
Cps1258 gnd px_lad115_7 1e-16
Cps1259 gnd px_lad115_8 1e-16
Cps1260 gnd px_lad115_9 1e-16
Cps1261 gnd px_lad116_0 1e-16
Cps1262 gnd px_lad116_1 1e-16
Cps1263 gnd px_lad116_2 1e-16
Cps1264 gnd px_lad116_3 1e-16
Cps1265 gnd px_lad116_4 1e-16
Cps1266 gnd px_lad116_5 1e-16
Cps1267 gnd px_lad116_6 1e-16
Cps1268 gnd px_lad116_7 1e-16
Cps1269 gnd px_lad116_8 1e-16
Cps1270 gnd px_lad116_9 1e-16
Cps1271 gnd px_lad117_0 1e-16
Cps1272 gnd px_lad117_1 1e-16
Cps1273 gnd px_lad117_2 1e-16
Cps1274 gnd px_lad117_3 1e-16
Cps1275 gnd px_lad117_4 1e-16
Cps1276 gnd px_lad117_5 1e-16
Cps1277 gnd px_lad117_6 1e-16
Cps1278 gnd px_lad117_7 1e-16
Cps1279 gnd px_lad117_8 1e-16
Cps1280 gnd px_lad117_9 1e-16
Cps1281 gnd px_lad118_0 1e-16
Cps1282 gnd px_lad118_1 1e-16
Cps1283 gnd px_lad118_2 1e-16
Cps1284 gnd px_lad118_3 1e-16
Cps1285 gnd px_lad118_4 1e-16
Cps1286 gnd px_lad118_5 1e-16
Cps1287 gnd px_lad118_6 1e-16
Cps1288 gnd px_lad118_7 1e-16
Cps1289 gnd px_lad118_8 1e-16
Cps1290 gnd px_lad118_9 1e-16
Cps1291 gnd px_lad119_0 1e-16
Cps1292 gnd px_lad119_1 1e-16
Cps1293 gnd px_lad119_2 1e-16
Cps1294 gnd px_lad119_3 1e-16
Cps1295 gnd px_lad119_4 1e-16
Cps1296 gnd px_lad119_5 1e-16
Cps1297 gnd px_lad119_6 1e-16
Cps1298 gnd px_lad119_7 1e-16
Cps1299 gnd px_lad119_8 1e-16
Cps1300 gnd px_lad119_9 1e-16
Cps1301 gnd px_lad11_0 1e-16
Cps1302 gnd px_lad11_1 1e-16
Cps1303 gnd px_lad11_2 1e-16
Cps1304 gnd px_lad11_3 1e-16
Cps1305 gnd px_lad11_4 1e-16
Cps1306 gnd px_lad11_5 1e-16
Cps1307 gnd px_lad11_6 1e-16
Cps1308 gnd px_lad11_7 1e-16
Cps1309 gnd px_lad11_8 1e-16
Cps1310 gnd px_lad11_9 1e-16
Cps1311 gnd px_lad120_0 1e-16
Cps1312 gnd px_lad120_1 1e-16
Cps1313 gnd px_lad120_2 1e-16
Cps1314 gnd px_lad120_3 1e-16
Cps1315 gnd px_lad120_4 1e-16
Cps1316 gnd px_lad120_5 1e-16
Cps1317 gnd px_lad120_6 1e-16
Cps1318 gnd px_lad120_7 1e-16
Cps1319 gnd px_lad120_8 1e-16
Cps1320 gnd px_lad120_9 1e-16
Cps1321 gnd px_lad121_0 1e-16
Cps1322 gnd px_lad121_1 1e-16
Cps1323 gnd px_lad121_2 1e-16
Cps1324 gnd px_lad121_3 1e-16
Cps1325 gnd px_lad121_4 1e-16
Cps1326 gnd px_lad121_5 1e-16
Cps1327 gnd px_lad121_6 1e-16
Cps1328 gnd px_lad121_7 1e-16
Cps1329 gnd px_lad121_8 1e-16
Cps1330 gnd px_lad121_9 1e-16
Cps1331 gnd px_lad122_0 1e-16
Cps1332 gnd px_lad122_1 1e-16
Cps1333 gnd px_lad122_2 1e-16
Cps1334 gnd px_lad122_3 1e-16
Cps1335 gnd px_lad122_4 1e-16
Cps1336 gnd px_lad122_5 1e-16
Cps1337 gnd px_lad122_6 1e-16
Cps1338 gnd px_lad122_7 1e-16
Cps1339 gnd px_lad122_8 1e-16
Cps1340 gnd px_lad122_9 1e-16
Cps1341 gnd px_lad123_0 1e-16
Cps1342 gnd px_lad123_1 1e-16
Cps1343 gnd px_lad123_2 1e-16
Cps1344 gnd px_lad123_3 1e-16
Cps1345 gnd px_lad123_4 1e-16
Cps1346 gnd px_lad123_5 1e-16
Cps1347 gnd px_lad123_6 1e-16
Cps1348 gnd px_lad123_7 1e-16
Cps1349 gnd px_lad123_8 1e-16
Cps1350 gnd px_lad123_9 1e-16
Cps1351 gnd px_lad124_0 1e-16
Cps1352 gnd px_lad124_1 1e-16
Cps1353 gnd px_lad124_2 1e-16
Cps1354 gnd px_lad124_3 1e-16
Cps1355 gnd px_lad124_4 1e-16
Cps1356 gnd px_lad124_5 1e-16
Cps1357 gnd px_lad124_6 1e-16
Cps1358 gnd px_lad124_7 1e-16
Cps1359 gnd px_lad124_8 1e-16
Cps1360 gnd px_lad124_9 1e-16
Cps1361 gnd px_lad125_0 1e-16
Cps1362 gnd px_lad125_1 1e-16
Cps1363 gnd px_lad125_2 1e-16
Cps1364 gnd px_lad125_3 1e-16
Cps1365 gnd px_lad125_4 1e-16
Cps1366 gnd px_lad125_5 1e-16
Cps1367 gnd px_lad125_6 1e-16
Cps1368 gnd px_lad125_7 1e-16
Cps1369 gnd px_lad125_8 1e-16
Cps1370 gnd px_lad125_9 1e-16
Cps1371 gnd px_lad126_0 1e-16
Cps1372 gnd px_lad126_1 1e-16
Cps1373 gnd px_lad126_2 1e-16
Cps1374 gnd px_lad126_3 1e-16
Cps1375 gnd px_lad126_4 1e-16
Cps1376 gnd px_lad126_5 1e-16
Cps1377 gnd px_lad126_6 1e-16
Cps1378 gnd px_lad126_7 1e-16
Cps1379 gnd px_lad126_8 1e-16
Cps1380 gnd px_lad126_9 1e-16
Cps1381 gnd px_lad127_0 1e-16
Cps1382 gnd px_lad127_1 1e-16
Cps1383 gnd px_lad127_2 1e-16
Cps1384 gnd px_lad127_3 1e-16
Cps1385 gnd px_lad127_4 1e-16
Cps1386 gnd px_lad127_5 1e-16
Cps1387 gnd px_lad127_6 1e-16
Cps1388 gnd px_lad127_7 1e-16
Cps1389 gnd px_lad127_8 1e-16
Cps1390 gnd px_lad127_9 1e-16
Cps1391 gnd px_lad128_0 1e-16
Cps1392 gnd px_lad128_1 1e-16
Cps1393 gnd px_lad128_2 1e-16
Cps1394 gnd px_lad128_3 1e-16
Cps1395 gnd px_lad128_4 1e-16
Cps1396 gnd px_lad128_5 1e-16
Cps1397 gnd px_lad128_6 1e-16
Cps1398 gnd px_lad128_7 1e-16
Cps1399 gnd px_lad128_8 1e-16
Cps1400 gnd px_lad128_9 1e-16
Cps1401 gnd px_lad129_0 1e-16
Cps1402 gnd px_lad129_1 1e-16
Cps1403 gnd px_lad129_2 1e-16
Cps1404 gnd px_lad129_3 1e-16
Cps1405 gnd px_lad129_4 1e-16
Cps1406 gnd px_lad129_5 1e-16
Cps1407 gnd px_lad129_6 1e-16
Cps1408 gnd px_lad129_7 1e-16
Cps1409 gnd px_lad129_8 1e-16
Cps1410 gnd px_lad129_9 1e-16
Cps1411 gnd px_lad12_0 1e-16
Cps1412 gnd px_lad12_1 1e-16
Cps1413 gnd px_lad12_2 1e-16
Cps1414 gnd px_lad12_3 1e-16
Cps1415 gnd px_lad12_4 1e-16
Cps1416 gnd px_lad12_5 1e-16
Cps1417 gnd px_lad12_6 1e-16
Cps1418 gnd px_lad12_7 1e-16
Cps1419 gnd px_lad12_8 1e-16
Cps1420 gnd px_lad12_9 1e-16
Cps1421 gnd px_lad130_0 1e-16
Cps1422 gnd px_lad130_1 1e-16
Cps1423 gnd px_lad130_2 1e-16
Cps1424 gnd px_lad130_3 1e-16
Cps1425 gnd px_lad130_4 1e-16
Cps1426 gnd px_lad130_5 1e-16
Cps1427 gnd px_lad130_6 1e-16
Cps1428 gnd px_lad130_7 1e-16
Cps1429 gnd px_lad130_8 1e-16
Cps1430 gnd px_lad130_9 1e-16
Cps1431 gnd px_lad131_0 1e-16
Cps1432 gnd px_lad131_1 1e-16
Cps1433 gnd px_lad131_2 1e-16
Cps1434 gnd px_lad131_3 1e-16
Cps1435 gnd px_lad131_4 1e-16
Cps1436 gnd px_lad131_5 1e-16
Cps1437 gnd px_lad131_6 1e-16
Cps1438 gnd px_lad131_7 1e-16
Cps1439 gnd px_lad131_8 1e-16
Cps1440 gnd px_lad131_9 1e-16
Cps1441 gnd px_lad132_0 1e-16
Cps1442 gnd px_lad132_1 1e-16
Cps1443 gnd px_lad132_2 1e-16
Cps1444 gnd px_lad132_3 1e-16
Cps1445 gnd px_lad132_4 1e-16
Cps1446 gnd px_lad132_5 1e-16
Cps1447 gnd px_lad132_6 1e-16
Cps1448 gnd px_lad132_7 1e-16
Cps1449 gnd px_lad132_8 1e-16
Cps1450 gnd px_lad132_9 1e-16
Cps1451 gnd px_lad133_0 1e-16
Cps1452 gnd px_lad133_1 1e-16
Cps1453 gnd px_lad133_2 1e-16
Cps1454 gnd px_lad133_3 1e-16
Cps1455 gnd px_lad133_4 1e-16
Cps1456 gnd px_lad133_5 1e-16
Cps1457 gnd px_lad133_6 1e-16
Cps1458 gnd px_lad133_7 1e-16
Cps1459 gnd px_lad133_8 1e-16
Cps1460 gnd px_lad133_9 1e-16
Cps1461 gnd px_lad134_0 1e-16
Cps1462 gnd px_lad134_1 1e-16
Cps1463 gnd px_lad134_2 1e-16
Cps1464 gnd px_lad134_3 1e-16
Cps1465 gnd px_lad134_4 1e-16
Cps1466 gnd px_lad134_5 1e-16
Cps1467 gnd px_lad134_6 1e-16
Cps1468 gnd px_lad134_7 1e-16
Cps1469 gnd px_lad134_8 1e-16
Cps1470 gnd px_lad134_9 1e-16
Cps1471 gnd px_lad135_0 1e-16
Cps1472 gnd px_lad135_1 1e-16
Cps1473 gnd px_lad135_2 1e-16
Cps1474 gnd px_lad135_3 1e-16
Cps1475 gnd px_lad135_4 1e-16
Cps1476 gnd px_lad135_5 1e-16
Cps1477 gnd px_lad135_6 1e-16
Cps1478 gnd px_lad135_7 1e-16
Cps1479 gnd px_lad135_8 1e-16
Cps1480 gnd px_lad135_9 1e-16
Cps1481 gnd px_lad136_0 1e-16
Cps1482 gnd px_lad136_1 1e-16
Cps1483 gnd px_lad136_2 1e-16
Cps1484 gnd px_lad136_3 1e-16
Cps1485 gnd px_lad136_4 1e-16
Cps1486 gnd px_lad136_5 1e-16
Cps1487 gnd px_lad136_6 1e-16
Cps1488 gnd px_lad136_7 1e-16
Cps1489 gnd px_lad136_8 1e-16
Cps1490 gnd px_lad136_9 1e-16
Cps1491 gnd px_lad137_0 1e-16
Cps1492 gnd px_lad137_1 1e-16
Cps1493 gnd px_lad137_2 1e-16
Cps1494 gnd px_lad137_3 1e-16
Cps1495 gnd px_lad137_4 1e-16
Cps1496 gnd px_lad137_5 1e-16
Cps1497 gnd px_lad137_6 1e-16
Cps1498 gnd px_lad137_7 1e-16
Cps1499 gnd px_lad137_8 1e-16
Cps1500 gnd px_lad137_9 1e-16
Cps1501 gnd px_lad138_0 1e-16
Cps1502 gnd px_lad138_1 1e-16
Cps1503 gnd px_lad138_2 1e-16
Cps1504 gnd px_lad138_3 1e-16
Cps1505 gnd px_lad138_4 1e-16
Cps1506 gnd px_lad138_5 1e-16
Cps1507 gnd px_lad138_6 1e-16
Cps1508 gnd px_lad138_7 1e-16
Cps1509 gnd px_lad138_8 1e-16
Cps1510 gnd px_lad138_9 1e-16
Cps1511 gnd px_lad139_0 1e-16
Cps1512 gnd px_lad139_1 1e-16
Cps1513 gnd px_lad139_2 1e-16
Cps1514 gnd px_lad139_3 1e-16
Cps1515 gnd px_lad139_4 1e-16
Cps1516 gnd px_lad139_5 1e-16
Cps1517 gnd px_lad139_6 1e-16
Cps1518 gnd px_lad139_7 1e-16
Cps1519 gnd px_lad139_8 1e-16
Cps1520 gnd px_lad139_9 1e-16
Cps1521 gnd px_lad13_0 1e-16
Cps1522 gnd px_lad13_1 1e-16
Cps1523 gnd px_lad13_2 1e-16
Cps1524 gnd px_lad13_3 1e-16
Cps1525 gnd px_lad13_4 1e-16
Cps1526 gnd px_lad13_5 1e-16
Cps1527 gnd px_lad13_6 1e-16
Cps1528 gnd px_lad13_7 1e-16
Cps1529 gnd px_lad13_8 1e-16
Cps1530 gnd px_lad13_9 1e-16
Cps1531 gnd px_lad140_0 1e-16
Cps1532 gnd px_lad140_1 1e-16
Cps1533 gnd px_lad140_2 1e-16
Cps1534 gnd px_lad140_3 1e-16
Cps1535 gnd px_lad140_4 1e-16
Cps1536 gnd px_lad140_5 1e-16
Cps1537 gnd px_lad140_6 1e-16
Cps1538 gnd px_lad140_7 1e-16
Cps1539 gnd px_lad140_8 1e-16
Cps1540 gnd px_lad140_9 1e-16
Cps1541 gnd px_lad141_0 1e-16
Cps1542 gnd px_lad141_1 1e-16
Cps1543 gnd px_lad141_2 1e-16
Cps1544 gnd px_lad141_3 1e-16
Cps1545 gnd px_lad141_4 1e-16
Cps1546 gnd px_lad141_5 1e-16
Cps1547 gnd px_lad141_6 1e-16
Cps1548 gnd px_lad141_7 1e-16
Cps1549 gnd px_lad141_8 1e-16
Cps1550 gnd px_lad141_9 1e-16
Cps1551 gnd px_lad142_0 1e-16
Cps1552 gnd px_lad142_1 1e-16
Cps1553 gnd px_lad142_2 1e-16
Cps1554 gnd px_lad142_3 1e-16
Cps1555 gnd px_lad142_4 1e-16
Cps1556 gnd px_lad142_5 1e-16
Cps1557 gnd px_lad142_6 1e-16
Cps1558 gnd px_lad142_7 1e-16
Cps1559 gnd px_lad142_8 1e-16
Cps1560 gnd px_lad142_9 1e-16
Cps1561 gnd px_lad143_0 1e-16
Cps1562 gnd px_lad143_1 1e-16
Cps1563 gnd px_lad143_2 1e-16
Cps1564 gnd px_lad143_3 1e-16
Cps1565 gnd px_lad143_4 1e-16
Cps1566 gnd px_lad143_5 1e-16
Cps1567 gnd px_lad143_6 1e-16
Cps1568 gnd px_lad143_7 1e-16
Cps1569 gnd px_lad143_8 1e-16
Cps1570 gnd px_lad143_9 1e-16
Cps1571 gnd px_lad144_0 1e-16
Cps1572 gnd px_lad144_1 1e-16
Cps1573 gnd px_lad144_2 1e-16
Cps1574 gnd px_lad144_3 1e-16
Cps1575 gnd px_lad144_4 1e-16
Cps1576 gnd px_lad144_5 1e-16
Cps1577 gnd px_lad144_6 1e-16
Cps1578 gnd px_lad144_7 1e-16
Cps1579 gnd px_lad144_8 1e-16
Cps1580 gnd px_lad144_9 1e-16
Cps1581 gnd px_lad145_0 1e-16
Cps1582 gnd px_lad145_1 1e-16
Cps1583 gnd px_lad145_2 1e-16
Cps1584 gnd px_lad145_3 1e-16
Cps1585 gnd px_lad145_4 1e-16
Cps1586 gnd px_lad145_5 1e-16
Cps1587 gnd px_lad145_6 1e-16
Cps1588 gnd px_lad145_7 1e-16
Cps1589 gnd px_lad145_8 1e-16
Cps1590 gnd px_lad145_9 1e-16
Cps1591 gnd px_lad146_0 1e-16
Cps1592 gnd px_lad146_1 1e-16
Cps1593 gnd px_lad146_2 1e-16
Cps1594 gnd px_lad146_3 1e-16
Cps1595 gnd px_lad146_4 1e-16
Cps1596 gnd px_lad146_5 1e-16
Cps1597 gnd px_lad146_6 1e-16
Cps1598 gnd px_lad146_7 1e-16
Cps1599 gnd px_lad146_8 1e-16
Cps1600 gnd px_lad146_9 1e-16
Cps1601 gnd px_lad147_0 1e-16
Cps1602 gnd px_lad147_1 1e-16
Cps1603 gnd px_lad147_2 1e-16
Cps1604 gnd px_lad147_3 1e-16
Cps1605 gnd px_lad147_4 1e-16
Cps1606 gnd px_lad147_5 1e-16
Cps1607 gnd px_lad147_6 1e-16
Cps1608 gnd px_lad147_7 1e-16
Cps1609 gnd px_lad147_8 1e-16
Cps1610 gnd px_lad147_9 1e-16
Cps1611 gnd px_lad148_0 1e-16
Cps1612 gnd px_lad148_1 1e-16
Cps1613 gnd px_lad148_2 1e-16
Cps1614 gnd px_lad148_3 1e-16
Cps1615 gnd px_lad148_4 1e-16
Cps1616 gnd px_lad148_5 1e-16
Cps1617 gnd px_lad148_6 1e-16
Cps1618 gnd px_lad148_7 1e-16
Cps1619 gnd px_lad148_8 1e-16
Cps1620 gnd px_lad148_9 1e-16
Cps1621 gnd px_lad149_0 1e-16
Cps1622 gnd px_lad149_1 1e-16
Cps1623 gnd px_lad149_2 1e-16
Cps1624 gnd px_lad149_3 1e-16
Cps1625 gnd px_lad149_4 1e-16
Cps1626 gnd px_lad149_5 1e-16
Cps1627 gnd px_lad149_6 1e-16
Cps1628 gnd px_lad149_7 1e-16
Cps1629 gnd px_lad149_8 1e-16
Cps1630 gnd px_lad149_9 1e-16
Cps1631 gnd px_lad14_0 1e-16
Cps1632 gnd px_lad14_1 1e-16
Cps1633 gnd px_lad14_2 1e-16
Cps1634 gnd px_lad14_3 1e-16
Cps1635 gnd px_lad14_4 1e-16
Cps1636 gnd px_lad14_5 1e-16
Cps1637 gnd px_lad14_6 1e-16
Cps1638 gnd px_lad14_7 1e-16
Cps1639 gnd px_lad14_8 1e-16
Cps1640 gnd px_lad14_9 1e-16
Cps1641 gnd px_lad15_0 1e-16
Cps1642 gnd px_lad15_1 1e-16
Cps1643 gnd px_lad15_2 1e-16
Cps1644 gnd px_lad15_3 1e-16
Cps1645 gnd px_lad15_4 1e-16
Cps1646 gnd px_lad15_5 1e-16
Cps1647 gnd px_lad15_6 1e-16
Cps1648 gnd px_lad15_7 1e-16
Cps1649 gnd px_lad15_8 1e-16
Cps1650 gnd px_lad15_9 1e-16
Cps1651 gnd px_lad16_0 1e-16
Cps1652 gnd px_lad16_1 1e-16
Cps1653 gnd px_lad16_2 1e-16
Cps1654 gnd px_lad16_3 1e-16
Cps1655 gnd px_lad16_4 1e-16
Cps1656 gnd px_lad16_5 1e-16
Cps1657 gnd px_lad16_6 1e-16
Cps1658 gnd px_lad16_7 1e-16
Cps1659 gnd px_lad16_8 1e-16
Cps1660 gnd px_lad16_9 1e-16
Cps1661 gnd px_lad17_0 1e-16
Cps1662 gnd px_lad17_1 1e-16
Cps1663 gnd px_lad17_2 1e-16
Cps1664 gnd px_lad17_3 1e-16
Cps1665 gnd px_lad17_4 1e-16
Cps1666 gnd px_lad17_5 1e-16
Cps1667 gnd px_lad17_6 1e-16
Cps1668 gnd px_lad17_7 1e-16
Cps1669 gnd px_lad17_8 1e-16
Cps1670 gnd px_lad17_9 1e-16
Cps1671 gnd px_lad18_0 1e-16
Cps1672 gnd px_lad18_1 1e-16
Cps1673 gnd px_lad18_2 1e-16
Cps1674 gnd px_lad18_3 1e-16
Cps1675 gnd px_lad18_4 1e-16
Cps1676 gnd px_lad18_5 1e-16
Cps1677 gnd px_lad18_6 1e-16
Cps1678 gnd px_lad18_7 1e-16
Cps1679 gnd px_lad18_8 1e-16
Cps1680 gnd px_lad18_9 1e-16
Cps1681 gnd px_lad19_0 1e-16
Cps1682 gnd px_lad19_1 1e-16
Cps1683 gnd px_lad19_2 1e-16
Cps1684 gnd px_lad19_3 1e-16
Cps1685 gnd px_lad19_4 1e-16
Cps1686 gnd px_lad19_5 1e-16
Cps1687 gnd px_lad19_6 1e-16
Cps1688 gnd px_lad19_7 1e-16
Cps1689 gnd px_lad19_8 1e-16
Cps1690 gnd px_lad19_9 1e-16
Cps1691 gnd px_lad1_0 1e-16
Cps1692 gnd px_lad1_1 1e-16
Cps1693 gnd px_lad1_2 1e-16
Cps1694 gnd px_lad1_3 1e-16
Cps1695 gnd px_lad1_4 1e-16
Cps1696 gnd px_lad1_5 1e-16
Cps1697 gnd px_lad1_6 1e-16
Cps1698 gnd px_lad1_7 1e-16
Cps1699 gnd px_lad1_8 1e-16
Cps1700 gnd px_lad1_9 1e-16
Cps1701 gnd px_lad20_0 1e-16
Cps1702 gnd px_lad20_1 1e-16
Cps1703 gnd px_lad20_2 1e-16
Cps1704 gnd px_lad20_3 1e-16
Cps1705 gnd px_lad20_4 1e-16
Cps1706 gnd px_lad20_5 1e-16
Cps1707 gnd px_lad20_6 1e-16
Cps1708 gnd px_lad20_7 1e-16
Cps1709 gnd px_lad20_8 1e-16
Cps1710 gnd px_lad20_9 1e-16
Cps1711 gnd px_lad21_0 1e-16
Cps1712 gnd px_lad21_1 1e-16
Cps1713 gnd px_lad21_2 1e-16
Cps1714 gnd px_lad21_3 1e-16
Cps1715 gnd px_lad21_4 1e-16
Cps1716 gnd px_lad21_5 1e-16
Cps1717 gnd px_lad21_6 1e-16
Cps1718 gnd px_lad21_7 1e-16
Cps1719 gnd px_lad21_8 1e-16
Cps1720 gnd px_lad21_9 1e-16
Cps1721 gnd px_lad22_0 1e-16
Cps1722 gnd px_lad22_1 1e-16
Cps1723 gnd px_lad22_2 1e-16
Cps1724 gnd px_lad22_3 1e-16
Cps1725 gnd px_lad22_4 1e-16
Cps1726 gnd px_lad22_5 1e-16
Cps1727 gnd px_lad22_6 1e-16
Cps1728 gnd px_lad22_7 1e-16
Cps1729 gnd px_lad22_8 1e-16
Cps1730 gnd px_lad22_9 1e-16
Cps1731 gnd px_lad23_0 1e-16
Cps1732 gnd px_lad23_1 1e-16
Cps1733 gnd px_lad23_2 1e-16
Cps1734 gnd px_lad23_3 1e-16
Cps1735 gnd px_lad23_4 1e-16
Cps1736 gnd px_lad23_5 1e-16
Cps1737 gnd px_lad23_6 1e-16
Cps1738 gnd px_lad23_7 1e-16
Cps1739 gnd px_lad23_8 1e-16
Cps1740 gnd px_lad23_9 1e-16
Cps1741 gnd px_lad24_0 1e-16
Cps1742 gnd px_lad24_1 1e-16
Cps1743 gnd px_lad24_2 1e-16
Cps1744 gnd px_lad24_3 1e-16
Cps1745 gnd px_lad24_4 1e-16
Cps1746 gnd px_lad24_5 1e-16
Cps1747 gnd px_lad24_6 1e-16
Cps1748 gnd px_lad24_7 1e-16
Cps1749 gnd px_lad24_8 1e-16
Cps1750 gnd px_lad24_9 1e-16
Cps1751 gnd px_lad25_0 1e-16
Cps1752 gnd px_lad25_1 1e-16
Cps1753 gnd px_lad25_2 1e-16
Cps1754 gnd px_lad25_3 1e-16
Cps1755 gnd px_lad25_4 1e-16
Cps1756 gnd px_lad25_5 1e-16
Cps1757 gnd px_lad25_6 1e-16
Cps1758 gnd px_lad25_7 1e-16
Cps1759 gnd px_lad25_8 1e-16
Cps1760 gnd px_lad25_9 1e-16
Cps1761 gnd px_lad26_0 1e-16
Cps1762 gnd px_lad26_1 1e-16
Cps1763 gnd px_lad26_2 1e-16
Cps1764 gnd px_lad26_3 1e-16
Cps1765 gnd px_lad26_4 1e-16
Cps1766 gnd px_lad26_5 1e-16
Cps1767 gnd px_lad26_6 1e-16
Cps1768 gnd px_lad26_7 1e-16
Cps1769 gnd px_lad26_8 1e-16
Cps1770 gnd px_lad26_9 1e-16
Cps1771 gnd px_lad27_0 1e-16
Cps1772 gnd px_lad27_1 1e-16
Cps1773 gnd px_lad27_2 1e-16
Cps1774 gnd px_lad27_3 1e-16
Cps1775 gnd px_lad27_4 1e-16
Cps1776 gnd px_lad27_5 1e-16
Cps1777 gnd px_lad27_6 1e-16
Cps1778 gnd px_lad27_7 1e-16
Cps1779 gnd px_lad27_8 1e-16
Cps1780 gnd px_lad27_9 1e-16
Cps1781 gnd px_lad28_0 1e-16
Cps1782 gnd px_lad28_1 1e-16
Cps1783 gnd px_lad28_2 1e-16
Cps1784 gnd px_lad28_3 1e-16
Cps1785 gnd px_lad28_4 1e-16
Cps1786 gnd px_lad28_5 1e-16
Cps1787 gnd px_lad28_6 1e-16
Cps1788 gnd px_lad28_7 1e-16
Cps1789 gnd px_lad28_8 1e-16
Cps1790 gnd px_lad28_9 1e-16
Cps1791 gnd px_lad29_0 1e-16
Cps1792 gnd px_lad29_1 1e-16
Cps1793 gnd px_lad29_2 1e-16
Cps1794 gnd px_lad29_3 1e-16
Cps1795 gnd px_lad29_4 1e-16
Cps1796 gnd px_lad29_5 1e-16
Cps1797 gnd px_lad29_6 1e-16
Cps1798 gnd px_lad29_7 1e-16
Cps1799 gnd px_lad29_8 1e-16
Cps1800 gnd px_lad29_9 1e-16
Cps1801 gnd px_lad2_0 1e-16
Cps1802 gnd px_lad2_1 1e-16
Cps1803 gnd px_lad2_2 1e-16
Cps1804 gnd px_lad2_3 1e-16
Cps1805 gnd px_lad2_4 1e-16
Cps1806 gnd px_lad2_5 1e-16
Cps1807 gnd px_lad2_6 1e-16
Cps1808 gnd px_lad2_7 1e-16
Cps1809 gnd px_lad2_8 1e-16
Cps1810 gnd px_lad2_9 1e-16
Cps1811 gnd px_lad30_0 1e-16
Cps1812 gnd px_lad30_1 1e-16
Cps1813 gnd px_lad30_2 1e-16
Cps1814 gnd px_lad30_3 1e-16
Cps1815 gnd px_lad30_4 1e-16
Cps1816 gnd px_lad30_5 1e-16
Cps1817 gnd px_lad30_6 1e-16
Cps1818 gnd px_lad30_7 1e-16
Cps1819 gnd px_lad30_8 1e-16
Cps1820 gnd px_lad30_9 1e-16
Cps1821 gnd px_lad31_0 1e-16
Cps1822 gnd px_lad31_1 1e-16
Cps1823 gnd px_lad31_2 1e-16
Cps1824 gnd px_lad31_3 1e-16
Cps1825 gnd px_lad31_4 1e-16
Cps1826 gnd px_lad31_5 1e-16
Cps1827 gnd px_lad31_6 1e-16
Cps1828 gnd px_lad31_7 1e-16
Cps1829 gnd px_lad31_8 1e-16
Cps1830 gnd px_lad31_9 1e-16
Cps1831 gnd px_lad32_0 1e-16
Cps1832 gnd px_lad32_1 1e-16
Cps1833 gnd px_lad32_2 1e-16
Cps1834 gnd px_lad32_3 1e-16
Cps1835 gnd px_lad32_4 1e-16
Cps1836 gnd px_lad32_5 1e-16
Cps1837 gnd px_lad32_6 1e-16
Cps1838 gnd px_lad32_7 1e-16
Cps1839 gnd px_lad32_8 1e-16
Cps1840 gnd px_lad32_9 1e-16
Cps1841 gnd px_lad33_0 1e-16
Cps1842 gnd px_lad33_1 1e-16
Cps1843 gnd px_lad33_2 1e-16
Cps1844 gnd px_lad33_3 1e-16
Cps1845 gnd px_lad33_4 1e-16
Cps1846 gnd px_lad33_5 1e-16
Cps1847 gnd px_lad33_6 1e-16
Cps1848 gnd px_lad33_7 1e-16
Cps1849 gnd px_lad33_8 1e-16
Cps1850 gnd px_lad33_9 1e-16
Cps1851 gnd px_lad34_0 1e-16
Cps1852 gnd px_lad34_1 1e-16
Cps1853 gnd px_lad34_2 1e-16
Cps1854 gnd px_lad34_3 1e-16
Cps1855 gnd px_lad34_4 1e-16
Cps1856 gnd px_lad34_5 1e-16
Cps1857 gnd px_lad34_6 1e-16
Cps1858 gnd px_lad34_7 1e-16
Cps1859 gnd px_lad34_8 1e-16
Cps1860 gnd px_lad34_9 1e-16
Cps1861 gnd px_lad35_0 1e-16
Cps1862 gnd px_lad35_1 1e-16
Cps1863 gnd px_lad35_2 1e-16
Cps1864 gnd px_lad35_3 1e-16
Cps1865 gnd px_lad35_4 1e-16
Cps1866 gnd px_lad35_5 1e-16
Cps1867 gnd px_lad35_6 1e-16
Cps1868 gnd px_lad35_7 1e-16
Cps1869 gnd px_lad35_8 1e-16
Cps1870 gnd px_lad35_9 1e-16
Cps1871 gnd px_lad36_0 1e-16
Cps1872 gnd px_lad36_1 1e-16
Cps1873 gnd px_lad36_2 1e-16
Cps1874 gnd px_lad36_3 1e-16
Cps1875 gnd px_lad36_4 1e-16
Cps1876 gnd px_lad36_5 1e-16
Cps1877 gnd px_lad36_6 1e-16
Cps1878 gnd px_lad36_7 1e-16
Cps1879 gnd px_lad36_8 1e-16
Cps1880 gnd px_lad36_9 1e-16
Cps1881 gnd px_lad37_0 1e-16
Cps1882 gnd px_lad37_1 1e-16
Cps1883 gnd px_lad37_2 1e-16
Cps1884 gnd px_lad37_3 1e-16
Cps1885 gnd px_lad37_4 1e-16
Cps1886 gnd px_lad37_5 1e-16
Cps1887 gnd px_lad37_6 1e-16
Cps1888 gnd px_lad37_7 1e-16
Cps1889 gnd px_lad37_8 1e-16
Cps1890 gnd px_lad37_9 1e-16
Cps1891 gnd px_lad38_0 1e-16
Cps1892 gnd px_lad38_1 1e-16
Cps1893 gnd px_lad38_2 1e-16
Cps1894 gnd px_lad38_3 1e-16
Cps1895 gnd px_lad38_4 1e-16
Cps1896 gnd px_lad38_5 1e-16
Cps1897 gnd px_lad38_6 1e-16
Cps1898 gnd px_lad38_7 1e-16
Cps1899 gnd px_lad38_8 1e-16
Cps1900 gnd px_lad38_9 1e-16
Cps1901 gnd px_lad39_0 1e-16
Cps1902 gnd px_lad39_1 1e-16
Cps1903 gnd px_lad39_2 1e-16
Cps1904 gnd px_lad39_3 1e-16
Cps1905 gnd px_lad39_4 1e-16
Cps1906 gnd px_lad39_5 1e-16
Cps1907 gnd px_lad39_6 1e-16
Cps1908 gnd px_lad39_7 1e-16
Cps1909 gnd px_lad39_8 1e-16
Cps1910 gnd px_lad39_9 1e-16
Cps1911 gnd px_lad3_0 1e-16
Cps1912 gnd px_lad3_1 1e-16
Cps1913 gnd px_lad3_2 1e-16
Cps1914 gnd px_lad3_3 1e-16
Cps1915 gnd px_lad3_4 1e-16
Cps1916 gnd px_lad3_5 1e-16
Cps1917 gnd px_lad3_6 1e-16
Cps1918 gnd px_lad3_7 1e-16
Cps1919 gnd px_lad3_8 1e-16
Cps1920 gnd px_lad3_9 1e-16
Cps1921 gnd px_lad40_0 1e-16
Cps1922 gnd px_lad40_1 1e-16
Cps1923 gnd px_lad40_2 1e-16
Cps1924 gnd px_lad40_3 1e-16
Cps1925 gnd px_lad40_4 1e-16
Cps1926 gnd px_lad40_5 1e-16
Cps1927 gnd px_lad40_6 1e-16
Cps1928 gnd px_lad40_7 1e-16
Cps1929 gnd px_lad40_8 1e-16
Cps1930 gnd px_lad40_9 1e-16
Cps1931 gnd px_lad41_0 1e-16
Cps1932 gnd px_lad41_1 1e-16
Cps1933 gnd px_lad41_2 1e-16
Cps1934 gnd px_lad41_3 1e-16
Cps1935 gnd px_lad41_4 1e-16
Cps1936 gnd px_lad41_5 1e-16
Cps1937 gnd px_lad41_6 1e-16
Cps1938 gnd px_lad41_7 1e-16
Cps1939 gnd px_lad41_8 1e-16
Cps1940 gnd px_lad41_9 1e-16
Cps1941 gnd px_lad42_0 1e-16
Cps1942 gnd px_lad42_1 1e-16
Cps1943 gnd px_lad42_2 1e-16
Cps1944 gnd px_lad42_3 1e-16
Cps1945 gnd px_lad42_4 1e-16
Cps1946 gnd px_lad42_5 1e-16
Cps1947 gnd px_lad42_6 1e-16
Cps1948 gnd px_lad42_7 1e-16
Cps1949 gnd px_lad42_8 1e-16
Cps1950 gnd px_lad42_9 1e-16
Cps1951 gnd px_lad43_0 1e-16
Cps1952 gnd px_lad43_1 1e-16
Cps1953 gnd px_lad43_2 1e-16
Cps1954 gnd px_lad43_3 1e-16
Cps1955 gnd px_lad43_4 1e-16
Cps1956 gnd px_lad43_5 1e-16
Cps1957 gnd px_lad43_6 1e-16
Cps1958 gnd px_lad43_7 1e-16
Cps1959 gnd px_lad43_8 1e-16
Cps1960 gnd px_lad43_9 1e-16
Cps1961 gnd px_lad44_0 1e-16
Cps1962 gnd px_lad44_1 1e-16
Cps1963 gnd px_lad44_2 1e-16
Cps1964 gnd px_lad44_3 1e-16
Cps1965 gnd px_lad44_4 1e-16
Cps1966 gnd px_lad44_5 1e-16
Cps1967 gnd px_lad44_6 1e-16
Cps1968 gnd px_lad44_7 1e-16
Cps1969 gnd px_lad44_8 1e-16
Cps1970 gnd px_lad44_9 1e-16
Cps1971 gnd px_lad45_0 1e-16
Cps1972 gnd px_lad45_1 1e-16
Cps1973 gnd px_lad45_2 1e-16
Cps1974 gnd px_lad45_3 1e-16
Cps1975 gnd px_lad45_4 1e-16
Cps1976 gnd px_lad45_5 1e-16
Cps1977 gnd px_lad45_6 1e-16
Cps1978 gnd px_lad45_7 1e-16
Cps1979 gnd px_lad45_8 1e-16
Cps1980 gnd px_lad45_9 1e-16
Cps1981 gnd px_lad46_0 1e-16
Cps1982 gnd px_lad46_1 1e-16
Cps1983 gnd px_lad46_2 1e-16
Cps1984 gnd px_lad46_3 1e-16
Cps1985 gnd px_lad46_4 1e-16
Cps1986 gnd px_lad46_5 1e-16
Cps1987 gnd px_lad46_6 1e-16
Cps1988 gnd px_lad46_7 1e-16
Cps1989 gnd px_lad46_8 1e-16
Cps1990 gnd px_lad46_9 1e-16
Cps1991 gnd px_lad47_0 1e-16
Cps1992 gnd px_lad47_1 1e-16
Cps1993 gnd px_lad47_2 1e-16
Cps1994 gnd px_lad47_3 1e-16
Cps1995 gnd px_lad47_4 1e-16
Cps1996 gnd px_lad47_5 1e-16
Cps1997 gnd px_lad47_6 1e-16
Cps1998 gnd px_lad47_7 1e-16
Cps1999 gnd px_lad47_8 1e-16
Cps2000 gnd px_lad47_9 1e-16
Cps2001 gnd px_lad48_0 1e-16
Cps2002 gnd px_lad48_1 1e-16
Cps2003 gnd px_lad48_2 1e-16
Cps2004 gnd px_lad48_3 1e-16
Cps2005 gnd px_lad48_4 1e-16
Cps2006 gnd px_lad48_5 1e-16
Cps2007 gnd px_lad48_6 1e-16
Cps2008 gnd px_lad48_7 1e-16
Cps2009 gnd px_lad48_8 1e-16
Cps2010 gnd px_lad48_9 1e-16
Cps2011 gnd px_lad49_0 1e-16
Cps2012 gnd px_lad49_1 1e-16
Cps2013 gnd px_lad49_2 1e-16
Cps2014 gnd px_lad49_3 1e-16
Cps2015 gnd px_lad49_4 1e-16
Cps2016 gnd px_lad49_5 1e-16
Cps2017 gnd px_lad49_6 1e-16
Cps2018 gnd px_lad49_7 1e-16
Cps2019 gnd px_lad49_8 1e-16
Cps2020 gnd px_lad49_9 1e-16
Cps2021 gnd px_lad4_0 1e-16
Cps2022 gnd px_lad4_1 1e-16
Cps2023 gnd px_lad4_2 1e-16
Cps2024 gnd px_lad4_3 1e-16
Cps2025 gnd px_lad4_4 1e-16
Cps2026 gnd px_lad4_5 1e-16
Cps2027 gnd px_lad4_6 1e-16
Cps2028 gnd px_lad4_7 1e-16
Cps2029 gnd px_lad4_8 1e-16
Cps2030 gnd px_lad4_9 1e-16
Cps2031 gnd px_lad50_0 1e-16
Cps2032 gnd px_lad50_1 1e-16
Cps2033 gnd px_lad50_2 1e-16
Cps2034 gnd px_lad50_3 1e-16
Cps2035 gnd px_lad50_4 1e-16
Cps2036 gnd px_lad50_5 1e-16
Cps2037 gnd px_lad50_6 1e-16
Cps2038 gnd px_lad50_7 1e-16
Cps2039 gnd px_lad50_8 1e-16
Cps2040 gnd px_lad50_9 1e-16
Cps2041 gnd px_lad51_0 1e-16
Cps2042 gnd px_lad51_1 1e-16
Cps2043 gnd px_lad51_2 1e-16
Cps2044 gnd px_lad51_3 1e-16
Cps2045 gnd px_lad51_4 1e-16
Cps2046 gnd px_lad51_5 1e-16
Cps2047 gnd px_lad51_6 1e-16
Cps2048 gnd px_lad51_7 1e-16
Cps2049 gnd px_lad51_8 1e-16
Cps2050 gnd px_lad51_9 1e-16
Cps2051 gnd px_lad52_0 1e-16
Cps2052 gnd px_lad52_1 1e-16
Cps2053 gnd px_lad52_2 1e-16
Cps2054 gnd px_lad52_3 1e-16
Cps2055 gnd px_lad52_4 1e-16
Cps2056 gnd px_lad52_5 1e-16
Cps2057 gnd px_lad52_6 1e-16
Cps2058 gnd px_lad52_7 1e-16
Cps2059 gnd px_lad52_8 1e-16
Cps2060 gnd px_lad52_9 1e-16
Cps2061 gnd px_lad53_0 1e-16
Cps2062 gnd px_lad53_1 1e-16
Cps2063 gnd px_lad53_2 1e-16
Cps2064 gnd px_lad53_3 1e-16
Cps2065 gnd px_lad53_4 1e-16
Cps2066 gnd px_lad53_5 1e-16
Cps2067 gnd px_lad53_6 1e-16
Cps2068 gnd px_lad53_7 1e-16
Cps2069 gnd px_lad53_8 1e-16
Cps2070 gnd px_lad53_9 1e-16
Cps2071 gnd px_lad54_0 1e-16
Cps2072 gnd px_lad54_1 1e-16
Cps2073 gnd px_lad54_2 1e-16
Cps2074 gnd px_lad54_3 1e-16
Cps2075 gnd px_lad54_4 1e-16
Cps2076 gnd px_lad54_5 1e-16
Cps2077 gnd px_lad54_6 1e-16
Cps2078 gnd px_lad54_7 1e-16
Cps2079 gnd px_lad54_8 1e-16
Cps2080 gnd px_lad54_9 1e-16
Cps2081 gnd px_lad55_0 1e-16
Cps2082 gnd px_lad55_1 1e-16
Cps2083 gnd px_lad55_2 1e-16
Cps2084 gnd px_lad55_3 1e-16
Cps2085 gnd px_lad55_4 1e-16
Cps2086 gnd px_lad55_5 1e-16
Cps2087 gnd px_lad55_6 1e-16
Cps2088 gnd px_lad55_7 1e-16
Cps2089 gnd px_lad55_8 1e-16
Cps2090 gnd px_lad55_9 1e-16
Cps2091 gnd px_lad56_0 1e-16
Cps2092 gnd px_lad56_1 1e-16
Cps2093 gnd px_lad56_2 1e-16
Cps2094 gnd px_lad56_3 1e-16
Cps2095 gnd px_lad56_4 1e-16
Cps2096 gnd px_lad56_5 1e-16
Cps2097 gnd px_lad56_6 1e-16
Cps2098 gnd px_lad56_7 1e-16
Cps2099 gnd px_lad56_8 1e-16
Cps2100 gnd px_lad56_9 1e-16
Cps2101 gnd px_lad57_0 1e-16
Cps2102 gnd px_lad57_1 1e-16
Cps2103 gnd px_lad57_2 1e-16
Cps2104 gnd px_lad57_3 1e-16
Cps2105 gnd px_lad57_4 1e-16
Cps2106 gnd px_lad57_5 1e-16
Cps2107 gnd px_lad57_6 1e-16
Cps2108 gnd px_lad57_7 1e-16
Cps2109 gnd px_lad57_8 1e-16
Cps2110 gnd px_lad57_9 1e-16
Cps2111 gnd px_lad58_0 1e-16
Cps2112 gnd px_lad58_1 1e-16
Cps2113 gnd px_lad58_2 1e-16
Cps2114 gnd px_lad58_3 1e-16
Cps2115 gnd px_lad58_4 1e-16
Cps2116 gnd px_lad58_5 1e-16
Cps2117 gnd px_lad58_6 1e-16
Cps2118 gnd px_lad58_7 1e-16
Cps2119 gnd px_lad58_8 1e-16
Cps2120 gnd px_lad58_9 1e-16
Cps2121 gnd px_lad59_0 1e-16
Cps2122 gnd px_lad59_1 1e-16
Cps2123 gnd px_lad59_2 1e-16
Cps2124 gnd px_lad59_3 1e-16
Cps2125 gnd px_lad59_4 1e-16
Cps2126 gnd px_lad59_5 1e-16
Cps2127 gnd px_lad59_6 1e-16
Cps2128 gnd px_lad59_7 1e-16
Cps2129 gnd px_lad59_8 1e-16
Cps2130 gnd px_lad59_9 1e-16
Cps2131 gnd px_lad5_0 1e-16
Cps2132 gnd px_lad5_1 1e-16
Cps2133 gnd px_lad5_2 1e-16
Cps2134 gnd px_lad5_3 1e-16
Cps2135 gnd px_lad5_4 1e-16
Cps2136 gnd px_lad5_5 1e-16
Cps2137 gnd px_lad5_6 1e-16
Cps2138 gnd px_lad5_7 1e-16
Cps2139 gnd px_lad5_8 1e-16
Cps2140 gnd px_lad5_9 1e-16
Cps2141 gnd px_lad60_0 1e-16
Cps2142 gnd px_lad60_1 1e-16
Cps2143 gnd px_lad60_2 1e-16
Cps2144 gnd px_lad60_3 1e-16
Cps2145 gnd px_lad60_4 1e-16
Cps2146 gnd px_lad60_5 1e-16
Cps2147 gnd px_lad60_6 1e-16
Cps2148 gnd px_lad60_7 1e-16
Cps2149 gnd px_lad60_8 1e-16
Cps2150 gnd px_lad60_9 1e-16
Cps2151 gnd px_lad61_0 1e-16
Cps2152 gnd px_lad61_1 1e-16
Cps2153 gnd px_lad61_2 1e-16
Cps2154 gnd px_lad61_3 1e-16
Cps2155 gnd px_lad61_4 1e-16
Cps2156 gnd px_lad61_5 1e-16
Cps2157 gnd px_lad61_6 1e-16
Cps2158 gnd px_lad61_7 1e-16
Cps2159 gnd px_lad61_8 1e-16
Cps2160 gnd px_lad61_9 1e-16
Cps2161 gnd px_lad62_0 1e-16
Cps2162 gnd px_lad62_1 1e-16
Cps2163 gnd px_lad62_2 1e-16
Cps2164 gnd px_lad62_3 1e-16
Cps2165 gnd px_lad62_4 1e-16
Cps2166 gnd px_lad62_5 1e-16
Cps2167 gnd px_lad62_6 1e-16
Cps2168 gnd px_lad62_7 1e-16
Cps2169 gnd px_lad62_8 1e-16
Cps2170 gnd px_lad62_9 1e-16
Cps2171 gnd px_lad63_0 1e-16
Cps2172 gnd px_lad63_1 1e-16
Cps2173 gnd px_lad63_2 1e-16
Cps2174 gnd px_lad63_3 1e-16
Cps2175 gnd px_lad63_4 1e-16
Cps2176 gnd px_lad63_5 1e-16
Cps2177 gnd px_lad63_6 1e-16
Cps2178 gnd px_lad63_7 1e-16
Cps2179 gnd px_lad63_8 1e-16
Cps2180 gnd px_lad63_9 1e-16
Cps2181 gnd px_lad64_0 1e-16
Cps2182 gnd px_lad64_1 1e-16
Cps2183 gnd px_lad64_2 1e-16
Cps2184 gnd px_lad64_3 1e-16
Cps2185 gnd px_lad64_4 1e-16
Cps2186 gnd px_lad64_5 1e-16
Cps2187 gnd px_lad64_6 1e-16
Cps2188 gnd px_lad64_7 1e-16
Cps2189 gnd px_lad64_8 1e-16
Cps2190 gnd px_lad64_9 1e-16
Cps2191 gnd px_lad65_0 1e-16
Cps2192 gnd px_lad65_1 1e-16
Cps2193 gnd px_lad65_2 1e-16
Cps2194 gnd px_lad65_3 1e-16
Cps2195 gnd px_lad65_4 1e-16
Cps2196 gnd px_lad65_5 1e-16
Cps2197 gnd px_lad65_6 1e-16
Cps2198 gnd px_lad65_7 1e-16
Cps2199 gnd px_lad65_8 1e-16
Cps2200 gnd px_lad65_9 1e-16
Cps2201 gnd px_lad66_0 1e-16
Cps2202 gnd px_lad66_1 1e-16
Cps2203 gnd px_lad66_2 1e-16
Cps2204 gnd px_lad66_3 1e-16
Cps2205 gnd px_lad66_4 1e-16
Cps2206 gnd px_lad66_5 1e-16
Cps2207 gnd px_lad66_6 1e-16
Cps2208 gnd px_lad66_7 1e-16
Cps2209 gnd px_lad66_8 1e-16
Cps2210 gnd px_lad66_9 1e-16
Cps2211 gnd px_lad67_0 1e-16
Cps2212 gnd px_lad67_1 1e-16
Cps2213 gnd px_lad67_2 1e-16
Cps2214 gnd px_lad67_3 1e-16
Cps2215 gnd px_lad67_4 1e-16
Cps2216 gnd px_lad67_5 1e-16
Cps2217 gnd px_lad67_6 1e-16
Cps2218 gnd px_lad67_7 1e-16
Cps2219 gnd px_lad67_8 1e-16
Cps2220 gnd px_lad67_9 1e-16
Cps2221 gnd px_lad68_0 1e-16
Cps2222 gnd px_lad68_1 1e-16
Cps2223 gnd px_lad68_2 1e-16
Cps2224 gnd px_lad68_3 1e-16
Cps2225 gnd px_lad68_4 1e-16
Cps2226 gnd px_lad68_5 1e-16
Cps2227 gnd px_lad68_6 1e-16
Cps2228 gnd px_lad68_7 1e-16
Cps2229 gnd px_lad68_8 1e-16
Cps2230 gnd px_lad68_9 1e-16
Cps2231 gnd px_lad69_0 1e-16
Cps2232 gnd px_lad69_1 1e-16
Cps2233 gnd px_lad69_2 1e-16
Cps2234 gnd px_lad69_3 1e-16
Cps2235 gnd px_lad69_4 1e-16
Cps2236 gnd px_lad69_5 1e-16
Cps2237 gnd px_lad69_6 1e-16
Cps2238 gnd px_lad69_7 1e-16
Cps2239 gnd px_lad69_8 1e-16
Cps2240 gnd px_lad69_9 1e-16
Cps2241 gnd px_lad6_0 1e-16
Cps2242 gnd px_lad6_1 1e-16
Cps2243 gnd px_lad6_2 1e-16
Cps2244 gnd px_lad6_3 1e-16
Cps2245 gnd px_lad6_4 1e-16
Cps2246 gnd px_lad6_5 1e-16
Cps2247 gnd px_lad6_6 1e-16
Cps2248 gnd px_lad6_7 1e-16
Cps2249 gnd px_lad6_8 1e-16
Cps2250 gnd px_lad6_9 1e-16
Cps2251 gnd px_lad70_0 1e-16
Cps2252 gnd px_lad70_1 1e-16
Cps2253 gnd px_lad70_2 1e-16
Cps2254 gnd px_lad70_3 1e-16
Cps2255 gnd px_lad70_4 1e-16
Cps2256 gnd px_lad70_5 1e-16
Cps2257 gnd px_lad70_6 1e-16
Cps2258 gnd px_lad70_7 1e-16
Cps2259 gnd px_lad70_8 1e-16
Cps2260 gnd px_lad70_9 1e-16
Cps2261 gnd px_lad71_0 1e-16
Cps2262 gnd px_lad71_1 1e-16
Cps2263 gnd px_lad71_2 1e-16
Cps2264 gnd px_lad71_3 1e-16
Cps2265 gnd px_lad71_4 1e-16
Cps2266 gnd px_lad71_5 1e-16
Cps2267 gnd px_lad71_6 1e-16
Cps2268 gnd px_lad71_7 1e-16
Cps2269 gnd px_lad71_8 1e-16
Cps2270 gnd px_lad71_9 1e-16
Cps2271 gnd px_lad72_0 1e-16
Cps2272 gnd px_lad72_1 1e-16
Cps2273 gnd px_lad72_2 1e-16
Cps2274 gnd px_lad72_3 1e-16
Cps2275 gnd px_lad72_4 1e-16
Cps2276 gnd px_lad72_5 1e-16
Cps2277 gnd px_lad72_6 1e-16
Cps2278 gnd px_lad72_7 1e-16
Cps2279 gnd px_lad72_8 1e-16
Cps2280 gnd px_lad72_9 1e-16
Cps2281 gnd px_lad73_0 1e-16
Cps2282 gnd px_lad73_1 1e-16
Cps2283 gnd px_lad73_2 1e-16
Cps2284 gnd px_lad73_3 1e-16
Cps2285 gnd px_lad73_4 1e-16
Cps2286 gnd px_lad73_5 1e-16
Cps2287 gnd px_lad73_6 1e-16
Cps2288 gnd px_lad73_7 1e-16
Cps2289 gnd px_lad73_8 1e-16
Cps2290 gnd px_lad73_9 1e-16
Cps2291 gnd px_lad74_0 1e-16
Cps2292 gnd px_lad74_1 1e-16
Cps2293 gnd px_lad74_2 1e-16
Cps2294 gnd px_lad74_3 1e-16
Cps2295 gnd px_lad74_4 1e-16
Cps2296 gnd px_lad74_5 1e-16
Cps2297 gnd px_lad74_6 1e-16
Cps2298 gnd px_lad74_7 1e-16
Cps2299 gnd px_lad74_8 1e-16
Cps2300 gnd px_lad74_9 1e-16
Cps2301 gnd px_lad75_0 1e-16
Cps2302 gnd px_lad75_1 1e-16
Cps2303 gnd px_lad75_2 1e-16
Cps2304 gnd px_lad75_3 1e-16
Cps2305 gnd px_lad75_4 1e-16
Cps2306 gnd px_lad75_5 1e-16
Cps2307 gnd px_lad75_6 1e-16
Cps2308 gnd px_lad75_7 1e-16
Cps2309 gnd px_lad75_8 1e-16
Cps2310 gnd px_lad75_9 1e-16
Cps2311 gnd px_lad76_0 1e-16
Cps2312 gnd px_lad76_1 1e-16
Cps2313 gnd px_lad76_2 1e-16
Cps2314 gnd px_lad76_3 1e-16
Cps2315 gnd px_lad76_4 1e-16
Cps2316 gnd px_lad76_5 1e-16
Cps2317 gnd px_lad76_6 1e-16
Cps2318 gnd px_lad76_7 1e-16
Cps2319 gnd px_lad76_8 1e-16
Cps2320 gnd px_lad76_9 1e-16
Cps2321 gnd px_lad77_0 1e-16
Cps2322 gnd px_lad77_1 1e-16
Cps2323 gnd px_lad77_2 1e-16
Cps2324 gnd px_lad77_3 1e-16
Cps2325 gnd px_lad77_4 1e-16
Cps2326 gnd px_lad77_5 1e-16
Cps2327 gnd px_lad77_6 1e-16
Cps2328 gnd px_lad77_7 1e-16
Cps2329 gnd px_lad77_8 1e-16
Cps2330 gnd px_lad77_9 1e-16
Cps2331 gnd px_lad78_0 1e-16
Cps2332 gnd px_lad78_1 1e-16
Cps2333 gnd px_lad78_2 1e-16
Cps2334 gnd px_lad78_3 1e-16
Cps2335 gnd px_lad78_4 1e-16
Cps2336 gnd px_lad78_5 1e-16
Cps2337 gnd px_lad78_6 1e-16
Cps2338 gnd px_lad78_7 1e-16
Cps2339 gnd px_lad78_8 1e-16
Cps2340 gnd px_lad78_9 1e-16
Cps2341 gnd px_lad79_0 1e-16
Cps2342 gnd px_lad79_1 1e-16
Cps2343 gnd px_lad79_2 1e-16
Cps2344 gnd px_lad79_3 1e-16
Cps2345 gnd px_lad79_4 1e-16
Cps2346 gnd px_lad79_5 1e-16
Cps2347 gnd px_lad79_6 1e-16
Cps2348 gnd px_lad79_7 1e-16
Cps2349 gnd px_lad79_8 1e-16
Cps2350 gnd px_lad79_9 1e-16
Cps2351 gnd px_lad7_0 1e-16
Cps2352 gnd px_lad7_1 1e-16
Cps2353 gnd px_lad7_2 1e-16
Cps2354 gnd px_lad7_3 1e-16
Cps2355 gnd px_lad7_4 1e-16
Cps2356 gnd px_lad7_5 1e-16
Cps2357 gnd px_lad7_6 1e-16
Cps2358 gnd px_lad7_7 1e-16
Cps2359 gnd px_lad7_8 1e-16
Cps2360 gnd px_lad7_9 1e-16
Cps2361 gnd px_lad80_0 1e-16
Cps2362 gnd px_lad80_1 1e-16
Cps2363 gnd px_lad80_2 1e-16
Cps2364 gnd px_lad80_3 1e-16
Cps2365 gnd px_lad80_4 1e-16
Cps2366 gnd px_lad80_5 1e-16
Cps2367 gnd px_lad80_6 1e-16
Cps2368 gnd px_lad80_7 1e-16
Cps2369 gnd px_lad80_8 1e-16
Cps2370 gnd px_lad80_9 1e-16
Cps2371 gnd px_lad81_0 1e-16
Cps2372 gnd px_lad81_1 1e-16
Cps2373 gnd px_lad81_2 1e-16
Cps2374 gnd px_lad81_3 1e-16
Cps2375 gnd px_lad81_4 1e-16
Cps2376 gnd px_lad81_5 1e-16
Cps2377 gnd px_lad81_6 1e-16
Cps2378 gnd px_lad81_7 1e-16
Cps2379 gnd px_lad81_8 1e-16
Cps2380 gnd px_lad81_9 1e-16
Cps2381 gnd px_lad82_0 1e-16
Cps2382 gnd px_lad82_1 1e-16
Cps2383 gnd px_lad82_2 1e-16
Cps2384 gnd px_lad82_3 1e-16
Cps2385 gnd px_lad82_4 1e-16
Cps2386 gnd px_lad82_5 1e-16
Cps2387 gnd px_lad82_6 1e-16
Cps2388 gnd px_lad82_7 1e-16
Cps2389 gnd px_lad82_8 1e-16
Cps2390 gnd px_lad82_9 1e-16
Cps2391 gnd px_lad83_0 1e-16
Cps2392 gnd px_lad83_1 1e-16
Cps2393 gnd px_lad83_2 1e-16
Cps2394 gnd px_lad83_3 1e-16
Cps2395 gnd px_lad83_4 1e-16
Cps2396 gnd px_lad83_5 1e-16
Cps2397 gnd px_lad83_6 1e-16
Cps2398 gnd px_lad83_7 1e-16
Cps2399 gnd px_lad83_8 1e-16
Cps2400 gnd px_lad83_9 1e-16
Cps2401 gnd px_lad84_0 1e-16
Cps2402 gnd px_lad84_1 1e-16
Cps2403 gnd px_lad84_2 1e-16
Cps2404 gnd px_lad84_3 1e-16
Cps2405 gnd px_lad84_4 1e-16
Cps2406 gnd px_lad84_5 1e-16
Cps2407 gnd px_lad84_6 1e-16
Cps2408 gnd px_lad84_7 1e-16
Cps2409 gnd px_lad84_8 1e-16
Cps2410 gnd px_lad84_9 1e-16
Cps2411 gnd px_lad85_0 1e-16
Cps2412 gnd px_lad85_1 1e-16
Cps2413 gnd px_lad85_2 1e-16
Cps2414 gnd px_lad85_3 1e-16
Cps2415 gnd px_lad85_4 1e-16
Cps2416 gnd px_lad85_5 1e-16
Cps2417 gnd px_lad85_6 1e-16
Cps2418 gnd px_lad85_7 1e-16
Cps2419 gnd px_lad85_8 1e-16
Cps2420 gnd px_lad85_9 1e-16
Cps2421 gnd px_lad86_0 1e-16
Cps2422 gnd px_lad86_1 1e-16
Cps2423 gnd px_lad86_2 1e-16
Cps2424 gnd px_lad86_3 1e-16
Cps2425 gnd px_lad86_4 1e-16
Cps2426 gnd px_lad86_5 1e-16
Cps2427 gnd px_lad86_6 1e-16
Cps2428 gnd px_lad86_7 1e-16
Cps2429 gnd px_lad86_8 1e-16
Cps2430 gnd px_lad86_9 1e-16
Cps2431 gnd px_lad87_0 1e-16
Cps2432 gnd px_lad87_1 1e-16
Cps2433 gnd px_lad87_2 1e-16
Cps2434 gnd px_lad87_3 1e-16
Cps2435 gnd px_lad87_4 1e-16
Cps2436 gnd px_lad87_5 1e-16
Cps2437 gnd px_lad87_6 1e-16
Cps2438 gnd px_lad87_7 1e-16
Cps2439 gnd px_lad87_8 1e-16
Cps2440 gnd px_lad87_9 1e-16
Cps2441 gnd px_lad88_0 1e-16
Cps2442 gnd px_lad88_1 1e-16
Cps2443 gnd px_lad88_2 1e-16
Cps2444 gnd px_lad88_3 1e-16
Cps2445 gnd px_lad88_4 1e-16
Cps2446 gnd px_lad88_5 1e-16
Cps2447 gnd px_lad88_6 1e-16
Cps2448 gnd px_lad88_7 1e-16
Cps2449 gnd px_lad88_8 1e-16
Cps2450 gnd px_lad88_9 1e-16
Cps2451 gnd px_lad89_0 1e-16
Cps2452 gnd px_lad89_1 1e-16
Cps2453 gnd px_lad89_2 1e-16
Cps2454 gnd px_lad89_3 1e-16
Cps2455 gnd px_lad89_4 1e-16
Cps2456 gnd px_lad89_5 1e-16
Cps2457 gnd px_lad89_6 1e-16
Cps2458 gnd px_lad89_7 1e-16
Cps2459 gnd px_lad89_8 1e-16
Cps2460 gnd px_lad89_9 1e-16
Cps2461 gnd px_lad8_0 1e-16
Cps2462 gnd px_lad8_1 1e-16
Cps2463 gnd px_lad8_2 1e-16
Cps2464 gnd px_lad8_3 1e-16
Cps2465 gnd px_lad8_4 1e-16
Cps2466 gnd px_lad8_5 1e-16
Cps2467 gnd px_lad8_6 1e-16
Cps2468 gnd px_lad8_7 1e-16
Cps2469 gnd px_lad8_8 1e-16
Cps2470 gnd px_lad8_9 1e-16
Cps2471 gnd px_lad90_0 1e-16
Cps2472 gnd px_lad90_1 1e-16
Cps2473 gnd px_lad90_2 1e-16
Cps2474 gnd px_lad90_3 1e-16
Cps2475 gnd px_lad90_4 1e-16
Cps2476 gnd px_lad90_5 1e-16
Cps2477 gnd px_lad90_6 1e-16
Cps2478 gnd px_lad90_7 1e-16
Cps2479 gnd px_lad90_8 1e-16
Cps2480 gnd px_lad90_9 1e-16
Cps2481 gnd px_lad91_0 1e-16
Cps2482 gnd px_lad91_1 1e-16
Cps2483 gnd px_lad91_2 1e-16
Cps2484 gnd px_lad91_3 1e-16
Cps2485 gnd px_lad91_4 1e-16
Cps2486 gnd px_lad91_5 1e-16
Cps2487 gnd px_lad91_6 1e-16
Cps2488 gnd px_lad91_7 1e-16
Cps2489 gnd px_lad91_8 1e-16
Cps2490 gnd px_lad91_9 1e-16
Cps2491 gnd px_lad92_0 1e-16
Cps2492 gnd px_lad92_1 1e-16
Cps2493 gnd px_lad92_2 1e-16
Cps2494 gnd px_lad92_3 1e-16
Cps2495 gnd px_lad92_4 1e-16
Cps2496 gnd px_lad92_5 1e-16
Cps2497 gnd px_lad92_6 1e-16
Cps2498 gnd px_lad92_7 1e-16
Cps2499 gnd px_lad92_8 1e-16
Cps2500 gnd px_lad92_9 1e-16
Cps2501 gnd px_lad93_0 1e-16
Cps2502 gnd px_lad93_1 1e-16
Cps2503 gnd px_lad93_2 1e-16
Cps2504 gnd px_lad93_3 1e-16
Cps2505 gnd px_lad93_4 1e-16
Cps2506 gnd px_lad93_5 1e-16
Cps2507 gnd px_lad93_6 1e-16
Cps2508 gnd px_lad93_7 1e-16
Cps2509 gnd px_lad93_8 1e-16
Cps2510 gnd px_lad93_9 1e-16
Cps2511 gnd px_lad94_0 1e-16
Cps2512 gnd px_lad94_1 1e-16
Cps2513 gnd px_lad94_2 1e-16
Cps2514 gnd px_lad94_3 1e-16
Cps2515 gnd px_lad94_4 1e-16
Cps2516 gnd px_lad94_5 1e-16
Cps2517 gnd px_lad94_6 1e-16
Cps2518 gnd px_lad94_7 1e-16
Cps2519 gnd px_lad94_8 1e-16
Cps2520 gnd px_lad94_9 1e-16
Cps2521 gnd px_lad95_0 1e-16
Cps2522 gnd px_lad95_1 1e-16
Cps2523 gnd px_lad95_2 1e-16
Cps2524 gnd px_lad95_3 1e-16
Cps2525 gnd px_lad95_4 1e-16
Cps2526 gnd px_lad95_5 1e-16
Cps2527 gnd px_lad95_6 1e-16
Cps2528 gnd px_lad95_7 1e-16
Cps2529 gnd px_lad95_8 1e-16
Cps2530 gnd px_lad95_9 1e-16
Cps2531 gnd px_lad96_0 1e-16
Cps2532 gnd px_lad96_1 1e-16
Cps2533 gnd px_lad96_2 1e-16
Cps2534 gnd px_lad96_3 1e-16
Cps2535 gnd px_lad96_4 1e-16
Cps2536 gnd px_lad96_5 1e-16
Cps2537 gnd px_lad96_6 1e-16
Cps2538 gnd px_lad96_7 1e-16
Cps2539 gnd px_lad96_8 1e-16
Cps2540 gnd px_lad96_9 1e-16
Cps2541 gnd px_lad97_0 1e-16
Cps2542 gnd px_lad97_1 1e-16
Cps2543 gnd px_lad97_2 1e-16
Cps2544 gnd px_lad97_3 1e-16
Cps2545 gnd px_lad97_4 1e-16
Cps2546 gnd px_lad97_5 1e-16
Cps2547 gnd px_lad97_6 1e-16
Cps2548 gnd px_lad97_7 1e-16
Cps2549 gnd px_lad97_8 1e-16
Cps2550 gnd px_lad97_9 1e-16
Cps2551 gnd px_lad98_0 1e-16
Cps2552 gnd px_lad98_1 1e-16
Cps2553 gnd px_lad98_2 1e-16
Cps2554 gnd px_lad98_3 1e-16
Cps2555 gnd px_lad98_4 1e-16
Cps2556 gnd px_lad98_5 1e-16
Cps2557 gnd px_lad98_6 1e-16
Cps2558 gnd px_lad98_7 1e-16
Cps2559 gnd px_lad98_8 1e-16
Cps2560 gnd px_lad98_9 1e-16
Cps2561 gnd px_lad99_0 1e-16
Cps2562 gnd px_lad99_1 1e-16
Cps2563 gnd px_lad99_2 1e-16
Cps2564 gnd px_lad99_3 1e-16
Cps2565 gnd px_lad99_4 1e-16
Cps2566 gnd px_lad99_5 1e-16
Cps2567 gnd px_lad99_6 1e-16
Cps2568 gnd px_lad99_7 1e-16
Cps2569 gnd px_lad99_8 1e-16
Cps2570 gnd px_lad99_9 1e-16
Cps2571 gnd px_lad9_0 1e-16
Cps2572 gnd px_lad9_1 1e-16
Cps2573 gnd px_lad9_2 1e-16
Cps2574 gnd px_lad9_3 1e-16
Cps2575 gnd px_lad9_4 1e-16
Cps2576 gnd px_lad9_5 1e-16
Cps2577 gnd px_lad9_6 1e-16
Cps2578 gnd px_lad9_7 1e-16
Cps2579 gnd px_lad9_8 1e-16
Cps2580 gnd px_lad9_9 1e-16
Cps2581 gnd rstb 3.9346e-15
Cps2582 gnd rstb_n 2.4821e-15
Cps2583 gnd t0 3.7023e-15
Cps2584 gnd t0b 5.7637e-15
Cps2585 gnd t1 6.1903e-15
Cps2586 gnd t1b 3.3435e-15
Cps2587 gnd top_n 4.9898e-15
Cps2588 gnd top_p 8.3866e-15
Cps2589 gnd trk0 3.8756e-15
Cps2590 gnd trk1 5.1735e-15
Cps2591 gnd vbn 3.5336e-15
Cps2592 gnd vbp 4.751e-15
Cps2593 gnd vdd 4.9225e-15
Cps2594 gnd vref 6.2898e-15
Cps2595 gnd vrefl 4.2081e-15
Cps2596 gnd xc4_din 3.1983e-15
Cps2597 gnd xc4_dip 3.7421e-15
Cps2598 gnd xc4_lt 4.5315e-15
Cps2599 gnd xc4_outnb 4.5412e-15
Cps2600 gnd xc4_outpb 5.696e-15
Cps2601 gnd xc4_xs1_tail 5.9755e-15
Cps2602 gnd xc4_xs1_tail0 1.3669e-15
Cps2603 gnd xc5_din 4.0085e-15
Cps2604 gnd xc5_dip 4.1736e-15
Cps2605 gnd xc5_lt 4.545e-15
Cps2606 gnd xc5_outnb 3.1315e-15
Cps2607 gnd xc5_outpb 5.7348e-15
Cps2608 gnd xc5_xs1_tail 3.7096e-15
Cps2609 gnd xc5_xs1_tail0 4.4444e-15
Cps2610 gnd xs0n_cbn 4.2548e-15
Cps2611 gnd xs0n_cbp 2.8669e-15
Cps2612 gnd xs0n_g 3.0976e-15
Cps2613 gnd xs0n_n10 3.6886e-15
Cps2614 gnd xs0n_x 3.3765e-15
Cps2615 gnd xs0p_cbn 3.918e-15
Cps2616 gnd xs0p_cbp 4.9035e-15
Cps2617 gnd xs0p_g 4.291e-15
Cps2618 gnd xs0p_n10 3.2789e-15
Cps2619 gnd xs0p_x 3.4656e-15
Cps2620 gnd xs1n_cbn 4.5742e-15
Cps2621 gnd xs1n_cbp 2.6012e-15
Cps2622 gnd xs1n_g 2.3755e-15
Cps2623 gnd xs1n_n10 4.2145e-15
Cps2624 gnd xs1n_x 3.5842e-15
Cps2625 gnd xs1p_cbn 5.5265e-15
Cps2626 gnd xs1p_cbp 4.2345e-15
Cps2627 gnd xs1p_g 4.4105e-15
Cps2628 gnd xs1p_n10 4.3938e-15
Cps2629 gnd xs1p_x 3.3252e-15
Cps2630 in0n in0p 1.27e-16
Cps2631 in0n in1p 7.87e-17
Cps2632 in0n onp 1.09e-16
Cps2633 in0n vrefl 1.6e-16
Cps2634 in0n xc4_din 1.28e-16
Cps2635 in0n xc4_dip 1.02e-16
Cps2636 in0n xc4_lt 2.6e-16
Cps2637 in0n xc4_xs1_tail 3.06e-17
Cps2638 in0n xc5_lt 1.57e-16
Cps2639 in0n xs0n_g 2.55e-17
Cps2640 in0n xs0p_x 4.14e-16
Cps2641 in0n xs1n_x 1.63e-16
Cps2642 in0n xs1p_cbn 5.83e-17
Cps2643 in0n xs1p_cbp 3.48e-17
Cps2644 in0n xs1p_x 1.25e-16
Cps2645 in0p lsb_p 2.725e-16
Cps2646 in0p nr 3.1e-16
Cps2647 in0p on 8.08e-17
Cps2648 in0p onp 5.86e-16
Cps2649 in0p rstb 2.01e-16
Cps2650 in0p top_p 1.14e-16
Cps2651 in0p vbn 5.25e-17
Cps2652 in0p xc5_dip 6.12e-16
Cps2653 in0p xs0n_x 1.83e-16
Cps2654 in0p xs0p_cbp 2.27e-16
Cps2655 in0p xs0p_n10 2.732e-16
Cps2656 in0p xs1n_cbn 1.42e-16
Cps2657 in0p xs1n_cbp 1.02e-16
Cps2658 in0p xs1p_cbn 2.37e-16
Cps2659 in0p xs1p_g 5.12e-17
Cps2660 in1n lsb_n 3.82e-16
Cps2661 in1n onp 1.41e-16
Cps2662 in1n t0 2.74e-16
Cps2663 in1n t0b 1.25e-16
Cps2664 in1n vbn 1.34e-17
Cps2665 in1n vbp 5.24e-17
Cps2666 in1n vdd 1.44e-16
Cps2667 in1n xc4_lt 2.88e-16
Cps2668 in1n xc5_dip 1.65e-16
Cps2669 in1n xc5_xs1_tail0 2.51e-16
Cps2670 in1n xs0p_g 2.94e-16
Cps2671 in1n xs0p_x 1.03e-16
Cps2672 in1n xs1n_n10 3.33e-16
Cps2673 in1p on 8.36e-17
Cps2674 in1p t1 1.17e-16
Cps2675 in1p vdd 2.55e-16
Cps2676 in1p vrefl 3.53e-16
Cps2677 in1p xc4_dip 6.29e-17
Cps2678 in1p xc4_xs1_tail0 3.81e-16
Cps2679 in1p xc5_outpb 2.59e-16
Cps2680 in1p xs0n_g 4.29e-16
Cps2681 in1p xs0p_cbn 5.72e-16
Cps2682 in1p xs0p_g 4.52e-17
Cps2683 in1p xs0p_n10 2.28e-16
Cps2684 in1p xs1n_g 6.1e-17
Cps2685 lsb_n on 5.18e-16
Cps2686 lsb_n onn 1.86e-17
Cps2687 lsb_n xc4_lt 2.38e-16
Cps2688 lsb_n xc5_din 5.11e-16
Cps2689 lsb_n xc5_outnb 5.79e-17
Cps2690 lsb_n xs0n_g 1.69e-16
Cps2691 lsb_n xs0p_cbn 4.214e-16
Cps2692 lsb_n xs0p_g 7.74e-17
Cps2693 lsb_n xs1p_cbn 9.84e-16
Cps2694 lsb_n xs1p_n10 1.34e-16
Cps2695 lsb_p on 4.03e-16
Cps2696 lsb_p onn 2.01e-16
Cps2697 lsb_p rstb_n 1.01e-16
Cps2698 lsb_p top_p 4.87e-17
Cps2699 lsb_p trk0 3.44e-16
Cps2700 lsb_p trk1 9.49e-17
Cps2701 lsb_p vdd 1.64e-16
Cps2702 lsb_p xc4_lt 2.47e-16
Cps2703 lsb_p xc5_outpb 1.69e-16
Cps2704 lsb_p xs0n_cbn 3.03e-16
Cps2705 lsb_p xs0n_x 5.3e-17
Cps2706 nr on 1.21e-15
Cps2707 nr rstb 2.643e-16
Cps2708 nr vbp 1.15e-16
Cps2709 nr vrefl 1.2742e-15
Cps2710 nr xc5_dip 3.08e-16
Cps2711 nr xc5_outnb 2.39e-16
Cps2712 nr xs0p_cbp 7.79e-16
Cps2713 nr xs1n_g 8.96e-17
Cps2714 nr xs1n_n10 3.35e-16
Cps2715 on op 3.3e-17
Cps2716 on t1b 1.41e-16
Cps2717 on vrefl 5.04e-16
Cps2718 on xc4_lt 1.33e-16
Cps2719 on xc5_dip 1.01e-16
Cps2720 on xc5_outpb 1.65e-16
Cps2721 on xc5_xs1_tail 4.48e-16
Cps2722 on xs0n_g 3.3e-17
Cps2723 on xs0p_n10 2.37e-16
Cps2724 on xs0p_x 1.18e-16
Cps2725 on xs1n_g 3.54e-16
Cps2726 on xs1p_cbn 1.62e-17
Cps2727 on xs1p_n10 1.02e-16
Cps2728 onn rstb 4.85e-16
Cps2729 onn top_p 4.88e-17
Cps2730 onn xc4_dip 2.67e-16
Cps2731 onn xc4_outnb 1.34e-16
Cps2732 onn xc5_dip 1.37e-16
Cps2733 onn xc5_outnb 1.18e-16
Cps2734 onn xc5_xs1_tail 1.1e-16
Cps2735 onn xs0p_n10 1.29e-16
Cps2736 onp trk1 5.88e-17
Cps2737 onp xc4_din 2.92e-16
Cps2738 onp xc4_dip 7.95e-17
Cps2739 onp xc4_xs1_tail 7.11e-17
Cps2740 onp xc5_lt 1.4e-16
Cps2741 onp xs0n_cbn 4.431e-16
Cps2742 onp xs0p_cbp 2.26e-16
Cps2743 onp xs0p_g 4.53e-16
Cps2744 onp xs1n_cbn 1.45e-16
Cps2745 onp xs1n_g 3e-16
Cps2746 op t1 8.52e-17
Cps2747 op trk0 6.52e-16
Cps2748 op vdd 1.82e-16
Cps2749 op xc4_din 5.17e-16
Cps2750 op xc4_outnb 1.4e-16
Cps2751 op xc4_xs1_tail 3.34e-16
Cps2752 op xc5_din 1.08e-16
Cps2753 op xc5_outpb 2.37e-16
Cps2754 op xs0p_cbp 3.904e-16
Cps2755 op xs0p_n10 9.96e-17
Cps2756 op xs1n_cbn 2.42e-16
Cps2757 op xs1n_cbp 4.21e-16
Cps2758 op xs1n_g 3.04e-16
Cps2759 op xs1n_n10 7.23e-17
Cps2760 op xs1p_cbn 6.81e-17
Cps2761 op xs1p_g 2.02e-16
Cps2762 rstb top_p 6.39e-17
Cps2763 rstb trk0 4.31e-16
Cps2764 rstb trk1 1.59e-16
Cps2765 rstb vbn 1.24e-16
Cps2766 rstb xc4_outnb 1.73e-16
Cps2767 rstb xc4_xs1_tail0 1.815e-16
Cps2768 rstb xs0p_g 3.61e-16
Cps2769 rstb xs0p_x 8.84e-17
Cps2770 rstb xs1n_cbp 2.04e-16
Cps2771 rstb_n xc4_din 1.01e-16
Cps2772 rstb_n xc4_outpb 7.48e-16
Cps2773 rstb_n xc4_xs1_tail0 6.28e-16
Cps2774 rstb_n xc5_outnb 1.11e-16
Cps2775 rstb_n xc5_xs1_tail 1.53e-16
Cps2776 rstb_n xs0n_x 2.52e-16
Cps2777 rstb_n xs0p_n10 5.21e-17
Cps2778 rstb_n xs1n_cbn 9.64e-17
Cps2779 rstb_n xs1n_x 2.31e-16
Cps2780 t0 t0b 6.4e-17
Cps2781 t0 t1b 5.17e-17
Cps2782 t0 top_n 2.23e-16
Cps2783 t0 vbn 6.7e-17
Cps2784 t0 vrefl 6.627e-16
Cps2785 t0 xc5_outnb 4.87e-16
Cps2786 t0 xc5_outpb 3.04e-16
Cps2787 t0 xs0p_cbn 1.68e-16
Cps2788 t0 xs0p_cbp 7.31e-17
Cps2789 t0 xs1p_cbn 1.5e-16
Cps2790 t0 xs1p_x 2.03e-16
Cps2791 t0b top_p 6.31e-17
Cps2792 t0b trk1 4.55e-16
Cps2793 t0b vbp 1.71e-16
Cps2794 t0b xc4_dip 7.3e-17
Cps2795 t0b xc5_din 1.181e-15
Cps2796 t0b xc5_dip 2.33e-16
Cps2797 t0b xs1n_cbn 2.685e-16
Cps2798 t0b xs1n_x 1.17e-16
Cps2799 t1 top_n 4.87e-17
Cps2800 t1 trk0 1.31e-16
Cps2801 t1 xc4_outnb 5.88e-16
Cps2802 t1 xc5_lt 1.7e-16
Cps2803 t1 xc5_xs1_tail 2.965e-16
Cps2804 t1 xs1n_cbn 6.9e-17
Cps2805 t1 xs1n_g 2.45e-16
Cps2806 t1 xs1p_g 9.14e-17
Cps2807 t1 xs1p_x 2.88e-16
Cps2808 t1b top_p 3.7e-17
Cps2809 t1b trk0 4.93e-17
Cps2810 t1b vbn 2.39e-17
Cps2811 t1b xc4_lt 1.053e-16
Cps2812 t1b xc4_outpb 2.6e-16
Cps2813 t1b xc5_din 5.36e-16
Cps2814 t1b xc5_dip 5.86e-16
Cps2815 t1b xc5_lt 1.71e-16
Cps2816 t1b xs0p_n10 5.94e-16
Cps2817 t1b xs1p_cbn 2.93e-16
Cps2818 t1b xs1p_n10 4.34e-16
Cps2819 top_n top_p 4.46e-16
Cps2820 top_n vbp 1.27e-16
Cps2821 top_n xc4_din 1.71e-16
Cps2822 top_n xc4_dip 2e-16
Cps2823 top_n xc4_outpb 2.28e-16
Cps2824 top_n xc4_xs1_tail 1.139e-16
Cps2825 top_n xc4_xs1_tail0 3.19e-17
Cps2826 top_n xc5_lt 1.18e-16
Cps2827 top_n xs0n_cbn 7.87e-17
Cps2828 top_n xs0n_g 1.29e-16
Cps2829 top_n xs1p_g 2.2e-16
Cps2830 top_n xs1p_n10 9.98e-17
Cps2831 top_p vrefl 7.05e-17
Cps2832 top_p xc4_outnb 2.19e-16
Cps2833 top_p xc5_outnb 9.83e-17
Cps2834 top_p xs0p_x 2.735e-16
Cps2835 top_p xs1p_cbp 3.85e-16
Cps2836 trk0 vbn 8.49e-17
Cps2837 trk0 xc4_xs1_tail0 2.99e-17
Cps2838 trk0 xc5_xs1_tail 1.68e-16
Cps2839 trk0 xs0p_cbn 4.453e-16
Cps2840 trk0 xs0p_cbp 1.54e-16
Cps2841 trk0 xs0p_n10 4.61e-16
Cps2842 trk0 xs0p_x 1.43e-16
Cps2843 trk0 xs1p_n10 2.58e-16
Cps2844 trk0 xs1p_x 1.04e-16
Cps2845 trk1 xs0n_cbn 2.36e-16
Cps2846 trk1 xs0p_cbn 6.32e-16
Cps2847 trk1 xs0p_n10 1.05e-16
Cps2848 trk1 xs1n_cbp 1.04e-16
Cps2849 trk1 xs1n_n10 8.99e-17
Cps2850 trk1 xs1p_cbn 1.24e-16
Cps2851 vbn xc4_xs1_tail0 1.46e-16
Cps2852 vbn xc5_din 1.16e-16
Cps2853 vbn xc5_dip 1.53e-16
Cps2854 vbn xc5_outnb 6.56e-17
Cps2855 vbn xc5_outpb 5.55e-16
Cps2856 vbn xs0n_x 7.16e-17
Cps2857 vbn xs0p_cbn 1.83e-16
Cps2858 vbn xs0p_x 8.1e-17
Cps2859 vbn xs1n_g 9.47e-17
Cps2860 vbn xs1n_n10 1.59e-16
Cps2861 vbn xs1p_cbp 3.57e-16
Cps2862 vbp xc4_xs1_tail 7.08e-16
Cps2863 vbp xc5_dip 1.835e-16
Cps2864 vbp xc5_lt 3.2e-17
Cps2865 vbp xc5_outnb 1.64e-16
Cps2866 vbp xc5_xs1_tail 3.06e-16
Cps2867 vbp xs0n_cbp 5.06e-16
Cps2868 vbp xs0n_x 3.97e-16
Cps2869 vbp xs0p_g 1.74e-16
Cps2870 vbp xs1n_n10 2.4e-17
Cps2871 vdd vrefl 2.35e-17
Cps2872 vdd xc4_dip 7.57e-17
Cps2873 vdd xc4_outnb 3.89e-17
Cps2874 vdd xc5_din 1.07e-16
Cps2875 vdd xc5_lt 6.75e-17
Cps2876 vdd xs1p_x 2.9e-16
Cps2877 vref xc4_xs1_tail 5.55e-17
Cps2878 vref xc5_dip 3.25e-16
Cps2879 vref xc5_xs1_tail0 1.5e-16
Cps2880 vref xs0n_cbn 5.07e-17
Cps2881 vref xs0n_g 1.31e-16
Cps2882 vref xs0p_n10 5.6e-17
Cps2883 vref xs0p_x 1.32e-16
Cps2884 vref xs1n_g 4.56e-16
Cps2885 vref xs1p_cbn 9.32e-18
Cps2886 vref xs1p_x 3.02e-16
Cps2887 vrefl xc4_din 1.9e-16
Cps2888 vrefl xc4_dip 2.062e-16
Cps2889 vrefl xc4_outnb 3.29e-16
Cps2890 vrefl xc4_xs1_tail0 2.88e-16
Cps2891 vrefl xs0p_cbn 6.69e-17
Cps2892 vrefl xs0p_g 4.11e-17
Cps2893 vrefl xs0p_n10 2.416e-16
Cps2894 xc4_din xc4_outnb 1.9e-16
Cps2895 xc4_din xc5_din 3.65e-17
Cps2896 xc4_din xc5_outnb 1.68e-16
Cps2897 xc4_din xs0n_g 2.48e-16
Cps2898 xc4_din xs0p_g 6.48e-16
Cps2899 xc4_din xs0p_x 4.91e-16
Cps2900 xc4_din xs1n_n10 2.43e-16
Cps2901 xc4_dip xc4_xs1_tail 7.14e-17
Cps2902 xc4_dip xs0n_cbn 9.16e-17
Cps2903 xc4_dip xs0p_cbp 1.77e-16
Cps2904 xc4_dip xs1n_cbn 4.32e-17
Cps2905 xc4_dip xs1p_cbp 7.39e-17
Cps2906 xc4_lt xc5_xs1_tail 9.59e-17
Cps2907 xc4_lt xc5_xs1_tail0 2.78e-16
Cps2908 xc4_lt xs0n_cbp 2.76e-16
Cps2909 xc4_lt xs0p_g 5.01e-16
Cps2910 xc4_outnb xc4_xs1_tail0 1.141e-16
Cps2911 xc4_outnb xc5_din 1.52e-16
Cps2912 xc4_outnb xc5_dip 2.17e-16
Cps2913 xc4_outnb xc5_outpb 8.47e-17
Cps2914 xc4_outnb xc5_xs1_tail 1.14e-16
Cps2915 xc4_outnb xs0n_g 1.33e-17
Cps2916 xc4_outnb xs0p_n10 3.07e-16
Cps2917 xc4_outnb xs1n_cbp 1.03e-16
Cps2918 xc4_outnb xs1n_g 3.93e-16
Cps2919 xc4_outnb xs1p_n10 1.68e-16
Cps2920 xc4_outnb xs1p_x 2.92e-16
Cps2921 xc4_outpb xc5_outnb 2.01e-16
Cps2922 xc4_outpb xs0n_cbp 2.45e-16
Cps2923 xc4_outpb xs0n_x 1.42e-16
Cps2924 xc4_outpb xs0p_cbp 2.6e-16
Cps2925 xc4_outpb xs1n_cbn 1.89e-16
Cps2926 xc4_outpb xs1n_x 1.07e-16
Cps2927 xc4_outpb xs1p_n10 3.88e-17
Cps2928 xc4_xs1_tail xc4_xs1_tail0 5.27e-16
Cps2929 xc4_xs1_tail xs0n_cbp 1.16e-16
Cps2930 xc4_xs1_tail xs0n_g 1.27e-16
Cps2931 xc4_xs1_tail xs0p_cbp 6.68e-16
Cps2932 xc4_xs1_tail xs0p_x 3.6e-17
Cps2933 xc4_xs1_tail xs1n_g 3.37e-16
Cps2934 xc4_xs1_tail0 xc5_lt 1.23e-16
Cps2935 xc4_xs1_tail0 xc5_outpb 1.82e-16
Cps2936 xc4_xs1_tail0 xc5_xs1_tail0 1.73e-17
Cps2937 xc4_xs1_tail0 xs0n_cbp 1.82e-16
Cps2938 xc4_xs1_tail0 xs1p_cbn 9.7e-17
Cps2939 xc4_xs1_tail0 xs1p_cbp 2.8e-16
Cps2940 xc4_xs1_tail0 xs1p_n10 4.93e-17
Cps2941 xc5_din xs0n_x 2.37e-16
Cps2942 xc5_din xs0p_n10 8.34e-17
Cps2943 xc5_din xs1n_g 2.99e-16
Cps2944 xc5_din xs1n_n10 7.56e-17
Cps2945 xc5_dip xs0n_g 1.7e-16
Cps2946 xc5_dip xs0p_cbn 4.09e-16
Cps2947 xc5_dip xs0p_g 5.63e-16
Cps2948 xc5_dip xs1p_g 2.76e-17
Cps2949 xc5_lt xc5_xs1_tail 4.33e-16
Cps2950 xc5_lt xc5_xs1_tail0 5.71e-17
Cps2951 xc5_lt xs0p_cbp 3.12e-16
Cps2952 xc5_lt xs1n_x 2.4e-16
Cps2953 xc5_lt xs1p_cbn 8.24e-17
Cps2954 xc5_outnb xs0p_n10 6.75e-16
Cps2955 xc5_outnb xs1p_n10 3.32e-16
Cps2956 xc5_outpb xs0n_g 1.85e-16
Cps2957 xc5_outpb xs0p_cbn 4.18e-16
Cps2958 xc5_outpb xs0p_cbp 1.9e-16
Cps2959 xc5_outpb xs0p_n10 1.05e-16
Cps2960 xc5_outpb xs1n_g 7.46e-17
Cps2961 xc5_outpb xs1n_n10 6.32e-17
Cps2962 xc5_outpb xs1p_g 4.4e-16
Cps2963 xc5_outpb xs1p_n10 1.71e-16
Cps2964 xc5_xs1_tail xs0n_cbn 2.57e-16
Cps2965 xc5_xs1_tail xs0p_cbp 1.34e-16
Cps2966 xc5_xs1_tail xs0p_n10 2.23e-17
Cps2967 xc5_xs1_tail xs1n_n10 4.84e-17
Cps2968 xc5_xs1_tail xs1p_cbp 1.41e-16
Cps2969 xc5_xs1_tail0 xs0n_cbn 2.23e-16
Cps2970 xc5_xs1_tail0 xs0n_cbp 1.34e-16
Cps2971 xc5_xs1_tail0 xs0n_x 3.37e-16
Cps2972 xc5_xs1_tail0 xs0p_cbn 1.31e-16
Cps2973 xc5_xs1_tail0 xs1p_g 1.29e-16
Cps2974 xs0n_cbn xs0p_x 2.32e-16
Cps2975 xs0n_cbp xs0p_cbp 1.22e-16
Cps2976 xs0n_cbp xs0p_g 1.6e-16
Cps2977 xs0n_cbp xs1n_cbn 1.08e-16
Cps2978 xs0n_cbp xs1n_g 2.47e-16
Cps2979 xs0n_cbp xs1p_cbn 2.011e-16
Cps2980 xs0n_cbp xs1p_n10 5.02e-16
Cps2981 xs0n_g xs0n_x 4.08e-16
Cps2982 xs0n_g xs1n_x 4.17e-17
Cps2983 xs0n_g xs1p_x 1.43e-16
Cps2984 xs0n_n10 xs1n_g 2.03e-16
Cps2985 xs0n_x xs1n_cbn 6.26e-16
Cps2986 xs0n_x xs1n_g 8.02e-17
Cps2987 xs0n_x xs1n_x 8.28e-17
Cps2988 xs0n_x xs1p_g 1.19e-16
Cps2989 xs0p_cbn xs1n_cbp 1.23e-16
Cps2990 xs0p_cbn xs1p_cbp 3.34e-17
Cps2991 xs0p_cbn xs1p_g 1.09e-16
Cps2992 xs0p_cbn xs1p_n10 1.35e-16
Cps2993 xs0p_cbp xs1n_cbn 5.29e-16
Cps2994 xs0p_cbp xs1n_n10 1.91e-16
Cps2995 xs0p_n10 xs0p_x 2.3e-16
Cps2996 xs0p_n10 xs1n_x 1.15e-16
Cps2997 xs0p_n10 xs1p_n10 6.76e-17
Cps2998 xs0p_x xs1n_cbn 4.96e-16
Cps2999 xs0p_x xs1n_x 1e-16
Cps3000 xs0p_x xs1p_cbp 1.84e-16
Cps3001 xs0p_x xs1p_g 1.28e-16
Cps3002 xs1n_cbn xs1n_n10 5.36e-16
Cps3003 xs1n_cbn xs1p_cbn 7.44e-17
Cps3004 xs1n_cbp xs1p_g 1.4e-16
Cps3005 xs1n_g xs1p_cbp 7.11e-16
Cps3006 xs1n_n10 xs1p_g 9.99e-17
Cps3007 xs1n_x xs1p_cbp 3.26e-16
Cps3008 xs1p_cbp xs1p_g 2.1e-16
Cps3009 xs1p_g xs1p_n10 6.69e-17
Rps0 cn4 px_lad0_0 19.2
Rps1 px_lad0_0 px_lad0_1 10.4
Rps2 px_lad0_1 px_lad0_2 1.15
Rps3 px_lad0_2 px_lad0_3 9.67
Rps4 px_lad0_3 px_lad0_4 12.5
Rps5 px_lad0_4 px_lad0_5 16.1
Rps6 px_lad0_5 px_lad0_6 11.1
Rps7 px_lad0_6 px_lad0_7 7.43
Rps8 px_lad0_7 px_lad0_8 17.3
Rps9 px_lad0_8 px_lad0_9 5.94
Rps10 xs0p_x px_lad1_0 12.2
Rps11 px_lad1_0 px_lad1_1 17.6
Rps12 px_lad1_1 px_lad1_2 7.68
Rps13 px_lad1_2 px_lad1_3 2.25
Rps14 px_lad1_3 px_lad1_4 8.49
Rps15 px_lad1_4 px_lad1_5 16.3
Rps16 px_lad1_5 px_lad1_6 19.9
Rps17 px_lad1_6 px_lad1_7 11.5
Rps18 px_lad1_7 px_lad1_8 5.33
Rps19 px_lad1_8 px_lad1_9 9.72
Rps20 rstb_n px_lad2_0 13.5
Rps21 px_lad2_0 px_lad2_1 1.61
Rps22 px_lad2_1 px_lad2_2 2.24
Rps23 px_lad2_2 px_lad2_3 2.54
Rps24 px_lad2_3 px_lad2_4 9.82
Rps25 px_lad2_4 px_lad2_5 12.3
Rps26 px_lad2_5 px_lad2_6 13
Rps27 px_lad2_6 px_lad2_7 1.82
Rps28 px_lad2_7 px_lad2_8 19.6
Rps29 px_lad2_8 px_lad2_9 14.1
Rps30 rstb px_lad3_0 7.64
Rps31 px_lad3_0 px_lad3_1 16.5
Rps32 px_lad3_1 px_lad3_2 11
Rps33 px_lad3_2 px_lad3_3 6.41
Rps34 px_lad3_3 px_lad3_4 4.12
Rps35 px_lad3_4 px_lad3_5 2.69
Rps36 px_lad3_5 px_lad3_6 9.82
Rps37 px_lad3_6 px_lad3_7 3.5
Rps38 px_lad3_7 px_lad3_8 8.47
Rps39 px_lad3_8 px_lad3_9 11.4
Rps40 rstb px_lad4_0 8.17
Rps41 px_lad4_0 px_lad4_1 14.5
Rps42 px_lad4_1 px_lad4_2 2.47
Rps43 px_lad4_2 px_lad4_3 5.86
Rps44 px_lad4_3 px_lad4_4 1.7
Rps45 px_lad4_4 px_lad4_5 9.39
Rps46 px_lad4_5 px_lad4_6 10
Rps47 px_lad4_6 px_lad4_7 13.3
Rps48 px_lad4_7 px_lad4_8 15.8
Rps49 px_lad4_8 px_lad4_9 19.9
Rps50 lsb_p px_lad5_0 10.3
Rps51 px_lad5_0 px_lad5_1 9.23
Rps52 px_lad5_1 px_lad5_2 9.9
Rps53 px_lad5_2 px_lad5_3 10.2
Rps54 px_lad5_3 px_lad5_4 14.6
Rps55 px_lad5_4 px_lad5_5 15.9
Rps56 px_lad5_5 px_lad5_6 9.13
Rps57 px_lad5_6 px_lad5_7 12.6
Rps58 px_lad5_7 px_lad5_8 18.2
Rps59 px_lad5_8 px_lad5_9 17.7
Rps60 bp8 px_lad6_0 2.92
Rps61 px_lad6_0 px_lad6_1 12.6
Rps62 px_lad6_1 px_lad6_2 19
Rps63 px_lad6_2 px_lad6_3 4.53
Rps64 px_lad6_3 px_lad6_4 3.63
Rps65 px_lad6_4 px_lad6_5 8.46
Rps66 px_lad6_5 px_lad6_6 10.4
Rps67 px_lad6_6 px_lad6_7 2.44
Rps68 px_lad6_7 px_lad6_8 14.6
Rps69 px_lad6_8 px_lad6_9 12
Rps70 t1 px_lad7_0 13.8
Rps71 px_lad7_0 px_lad7_1 11.1
Rps72 px_lad7_1 px_lad7_2 15.1
Rps73 px_lad7_2 px_lad7_3 11.3
Rps74 px_lad7_3 px_lad7_4 7.34
Rps75 px_lad7_4 px_lad7_5 19
Rps76 px_lad7_5 px_lad7_6 15.9
Rps77 px_lad7_6 px_lad7_7 17.4
Rps78 px_lad7_7 px_lad7_8 12.3
Rps79 px_lad7_8 px_lad7_9 9.4
Rps80 cp6 px_lad8_0 16.7
Rps81 px_lad8_0 px_lad8_1 10.1
Rps82 px_lad8_1 px_lad8_2 6.05
Rps83 px_lad8_2 px_lad8_3 7.76
Rps84 px_lad8_3 px_lad8_4 10.6
Rps85 px_lad8_4 px_lad8_5 3.26
Rps86 px_lad8_5 px_lad8_6 5.37
Rps87 px_lad8_6 px_lad8_7 11.7
Rps88 px_lad8_7 px_lad8_8 12.7
Rps89 px_lad8_8 px_lad8_9 5.67
Rps90 bn3 px_lad9_0 16.4
Rps91 px_lad9_0 px_lad9_1 5.85
Rps92 px_lad9_1 px_lad9_2 3.48
Rps93 px_lad9_2 px_lad9_3 15.8
Rps94 px_lad9_3 px_lad9_4 8.01
Rps95 px_lad9_4 px_lad9_5 6.38
Rps96 px_lad9_5 px_lad9_6 2.76
Rps97 px_lad9_6 px_lad9_7 8.12
Rps98 px_lad9_7 px_lad9_8 16.2
Rps99 px_lad9_8 px_lad9_9 2
Rps100 xs0n_cbp px_lad10_0 3.47
Rps101 px_lad10_0 px_lad10_1 1.29
Rps102 px_lad10_1 px_lad10_2 19.8
Rps103 px_lad10_2 px_lad10_3 8.64
Rps104 px_lad10_3 px_lad10_4 3.81
Rps105 px_lad10_4 px_lad10_5 5.19
Rps106 px_lad10_5 px_lad10_6 11.7
Rps107 px_lad10_6 px_lad10_7 15.7
Rps108 px_lad10_7 px_lad10_8 7.17
Rps109 px_lad10_8 px_lad10_9 18.7
Rps110 xs0n_n10 px_lad11_0 6.32
Rps111 px_lad11_0 px_lad11_1 18.5
Rps112 px_lad11_1 px_lad11_2 9.63
Rps113 px_lad11_2 px_lad11_3 19.7
Rps114 px_lad11_3 px_lad11_4 10.9
Rps115 px_lad11_4 px_lad11_5 11.3
Rps116 px_lad11_5 px_lad11_6 11.6
Rps117 px_lad11_6 px_lad11_7 5.18
Rps118 px_lad11_7 px_lad11_8 11.9
Rps119 px_lad11_8 px_lad11_9 4.04
Rps120 xs0p_n10 px_lad12_0 5.66
Rps121 px_lad12_0 px_lad12_1 3.95
Rps122 px_lad12_1 px_lad12_2 9.72
Rps123 px_lad12_2 px_lad12_3 15.3
Rps124 px_lad12_3 px_lad12_4 19.1
Rps125 px_lad12_4 px_lad12_5 12.1
Rps126 px_lad12_5 px_lad12_6 4.66
Rps127 px_lad12_6 px_lad12_7 3.64
Rps128 px_lad12_7 px_lad12_8 8.91
Rps129 px_lad12_8 px_lad12_9 13.1
Rps130 clk px_lad13_0 17.4
Rps131 px_lad13_0 px_lad13_1 16.5
Rps132 px_lad13_1 px_lad13_2 3.22
Rps133 px_lad13_2 px_lad13_3 2.21
Rps134 px_lad13_3 px_lad13_4 15.5
Rps135 px_lad13_4 px_lad13_5 9.48
Rps136 px_lad13_5 px_lad13_6 13.7
Rps137 px_lad13_6 px_lad13_7 18.1
Rps138 px_lad13_7 px_lad13_8 13.7
Rps139 px_lad13_8 px_lad13_9 4.65
Rps140 xc4_outnb px_lad14_0 19.5
Rps141 px_lad14_0 px_lad14_1 11.5
Rps142 px_lad14_1 px_lad14_2 4.3
Rps143 px_lad14_2 px_lad14_3 13.8
Rps144 px_lad14_3 px_lad14_4 3.1
Rps145 px_lad14_4 px_lad14_5 19.2
Rps146 px_lad14_5 px_lad14_6 13
Rps147 px_lad14_6 px_lad14_7 7.93
Rps148 px_lad14_7 px_lad14_8 1.56
Rps149 px_lad14_8 px_lad14_9 8.32
Rps150 xs0n_cbn px_lad15_0 16.1
Rps151 px_lad15_0 px_lad15_1 13
Rps152 px_lad15_1 px_lad15_2 1.9
Rps153 px_lad15_2 px_lad15_3 12.3
Rps154 px_lad15_3 px_lad15_4 2.25
Rps155 px_lad15_4 px_lad15_5 3.87
Rps156 px_lad15_5 px_lad15_6 6.86
Rps157 px_lad15_6 px_lad15_7 7.38
Rps158 px_lad15_7 px_lad15_8 7.09
Rps159 px_lad15_8 px_lad15_9 16.5
Rps160 bp1 px_lad16_0 8.41
Rps161 px_lad16_0 px_lad16_1 13.5
Rps162 px_lad16_1 px_lad16_2 6.23
Rps163 px_lad16_2 px_lad16_3 17.6
Rps164 px_lad16_3 px_lad16_4 3.74
Rps165 px_lad16_4 px_lad16_5 7.29
Rps166 px_lad16_5 px_lad16_6 4.23
Rps167 px_lad16_6 px_lad16_7 15.9
Rps168 px_lad16_7 px_lad16_8 3.82
Rps169 px_lad16_8 px_lad16_9 17.5
Rps170 cp6 px_lad17_0 15.9
Rps171 px_lad17_0 px_lad17_1 5.26
Rps172 px_lad17_1 px_lad17_2 12.5
Rps173 px_lad17_2 px_lad17_3 9.95
Rps174 px_lad17_3 px_lad17_4 10.4
Rps175 px_lad17_4 px_lad17_5 12.5
Rps176 px_lad17_5 px_lad17_6 11.5
Rps177 px_lad17_6 px_lad17_7 6.98
Rps178 px_lad17_7 px_lad17_8 7.36
Rps179 px_lad17_8 px_lad17_9 12.4
Rps180 lsb_n px_lad18_0 6.25
Rps181 px_lad18_0 px_lad18_1 6.18
Rps182 px_lad18_1 px_lad18_2 15
Rps183 px_lad18_2 px_lad18_3 19.2
Rps184 px_lad18_3 px_lad18_4 4.8
Rps185 px_lad18_4 px_lad18_5 11.7
Rps186 px_lad18_5 px_lad18_6 7.13
Rps187 px_lad18_6 px_lad18_7 14.9
Rps188 px_lad18_7 px_lad18_8 4.74
Rps189 px_lad18_8 px_lad18_9 18.5
Rps190 xc5_lt px_lad19_0 17.8
Rps191 px_lad19_0 px_lad19_1 9.85
Rps192 px_lad19_1 px_lad19_2 8.96
Rps193 px_lad19_2 px_lad19_3 19.6
Rps194 px_lad19_3 px_lad19_4 18.1
Rps195 px_lad19_4 px_lad19_5 17.4
Rps196 px_lad19_5 px_lad19_6 9.7
Rps197 px_lad19_6 px_lad19_7 6.82
Rps198 px_lad19_7 px_lad19_8 11.9
Rps199 px_lad19_8 px_lad19_9 4.39
Rps200 bn7 px_lad20_0 6.87
Rps201 px_lad20_0 px_lad20_1 1.95
Rps202 px_lad20_1 px_lad20_2 4.05
Rps203 px_lad20_2 px_lad20_3 12.3
Rps204 px_lad20_3 px_lad20_4 12.3
Rps205 px_lad20_4 px_lad20_5 4.74
Rps206 px_lad20_5 px_lad20_6 14
Rps207 px_lad20_6 px_lad20_7 16.7
Rps208 px_lad20_7 px_lad20_8 6.53
Rps209 px_lad20_8 px_lad20_9 5.8
Rps210 xs0n_cbn px_lad21_0 2.96
Rps211 px_lad21_0 px_lad21_1 13.6
Rps212 px_lad21_1 px_lad21_2 12.5
Rps213 px_lad21_2 px_lad21_3 3.85
Rps214 px_lad21_3 px_lad21_4 13.8
Rps215 px_lad21_4 px_lad21_5 17.1
Rps216 px_lad21_5 px_lad21_6 18.7
Rps217 px_lad21_6 px_lad21_7 18.2
Rps218 px_lad21_7 px_lad21_8 20
Rps219 px_lad21_8 px_lad21_9 2.14
Rps220 cn3 px_lad22_0 8.94
Rps221 px_lad22_0 px_lad22_1 2.3
Rps222 px_lad22_1 px_lad22_2 5.73
Rps223 px_lad22_2 px_lad22_3 7.01
Rps224 px_lad22_3 px_lad22_4 12.5
Rps225 px_lad22_4 px_lad22_5 14.6
Rps226 px_lad22_5 px_lad22_6 18
Rps227 px_lad22_6 px_lad22_7 10.8
Rps228 px_lad22_7 px_lad22_8 5.46
Rps229 px_lad22_8 px_lad22_9 9.8
Rps230 lsb_n px_lad23_0 5.69
Rps231 px_lad23_0 px_lad23_1 11.3
Rps232 px_lad23_1 px_lad23_2 6.86
Rps233 px_lad23_2 px_lad23_3 4.11
Rps234 px_lad23_3 px_lad23_4 10.2
Rps235 px_lad23_4 px_lad23_5 10
Rps236 px_lad23_5 px_lad23_6 16.6
Rps237 px_lad23_6 px_lad23_7 12.1
Rps238 px_lad23_7 px_lad23_8 3.1
Rps239 px_lad23_8 px_lad23_9 10.7
Rps240 t0b px_lad24_0 15.5
Rps241 px_lad24_0 px_lad24_1 11.9
Rps242 px_lad24_1 px_lad24_2 13.2
Rps243 px_lad24_2 px_lad24_3 10.1
Rps244 px_lad24_3 px_lad24_4 15.5
Rps245 px_lad24_4 px_lad24_5 17.9
Rps246 px_lad24_5 px_lad24_6 19.8
Rps247 px_lad24_6 px_lad24_7 7.38
Rps248 px_lad24_7 px_lad24_8 12.6
Rps249 px_lad24_8 px_lad24_9 7.71
Rps250 cp12 px_lad25_0 10.6
Rps251 px_lad25_0 px_lad25_1 16.1
Rps252 px_lad25_1 px_lad25_2 19.7
Rps253 px_lad25_2 px_lad25_3 17.7
Rps254 px_lad25_3 px_lad25_4 10.7
Rps255 px_lad25_4 px_lad25_5 14.7
Rps256 px_lad25_5 px_lad25_6 4.52
Rps257 px_lad25_6 px_lad25_7 15.8
Rps258 px_lad25_7 px_lad25_8 11.1
Rps259 px_lad25_8 px_lad25_9 19.9
Rps260 xc4_xs1_tail0 px_lad26_0 11.4
Rps261 px_lad26_0 px_lad26_1 4.37
Rps262 px_lad26_1 px_lad26_2 18.6
Rps263 px_lad26_2 px_lad26_3 17.1
Rps264 px_lad26_3 px_lad26_4 11.5
Rps265 px_lad26_4 px_lad26_5 17.6
Rps266 px_lad26_5 px_lad26_6 11.9
Rps267 px_lad26_6 px_lad26_7 11.2
Rps268 px_lad26_7 px_lad26_8 16
Rps269 px_lad26_8 px_lad26_9 11.2
Rps270 xc5_xs1_tail px_lad27_0 16.4
Rps271 px_lad27_0 px_lad27_1 12.1
Rps272 px_lad27_1 px_lad27_2 1.85
Rps273 px_lad27_2 px_lad27_3 5.92
Rps274 px_lad27_3 px_lad27_4 13.9
Rps275 px_lad27_4 px_lad27_5 15.5
Rps276 px_lad27_5 px_lad27_6 1.25
Rps277 px_lad27_6 px_lad27_7 11.7
Rps278 px_lad27_7 px_lad27_8 8.39
Rps279 px_lad27_8 px_lad27_9 2.21
Rps280 t0 px_lad28_0 7.27
Rps281 px_lad28_0 px_lad28_1 17.7
Rps282 px_lad28_1 px_lad28_2 5.68
Rps283 px_lad28_2 px_lad28_3 6.85
Rps284 px_lad28_3 px_lad28_4 16.6
Rps285 px_lad28_4 px_lad28_5 17.4
Rps286 px_lad28_5 px_lad28_6 1.17
Rps287 px_lad28_6 px_lad28_7 16.3
Rps288 px_lad28_7 px_lad28_8 5.31
Rps289 px_lad28_8 px_lad28_9 17.5
Rps290 xc4_xs1_tail0 px_lad29_0 18.5
Rps291 px_lad29_0 px_lad29_1 13
Rps292 px_lad29_1 px_lad29_2 12.6
Rps293 px_lad29_2 px_lad29_3 1.39
Rps294 px_lad29_3 px_lad29_4 17.2
Rps295 px_lad29_4 px_lad29_5 8.72
Rps296 px_lad29_5 px_lad29_6 19.9
Rps297 px_lad29_6 px_lad29_7 16.1
Rps298 px_lad29_7 px_lad29_8 18.7
Rps299 px_lad29_8 px_lad29_9 4.08
Rps300 bp12 px_lad30_0 17.1
Rps301 px_lad30_0 px_lad30_1 10.2
Rps302 px_lad30_1 px_lad30_2 3.34
Rps303 px_lad30_2 px_lad30_3 12.1
Rps304 px_lad30_3 px_lad30_4 13.2
Rps305 px_lad30_4 px_lad30_5 6.65
Rps306 px_lad30_5 px_lad30_6 3.26
Rps307 px_lad30_6 px_lad30_7 18.8
Rps308 px_lad30_7 px_lad30_8 13
Rps309 px_lad30_8 px_lad30_9 8.94
Rps310 in1p px_lad31_0 9.06
Rps311 px_lad31_0 px_lad31_1 19.7
Rps312 px_lad31_1 px_lad31_2 9.72
Rps313 px_lad31_2 px_lad31_3 14
Rps314 px_lad31_3 px_lad31_4 17.6
Rps315 px_lad31_4 px_lad31_5 12.1
Rps316 px_lad31_5 px_lad31_6 11
Rps317 px_lad31_6 px_lad31_7 7.37
Rps318 px_lad31_7 px_lad31_8 15.9
Rps319 px_lad31_8 px_lad31_9 8.6
Rps320 xc5_lt px_lad32_0 9.72
Rps321 px_lad32_0 px_lad32_1 6.37
Rps322 px_lad32_1 px_lad32_2 2.09
Rps323 px_lad32_2 px_lad32_3 11.2
Rps324 px_lad32_3 px_lad32_4 10.2
Rps325 px_lad32_4 px_lad32_5 7.17
Rps326 px_lad32_5 px_lad32_6 6.13
Rps327 px_lad32_6 px_lad32_7 16.1
Rps328 px_lad32_7 px_lad32_8 19.4
Rps329 px_lad32_8 px_lad32_9 17.3
Rps330 xs1p_g px_lad33_0 2.31
Rps331 px_lad33_0 px_lad33_1 11.3
Rps332 px_lad33_1 px_lad33_2 19.9
Rps333 px_lad33_2 px_lad33_3 2.68
Rps334 px_lad33_3 px_lad33_4 11.2
Rps335 px_lad33_4 px_lad33_5 11
Rps336 px_lad33_5 px_lad33_6 2.58
Rps337 px_lad33_6 px_lad33_7 1.6
Rps338 px_lad33_7 px_lad33_8 5.74
Rps339 px_lad33_8 px_lad33_9 6.25
Rps340 xs0p_n10 px_lad34_0 16
Rps341 px_lad34_0 px_lad34_1 2.84
Rps342 px_lad34_1 px_lad34_2 10.4
Rps343 px_lad34_2 px_lad34_3 13.7
Rps344 px_lad34_3 px_lad34_4 4.09
Rps345 px_lad34_4 px_lad34_5 5.12
Rps346 px_lad34_5 px_lad34_6 15.2
Rps347 px_lad34_6 px_lad34_7 5.41
Rps348 px_lad34_7 px_lad34_8 1.28
Rps349 px_lad34_8 px_lad34_9 4.27
Rps350 cn12 px_lad35_0 14.3
Rps351 px_lad35_0 px_lad35_1 6.27
Rps352 px_lad35_1 px_lad35_2 16.2
Rps353 px_lad35_2 px_lad35_3 5.72
Rps354 px_lad35_3 px_lad35_4 2.77
Rps355 px_lad35_4 px_lad35_5 15.9
Rps356 px_lad35_5 px_lad35_6 4.23
Rps357 px_lad35_6 px_lad35_7 5
Rps358 px_lad35_7 px_lad35_8 16.3
Rps359 px_lad35_8 px_lad35_9 14
Rps360 cn6 px_lad36_0 8.59
Rps361 px_lad36_0 px_lad36_1 6.52
Rps362 px_lad36_1 px_lad36_2 6.41
Rps363 px_lad36_2 px_lad36_3 15.1
Rps364 px_lad36_3 px_lad36_4 1.63
Rps365 px_lad36_4 px_lad36_5 13
Rps366 px_lad36_5 px_lad36_6 9.49
Rps367 px_lad36_6 px_lad36_7 10.9
Rps368 px_lad36_7 px_lad36_8 1.45
Rps369 px_lad36_8 px_lad36_9 13.3
Rps370 cp12 px_lad37_0 8.58
Rps371 px_lad37_0 px_lad37_1 17.4
Rps372 px_lad37_1 px_lad37_2 17.5
Rps373 px_lad37_2 px_lad37_3 19.9
Rps374 px_lad37_3 px_lad37_4 19.3
Rps375 px_lad37_4 px_lad37_5 13.7
Rps376 px_lad37_5 px_lad37_6 14.5
Rps377 px_lad37_6 px_lad37_7 7.96
Rps378 px_lad37_7 px_lad37_8 9.31
Rps379 px_lad37_8 px_lad37_9 2.22
Rps380 xs1p_g px_lad38_0 15.2
Rps381 px_lad38_0 px_lad38_1 19.8
Rps382 px_lad38_1 px_lad38_2 1.54
Rps383 px_lad38_2 px_lad38_3 15.8
Rps384 px_lad38_3 px_lad38_4 4.77
Rps385 px_lad38_4 px_lad38_5 19.9
Rps386 px_lad38_5 px_lad38_6 4.2
Rps387 px_lad38_6 px_lad38_7 6.46
Rps388 px_lad38_7 px_lad38_8 7.27
Rps389 px_lad38_8 px_lad38_9 4.56
Rps390 cp11 px_lad39_0 1.88
Rps391 px_lad39_0 px_lad39_1 13
Rps392 px_lad39_1 px_lad39_2 14.3
Rps393 px_lad39_2 px_lad39_3 8.76
Rps394 px_lad39_3 px_lad39_4 1.29
Rps395 px_lad39_4 px_lad39_5 15.5
Rps396 px_lad39_5 px_lad39_6 5.82
Rps397 px_lad39_6 px_lad39_7 3.72
Rps398 px_lad39_7 px_lad39_8 6.05
Rps399 px_lad39_8 px_lad39_9 15.7
Rps400 bn11 px_lad40_0 19.5
Rps401 px_lad40_0 px_lad40_1 16.3
Rps402 px_lad40_1 px_lad40_2 2.16
Rps403 px_lad40_2 px_lad40_3 14.6
Rps404 px_lad40_3 px_lad40_4 10.4
Rps405 px_lad40_4 px_lad40_5 9.08
Rps406 px_lad40_5 px_lad40_6 19.4
Rps407 px_lad40_6 px_lad40_7 18.7
Rps408 px_lad40_7 px_lad40_8 3.76
Rps409 px_lad40_8 px_lad40_9 8.08
Rps410 bp7 px_lad41_0 16.3
Rps411 px_lad41_0 px_lad41_1 19.9
Rps412 px_lad41_1 px_lad41_2 13.4
Rps413 px_lad41_2 px_lad41_3 16.6
Rps414 px_lad41_3 px_lad41_4 11.3
Rps415 px_lad41_4 px_lad41_5 1.02
Rps416 px_lad41_5 px_lad41_6 2.35
Rps417 px_lad41_6 px_lad41_7 3.28
Rps418 px_lad41_7 px_lad41_8 18.5
Rps419 px_lad41_8 px_lad41_9 1.27
Rps420 xc4_xs1_tail0 px_lad42_0 7.74
Rps421 px_lad42_0 px_lad42_1 9.98
Rps422 px_lad42_1 px_lad42_2 2.98
Rps423 px_lad42_2 px_lad42_3 4.71
Rps424 px_lad42_3 px_lad42_4 13.1
Rps425 px_lad42_4 px_lad42_5 4.03
Rps426 px_lad42_5 px_lad42_6 18.3
Rps427 px_lad42_6 px_lad42_7 7.62
Rps428 px_lad42_7 px_lad42_8 19.3
Rps429 px_lad42_8 px_lad42_9 3.76
Rps430 xc5_xs1_tail px_lad43_0 12.2
Rps431 px_lad43_0 px_lad43_1 13.7
Rps432 px_lad43_1 px_lad43_2 7
Rps433 px_lad43_2 px_lad43_3 1.67
Rps434 px_lad43_3 px_lad43_4 14.7
Rps435 px_lad43_4 px_lad43_5 2.36
Rps436 px_lad43_5 px_lad43_6 13.7
Rps437 px_lad43_6 px_lad43_7 19.1
Rps438 px_lad43_7 px_lad43_8 8.89
Rps439 px_lad43_8 px_lad43_9 19.3
Rps440 trk0 px_lad44_0 6.35
Rps441 px_lad44_0 px_lad44_1 8.58
Rps442 px_lad44_1 px_lad44_2 9.89
Rps443 px_lad44_2 px_lad44_3 12.7
Rps444 px_lad44_3 px_lad44_4 12.4
Rps445 px_lad44_4 px_lad44_5 3.39
Rps446 px_lad44_5 px_lad44_6 11
Rps447 px_lad44_6 px_lad44_7 19.8
Rps448 px_lad44_7 px_lad44_8 4.36
Rps449 px_lad44_8 px_lad44_9 11.1
Rps450 bn1 px_lad45_0 1.43
Rps451 px_lad45_0 px_lad45_1 19.1
Rps452 px_lad45_1 px_lad45_2 9.9
Rps453 px_lad45_2 px_lad45_3 5.75
Rps454 px_lad45_3 px_lad45_4 11.7
Rps455 px_lad45_4 px_lad45_5 8.15
Rps456 px_lad45_5 px_lad45_6 15.6
Rps457 px_lad45_6 px_lad45_7 7.33
Rps458 px_lad45_7 px_lad45_8 16.3
Rps459 px_lad45_8 px_lad45_9 4.9
Rps460 t0b px_lad46_0 10.7
Rps461 px_lad46_0 px_lad46_1 20
Rps462 px_lad46_1 px_lad46_2 16.7
Rps463 px_lad46_2 px_lad46_3 13.4
Rps464 px_lad46_3 px_lad46_4 19.7
Rps465 px_lad46_4 px_lad46_5 1.85
Rps466 px_lad46_5 px_lad46_6 8.62
Rps467 px_lad46_6 px_lad46_7 5.65
Rps468 px_lad46_7 px_lad46_8 11.7
Rps469 px_lad46_8 px_lad46_9 10.3
Rps470 cn11 px_lad47_0 3.02
Rps471 px_lad47_0 px_lad47_1 15.6
Rps472 px_lad47_1 px_lad47_2 16
Rps473 px_lad47_2 px_lad47_3 19.1
Rps474 px_lad47_3 px_lad47_4 16.4
Rps475 px_lad47_4 px_lad47_5 8.51
Rps476 px_lad47_5 px_lad47_6 9.44
Rps477 px_lad47_6 px_lad47_7 18.3
Rps478 px_lad47_7 px_lad47_8 12.2
Rps479 px_lad47_8 px_lad47_9 11.8
Rps480 bn10 px_lad48_0 14.6
Rps481 px_lad48_0 px_lad48_1 7.43
Rps482 px_lad48_1 px_lad48_2 9.24
Rps483 px_lad48_2 px_lad48_3 3.22
Rps484 px_lad48_3 px_lad48_4 11.5
Rps485 px_lad48_4 px_lad48_5 10.6
Rps486 px_lad48_5 px_lad48_6 12.1
Rps487 px_lad48_6 px_lad48_7 18
Rps488 px_lad48_7 px_lad48_8 15.3
Rps489 px_lad48_8 px_lad48_9 5.82
Rps490 bp1 px_lad49_0 1.34
Rps491 px_lad49_0 px_lad49_1 4.04
Rps492 px_lad49_1 px_lad49_2 19.7
Rps493 px_lad49_2 px_lad49_3 10.2
Rps494 px_lad49_3 px_lad49_4 6.22
Rps495 px_lad49_4 px_lad49_5 19
Rps496 px_lad49_5 px_lad49_6 6.08
Rps497 px_lad49_6 px_lad49_7 15.2
Rps498 px_lad49_7 px_lad49_8 15.6
Rps499 px_lad49_8 px_lad49_9 7.13
Rps500 xs0n_cbp px_lad50_0 8.76
Rps501 px_lad50_0 px_lad50_1 19.8
Rps502 px_lad50_1 px_lad50_2 4.09
Rps503 px_lad50_2 px_lad50_3 15.3
Rps504 px_lad50_3 px_lad50_4 1.2
Rps505 px_lad50_4 px_lad50_5 18.6
Rps506 px_lad50_5 px_lad50_6 1.43
Rps507 px_lad50_6 px_lad50_7 11.9
Rps508 px_lad50_7 px_lad50_8 1.53
Rps509 px_lad50_8 px_lad50_9 14.5
Rps510 cn7 px_lad51_0 2.53
Rps511 px_lad51_0 px_lad51_1 12.5
Rps512 px_lad51_1 px_lad51_2 6.41
Rps513 px_lad51_2 px_lad51_3 11.8
Rps514 px_lad51_3 px_lad51_4 19.9
Rps515 px_lad51_4 px_lad51_5 14.8
Rps516 px_lad51_5 px_lad51_6 17.3
Rps517 px_lad51_6 px_lad51_7 10.8
Rps518 px_lad51_7 px_lad51_8 5.84
Rps519 px_lad51_8 px_lad51_9 13.2
Rps520 trk0 px_lad52_0 8.72
Rps521 px_lad52_0 px_lad52_1 6.8
Rps522 px_lad52_1 px_lad52_2 18.2
Rps523 px_lad52_2 px_lad52_3 6.8
Rps524 px_lad52_3 px_lad52_4 14.8
Rps525 px_lad52_4 px_lad52_5 12.9
Rps526 px_lad52_5 px_lad52_6 10.9
Rps527 px_lad52_6 px_lad52_7 10.5
Rps528 px_lad52_7 px_lad52_8 18.1
Rps529 px_lad52_8 px_lad52_9 6.39
Rps530 bp0 px_lad53_0 1.84
Rps531 px_lad53_0 px_lad53_1 8
Rps532 px_lad53_1 px_lad53_2 3.28
Rps533 px_lad53_2 px_lad53_3 1.93
Rps534 px_lad53_3 px_lad53_4 17.8
Rps535 px_lad53_4 px_lad53_5 12.4
Rps536 px_lad53_5 px_lad53_6 9.96
Rps537 px_lad53_6 px_lad53_7 8.46
Rps538 px_lad53_7 px_lad53_8 7.16
Rps539 px_lad53_8 px_lad53_9 8.61
Rps540 nr px_lad54_0 1.45
Rps541 px_lad54_0 px_lad54_1 15.5
Rps542 px_lad54_1 px_lad54_2 17.8
Rps543 px_lad54_2 px_lad54_3 3.39
Rps544 px_lad54_3 px_lad54_4 6.8
Rps545 px_lad54_4 px_lad54_5 11.6
Rps546 px_lad54_5 px_lad54_6 2.6
Rps547 px_lad54_6 px_lad54_7 9.55
Rps548 px_lad54_7 px_lad54_8 7.15
Rps549 px_lad54_8 px_lad54_9 1.35
Rps550 bn11 px_lad55_0 6.45
Rps551 px_lad55_0 px_lad55_1 5.52
Rps552 px_lad55_1 px_lad55_2 13.9
Rps553 px_lad55_2 px_lad55_3 16.3
Rps554 px_lad55_3 px_lad55_4 2.66
Rps555 px_lad55_4 px_lad55_5 6.6
Rps556 px_lad55_5 px_lad55_6 12.5
Rps557 px_lad55_6 px_lad55_7 7.26
Rps558 px_lad55_7 px_lad55_8 2.31
Rps559 px_lad55_8 px_lad55_9 17.5
Rps560 onn px_lad56_0 3.16
Rps561 px_lad56_0 px_lad56_1 16.2
Rps562 px_lad56_1 px_lad56_2 7.88
Rps563 px_lad56_2 px_lad56_3 1.69
Rps564 px_lad56_3 px_lad56_4 3.03
Rps565 px_lad56_4 px_lad56_5 9.47
Rps566 px_lad56_5 px_lad56_6 19.2
Rps567 px_lad56_6 px_lad56_7 6.18
Rps568 px_lad56_7 px_lad56_8 11.3
Rps569 px_lad56_8 px_lad56_9 4.64
Rps570 xs1n_cbp px_lad57_0 8.46
Rps571 px_lad57_0 px_lad57_1 2.98
Rps572 px_lad57_1 px_lad57_2 1.79
Rps573 px_lad57_2 px_lad57_3 15.3
Rps574 px_lad57_3 px_lad57_4 18.9
Rps575 px_lad57_4 px_lad57_5 11.7
Rps576 px_lad57_5 px_lad57_6 9.18
Rps577 px_lad57_6 px_lad57_7 8
Rps578 px_lad57_7 px_lad57_8 5.07
Rps579 px_lad57_8 px_lad57_9 3
Rps580 cn9 px_lad58_0 7.64
Rps581 px_lad58_0 px_lad58_1 6.33
Rps582 px_lad58_1 px_lad58_2 16.8
Rps583 px_lad58_2 px_lad58_3 19.4
Rps584 px_lad58_3 px_lad58_4 15.6
Rps585 px_lad58_4 px_lad58_5 13.2
Rps586 px_lad58_5 px_lad58_6 8.14
Rps587 px_lad58_6 px_lad58_7 19.7
Rps588 px_lad58_7 px_lad58_8 17.9
Rps589 px_lad58_8 px_lad58_9 6.31
Rps590 cp4 px_lad59_0 9.42
Rps591 px_lad59_0 px_lad59_1 2.6
Rps592 px_lad59_1 px_lad59_2 15.1
Rps593 px_lad59_2 px_lad59_3 17
Rps594 px_lad59_3 px_lad59_4 4.57
Rps595 px_lad59_4 px_lad59_5 4.73
Rps596 px_lad59_5 px_lad59_6 19.7
Rps597 px_lad59_6 px_lad59_7 17.4
Rps598 px_lad59_7 px_lad59_8 2.26
Rps599 px_lad59_8 px_lad59_9 16.9
Rps600 cn7 px_lad60_0 13.4
Rps601 px_lad60_0 px_lad60_1 9.65
Rps602 px_lad60_1 px_lad60_2 15.2
Rps603 px_lad60_2 px_lad60_3 2.46
Rps604 px_lad60_3 px_lad60_4 1.36
Rps605 px_lad60_4 px_lad60_5 19
Rps606 px_lad60_5 px_lad60_6 2.15
Rps607 px_lad60_6 px_lad60_7 13
Rps608 px_lad60_7 px_lad60_8 13.6
Rps609 px_lad60_8 px_lad60_9 6.61
Rps610 t0 px_lad61_0 3.83
Rps611 px_lad61_0 px_lad61_1 13.8
Rps612 px_lad61_1 px_lad61_2 15.9
Rps613 px_lad61_2 px_lad61_3 13.5
Rps614 px_lad61_3 px_lad61_4 5.21
Rps615 px_lad61_4 px_lad61_5 3.14
Rps616 px_lad61_5 px_lad61_6 3.58
Rps617 px_lad61_6 px_lad61_7 1.38
Rps618 px_lad61_7 px_lad61_8 3.42
Rps619 px_lad61_8 px_lad61_9 18.7
Rps620 bn0 px_lad62_0 4.61
Rps621 px_lad62_0 px_lad62_1 15
Rps622 px_lad62_1 px_lad62_2 8.6
Rps623 px_lad62_2 px_lad62_3 7.99
Rps624 px_lad62_3 px_lad62_4 1.44
Rps625 px_lad62_4 px_lad62_5 1.61
Rps626 px_lad62_5 px_lad62_6 9.76
Rps627 px_lad62_6 px_lad62_7 9.78
Rps628 px_lad62_7 px_lad62_8 14
Rps629 px_lad62_8 px_lad62_9 3.55
Rps630 cn12 px_lad63_0 12.6
Rps631 px_lad63_0 px_lad63_1 14.5
Rps632 px_lad63_1 px_lad63_2 16
Rps633 px_lad63_2 px_lad63_3 16.5
Rps634 px_lad63_3 px_lad63_4 1.96
Rps635 px_lad63_4 px_lad63_5 16.4
Rps636 px_lad63_5 px_lad63_6 13.4
Rps637 px_lad63_6 px_lad63_7 4.51
Rps638 px_lad63_7 px_lad63_8 7.71
Rps639 px_lad63_8 px_lad63_9 15.1
Rps640 xs1n_g px_lad64_0 10.6
Rps641 px_lad64_0 px_lad64_1 8.56
Rps642 px_lad64_1 px_lad64_2 13.1
Rps643 px_lad64_2 px_lad64_3 3.98
Rps644 px_lad64_3 px_lad64_4 10.8
Rps645 px_lad64_4 px_lad64_5 17.7
Rps646 px_lad64_5 px_lad64_6 17.4
Rps647 px_lad64_6 px_lad64_7 10.3
Rps648 px_lad64_7 px_lad64_8 11.3
Rps649 px_lad64_8 px_lad64_9 10.3
Rps650 bn12 px_lad65_0 1.87
Rps651 px_lad65_0 px_lad65_1 8.6
Rps652 px_lad65_1 px_lad65_2 12.9
Rps653 px_lad65_2 px_lad65_3 7.61
Rps654 px_lad65_3 px_lad65_4 15.1
Rps655 px_lad65_4 px_lad65_5 9.38
Rps656 px_lad65_5 px_lad65_6 6.23
Rps657 px_lad65_6 px_lad65_7 9.54
Rps658 px_lad65_7 px_lad65_8 6.07
Rps659 px_lad65_8 px_lad65_9 6.24
Rps660 cn12 px_lad66_0 13.7
Rps661 px_lad66_0 px_lad66_1 9.86
Rps662 px_lad66_1 px_lad66_2 7.62
Rps663 px_lad66_2 px_lad66_3 17
Rps664 px_lad66_3 px_lad66_4 16.5
Rps665 px_lad66_4 px_lad66_5 3.33
Rps666 px_lad66_5 px_lad66_6 18.1
Rps667 px_lad66_6 px_lad66_7 11.4
Rps668 px_lad66_7 px_lad66_8 12
Rps669 px_lad66_8 px_lad66_9 16.1
Rps670 cn3 px_lad67_0 11.7
Rps671 px_lad67_0 px_lad67_1 7.81
Rps672 px_lad67_1 px_lad67_2 19.6
Rps673 px_lad67_2 px_lad67_3 7.56
Rps674 px_lad67_3 px_lad67_4 18.8
Rps675 px_lad67_4 px_lad67_5 17.6
Rps676 px_lad67_5 px_lad67_6 4.97
Rps677 px_lad67_6 px_lad67_7 10.5
Rps678 px_lad67_7 px_lad67_8 4.87
Rps679 px_lad67_8 px_lad67_9 12.9
Rps680 clkn px_lad68_0 3.39
Rps681 px_lad68_0 px_lad68_1 15
Rps682 px_lad68_1 px_lad68_2 9.47
Rps683 px_lad68_2 px_lad68_3 16.7
Rps684 px_lad68_3 px_lad68_4 2.72
Rps685 px_lad68_4 px_lad68_5 12.9
Rps686 px_lad68_5 px_lad68_6 1.86
Rps687 px_lad68_6 px_lad68_7 1.32
Rps688 px_lad68_7 px_lad68_8 13.7
Rps689 px_lad68_8 px_lad68_9 12.1
Rps690 t1b px_lad69_0 14.8
Rps691 px_lad69_0 px_lad69_1 4.28
Rps692 px_lad69_1 px_lad69_2 11.4
Rps693 px_lad69_2 px_lad69_3 8.18
Rps694 px_lad69_3 px_lad69_4 12.2
Rps695 px_lad69_4 px_lad69_5 18.2
Rps696 px_lad69_5 px_lad69_6 5.77
Rps697 px_lad69_6 px_lad69_7 12.7
Rps698 px_lad69_7 px_lad69_8 1.06
Rps699 px_lad69_8 px_lad69_9 14.9
Rps700 xs1n_cbp px_lad70_0 2.91
Rps701 px_lad70_0 px_lad70_1 9.11
Rps702 px_lad70_1 px_lad70_2 1.5
Rps703 px_lad70_2 px_lad70_3 10.6
Rps704 px_lad70_3 px_lad70_4 19
Rps705 px_lad70_4 px_lad70_5 1.51
Rps706 px_lad70_5 px_lad70_6 13.5
Rps707 px_lad70_6 px_lad70_7 8.42
Rps708 px_lad70_7 px_lad70_8 17.3
Rps709 px_lad70_8 px_lad70_9 6.36
Rps710 xc4_outpb px_lad71_0 19.2
Rps711 px_lad71_0 px_lad71_1 16.3
Rps712 px_lad71_1 px_lad71_2 7.45
Rps713 px_lad71_2 px_lad71_3 4.71
Rps714 px_lad71_3 px_lad71_4 10
Rps715 px_lad71_4 px_lad71_5 10.1
Rps716 px_lad71_5 px_lad71_6 1.12
Rps717 px_lad71_6 px_lad71_7 15.9
Rps718 px_lad71_7 px_lad71_8 6.81
Rps719 px_lad71_8 px_lad71_9 18.2
Rps720 bp10 px_lad72_0 6.37
Rps721 px_lad72_0 px_lad72_1 19.6
Rps722 px_lad72_1 px_lad72_2 11.4
Rps723 px_lad72_2 px_lad72_3 17.7
Rps724 px_lad72_3 px_lad72_4 14.7
Rps725 px_lad72_4 px_lad72_5 1.42
Rps726 px_lad72_5 px_lad72_6 11.8
Rps727 px_lad72_6 px_lad72_7 2.03
Rps728 px_lad72_7 px_lad72_8 19.9
Rps729 px_lad72_8 px_lad72_9 2.42
Rps730 xc5_outpb px_lad73_0 19.7
Rps731 px_lad73_0 px_lad73_1 2.92
Rps732 px_lad73_1 px_lad73_2 8.33
Rps733 px_lad73_2 px_lad73_3 18.9
Rps734 px_lad73_3 px_lad73_4 4.9
Rps735 px_lad73_4 px_lad73_5 18.9
Rps736 px_lad73_5 px_lad73_6 15.2
Rps737 px_lad73_6 px_lad73_7 1.58
Rps738 px_lad73_7 px_lad73_8 13
Rps739 px_lad73_8 px_lad73_9 5.96
Rps740 bp2 px_lad74_0 12.8
Rps741 px_lad74_0 px_lad74_1 2.21
Rps742 px_lad74_1 px_lad74_2 2.71
Rps743 px_lad74_2 px_lad74_3 6.83
Rps744 px_lad74_3 px_lad74_4 12.4
Rps745 px_lad74_4 px_lad74_5 12.3
Rps746 px_lad74_5 px_lad74_6 4.8
Rps747 px_lad74_6 px_lad74_7 11.2
Rps748 px_lad74_7 px_lad74_8 14.6
Rps749 px_lad74_8 px_lad74_9 16.4
Rps750 bp8 px_lad75_0 13.5
Rps751 px_lad75_0 px_lad75_1 1.14
Rps752 px_lad75_1 px_lad75_2 4.24
Rps753 px_lad75_2 px_lad75_3 12.1
Rps754 px_lad75_3 px_lad75_4 19.1
Rps755 px_lad75_4 px_lad75_5 16.8
Rps756 px_lad75_5 px_lad75_6 13.2
Rps757 px_lad75_6 px_lad75_7 17.4
Rps758 px_lad75_7 px_lad75_8 14.2
Rps759 px_lad75_8 px_lad75_9 11
Rps760 cp11 px_lad76_0 7.33
Rps761 px_lad76_0 px_lad76_1 1.18
Rps762 px_lad76_1 px_lad76_2 8.32
Rps763 px_lad76_2 px_lad76_3 2.92
Rps764 px_lad76_3 px_lad76_4 9.12
Rps765 px_lad76_4 px_lad76_5 4.03
Rps766 px_lad76_5 px_lad76_6 4.45
Rps767 px_lad76_6 px_lad76_7 3.11
Rps768 px_lad76_7 px_lad76_8 10.5
Rps769 px_lad76_8 px_lad76_9 11.4
Rps770 xc4_outnb px_lad77_0 16.6
Rps771 px_lad77_0 px_lad77_1 3.94
Rps772 px_lad77_1 px_lad77_2 16.2
Rps773 px_lad77_2 px_lad77_3 1.41
Rps774 px_lad77_3 px_lad77_4 17.9
Rps775 px_lad77_4 px_lad77_5 7.11
Rps776 px_lad77_5 px_lad77_6 12.1
Rps777 px_lad77_6 px_lad77_7 8.48
Rps778 px_lad77_7 px_lad77_8 13.6
Rps779 px_lad77_8 px_lad77_9 1.54
Rps780 cp6 px_lad78_0 12.4
Rps781 px_lad78_0 px_lad78_1 10.8
Rps782 px_lad78_1 px_lad78_2 1.68
Rps783 px_lad78_2 px_lad78_3 7.8
Rps784 px_lad78_3 px_lad78_4 6.46
Rps785 px_lad78_4 px_lad78_5 17.1
Rps786 px_lad78_5 px_lad78_6 6.5
Rps787 px_lad78_6 px_lad78_7 14.5
Rps788 px_lad78_7 px_lad78_8 16.7
Rps789 px_lad78_8 px_lad78_9 7.27
Rps790 cp2 px_lad79_0 3.56
Rps791 px_lad79_0 px_lad79_1 6.78
Rps792 px_lad79_1 px_lad79_2 3.68
Rps793 px_lad79_2 px_lad79_3 18.4
Rps794 px_lad79_3 px_lad79_4 5.77
Rps795 px_lad79_4 px_lad79_5 7.16
Rps796 px_lad79_5 px_lad79_6 12.7
Rps797 px_lad79_6 px_lad79_7 5.63
Rps798 px_lad79_7 px_lad79_8 5.29
Rps799 px_lad79_8 px_lad79_9 2.27
Rps800 bn0 px_lad80_0 16
Rps801 px_lad80_0 px_lad80_1 8.93
Rps802 px_lad80_1 px_lad80_2 2.52
Rps803 px_lad80_2 px_lad80_3 7.33
Rps804 px_lad80_3 px_lad80_4 1.57
Rps805 px_lad80_4 px_lad80_5 14.9
Rps806 px_lad80_5 px_lad80_6 7.67
Rps807 px_lad80_6 px_lad80_7 11.4
Rps808 px_lad80_7 px_lad80_8 8.69
Rps809 px_lad80_8 px_lad80_9 3.9
Rps810 cn3 px_lad81_0 8.57
Rps811 px_lad81_0 px_lad81_1 2.2
Rps812 px_lad81_1 px_lad81_2 13.8
Rps813 px_lad81_2 px_lad81_3 19.5
Rps814 px_lad81_3 px_lad81_4 12.6
Rps815 px_lad81_4 px_lad81_5 16.3
Rps816 px_lad81_5 px_lad81_6 18.7
Rps817 px_lad81_6 px_lad81_7 3.92
Rps818 px_lad81_7 px_lad81_8 19.9
Rps819 px_lad81_8 px_lad81_9 15.7
Rps820 cp6 px_lad82_0 7.36
Rps821 px_lad82_0 px_lad82_1 18.8
Rps822 px_lad82_1 px_lad82_2 18.2
Rps823 px_lad82_2 px_lad82_3 15.8
Rps824 px_lad82_3 px_lad82_4 16.4
Rps825 px_lad82_4 px_lad82_5 17
Rps826 px_lad82_5 px_lad82_6 2.24
Rps827 px_lad82_6 px_lad82_7 9.36
Rps828 px_lad82_7 px_lad82_8 3.95
Rps829 px_lad82_8 px_lad82_9 18.8
Rps830 bn0 px_lad83_0 4.28
Rps831 px_lad83_0 px_lad83_1 12.2
Rps832 px_lad83_1 px_lad83_2 5.43
Rps833 px_lad83_2 px_lad83_3 1.29
Rps834 px_lad83_3 px_lad83_4 8.08
Rps835 px_lad83_4 px_lad83_5 9.55
Rps836 px_lad83_5 px_lad83_6 10.5
Rps837 px_lad83_6 px_lad83_7 9.24
Rps838 px_lad83_7 px_lad83_8 6.8
Rps839 px_lad83_8 px_lad83_9 8.07
Rps840 xc5_din px_lad84_0 6.83
Rps841 px_lad84_0 px_lad84_1 6.62
Rps842 px_lad84_1 px_lad84_2 20
Rps843 px_lad84_2 px_lad84_3 12.7
Rps844 px_lad84_3 px_lad84_4 11.7
Rps845 px_lad84_4 px_lad84_5 19.8
Rps846 px_lad84_5 px_lad84_6 19.9
Rps847 px_lad84_6 px_lad84_7 2.36
Rps848 px_lad84_7 px_lad84_8 8.41
Rps849 px_lad84_8 px_lad84_9 16.1
Rps850 xc5_xs1_tail0 px_lad85_0 3.64
Rps851 px_lad85_0 px_lad85_1 2.17
Rps852 px_lad85_1 px_lad85_2 8.6
Rps853 px_lad85_2 px_lad85_3 9.85
Rps854 px_lad85_3 px_lad85_4 4.97
Rps855 px_lad85_4 px_lad85_5 19.9
Rps856 px_lad85_5 px_lad85_6 18.1
Rps857 px_lad85_6 px_lad85_7 14.3
Rps858 px_lad85_7 px_lad85_8 15.7
Rps859 px_lad85_8 px_lad85_9 3.3
Rps860 bp7 px_lad86_0 13.2
Rps861 px_lad86_0 px_lad86_1 10.2
Rps862 px_lad86_1 px_lad86_2 6
Rps863 px_lad86_2 px_lad86_3 12.5
Rps864 px_lad86_3 px_lad86_4 1.69
Rps865 px_lad86_4 px_lad86_5 4.53
Rps866 px_lad86_5 px_lad86_6 8.51
Rps867 px_lad86_6 px_lad86_7 15.9
Rps868 px_lad86_7 px_lad86_8 17.5
Rps869 px_lad86_8 px_lad86_9 18.2
Rps870 bn2 px_lad87_0 1.51
Rps871 px_lad87_0 px_lad87_1 6.94
Rps872 px_lad87_1 px_lad87_2 10.8
Rps873 px_lad87_2 px_lad87_3 13.1
Rps874 px_lad87_3 px_lad87_4 6.32
Rps875 px_lad87_4 px_lad87_5 2.53
Rps876 px_lad87_5 px_lad87_6 13.9
Rps877 px_lad87_6 px_lad87_7 8.19
Rps878 px_lad87_7 px_lad87_8 3.47
Rps879 px_lad87_8 px_lad87_9 6.93
Rps880 t0b px_lad88_0 15.6
Rps881 px_lad88_0 px_lad88_1 17.2
Rps882 px_lad88_1 px_lad88_2 4.53
Rps883 px_lad88_2 px_lad88_3 14.4
Rps884 px_lad88_3 px_lad88_4 17.8
Rps885 px_lad88_4 px_lad88_5 18
Rps886 px_lad88_5 px_lad88_6 2.63
Rps887 px_lad88_6 px_lad88_7 7.82
Rps888 px_lad88_7 px_lad88_8 4.89
Rps889 px_lad88_8 px_lad88_9 5.31
Rps890 bp1 px_lad89_0 7.15
Rps891 px_lad89_0 px_lad89_1 1.2
Rps892 px_lad89_1 px_lad89_2 10.4
Rps893 px_lad89_2 px_lad89_3 14.7
Rps894 px_lad89_3 px_lad89_4 16.7
Rps895 px_lad89_4 px_lad89_5 16.2
Rps896 px_lad89_5 px_lad89_6 11.5
Rps897 px_lad89_6 px_lad89_7 17.8
Rps898 px_lad89_7 px_lad89_8 14.1
Rps899 px_lad89_8 px_lad89_9 16.1
Rps900 bp10 px_lad90_0 7.61
Rps901 px_lad90_0 px_lad90_1 12.7
Rps902 px_lad90_1 px_lad90_2 14.6
Rps903 px_lad90_2 px_lad90_3 6.05
Rps904 px_lad90_3 px_lad90_4 8.24
Rps905 px_lad90_4 px_lad90_5 3.01
Rps906 px_lad90_5 px_lad90_6 3.3
Rps907 px_lad90_6 px_lad90_7 3.93
Rps908 px_lad90_7 px_lad90_8 19
Rps909 px_lad90_8 px_lad90_9 16.9
Rps910 bp2 px_lad91_0 8.38
Rps911 px_lad91_0 px_lad91_1 8.99
Rps912 px_lad91_1 px_lad91_2 3.94
Rps913 px_lad91_2 px_lad91_3 15.7
Rps914 px_lad91_3 px_lad91_4 1.8
Rps915 px_lad91_4 px_lad91_5 2.57
Rps916 px_lad91_5 px_lad91_6 13.4
Rps917 px_lad91_6 px_lad91_7 11.5
Rps918 px_lad91_7 px_lad91_8 5.91
Rps919 px_lad91_8 px_lad91_9 13.7
Rps920 bn2 px_lad92_0 5.01
Rps921 px_lad92_0 px_lad92_1 1.74
Rps922 px_lad92_1 px_lad92_2 14
Rps923 px_lad92_2 px_lad92_3 19.9
Rps924 px_lad92_3 px_lad92_4 7.83
Rps925 px_lad92_4 px_lad92_5 1.53
Rps926 px_lad92_5 px_lad92_6 18.6
Rps927 px_lad92_6 px_lad92_7 2.67
Rps928 px_lad92_7 px_lad92_8 6
Rps929 px_lad92_8 px_lad92_9 6.6
Rps930 xs0n_x px_lad93_0 18.4
Rps931 px_lad93_0 px_lad93_1 13.9
Rps932 px_lad93_1 px_lad93_2 13.5
Rps933 px_lad93_2 px_lad93_3 9.2
Rps934 px_lad93_3 px_lad93_4 2.75
Rps935 px_lad93_4 px_lad93_5 6.68
Rps936 px_lad93_5 px_lad93_6 10.5
Rps937 px_lad93_6 px_lad93_7 2.78
Rps938 px_lad93_7 px_lad93_8 4.19
Rps939 px_lad93_8 px_lad93_9 14.8
Rps940 clkn px_lad94_0 17
Rps941 px_lad94_0 px_lad94_1 14.3
Rps942 px_lad94_1 px_lad94_2 17.4
Rps943 px_lad94_2 px_lad94_3 14.3
Rps944 px_lad94_3 px_lad94_4 17.2
Rps945 px_lad94_4 px_lad94_5 9.89
Rps946 px_lad94_5 px_lad94_6 20
Rps947 px_lad94_6 px_lad94_7 14.4
Rps948 px_lad94_7 px_lad94_8 17.9
Rps949 px_lad94_8 px_lad94_9 10.2
Rps950 cp12 px_lad95_0 9.74
Rps951 px_lad95_0 px_lad95_1 2.59
Rps952 px_lad95_1 px_lad95_2 14.9
Rps953 px_lad95_2 px_lad95_3 7.04
Rps954 px_lad95_3 px_lad95_4 7.75
Rps955 px_lad95_4 px_lad95_5 15.2
Rps956 px_lad95_5 px_lad95_6 4.61
Rps957 px_lad95_6 px_lad95_7 2.36
Rps958 px_lad95_7 px_lad95_8 7.75
Rps959 px_lad95_8 px_lad95_9 7.62
Rps960 top_p px_lad96_0 19.7
Rps961 px_lad96_0 px_lad96_1 1.85
Rps962 px_lad96_1 px_lad96_2 11.4
Rps963 px_lad96_2 px_lad96_3 19.8
Rps964 px_lad96_3 px_lad96_4 18.7
Rps965 px_lad96_4 px_lad96_5 1.46
Rps966 px_lad96_5 px_lad96_6 7.73
Rps967 px_lad96_6 px_lad96_7 8.58
Rps968 px_lad96_7 px_lad96_8 5.03
Rps969 px_lad96_8 px_lad96_9 8.91
Rps970 cn7 px_lad97_0 7.63
Rps971 px_lad97_0 px_lad97_1 14.8
Rps972 px_lad97_1 px_lad97_2 14.3
Rps973 px_lad97_2 px_lad97_3 15.5
Rps974 px_lad97_3 px_lad97_4 17.4
Rps975 px_lad97_4 px_lad97_5 19.2
Rps976 px_lad97_5 px_lad97_6 16.3
Rps977 px_lad97_6 px_lad97_7 4.75
Rps978 px_lad97_7 px_lad97_8 3.39
Rps979 px_lad97_8 px_lad97_9 3.45
Rps980 xs1p_g px_lad98_0 8.72
Rps981 px_lad98_0 px_lad98_1 6.7
Rps982 px_lad98_1 px_lad98_2 13.4
Rps983 px_lad98_2 px_lad98_3 14.8
Rps984 px_lad98_3 px_lad98_4 1.36
Rps985 px_lad98_4 px_lad98_5 9.7
Rps986 px_lad98_5 px_lad98_6 18
Rps987 px_lad98_6 px_lad98_7 19.9
Rps988 px_lad98_7 px_lad98_8 11.6
Rps989 px_lad98_8 px_lad98_9 12.1
Rps990 rstb px_lad99_0 14
Rps991 px_lad99_0 px_lad99_1 3.53
Rps992 px_lad99_1 px_lad99_2 12.9
Rps993 px_lad99_2 px_lad99_3 10.9
Rps994 px_lad99_3 px_lad99_4 7.32
Rps995 px_lad99_4 px_lad99_5 9.54
Rps996 px_lad99_5 px_lad99_6 17.4
Rps997 px_lad99_6 px_lad99_7 14.9
Rps998 px_lad99_7 px_lad99_8 2.75
Rps999 px_lad99_8 px_lad99_9 7.92
Rps1000 vdd px_lad100_0 15.1
Rps1001 px_lad100_0 px_lad100_1 17.4
Rps1002 px_lad100_1 px_lad100_2 7.09
Rps1003 px_lad100_2 px_lad100_3 18.8
Rps1004 px_lad100_3 px_lad100_4 19.9
Rps1005 px_lad100_4 px_lad100_5 3.03
Rps1006 px_lad100_5 px_lad100_6 16.3
Rps1007 px_lad100_6 px_lad100_7 7.61
Rps1008 px_lad100_7 px_lad100_8 5.24
Rps1009 px_lad100_8 px_lad100_9 15.6
Rps1010 xc4_dip px_lad101_0 9.87
Rps1011 px_lad101_0 px_lad101_1 15.2
Rps1012 px_lad101_1 px_lad101_2 9.78
Rps1013 px_lad101_2 px_lad101_3 3.37
Rps1014 px_lad101_3 px_lad101_4 1.81
Rps1015 px_lad101_4 px_lad101_5 19.7
Rps1016 px_lad101_5 px_lad101_6 1.37
Rps1017 px_lad101_6 px_lad101_7 14
Rps1018 px_lad101_7 px_lad101_8 17.6
Rps1019 px_lad101_8 px_lad101_9 16.4
Rps1020 bp3 px_lad102_0 14.6
Rps1021 px_lad102_0 px_lad102_1 13.9
Rps1022 px_lad102_1 px_lad102_2 18.7
Rps1023 px_lad102_2 px_lad102_3 19.6
Rps1024 px_lad102_3 px_lad102_4 17.7
Rps1025 px_lad102_4 px_lad102_5 15
Rps1026 px_lad102_5 px_lad102_6 9.06
Rps1027 px_lad102_6 px_lad102_7 3.05
Rps1028 px_lad102_7 px_lad102_8 11.2
Rps1029 px_lad102_8 px_lad102_9 18.9
Rps1030 on px_lad103_0 7.8
Rps1031 px_lad103_0 px_lad103_1 6.58
Rps1032 px_lad103_1 px_lad103_2 2.3
Rps1033 px_lad103_2 px_lad103_3 9
Rps1034 px_lad103_3 px_lad103_4 15
Rps1035 px_lad103_4 px_lad103_5 2.07
Rps1036 px_lad103_5 px_lad103_6 9.83
Rps1037 px_lad103_6 px_lad103_7 2.9
Rps1038 px_lad103_7 px_lad103_8 2.97
Rps1039 px_lad103_8 px_lad103_9 14.6
Rps1040 xc5_dip px_lad104_0 12.4
Rps1041 px_lad104_0 px_lad104_1 8.17
Rps1042 px_lad104_1 px_lad104_2 8.44
Rps1043 px_lad104_2 px_lad104_3 8.5
Rps1044 px_lad104_3 px_lad104_4 11.9
Rps1045 px_lad104_4 px_lad104_5 3.07
Rps1046 px_lad104_5 px_lad104_6 13.1
Rps1047 px_lad104_6 px_lad104_7 5
Rps1048 px_lad104_7 px_lad104_8 13.8
Rps1049 px_lad104_8 px_lad104_9 14.4
Rps1050 onp px_lad105_0 6.62
Rps1051 px_lad105_0 px_lad105_1 7.67
Rps1052 px_lad105_1 px_lad105_2 6.29
Rps1053 px_lad105_2 px_lad105_3 3.83
Rps1054 px_lad105_3 px_lad105_4 1.96
Rps1055 px_lad105_4 px_lad105_5 8.42
Rps1056 px_lad105_5 px_lad105_6 11.5
Rps1057 px_lad105_6 px_lad105_7 9.77
Rps1058 px_lad105_7 px_lad105_8 8.61
Rps1059 px_lad105_8 px_lad105_9 1.65
Rps1060 clkb px_lad106_0 10.6
Rps1061 px_lad106_0 px_lad106_1 19.4
Rps1062 px_lad106_1 px_lad106_2 10.7
Rps1063 px_lad106_2 px_lad106_3 19.7
Rps1064 px_lad106_3 px_lad106_4 4.59
Rps1065 px_lad106_4 px_lad106_5 12.4
Rps1066 px_lad106_5 px_lad106_6 10.1
Rps1067 px_lad106_6 px_lad106_7 8.97
Rps1068 px_lad106_7 px_lad106_8 8.69
Rps1069 px_lad106_8 px_lad106_9 14.8
Rps1070 xc5_xs1_tail px_lad107_0 5.54
Rps1071 px_lad107_0 px_lad107_1 7.51
Rps1072 px_lad107_1 px_lad107_2 18.4
Rps1073 px_lad107_2 px_lad107_3 9.38
Rps1074 px_lad107_3 px_lad107_4 2.12
Rps1075 px_lad107_4 px_lad107_5 15.4
Rps1076 px_lad107_5 px_lad107_6 19.6
Rps1077 px_lad107_6 px_lad107_7 5.78
Rps1078 px_lad107_7 px_lad107_8 1.19
Rps1079 px_lad107_8 px_lad107_9 10.6
Rps1080 bp9 px_lad108_0 17.1
Rps1081 px_lad108_0 px_lad108_1 8.09
Rps1082 px_lad108_1 px_lad108_2 11.9
Rps1083 px_lad108_2 px_lad108_3 15.6
Rps1084 px_lad108_3 px_lad108_4 10.2
Rps1085 px_lad108_4 px_lad108_5 7.73
Rps1086 px_lad108_5 px_lad108_6 13
Rps1087 px_lad108_6 px_lad108_7 19.8
Rps1088 px_lad108_7 px_lad108_8 15.4
Rps1089 px_lad108_8 px_lad108_9 5.11
Rps1090 cp6 px_lad109_0 12.2
Rps1091 px_lad109_0 px_lad109_1 4.51
Rps1092 px_lad109_1 px_lad109_2 2.23
Rps1093 px_lad109_2 px_lad109_3 7.58
Rps1094 px_lad109_3 px_lad109_4 15.5
Rps1095 px_lad109_4 px_lad109_5 13.9
Rps1096 px_lad109_5 px_lad109_6 2.12
Rps1097 px_lad109_6 px_lad109_7 4.38
Rps1098 px_lad109_7 px_lad109_8 19.7
Rps1099 px_lad109_8 px_lad109_9 15.6
Rps1100 onp px_lad110_0 13.8
Rps1101 px_lad110_0 px_lad110_1 11.2
Rps1102 px_lad110_1 px_lad110_2 2.48
Rps1103 px_lad110_2 px_lad110_3 12.6
Rps1104 px_lad110_3 px_lad110_4 9.93
Rps1105 px_lad110_4 px_lad110_5 12.8
Rps1106 px_lad110_5 px_lad110_6 18.9
Rps1107 px_lad110_6 px_lad110_7 1.66
Rps1108 px_lad110_7 px_lad110_8 4.76
Rps1109 px_lad110_8 px_lad110_9 4.55
Rps1110 rstb px_lad111_0 6.41
Rps1111 px_lad111_0 px_lad111_1 1.43
Rps1112 px_lad111_1 px_lad111_2 17.2
Rps1113 px_lad111_2 px_lad111_3 9.02
Rps1114 px_lad111_3 px_lad111_4 18.9
Rps1115 px_lad111_4 px_lad111_5 18.5
Rps1116 px_lad111_5 px_lad111_6 4.57
Rps1117 px_lad111_6 px_lad111_7 2.04
Rps1118 px_lad111_7 px_lad111_8 11.5
Rps1119 px_lad111_8 px_lad111_9 5.44
Rps1120 in0n px_lad112_0 16.8
Rps1121 px_lad112_0 px_lad112_1 15
Rps1122 px_lad112_1 px_lad112_2 3.69
Rps1123 px_lad112_2 px_lad112_3 14.2
Rps1124 px_lad112_3 px_lad112_4 6.86
Rps1125 px_lad112_4 px_lad112_5 10.5
Rps1126 px_lad112_5 px_lad112_6 2.5
Rps1127 px_lad112_6 px_lad112_7 3.92
Rps1128 px_lad112_7 px_lad112_8 1.39
Rps1129 px_lad112_8 px_lad112_9 5.62
Rps1130 bp10 px_lad113_0 14.8
Rps1131 px_lad113_0 px_lad113_1 8.26
Rps1132 px_lad113_1 px_lad113_2 8.45
Rps1133 px_lad113_2 px_lad113_3 19.6
Rps1134 px_lad113_3 px_lad113_4 7.03
Rps1135 px_lad113_4 px_lad113_5 15.3
Rps1136 px_lad113_5 px_lad113_6 13.7
Rps1137 px_lad113_6 px_lad113_7 11.8
Rps1138 px_lad113_7 px_lad113_8 17.4
Rps1139 px_lad113_8 px_lad113_9 5.6
Rps1140 op px_lad114_0 9.42
Rps1141 px_lad114_0 px_lad114_1 9.49
Rps1142 px_lad114_1 px_lad114_2 16.3
Rps1143 px_lad114_2 px_lad114_3 3.26
Rps1144 px_lad114_3 px_lad114_4 9.48
Rps1145 px_lad114_4 px_lad114_5 2.39
Rps1146 px_lad114_5 px_lad114_6 4.24
Rps1147 px_lad114_6 px_lad114_7 13
Rps1148 px_lad114_7 px_lad114_8 14.9
Rps1149 px_lad114_8 px_lad114_9 17.1
Rps1150 xc5_outnb px_lad115_0 11.4
Rps1151 px_lad115_0 px_lad115_1 11.6
Rps1152 px_lad115_1 px_lad115_2 6.64
Rps1153 px_lad115_2 px_lad115_3 6.46
Rps1154 px_lad115_3 px_lad115_4 2.22
Rps1155 px_lad115_4 px_lad115_5 13.1
Rps1156 px_lad115_5 px_lad115_6 19
Rps1157 px_lad115_6 px_lad115_7 19.3
Rps1158 px_lad115_7 px_lad115_8 8.01
Rps1159 px_lad115_8 px_lad115_9 17
Rps1160 cp6 px_lad116_0 3.67
Rps1161 px_lad116_0 px_lad116_1 9.03
Rps1162 px_lad116_1 px_lad116_2 4.19
Rps1163 px_lad116_2 px_lad116_3 9.81
Rps1164 px_lad116_3 px_lad116_4 9.86
Rps1165 px_lad116_4 px_lad116_5 3.28
Rps1166 px_lad116_5 px_lad116_6 7.66
Rps1167 px_lad116_6 px_lad116_7 13.9
Rps1168 px_lad116_7 px_lad116_8 10.5
Rps1169 px_lad116_8 px_lad116_9 19.6
Rps1170 xs0n_g px_lad117_0 7.7
Rps1171 px_lad117_0 px_lad117_1 4.29
Rps1172 px_lad117_1 px_lad117_2 8.96
Rps1173 px_lad117_2 px_lad117_3 3.29
Rps1174 px_lad117_3 px_lad117_4 7.72
Rps1175 px_lad117_4 px_lad117_5 15.1
Rps1176 px_lad117_5 px_lad117_6 17
Rps1177 px_lad117_6 px_lad117_7 9.7
Rps1178 px_lad117_7 px_lad117_8 16.5
Rps1179 px_lad117_8 px_lad117_9 14.8
Rps1180 xc5_dip px_lad118_0 6.41
Rps1181 px_lad118_0 px_lad118_1 2.9
Rps1182 px_lad118_1 px_lad118_2 19.3
Rps1183 px_lad118_2 px_lad118_3 4.59
Rps1184 px_lad118_3 px_lad118_4 18.2
Rps1185 px_lad118_4 px_lad118_5 1.12
Rps1186 px_lad118_5 px_lad118_6 6.44
Rps1187 px_lad118_6 px_lad118_7 8.1
Rps1188 px_lad118_7 px_lad118_8 11.9
Rps1189 px_lad118_8 px_lad118_9 8.85
Rps1190 lsb_p px_lad119_0 7.79
Rps1191 px_lad119_0 px_lad119_1 11.2
Rps1192 px_lad119_1 px_lad119_2 17.1
Rps1193 px_lad119_2 px_lad119_3 18
Rps1194 px_lad119_3 px_lad119_4 5.9
Rps1195 px_lad119_4 px_lad119_5 7.31
Rps1196 px_lad119_5 px_lad119_6 2.19
Rps1197 px_lad119_6 px_lad119_7 6.02
Rps1198 px_lad119_7 px_lad119_8 4.69
Rps1199 px_lad119_8 px_lad119_9 6.11
Rps1200 bp11 px_lad120_0 12.3
Rps1201 px_lad120_0 px_lad120_1 12.7
Rps1202 px_lad120_1 px_lad120_2 6.74
Rps1203 px_lad120_2 px_lad120_3 9.76
Rps1204 px_lad120_3 px_lad120_4 7.43
Rps1205 px_lad120_4 px_lad120_5 2.21
Rps1206 px_lad120_5 px_lad120_6 16.5
Rps1207 px_lad120_6 px_lad120_7 18.2
Rps1208 px_lad120_7 px_lad120_8 10.1
Rps1209 px_lad120_8 px_lad120_9 5.41
Rps1210 xs1p_cbp px_lad121_0 11.4
Rps1211 px_lad121_0 px_lad121_1 16.4
Rps1212 px_lad121_1 px_lad121_2 1.55
Rps1213 px_lad121_2 px_lad121_3 3.09
Rps1214 px_lad121_3 px_lad121_4 6.49
Rps1215 px_lad121_4 px_lad121_5 1.26
Rps1216 px_lad121_5 px_lad121_6 9.24
Rps1217 px_lad121_6 px_lad121_7 4.21
Rps1218 px_lad121_7 px_lad121_8 16.4
Rps1219 px_lad121_8 px_lad121_9 3.22
Rps1220 xs0n_n10 px_lad122_0 1.9
Rps1221 px_lad122_0 px_lad122_1 11.6
Rps1222 px_lad122_1 px_lad122_2 16.4
Rps1223 px_lad122_2 px_lad122_3 9.42
Rps1224 px_lad122_3 px_lad122_4 11.6
Rps1225 px_lad122_4 px_lad122_5 14.7
Rps1226 px_lad122_5 px_lad122_6 13.1
Rps1227 px_lad122_6 px_lad122_7 4.53
Rps1228 px_lad122_7 px_lad122_8 1.19
Rps1229 px_lad122_8 px_lad122_9 5.98
Rps1230 bn6 px_lad123_0 10
Rps1231 px_lad123_0 px_lad123_1 7.51
Rps1232 px_lad123_1 px_lad123_2 18.3
Rps1233 px_lad123_2 px_lad123_3 4.52
Rps1234 px_lad123_3 px_lad123_4 12.5
Rps1235 px_lad123_4 px_lad123_5 13.7
Rps1236 px_lad123_5 px_lad123_6 19.9
Rps1237 px_lad123_6 px_lad123_7 2.37
Rps1238 px_lad123_7 px_lad123_8 5.01
Rps1239 px_lad123_8 px_lad123_9 15.6
Rps1240 bn6 px_lad124_0 16.3
Rps1241 px_lad124_0 px_lad124_1 14.4
Rps1242 px_lad124_1 px_lad124_2 14.9
Rps1243 px_lad124_2 px_lad124_3 17.1
Rps1244 px_lad124_3 px_lad124_4 16.6
Rps1245 px_lad124_4 px_lad124_5 9.87
Rps1246 px_lad124_5 px_lad124_6 8.16
Rps1247 px_lad124_6 px_lad124_7 9.33
Rps1248 px_lad124_7 px_lad124_8 9.45
Rps1249 px_lad124_8 px_lad124_9 15
Rps1250 bp4 px_lad125_0 15.5
Rps1251 px_lad125_0 px_lad125_1 2.88
Rps1252 px_lad125_1 px_lad125_2 1.62
Rps1253 px_lad125_2 px_lad125_3 7.35
Rps1254 px_lad125_3 px_lad125_4 12.7
Rps1255 px_lad125_4 px_lad125_5 13.4
Rps1256 px_lad125_5 px_lad125_6 2.79
Rps1257 px_lad125_6 px_lad125_7 10.6
Rps1258 px_lad125_7 px_lad125_8 15.3
Rps1259 px_lad125_8 px_lad125_9 6.85
Rps1260 bp3 px_lad126_0 10.6
Rps1261 px_lad126_0 px_lad126_1 11
Rps1262 px_lad126_1 px_lad126_2 4.8
Rps1263 px_lad126_2 px_lad126_3 4.89
Rps1264 px_lad126_3 px_lad126_4 19.6
Rps1265 px_lad126_4 px_lad126_5 2.32
Rps1266 px_lad126_5 px_lad126_6 1.93
Rps1267 px_lad126_6 px_lad126_7 17.4
Rps1268 px_lad126_7 px_lad126_8 17.4
Rps1269 px_lad126_8 px_lad126_9 18.5
Rps1270 bp9 px_lad127_0 7.51
Rps1271 px_lad127_0 px_lad127_1 3.07
Rps1272 px_lad127_1 px_lad127_2 13.7
Rps1273 px_lad127_2 px_lad127_3 14.4
Rps1274 px_lad127_3 px_lad127_4 9.58
Rps1275 px_lad127_4 px_lad127_5 18.9
Rps1276 px_lad127_5 px_lad127_6 3.41
Rps1277 px_lad127_6 px_lad127_7 11.6
Rps1278 px_lad127_7 px_lad127_8 11.7
Rps1279 px_lad127_8 px_lad127_9 3.33
Rps1280 bp2 px_lad128_0 17.9
Rps1281 px_lad128_0 px_lad128_1 6.66
Rps1282 px_lad128_1 px_lad128_2 5.41
Rps1283 px_lad128_2 px_lad128_3 4.62
Rps1284 px_lad128_3 px_lad128_4 16.1
Rps1285 px_lad128_4 px_lad128_5 3.75
Rps1286 px_lad128_5 px_lad128_6 1.31
Rps1287 px_lad128_6 px_lad128_7 3.17
Rps1288 px_lad128_7 px_lad128_8 2.32
Rps1289 px_lad128_8 px_lad128_9 5.28
Rps1290 xs0n_cbn px_lad129_0 14.6
Rps1291 px_lad129_0 px_lad129_1 15.2
Rps1292 px_lad129_1 px_lad129_2 16.8
Rps1293 px_lad129_2 px_lad129_3 15.4
Rps1294 px_lad129_3 px_lad129_4 16.3
Rps1295 px_lad129_4 px_lad129_5 11.8
Rps1296 px_lad129_5 px_lad129_6 12.8
Rps1297 px_lad129_6 px_lad129_7 9.3
Rps1298 px_lad129_7 px_lad129_8 5.45
Rps1299 px_lad129_8 px_lad129_9 13
Rps1300 xs1n_n10 px_lad130_0 8.05
Rps1301 px_lad130_0 px_lad130_1 20
Rps1302 px_lad130_1 px_lad130_2 14.4
Rps1303 px_lad130_2 px_lad130_3 3.54
Rps1304 px_lad130_3 px_lad130_4 16.2
Rps1305 px_lad130_4 px_lad130_5 5
Rps1306 px_lad130_5 px_lad130_6 7.29
Rps1307 px_lad130_6 px_lad130_7 8.25
Rps1308 px_lad130_7 px_lad130_8 15.1
Rps1309 px_lad130_8 px_lad130_9 2.75
Rps1310 bn1 px_lad131_0 14.2
Rps1311 px_lad131_0 px_lad131_1 19.1
Rps1312 px_lad131_1 px_lad131_2 1.37
Rps1313 px_lad131_2 px_lad131_3 16.5
Rps1314 px_lad131_3 px_lad131_4 16.3
Rps1315 px_lad131_4 px_lad131_5 18.4
Rps1316 px_lad131_5 px_lad131_6 19.4
Rps1317 px_lad131_6 px_lad131_7 2.02
Rps1318 px_lad131_7 px_lad131_8 13.1
Rps1319 px_lad131_8 px_lad131_9 10.5
Rps1320 xs0n_g px_lad132_0 16.1
Rps1321 px_lad132_0 px_lad132_1 1.98
Rps1322 px_lad132_1 px_lad132_2 15.9
Rps1323 px_lad132_2 px_lad132_3 13.3
Rps1324 px_lad132_3 px_lad132_4 12
Rps1325 px_lad132_4 px_lad132_5 19.7
Rps1326 px_lad132_5 px_lad132_6 9.21
Rps1327 px_lad132_6 px_lad132_7 1.59
Rps1328 px_lad132_7 px_lad132_8 7.67
Rps1329 px_lad132_8 px_lad132_9 16.3
Rps1330 xs1n_n10 px_lad133_0 4.87
Rps1331 px_lad133_0 px_lad133_1 2.14
Rps1332 px_lad133_1 px_lad133_2 12.2
Rps1333 px_lad133_2 px_lad133_3 17.9
Rps1334 px_lad133_3 px_lad133_4 7.52
Rps1335 px_lad133_4 px_lad133_5 16.3
Rps1336 px_lad133_5 px_lad133_6 18.2
Rps1337 px_lad133_6 px_lad133_7 9.87
Rps1338 px_lad133_7 px_lad133_8 4.47
Rps1339 px_lad133_8 px_lad133_9 4.64
Rps1340 onp px_lad134_0 1.79
Rps1341 px_lad134_0 px_lad134_1 7.43
Rps1342 px_lad134_1 px_lad134_2 2.72
Rps1343 px_lad134_2 px_lad134_3 1.24
Rps1344 px_lad134_3 px_lad134_4 15.7
Rps1345 px_lad134_4 px_lad134_5 3.48
Rps1346 px_lad134_5 px_lad134_6 1.1
Rps1347 px_lad134_6 px_lad134_7 17.6
Rps1348 px_lad134_7 px_lad134_8 1.15
Rps1349 px_lad134_8 px_lad134_9 6.81
Rps1350 cn7 px_lad135_0 11.3
Rps1351 px_lad135_0 px_lad135_1 3.33
Rps1352 px_lad135_1 px_lad135_2 16.1
Rps1353 px_lad135_2 px_lad135_3 1.03
Rps1354 px_lad135_3 px_lad135_4 19.1
Rps1355 px_lad135_4 px_lad135_5 16.5
Rps1356 px_lad135_5 px_lad135_6 17
Rps1357 px_lad135_6 px_lad135_7 18.3
Rps1358 px_lad135_7 px_lad135_8 5.98
Rps1359 px_lad135_8 px_lad135_9 7.07
Rps1360 xs1n_n10 px_lad136_0 7.54
Rps1361 px_lad136_0 px_lad136_1 8.83
Rps1362 px_lad136_1 px_lad136_2 6.8
Rps1363 px_lad136_2 px_lad136_3 12.4
Rps1364 px_lad136_3 px_lad136_4 10.4
Rps1365 px_lad136_4 px_lad136_5 13.1
Rps1366 px_lad136_5 px_lad136_6 8.32
Rps1367 px_lad136_6 px_lad136_7 16.8
Rps1368 px_lad136_7 px_lad136_8 8.93
Rps1369 px_lad136_8 px_lad136_9 1.66
Rps1370 cn1 px_lad137_0 15
Rps1371 px_lad137_0 px_lad137_1 11.2
Rps1372 px_lad137_1 px_lad137_2 2.04
Rps1373 px_lad137_2 px_lad137_3 7.75
Rps1374 px_lad137_3 px_lad137_4 16
Rps1375 px_lad137_4 px_lad137_5 1.07
Rps1376 px_lad137_5 px_lad137_6 4.18
Rps1377 px_lad137_6 px_lad137_7 13.6
Rps1378 px_lad137_7 px_lad137_8 13
Rps1379 px_lad137_8 px_lad137_9 16.8
Rps1380 cp12 px_lad138_0 9.05
Rps1381 px_lad138_0 px_lad138_1 6.12
Rps1382 px_lad138_1 px_lad138_2 14.4
Rps1383 px_lad138_2 px_lad138_3 19.1
Rps1384 px_lad138_3 px_lad138_4 17.7
Rps1385 px_lad138_4 px_lad138_5 6.38
Rps1386 px_lad138_5 px_lad138_6 3.5
Rps1387 px_lad138_6 px_lad138_7 1.26
Rps1388 px_lad138_7 px_lad138_8 7.44
Rps1389 px_lad138_8 px_lad138_9 18.2
Rps1390 cn3 px_lad139_0 11.8
Rps1391 px_lad139_0 px_lad139_1 3.76
Rps1392 px_lad139_1 px_lad139_2 4.38
Rps1393 px_lad139_2 px_lad139_3 2.98
Rps1394 px_lad139_3 px_lad139_4 17.7
Rps1395 px_lad139_4 px_lad139_5 12.6
Rps1396 px_lad139_5 px_lad139_6 1.24
Rps1397 px_lad139_6 px_lad139_7 2.19
Rps1398 px_lad139_7 px_lad139_8 3.31
Rps1399 px_lad139_8 px_lad139_9 11
Rps1400 bp10 px_lad140_0 13.9
Rps1401 px_lad140_0 px_lad140_1 3.53
Rps1402 px_lad140_1 px_lad140_2 6.11
Rps1403 px_lad140_2 px_lad140_3 9.4
Rps1404 px_lad140_3 px_lad140_4 14
Rps1405 px_lad140_4 px_lad140_5 14.2
Rps1406 px_lad140_5 px_lad140_6 5.55
Rps1407 px_lad140_6 px_lad140_7 17.5
Rps1408 px_lad140_7 px_lad140_8 9.62
Rps1409 px_lad140_8 px_lad140_9 8.7
Rps1410 cn6 px_lad141_0 16.8
Rps1411 px_lad141_0 px_lad141_1 7.38
Rps1412 px_lad141_1 px_lad141_2 3.64
Rps1413 px_lad141_2 px_lad141_3 15.7
Rps1414 px_lad141_3 px_lad141_4 13.1
Rps1415 px_lad141_4 px_lad141_5 14.8
Rps1416 px_lad141_5 px_lad141_6 19.1
Rps1417 px_lad141_6 px_lad141_7 17
Rps1418 px_lad141_7 px_lad141_8 14.7
Rps1419 px_lad141_8 px_lad141_9 4.33
Rps1420 vbp px_lad142_0 3.02
Rps1421 px_lad142_0 px_lad142_1 2.64
Rps1422 px_lad142_1 px_lad142_2 13.9
Rps1423 px_lad142_2 px_lad142_3 12.2
Rps1424 px_lad142_3 px_lad142_4 5.83
Rps1425 px_lad142_4 px_lad142_5 18.6
Rps1426 px_lad142_5 px_lad142_6 5.43
Rps1427 px_lad142_6 px_lad142_7 14.3
Rps1428 px_lad142_7 px_lad142_8 12.5
Rps1429 px_lad142_8 px_lad142_9 2.52
Rps1430 xs1n_x px_lad143_0 5.89
Rps1431 px_lad143_0 px_lad143_1 14.4
Rps1432 px_lad143_1 px_lad143_2 18.6
Rps1433 px_lad143_2 px_lad143_3 2.55
Rps1434 px_lad143_3 px_lad143_4 19.7
Rps1435 px_lad143_4 px_lad143_5 16.6
Rps1436 px_lad143_5 px_lad143_6 2.29
Rps1437 px_lad143_6 px_lad143_7 18.2
Rps1438 px_lad143_7 px_lad143_8 7.96
Rps1439 px_lad143_8 px_lad143_9 5.58
Rps1440 bp6 px_lad144_0 11.9
Rps1441 px_lad144_0 px_lad144_1 19.7
Rps1442 px_lad144_1 px_lad144_2 3.54
Rps1443 px_lad144_2 px_lad144_3 15.6
Rps1444 px_lad144_3 px_lad144_4 3.36
Rps1445 px_lad144_4 px_lad144_5 16
Rps1446 px_lad144_5 px_lad144_6 4.17
Rps1447 px_lad144_6 px_lad144_7 3.07
Rps1448 px_lad144_7 px_lad144_8 2.36
Rps1449 px_lad144_8 px_lad144_9 12
Rps1450 cp6 px_lad145_0 16.5
Rps1451 px_lad145_0 px_lad145_1 6.11
Rps1452 px_lad145_1 px_lad145_2 12.1
Rps1453 px_lad145_2 px_lad145_3 2.72
Rps1454 px_lad145_3 px_lad145_4 16.3
Rps1455 px_lad145_4 px_lad145_5 11.3
Rps1456 px_lad145_5 px_lad145_6 5.96
Rps1457 px_lad145_6 px_lad145_7 14.1
Rps1458 px_lad145_7 px_lad145_8 9.95
Rps1459 px_lad145_8 px_lad145_9 17.9
Rps1460 rstb_n px_lad146_0 17.7
Rps1461 px_lad146_0 px_lad146_1 11
Rps1462 px_lad146_1 px_lad146_2 5.75
Rps1463 px_lad146_2 px_lad146_3 1.69
Rps1464 px_lad146_3 px_lad146_4 14
Rps1465 px_lad146_4 px_lad146_5 6.16
Rps1466 px_lad146_5 px_lad146_6 11.9
Rps1467 px_lad146_6 px_lad146_7 7.93
Rps1468 px_lad146_7 px_lad146_8 5.99
Rps1469 px_lad146_8 px_lad146_9 3.39
Rps1470 clkn px_lad147_0 1.34
Rps1471 px_lad147_0 px_lad147_1 16.5
Rps1472 px_lad147_1 px_lad147_2 1.85
Rps1473 px_lad147_2 px_lad147_3 1.35
Rps1474 px_lad147_3 px_lad147_4 12.4
Rps1475 px_lad147_4 px_lad147_5 19
Rps1476 px_lad147_5 px_lad147_6 15.2
Rps1477 px_lad147_6 px_lad147_7 4.48
Rps1478 px_lad147_7 px_lad147_8 18.6
Rps1479 px_lad147_8 px_lad147_9 1.13
Rps1480 clknb px_lad148_0 16.5
Rps1481 px_lad148_0 px_lad148_1 9.68
Rps1482 px_lad148_1 px_lad148_2 3.75
Rps1483 px_lad148_2 px_lad148_3 11.6
Rps1484 px_lad148_3 px_lad148_4 7.23
Rps1485 px_lad148_4 px_lad148_5 10.3
Rps1486 px_lad148_5 px_lad148_6 9.85
Rps1487 px_lad148_6 px_lad148_7 14.4
Rps1488 px_lad148_7 px_lad148_8 1.85
Rps1489 px_lad148_8 px_lad148_9 8.67
Rps1490 clk px_lad149_0 20
Rps1491 px_lad149_0 px_lad149_1 10.9
Rps1492 px_lad149_1 px_lad149_2 9.04
Rps1493 px_lad149_2 px_lad149_3 1.05
Rps1494 px_lad149_3 px_lad149_4 7.72
Rps1495 px_lad149_4 px_lad149_5 18.5
Rps1496 px_lad149_5 px_lad149_6 2.41
Rps1497 px_lad149_6 px_lad149_7 7.55
Rps1498 px_lad149_7 px_lad149_8 4.95
Rps1499 px_lad149_8 px_lad149_9 5.45
.ends
.subckt r1_adc_lay adc_hold is_smp clk adc_start adc_sel adc_valid_a adc_raw_a_0 adc_raw_a_1 adc_raw_a_2 adc_raw_a_3 adc_raw_a_4 adc_raw_a_5 adc_raw_a_6 adc_raw_a_7 adc_raw_a_8 adc_raw_a_9 adc_raw_a_10 adc_raw_a_11 adc_raw_a_12 adc_raw_a_13 adc_valid_b adc_raw_b_0 adc_raw_b_1 adc_raw_b_2 adc_raw_b_3 adc_raw_b_4 adc_raw_b_5 adc_raw_b_6 adc_raw_b_7 adc_raw_b_8 adc_raw_b_9 adc_raw_b_10 adc_raw_b_11 adc_raw_b_12 adc_raw_b_13 por_n ain_sin_p ain_sin_n ain_cos_p ain_cos_n vcm2 ibias ain_isa_p ain_isa_n ain_isb_p ain_isb_n vcm vdda vdd vss vref_in topap topan topbp topbn sar_clka sar_clkab sar_clkb sar_clkbb sar_clkna sar_clknab sar_clknb sar_clknbb sar_cna0 sar_cna1 sar_cna10 sar_cna11 sar_cna12 sar_cna2 sar_cna3 sar_cna4 sar_cna5 sar_cna6 sar_cna7 sar_cna8 sar_cna9 sar_cnb0 sar_cnb1 sar_cnb10 sar_cnb11 sar_cnb12 sar_cnb2 sar_cnb3 sar_cnb4 sar_cnb5 sar_cnb6 sar_cnb7 sar_cnb8 sar_cnb9 sar_cpa0 sar_cpa1 sar_cpa10 sar_cpa11 sar_cpa12 sar_cpa2 sar_cpa3 sar_cpa4 sar_cpa5 sar_cpa6 sar_cpa7 sar_cpa8 sar_cpa9 sar_cpb0 sar_cpb1 sar_cpb10 sar_cpb11 sar_cpb12 sar_cpb2 sar_cpb3 sar_cpb4 sar_cpb5 sar_cpb6 sar_cpb7 sar_cpb8 sar_cpb9 sar_oan sar_oann sar_oanp sar_oap sar_obn sar_obnn sar_obnp sar_obp sar_trka0 sar_trka1 sar_trkb0 sar_trkb1 sar_mclk
Xxckg_xpd0 xckg_d0 clk vdd vdd sg13_lv_pmos w=1u l=0.5u ng=1 m=1
Xxckg_xnd0 xckg_d0 clk vss vss sg13_lv_nmos w=0.5u l=0.5u ng=1 m=1
Xxckg_cd0 xckg_d0 vss cap_cmim w=2.53u l=2.53u m=1
Xxckg_xpd1 xckg_d1 xckg_d0 vdd vdd sg13_lv_pmos w=1u l=0.5u ng=1 m=1
Xxckg_xnd1 xckg_d1 xckg_d0 vss vss sg13_lv_nmos w=0.5u l=0.5u ng=1 m=1
Xxckg_cd1 xckg_d1 vss cap_cmim w=2.53u l=2.53u m=1
Xxckg_xpd2 xckg_d2 xckg_d1 vdd vdd sg13_lv_pmos w=1u l=0.5u ng=1 m=1
Xxckg_xnd2 xckg_d2 xckg_d1 vss vss sg13_lv_nmos w=0.5u l=0.5u ng=1 m=1
Xxckg_cd2 xckg_d2 vss cap_cmim w=2.53u l=2.53u m=1
Xxckg_xpd3 xckg_d3 xckg_d2 vdd vdd sg13_lv_pmos w=1u l=0.5u ng=1 m=1
Xxckg_xnd3 xckg_d3 xckg_d2 vss vss sg13_lv_nmos w=0.5u l=0.5u ng=1 m=1
Xxckg_cd3 xckg_d3 vss cap_cmim w=2.53u l=2.53u m=1
Xxckg_xpd4 xckg_x xckg_d3 vdd vdd sg13_lv_pmos w=1u l=0.5u ng=1 m=1
Xxckg_xnd4 xckg_x xckg_d3 vss vss sg13_lv_nmos w=0.5u l=0.5u ng=1 m=1
Xxckg_cd4 xckg_x vss cap_cmim w=2.53u l=2.53u m=1
Xxckg_xpa sar_mclk clk vdd vdd sg13_lv_pmos w=2u l=0.13u ng=1 m=1
Xxckg_xpb sar_mclk xckg_x vdd vdd sg13_lv_pmos w=2u l=0.13u ng=1 m=1
Xxckg_xna sar_mclk clk xckg_nn vss sg13_lv_nmos w=2u l=0.13u ng=1 m=1
Xxckg_xnb xckg_nn xckg_x vss vss sg13_lv_nmos w=2u l=0.13u ng=1 m=1
Xxckg_xpi mclkb sar_mclk vdd vdd sg13_lv_pmos w=2u l=0.13u ng=1 m=1
Xxckg_xni mclkb sar_mclk vss vss sg13_lv_nmos w=1u l=0.13u ng=1 m=1
Xxcbias_xmbd vbp vbp vdd vdd sg13_lv_pmos w=0.8u l=0.5u ng=1 m=1
Xxcbias_xrb_g0 vbp xcbias_xrb_s1 vss rppd w=1u l=40u m=1 b=0
Xxcbias_xrb_g1 xcbias_xrb_s1 xcbias_xrb_s2 vss rppd w=1u l=40u m=1 b=0
Xxcbias_xrb_g2 xcbias_xrb_s2 xcbias_xrb_s3 vss rppd w=1u l=40u m=1 b=0
Xxcbias_xrb_g3 xcbias_xrb_s3 vss vss rppd w=1u l=40u m=1 b=0
Xxcbiasn_xmbd vbn vbn vss vss sg13_lv_nmos w=0.2u l=0.5u ng=1 m=1
Xxcbiasn_xrb_g0 vdd xcbiasn_xrb_s1 vss rppd w=1u l=40u m=1 b=0
Xxcbiasn_xrb_g1 xcbiasn_xrb_s1 xcbiasn_xrb_s2 vss rppd w=1u l=40u m=1 b=0
Xxcbiasn_xrb_g2 xcbiasn_xrb_s2 xcbiasn_xrb_s3 vss rppd w=1u l=40u m=1 b=0
Xxcbiasn_xrb_g3 xcbiasn_xrb_s3 vbn vss rppd w=1u l=40u m=1 b=0
Xxref_xmb0 ibias ibias vss vss sg13_hv_nmos w=2u l=1u ng=1 m=1
Xxref_xmt xref_ntl ibias vss vss sg13_hv_nmos w=2u l=8u ng=1 m=1
Xxref_xm1 xref_na vref_in xref_ntl vss sg13_hv_nmos w=10u l=1u ng=2 m=1
Xxref_xm2 xref_ng vref xref_ntl vss sg13_hv_nmos w=10u l=1u ng=2 m=1
Xxref_xm3 xref_na xref_na vdda vdda sg13_hv_pmos w=4u l=1u ng=1 m=1
Xxref_xm4 xref_ng xref_na vdda vdda sg13_hv_pmos w=4u l=1u ng=1 m=1
Xxref_xcg_u0 vss xref_ng cap_cmim w=26.32u l=95u m=1
Xxref_xmsf_s0 vdda xref_ng vref vss sg13_hv_nmos w=80u l=0.45u ng=32 m=4
Xxref_xmib_s0 vref ibias vss vss sg13_hv_nmos w=80u l=1u ng=40 m=4
Xxref_xcd_u0 vss vref cap_cmim w=51.58u l=95u m=4
Xxref_xmsfl_s0 vdda xref_ng vrefl vss sg13_hv_nmos w=80u l=0.45u ng=32 m=1
Xxref_xmibl_s0 vrefl ibias vss vss sg13_hv_nmos w=80u l=1u ng=40 m=1
Xxref_xcdl_u0 vss vrefl cap_cmim w=51.58u l=95u m=2
Xxfilt_xcf_u0 vss vref_in cap_cmim w=37.36u l=90u m=2
Xslice_a ain_sin_p ain_sin_n ain_isa_p ain_isa_n sar_trka0 sar_trka1 sar_cpa0 sar_cpa1 sar_cpa2 sar_cpa3 sar_cpa4 sar_cpa5 sar_cpa6 sar_cpa7 sar_cpa8 sar_cpa9 sar_cpa10 sar_cpa11 sar_cpa12 sar_cna0 sar_cna1 sar_cna2 sar_cna3 sar_cna4 sar_cna5 sar_cna6 sar_cna7 sar_cna8 sar_cna9 sar_cna10 sar_cna11 sar_cna12 sar_clka sar_clkab sar_clkna sar_clknab sar_oap sar_oan sar_oanp sar_oann vbp vbn vref vrefl topap topan vdd vss r1_adc_slice_lay
Xslice_b ain_cos_p ain_cos_n ain_isb_p ain_isb_n sar_trkb0 sar_trkb1 sar_cpb0 sar_cpb1 sar_cpb2 sar_cpb3 sar_cpb4 sar_cpb5 sar_cpb6 sar_cpb7 sar_cpb8 sar_cpb9 sar_cpb10 sar_cpb11 sar_cpb12 sar_cnb0 sar_cnb1 sar_cnb2 sar_cnb3 sar_cnb4 sar_cnb5 sar_cnb6 sar_cnb7 sar_cnb8 sar_cnb9 sar_cnb10 sar_cnb11 sar_cnb12 sar_clkb sar_clkbb sar_clknb sar_clknbb sar_obp sar_obn sar_obnp sar_obnn vbp vbn vref vrefl topbp topbn vdd vss r1_adc_slice_lay
* parasitics, scope top: 825 C (4.62e-13 F total), 500 R, 500 internal nodes
Cpt0 clk ibias 2.245e-16
Cpt1 clk mclkb 1.966e-16
Cpt2 clk sar_mclk 3.48e-16
Cpt3 clk vbn 5.013e-16
Cpt4 clk vbp 5.97e-17
Cpt5 clk vdd 5.18e-16
Cpt6 clk vdda 8.71e-16
Cpt7 clk vref 8.066e-16
Cpt8 clk vref_in 5.4e-16
Cpt9 clk vrefl 1.71e-16
Cpt10 clk vss 1.0346e-14
Cpt11 clk xcbias_xrb_s1 4.91e-17
Cpt12 clk xcbias_xrb_s2 6.97e-16
Cpt13 clk xcbias_xrb_s3 1.27e-16
Cpt14 clk xcbiasn_xrb_s1 2.848e-16
Cpt15 clk xcbiasn_xrb_s2 1.0039e-15
Cpt16 clk xcbiasn_xrb_s3 2.33e-15
Cpt17 clk xckg_d0 9.735e-16
Cpt18 clk xckg_d1 3.35e-16
Cpt19 clk xckg_d2 6.2e-16
Cpt20 clk xckg_d3 4.57e-16
Cpt21 clk xckg_nn 1.1172e-15
Cpt22 clk xckg_x 2.033e-16
Cpt23 clk xref_na 1.41e-16
Cpt24 clk xref_ng 7.451e-16
Cpt25 clk xref_ntl 9.32e-16
Cpt26 ibias sar_mclk 8.65e-16
Cpt27 ibias vbn 5.563e-16
Cpt28 ibias vbp 6.041e-16
Cpt29 ibias vdd 2.34e-16
Cpt30 ibias vdda 2.094e-16
Cpt31 ibias vref 9.509e-16
Cpt32 ibias vref_in 4.6e-16
Cpt33 ibias vss 5.7227e-15
Cpt34 ibias xcbias_xrb_s1 2.5e-16
Cpt35 ibias xcbias_xrb_s2 3.28e-16
Cpt36 ibias xcbias_xrb_s3 4.9e-16
Cpt37 ibias xcbiasn_xrb_s1 2.693e-15
Cpt38 ibias xcbiasn_xrb_s2 3.627e-16
Cpt39 ibias xcbiasn_xrb_s3 1.141e-16
Cpt40 ibias xckg_d1 7.71e-16
Cpt41 ibias xckg_d2 4.124e-16
Cpt42 ibias xckg_d3 2.558e-16
Cpt43 ibias xckg_nn 3.058e-16
Cpt44 ibias xckg_x 7.272e-16
Cpt45 ibias xref_na 6.269e-16
Cpt46 ibias xref_ng 3.985e-16
Cpt47 ibias xref_ntl 5.828e-16
Cpt48 mclkb sar_mclk 3.68e-16
Cpt49 mclkb vbn 1.339e-15
Cpt50 mclkb vbp 4.38e-16
Cpt51 mclkb vdd 1.76e-16
Cpt52 mclkb vdda 4.586e-16
Cpt53 mclkb vref 7.425e-16
Cpt54 mclkb vref_in 1.436e-16
Cpt55 mclkb vrefl 7.774e-16
Cpt56 mclkb vss 1.0911e-14
Cpt57 mclkb xcbias_xrb_s1 1.8533e-15
Cpt58 mclkb xcbias_xrb_s2 2.29e-16
Cpt59 mclkb xcbiasn_xrb_s1 5.111e-16
Cpt60 mclkb xcbiasn_xrb_s2 1.93e-16
Cpt61 mclkb xcbiasn_xrb_s3 3.17e-16
Cpt62 mclkb xckg_d0 5.39e-16
Cpt63 mclkb xckg_d1 2.44e-16
Cpt64 mclkb xckg_d3 1.02e-16
Cpt65 mclkb xckg_nn 6.487e-16
Cpt66 mclkb xckg_x 1.7e-16
Cpt67 mclkb xref_na 1.159e-16
Cpt68 mclkb xref_ng 1.51e-16
Cpt69 mclkb xref_ntl 2.24e-16
Cpt70 px_lad0_0 vss 1e-16
Cpt71 px_lad0_1 vss 1e-16
Cpt72 px_lad0_2 vss 1e-16
Cpt73 px_lad0_3 vss 1e-16
Cpt74 px_lad0_4 vss 1e-16
Cpt75 px_lad0_5 vss 1e-16
Cpt76 px_lad0_6 vss 1e-16
Cpt77 px_lad0_7 vss 1e-16
Cpt78 px_lad0_8 vss 1e-16
Cpt79 px_lad0_9 vss 1e-16
Cpt80 px_lad10_0 vss 1e-16
Cpt81 px_lad10_1 vss 1e-16
Cpt82 px_lad10_2 vss 1e-16
Cpt83 px_lad10_3 vss 1e-16
Cpt84 px_lad10_4 vss 1e-16
Cpt85 px_lad10_5 vss 1e-16
Cpt86 px_lad10_6 vss 1e-16
Cpt87 px_lad10_7 vss 1e-16
Cpt88 px_lad10_8 vss 1e-16
Cpt89 px_lad10_9 vss 1e-16
Cpt90 px_lad11_0 vss 1e-16
Cpt91 px_lad11_1 vss 1e-16
Cpt92 px_lad11_2 vss 1e-16
Cpt93 px_lad11_3 vss 1e-16
Cpt94 px_lad11_4 vss 1e-16
Cpt95 px_lad11_5 vss 1e-16
Cpt96 px_lad11_6 vss 1e-16
Cpt97 px_lad11_7 vss 1e-16
Cpt98 px_lad11_8 vss 1e-16
Cpt99 px_lad11_9 vss 1e-16
Cpt100 px_lad12_0 vss 1e-16
Cpt101 px_lad12_1 vss 1e-16
Cpt102 px_lad12_2 vss 1e-16
Cpt103 px_lad12_3 vss 1e-16
Cpt104 px_lad12_4 vss 1e-16
Cpt105 px_lad12_5 vss 1e-16
Cpt106 px_lad12_6 vss 1e-16
Cpt107 px_lad12_7 vss 1e-16
Cpt108 px_lad12_8 vss 1e-16
Cpt109 px_lad12_9 vss 1e-16
Cpt110 px_lad13_0 vss 1e-16
Cpt111 px_lad13_1 vss 1e-16
Cpt112 px_lad13_2 vss 1e-16
Cpt113 px_lad13_3 vss 1e-16
Cpt114 px_lad13_4 vss 1e-16
Cpt115 px_lad13_5 vss 1e-16
Cpt116 px_lad13_6 vss 1e-16
Cpt117 px_lad13_7 vss 1e-16
Cpt118 px_lad13_8 vss 1e-16
Cpt119 px_lad13_9 vss 1e-16
Cpt120 px_lad14_0 vss 1e-16
Cpt121 px_lad14_1 vss 1e-16
Cpt122 px_lad14_2 vss 1e-16
Cpt123 px_lad14_3 vss 1e-16
Cpt124 px_lad14_4 vss 1e-16
Cpt125 px_lad14_5 vss 1e-16
Cpt126 px_lad14_6 vss 1e-16
Cpt127 px_lad14_7 vss 1e-16
Cpt128 px_lad14_8 vss 1e-16
Cpt129 px_lad14_9 vss 1e-16
Cpt130 px_lad15_0 vss 1e-16
Cpt131 px_lad15_1 vss 1e-16
Cpt132 px_lad15_2 vss 1e-16
Cpt133 px_lad15_3 vss 1e-16
Cpt134 px_lad15_4 vss 1e-16
Cpt135 px_lad15_5 vss 1e-16
Cpt136 px_lad15_6 vss 1e-16
Cpt137 px_lad15_7 vss 1e-16
Cpt138 px_lad15_8 vss 1e-16
Cpt139 px_lad15_9 vss 1e-16
Cpt140 px_lad16_0 vss 1e-16
Cpt141 px_lad16_1 vss 1e-16
Cpt142 px_lad16_2 vss 1e-16
Cpt143 px_lad16_3 vss 1e-16
Cpt144 px_lad16_4 vss 1e-16
Cpt145 px_lad16_5 vss 1e-16
Cpt146 px_lad16_6 vss 1e-16
Cpt147 px_lad16_7 vss 1e-16
Cpt148 px_lad16_8 vss 1e-16
Cpt149 px_lad16_9 vss 1e-16
Cpt150 px_lad17_0 vss 1e-16
Cpt151 px_lad17_1 vss 1e-16
Cpt152 px_lad17_2 vss 1e-16
Cpt153 px_lad17_3 vss 1e-16
Cpt154 px_lad17_4 vss 1e-16
Cpt155 px_lad17_5 vss 1e-16
Cpt156 px_lad17_6 vss 1e-16
Cpt157 px_lad17_7 vss 1e-16
Cpt158 px_lad17_8 vss 1e-16
Cpt159 px_lad17_9 vss 1e-16
Cpt160 px_lad18_0 vss 1e-16
Cpt161 px_lad18_1 vss 1e-16
Cpt162 px_lad18_2 vss 1e-16
Cpt163 px_lad18_3 vss 1e-16
Cpt164 px_lad18_4 vss 1e-16
Cpt165 px_lad18_5 vss 1e-16
Cpt166 px_lad18_6 vss 1e-16
Cpt167 px_lad18_7 vss 1e-16
Cpt168 px_lad18_8 vss 1e-16
Cpt169 px_lad18_9 vss 1e-16
Cpt170 px_lad19_0 vss 1e-16
Cpt171 px_lad19_1 vss 1e-16
Cpt172 px_lad19_2 vss 1e-16
Cpt173 px_lad19_3 vss 1e-16
Cpt174 px_lad19_4 vss 1e-16
Cpt175 px_lad19_5 vss 1e-16
Cpt176 px_lad19_6 vss 1e-16
Cpt177 px_lad19_7 vss 1e-16
Cpt178 px_lad19_8 vss 1e-16
Cpt179 px_lad19_9 vss 1e-16
Cpt180 px_lad1_0 vss 1e-16
Cpt181 px_lad1_1 vss 1e-16
Cpt182 px_lad1_2 vss 1e-16
Cpt183 px_lad1_3 vss 1e-16
Cpt184 px_lad1_4 vss 1e-16
Cpt185 px_lad1_5 vss 1e-16
Cpt186 px_lad1_6 vss 1e-16
Cpt187 px_lad1_7 vss 1e-16
Cpt188 px_lad1_8 vss 1e-16
Cpt189 px_lad1_9 vss 1e-16
Cpt190 px_lad20_0 vss 1e-16
Cpt191 px_lad20_1 vss 1e-16
Cpt192 px_lad20_2 vss 1e-16
Cpt193 px_lad20_3 vss 1e-16
Cpt194 px_lad20_4 vss 1e-16
Cpt195 px_lad20_5 vss 1e-16
Cpt196 px_lad20_6 vss 1e-16
Cpt197 px_lad20_7 vss 1e-16
Cpt198 px_lad20_8 vss 1e-16
Cpt199 px_lad20_9 vss 1e-16
Cpt200 px_lad21_0 vss 1e-16
Cpt201 px_lad21_1 vss 1e-16
Cpt202 px_lad21_2 vss 1e-16
Cpt203 px_lad21_3 vss 1e-16
Cpt204 px_lad21_4 vss 1e-16
Cpt205 px_lad21_5 vss 1e-16
Cpt206 px_lad21_6 vss 1e-16
Cpt207 px_lad21_7 vss 1e-16
Cpt208 px_lad21_8 vss 1e-16
Cpt209 px_lad21_9 vss 1e-16
Cpt210 px_lad22_0 vss 1e-16
Cpt211 px_lad22_1 vss 1e-16
Cpt212 px_lad22_2 vss 1e-16
Cpt213 px_lad22_3 vss 1e-16
Cpt214 px_lad22_4 vss 1e-16
Cpt215 px_lad22_5 vss 1e-16
Cpt216 px_lad22_6 vss 1e-16
Cpt217 px_lad22_7 vss 1e-16
Cpt218 px_lad22_8 vss 1e-16
Cpt219 px_lad22_9 vss 1e-16
Cpt220 px_lad23_0 vss 1e-16
Cpt221 px_lad23_1 vss 1e-16
Cpt222 px_lad23_2 vss 1e-16
Cpt223 px_lad23_3 vss 1e-16
Cpt224 px_lad23_4 vss 1e-16
Cpt225 px_lad23_5 vss 1e-16
Cpt226 px_lad23_6 vss 1e-16
Cpt227 px_lad23_7 vss 1e-16
Cpt228 px_lad23_8 vss 1e-16
Cpt229 px_lad23_9 vss 1e-16
Cpt230 px_lad24_0 vss 1e-16
Cpt231 px_lad24_1 vss 1e-16
Cpt232 px_lad24_2 vss 1e-16
Cpt233 px_lad24_3 vss 1e-16
Cpt234 px_lad24_4 vss 1e-16
Cpt235 px_lad24_5 vss 1e-16
Cpt236 px_lad24_6 vss 1e-16
Cpt237 px_lad24_7 vss 1e-16
Cpt238 px_lad24_8 vss 1e-16
Cpt239 px_lad24_9 vss 1e-16
Cpt240 px_lad25_0 vss 1e-16
Cpt241 px_lad25_1 vss 1e-16
Cpt242 px_lad25_2 vss 1e-16
Cpt243 px_lad25_3 vss 1e-16
Cpt244 px_lad25_4 vss 1e-16
Cpt245 px_lad25_5 vss 1e-16
Cpt246 px_lad25_6 vss 1e-16
Cpt247 px_lad25_7 vss 1e-16
Cpt248 px_lad25_8 vss 1e-16
Cpt249 px_lad25_9 vss 1e-16
Cpt250 px_lad26_0 vss 1e-16
Cpt251 px_lad26_1 vss 1e-16
Cpt252 px_lad26_2 vss 1e-16
Cpt253 px_lad26_3 vss 1e-16
Cpt254 px_lad26_4 vss 1e-16
Cpt255 px_lad26_5 vss 1e-16
Cpt256 px_lad26_6 vss 1e-16
Cpt257 px_lad26_7 vss 1e-16
Cpt258 px_lad26_8 vss 1e-16
Cpt259 px_lad26_9 vss 1e-16
Cpt260 px_lad27_0 vss 1e-16
Cpt261 px_lad27_1 vss 1e-16
Cpt262 px_lad27_2 vss 1e-16
Cpt263 px_lad27_3 vss 1e-16
Cpt264 px_lad27_4 vss 1e-16
Cpt265 px_lad27_5 vss 1e-16
Cpt266 px_lad27_6 vss 1e-16
Cpt267 px_lad27_7 vss 1e-16
Cpt268 px_lad27_8 vss 1e-16
Cpt269 px_lad27_9 vss 1e-16
Cpt270 px_lad28_0 vss 1e-16
Cpt271 px_lad28_1 vss 1e-16
Cpt272 px_lad28_2 vss 1e-16
Cpt273 px_lad28_3 vss 1e-16
Cpt274 px_lad28_4 vss 1e-16
Cpt275 px_lad28_5 vss 1e-16
Cpt276 px_lad28_6 vss 1e-16
Cpt277 px_lad28_7 vss 1e-16
Cpt278 px_lad28_8 vss 1e-16
Cpt279 px_lad28_9 vss 1e-16
Cpt280 px_lad29_0 vss 1e-16
Cpt281 px_lad29_1 vss 1e-16
Cpt282 px_lad29_2 vss 1e-16
Cpt283 px_lad29_3 vss 1e-16
Cpt284 px_lad29_4 vss 1e-16
Cpt285 px_lad29_5 vss 1e-16
Cpt286 px_lad29_6 vss 1e-16
Cpt287 px_lad29_7 vss 1e-16
Cpt288 px_lad29_8 vss 1e-16
Cpt289 px_lad29_9 vss 1e-16
Cpt290 px_lad2_0 vss 1e-16
Cpt291 px_lad2_1 vss 1e-16
Cpt292 px_lad2_2 vss 1e-16
Cpt293 px_lad2_3 vss 1e-16
Cpt294 px_lad2_4 vss 1e-16
Cpt295 px_lad2_5 vss 1e-16
Cpt296 px_lad2_6 vss 1e-16
Cpt297 px_lad2_7 vss 1e-16
Cpt298 px_lad2_8 vss 1e-16
Cpt299 px_lad2_9 vss 1e-16
Cpt300 px_lad30_0 vss 1e-16
Cpt301 px_lad30_1 vss 1e-16
Cpt302 px_lad30_2 vss 1e-16
Cpt303 px_lad30_3 vss 1e-16
Cpt304 px_lad30_4 vss 1e-16
Cpt305 px_lad30_5 vss 1e-16
Cpt306 px_lad30_6 vss 1e-16
Cpt307 px_lad30_7 vss 1e-16
Cpt308 px_lad30_8 vss 1e-16
Cpt309 px_lad30_9 vss 1e-16
Cpt310 px_lad31_0 vss 1e-16
Cpt311 px_lad31_1 vss 1e-16
Cpt312 px_lad31_2 vss 1e-16
Cpt313 px_lad31_3 vss 1e-16
Cpt314 px_lad31_4 vss 1e-16
Cpt315 px_lad31_5 vss 1e-16
Cpt316 px_lad31_6 vss 1e-16
Cpt317 px_lad31_7 vss 1e-16
Cpt318 px_lad31_8 vss 1e-16
Cpt319 px_lad31_9 vss 1e-16
Cpt320 px_lad32_0 vss 1e-16
Cpt321 px_lad32_1 vss 1e-16
Cpt322 px_lad32_2 vss 1e-16
Cpt323 px_lad32_3 vss 1e-16
Cpt324 px_lad32_4 vss 1e-16
Cpt325 px_lad32_5 vss 1e-16
Cpt326 px_lad32_6 vss 1e-16
Cpt327 px_lad32_7 vss 1e-16
Cpt328 px_lad32_8 vss 1e-16
Cpt329 px_lad32_9 vss 1e-16
Cpt330 px_lad33_0 vss 1e-16
Cpt331 px_lad33_1 vss 1e-16
Cpt332 px_lad33_2 vss 1e-16
Cpt333 px_lad33_3 vss 1e-16
Cpt334 px_lad33_4 vss 1e-16
Cpt335 px_lad33_5 vss 1e-16
Cpt336 px_lad33_6 vss 1e-16
Cpt337 px_lad33_7 vss 1e-16
Cpt338 px_lad33_8 vss 1e-16
Cpt339 px_lad33_9 vss 1e-16
Cpt340 px_lad34_0 vss 1e-16
Cpt341 px_lad34_1 vss 1e-16
Cpt342 px_lad34_2 vss 1e-16
Cpt343 px_lad34_3 vss 1e-16
Cpt344 px_lad34_4 vss 1e-16
Cpt345 px_lad34_5 vss 1e-16
Cpt346 px_lad34_6 vss 1e-16
Cpt347 px_lad34_7 vss 1e-16
Cpt348 px_lad34_8 vss 1e-16
Cpt349 px_lad34_9 vss 1e-16
Cpt350 px_lad35_0 vss 1e-16
Cpt351 px_lad35_1 vss 1e-16
Cpt352 px_lad35_2 vss 1e-16
Cpt353 px_lad35_3 vss 1e-16
Cpt354 px_lad35_4 vss 1e-16
Cpt355 px_lad35_5 vss 1e-16
Cpt356 px_lad35_6 vss 1e-16
Cpt357 px_lad35_7 vss 1e-16
Cpt358 px_lad35_8 vss 1e-16
Cpt359 px_lad35_9 vss 1e-16
Cpt360 px_lad36_0 vss 1e-16
Cpt361 px_lad36_1 vss 1e-16
Cpt362 px_lad36_2 vss 1e-16
Cpt363 px_lad36_3 vss 1e-16
Cpt364 px_lad36_4 vss 1e-16
Cpt365 px_lad36_5 vss 1e-16
Cpt366 px_lad36_6 vss 1e-16
Cpt367 px_lad36_7 vss 1e-16
Cpt368 px_lad36_8 vss 1e-16
Cpt369 px_lad36_9 vss 1e-16
Cpt370 px_lad37_0 vss 1e-16
Cpt371 px_lad37_1 vss 1e-16
Cpt372 px_lad37_2 vss 1e-16
Cpt373 px_lad37_3 vss 1e-16
Cpt374 px_lad37_4 vss 1e-16
Cpt375 px_lad37_5 vss 1e-16
Cpt376 px_lad37_6 vss 1e-16
Cpt377 px_lad37_7 vss 1e-16
Cpt378 px_lad37_8 vss 1e-16
Cpt379 px_lad37_9 vss 1e-16
Cpt380 px_lad38_0 vss 1e-16
Cpt381 px_lad38_1 vss 1e-16
Cpt382 px_lad38_2 vss 1e-16
Cpt383 px_lad38_3 vss 1e-16
Cpt384 px_lad38_4 vss 1e-16
Cpt385 px_lad38_5 vss 1e-16
Cpt386 px_lad38_6 vss 1e-16
Cpt387 px_lad38_7 vss 1e-16
Cpt388 px_lad38_8 vss 1e-16
Cpt389 px_lad38_9 vss 1e-16
Cpt390 px_lad39_0 vss 1e-16
Cpt391 px_lad39_1 vss 1e-16
Cpt392 px_lad39_2 vss 1e-16
Cpt393 px_lad39_3 vss 1e-16
Cpt394 px_lad39_4 vss 1e-16
Cpt395 px_lad39_5 vss 1e-16
Cpt396 px_lad39_6 vss 1e-16
Cpt397 px_lad39_7 vss 1e-16
Cpt398 px_lad39_8 vss 1e-16
Cpt399 px_lad39_9 vss 1e-16
Cpt400 px_lad3_0 vss 1e-16
Cpt401 px_lad3_1 vss 1e-16
Cpt402 px_lad3_2 vss 1e-16
Cpt403 px_lad3_3 vss 1e-16
Cpt404 px_lad3_4 vss 1e-16
Cpt405 px_lad3_5 vss 1e-16
Cpt406 px_lad3_6 vss 1e-16
Cpt407 px_lad3_7 vss 1e-16
Cpt408 px_lad3_8 vss 1e-16
Cpt409 px_lad3_9 vss 1e-16
Cpt410 px_lad40_0 vss 1e-16
Cpt411 px_lad40_1 vss 1e-16
Cpt412 px_lad40_2 vss 1e-16
Cpt413 px_lad40_3 vss 1e-16
Cpt414 px_lad40_4 vss 1e-16
Cpt415 px_lad40_5 vss 1e-16
Cpt416 px_lad40_6 vss 1e-16
Cpt417 px_lad40_7 vss 1e-16
Cpt418 px_lad40_8 vss 1e-16
Cpt419 px_lad40_9 vss 1e-16
Cpt420 px_lad41_0 vss 1e-16
Cpt421 px_lad41_1 vss 1e-16
Cpt422 px_lad41_2 vss 1e-16
Cpt423 px_lad41_3 vss 1e-16
Cpt424 px_lad41_4 vss 1e-16
Cpt425 px_lad41_5 vss 1e-16
Cpt426 px_lad41_6 vss 1e-16
Cpt427 px_lad41_7 vss 1e-16
Cpt428 px_lad41_8 vss 1e-16
Cpt429 px_lad41_9 vss 1e-16
Cpt430 px_lad42_0 vss 1e-16
Cpt431 px_lad42_1 vss 1e-16
Cpt432 px_lad42_2 vss 1e-16
Cpt433 px_lad42_3 vss 1e-16
Cpt434 px_lad42_4 vss 1e-16
Cpt435 px_lad42_5 vss 1e-16
Cpt436 px_lad42_6 vss 1e-16
Cpt437 px_lad42_7 vss 1e-16
Cpt438 px_lad42_8 vss 1e-16
Cpt439 px_lad42_9 vss 1e-16
Cpt440 px_lad43_0 vss 1e-16
Cpt441 px_lad43_1 vss 1e-16
Cpt442 px_lad43_2 vss 1e-16
Cpt443 px_lad43_3 vss 1e-16
Cpt444 px_lad43_4 vss 1e-16
Cpt445 px_lad43_5 vss 1e-16
Cpt446 px_lad43_6 vss 1e-16
Cpt447 px_lad43_7 vss 1e-16
Cpt448 px_lad43_8 vss 1e-16
Cpt449 px_lad43_9 vss 1e-16
Cpt450 px_lad44_0 vss 1e-16
Cpt451 px_lad44_1 vss 1e-16
Cpt452 px_lad44_2 vss 1e-16
Cpt453 px_lad44_3 vss 1e-16
Cpt454 px_lad44_4 vss 1e-16
Cpt455 px_lad44_5 vss 1e-16
Cpt456 px_lad44_6 vss 1e-16
Cpt457 px_lad44_7 vss 1e-16
Cpt458 px_lad44_8 vss 1e-16
Cpt459 px_lad44_9 vss 1e-16
Cpt460 px_lad45_0 vss 1e-16
Cpt461 px_lad45_1 vss 1e-16
Cpt462 px_lad45_2 vss 1e-16
Cpt463 px_lad45_3 vss 1e-16
Cpt464 px_lad45_4 vss 1e-16
Cpt465 px_lad45_5 vss 1e-16
Cpt466 px_lad45_6 vss 1e-16
Cpt467 px_lad45_7 vss 1e-16
Cpt468 px_lad45_8 vss 1e-16
Cpt469 px_lad45_9 vss 1e-16
Cpt470 px_lad46_0 vss 1e-16
Cpt471 px_lad46_1 vss 1e-16
Cpt472 px_lad46_2 vss 1e-16
Cpt473 px_lad46_3 vss 1e-16
Cpt474 px_lad46_4 vss 1e-16
Cpt475 px_lad46_5 vss 1e-16
Cpt476 px_lad46_6 vss 1e-16
Cpt477 px_lad46_7 vss 1e-16
Cpt478 px_lad46_8 vss 1e-16
Cpt479 px_lad46_9 vss 1e-16
Cpt480 px_lad47_0 vss 1e-16
Cpt481 px_lad47_1 vss 1e-16
Cpt482 px_lad47_2 vss 1e-16
Cpt483 px_lad47_3 vss 1e-16
Cpt484 px_lad47_4 vss 1e-16
Cpt485 px_lad47_5 vss 1e-16
Cpt486 px_lad47_6 vss 1e-16
Cpt487 px_lad47_7 vss 1e-16
Cpt488 px_lad47_8 vss 1e-16
Cpt489 px_lad47_9 vss 1e-16
Cpt490 px_lad48_0 vss 1e-16
Cpt491 px_lad48_1 vss 1e-16
Cpt492 px_lad48_2 vss 1e-16
Cpt493 px_lad48_3 vss 1e-16
Cpt494 px_lad48_4 vss 1e-16
Cpt495 px_lad48_5 vss 1e-16
Cpt496 px_lad48_6 vss 1e-16
Cpt497 px_lad48_7 vss 1e-16
Cpt498 px_lad48_8 vss 1e-16
Cpt499 px_lad48_9 vss 1e-16
Cpt500 px_lad49_0 vss 1e-16
Cpt501 px_lad49_1 vss 1e-16
Cpt502 px_lad49_2 vss 1e-16
Cpt503 px_lad49_3 vss 1e-16
Cpt504 px_lad49_4 vss 1e-16
Cpt505 px_lad49_5 vss 1e-16
Cpt506 px_lad49_6 vss 1e-16
Cpt507 px_lad49_7 vss 1e-16
Cpt508 px_lad49_8 vss 1e-16
Cpt509 px_lad49_9 vss 1e-16
Cpt510 px_lad4_0 vss 1e-16
Cpt511 px_lad4_1 vss 1e-16
Cpt512 px_lad4_2 vss 1e-16
Cpt513 px_lad4_3 vss 1e-16
Cpt514 px_lad4_4 vss 1e-16
Cpt515 px_lad4_5 vss 1e-16
Cpt516 px_lad4_6 vss 1e-16
Cpt517 px_lad4_7 vss 1e-16
Cpt518 px_lad4_8 vss 1e-16
Cpt519 px_lad4_9 vss 1e-16
Cpt520 px_lad5_0 vss 1e-16
Cpt521 px_lad5_1 vss 1e-16
Cpt522 px_lad5_2 vss 1e-16
Cpt523 px_lad5_3 vss 1e-16
Cpt524 px_lad5_4 vss 1e-16
Cpt525 px_lad5_5 vss 1e-16
Cpt526 px_lad5_6 vss 1e-16
Cpt527 px_lad5_7 vss 1e-16
Cpt528 px_lad5_8 vss 1e-16
Cpt529 px_lad5_9 vss 1e-16
Cpt530 px_lad6_0 vss 1e-16
Cpt531 px_lad6_1 vss 1e-16
Cpt532 px_lad6_2 vss 1e-16
Cpt533 px_lad6_3 vss 1e-16
Cpt534 px_lad6_4 vss 1e-16
Cpt535 px_lad6_5 vss 1e-16
Cpt536 px_lad6_6 vss 1e-16
Cpt537 px_lad6_7 vss 1e-16
Cpt538 px_lad6_8 vss 1e-16
Cpt539 px_lad6_9 vss 1e-16
Cpt540 px_lad7_0 vss 1e-16
Cpt541 px_lad7_1 vss 1e-16
Cpt542 px_lad7_2 vss 1e-16
Cpt543 px_lad7_3 vss 1e-16
Cpt544 px_lad7_4 vss 1e-16
Cpt545 px_lad7_5 vss 1e-16
Cpt546 px_lad7_6 vss 1e-16
Cpt547 px_lad7_7 vss 1e-16
Cpt548 px_lad7_8 vss 1e-16
Cpt549 px_lad7_9 vss 1e-16
Cpt550 px_lad8_0 vss 1e-16
Cpt551 px_lad8_1 vss 1e-16
Cpt552 px_lad8_2 vss 1e-16
Cpt553 px_lad8_3 vss 1e-16
Cpt554 px_lad8_4 vss 1e-16
Cpt555 px_lad8_5 vss 1e-16
Cpt556 px_lad8_6 vss 1e-16
Cpt557 px_lad8_7 vss 1e-16
Cpt558 px_lad8_8 vss 1e-16
Cpt559 px_lad8_9 vss 1e-16
Cpt560 px_lad9_0 vss 1e-16
Cpt561 px_lad9_1 vss 1e-16
Cpt562 px_lad9_2 vss 1e-16
Cpt563 px_lad9_3 vss 1e-16
Cpt564 px_lad9_4 vss 1e-16
Cpt565 px_lad9_5 vss 1e-16
Cpt566 px_lad9_6 vss 1e-16
Cpt567 px_lad9_7 vss 1e-16
Cpt568 px_lad9_8 vss 1e-16
Cpt569 px_lad9_9 vss 1e-16
Cpt570 sar_mclk vbn 2.64e-16
Cpt571 sar_mclk vbp 3.363e-16
Cpt572 sar_mclk vdd 6.254e-16
Cpt573 sar_mclk vdda 2.78e-16
Cpt574 sar_mclk vref 2.82e-16
Cpt575 sar_mclk vref_in 6.785e-16
Cpt576 sar_mclk vss 9.2332e-15
Cpt577 sar_mclk xcbias_xrb_s1 2.49e-16
Cpt578 sar_mclk xcbias_xrb_s2 1.02e-15
Cpt579 sar_mclk xcbias_xrb_s3 1.041e-15
Cpt580 sar_mclk xcbiasn_xrb_s1 4.03e-16
Cpt581 sar_mclk xcbiasn_xrb_s2 4.554e-16
Cpt582 sar_mclk xcbiasn_xrb_s3 1.8e-16
Cpt583 sar_mclk xckg_d0 3.91e-16
Cpt584 sar_mclk xckg_d1 1.997e-16
Cpt585 sar_mclk xckg_d2 1.2706e-15
Cpt586 sar_mclk xckg_d3 8.236e-16
Cpt587 sar_mclk xckg_nn 2.457e-16
Cpt588 sar_mclk xckg_x 6.77e-16
Cpt589 sar_mclk xref_na 4.36e-16
Cpt590 sar_mclk xref_ng 2.02e-16
Cpt591 sar_mclk xref_ntl 3.68e-16
Cpt592 vbn vbp 1.852e-16
Cpt593 vbn vdd 3.3e-16
Cpt594 vbn vdda 9.77e-16
Cpt595 vbn vref 4.704e-16
Cpt596 vbn vref_in 5.12e-17
Cpt597 vbn vrefl 9.008e-16
Cpt598 vbn vss 1.3062e-14
Cpt599 vbn xcbias_xrb_s1 3.033e-16
Cpt600 vbn xcbias_xrb_s2 6.697e-16
Cpt601 vbn xcbias_xrb_s3 4.97e-16
Cpt602 vbn xcbiasn_xrb_s1 1.0144e-15
Cpt603 vbn xcbiasn_xrb_s2 3.084e-16
Cpt604 vbn xcbiasn_xrb_s3 4.454e-16
Cpt605 vbn xckg_d0 4.107e-16
Cpt606 vbn xckg_d1 4.91e-16
Cpt607 vbn xckg_d2 2.99e-16
Cpt608 vbn xckg_d3 4.98e-16
Cpt609 vbn xckg_nn 1.34e-16
Cpt610 vbn xckg_x 1.593e-16
Cpt611 vbn xref_na 4.57e-16
Cpt612 vbn xref_ng 7.39e-16
Cpt613 vbn xref_ntl 1.85e-16
Cpt614 vbp vdd 4.17e-16
Cpt615 vbp vdda 6.03e-16
Cpt616 vbp vref 3.53e-16
Cpt617 vbp vref_in 1.86e-16
Cpt618 vbp vrefl 6.9e-16
Cpt619 vbp vss 1.0818e-14
Cpt620 vbp xcbias_xrb_s1 5.84e-16
Cpt621 vbp xcbias_xrb_s2 5.34e-17
Cpt622 vbp xcbias_xrb_s3 1.224e-15
Cpt623 vbp xcbiasn_xrb_s1 1.1525e-15
Cpt624 vbp xcbiasn_xrb_s3 3.12e-17
Cpt625 vbp xckg_d0 6.88e-16
Cpt626 vbp xckg_d2 1.33e-16
Cpt627 vbp xckg_d3 3.86e-16
Cpt628 vbp xckg_nn 6.46e-16
Cpt629 vbp xckg_x 1.3e-16
Cpt630 vbp xref_na 6.78e-17
Cpt631 vbp xref_ng 6.849e-16
Cpt632 vdd vdda 2.44e-16
Cpt633 vdd vref 1.89e-16
Cpt634 vdd vref_in 2.567e-16
Cpt635 vdd vrefl 6.32e-17
Cpt636 vdd vss 1.5768e-14
Cpt637 vdd xcbias_xrb_s1 7.763e-16
Cpt638 vdd xcbias_xrb_s2 4.96e-16
Cpt639 vdd xcbiasn_xrb_s2 2.6517e-15
Cpt640 vdd xcbiasn_xrb_s3 2.49e-16
Cpt641 vdd xckg_d0 7.946e-16
Cpt642 vdd xckg_d3 9.77e-17
Cpt643 vdd xckg_nn 1.6e-16
Cpt644 vdd xckg_x 5.401e-16
Cpt645 vdd xref_na 2.79e-16
Cpt646 vdd xref_ng 2.684e-16
Cpt647 vdd xref_ntl 1.61e-16
Cpt648 vdda vref 2.999e-16
Cpt649 vdda vref_in 6.14e-16
Cpt650 vdda vrefl 7.752e-16
Cpt651 vdda vss 7.799e-15
Cpt652 vdda xcbias_xrb_s1 5.38e-16
Cpt653 vdda xcbias_xrb_s2 1.584e-16
Cpt654 vdda xcbias_xrb_s3 5.842e-16
Cpt655 vdda xcbiasn_xrb_s1 9.85e-17
Cpt656 vdda xcbiasn_xrb_s2 9.136e-16
Cpt657 vdda xcbiasn_xrb_s3 7.59e-16
Cpt658 vdda xckg_d1 9.28e-16
Cpt659 vdda xckg_d2 4.58e-16
Cpt660 vdda xckg_d3 1.915e-16
Cpt661 vdda xckg_nn 6.1e-16
Cpt662 vdda xckg_x 2.1e-16
Cpt663 vdda xref_na 2.316e-15
Cpt664 vdda xref_ng 1.99e-16
Cpt665 vdda xref_ntl 3.79e-17
Cpt666 vref vref_in 1.76e-16
Cpt667 vref vss 7.0248e-15
Cpt668 vref xcbias_xrb_s1 2.2e-16
Cpt669 vref xcbias_xrb_s2 5.08e-16
Cpt670 vref xcbias_xrb_s3 1.69e-16
Cpt671 vref xcbiasn_xrb_s1 1.1916e-15
Cpt672 vref xcbiasn_xrb_s2 1.778e-16
Cpt673 vref xcbiasn_xrb_s3 1.95e-16
Cpt674 vref xckg_d1 6.319e-16
Cpt675 vref xckg_d2 9.84e-16
Cpt676 vref xckg_d3 2.79e-16
Cpt677 vref xckg_nn 8.16e-16
Cpt678 vref xckg_x 2.28e-16
Cpt679 vref xref_na 8.258e-16
Cpt680 vref xref_ng 4.83e-16
Cpt681 vref xref_ntl 5.999e-16
Cpt682 vref_in vrefl 1.3412e-15
Cpt683 vref_in vss 8.1237e-15
Cpt684 vref_in xcbias_xrb_s1 1.0387e-15
Cpt685 vref_in xcbias_xrb_s2 1.735e-15
Cpt686 vref_in xcbias_xrb_s3 9.93e-16
Cpt687 vref_in xcbiasn_xrb_s1 1.771e-16
Cpt688 vref_in xcbiasn_xrb_s2 1.2079e-15
Cpt689 vref_in xcbiasn_xrb_s3 6.74e-16
Cpt690 vref_in xckg_d0 3.48e-16
Cpt691 vref_in xckg_d1 5.92e-17
Cpt692 vref_in xckg_d2 5.38e-16
Cpt693 vref_in xckg_d3 5.99e-16
Cpt694 vref_in xckg_nn 6.101e-16
Cpt695 vref_in xckg_x 1.053e-15
Cpt696 vref_in xref_na 5.81e-16
Cpt697 vref_in xref_ng 2.571e-16
Cpt698 vref_in xref_ntl 2.713e-16
Cpt699 vrefl vss 1.33e-14
Cpt700 vrefl xcbias_xrb_s1 1.322e-15
Cpt701 vrefl xcbias_xrb_s2 1.15e-15
Cpt702 vrefl xcbias_xrb_s3 9.11e-17
Cpt703 vrefl xcbiasn_xrb_s1 3.48e-16
Cpt704 vrefl xckg_d0 6.028e-16
Cpt705 vrefl xckg_d1 2.511e-16
Cpt706 vrefl xckg_d2 1.328e-16
Cpt707 vrefl xckg_d3 6.64e-16
Cpt708 vrefl xckg_nn 7.074e-16
Cpt709 vrefl xckg_x 9.17e-16
Cpt710 vrefl xref_na 4.66e-16
Cpt711 vrefl xref_ng 7.258e-16
Cpt712 vrefl xref_ntl 2.64e-16
Cpt713 vss xcbias_xrb_s1 5.4792e-15
Cpt714 vss xcbias_xrb_s2 8.4665e-15
Cpt715 vss xcbias_xrb_s3 9.4649e-15
Cpt716 vss xcbiasn_xrb_s1 9.9862e-15
Cpt717 vss xcbiasn_xrb_s2 1.1112e-14
Cpt718 vss xcbiasn_xrb_s3 1.1496e-14
Cpt719 vss xckg_d0 5.8766e-15
Cpt720 vss xckg_d1 9.229e-15
Cpt721 vss xckg_d2 1.2092e-14
Cpt722 vss xckg_d3 1.0663e-14
Cpt723 vss xckg_nn 8.8254e-15
Cpt724 vss xckg_x 8.6463e-15
Cpt725 vss xref_na 6.9751e-15
Cpt726 vss xref_ng 1.2608e-14
Cpt727 vss xref_ntl 1.0793e-14
Cpt728 xcbias_xrb_s1 xcbias_xrb_s2 5.72e-16
Cpt729 xcbias_xrb_s1 xcbias_xrb_s3 2.65e-16
Cpt730 xcbias_xrb_s1 xcbiasn_xrb_s1 6.899e-16
Cpt731 xcbias_xrb_s1 xcbiasn_xrb_s2 1e-16
Cpt732 xcbias_xrb_s1 xcbiasn_xrb_s3 4.157e-16
Cpt733 xcbias_xrb_s1 xckg_d1 4.05e-16
Cpt734 xcbias_xrb_s1 xckg_d2 1.36e-16
Cpt735 xcbias_xrb_s1 xckg_d3 3.56e-16
Cpt736 xcbias_xrb_s1 xckg_nn 1.485e-16
Cpt737 xcbias_xrb_s1 xckg_x 4.206e-16
Cpt738 xcbias_xrb_s1 xref_na 4e-16
Cpt739 xcbias_xrb_s1 xref_ng 3.367e-16
Cpt740 xcbias_xrb_s1 xref_ntl 3.52e-16
Cpt741 xcbias_xrb_s2 xcbias_xrb_s3 1.5e-16
Cpt742 xcbias_xrb_s2 xcbiasn_xrb_s2 5.83e-17
Cpt743 xcbias_xrb_s2 xcbiasn_xrb_s3 2.82e-17
Cpt744 xcbias_xrb_s2 xckg_d0 9.64e-16
Cpt745 xcbias_xrb_s2 xckg_d2 5.305e-16
Cpt746 xcbias_xrb_s2 xckg_d3 1.011e-15
Cpt747 xcbias_xrb_s2 xckg_nn 8.82e-16
Cpt748 xcbias_xrb_s2 xckg_x 8.05e-16
Cpt749 xcbias_xrb_s2 xref_na 1.2828e-15
Cpt750 xcbias_xrb_s2 xref_ng 4.16e-16
Cpt751 xcbias_xrb_s2 xref_ntl 8.865e-16
Cpt752 xcbias_xrb_s3 xcbiasn_xrb_s1 7.93e-17
Cpt753 xcbias_xrb_s3 xcbiasn_xrb_s3 2.53e-16
Cpt754 xcbias_xrb_s3 xckg_d1 1.952e-16
Cpt755 xcbias_xrb_s3 xckg_d2 4.445e-16
Cpt756 xcbias_xrb_s3 xckg_d3 6.71e-16
Cpt757 xcbias_xrb_s3 xckg_nn 3.97e-16
Cpt758 xcbias_xrb_s3 xckg_x 3.92e-17
Cpt759 xcbias_xrb_s3 xref_na 6.06e-16
Cpt760 xcbias_xrb_s3 xref_ng 5.311e-16
Cpt761 xcbias_xrb_s3 xref_ntl 4.87e-17
Cpt762 xcbiasn_xrb_s1 xcbiasn_xrb_s2 1.0082e-15
Cpt763 xcbiasn_xrb_s1 xcbiasn_xrb_s3 3.46e-16
Cpt764 xcbiasn_xrb_s1 xckg_d0 6.41e-16
Cpt765 xcbiasn_xrb_s1 xckg_d1 7.618e-16
Cpt766 xcbiasn_xrb_s1 xckg_d2 2.023e-16
Cpt767 xcbiasn_xrb_s1 xckg_d3 4.79e-16
Cpt768 xcbiasn_xrb_s1 xckg_nn 2.695e-16
Cpt769 xcbiasn_xrb_s1 xckg_x 5.36e-16
Cpt770 xcbiasn_xrb_s1 xref_na 9.38e-16
Cpt771 xcbiasn_xrb_s1 xref_ng 1.5e-16
Cpt772 xcbiasn_xrb_s1 xref_ntl 9.37e-16
Cpt773 xcbiasn_xrb_s2 xcbiasn_xrb_s3 7.01e-17
Cpt774 xcbiasn_xrb_s2 xckg_d0 7.08e-17
Cpt775 xcbiasn_xrb_s2 xckg_d1 4.484e-16
Cpt776 xcbiasn_xrb_s2 xckg_d2 5.15e-16
Cpt777 xcbiasn_xrb_s2 xckg_d3 4.539e-16
Cpt778 xcbiasn_xrb_s2 xckg_nn 5.931e-16
Cpt779 xcbiasn_xrb_s2 xckg_x 2.5e-16
Cpt780 xcbiasn_xrb_s2 xref_na 1.6086e-15
Cpt781 xcbiasn_xrb_s2 xref_ng 1.0518e-15
Cpt782 xcbiasn_xrb_s2 xref_ntl 5.07e-16
Cpt783 xcbiasn_xrb_s3 xckg_d0 4.16e-16
Cpt784 xcbiasn_xrb_s3 xckg_d1 6.5e-16
Cpt785 xcbiasn_xrb_s3 xckg_d2 5.37e-16
Cpt786 xcbiasn_xrb_s3 xckg_d3 3.21e-16
Cpt787 xcbiasn_xrb_s3 xckg_nn 1.941e-16
Cpt788 xcbiasn_xrb_s3 xckg_x 9.317e-16
Cpt789 xcbiasn_xrb_s3 xref_na 1.537e-15
Cpt790 xcbiasn_xrb_s3 xref_ng 2.81e-16
Cpt791 xcbiasn_xrb_s3 xref_ntl 3e-16
Cpt792 xckg_d0 xckg_d2 4.39e-16
Cpt793 xckg_d0 xckg_d3 7.375e-16
Cpt794 xckg_d0 xckg_nn 1.5869e-15
Cpt795 xckg_d0 xckg_x 7.39e-16
Cpt796 xckg_d0 xref_na 4.702e-16
Cpt797 xckg_d0 xref_ng 1.022e-15
Cpt798 xckg_d0 xref_ntl 2.58e-16
Cpt799 xckg_d1 xckg_d2 1.32e-16
Cpt800 xckg_d1 xckg_d3 3.08e-16
Cpt801 xckg_d1 xckg_nn 2.24e-16
Cpt802 xckg_d1 xckg_x 6.44e-16
Cpt803 xckg_d1 xref_na 6.5e-17
Cpt804 xckg_d1 xref_ng 8.152e-16
Cpt805 xckg_d2 xckg_d3 2.52e-16
Cpt806 xckg_d2 xckg_nn 7.16e-16
Cpt807 xckg_d2 xckg_x 5.94e-16
Cpt808 xckg_d2 xref_na 3.636e-16
Cpt809 xckg_d2 xref_ntl 9.9e-17
Cpt810 xckg_d3 xckg_nn 2.486e-16
Cpt811 xckg_d3 xckg_x 4.639e-16
Cpt812 xckg_d3 xref_na 5.48e-16
Cpt813 xckg_d3 xref_ng 7.914e-16
Cpt814 xckg_d3 xref_ntl 2.51e-16
Cpt815 xckg_nn xckg_x 8.66e-17
Cpt816 xckg_nn xref_na 4.687e-16
Cpt817 xckg_nn xref_ng 3.786e-16
Cpt818 xckg_nn xref_ntl 6.65e-16
Cpt819 xckg_x xref_na 8.032e-16
Cpt820 xckg_x xref_ng 1.7827e-15
Cpt821 xckg_x xref_ntl 2.131e-16
Cpt822 xref_na xref_ng 3.28e-16
Cpt823 xref_na xref_ntl 5.46e-16
Cpt824 xref_ng xref_ntl 1.5821e-15
Rpt0 xckg_x px_lad0_0 15.8
Rpt1 px_lad0_0 px_lad0_1 3.34
Rpt2 px_lad0_1 px_lad0_2 7.83
Rpt3 px_lad0_2 px_lad0_3 17.4
Rpt4 px_lad0_3 px_lad0_4 1.91
Rpt5 px_lad0_4 px_lad0_5 2.42
Rpt6 px_lad0_5 px_lad0_6 5.31
Rpt7 px_lad0_6 px_lad0_7 7.68
Rpt8 px_lad0_7 px_lad0_8 12.5
Rpt9 px_lad0_8 px_lad0_9 19.9
Rpt10 xcbiasn_xrb_s1 px_lad1_0 19.4
Rpt11 px_lad1_0 px_lad1_1 9.84
Rpt12 px_lad1_1 px_lad1_2 3.76
Rpt13 px_lad1_2 px_lad1_3 4.3
Rpt14 px_lad1_3 px_lad1_4 13.5
Rpt15 px_lad1_4 px_lad1_5 3.99
Rpt16 px_lad1_5 px_lad1_6 7.94
Rpt17 px_lad1_6 px_lad1_7 17
Rpt18 px_lad1_7 px_lad1_8 11.6
Rpt19 px_lad1_8 px_lad1_9 2.63
Rpt20 xref_ng px_lad2_0 18.5
Rpt21 px_lad2_0 px_lad2_1 12.2
Rpt22 px_lad2_1 px_lad2_2 17.5
Rpt23 px_lad2_2 px_lad2_3 16.1
Rpt24 px_lad2_3 px_lad2_4 8.84
Rpt25 px_lad2_4 px_lad2_5 16.5
Rpt26 px_lad2_5 px_lad2_6 17.6
Rpt27 px_lad2_6 px_lad2_7 8.04
Rpt28 px_lad2_7 px_lad2_8 5.87
Rpt29 px_lad2_8 px_lad2_9 8.77
Rpt30 vref px_lad3_0 12.8
Rpt31 px_lad3_0 px_lad3_1 10.1
Rpt32 px_lad3_1 px_lad3_2 3.77
Rpt33 px_lad3_2 px_lad3_3 19.5
Rpt34 px_lad3_3 px_lad3_4 18
Rpt35 px_lad3_4 px_lad3_5 17.8
Rpt36 px_lad3_5 px_lad3_6 17.4
Rpt37 px_lad3_6 px_lad3_7 4.66
Rpt38 px_lad3_7 px_lad3_8 15
Rpt39 px_lad3_8 px_lad3_9 9.22
Rpt40 xcbiasn_xrb_s1 px_lad4_0 15.2
Rpt41 px_lad4_0 px_lad4_1 14.7
Rpt42 px_lad4_1 px_lad4_2 13.8
Rpt43 px_lad4_2 px_lad4_3 10.7
Rpt44 px_lad4_3 px_lad4_4 14.8
Rpt45 px_lad4_4 px_lad4_5 11.9
Rpt46 px_lad4_5 px_lad4_6 19.7
Rpt47 px_lad4_6 px_lad4_7 3.58
Rpt48 px_lad4_7 px_lad4_8 1.16
Rpt49 px_lad4_8 px_lad4_9 7.01
Rpt50 xckg_d0 px_lad5_0 7.61
Rpt51 px_lad5_0 px_lad5_1 9.95
Rpt52 px_lad5_1 px_lad5_2 11.1
Rpt53 px_lad5_2 px_lad5_3 13.8
Rpt54 px_lad5_3 px_lad5_4 16.3
Rpt55 px_lad5_4 px_lad5_5 14.1
Rpt56 px_lad5_5 px_lad5_6 7.37
Rpt57 px_lad5_6 px_lad5_7 19.6
Rpt58 px_lad5_7 px_lad5_8 2.01
Rpt59 px_lad5_8 px_lad5_9 9.24
Rpt60 xcbiasn_xrb_s3 px_lad6_0 17.2
Rpt61 px_lad6_0 px_lad6_1 6.89
Rpt62 px_lad6_1 px_lad6_2 9.07
Rpt63 px_lad6_2 px_lad6_3 11.3
Rpt64 px_lad6_3 px_lad6_4 9.5
Rpt65 px_lad6_4 px_lad6_5 5.67
Rpt66 px_lad6_5 px_lad6_6 19.9
Rpt67 px_lad6_6 px_lad6_7 5.12
Rpt68 px_lad6_7 px_lad6_8 17
Rpt69 px_lad6_8 px_lad6_9 3.07
Rpt70 xcbias_xrb_s3 px_lad7_0 7
Rpt71 px_lad7_0 px_lad7_1 15.9
Rpt72 px_lad7_1 px_lad7_2 15
Rpt73 px_lad7_2 px_lad7_3 16.8
Rpt74 px_lad7_3 px_lad7_4 14.1
Rpt75 px_lad7_4 px_lad7_5 12.4
Rpt76 px_lad7_5 px_lad7_6 18.3
Rpt77 px_lad7_6 px_lad7_7 10.4
Rpt78 px_lad7_7 px_lad7_8 16.2
Rpt79 px_lad7_8 px_lad7_9 13.9
Rpt80 xcbiasn_xrb_s2 px_lad8_0 1.94
Rpt81 px_lad8_0 px_lad8_1 4.1
Rpt82 px_lad8_1 px_lad8_2 18.8
Rpt83 px_lad8_2 px_lad8_3 2.17
Rpt84 px_lad8_3 px_lad8_4 16.2
Rpt85 px_lad8_4 px_lad8_5 2.9
Rpt86 px_lad8_5 px_lad8_6 19.1
Rpt87 px_lad8_6 px_lad8_7 1.19
Rpt88 px_lad8_7 px_lad8_8 7.66
Rpt89 px_lad8_8 px_lad8_9 3.76
Rpt90 clk px_lad9_0 2.3
Rpt91 px_lad9_0 px_lad9_1 17.8
Rpt92 px_lad9_1 px_lad9_2 19.2
Rpt93 px_lad9_2 px_lad9_3 14.4
Rpt94 px_lad9_3 px_lad9_4 9.91
Rpt95 px_lad9_4 px_lad9_5 17.8
Rpt96 px_lad9_5 px_lad9_6 10.1
Rpt97 px_lad9_6 px_lad9_7 11.2
Rpt98 px_lad9_7 px_lad9_8 15.8
Rpt99 px_lad9_8 px_lad9_9 12.8
Rpt100 vss px_lad10_0 17.7
Rpt101 px_lad10_0 px_lad10_1 11.4
Rpt102 px_lad10_1 px_lad10_2 11.6
Rpt103 px_lad10_2 px_lad10_3 2.25
Rpt104 px_lad10_3 px_lad10_4 2.41
Rpt105 px_lad10_4 px_lad10_5 15.4
Rpt106 px_lad10_5 px_lad10_6 12.9
Rpt107 px_lad10_6 px_lad10_7 14.5
Rpt108 px_lad10_7 px_lad10_8 14.5
Rpt109 px_lad10_8 px_lad10_9 14
Rpt110 xcbias_xrb_s1 px_lad11_0 19.4
Rpt111 px_lad11_0 px_lad11_1 12.5
Rpt112 px_lad11_1 px_lad11_2 12.7
Rpt113 px_lad11_2 px_lad11_3 12.5
Rpt114 px_lad11_3 px_lad11_4 5.76
Rpt115 px_lad11_4 px_lad11_5 4.72
Rpt116 px_lad11_5 px_lad11_6 10.3
Rpt117 px_lad11_6 px_lad11_7 15.1
Rpt118 px_lad11_7 px_lad11_8 18.6
Rpt119 px_lad11_8 px_lad11_9 3.23
Rpt120 mclkb px_lad12_0 14.1
Rpt121 px_lad12_0 px_lad12_1 14.7
Rpt122 px_lad12_1 px_lad12_2 4.56
Rpt123 px_lad12_2 px_lad12_3 19.2
Rpt124 px_lad12_3 px_lad12_4 3.22
Rpt125 px_lad12_4 px_lad12_5 15.1
Rpt126 px_lad12_5 px_lad12_6 1.7
Rpt127 px_lad12_6 px_lad12_7 12.5
Rpt128 px_lad12_7 px_lad12_8 5.02
Rpt129 px_lad12_8 px_lad12_9 14.2
Rpt130 xckg_nn px_lad13_0 19
Rpt131 px_lad13_0 px_lad13_1 3.46
Rpt132 px_lad13_1 px_lad13_2 15.1
Rpt133 px_lad13_2 px_lad13_3 11.8
Rpt134 px_lad13_3 px_lad13_4 17.6
Rpt135 px_lad13_4 px_lad13_5 2.14
Rpt136 px_lad13_5 px_lad13_6 4.95
Rpt137 px_lad13_6 px_lad13_7 6.21
Rpt138 px_lad13_7 px_lad13_8 1.21
Rpt139 px_lad13_8 px_lad13_9 16.7
Rpt140 xckg_nn px_lad14_0 13.9
Rpt141 px_lad14_0 px_lad14_1 18.7
Rpt142 px_lad14_1 px_lad14_2 7.95
Rpt143 px_lad14_2 px_lad14_3 14.5
Rpt144 px_lad14_3 px_lad14_4 19.8
Rpt145 px_lad14_4 px_lad14_5 19.9
Rpt146 px_lad14_5 px_lad14_6 5.74
Rpt147 px_lad14_6 px_lad14_7 6.12
Rpt148 px_lad14_7 px_lad14_8 13.8
Rpt149 px_lad14_8 px_lad14_9 18.2
Rpt150 xcbias_xrb_s1 px_lad15_0 10.9
Rpt151 px_lad15_0 px_lad15_1 2.44
Rpt152 px_lad15_1 px_lad15_2 15.8
Rpt153 px_lad15_2 px_lad15_3 19.4
Rpt154 px_lad15_3 px_lad15_4 18.2
Rpt155 px_lad15_4 px_lad15_5 4.54
Rpt156 px_lad15_5 px_lad15_6 4.38
Rpt157 px_lad15_6 px_lad15_7 15.6
Rpt158 px_lad15_7 px_lad15_8 11.4
Rpt159 px_lad15_8 px_lad15_9 10.6
Rpt160 xref_ntl px_lad16_0 6.2
Rpt161 px_lad16_0 px_lad16_1 5.19
Rpt162 px_lad16_1 px_lad16_2 11.9
Rpt163 px_lad16_2 px_lad16_3 8.01
Rpt164 px_lad16_3 px_lad16_4 3.66
Rpt165 px_lad16_4 px_lad16_5 7.14
Rpt166 px_lad16_5 px_lad16_6 11.6
Rpt167 px_lad16_6 px_lad16_7 7.73
Rpt168 px_lad16_7 px_lad16_8 3.56
Rpt169 px_lad16_8 px_lad16_9 4.42
Rpt170 vbn px_lad17_0 8.45
Rpt171 px_lad17_0 px_lad17_1 9.67
Rpt172 px_lad17_1 px_lad17_2 16.9
Rpt173 px_lad17_2 px_lad17_3 12.7
Rpt174 px_lad17_3 px_lad17_4 13.4
Rpt175 px_lad17_4 px_lad17_5 6.14
Rpt176 px_lad17_5 px_lad17_6 1.78
Rpt177 px_lad17_6 px_lad17_7 5.3
Rpt178 px_lad17_7 px_lad17_8 8.87
Rpt179 px_lad17_8 px_lad17_9 3.19
Rpt180 xckg_x px_lad18_0 18.6
Rpt181 px_lad18_0 px_lad18_1 18.5
Rpt182 px_lad18_1 px_lad18_2 10.2
Rpt183 px_lad18_2 px_lad18_3 1.53
Rpt184 px_lad18_3 px_lad18_4 19.4
Rpt185 px_lad18_4 px_lad18_5 6.84
Rpt186 px_lad18_5 px_lad18_6 13.7
Rpt187 px_lad18_6 px_lad18_7 16.9
Rpt188 px_lad18_7 px_lad18_8 18.2
Rpt189 px_lad18_8 px_lad18_9 11.2
Rpt190 xcbiasn_xrb_s2 px_lad19_0 1.87
Rpt191 px_lad19_0 px_lad19_1 16.8
Rpt192 px_lad19_1 px_lad19_2 8.64
Rpt193 px_lad19_2 px_lad19_3 5.66
Rpt194 px_lad19_3 px_lad19_4 3.91
Rpt195 px_lad19_4 px_lad19_5 6.81
Rpt196 px_lad19_5 px_lad19_6 3.13
Rpt197 px_lad19_6 px_lad19_7 7.03
Rpt198 px_lad19_7 px_lad19_8 18.5
Rpt199 px_lad19_8 px_lad19_9 3.12
Rpt200 vbp px_lad20_0 1.25
Rpt201 px_lad20_0 px_lad20_1 3.15
Rpt202 px_lad20_1 px_lad20_2 2.37
Rpt203 px_lad20_2 px_lad20_3 11.7
Rpt204 px_lad20_3 px_lad20_4 15.4
Rpt205 px_lad20_4 px_lad20_5 13
Rpt206 px_lad20_5 px_lad20_6 3.74
Rpt207 px_lad20_6 px_lad20_7 17
Rpt208 px_lad20_7 px_lad20_8 14.3
Rpt209 px_lad20_8 px_lad20_9 19.4
Rpt210 ibias px_lad21_0 14.3
Rpt211 px_lad21_0 px_lad21_1 11.8
Rpt212 px_lad21_1 px_lad21_2 10.9
Rpt213 px_lad21_2 px_lad21_3 3.59
Rpt214 px_lad21_3 px_lad21_4 3.73
Rpt215 px_lad21_4 px_lad21_5 8.22
Rpt216 px_lad21_5 px_lad21_6 19.8
Rpt217 px_lad21_6 px_lad21_7 1.03
Rpt218 px_lad21_7 px_lad21_8 9.05
Rpt219 px_lad21_8 px_lad21_9 1.72
Rpt220 xckg_d1 px_lad22_0 15.1
Rpt221 px_lad22_0 px_lad22_1 10.4
Rpt222 px_lad22_1 px_lad22_2 3.9
Rpt223 px_lad22_2 px_lad22_3 18.5
Rpt224 px_lad22_3 px_lad22_4 14.5
Rpt225 px_lad22_4 px_lad22_5 5.57
Rpt226 px_lad22_5 px_lad22_6 2.63
Rpt227 px_lad22_6 px_lad22_7 1.82
Rpt228 px_lad22_7 px_lad22_8 10.3
Rpt229 px_lad22_8 px_lad22_9 6.2
Rpt230 vref px_lad23_0 18.1
Rpt231 px_lad23_0 px_lad23_1 1.49
Rpt232 px_lad23_1 px_lad23_2 1.83
Rpt233 px_lad23_2 px_lad23_3 15.8
Rpt234 px_lad23_3 px_lad23_4 18.1
Rpt235 px_lad23_4 px_lad23_5 14.6
Rpt236 px_lad23_5 px_lad23_6 10.8
Rpt237 px_lad23_6 px_lad23_7 15.2
Rpt238 px_lad23_7 px_lad23_8 12.6
Rpt239 px_lad23_8 px_lad23_9 13
Rpt240 sar_mclk px_lad24_0 18.7
Rpt241 px_lad24_0 px_lad24_1 10.3
Rpt242 px_lad24_1 px_lad24_2 18.8
Rpt243 px_lad24_2 px_lad24_3 9.6
Rpt244 px_lad24_3 px_lad24_4 14.8
Rpt245 px_lad24_4 px_lad24_5 11.6
Rpt246 px_lad24_5 px_lad24_6 8.59
Rpt247 px_lad24_6 px_lad24_7 16
Rpt248 px_lad24_7 px_lad24_8 3.48
Rpt249 px_lad24_8 px_lad24_9 7.45
Rpt250 xckg_d0 px_lad25_0 15
Rpt251 px_lad25_0 px_lad25_1 15.1
Rpt252 px_lad25_1 px_lad25_2 1.94
Rpt253 px_lad25_2 px_lad25_3 14.2
Rpt254 px_lad25_3 px_lad25_4 6.02
Rpt255 px_lad25_4 px_lad25_5 4.97
Rpt256 px_lad25_5 px_lad25_6 18.8
Rpt257 px_lad25_6 px_lad25_7 20
Rpt258 px_lad25_7 px_lad25_8 14.1
Rpt259 px_lad25_8 px_lad25_9 14
Rpt260 vdd px_lad26_0 10.9
Rpt261 px_lad26_0 px_lad26_1 2.54
Rpt262 px_lad26_1 px_lad26_2 2.57
Rpt263 px_lad26_2 px_lad26_3 8.25
Rpt264 px_lad26_3 px_lad26_4 9.57
Rpt265 px_lad26_4 px_lad26_5 4.81
Rpt266 px_lad26_5 px_lad26_6 7.45
Rpt267 px_lad26_6 px_lad26_7 11.1
Rpt268 px_lad26_7 px_lad26_8 14.4
Rpt269 px_lad26_8 px_lad26_9 15.8
Rpt270 xckg_d2 px_lad27_0 5.6
Rpt271 px_lad27_0 px_lad27_1 14.1
Rpt272 px_lad27_1 px_lad27_2 17.2
Rpt273 px_lad27_2 px_lad27_3 5.9
Rpt274 px_lad27_3 px_lad27_4 8.71
Rpt275 px_lad27_4 px_lad27_5 9.31
Rpt276 px_lad27_5 px_lad27_6 15.2
Rpt277 px_lad27_6 px_lad27_7 1.59
Rpt278 px_lad27_7 px_lad27_8 3.44
Rpt279 px_lad27_8 px_lad27_9 17.2
Rpt280 xcbias_xrb_s1 px_lad28_0 1.03
Rpt281 px_lad28_0 px_lad28_1 17.4
Rpt282 px_lad28_1 px_lad28_2 13.3
Rpt283 px_lad28_2 px_lad28_3 12
Rpt284 px_lad28_3 px_lad28_4 15.3
Rpt285 px_lad28_4 px_lad28_5 2.38
Rpt286 px_lad28_5 px_lad28_6 2.09
Rpt287 px_lad28_6 px_lad28_7 17
Rpt288 px_lad28_7 px_lad28_8 12.5
Rpt289 px_lad28_8 px_lad28_9 4.21
Rpt290 vbp px_lad29_0 11.6
Rpt291 px_lad29_0 px_lad29_1 6.63
Rpt292 px_lad29_1 px_lad29_2 9
Rpt293 px_lad29_2 px_lad29_3 10.6
Rpt294 px_lad29_3 px_lad29_4 1.71
Rpt295 px_lad29_4 px_lad29_5 6.66
Rpt296 px_lad29_5 px_lad29_6 14.2
Rpt297 px_lad29_6 px_lad29_7 7.77
Rpt298 px_lad29_7 px_lad29_8 4.69
Rpt299 px_lad29_8 px_lad29_9 1
Rpt300 vdda px_lad30_0 15.7
Rpt301 px_lad30_0 px_lad30_1 2.36
Rpt302 px_lad30_1 px_lad30_2 12.1
Rpt303 px_lad30_2 px_lad30_3 12.1
Rpt304 px_lad30_3 px_lad30_4 14.9
Rpt305 px_lad30_4 px_lad30_5 19.1
Rpt306 px_lad30_5 px_lad30_6 13.1
Rpt307 px_lad30_6 px_lad30_7 11.7
Rpt308 px_lad30_7 px_lad30_8 6.35
Rpt309 px_lad30_8 px_lad30_9 10.8
Rpt310 vref px_lad31_0 8.92
Rpt311 px_lad31_0 px_lad31_1 16
Rpt312 px_lad31_1 px_lad31_2 1.42
Rpt313 px_lad31_2 px_lad31_3 1.93
Rpt314 px_lad31_3 px_lad31_4 4.58
Rpt315 px_lad31_4 px_lad31_5 3.86
Rpt316 px_lad31_5 px_lad31_6 5.27
Rpt317 px_lad31_6 px_lad31_7 5.76
Rpt318 px_lad31_7 px_lad31_8 12.1
Rpt319 px_lad31_8 px_lad31_9 19.2
Rpt320 vbp px_lad32_0 17.9
Rpt321 px_lad32_0 px_lad32_1 18.6
Rpt322 px_lad32_1 px_lad32_2 17.4
Rpt323 px_lad32_2 px_lad32_3 17.1
Rpt324 px_lad32_3 px_lad32_4 5.42
Rpt325 px_lad32_4 px_lad32_5 9.99
Rpt326 px_lad32_5 px_lad32_6 7.15
Rpt327 px_lad32_6 px_lad32_7 16.1
Rpt328 px_lad32_7 px_lad32_8 9.11
Rpt329 px_lad32_8 px_lad32_9 12.7
Rpt330 xcbiasn_xrb_s2 px_lad33_0 13.8
Rpt331 px_lad33_0 px_lad33_1 11.7
Rpt332 px_lad33_1 px_lad33_2 11.4
Rpt333 px_lad33_2 px_lad33_3 12
Rpt334 px_lad33_3 px_lad33_4 2.97
Rpt335 px_lad33_4 px_lad33_5 2.36
Rpt336 px_lad33_5 px_lad33_6 12.1
Rpt337 px_lad33_6 px_lad33_7 4.68
Rpt338 px_lad33_7 px_lad33_8 1.58
Rpt339 px_lad33_8 px_lad33_9 14.3
Rpt340 vss px_lad34_0 2.68
Rpt341 px_lad34_0 px_lad34_1 18.8
Rpt342 px_lad34_1 px_lad34_2 2.49
Rpt343 px_lad34_2 px_lad34_3 6.94
Rpt344 px_lad34_3 px_lad34_4 12.2
Rpt345 px_lad34_4 px_lad34_5 1.32
Rpt346 px_lad34_5 px_lad34_6 13.8
Rpt347 px_lad34_6 px_lad34_7 4.68
Rpt348 px_lad34_7 px_lad34_8 5.43
Rpt349 px_lad34_8 px_lad34_9 9.13
Rpt350 xcbiasn_xrb_s2 px_lad35_0 17.2
Rpt351 px_lad35_0 px_lad35_1 5.6
Rpt352 px_lad35_1 px_lad35_2 5.62
Rpt353 px_lad35_2 px_lad35_3 17.8
Rpt354 px_lad35_3 px_lad35_4 12.2
Rpt355 px_lad35_4 px_lad35_5 3.07
Rpt356 px_lad35_5 px_lad35_6 10.8
Rpt357 px_lad35_6 px_lad35_7 4.17
Rpt358 px_lad35_7 px_lad35_8 7.13
Rpt359 px_lad35_8 px_lad35_9 3.44
Rpt360 clk px_lad36_0 3.68
Rpt361 px_lad36_0 px_lad36_1 13.3
Rpt362 px_lad36_1 px_lad36_2 18.8
Rpt363 px_lad36_2 px_lad36_3 1.45
Rpt364 px_lad36_3 px_lad36_4 7.69
Rpt365 px_lad36_4 px_lad36_5 17.6
Rpt366 px_lad36_5 px_lad36_6 6.33
Rpt367 px_lad36_6 px_lad36_7 18.9
Rpt368 px_lad36_7 px_lad36_8 7.95
Rpt369 px_lad36_8 px_lad36_9 12.3
Rpt370 vref_in px_lad37_0 1.97
Rpt371 px_lad37_0 px_lad37_1 11.1
Rpt372 px_lad37_1 px_lad37_2 13.4
Rpt373 px_lad37_2 px_lad37_3 12.7
Rpt374 px_lad37_3 px_lad37_4 19.9
Rpt375 px_lad37_4 px_lad37_5 8.81
Rpt376 px_lad37_5 px_lad37_6 6.49
Rpt377 px_lad37_6 px_lad37_7 7.66
Rpt378 px_lad37_7 px_lad37_8 10.9
Rpt379 px_lad37_8 px_lad37_9 19.9
Rpt380 xckg_d0 px_lad38_0 9.29
Rpt381 px_lad38_0 px_lad38_1 15.9
Rpt382 px_lad38_1 px_lad38_2 16
Rpt383 px_lad38_2 px_lad38_3 13.9
Rpt384 px_lad38_3 px_lad38_4 7.78
Rpt385 px_lad38_4 px_lad38_5 11.7
Rpt386 px_lad38_5 px_lad38_6 7.83
Rpt387 px_lad38_6 px_lad38_7 10.5
Rpt388 px_lad38_7 px_lad38_8 14.6
Rpt389 px_lad38_8 px_lad38_9 15.9
Rpt390 xckg_d2 px_lad39_0 8.75
Rpt391 px_lad39_0 px_lad39_1 4.94
Rpt392 px_lad39_1 px_lad39_2 6.99
Rpt393 px_lad39_2 px_lad39_3 15.8
Rpt394 px_lad39_3 px_lad39_4 1.32
Rpt395 px_lad39_4 px_lad39_5 19.7
Rpt396 px_lad39_5 px_lad39_6 1.49
Rpt397 px_lad39_6 px_lad39_7 9.32
Rpt398 px_lad39_7 px_lad39_8 19.5
Rpt399 px_lad39_8 px_lad39_9 8.74
Rpt400 vref px_lad40_0 16.8
Rpt401 px_lad40_0 px_lad40_1 7.16
Rpt402 px_lad40_1 px_lad40_2 5.78
Rpt403 px_lad40_2 px_lad40_3 15
Rpt404 px_lad40_3 px_lad40_4 11.9
Rpt405 px_lad40_4 px_lad40_5 13.1
Rpt406 px_lad40_5 px_lad40_6 14.6
Rpt407 px_lad40_6 px_lad40_7 10.6
Rpt408 px_lad40_7 px_lad40_8 7.87
Rpt409 px_lad40_8 px_lad40_9 17.8
Rpt410 ibias px_lad41_0 19.4
Rpt411 px_lad41_0 px_lad41_1 11.9
Rpt412 px_lad41_1 px_lad41_2 5.53
Rpt413 px_lad41_2 px_lad41_3 15.9
Rpt414 px_lad41_3 px_lad41_4 18.4
Rpt415 px_lad41_4 px_lad41_5 11.2
Rpt416 px_lad41_5 px_lad41_6 5.94
Rpt417 px_lad41_6 px_lad41_7 18.9
Rpt418 px_lad41_7 px_lad41_8 18.3
Rpt419 px_lad41_8 px_lad41_9 16.3
Rpt420 xckg_d0 px_lad42_0 1.55
Rpt421 px_lad42_0 px_lad42_1 1.37
Rpt422 px_lad42_1 px_lad42_2 14.4
Rpt423 px_lad42_2 px_lad42_3 17.1
Rpt424 px_lad42_3 px_lad42_4 2.63
Rpt425 px_lad42_4 px_lad42_5 17.7
Rpt426 px_lad42_5 px_lad42_6 10
Rpt427 px_lad42_6 px_lad42_7 16.4
Rpt428 px_lad42_7 px_lad42_8 12.1
Rpt429 px_lad42_8 px_lad42_9 13
Rpt430 xcbiasn_xrb_s2 px_lad43_0 6.39
Rpt431 px_lad43_0 px_lad43_1 1.56
Rpt432 px_lad43_1 px_lad43_2 19.7
Rpt433 px_lad43_2 px_lad43_3 9
Rpt434 px_lad43_3 px_lad43_4 12.3
Rpt435 px_lad43_4 px_lad43_5 6.16
Rpt436 px_lad43_5 px_lad43_6 8.1
Rpt437 px_lad43_6 px_lad43_7 1.96
Rpt438 px_lad43_7 px_lad43_8 11.4
Rpt439 px_lad43_8 px_lad43_9 6.77
Rpt440 vdda px_lad44_0 8.29
Rpt441 px_lad44_0 px_lad44_1 10.3
Rpt442 px_lad44_1 px_lad44_2 5.79
Rpt443 px_lad44_2 px_lad44_3 17.7
Rpt444 px_lad44_3 px_lad44_4 15.2
Rpt445 px_lad44_4 px_lad44_5 12.2
Rpt446 px_lad44_5 px_lad44_6 16.1
Rpt447 px_lad44_6 px_lad44_7 4.62
Rpt448 px_lad44_7 px_lad44_8 19
Rpt449 px_lad44_8 px_lad44_9 8.63
Rpt450 xref_ntl px_lad45_0 3.61
Rpt451 px_lad45_0 px_lad45_1 5.62
Rpt452 px_lad45_1 px_lad45_2 11.6
Rpt453 px_lad45_2 px_lad45_3 8.57
Rpt454 px_lad45_3 px_lad45_4 4.97
Rpt455 px_lad45_4 px_lad45_5 15
Rpt456 px_lad45_5 px_lad45_6 15
Rpt457 px_lad45_6 px_lad45_7 16.8
Rpt458 px_lad45_7 px_lad45_8 2.1
Rpt459 px_lad45_8 px_lad45_9 6.95
Rpt460 xcbiasn_xrb_s3 px_lad46_0 16.1
Rpt461 px_lad46_0 px_lad46_1 3.16
Rpt462 px_lad46_1 px_lad46_2 3.09
Rpt463 px_lad46_2 px_lad46_3 12.8
Rpt464 px_lad46_3 px_lad46_4 8.25
Rpt465 px_lad46_4 px_lad46_5 10.2
Rpt466 px_lad46_5 px_lad46_6 11.4
Rpt467 px_lad46_6 px_lad46_7 2.91
Rpt468 px_lad46_7 px_lad46_8 10.2
Rpt469 px_lad46_8 px_lad46_9 16.8
Rpt470 xcbias_xrb_s1 px_lad47_0 13.4
Rpt471 px_lad47_0 px_lad47_1 10.2
Rpt472 px_lad47_1 px_lad47_2 6.17
Rpt473 px_lad47_2 px_lad47_3 19.3
Rpt474 px_lad47_3 px_lad47_4 11.2
Rpt475 px_lad47_4 px_lad47_5 12.3
Rpt476 px_lad47_5 px_lad47_6 3.11
Rpt477 px_lad47_6 px_lad47_7 13.3
Rpt478 px_lad47_7 px_lad47_8 10.4
Rpt479 px_lad47_8 px_lad47_9 8.2
Rpt480 xcbias_xrb_s1 px_lad48_0 10.3
Rpt481 px_lad48_0 px_lad48_1 7
Rpt482 px_lad48_1 px_lad48_2 18.7
Rpt483 px_lad48_2 px_lad48_3 9.24
Rpt484 px_lad48_3 px_lad48_4 11.5
Rpt485 px_lad48_4 px_lad48_5 15.5
Rpt486 px_lad48_5 px_lad48_6 12.6
Rpt487 px_lad48_6 px_lad48_7 1.67
Rpt488 px_lad48_7 px_lad48_8 13.7
Rpt489 px_lad48_8 px_lad48_9 2.03
Rpt490 xref_na px_lad49_0 8.24
Rpt491 px_lad49_0 px_lad49_1 2.06
Rpt492 px_lad49_1 px_lad49_2 3.94
Rpt493 px_lad49_2 px_lad49_3 14.9
Rpt494 px_lad49_3 px_lad49_4 13.4
Rpt495 px_lad49_4 px_lad49_5 4.71
Rpt496 px_lad49_5 px_lad49_6 8.7
Rpt497 px_lad49_6 px_lad49_7 7.46
Rpt498 px_lad49_7 px_lad49_8 14.2
Rpt499 px_lad49_8 px_lad49_9 2.53
.ends
.subckt r1_adc_lay_pr adc_hold is_smp clk adc_start adc_sel adc_valid_a adc_raw_a_0 adc_raw_a_1 adc_raw_a_2 adc_raw_a_3 adc_raw_a_4 adc_raw_a_5 adc_raw_a_6 adc_raw_a_7 adc_raw_a_8 adc_raw_a_9 adc_raw_a_10 adc_raw_a_11 adc_raw_a_12 adc_raw_a_13 adc_valid_b adc_raw_b_0 adc_raw_b_1 adc_raw_b_2 adc_raw_b_3 adc_raw_b_4 adc_raw_b_5 adc_raw_b_6 adc_raw_b_7 adc_raw_b_8 adc_raw_b_9 adc_raw_b_10 adc_raw_b_11 adc_raw_b_12 adc_raw_b_13 por_n ain_sin_p ain_sin_n ain_cos_p ain_cos_n vcm2 ibias ain_isa_p ain_isa_n ain_isb_p ain_isb_n vcm vdda vdd vss vref_in topap topan topbp topbn sar_clka sar_clkab sar_clkb sar_clkbb sar_clkna sar_clknab sar_clknb sar_clknbb sar_cna0 sar_cna1 sar_cna10 sar_cna11 sar_cna12 sar_cna2 sar_cna3 sar_cna4 sar_cna5 sar_cna6 sar_cna7 sar_cna8 sar_cna9 sar_cnb0 sar_cnb1 sar_cnb10 sar_cnb11 sar_cnb12 sar_cnb2 sar_cnb3 sar_cnb4 sar_cnb5 sar_cnb6 sar_cnb7 sar_cnb8 sar_cnb9 sar_cpa0 sar_cpa1 sar_cpa10 sar_cpa11 sar_cpa12 sar_cpa2 sar_cpa3 sar_cpa4 sar_cpa5 sar_cpa6 sar_cpa7 sar_cpa8 sar_cpa9 sar_cpb0 sar_cpb1 sar_cpb10 sar_cpb11 sar_cpb12 sar_cpb2 sar_cpb3 sar_cpb4 sar_cpb5 sar_cpb6 sar_cpb7 sar_cpb8 sar_cpb9 sar_oan sar_oann sar_oanp sar_oap sar_obn sar_obnn sar_obnp sar_obp sar_trka0 sar_trka1 sar_trkb0 sar_trkb1 sar_mclk vref vrefl
Xxckg_xpd0 xckg_d0 clk vdd vdd sg13_lv_pmos w=1u l=0.5u ng=1 m=1
Xxckg_xnd0 xckg_d0 clk vss vss sg13_lv_nmos w=0.5u l=0.5u ng=1 m=1
Xxckg_cd0 xckg_d0 vss cap_cmim w=2.53u l=2.53u m=1
Xxckg_xpd1 xckg_d1 xckg_d0 vdd vdd sg13_lv_pmos w=1u l=0.5u ng=1 m=1
Xxckg_xnd1 xckg_d1 xckg_d0 vss vss sg13_lv_nmos w=0.5u l=0.5u ng=1 m=1
Xxckg_cd1 xckg_d1 vss cap_cmim w=2.53u l=2.53u m=1
Xxckg_xpd2 xckg_d2 xckg_d1 vdd vdd sg13_lv_pmos w=1u l=0.5u ng=1 m=1
Xxckg_xnd2 xckg_d2 xckg_d1 vss vss sg13_lv_nmos w=0.5u l=0.5u ng=1 m=1
Xxckg_cd2 xckg_d2 vss cap_cmim w=2.53u l=2.53u m=1
Xxckg_xpd3 xckg_d3 xckg_d2 vdd vdd sg13_lv_pmos w=1u l=0.5u ng=1 m=1
Xxckg_xnd3 xckg_d3 xckg_d2 vss vss sg13_lv_nmos w=0.5u l=0.5u ng=1 m=1
Xxckg_cd3 xckg_d3 vss cap_cmim w=2.53u l=2.53u m=1
Xxckg_xpd4 xckg_x xckg_d3 vdd vdd sg13_lv_pmos w=1u l=0.5u ng=1 m=1
Xxckg_xnd4 xckg_x xckg_d3 vss vss sg13_lv_nmos w=0.5u l=0.5u ng=1 m=1
Xxckg_cd4 xckg_x vss cap_cmim w=2.53u l=2.53u m=1
Xxckg_xpa sar_mclk clk vdd vdd sg13_lv_pmos w=2u l=0.13u ng=1 m=1
Xxckg_xpb sar_mclk xckg_x vdd vdd sg13_lv_pmos w=2u l=0.13u ng=1 m=1
Xxckg_xna sar_mclk clk xckg_nn vss sg13_lv_nmos w=2u l=0.13u ng=1 m=1
Xxckg_xnb xckg_nn xckg_x vss vss sg13_lv_nmos w=2u l=0.13u ng=1 m=1
Xxckg_xpi mclkb sar_mclk vdd vdd sg13_lv_pmos w=2u l=0.13u ng=1 m=1
Xxckg_xni mclkb sar_mclk vss vss sg13_lv_nmos w=1u l=0.13u ng=1 m=1
Xxcbias_xmbd vbp vbp vdd vdd sg13_lv_pmos w=0.8u l=0.5u ng=1 m=1
Xxcbias_xrb_g0 vbp xcbias_xrb_s1 vss rppd w=1u l=40u m=1 b=0
Xxcbias_xrb_g1 xcbias_xrb_s1 xcbias_xrb_s2 vss rppd w=1u l=40u m=1 b=0
Xxcbias_xrb_g2 xcbias_xrb_s2 xcbias_xrb_s3 vss rppd w=1u l=40u m=1 b=0
Xxcbias_xrb_g3 xcbias_xrb_s3 vss vss rppd w=1u l=40u m=1 b=0
Xxcbiasn_xmbd vbn vbn vss vss sg13_lv_nmos w=0.2u l=0.5u ng=1 m=1
Xxcbiasn_xrb_g0 vdd xcbiasn_xrb_s1 vss rppd w=1u l=40u m=1 b=0
Xxcbiasn_xrb_g1 xcbiasn_xrb_s1 xcbiasn_xrb_s2 vss rppd w=1u l=40u m=1 b=0
Xxcbiasn_xrb_g2 xcbiasn_xrb_s2 xcbiasn_xrb_s3 vss rppd w=1u l=40u m=1 b=0
Xxcbiasn_xrb_g3 xcbiasn_xrb_s3 vbn vss rppd w=1u l=40u m=1 b=0
Xxref_xmb0 ibias ibias vss vss sg13_hv_nmos w=2u l=1u ng=1 m=1
Xxref_xmt xref_ntl ibias vss vss sg13_hv_nmos w=2u l=8u ng=1 m=1
Xxref_xm1 xref_na vref_in xref_ntl vss sg13_hv_nmos w=10u l=1u ng=2 m=1
Xxref_xm2 xref_ng vref xref_ntl vss sg13_hv_nmos w=10u l=1u ng=2 m=1
Xxref_xm3 xref_na xref_na vdda vdda sg13_hv_pmos w=4u l=1u ng=1 m=1
Xxref_xm4 xref_ng xref_na vdda vdda sg13_hv_pmos w=4u l=1u ng=1 m=1
Xxref_xcg_u0 vss xref_ng cap_cmim w=26.32u l=95u m=1
Xxref_xmsf_s0 vdda xref_ng vref vss sg13_hv_nmos w=80u l=0.45u ng=32 m=4
Xxref_xmib_s0 vref ibias vss vss sg13_hv_nmos w=80u l=1u ng=40 m=4
Xxref_xcd_u0 vss vref cap_cmim w=51.58u l=95u m=4
Xxref_xmsfl_s0 vdda xref_ng vrefl vss sg13_hv_nmos w=80u l=0.45u ng=32 m=1
Xxref_xmibl_s0 vrefl ibias vss vss sg13_hv_nmos w=80u l=1u ng=40 m=1
Xxref_xcdl_u0 vss vrefl cap_cmim w=51.58u l=95u m=2
Xxfilt_xcf_u0 vss vref_in cap_cmim w=37.36u l=90u m=2
Xslice_a ain_sin_p ain_sin_n ain_isa_p ain_isa_n sar_trka0 sar_trka1 sar_cpa0 sar_cpa1 sar_cpa2 sar_cpa3 sar_cpa4 sar_cpa5 sar_cpa6 sar_cpa7 sar_cpa8 sar_cpa9 sar_cpa10 sar_cpa11 sar_cpa12 sar_cna0 sar_cna1 sar_cna2 sar_cna3 sar_cna4 sar_cna5 sar_cna6 sar_cna7 sar_cna8 sar_cna9 sar_cna10 sar_cna11 sar_cna12 sar_clka sar_clkab sar_clkna sar_clknab sar_oap sar_oan sar_oanp sar_oann vbp vbn vref vrefl topap topan vdd vss r1_adc_slice_lay
Xslice_b ain_cos_p ain_cos_n ain_isb_p ain_isb_n sar_trkb0 sar_trkb1 sar_cpb0 sar_cpb1 sar_cpb2 sar_cpb3 sar_cpb4 sar_cpb5 sar_cpb6 sar_cpb7 sar_cpb8 sar_cpb9 sar_cpb10 sar_cpb11 sar_cpb12 sar_cnb0 sar_cnb1 sar_cnb2 sar_cnb3 sar_cnb4 sar_cnb5 sar_cnb6 sar_cnb7 sar_cnb8 sar_cnb9 sar_cnb10 sar_cnb11 sar_cnb12 sar_clkb sar_clkbb sar_clknb sar_clknbb sar_obp sar_obn sar_obnp sar_obnn vbp vbn vref vrefl topbp topbn vdd vss r1_adc_slice_lay
* parasitics, scope top: 825 C (4.62e-13 F total), 500 R, 500 internal nodes
Cpt0 clk ibias 2.245e-16
Cpt1 clk mclkb 1.966e-16
Cpt2 clk sar_mclk 3.48e-16
Cpt3 clk vbn 5.013e-16
Cpt4 clk vbp 5.97e-17
Cpt5 clk vdd 5.18e-16
Cpt6 clk vdda 8.71e-16
Cpt7 clk vref 8.066e-16
Cpt8 clk vref_in 5.4e-16
Cpt9 clk vrefl 1.71e-16
Cpt10 clk vss 1.0346e-14
Cpt11 clk xcbias_xrb_s1 4.91e-17
Cpt12 clk xcbias_xrb_s2 6.97e-16
Cpt13 clk xcbias_xrb_s3 1.27e-16
Cpt14 clk xcbiasn_xrb_s1 2.848e-16
Cpt15 clk xcbiasn_xrb_s2 1.0039e-15
Cpt16 clk xcbiasn_xrb_s3 2.33e-15
Cpt17 clk xckg_d0 9.735e-16
Cpt18 clk xckg_d1 3.35e-16
Cpt19 clk xckg_d2 6.2e-16
Cpt20 clk xckg_d3 4.57e-16
Cpt21 clk xckg_nn 1.1172e-15
Cpt22 clk xckg_x 2.033e-16
Cpt23 clk xref_na 1.41e-16
Cpt24 clk xref_ng 7.451e-16
Cpt25 clk xref_ntl 9.32e-16
Cpt26 ibias sar_mclk 8.65e-16
Cpt27 ibias vbn 5.563e-16
Cpt28 ibias vbp 6.041e-16
Cpt29 ibias vdd 2.34e-16
Cpt30 ibias vdda 2.094e-16
Cpt31 ibias vref 9.509e-16
Cpt32 ibias vref_in 4.6e-16
Cpt33 ibias vss 5.7227e-15
Cpt34 ibias xcbias_xrb_s1 2.5e-16
Cpt35 ibias xcbias_xrb_s2 3.28e-16
Cpt36 ibias xcbias_xrb_s3 4.9e-16
Cpt37 ibias xcbiasn_xrb_s1 2.693e-15
Cpt38 ibias xcbiasn_xrb_s2 3.627e-16
Cpt39 ibias xcbiasn_xrb_s3 1.141e-16
Cpt40 ibias xckg_d1 7.71e-16
Cpt41 ibias xckg_d2 4.124e-16
Cpt42 ibias xckg_d3 2.558e-16
Cpt43 ibias xckg_nn 3.058e-16
Cpt44 ibias xckg_x 7.272e-16
Cpt45 ibias xref_na 6.269e-16
Cpt46 ibias xref_ng 3.985e-16
Cpt47 ibias xref_ntl 5.828e-16
Cpt48 mclkb sar_mclk 3.68e-16
Cpt49 mclkb vbn 1.339e-15
Cpt50 mclkb vbp 4.38e-16
Cpt51 mclkb vdd 1.76e-16
Cpt52 mclkb vdda 4.586e-16
Cpt53 mclkb vref 7.425e-16
Cpt54 mclkb vref_in 1.436e-16
Cpt55 mclkb vrefl 7.774e-16
Cpt56 mclkb vss 1.0911e-14
Cpt57 mclkb xcbias_xrb_s1 1.8533e-15
Cpt58 mclkb xcbias_xrb_s2 2.29e-16
Cpt59 mclkb xcbiasn_xrb_s1 5.111e-16
Cpt60 mclkb xcbiasn_xrb_s2 1.93e-16
Cpt61 mclkb xcbiasn_xrb_s3 3.17e-16
Cpt62 mclkb xckg_d0 5.39e-16
Cpt63 mclkb xckg_d1 2.44e-16
Cpt64 mclkb xckg_d3 1.02e-16
Cpt65 mclkb xckg_nn 6.487e-16
Cpt66 mclkb xckg_x 1.7e-16
Cpt67 mclkb xref_na 1.159e-16
Cpt68 mclkb xref_ng 1.51e-16
Cpt69 mclkb xref_ntl 2.24e-16
Cpt70 px_lad0_0 vss 1e-16
Cpt71 px_lad0_1 vss 1e-16
Cpt72 px_lad0_2 vss 1e-16
Cpt73 px_lad0_3 vss 1e-16
Cpt74 px_lad0_4 vss 1e-16
Cpt75 px_lad0_5 vss 1e-16
Cpt76 px_lad0_6 vss 1e-16
Cpt77 px_lad0_7 vss 1e-16
Cpt78 px_lad0_8 vss 1e-16
Cpt79 px_lad0_9 vss 1e-16
Cpt80 px_lad10_0 vss 1e-16
Cpt81 px_lad10_1 vss 1e-16
Cpt82 px_lad10_2 vss 1e-16
Cpt83 px_lad10_3 vss 1e-16
Cpt84 px_lad10_4 vss 1e-16
Cpt85 px_lad10_5 vss 1e-16
Cpt86 px_lad10_6 vss 1e-16
Cpt87 px_lad10_7 vss 1e-16
Cpt88 px_lad10_8 vss 1e-16
Cpt89 px_lad10_9 vss 1e-16
Cpt90 px_lad11_0 vss 1e-16
Cpt91 px_lad11_1 vss 1e-16
Cpt92 px_lad11_2 vss 1e-16
Cpt93 px_lad11_3 vss 1e-16
Cpt94 px_lad11_4 vss 1e-16
Cpt95 px_lad11_5 vss 1e-16
Cpt96 px_lad11_6 vss 1e-16
Cpt97 px_lad11_7 vss 1e-16
Cpt98 px_lad11_8 vss 1e-16
Cpt99 px_lad11_9 vss 1e-16
Cpt100 px_lad12_0 vss 1e-16
Cpt101 px_lad12_1 vss 1e-16
Cpt102 px_lad12_2 vss 1e-16
Cpt103 px_lad12_3 vss 1e-16
Cpt104 px_lad12_4 vss 1e-16
Cpt105 px_lad12_5 vss 1e-16
Cpt106 px_lad12_6 vss 1e-16
Cpt107 px_lad12_7 vss 1e-16
Cpt108 px_lad12_8 vss 1e-16
Cpt109 px_lad12_9 vss 1e-16
Cpt110 px_lad13_0 vss 1e-16
Cpt111 px_lad13_1 vss 1e-16
Cpt112 px_lad13_2 vss 1e-16
Cpt113 px_lad13_3 vss 1e-16
Cpt114 px_lad13_4 vss 1e-16
Cpt115 px_lad13_5 vss 1e-16
Cpt116 px_lad13_6 vss 1e-16
Cpt117 px_lad13_7 vss 1e-16
Cpt118 px_lad13_8 vss 1e-16
Cpt119 px_lad13_9 vss 1e-16
Cpt120 px_lad14_0 vss 1e-16
Cpt121 px_lad14_1 vss 1e-16
Cpt122 px_lad14_2 vss 1e-16
Cpt123 px_lad14_3 vss 1e-16
Cpt124 px_lad14_4 vss 1e-16
Cpt125 px_lad14_5 vss 1e-16
Cpt126 px_lad14_6 vss 1e-16
Cpt127 px_lad14_7 vss 1e-16
Cpt128 px_lad14_8 vss 1e-16
Cpt129 px_lad14_9 vss 1e-16
Cpt130 px_lad15_0 vss 1e-16
Cpt131 px_lad15_1 vss 1e-16
Cpt132 px_lad15_2 vss 1e-16
Cpt133 px_lad15_3 vss 1e-16
Cpt134 px_lad15_4 vss 1e-16
Cpt135 px_lad15_5 vss 1e-16
Cpt136 px_lad15_6 vss 1e-16
Cpt137 px_lad15_7 vss 1e-16
Cpt138 px_lad15_8 vss 1e-16
Cpt139 px_lad15_9 vss 1e-16
Cpt140 px_lad16_0 vss 1e-16
Cpt141 px_lad16_1 vss 1e-16
Cpt142 px_lad16_2 vss 1e-16
Cpt143 px_lad16_3 vss 1e-16
Cpt144 px_lad16_4 vss 1e-16
Cpt145 px_lad16_5 vss 1e-16
Cpt146 px_lad16_6 vss 1e-16
Cpt147 px_lad16_7 vss 1e-16
Cpt148 px_lad16_8 vss 1e-16
Cpt149 px_lad16_9 vss 1e-16
Cpt150 px_lad17_0 vss 1e-16
Cpt151 px_lad17_1 vss 1e-16
Cpt152 px_lad17_2 vss 1e-16
Cpt153 px_lad17_3 vss 1e-16
Cpt154 px_lad17_4 vss 1e-16
Cpt155 px_lad17_5 vss 1e-16
Cpt156 px_lad17_6 vss 1e-16
Cpt157 px_lad17_7 vss 1e-16
Cpt158 px_lad17_8 vss 1e-16
Cpt159 px_lad17_9 vss 1e-16
Cpt160 px_lad18_0 vss 1e-16
Cpt161 px_lad18_1 vss 1e-16
Cpt162 px_lad18_2 vss 1e-16
Cpt163 px_lad18_3 vss 1e-16
Cpt164 px_lad18_4 vss 1e-16
Cpt165 px_lad18_5 vss 1e-16
Cpt166 px_lad18_6 vss 1e-16
Cpt167 px_lad18_7 vss 1e-16
Cpt168 px_lad18_8 vss 1e-16
Cpt169 px_lad18_9 vss 1e-16
Cpt170 px_lad19_0 vss 1e-16
Cpt171 px_lad19_1 vss 1e-16
Cpt172 px_lad19_2 vss 1e-16
Cpt173 px_lad19_3 vss 1e-16
Cpt174 px_lad19_4 vss 1e-16
Cpt175 px_lad19_5 vss 1e-16
Cpt176 px_lad19_6 vss 1e-16
Cpt177 px_lad19_7 vss 1e-16
Cpt178 px_lad19_8 vss 1e-16
Cpt179 px_lad19_9 vss 1e-16
Cpt180 px_lad1_0 vss 1e-16
Cpt181 px_lad1_1 vss 1e-16
Cpt182 px_lad1_2 vss 1e-16
Cpt183 px_lad1_3 vss 1e-16
Cpt184 px_lad1_4 vss 1e-16
Cpt185 px_lad1_5 vss 1e-16
Cpt186 px_lad1_6 vss 1e-16
Cpt187 px_lad1_7 vss 1e-16
Cpt188 px_lad1_8 vss 1e-16
Cpt189 px_lad1_9 vss 1e-16
Cpt190 px_lad20_0 vss 1e-16
Cpt191 px_lad20_1 vss 1e-16
Cpt192 px_lad20_2 vss 1e-16
Cpt193 px_lad20_3 vss 1e-16
Cpt194 px_lad20_4 vss 1e-16
Cpt195 px_lad20_5 vss 1e-16
Cpt196 px_lad20_6 vss 1e-16
Cpt197 px_lad20_7 vss 1e-16
Cpt198 px_lad20_8 vss 1e-16
Cpt199 px_lad20_9 vss 1e-16
Cpt200 px_lad21_0 vss 1e-16
Cpt201 px_lad21_1 vss 1e-16
Cpt202 px_lad21_2 vss 1e-16
Cpt203 px_lad21_3 vss 1e-16
Cpt204 px_lad21_4 vss 1e-16
Cpt205 px_lad21_5 vss 1e-16
Cpt206 px_lad21_6 vss 1e-16
Cpt207 px_lad21_7 vss 1e-16
Cpt208 px_lad21_8 vss 1e-16
Cpt209 px_lad21_9 vss 1e-16
Cpt210 px_lad22_0 vss 1e-16
Cpt211 px_lad22_1 vss 1e-16
Cpt212 px_lad22_2 vss 1e-16
Cpt213 px_lad22_3 vss 1e-16
Cpt214 px_lad22_4 vss 1e-16
Cpt215 px_lad22_5 vss 1e-16
Cpt216 px_lad22_6 vss 1e-16
Cpt217 px_lad22_7 vss 1e-16
Cpt218 px_lad22_8 vss 1e-16
Cpt219 px_lad22_9 vss 1e-16
Cpt220 px_lad23_0 vss 1e-16
Cpt221 px_lad23_1 vss 1e-16
Cpt222 px_lad23_2 vss 1e-16
Cpt223 px_lad23_3 vss 1e-16
Cpt224 px_lad23_4 vss 1e-16
Cpt225 px_lad23_5 vss 1e-16
Cpt226 px_lad23_6 vss 1e-16
Cpt227 px_lad23_7 vss 1e-16
Cpt228 px_lad23_8 vss 1e-16
Cpt229 px_lad23_9 vss 1e-16
Cpt230 px_lad24_0 vss 1e-16
Cpt231 px_lad24_1 vss 1e-16
Cpt232 px_lad24_2 vss 1e-16
Cpt233 px_lad24_3 vss 1e-16
Cpt234 px_lad24_4 vss 1e-16
Cpt235 px_lad24_5 vss 1e-16
Cpt236 px_lad24_6 vss 1e-16
Cpt237 px_lad24_7 vss 1e-16
Cpt238 px_lad24_8 vss 1e-16
Cpt239 px_lad24_9 vss 1e-16
Cpt240 px_lad25_0 vss 1e-16
Cpt241 px_lad25_1 vss 1e-16
Cpt242 px_lad25_2 vss 1e-16
Cpt243 px_lad25_3 vss 1e-16
Cpt244 px_lad25_4 vss 1e-16
Cpt245 px_lad25_5 vss 1e-16
Cpt246 px_lad25_6 vss 1e-16
Cpt247 px_lad25_7 vss 1e-16
Cpt248 px_lad25_8 vss 1e-16
Cpt249 px_lad25_9 vss 1e-16
Cpt250 px_lad26_0 vss 1e-16
Cpt251 px_lad26_1 vss 1e-16
Cpt252 px_lad26_2 vss 1e-16
Cpt253 px_lad26_3 vss 1e-16
Cpt254 px_lad26_4 vss 1e-16
Cpt255 px_lad26_5 vss 1e-16
Cpt256 px_lad26_6 vss 1e-16
Cpt257 px_lad26_7 vss 1e-16
Cpt258 px_lad26_8 vss 1e-16
Cpt259 px_lad26_9 vss 1e-16
Cpt260 px_lad27_0 vss 1e-16
Cpt261 px_lad27_1 vss 1e-16
Cpt262 px_lad27_2 vss 1e-16
Cpt263 px_lad27_3 vss 1e-16
Cpt264 px_lad27_4 vss 1e-16
Cpt265 px_lad27_5 vss 1e-16
Cpt266 px_lad27_6 vss 1e-16
Cpt267 px_lad27_7 vss 1e-16
Cpt268 px_lad27_8 vss 1e-16
Cpt269 px_lad27_9 vss 1e-16
Cpt270 px_lad28_0 vss 1e-16
Cpt271 px_lad28_1 vss 1e-16
Cpt272 px_lad28_2 vss 1e-16
Cpt273 px_lad28_3 vss 1e-16
Cpt274 px_lad28_4 vss 1e-16
Cpt275 px_lad28_5 vss 1e-16
Cpt276 px_lad28_6 vss 1e-16
Cpt277 px_lad28_7 vss 1e-16
Cpt278 px_lad28_8 vss 1e-16
Cpt279 px_lad28_9 vss 1e-16
Cpt280 px_lad29_0 vss 1e-16
Cpt281 px_lad29_1 vss 1e-16
Cpt282 px_lad29_2 vss 1e-16
Cpt283 px_lad29_3 vss 1e-16
Cpt284 px_lad29_4 vss 1e-16
Cpt285 px_lad29_5 vss 1e-16
Cpt286 px_lad29_6 vss 1e-16
Cpt287 px_lad29_7 vss 1e-16
Cpt288 px_lad29_8 vss 1e-16
Cpt289 px_lad29_9 vss 1e-16
Cpt290 px_lad2_0 vss 1e-16
Cpt291 px_lad2_1 vss 1e-16
Cpt292 px_lad2_2 vss 1e-16
Cpt293 px_lad2_3 vss 1e-16
Cpt294 px_lad2_4 vss 1e-16
Cpt295 px_lad2_5 vss 1e-16
Cpt296 px_lad2_6 vss 1e-16
Cpt297 px_lad2_7 vss 1e-16
Cpt298 px_lad2_8 vss 1e-16
Cpt299 px_lad2_9 vss 1e-16
Cpt300 px_lad30_0 vss 1e-16
Cpt301 px_lad30_1 vss 1e-16
Cpt302 px_lad30_2 vss 1e-16
Cpt303 px_lad30_3 vss 1e-16
Cpt304 px_lad30_4 vss 1e-16
Cpt305 px_lad30_5 vss 1e-16
Cpt306 px_lad30_6 vss 1e-16
Cpt307 px_lad30_7 vss 1e-16
Cpt308 px_lad30_8 vss 1e-16
Cpt309 px_lad30_9 vss 1e-16
Cpt310 px_lad31_0 vss 1e-16
Cpt311 px_lad31_1 vss 1e-16
Cpt312 px_lad31_2 vss 1e-16
Cpt313 px_lad31_3 vss 1e-16
Cpt314 px_lad31_4 vss 1e-16
Cpt315 px_lad31_5 vss 1e-16
Cpt316 px_lad31_6 vss 1e-16
Cpt317 px_lad31_7 vss 1e-16
Cpt318 px_lad31_8 vss 1e-16
Cpt319 px_lad31_9 vss 1e-16
Cpt320 px_lad32_0 vss 1e-16
Cpt321 px_lad32_1 vss 1e-16
Cpt322 px_lad32_2 vss 1e-16
Cpt323 px_lad32_3 vss 1e-16
Cpt324 px_lad32_4 vss 1e-16
Cpt325 px_lad32_5 vss 1e-16
Cpt326 px_lad32_6 vss 1e-16
Cpt327 px_lad32_7 vss 1e-16
Cpt328 px_lad32_8 vss 1e-16
Cpt329 px_lad32_9 vss 1e-16
Cpt330 px_lad33_0 vss 1e-16
Cpt331 px_lad33_1 vss 1e-16
Cpt332 px_lad33_2 vss 1e-16
Cpt333 px_lad33_3 vss 1e-16
Cpt334 px_lad33_4 vss 1e-16
Cpt335 px_lad33_5 vss 1e-16
Cpt336 px_lad33_6 vss 1e-16
Cpt337 px_lad33_7 vss 1e-16
Cpt338 px_lad33_8 vss 1e-16
Cpt339 px_lad33_9 vss 1e-16
Cpt340 px_lad34_0 vss 1e-16
Cpt341 px_lad34_1 vss 1e-16
Cpt342 px_lad34_2 vss 1e-16
Cpt343 px_lad34_3 vss 1e-16
Cpt344 px_lad34_4 vss 1e-16
Cpt345 px_lad34_5 vss 1e-16
Cpt346 px_lad34_6 vss 1e-16
Cpt347 px_lad34_7 vss 1e-16
Cpt348 px_lad34_8 vss 1e-16
Cpt349 px_lad34_9 vss 1e-16
Cpt350 px_lad35_0 vss 1e-16
Cpt351 px_lad35_1 vss 1e-16
Cpt352 px_lad35_2 vss 1e-16
Cpt353 px_lad35_3 vss 1e-16
Cpt354 px_lad35_4 vss 1e-16
Cpt355 px_lad35_5 vss 1e-16
Cpt356 px_lad35_6 vss 1e-16
Cpt357 px_lad35_7 vss 1e-16
Cpt358 px_lad35_8 vss 1e-16
Cpt359 px_lad35_9 vss 1e-16
Cpt360 px_lad36_0 vss 1e-16
Cpt361 px_lad36_1 vss 1e-16
Cpt362 px_lad36_2 vss 1e-16
Cpt363 px_lad36_3 vss 1e-16
Cpt364 px_lad36_4 vss 1e-16
Cpt365 px_lad36_5 vss 1e-16
Cpt366 px_lad36_6 vss 1e-16
Cpt367 px_lad36_7 vss 1e-16
Cpt368 px_lad36_8 vss 1e-16
Cpt369 px_lad36_9 vss 1e-16
Cpt370 px_lad37_0 vss 1e-16
Cpt371 px_lad37_1 vss 1e-16
Cpt372 px_lad37_2 vss 1e-16
Cpt373 px_lad37_3 vss 1e-16
Cpt374 px_lad37_4 vss 1e-16
Cpt375 px_lad37_5 vss 1e-16
Cpt376 px_lad37_6 vss 1e-16
Cpt377 px_lad37_7 vss 1e-16
Cpt378 px_lad37_8 vss 1e-16
Cpt379 px_lad37_9 vss 1e-16
Cpt380 px_lad38_0 vss 1e-16
Cpt381 px_lad38_1 vss 1e-16
Cpt382 px_lad38_2 vss 1e-16
Cpt383 px_lad38_3 vss 1e-16
Cpt384 px_lad38_4 vss 1e-16
Cpt385 px_lad38_5 vss 1e-16
Cpt386 px_lad38_6 vss 1e-16
Cpt387 px_lad38_7 vss 1e-16
Cpt388 px_lad38_8 vss 1e-16
Cpt389 px_lad38_9 vss 1e-16
Cpt390 px_lad39_0 vss 1e-16
Cpt391 px_lad39_1 vss 1e-16
Cpt392 px_lad39_2 vss 1e-16
Cpt393 px_lad39_3 vss 1e-16
Cpt394 px_lad39_4 vss 1e-16
Cpt395 px_lad39_5 vss 1e-16
Cpt396 px_lad39_6 vss 1e-16
Cpt397 px_lad39_7 vss 1e-16
Cpt398 px_lad39_8 vss 1e-16
Cpt399 px_lad39_9 vss 1e-16
Cpt400 px_lad3_0 vss 1e-16
Cpt401 px_lad3_1 vss 1e-16
Cpt402 px_lad3_2 vss 1e-16
Cpt403 px_lad3_3 vss 1e-16
Cpt404 px_lad3_4 vss 1e-16
Cpt405 px_lad3_5 vss 1e-16
Cpt406 px_lad3_6 vss 1e-16
Cpt407 px_lad3_7 vss 1e-16
Cpt408 px_lad3_8 vss 1e-16
Cpt409 px_lad3_9 vss 1e-16
Cpt410 px_lad40_0 vss 1e-16
Cpt411 px_lad40_1 vss 1e-16
Cpt412 px_lad40_2 vss 1e-16
Cpt413 px_lad40_3 vss 1e-16
Cpt414 px_lad40_4 vss 1e-16
Cpt415 px_lad40_5 vss 1e-16
Cpt416 px_lad40_6 vss 1e-16
Cpt417 px_lad40_7 vss 1e-16
Cpt418 px_lad40_8 vss 1e-16
Cpt419 px_lad40_9 vss 1e-16
Cpt420 px_lad41_0 vss 1e-16
Cpt421 px_lad41_1 vss 1e-16
Cpt422 px_lad41_2 vss 1e-16
Cpt423 px_lad41_3 vss 1e-16
Cpt424 px_lad41_4 vss 1e-16
Cpt425 px_lad41_5 vss 1e-16
Cpt426 px_lad41_6 vss 1e-16
Cpt427 px_lad41_7 vss 1e-16
Cpt428 px_lad41_8 vss 1e-16
Cpt429 px_lad41_9 vss 1e-16
Cpt430 px_lad42_0 vss 1e-16
Cpt431 px_lad42_1 vss 1e-16
Cpt432 px_lad42_2 vss 1e-16
Cpt433 px_lad42_3 vss 1e-16
Cpt434 px_lad42_4 vss 1e-16
Cpt435 px_lad42_5 vss 1e-16
Cpt436 px_lad42_6 vss 1e-16
Cpt437 px_lad42_7 vss 1e-16
Cpt438 px_lad42_8 vss 1e-16
Cpt439 px_lad42_9 vss 1e-16
Cpt440 px_lad43_0 vss 1e-16
Cpt441 px_lad43_1 vss 1e-16
Cpt442 px_lad43_2 vss 1e-16
Cpt443 px_lad43_3 vss 1e-16
Cpt444 px_lad43_4 vss 1e-16
Cpt445 px_lad43_5 vss 1e-16
Cpt446 px_lad43_6 vss 1e-16
Cpt447 px_lad43_7 vss 1e-16
Cpt448 px_lad43_8 vss 1e-16
Cpt449 px_lad43_9 vss 1e-16
Cpt450 px_lad44_0 vss 1e-16
Cpt451 px_lad44_1 vss 1e-16
Cpt452 px_lad44_2 vss 1e-16
Cpt453 px_lad44_3 vss 1e-16
Cpt454 px_lad44_4 vss 1e-16
Cpt455 px_lad44_5 vss 1e-16
Cpt456 px_lad44_6 vss 1e-16
Cpt457 px_lad44_7 vss 1e-16
Cpt458 px_lad44_8 vss 1e-16
Cpt459 px_lad44_9 vss 1e-16
Cpt460 px_lad45_0 vss 1e-16
Cpt461 px_lad45_1 vss 1e-16
Cpt462 px_lad45_2 vss 1e-16
Cpt463 px_lad45_3 vss 1e-16
Cpt464 px_lad45_4 vss 1e-16
Cpt465 px_lad45_5 vss 1e-16
Cpt466 px_lad45_6 vss 1e-16
Cpt467 px_lad45_7 vss 1e-16
Cpt468 px_lad45_8 vss 1e-16
Cpt469 px_lad45_9 vss 1e-16
Cpt470 px_lad46_0 vss 1e-16
Cpt471 px_lad46_1 vss 1e-16
Cpt472 px_lad46_2 vss 1e-16
Cpt473 px_lad46_3 vss 1e-16
Cpt474 px_lad46_4 vss 1e-16
Cpt475 px_lad46_5 vss 1e-16
Cpt476 px_lad46_6 vss 1e-16
Cpt477 px_lad46_7 vss 1e-16
Cpt478 px_lad46_8 vss 1e-16
Cpt479 px_lad46_9 vss 1e-16
Cpt480 px_lad47_0 vss 1e-16
Cpt481 px_lad47_1 vss 1e-16
Cpt482 px_lad47_2 vss 1e-16
Cpt483 px_lad47_3 vss 1e-16
Cpt484 px_lad47_4 vss 1e-16
Cpt485 px_lad47_5 vss 1e-16
Cpt486 px_lad47_6 vss 1e-16
Cpt487 px_lad47_7 vss 1e-16
Cpt488 px_lad47_8 vss 1e-16
Cpt489 px_lad47_9 vss 1e-16
Cpt490 px_lad48_0 vss 1e-16
Cpt491 px_lad48_1 vss 1e-16
Cpt492 px_lad48_2 vss 1e-16
Cpt493 px_lad48_3 vss 1e-16
Cpt494 px_lad48_4 vss 1e-16
Cpt495 px_lad48_5 vss 1e-16
Cpt496 px_lad48_6 vss 1e-16
Cpt497 px_lad48_7 vss 1e-16
Cpt498 px_lad48_8 vss 1e-16
Cpt499 px_lad48_9 vss 1e-16
Cpt500 px_lad49_0 vss 1e-16
Cpt501 px_lad49_1 vss 1e-16
Cpt502 px_lad49_2 vss 1e-16
Cpt503 px_lad49_3 vss 1e-16
Cpt504 px_lad49_4 vss 1e-16
Cpt505 px_lad49_5 vss 1e-16
Cpt506 px_lad49_6 vss 1e-16
Cpt507 px_lad49_7 vss 1e-16
Cpt508 px_lad49_8 vss 1e-16
Cpt509 px_lad49_9 vss 1e-16
Cpt510 px_lad4_0 vss 1e-16
Cpt511 px_lad4_1 vss 1e-16
Cpt512 px_lad4_2 vss 1e-16
Cpt513 px_lad4_3 vss 1e-16
Cpt514 px_lad4_4 vss 1e-16
Cpt515 px_lad4_5 vss 1e-16
Cpt516 px_lad4_6 vss 1e-16
Cpt517 px_lad4_7 vss 1e-16
Cpt518 px_lad4_8 vss 1e-16
Cpt519 px_lad4_9 vss 1e-16
Cpt520 px_lad5_0 vss 1e-16
Cpt521 px_lad5_1 vss 1e-16
Cpt522 px_lad5_2 vss 1e-16
Cpt523 px_lad5_3 vss 1e-16
Cpt524 px_lad5_4 vss 1e-16
Cpt525 px_lad5_5 vss 1e-16
Cpt526 px_lad5_6 vss 1e-16
Cpt527 px_lad5_7 vss 1e-16
Cpt528 px_lad5_8 vss 1e-16
Cpt529 px_lad5_9 vss 1e-16
Cpt530 px_lad6_0 vss 1e-16
Cpt531 px_lad6_1 vss 1e-16
Cpt532 px_lad6_2 vss 1e-16
Cpt533 px_lad6_3 vss 1e-16
Cpt534 px_lad6_4 vss 1e-16
Cpt535 px_lad6_5 vss 1e-16
Cpt536 px_lad6_6 vss 1e-16
Cpt537 px_lad6_7 vss 1e-16
Cpt538 px_lad6_8 vss 1e-16
Cpt539 px_lad6_9 vss 1e-16
Cpt540 px_lad7_0 vss 1e-16
Cpt541 px_lad7_1 vss 1e-16
Cpt542 px_lad7_2 vss 1e-16
Cpt543 px_lad7_3 vss 1e-16
Cpt544 px_lad7_4 vss 1e-16
Cpt545 px_lad7_5 vss 1e-16
Cpt546 px_lad7_6 vss 1e-16
Cpt547 px_lad7_7 vss 1e-16
Cpt548 px_lad7_8 vss 1e-16
Cpt549 px_lad7_9 vss 1e-16
Cpt550 px_lad8_0 vss 1e-16
Cpt551 px_lad8_1 vss 1e-16
Cpt552 px_lad8_2 vss 1e-16
Cpt553 px_lad8_3 vss 1e-16
Cpt554 px_lad8_4 vss 1e-16
Cpt555 px_lad8_5 vss 1e-16
Cpt556 px_lad8_6 vss 1e-16
Cpt557 px_lad8_7 vss 1e-16
Cpt558 px_lad8_8 vss 1e-16
Cpt559 px_lad8_9 vss 1e-16
Cpt560 px_lad9_0 vss 1e-16
Cpt561 px_lad9_1 vss 1e-16
Cpt562 px_lad9_2 vss 1e-16
Cpt563 px_lad9_3 vss 1e-16
Cpt564 px_lad9_4 vss 1e-16
Cpt565 px_lad9_5 vss 1e-16
Cpt566 px_lad9_6 vss 1e-16
Cpt567 px_lad9_7 vss 1e-16
Cpt568 px_lad9_8 vss 1e-16
Cpt569 px_lad9_9 vss 1e-16
Cpt570 sar_mclk vbn 2.64e-16
Cpt571 sar_mclk vbp 3.363e-16
Cpt572 sar_mclk vdd 6.254e-16
Cpt573 sar_mclk vdda 2.78e-16
Cpt574 sar_mclk vref 2.82e-16
Cpt575 sar_mclk vref_in 6.785e-16
Cpt576 sar_mclk vss 9.2332e-15
Cpt577 sar_mclk xcbias_xrb_s1 2.49e-16
Cpt578 sar_mclk xcbias_xrb_s2 1.02e-15
Cpt579 sar_mclk xcbias_xrb_s3 1.041e-15
Cpt580 sar_mclk xcbiasn_xrb_s1 4.03e-16
Cpt581 sar_mclk xcbiasn_xrb_s2 4.554e-16
Cpt582 sar_mclk xcbiasn_xrb_s3 1.8e-16
Cpt583 sar_mclk xckg_d0 3.91e-16
Cpt584 sar_mclk xckg_d1 1.997e-16
Cpt585 sar_mclk xckg_d2 1.2706e-15
Cpt586 sar_mclk xckg_d3 8.236e-16
Cpt587 sar_mclk xckg_nn 2.457e-16
Cpt588 sar_mclk xckg_x 6.77e-16
Cpt589 sar_mclk xref_na 4.36e-16
Cpt590 sar_mclk xref_ng 2.02e-16
Cpt591 sar_mclk xref_ntl 3.68e-16
Cpt592 vbn vbp 1.852e-16
Cpt593 vbn vdd 3.3e-16
Cpt594 vbn vdda 9.77e-16
Cpt595 vbn vref 4.704e-16
Cpt596 vbn vref_in 5.12e-17
Cpt597 vbn vrefl 9.008e-16
Cpt598 vbn vss 1.3062e-14
Cpt599 vbn xcbias_xrb_s1 3.033e-16
Cpt600 vbn xcbias_xrb_s2 6.697e-16
Cpt601 vbn xcbias_xrb_s3 4.97e-16
Cpt602 vbn xcbiasn_xrb_s1 1.0144e-15
Cpt603 vbn xcbiasn_xrb_s2 3.084e-16
Cpt604 vbn xcbiasn_xrb_s3 4.454e-16
Cpt605 vbn xckg_d0 4.107e-16
Cpt606 vbn xckg_d1 4.91e-16
Cpt607 vbn xckg_d2 2.99e-16
Cpt608 vbn xckg_d3 4.98e-16
Cpt609 vbn xckg_nn 1.34e-16
Cpt610 vbn xckg_x 1.593e-16
Cpt611 vbn xref_na 4.57e-16
Cpt612 vbn xref_ng 7.39e-16
Cpt613 vbn xref_ntl 1.85e-16
Cpt614 vbp vdd 4.17e-16
Cpt615 vbp vdda 6.03e-16
Cpt616 vbp vref 3.53e-16
Cpt617 vbp vref_in 1.86e-16
Cpt618 vbp vrefl 6.9e-16
Cpt619 vbp vss 1.0818e-14
Cpt620 vbp xcbias_xrb_s1 5.84e-16
Cpt621 vbp xcbias_xrb_s2 5.34e-17
Cpt622 vbp xcbias_xrb_s3 1.224e-15
Cpt623 vbp xcbiasn_xrb_s1 1.1525e-15
Cpt624 vbp xcbiasn_xrb_s3 3.12e-17
Cpt625 vbp xckg_d0 6.88e-16
Cpt626 vbp xckg_d2 1.33e-16
Cpt627 vbp xckg_d3 3.86e-16
Cpt628 vbp xckg_nn 6.46e-16
Cpt629 vbp xckg_x 1.3e-16
Cpt630 vbp xref_na 6.78e-17
Cpt631 vbp xref_ng 6.849e-16
Cpt632 vdd vdda 2.44e-16
Cpt633 vdd vref 1.89e-16
Cpt634 vdd vref_in 2.567e-16
Cpt635 vdd vrefl 6.32e-17
Cpt636 vdd vss 1.5768e-14
Cpt637 vdd xcbias_xrb_s1 7.763e-16
Cpt638 vdd xcbias_xrb_s2 4.96e-16
Cpt639 vdd xcbiasn_xrb_s2 2.6517e-15
Cpt640 vdd xcbiasn_xrb_s3 2.49e-16
Cpt641 vdd xckg_d0 7.946e-16
Cpt642 vdd xckg_d3 9.77e-17
Cpt643 vdd xckg_nn 1.6e-16
Cpt644 vdd xckg_x 5.401e-16
Cpt645 vdd xref_na 2.79e-16
Cpt646 vdd xref_ng 2.684e-16
Cpt647 vdd xref_ntl 1.61e-16
Cpt648 vdda vref 2.999e-16
Cpt649 vdda vref_in 6.14e-16
Cpt650 vdda vrefl 7.752e-16
Cpt651 vdda vss 7.799e-15
Cpt652 vdda xcbias_xrb_s1 5.38e-16
Cpt653 vdda xcbias_xrb_s2 1.584e-16
Cpt654 vdda xcbias_xrb_s3 5.842e-16
Cpt655 vdda xcbiasn_xrb_s1 9.85e-17
Cpt656 vdda xcbiasn_xrb_s2 9.136e-16
Cpt657 vdda xcbiasn_xrb_s3 7.59e-16
Cpt658 vdda xckg_d1 9.28e-16
Cpt659 vdda xckg_d2 4.58e-16
Cpt660 vdda xckg_d3 1.915e-16
Cpt661 vdda xckg_nn 6.1e-16
Cpt662 vdda xckg_x 2.1e-16
Cpt663 vdda xref_na 2.316e-15
Cpt664 vdda xref_ng 1.99e-16
Cpt665 vdda xref_ntl 3.79e-17
Cpt666 vref vref_in 1.76e-16
Cpt667 vref vss 7.0248e-15
Cpt668 vref xcbias_xrb_s1 2.2e-16
Cpt669 vref xcbias_xrb_s2 5.08e-16
Cpt670 vref xcbias_xrb_s3 1.69e-16
Cpt671 vref xcbiasn_xrb_s1 1.1916e-15
Cpt672 vref xcbiasn_xrb_s2 1.778e-16
Cpt673 vref xcbiasn_xrb_s3 1.95e-16
Cpt674 vref xckg_d1 6.319e-16
Cpt675 vref xckg_d2 9.84e-16
Cpt676 vref xckg_d3 2.79e-16
Cpt677 vref xckg_nn 8.16e-16
Cpt678 vref xckg_x 2.28e-16
Cpt679 vref xref_na 8.258e-16
Cpt680 vref xref_ng 4.83e-16
Cpt681 vref xref_ntl 5.999e-16
Cpt682 vref_in vrefl 1.3412e-15
Cpt683 vref_in vss 8.1237e-15
Cpt684 vref_in xcbias_xrb_s1 1.0387e-15
Cpt685 vref_in xcbias_xrb_s2 1.735e-15
Cpt686 vref_in xcbias_xrb_s3 9.93e-16
Cpt687 vref_in xcbiasn_xrb_s1 1.771e-16
Cpt688 vref_in xcbiasn_xrb_s2 1.2079e-15
Cpt689 vref_in xcbiasn_xrb_s3 6.74e-16
Cpt690 vref_in xckg_d0 3.48e-16
Cpt691 vref_in xckg_d1 5.92e-17
Cpt692 vref_in xckg_d2 5.38e-16
Cpt693 vref_in xckg_d3 5.99e-16
Cpt694 vref_in xckg_nn 6.101e-16
Cpt695 vref_in xckg_x 1.053e-15
Cpt696 vref_in xref_na 5.81e-16
Cpt697 vref_in xref_ng 2.571e-16
Cpt698 vref_in xref_ntl 2.713e-16
Cpt699 vrefl vss 1.33e-14
Cpt700 vrefl xcbias_xrb_s1 1.322e-15
Cpt701 vrefl xcbias_xrb_s2 1.15e-15
Cpt702 vrefl xcbias_xrb_s3 9.11e-17
Cpt703 vrefl xcbiasn_xrb_s1 3.48e-16
Cpt704 vrefl xckg_d0 6.028e-16
Cpt705 vrefl xckg_d1 2.511e-16
Cpt706 vrefl xckg_d2 1.328e-16
Cpt707 vrefl xckg_d3 6.64e-16
Cpt708 vrefl xckg_nn 7.074e-16
Cpt709 vrefl xckg_x 9.17e-16
Cpt710 vrefl xref_na 4.66e-16
Cpt711 vrefl xref_ng 7.258e-16
Cpt712 vrefl xref_ntl 2.64e-16
Cpt713 vss xcbias_xrb_s1 5.4792e-15
Cpt714 vss xcbias_xrb_s2 8.4665e-15
Cpt715 vss xcbias_xrb_s3 9.4649e-15
Cpt716 vss xcbiasn_xrb_s1 9.9862e-15
Cpt717 vss xcbiasn_xrb_s2 1.1112e-14
Cpt718 vss xcbiasn_xrb_s3 1.1496e-14
Cpt719 vss xckg_d0 5.8766e-15
Cpt720 vss xckg_d1 9.229e-15
Cpt721 vss xckg_d2 1.2092e-14
Cpt722 vss xckg_d3 1.0663e-14
Cpt723 vss xckg_nn 8.8254e-15
Cpt724 vss xckg_x 8.6463e-15
Cpt725 vss xref_na 6.9751e-15
Cpt726 vss xref_ng 1.2608e-14
Cpt727 vss xref_ntl 1.0793e-14
Cpt728 xcbias_xrb_s1 xcbias_xrb_s2 5.72e-16
Cpt729 xcbias_xrb_s1 xcbias_xrb_s3 2.65e-16
Cpt730 xcbias_xrb_s1 xcbiasn_xrb_s1 6.899e-16
Cpt731 xcbias_xrb_s1 xcbiasn_xrb_s2 1e-16
Cpt732 xcbias_xrb_s1 xcbiasn_xrb_s3 4.157e-16
Cpt733 xcbias_xrb_s1 xckg_d1 4.05e-16
Cpt734 xcbias_xrb_s1 xckg_d2 1.36e-16
Cpt735 xcbias_xrb_s1 xckg_d3 3.56e-16
Cpt736 xcbias_xrb_s1 xckg_nn 1.485e-16
Cpt737 xcbias_xrb_s1 xckg_x 4.206e-16
Cpt738 xcbias_xrb_s1 xref_na 4e-16
Cpt739 xcbias_xrb_s1 xref_ng 3.367e-16
Cpt740 xcbias_xrb_s1 xref_ntl 3.52e-16
Cpt741 xcbias_xrb_s2 xcbias_xrb_s3 1.5e-16
Cpt742 xcbias_xrb_s2 xcbiasn_xrb_s2 5.83e-17
Cpt743 xcbias_xrb_s2 xcbiasn_xrb_s3 2.82e-17
Cpt744 xcbias_xrb_s2 xckg_d0 9.64e-16
Cpt745 xcbias_xrb_s2 xckg_d2 5.305e-16
Cpt746 xcbias_xrb_s2 xckg_d3 1.011e-15
Cpt747 xcbias_xrb_s2 xckg_nn 8.82e-16
Cpt748 xcbias_xrb_s2 xckg_x 8.05e-16
Cpt749 xcbias_xrb_s2 xref_na 1.2828e-15
Cpt750 xcbias_xrb_s2 xref_ng 4.16e-16
Cpt751 xcbias_xrb_s2 xref_ntl 8.865e-16
Cpt752 xcbias_xrb_s3 xcbiasn_xrb_s1 7.93e-17
Cpt753 xcbias_xrb_s3 xcbiasn_xrb_s3 2.53e-16
Cpt754 xcbias_xrb_s3 xckg_d1 1.952e-16
Cpt755 xcbias_xrb_s3 xckg_d2 4.445e-16
Cpt756 xcbias_xrb_s3 xckg_d3 6.71e-16
Cpt757 xcbias_xrb_s3 xckg_nn 3.97e-16
Cpt758 xcbias_xrb_s3 xckg_x 3.92e-17
Cpt759 xcbias_xrb_s3 xref_na 6.06e-16
Cpt760 xcbias_xrb_s3 xref_ng 5.311e-16
Cpt761 xcbias_xrb_s3 xref_ntl 4.87e-17
Cpt762 xcbiasn_xrb_s1 xcbiasn_xrb_s2 1.0082e-15
Cpt763 xcbiasn_xrb_s1 xcbiasn_xrb_s3 3.46e-16
Cpt764 xcbiasn_xrb_s1 xckg_d0 6.41e-16
Cpt765 xcbiasn_xrb_s1 xckg_d1 7.618e-16
Cpt766 xcbiasn_xrb_s1 xckg_d2 2.023e-16
Cpt767 xcbiasn_xrb_s1 xckg_d3 4.79e-16
Cpt768 xcbiasn_xrb_s1 xckg_nn 2.695e-16
Cpt769 xcbiasn_xrb_s1 xckg_x 5.36e-16
Cpt770 xcbiasn_xrb_s1 xref_na 9.38e-16
Cpt771 xcbiasn_xrb_s1 xref_ng 1.5e-16
Cpt772 xcbiasn_xrb_s1 xref_ntl 9.37e-16
Cpt773 xcbiasn_xrb_s2 xcbiasn_xrb_s3 7.01e-17
Cpt774 xcbiasn_xrb_s2 xckg_d0 7.08e-17
Cpt775 xcbiasn_xrb_s2 xckg_d1 4.484e-16
Cpt776 xcbiasn_xrb_s2 xckg_d2 5.15e-16
Cpt777 xcbiasn_xrb_s2 xckg_d3 4.539e-16
Cpt778 xcbiasn_xrb_s2 xckg_nn 5.931e-16
Cpt779 xcbiasn_xrb_s2 xckg_x 2.5e-16
Cpt780 xcbiasn_xrb_s2 xref_na 1.6086e-15
Cpt781 xcbiasn_xrb_s2 xref_ng 1.0518e-15
Cpt782 xcbiasn_xrb_s2 xref_ntl 5.07e-16
Cpt783 xcbiasn_xrb_s3 xckg_d0 4.16e-16
Cpt784 xcbiasn_xrb_s3 xckg_d1 6.5e-16
Cpt785 xcbiasn_xrb_s3 xckg_d2 5.37e-16
Cpt786 xcbiasn_xrb_s3 xckg_d3 3.21e-16
Cpt787 xcbiasn_xrb_s3 xckg_nn 1.941e-16
Cpt788 xcbiasn_xrb_s3 xckg_x 9.317e-16
Cpt789 xcbiasn_xrb_s3 xref_na 1.537e-15
Cpt790 xcbiasn_xrb_s3 xref_ng 2.81e-16
Cpt791 xcbiasn_xrb_s3 xref_ntl 3e-16
Cpt792 xckg_d0 xckg_d2 4.39e-16
Cpt793 xckg_d0 xckg_d3 7.375e-16
Cpt794 xckg_d0 xckg_nn 1.5869e-15
Cpt795 xckg_d0 xckg_x 7.39e-16
Cpt796 xckg_d0 xref_na 4.702e-16
Cpt797 xckg_d0 xref_ng 1.022e-15
Cpt798 xckg_d0 xref_ntl 2.58e-16
Cpt799 xckg_d1 xckg_d2 1.32e-16
Cpt800 xckg_d1 xckg_d3 3.08e-16
Cpt801 xckg_d1 xckg_nn 2.24e-16
Cpt802 xckg_d1 xckg_x 6.44e-16
Cpt803 xckg_d1 xref_na 6.5e-17
Cpt804 xckg_d1 xref_ng 8.152e-16
Cpt805 xckg_d2 xckg_d3 2.52e-16
Cpt806 xckg_d2 xckg_nn 7.16e-16
Cpt807 xckg_d2 xckg_x 5.94e-16
Cpt808 xckg_d2 xref_na 3.636e-16
Cpt809 xckg_d2 xref_ntl 9.9e-17
Cpt810 xckg_d3 xckg_nn 2.486e-16
Cpt811 xckg_d3 xckg_x 4.639e-16
Cpt812 xckg_d3 xref_na 5.48e-16
Cpt813 xckg_d3 xref_ng 7.914e-16
Cpt814 xckg_d3 xref_ntl 2.51e-16
Cpt815 xckg_nn xckg_x 8.66e-17
Cpt816 xckg_nn xref_na 4.687e-16
Cpt817 xckg_nn xref_ng 3.786e-16
Cpt818 xckg_nn xref_ntl 6.65e-16
Cpt819 xckg_x xref_na 8.032e-16
Cpt820 xckg_x xref_ng 1.7827e-15
Cpt821 xckg_x xref_ntl 2.131e-16
Cpt822 xref_na xref_ng 3.28e-16
Cpt823 xref_na xref_ntl 5.46e-16
Cpt824 xref_ng xref_ntl 1.5821e-15
Rpt0 xckg_x px_lad0_0 15.8
Rpt1 px_lad0_0 px_lad0_1 3.34
Rpt2 px_lad0_1 px_lad0_2 7.83
Rpt3 px_lad0_2 px_lad0_3 17.4
Rpt4 px_lad0_3 px_lad0_4 1.91
Rpt5 px_lad0_4 px_lad0_5 2.42
Rpt6 px_lad0_5 px_lad0_6 5.31
Rpt7 px_lad0_6 px_lad0_7 7.68
Rpt8 px_lad0_7 px_lad0_8 12.5
Rpt9 px_lad0_8 px_lad0_9 19.9
Rpt10 xcbiasn_xrb_s1 px_lad1_0 19.4
Rpt11 px_lad1_0 px_lad1_1 9.84
Rpt12 px_lad1_1 px_lad1_2 3.76
Rpt13 px_lad1_2 px_lad1_3 4.3
Rpt14 px_lad1_3 px_lad1_4 13.5
Rpt15 px_lad1_4 px_lad1_5 3.99
Rpt16 px_lad1_5 px_lad1_6 7.94
Rpt17 px_lad1_6 px_lad1_7 17
Rpt18 px_lad1_7 px_lad1_8 11.6
Rpt19 px_lad1_8 px_lad1_9 2.63
Rpt20 xref_ng px_lad2_0 18.5
Rpt21 px_lad2_0 px_lad2_1 12.2
Rpt22 px_lad2_1 px_lad2_2 17.5
Rpt23 px_lad2_2 px_lad2_3 16.1
Rpt24 px_lad2_3 px_lad2_4 8.84
Rpt25 px_lad2_4 px_lad2_5 16.5
Rpt26 px_lad2_5 px_lad2_6 17.6
Rpt27 px_lad2_6 px_lad2_7 8.04
Rpt28 px_lad2_7 px_lad2_8 5.87
Rpt29 px_lad2_8 px_lad2_9 8.77
Rpt30 vref px_lad3_0 12.8
Rpt31 px_lad3_0 px_lad3_1 10.1
Rpt32 px_lad3_1 px_lad3_2 3.77
Rpt33 px_lad3_2 px_lad3_3 19.5
Rpt34 px_lad3_3 px_lad3_4 18
Rpt35 px_lad3_4 px_lad3_5 17.8
Rpt36 px_lad3_5 px_lad3_6 17.4
Rpt37 px_lad3_6 px_lad3_7 4.66
Rpt38 px_lad3_7 px_lad3_8 15
Rpt39 px_lad3_8 px_lad3_9 9.22
Rpt40 xcbiasn_xrb_s1 px_lad4_0 15.2
Rpt41 px_lad4_0 px_lad4_1 14.7
Rpt42 px_lad4_1 px_lad4_2 13.8
Rpt43 px_lad4_2 px_lad4_3 10.7
Rpt44 px_lad4_3 px_lad4_4 14.8
Rpt45 px_lad4_4 px_lad4_5 11.9
Rpt46 px_lad4_5 px_lad4_6 19.7
Rpt47 px_lad4_6 px_lad4_7 3.58
Rpt48 px_lad4_7 px_lad4_8 1.16
Rpt49 px_lad4_8 px_lad4_9 7.01
Rpt50 xckg_d0 px_lad5_0 7.61
Rpt51 px_lad5_0 px_lad5_1 9.95
Rpt52 px_lad5_1 px_lad5_2 11.1
Rpt53 px_lad5_2 px_lad5_3 13.8
Rpt54 px_lad5_3 px_lad5_4 16.3
Rpt55 px_lad5_4 px_lad5_5 14.1
Rpt56 px_lad5_5 px_lad5_6 7.37
Rpt57 px_lad5_6 px_lad5_7 19.6
Rpt58 px_lad5_7 px_lad5_8 2.01
Rpt59 px_lad5_8 px_lad5_9 9.24
Rpt60 xcbiasn_xrb_s3 px_lad6_0 17.2
Rpt61 px_lad6_0 px_lad6_1 6.89
Rpt62 px_lad6_1 px_lad6_2 9.07
Rpt63 px_lad6_2 px_lad6_3 11.3
Rpt64 px_lad6_3 px_lad6_4 9.5
Rpt65 px_lad6_4 px_lad6_5 5.67
Rpt66 px_lad6_5 px_lad6_6 19.9
Rpt67 px_lad6_6 px_lad6_7 5.12
Rpt68 px_lad6_7 px_lad6_8 17
Rpt69 px_lad6_8 px_lad6_9 3.07
Rpt70 xcbias_xrb_s3 px_lad7_0 7
Rpt71 px_lad7_0 px_lad7_1 15.9
Rpt72 px_lad7_1 px_lad7_2 15
Rpt73 px_lad7_2 px_lad7_3 16.8
Rpt74 px_lad7_3 px_lad7_4 14.1
Rpt75 px_lad7_4 px_lad7_5 12.4
Rpt76 px_lad7_5 px_lad7_6 18.3
Rpt77 px_lad7_6 px_lad7_7 10.4
Rpt78 px_lad7_7 px_lad7_8 16.2
Rpt79 px_lad7_8 px_lad7_9 13.9
Rpt80 xcbiasn_xrb_s2 px_lad8_0 1.94
Rpt81 px_lad8_0 px_lad8_1 4.1
Rpt82 px_lad8_1 px_lad8_2 18.8
Rpt83 px_lad8_2 px_lad8_3 2.17
Rpt84 px_lad8_3 px_lad8_4 16.2
Rpt85 px_lad8_4 px_lad8_5 2.9
Rpt86 px_lad8_5 px_lad8_6 19.1
Rpt87 px_lad8_6 px_lad8_7 1.19
Rpt88 px_lad8_7 px_lad8_8 7.66
Rpt89 px_lad8_8 px_lad8_9 3.76
Rpt90 clk px_lad9_0 2.3
Rpt91 px_lad9_0 px_lad9_1 17.8
Rpt92 px_lad9_1 px_lad9_2 19.2
Rpt93 px_lad9_2 px_lad9_3 14.4
Rpt94 px_lad9_3 px_lad9_4 9.91
Rpt95 px_lad9_4 px_lad9_5 17.8
Rpt96 px_lad9_5 px_lad9_6 10.1
Rpt97 px_lad9_6 px_lad9_7 11.2
Rpt98 px_lad9_7 px_lad9_8 15.8
Rpt99 px_lad9_8 px_lad9_9 12.8
Rpt100 vss px_lad10_0 17.7
Rpt101 px_lad10_0 px_lad10_1 11.4
Rpt102 px_lad10_1 px_lad10_2 11.6
Rpt103 px_lad10_2 px_lad10_3 2.25
Rpt104 px_lad10_3 px_lad10_4 2.41
Rpt105 px_lad10_4 px_lad10_5 15.4
Rpt106 px_lad10_5 px_lad10_6 12.9
Rpt107 px_lad10_6 px_lad10_7 14.5
Rpt108 px_lad10_7 px_lad10_8 14.5
Rpt109 px_lad10_8 px_lad10_9 14
Rpt110 xcbias_xrb_s1 px_lad11_0 19.4
Rpt111 px_lad11_0 px_lad11_1 12.5
Rpt112 px_lad11_1 px_lad11_2 12.7
Rpt113 px_lad11_2 px_lad11_3 12.5
Rpt114 px_lad11_3 px_lad11_4 5.76
Rpt115 px_lad11_4 px_lad11_5 4.72
Rpt116 px_lad11_5 px_lad11_6 10.3
Rpt117 px_lad11_6 px_lad11_7 15.1
Rpt118 px_lad11_7 px_lad11_8 18.6
Rpt119 px_lad11_8 px_lad11_9 3.23
Rpt120 mclkb px_lad12_0 14.1
Rpt121 px_lad12_0 px_lad12_1 14.7
Rpt122 px_lad12_1 px_lad12_2 4.56
Rpt123 px_lad12_2 px_lad12_3 19.2
Rpt124 px_lad12_3 px_lad12_4 3.22
Rpt125 px_lad12_4 px_lad12_5 15.1
Rpt126 px_lad12_5 px_lad12_6 1.7
Rpt127 px_lad12_6 px_lad12_7 12.5
Rpt128 px_lad12_7 px_lad12_8 5.02
Rpt129 px_lad12_8 px_lad12_9 14.2
Rpt130 xckg_nn px_lad13_0 19
Rpt131 px_lad13_0 px_lad13_1 3.46
Rpt132 px_lad13_1 px_lad13_2 15.1
Rpt133 px_lad13_2 px_lad13_3 11.8
Rpt134 px_lad13_3 px_lad13_4 17.6
Rpt135 px_lad13_4 px_lad13_5 2.14
Rpt136 px_lad13_5 px_lad13_6 4.95
Rpt137 px_lad13_6 px_lad13_7 6.21
Rpt138 px_lad13_7 px_lad13_8 1.21
Rpt139 px_lad13_8 px_lad13_9 16.7
Rpt140 xckg_nn px_lad14_0 13.9
Rpt141 px_lad14_0 px_lad14_1 18.7
Rpt142 px_lad14_1 px_lad14_2 7.95
Rpt143 px_lad14_2 px_lad14_3 14.5
Rpt144 px_lad14_3 px_lad14_4 19.8
Rpt145 px_lad14_4 px_lad14_5 19.9
Rpt146 px_lad14_5 px_lad14_6 5.74
Rpt147 px_lad14_6 px_lad14_7 6.12
Rpt148 px_lad14_7 px_lad14_8 13.8
Rpt149 px_lad14_8 px_lad14_9 18.2
Rpt150 xcbias_xrb_s1 px_lad15_0 10.9
Rpt151 px_lad15_0 px_lad15_1 2.44
Rpt152 px_lad15_1 px_lad15_2 15.8
Rpt153 px_lad15_2 px_lad15_3 19.4
Rpt154 px_lad15_3 px_lad15_4 18.2
Rpt155 px_lad15_4 px_lad15_5 4.54
Rpt156 px_lad15_5 px_lad15_6 4.38
Rpt157 px_lad15_6 px_lad15_7 15.6
Rpt158 px_lad15_7 px_lad15_8 11.4
Rpt159 px_lad15_8 px_lad15_9 10.6
Rpt160 xref_ntl px_lad16_0 6.2
Rpt161 px_lad16_0 px_lad16_1 5.19
Rpt162 px_lad16_1 px_lad16_2 11.9
Rpt163 px_lad16_2 px_lad16_3 8.01
Rpt164 px_lad16_3 px_lad16_4 3.66
Rpt165 px_lad16_4 px_lad16_5 7.14
Rpt166 px_lad16_5 px_lad16_6 11.6
Rpt167 px_lad16_6 px_lad16_7 7.73
Rpt168 px_lad16_7 px_lad16_8 3.56
Rpt169 px_lad16_8 px_lad16_9 4.42
Rpt170 vbn px_lad17_0 8.45
Rpt171 px_lad17_0 px_lad17_1 9.67
Rpt172 px_lad17_1 px_lad17_2 16.9
Rpt173 px_lad17_2 px_lad17_3 12.7
Rpt174 px_lad17_3 px_lad17_4 13.4
Rpt175 px_lad17_4 px_lad17_5 6.14
Rpt176 px_lad17_5 px_lad17_6 1.78
Rpt177 px_lad17_6 px_lad17_7 5.3
Rpt178 px_lad17_7 px_lad17_8 8.87
Rpt179 px_lad17_8 px_lad17_9 3.19
Rpt180 xckg_x px_lad18_0 18.6
Rpt181 px_lad18_0 px_lad18_1 18.5
Rpt182 px_lad18_1 px_lad18_2 10.2
Rpt183 px_lad18_2 px_lad18_3 1.53
Rpt184 px_lad18_3 px_lad18_4 19.4
Rpt185 px_lad18_4 px_lad18_5 6.84
Rpt186 px_lad18_5 px_lad18_6 13.7
Rpt187 px_lad18_6 px_lad18_7 16.9
Rpt188 px_lad18_7 px_lad18_8 18.2
Rpt189 px_lad18_8 px_lad18_9 11.2
Rpt190 xcbiasn_xrb_s2 px_lad19_0 1.87
Rpt191 px_lad19_0 px_lad19_1 16.8
Rpt192 px_lad19_1 px_lad19_2 8.64
Rpt193 px_lad19_2 px_lad19_3 5.66
Rpt194 px_lad19_3 px_lad19_4 3.91
Rpt195 px_lad19_4 px_lad19_5 6.81
Rpt196 px_lad19_5 px_lad19_6 3.13
Rpt197 px_lad19_6 px_lad19_7 7.03
Rpt198 px_lad19_7 px_lad19_8 18.5
Rpt199 px_lad19_8 px_lad19_9 3.12
Rpt200 vbp px_lad20_0 1.25
Rpt201 px_lad20_0 px_lad20_1 3.15
Rpt202 px_lad20_1 px_lad20_2 2.37
Rpt203 px_lad20_2 px_lad20_3 11.7
Rpt204 px_lad20_3 px_lad20_4 15.4
Rpt205 px_lad20_4 px_lad20_5 13
Rpt206 px_lad20_5 px_lad20_6 3.74
Rpt207 px_lad20_6 px_lad20_7 17
Rpt208 px_lad20_7 px_lad20_8 14.3
Rpt209 px_lad20_8 px_lad20_9 19.4
Rpt210 ibias px_lad21_0 14.3
Rpt211 px_lad21_0 px_lad21_1 11.8
Rpt212 px_lad21_1 px_lad21_2 10.9
Rpt213 px_lad21_2 px_lad21_3 3.59
Rpt214 px_lad21_3 px_lad21_4 3.73
Rpt215 px_lad21_4 px_lad21_5 8.22
Rpt216 px_lad21_5 px_lad21_6 19.8
Rpt217 px_lad21_6 px_lad21_7 1.03
Rpt218 px_lad21_7 px_lad21_8 9.05
Rpt219 px_lad21_8 px_lad21_9 1.72
Rpt220 xckg_d1 px_lad22_0 15.1
Rpt221 px_lad22_0 px_lad22_1 10.4
Rpt222 px_lad22_1 px_lad22_2 3.9
Rpt223 px_lad22_2 px_lad22_3 18.5
Rpt224 px_lad22_3 px_lad22_4 14.5
Rpt225 px_lad22_4 px_lad22_5 5.57
Rpt226 px_lad22_5 px_lad22_6 2.63
Rpt227 px_lad22_6 px_lad22_7 1.82
Rpt228 px_lad22_7 px_lad22_8 10.3
Rpt229 px_lad22_8 px_lad22_9 6.2
Rpt230 vref px_lad23_0 18.1
Rpt231 px_lad23_0 px_lad23_1 1.49
Rpt232 px_lad23_1 px_lad23_2 1.83
Rpt233 px_lad23_2 px_lad23_3 15.8
Rpt234 px_lad23_3 px_lad23_4 18.1
Rpt235 px_lad23_4 px_lad23_5 14.6
Rpt236 px_lad23_5 px_lad23_6 10.8
Rpt237 px_lad23_6 px_lad23_7 15.2
Rpt238 px_lad23_7 px_lad23_8 12.6
Rpt239 px_lad23_8 px_lad23_9 13
Rpt240 sar_mclk px_lad24_0 18.7
Rpt241 px_lad24_0 px_lad24_1 10.3
Rpt242 px_lad24_1 px_lad24_2 18.8
Rpt243 px_lad24_2 px_lad24_3 9.6
Rpt244 px_lad24_3 px_lad24_4 14.8
Rpt245 px_lad24_4 px_lad24_5 11.6
Rpt246 px_lad24_5 px_lad24_6 8.59
Rpt247 px_lad24_6 px_lad24_7 16
Rpt248 px_lad24_7 px_lad24_8 3.48
Rpt249 px_lad24_8 px_lad24_9 7.45
Rpt250 xckg_d0 px_lad25_0 15
Rpt251 px_lad25_0 px_lad25_1 15.1
Rpt252 px_lad25_1 px_lad25_2 1.94
Rpt253 px_lad25_2 px_lad25_3 14.2
Rpt254 px_lad25_3 px_lad25_4 6.02
Rpt255 px_lad25_4 px_lad25_5 4.97
Rpt256 px_lad25_5 px_lad25_6 18.8
Rpt257 px_lad25_6 px_lad25_7 20
Rpt258 px_lad25_7 px_lad25_8 14.1
Rpt259 px_lad25_8 px_lad25_9 14
Rpt260 vdd px_lad26_0 10.9
Rpt261 px_lad26_0 px_lad26_1 2.54
Rpt262 px_lad26_1 px_lad26_2 2.57
Rpt263 px_lad26_2 px_lad26_3 8.25
Rpt264 px_lad26_3 px_lad26_4 9.57
Rpt265 px_lad26_4 px_lad26_5 4.81
Rpt266 px_lad26_5 px_lad26_6 7.45
Rpt267 px_lad26_6 px_lad26_7 11.1
Rpt268 px_lad26_7 px_lad26_8 14.4
Rpt269 px_lad26_8 px_lad26_9 15.8
Rpt270 xckg_d2 px_lad27_0 5.6
Rpt271 px_lad27_0 px_lad27_1 14.1
Rpt272 px_lad27_1 px_lad27_2 17.2
Rpt273 px_lad27_2 px_lad27_3 5.9
Rpt274 px_lad27_3 px_lad27_4 8.71
Rpt275 px_lad27_4 px_lad27_5 9.31
Rpt276 px_lad27_5 px_lad27_6 15.2
Rpt277 px_lad27_6 px_lad27_7 1.59
Rpt278 px_lad27_7 px_lad27_8 3.44
Rpt279 px_lad27_8 px_lad27_9 17.2
Rpt280 xcbias_xrb_s1 px_lad28_0 1.03
Rpt281 px_lad28_0 px_lad28_1 17.4
Rpt282 px_lad28_1 px_lad28_2 13.3
Rpt283 px_lad28_2 px_lad28_3 12
Rpt284 px_lad28_3 px_lad28_4 15.3
Rpt285 px_lad28_4 px_lad28_5 2.38
Rpt286 px_lad28_5 px_lad28_6 2.09
Rpt287 px_lad28_6 px_lad28_7 17
Rpt288 px_lad28_7 px_lad28_8 12.5
Rpt289 px_lad28_8 px_lad28_9 4.21
Rpt290 vbp px_lad29_0 11.6
Rpt291 px_lad29_0 px_lad29_1 6.63
Rpt292 px_lad29_1 px_lad29_2 9
Rpt293 px_lad29_2 px_lad29_3 10.6
Rpt294 px_lad29_3 px_lad29_4 1.71
Rpt295 px_lad29_4 px_lad29_5 6.66
Rpt296 px_lad29_5 px_lad29_6 14.2
Rpt297 px_lad29_6 px_lad29_7 7.77
Rpt298 px_lad29_7 px_lad29_8 4.69
Rpt299 px_lad29_8 px_lad29_9 1
Rpt300 vdda px_lad30_0 15.7
Rpt301 px_lad30_0 px_lad30_1 2.36
Rpt302 px_lad30_1 px_lad30_2 12.1
Rpt303 px_lad30_2 px_lad30_3 12.1
Rpt304 px_lad30_3 px_lad30_4 14.9
Rpt305 px_lad30_4 px_lad30_5 19.1
Rpt306 px_lad30_5 px_lad30_6 13.1
Rpt307 px_lad30_6 px_lad30_7 11.7
Rpt308 px_lad30_7 px_lad30_8 6.35
Rpt309 px_lad30_8 px_lad30_9 10.8
Rpt310 vref px_lad31_0 8.92
Rpt311 px_lad31_0 px_lad31_1 16
Rpt312 px_lad31_1 px_lad31_2 1.42
Rpt313 px_lad31_2 px_lad31_3 1.93
Rpt314 px_lad31_3 px_lad31_4 4.58
Rpt315 px_lad31_4 px_lad31_5 3.86
Rpt316 px_lad31_5 px_lad31_6 5.27
Rpt317 px_lad31_6 px_lad31_7 5.76
Rpt318 px_lad31_7 px_lad31_8 12.1
Rpt319 px_lad31_8 px_lad31_9 19.2
Rpt320 vbp px_lad32_0 17.9
Rpt321 px_lad32_0 px_lad32_1 18.6
Rpt322 px_lad32_1 px_lad32_2 17.4
Rpt323 px_lad32_2 px_lad32_3 17.1
Rpt324 px_lad32_3 px_lad32_4 5.42
Rpt325 px_lad32_4 px_lad32_5 9.99
Rpt326 px_lad32_5 px_lad32_6 7.15
Rpt327 px_lad32_6 px_lad32_7 16.1
Rpt328 px_lad32_7 px_lad32_8 9.11
Rpt329 px_lad32_8 px_lad32_9 12.7
Rpt330 xcbiasn_xrb_s2 px_lad33_0 13.8
Rpt331 px_lad33_0 px_lad33_1 11.7
Rpt332 px_lad33_1 px_lad33_2 11.4
Rpt333 px_lad33_2 px_lad33_3 12
Rpt334 px_lad33_3 px_lad33_4 2.97
Rpt335 px_lad33_4 px_lad33_5 2.36
Rpt336 px_lad33_5 px_lad33_6 12.1
Rpt337 px_lad33_6 px_lad33_7 4.68
Rpt338 px_lad33_7 px_lad33_8 1.58
Rpt339 px_lad33_8 px_lad33_9 14.3
Rpt340 vss px_lad34_0 2.68
Rpt341 px_lad34_0 px_lad34_1 18.8
Rpt342 px_lad34_1 px_lad34_2 2.49
Rpt343 px_lad34_2 px_lad34_3 6.94
Rpt344 px_lad34_3 px_lad34_4 12.2
Rpt345 px_lad34_4 px_lad34_5 1.32
Rpt346 px_lad34_5 px_lad34_6 13.8
Rpt347 px_lad34_6 px_lad34_7 4.68
Rpt348 px_lad34_7 px_lad34_8 5.43
Rpt349 px_lad34_8 px_lad34_9 9.13
Rpt350 xcbiasn_xrb_s2 px_lad35_0 17.2
Rpt351 px_lad35_0 px_lad35_1 5.6
Rpt352 px_lad35_1 px_lad35_2 5.62
Rpt353 px_lad35_2 px_lad35_3 17.8
Rpt354 px_lad35_3 px_lad35_4 12.2
Rpt355 px_lad35_4 px_lad35_5 3.07
Rpt356 px_lad35_5 px_lad35_6 10.8
Rpt357 px_lad35_6 px_lad35_7 4.17
Rpt358 px_lad35_7 px_lad35_8 7.13
Rpt359 px_lad35_8 px_lad35_9 3.44
Rpt360 clk px_lad36_0 3.68
Rpt361 px_lad36_0 px_lad36_1 13.3
Rpt362 px_lad36_1 px_lad36_2 18.8
Rpt363 px_lad36_2 px_lad36_3 1.45
Rpt364 px_lad36_3 px_lad36_4 7.69
Rpt365 px_lad36_4 px_lad36_5 17.6
Rpt366 px_lad36_5 px_lad36_6 6.33
Rpt367 px_lad36_6 px_lad36_7 18.9
Rpt368 px_lad36_7 px_lad36_8 7.95
Rpt369 px_lad36_8 px_lad36_9 12.3
Rpt370 vref_in px_lad37_0 1.97
Rpt371 px_lad37_0 px_lad37_1 11.1
Rpt372 px_lad37_1 px_lad37_2 13.4
Rpt373 px_lad37_2 px_lad37_3 12.7
Rpt374 px_lad37_3 px_lad37_4 19.9
Rpt375 px_lad37_4 px_lad37_5 8.81
Rpt376 px_lad37_5 px_lad37_6 6.49
Rpt377 px_lad37_6 px_lad37_7 7.66
Rpt378 px_lad37_7 px_lad37_8 10.9
Rpt379 px_lad37_8 px_lad37_9 19.9
Rpt380 xckg_d0 px_lad38_0 9.29
Rpt381 px_lad38_0 px_lad38_1 15.9
Rpt382 px_lad38_1 px_lad38_2 16
Rpt383 px_lad38_2 px_lad38_3 13.9
Rpt384 px_lad38_3 px_lad38_4 7.78
Rpt385 px_lad38_4 px_lad38_5 11.7
Rpt386 px_lad38_5 px_lad38_6 7.83
Rpt387 px_lad38_6 px_lad38_7 10.5
Rpt388 px_lad38_7 px_lad38_8 14.6
Rpt389 px_lad38_8 px_lad38_9 15.9
Rpt390 xckg_d2 px_lad39_0 8.75
Rpt391 px_lad39_0 px_lad39_1 4.94
Rpt392 px_lad39_1 px_lad39_2 6.99
Rpt393 px_lad39_2 px_lad39_3 15.8
Rpt394 px_lad39_3 px_lad39_4 1.32
Rpt395 px_lad39_4 px_lad39_5 19.7
Rpt396 px_lad39_5 px_lad39_6 1.49
Rpt397 px_lad39_6 px_lad39_7 9.32
Rpt398 px_lad39_7 px_lad39_8 19.5
Rpt399 px_lad39_8 px_lad39_9 8.74
Rpt400 vref px_lad40_0 16.8
Rpt401 px_lad40_0 px_lad40_1 7.16
Rpt402 px_lad40_1 px_lad40_2 5.78
Rpt403 px_lad40_2 px_lad40_3 15
Rpt404 px_lad40_3 px_lad40_4 11.9
Rpt405 px_lad40_4 px_lad40_5 13.1
Rpt406 px_lad40_5 px_lad40_6 14.6
Rpt407 px_lad40_6 px_lad40_7 10.6
Rpt408 px_lad40_7 px_lad40_8 7.87
Rpt409 px_lad40_8 px_lad40_9 17.8
Rpt410 ibias px_lad41_0 19.4
Rpt411 px_lad41_0 px_lad41_1 11.9
Rpt412 px_lad41_1 px_lad41_2 5.53
Rpt413 px_lad41_2 px_lad41_3 15.9
Rpt414 px_lad41_3 px_lad41_4 18.4
Rpt415 px_lad41_4 px_lad41_5 11.2
Rpt416 px_lad41_5 px_lad41_6 5.94
Rpt417 px_lad41_6 px_lad41_7 18.9
Rpt418 px_lad41_7 px_lad41_8 18.3
Rpt419 px_lad41_8 px_lad41_9 16.3
Rpt420 xckg_d0 px_lad42_0 1.55
Rpt421 px_lad42_0 px_lad42_1 1.37
Rpt422 px_lad42_1 px_lad42_2 14.4
Rpt423 px_lad42_2 px_lad42_3 17.1
Rpt424 px_lad42_3 px_lad42_4 2.63
Rpt425 px_lad42_4 px_lad42_5 17.7
Rpt426 px_lad42_5 px_lad42_6 10
Rpt427 px_lad42_6 px_lad42_7 16.4
Rpt428 px_lad42_7 px_lad42_8 12.1
Rpt429 px_lad42_8 px_lad42_9 13
Rpt430 xcbiasn_xrb_s2 px_lad43_0 6.39
Rpt431 px_lad43_0 px_lad43_1 1.56
Rpt432 px_lad43_1 px_lad43_2 19.7
Rpt433 px_lad43_2 px_lad43_3 9
Rpt434 px_lad43_3 px_lad43_4 12.3
Rpt435 px_lad43_4 px_lad43_5 6.16
Rpt436 px_lad43_5 px_lad43_6 8.1
Rpt437 px_lad43_6 px_lad43_7 1.96
Rpt438 px_lad43_7 px_lad43_8 11.4
Rpt439 px_lad43_8 px_lad43_9 6.77
Rpt440 vdda px_lad44_0 8.29
Rpt441 px_lad44_0 px_lad44_1 10.3
Rpt442 px_lad44_1 px_lad44_2 5.79
Rpt443 px_lad44_2 px_lad44_3 17.7
Rpt444 px_lad44_3 px_lad44_4 15.2
Rpt445 px_lad44_4 px_lad44_5 12.2
Rpt446 px_lad44_5 px_lad44_6 16.1
Rpt447 px_lad44_6 px_lad44_7 4.62
Rpt448 px_lad44_7 px_lad44_8 19
Rpt449 px_lad44_8 px_lad44_9 8.63
Rpt450 xref_ntl px_lad45_0 3.61
Rpt451 px_lad45_0 px_lad45_1 5.62
Rpt452 px_lad45_1 px_lad45_2 11.6
Rpt453 px_lad45_2 px_lad45_3 8.57
Rpt454 px_lad45_3 px_lad45_4 4.97
Rpt455 px_lad45_4 px_lad45_5 15
Rpt456 px_lad45_5 px_lad45_6 15
Rpt457 px_lad45_6 px_lad45_7 16.8
Rpt458 px_lad45_7 px_lad45_8 2.1
Rpt459 px_lad45_8 px_lad45_9 6.95
Rpt460 xcbiasn_xrb_s3 px_lad46_0 16.1
Rpt461 px_lad46_0 px_lad46_1 3.16
Rpt462 px_lad46_1 px_lad46_2 3.09
Rpt463 px_lad46_2 px_lad46_3 12.8
Rpt464 px_lad46_3 px_lad46_4 8.25
Rpt465 px_lad46_4 px_lad46_5 10.2
Rpt466 px_lad46_5 px_lad46_6 11.4
Rpt467 px_lad46_6 px_lad46_7 2.91
Rpt468 px_lad46_7 px_lad46_8 10.2
Rpt469 px_lad46_8 px_lad46_9 16.8
Rpt470 xcbias_xrb_s1 px_lad47_0 13.4
Rpt471 px_lad47_0 px_lad47_1 10.2
Rpt472 px_lad47_1 px_lad47_2 6.17
Rpt473 px_lad47_2 px_lad47_3 19.3
Rpt474 px_lad47_3 px_lad47_4 11.2
Rpt475 px_lad47_4 px_lad47_5 12.3
Rpt476 px_lad47_5 px_lad47_6 3.11
Rpt477 px_lad47_6 px_lad47_7 13.3
Rpt478 px_lad47_7 px_lad47_8 10.4
Rpt479 px_lad47_8 px_lad47_9 8.2
Rpt480 xcbias_xrb_s1 px_lad48_0 10.3
Rpt481 px_lad48_0 px_lad48_1 7
Rpt482 px_lad48_1 px_lad48_2 18.7
Rpt483 px_lad48_2 px_lad48_3 9.24
Rpt484 px_lad48_3 px_lad48_4 11.5
Rpt485 px_lad48_4 px_lad48_5 15.5
Rpt486 px_lad48_5 px_lad48_6 12.6
Rpt487 px_lad48_6 px_lad48_7 1.67
Rpt488 px_lad48_7 px_lad48_8 13.7
Rpt489 px_lad48_8 px_lad48_9 2.03
Rpt490 xref_na px_lad49_0 8.24
Rpt491 px_lad49_0 px_lad49_1 2.06
Rpt492 px_lad49_1 px_lad49_2 3.94
Rpt493 px_lad49_2 px_lad49_3 14.9
Rpt494 px_lad49_3 px_lad49_4 13.4
Rpt495 px_lad49_4 px_lad49_5 4.71
Rpt496 px_lad49_5 px_lad49_6 8.7
Rpt497 px_lad49_6 px_lad49_7 7.46
Rpt498 px_lad49_7 px_lad49_8 14.2
Rpt499 px_lad49_8 px_lad49_9 2.53
.ends
