* synthetic parasitics (make_synth_pex.py, seed 7): 4000 C, 0 RC ladders of 10
C0 cp12 VSUBS 0.0333f
C1 bp7 VSUBS 0.106f
C2 xs1n_n10 VSUBS 0.152f
C3 cp2 cp1 0.113f
C4 bn0 VSUBS 0.225f
C5 cp1 VSUBS 0.122f
C6 gnd cp7 0.0771f
C7 cn12 VSUBS 0.297f
C8 vbn xs1n_n10 0.159f
C9 t1 VSUBS 0.0619f
C10 bn1 VSUBS 0.145f
C11 xc5_lt bp7 0.047f
C12 bn7 VSUBS 0.236f
C13 xc5_lt VSUBS 0.142f
C14 bp5 VSUBS 0.0333f
C15 xs0n_cbn VSUBS 0.218f
C16 bn12 VSUBS 0.181f
C17 t1b VSUBS 0.145f
C18 cn1 VSUBS 0.69f
C19 op VSUBS 0.0651f
C20 cp12 VSUBS 0.186f
C21 trk0 bp1 0.0986f
C22 bp4 bp10 0.21f
C23 cp0 VSUBS 0.0687f
C24 cp8 xc4_outpb 0.413f
C25 clknb VSUBS 0.407f
C26 vbp VSUBS 0.564f
C27 vref VSUBS 0.0738f
C28 rstb_n xs0p_n10 0.0521f
C29 lsb_p bn9 0.0265f
C30 bn3 VSUBS 0.199f
C31 xs1p_cbp xs0p_x 0.184f
C32 bp12 VSUBS 0.0497f
C33 xs0p_g VSUBS 0.0436f
C34 cp12 VSUBS 0.212f
C35 trk0 VSUBS 0.227f
C36 bn3 VSUBS 0.26f
C37 xc5_lt cp9 0.145f
C38 bn9 VSUBS 0.0619f
C39 cn8 VSUBS 0.0221f
C40 cp0 nr 0.0547f
C41 trk1 VSUBS 0.198f
C42 xc4_outpb VSUBS 0.177f
C43 bp1 VSUBS 0.463f
C44 cn9 xc5_xs1_tail 0.154f
C45 bn6 VSUBS 0.0992f
C46 xc4_lt VSUBS 0.593f
C47 on VSUBS 0.104f
C48 bn7 clkb 0.0559f
C49 xs0n_n10 VSUBS 0.174f
C50 cp5 VSUBS 0.219f
C51 bn0 VSUBS 0.361f
C52 xs1n_cbp cp1 0.691f
C53 cp2 VSUBS 0.182f
C54 bn2 VSUBS 0.25f
C55 cn7 clkn 0.167f
C56 xs1n_cbn VSUBS 0.0573f
C57 xs1p_cbn xc5_lt 0.0824f
C58 xs1n_x cp2 0.34f
C59 bp8 cp3 0.0252f
C60 xs0p_x top_p 0.0815f
C61 xs1p_cbp VSUBS 0.238f
C62 vbn trk0 0.0849f
C63 xc5_xs1_tail0 xs0n_cbn 0.223f
C64 bn5 xs0n_cbn 0.121f
C65 cp9 cp3 0.0776f
C66 bp2 cp4 0.128f
C67 xs0p_cbp VSUBS 0.262f
C68 bn2 clknb 0.0409f
C69 rstb trk1 0.159f
C70 onp xc4_xs1_tail 0.0711f
C71 cp9 VSUBS 0.0733f
C72 t0 VSUBS 0.0693f
C73 bn6 VSUBS 0.313f
C74 bp4 VSUBS 0.204f
C75 xc4_dip onp 0.0795f
C76 bn8 VSUBS 0.193f
C77 t0b bp5 0.0879f
C78 bp3 cp10 0.191f
C79 cn11 VSUBS 0.398f
C80 vbp xc5_dip 0.0815f
C81 bn9 VSUBS 0.2f
C82 op VSUBS 0.232f
C83 cn4 VSUBS 0.116f
C84 xs1p_cbn VSUBS 0.17f
C85 onp VSUBS 0.644f
C86 lsb_p VSUBS 0.179f
C87 xs1n_g op 0.304f
C88 cn8 vbp 0.388f
C89 xs0p_n10 VSUBS 0.0403f
C90 cn7 cn3 0.105f
C91 bn11 VSUBS 0.131f
C92 xc4_outnb VSUBS 0.101f
C93 cn4 VSUBS 0.077f
C94 xc4_outpb bn8 0.263f
C95 cn8 VSUBS 0.134f
C96 nr rstb 0.173f
C97 xs0p_x VSUBS 0.604f
C98 bn10 VSUBS 0.152f
C99 cn1 xs1p_cbn 0.0732f
C100 xs0p_x xs1p_g 0.128f
C101 bp4 VSUBS 0.149f
C102 bn0 VSUBS 0.327f
C103 cn8 VSUBS 0.162f
C104 xs0p_cbn VSUBS 0.161f
C105 xs1p_n10 bn8 0.16f
C106 bp6 VSUBS 0.413f
C107 cp8 VSUBS 0.00893f
C108 bn5 bp12 0.135f
C109 bn12 VSUBS 0.0937f
C110 op VSUBS 0.129f
C111 cn1 bp5 0.213f
C112 in1n clkn 0.505f
C113 trk0 xc4_xs1_tail0 0.0299f
C114 cp6 VSUBS 0.148f
C115 xs1n_cbn bp9 0.248f
C116 rstb cn10 0.254f
C117 trk1 VSUBS 0.22f
C118 cn5 VSUBS 0.118f
C119 vrefl bp12 0.24f
C120 bn10 onp 0.565f
C121 cn8 VSUBS 0.0332f
C122 bp2 VSUBS 0.131f
C123 vbp VSUBS 0.369f
C124 on VSUBS 0.0237f
C125 cp12 bn1 0.309f
C126 xc4_dip VSUBS 0.238f
C127 cn2 VSUBS 0.0576f
C128 xs1p_x VSUBS 0.149f
C129 cn0 VSUBS 0.129f
C130 in0n VSUBS 0.223f
C131 in1n clkb 0.161f
C132 bn10 xs1n_cbn 0.504f
C133 bn12 VSUBS 0.139f
C134 top_p VSUBS 0.0299f
C135 trk1 VSUBS 0.222f
C136 xs0p_cbp VSUBS 0.178f
C137 xc5_xs1_tail0 VSUBS 0.0828f
C138 xs1n_cbn VSUBS 0.303f
C139 cn5 bn12 0.0326f
C140 xc5_dip clk 0.143f
C141 xs1p_n10 xc4_xs1_tail0 0.0493f
C142 nr VSUBS 0.373f
C143 xs0n_cbn cp3 0.113f
C144 vrefl cp9 0.0702f
C145 trk1 VSUBS 0.46f
C146 rstb_n cp5 0.0798f
C147 cn10 t0b 0.265f
C148 bn12 VSUBS 0.0866f
C149 cp12 VSUBS 0.051f
C150 t1b VSUBS 0.26f
C151 cp6 VSUBS 0.165f
C152 top_p VSUBS 0.624f
C153 t0b t0 0.064f
C154 bn4 bn10 0.175f
C155 xs0n_x bp8 0.221f
C156 on VSUBS 0.127f
C157 vbp xs1n_n10 0.024f
C158 clkb top_n 0.0238f
C159 xs1n_g bn0 0.159f
C160 cp10 VSUBS 0.0439f
C161 xc4_din cp6 0.0688f
C162 bp8 VSUBS 0.133f
C163 xc4_dip VSUBS 0.175f
C164 bn2 VSUBS 0.0956f
C165 bn12 onn 0.0255f
C166 bp4 VSUBS 0.209f
C167 bn8 xs0p_n10 0.194f
C168 xs1p_cbp VSUBS 0.123f
C169 cn11 vbn 0.0744f
C170 onp VSUBS 0.125f
C171 cp4 VSUBS 0.0225f
C172 vref VSUBS 0.31f
C173 xc4_dip VSUBS 0.241f
C174 bp6 xs0n_cbn 0.0448f
C175 cp0 VSUBS 0.559f
C176 bp2 VSUBS 0.0207f
C177 cp10 VSUBS 0.0575f
C178 cp11 vrefl 0.0432f
C179 bp3 VSUBS 0.166f
C180 cp1 VSUBS 0.596f
C181 cp2 cn6 0.0314f
C182 bp1 xs1p_cbp 0.115f
C183 cp1 VSUBS 0.091f
C184 vdd VSUBS 0.111f
C185 xc5_xs1_tail0 VSUBS 0.0918f
C186 trk1 bn8 0.0881f
C187 clk cn5 0.0496f
C188 cp5 VSUBS 0.0463f
C189 top_n VSUBS 0.148f
C190 bn10 cn1 0.137f
C191 bn3 VSUBS 0.228f
C192 bp6 cn1 0.618f
C193 xs0n_x in0p 0.183f
C194 t1 VSUBS 0.05f
C195 xc5_xs1_tail0 in1n 0.251f
C196 cn0 VSUBS 0.124f
C197 in1n VSUBS 0.173f
C198 bn10 VSUBS 0.127f
C199 clkn lsb_p 0.0681f
C200 cp12 cn6 0.687f
C201 bp1 bn4 0.0157f
C202 lsb_n cn2 0.0508f
C203 cn0 cp10 0.0706f
C204 gnd VSUBS 0.142f
C205 cn2 VSUBS 0.204f
C206 rstb_n VSUBS 0.263f
C207 bn8 VSUBS 0.273f
C208 on VSUBS 0.202f
C209 cp9 VSUBS 0.0689f
C210 xs0n_cbp bn3 0.443f
C211 xs1n_n10 nr 0.335f
C212 xc5_outnb VSUBS 0.0879f
C213 gnd VSUBS 0.0469f
C214 cn1 VSUBS 0.0917f
C215 xs0p_x cp1 0.277f
C216 cp3 VSUBS 0.373f
C217 t1 cn3 0.132f
C218 cp6 VSUBS 0.508f
C219 xs0p_cbn xs1p_cbp 0.0334f
C220 trk0 VSUBS 0.125f
C221 rstb VSUBS 0.0663f
C222 bp12 xc4_lt 0.168f
C223 nr cp3 0.165f
C224 bn3 VSUBS 0.0769f
C225 trk1 xs0p_cbn 0.171f
C226 rstb VSUBS 0.0639f
C227 nr vbp 0.115f
C228 in1p VSUBS 0.604f
C229 bn10 xs1n_cbn 0.172f
C230 xc5_outpb VSUBS 0.0523f
C231 xs1n_cbn VSUBS 0.552f
C232 xc5_xs1_tail vbp 0.306f
C233 bp9 VSUBS 0.0499f
C234 xc4_outnb rstb 0.173f
C235 bp10 VSUBS 0.0582f
C236 bp5 VSUBS 0.115f
C237 in1p VSUBS 0.0666f
C238 t0b xc4_dip 0.073f
C239 bp0 VSUBS 0.047f
C240 bp1 clkn 0.284f
C241 bn12 VSUBS 0.0734f
C242 xs0p_cbp op 0.226f
C243 nr VSUBS 0.783f
C244 onp VSUBS 0.491f
C245 cn1 t1 0.206f
C246 xc5_xs1_tail0 VSUBS 1.12f
C247 xs0n_x cp2 0.219f
C248 cp6 xc5_outnb 0.148f
C249 bp3 VSUBS 0.02f
C250 xc5_dip bp7 0.255f
C251 xs0p_cbn xc5_outpb 0.418f
C252 xc4_lt VSUBS 0.225f
C253 top_p VSUBS 0.0706f
C254 bp2 VSUBS 0.225f
C255 cn3 VSUBS 0.232f
C256 bp10 cn2 0.131f
C257 vbn VSUBS 0.278f
C258 clknb VSUBS 0.0458f
C259 xs1p_n10 VSUBS 0.764f
C260 cp6 VSUBS 0.302f
C261 bp6 VSUBS 0.266f
C262 xc5_dip t1b 0.586f
C263 t1 VSUBS 0.0995f
C264 xc4_dip VSUBS 0.0487f
C265 xc4_xs1_tail0 bn2 0.294f
C266 cp9 VSUBS 0.129f
C267 xs1n_n10 VSUBS 0.246f
C268 xs1n_cbn clknb 0.122f
C269 bn8 VSUBS 0.956f
C270 xc5_dip VSUBS 0.285f
C271 bn3 VSUBS 0.0495f
C272 bn7 VSUBS 0.0648f
C273 vref VSUBS 0.37f
C274 cp8 VSUBS 0.0736f
C275 bp1 vref 0.267f
C276 xs0n_cbp xs1p_n10 0.502f
C277 bn2 cn7 0.111f
C278 onn VSUBS 0.127f
C279 bn6 bn10 0.342f
C280 cn5 VSUBS 0.103f
C281 vref bn4 0.237f
C282 bn12 cp12 0.147f
C283 xc5_outnb VSUBS 0.426f
C284 xs0n_cbn VSUBS 0.0808f
C285 bp11 VSUBS 0.272f
C286 trk0 VSUBS 0.264f
C287 vbn VSUBS 0.0923f
C288 bn4 VSUBS 0.22f
C289 top_p cp2 0.0353f
C290 in0p bp10 0.414f
C291 clknb cp12 0.0312f
C292 cp11 VSUBS 0.0657f
C293 in1n vdd 0.144f
C294 cp7 VSUBS 0.217f
C295 trk1 bp2 0.273f
C296 bn6 VSUBS 0.144f
C297 onp VSUBS 0.248f
C298 onp VSUBS 0.105f
C299 cn5 VSUBS 0.0892f
C300 top_n VSUBS 0.186f
C301 t1b xc4_lt 0.0432f
C302 cp7 VSUBS 0.417f
C303 xc4_lt cp8 0.233f
C304 bp6 cn2 0.0804f
C305 t0 VSUBS 0.133f
C306 xc4_outpb VSUBS 0.261f
C307 bn12 bn10 0.0416f
C308 rstb_n bp6 0.444f
C309 xc4_dip VSUBS 0.1f
C310 onn lsb_n 0.0186f
C311 cn1 xs1n_n10 0.171f
C312 cn10 VSUBS 0.14f
C313 clkb VSUBS 0.0557f
C314 vref VSUBS 0.481f
C315 in0n onp 0.109f
C316 bn0 xs0p_cbn 0.131f
C317 bn2 VSUBS 0.189f
C318 bn10 bn2 0.0729f
C319 cn5 VSUBS 0.0969f
C320 bp4 rstb 0.82f
C321 cp12 VSUBS 0.171f
C322 xs1n_cbn bn8 0.175f
C323 clknb clknb 0.297f
C324 cp5 VSUBS 0.342f
C325 cp8 top_n 0.0744f
C326 bp6 xs0n_cbp 0.211f
C327 cp4 lsb_n 0.262f
C328 xs1p_x xs0n_g 0.143f
C329 cn8 xc5_lt 0.592f
C330 bn12 cp2 0.142f
C331 xs0p_cbp VSUBS 0.199f
C332 clk VSUBS 0.0657f
C333 xs0n_x vbp 0.397f
C334 xc5_lt VSUBS 0.181f
C335 xc5_xs1_tail0 VSUBS 0.315f
C336 op VSUBS 0.0233f
C337 gnd VSUBS 0.226f
C338 xs0n_cbp xc4_outpb 0.245f
C339 op VSUBS 0.15f
C340 xc5_din VSUBS 0.154f
C341 xc4_outnb VSUBS 0.338f
C342 xc4_lt bp1 0.0873f
C343 t1b VSUBS 0.145f
C344 bp7 VSUBS 0.351f
C345 xs1n_n10 VSUBS 0.174f
C346 xs0p_x clkb 0.182f
C347 bn11 cn6 0.156f
C348 xc5_din cp7 0.135f
C349 clk VSUBS 0.134f
C350 lsb_n VSUBS 0.428f
C351 bp5 VSUBS 0.247f
C352 cp9 rstb_n 0.789f
C353 cp8 VSUBS 0.128f
C354 cn2 bn8 0.298f
C355 cp2 VSUBS 0.15f
C356 xs0p_cbp VSUBS 0.0493f
C357 cn5 op 0.47f
C358 in0p nr 0.31f
C359 vref VSUBS 0.0797f
C360 onn cp2 0.0452f
C361 xc5_lt VSUBS 0.0276f
C362 bn8 VSUBS 0.154f
C363 xs1p_g top_n 0.22f
C364 xc4_xs1_tail VSUBS 0.894f
C365 xs1p_g VSUBS 0.107f
C366 xs1p_n10 VSUBS 0.54f
C367 t1b clk 0.28f
C368 cp1 VSUBS 0.165f
C369 xs0n_cbp VSUBS 0.146f
C370 xs1p_x VSUBS 0.084f
C371 bp3 VSUBS 0.0949f
C372 bn7 VSUBS 0.197f
C373 xs1n_cbp VSUBS 0.104f
C374 cn6 bn9 0.218f
C375 bn5 vdd 0.0955f
C376 xc4_outpb cp12 0.449f
C377 cn8 VSUBS 0.642f
C378 cp5 VSUBS 0.0652f
C379 vbn VSUBS 0.0851f
C380 t0b VSUBS 0.035f
C381 vref vref 0.155f
C382 clk VSUBS 0.102f
C383 bn0 VSUBS 0.0444f
C384 cp4 xs1n_cbn 0.164f
C385 vrefl VSUBS 0.306f
C386 bn0 cp2 0.0445f
C387 xc5_lt vbp 0.032f
C388 top_p VSUBS 0.225f
C389 bn11 VSUBS 0.154f
C390 bn3 VSUBS 0.139f
C391 xs1p_cbn VSUBS 0.08f
C392 cp8 VSUBS 0.0586f
C393 xc4_lt lsb_n 0.238f
C394 cp6 VSUBS 0.302f
C395 bp11 xc4_din 0.131f
C396 trk1 bp12 0.127f
C397 bn5 cp8 0.137f
C398 xc5_din VSUBS 0.0891f
C399 bp2 VSUBS 0.0667f
C400 cn3 VSUBS 0.205f
C401 cn7 VSUBS 0.0273f
C402 bn7 VSUBS 0.0669f
C403 bn11 VSUBS 0.0942f
C404 cp10 VSUBS 0.083f
C405 lsb_p VSUBS 0.134f
C406 clknb VSUBS 0.178f
C407 onp bn1 0.0733f
C408 xs1p_n10 bn12 0.0628f
C409 xs1n_cbn bn3 0.0385f
C410 cp11 bn12 0.164f
C411 bn0 xc4_dip 0.105f
C412 cn6 VSUBS 0.197f
C413 cn2 t1 0.19f
C414 bp3 VSUBS 0.115f
C415 t0b xc5_din 0.285f
C416 t1b VSUBS 0.215f
C417 bp5 VSUBS 0.056f
C418 rstb_n xs1n_cbn 0.0964f
C419 gnd clknb 0.0323f
C420 in1p VSUBS 0.408f
C421 bp0 VSUBS 0.579f
C422 vdd VSUBS 0.103f
C423 bn7 bp2 0.228f
C424 xs0p_cbn VSUBS 0.456f
C425 cp6 VSUBS 0.247f
C426 xs0p_g VSUBS 0.151f
C427 cn3 cn11 0.306f
C428 xs1n_g cp2 0.166f
C429 xs1n_cbp VSUBS 0.409f
C430 bp2 t0b 0.355f
C431 bp4 VSUBS 0.166f
C432 trk1 VSUBS 0.426f
C433 t0b VSUBS 0.303f
C434 vrefl xs0p_cbn 0.0669f
C435 op VSUBS 0.0368f
C436 bp3 xs1n_g 0.634f
C437 xs1p_cbn VSUBS 0.244f
C438 xs0n_cbp vbp 0.178f
C439 xc4_dip xs0p_cbp 0.0997f
C440 gnd vref 0.517f
C441 xs0p_n10 trk0 0.361f
C442 bn0 VSUBS 0.104f
C443 lsb_p VSUBS 0.0518f
C444 bn7 VSUBS 0.101f
C445 bp9 VSUBS 0.0723f
C446 in1p xc5_outpb 0.259f
C447 bp7 VSUBS 0.047f
C448 cp11 VSUBS 0.068f
C449 bn9 cp4 0.277f
C450 cp3 VSUBS 0.186f
C451 xs0p_n10 t1b 0.231f
C452 cp6 VSUBS 0.285f
C453 cn1 xs1n_n10 0.213f
C454 vdd VSUBS 0.257f
C455 cp9 xc4_outnb 0.19f
C456 xs1n_x VSUBS 0.0781f
C457 xc5_xs1_tail xs1p_cbp 0.141f
C458 xc5_dip VSUBS 0.0415f
C459 cp7 VSUBS 0.0687f
C460 nr VSUBS 0.114f
C461 xs1n_cbn VSUBS 0.035f
C462 cp12 VSUBS 0.13f
C463 t0 VSUBS 0.327f
C464 cn5 cp12 0.0892f
C465 xs0p_cbp VSUBS 0.132f
C466 bn5 xs1p_g 0.179f
C467 cp0 VSUBS 0.0796f
C468 cp9 VSUBS 0.597f
C469 gnd bn6 0.195f
C470 xc5_xs1_tail0 VSUBS 0.126f
C471 top_n VSUBS 0.0111f
C472 top_n VSUBS 0.0837f
C473 xc4_din xs0p_g 0.648f
C474 cn8 xc4_outpb 0.105f
C475 cn7 clkn 0.197f
C476 bp5 VSUBS 0.535f
C477 bn5 clknb 0.121f
C478 clk cn4 0.151f
C479 cp10 VSUBS 0.263f
C480 vbp bp12 0.194f
C481 t0b xc5_din 0.896f
C482 xs0p_n10 VSUBS 0.207f
C483 top_n VSUBS 0.078f
C484 lsb_p cp10 0.394f
C485 xc5_xs1_tail VSUBS 0.389f
C486 bp4 trk0 0.238f
C487 lsb_p VSUBS 0.131f
C488 cn1 bn12 0.323f
C489 cp6 VSUBS 0.0689f
C490 bp3 VSUBS 0.291f
C491 bn6 bp0 0.223f
C492 cn5 VSUBS 0.196f
C493 bn9 cn7 0.0989f
C494 t1b VSUBS 0.432f
C495 cn1 VSUBS 0.181f
C496 bn12 in1n 0.301f
C497 bn8 VSUBS 0.112f
C498 bn11 VSUBS 0.0887f
C499 vrefl nr 0.999f
C500 xs0n_cbn cp6 0.0548f
C501 nr VSUBS 0.673f
C502 cn10 cn3 1.01f
C503 xs1p_cbp VSUBS 0.595f
C504 vdd VSUBS 0.161f
C505 xs0p_g lsb_n 0.0774f
C506 xc4_din bn0 0.0433f
C507 bn5 VSUBS 0.325f
C508 top_p VSUBS 0.152f
C509 clknb VSUBS 0.274f
C510 cp11 clknb 0.155f
C511 t1b xc4_lt 0.0621f
C512 in1n cp8 0.399f
C513 xs1p_cbp bn10 0.185f
C514 bn12 VSUBS 0.664f
C515 bp9 VSUBS 0.198f
C516 in1n bp3 0.159f
C517 bn1 VSUBS 0.0454f
C518 bp2 in1p 0.117f
C519 clkn VSUBS 0.0508f
C520 op cn8 0.0543f
C521 onn VSUBS 0.0478f
C522 clkb bn6 0.0535f
C523 lsb_p cp7 0.155f
C524 bp1 bp1 0.204f
C525 lsb_n cn4 0.0423f
C526 xc4_outpb VSUBS 0.0366f
C527 clknb VSUBS 0.17f
C528 top_n VSUBS 0.388f
C529 cn6 bp3 0.218f
C530 bn8 VSUBS 0.0328f
C531 xs0n_cbn lsb_p 0.107f
C532 bn3 VSUBS 0.0637f
C533 bn1 xs0p_x 1.54f
C534 bn7 VSUBS 0.169f
C535 xc4_outpb VSUBS 0.234f
C536 bp4 VSUBS 0.23f
C537 in1n VSUBS 0.0384f
C538 bn9 bn9 0.241f
C539 xs1n_g VSUBS 0.179f
C540 xs0p_cbn trk1 0.461f
C541 bn7 bp9 0.154f
C542 xs0p_n10 trk0 0.1f
C543 bn12 VSUBS 0.477f
C544 xs0n_x VSUBS 0.0671f
C545 xs0p_g VSUBS 0.114f
C546 vref VSUBS 0.691f
C547 in0n VSUBS 0.0529f
C548 xs0p_cbp VSUBS 0.387f
C549 bp11 bp0 0.0718f
C550 bp6 xc4_outnb 0.108f
C551 xs1p_cbn cn8 0.06f
C552 cn1 VSUBS 0.171f
C553 bp1 cn6 0.159f
C554 t0b bp0 0.295f
C555 xs1p_cbn VSUBS 0.0444f
C556 xc4_lt clkb 0.0595f
C557 cp9 cn1 0.498f
C558 bp9 VSUBS 0.12f
C559 cp12 VSUBS 0.0397f
C560 cp4 bn4 0.102f
C561 cp6 bn4 0.452f
C562 xs0p_g in1p 0.0452f
C563 cn10 bp9 0.402f
C564 bn10 VSUBS 0.175f
C565 xc4_outpb VSUBS 0.0673f
C566 lsb_n VSUBS 0.261f
C567 gnd bn3 0.086f
C568 xc4_dip VSUBS 0.668f
C569 nr VSUBS 0.139f
C570 bp7 VSUBS 0.121f
C571 bn11 t0b 0.153f
C572 cn9 VSUBS 0.115f
C573 cn10 VSUBS 0.0569f
C574 bp0 VSUBS 0.105f
C575 xs1p_x VSUBS 0.241f
C576 xc5_xs1_tail0 cp7 0.421f
C577 cp12 VSUBS 0.0661f
C578 xs1p_n10 cn3 0.0428f
C579 cn7 VSUBS 0.237f
C580 bp3 xs0n_cbp 0.0279f
C581 xs1n_x VSUBS 0.227f
C582 on VSUBS 0.114f
C583 cp12 VSUBS 0.12f
C584 in0n VSUBS 0.543f
C585 xs1n_x bn4 0.12f
C586 bn12 VSUBS 0.203f
C587 bp6 VSUBS 0.0612f
C588 cn12 VSUBS 0.0433f
C589 xs1p_g VSUBS 0.0584f
C590 xs1n_n10 bn4 0.291f
C591 bp1 VSUBS 0.489f
C592 bn5 xc4_din 0.432f
C593 top_n xc4_xs1_tail0 0.0319f
C594 xs0p_cbn VSUBS 0.286f
C595 cn3 lsb_n 0.167f
C596 bp3 VSUBS 0.124f
C597 cp5 VSUBS 0.152f
C598 rstb_n VSUBS 0.218f
C599 cp12 VSUBS 0.279f
C600 bn7 VSUBS 0.0944f
C601 in0p cp3 0.388f
C602 cn10 bp12 0.39f
C603 bn8 VSUBS 0.107f
C604 vbp VSUBS 0.123f
C605 bp4 VSUBS 0.111f
C606 cp2 VSUBS 0.379f
C607 xc4_xs1_tail xs1n_g 0.337f
C608 cp6 bp10 0.259f
C609 xs1n_cbn xc4_dip 0.0432f
C610 bp12 VSUBS 0.23f
C611 bp12 VSUBS 0.161f
C612 cn9 bp6 0.0574f
C613 on vrefl 0.313f
C614 cp3 VSUBS 0.0968f
C615 cp9 VSUBS 0.077f
C616 bp9 cp5 0.134f
C617 vbp VSUBS 0.0968f
C618 bp5 VSUBS 0.0361f
C619 rstb VSUBS 0.118f
C620 vrefl xs0p_g 0.0411f
C621 lsb_n VSUBS 0.0754f
C622 cp8 nr 0.117f
C623 bn3 VSUBS 0.0204f
C624 bp7 VSUBS 0.132f
C625 xs1n_g bp1 0.0356f
C626 t1 in1p 0.117f
C627 cp7 VSUBS 0.553f
C628 trk0 cp10 0.174f
C629 bp9 bp0 0.149f
C630 bn2 VSUBS 0.107f
C631 bp3 VSUBS 0.169f
C632 xs1n_cbn VSUBS 0.858f
C633 xc5_dip vref 0.325f
C634 xc4_xs1_tail VSUBS 0.439f
C635 bp0 VSUBS 0.0904f
C636 vrefl VSUBS 0.135f
C637 cn6 VSUBS 0.158f
C638 t1 op 0.0852f
C639 xs1p_n10 bn12 0.158f
C640 xs1p_n10 VSUBS 0.114f
C641 on VSUBS 0.215f
C642 bp8 VSUBS 0.163f
C643 cn2 VSUBS 0.151f
C644 bn4 bp5 0.133f
C645 xc4_xs1_tail VSUBS 0.105f
C646 trk0 VSUBS 0.176f
C647 xs1p_x VSUBS 0.0539f
C648 bp1 VSUBS 0.333f
C649 bp6 VSUBS 0.385f
C650 cp12 xc4_xs1_tail0 0.0609f
C651 bp9 VSUBS 0.0693f
C652 rstb_n xc4_outpb 0.16f
C653 t0b bn12 0.0992f
C654 rstb VSUBS 0.126f
C655 on VSUBS 0.0819f
C656 xc4_xs1_tail xs0n_cbp 0.116f
C657 xc5_din VSUBS 0.136f
C658 clk VSUBS 0.0749f
C659 cn2 VSUBS 0.154f
C660 xc4_outpb VSUBS 0.0233f
C661 xs0n_n10 VSUBS 0.193f
C662 onn bn7 0.375f
C663 top_n VSUBS 0.0326f
C664 cn2 cn4 0.0576f
C665 cp0 cn6 0.129f
C666 cn4 VSUBS 0.0627f
C667 onn VSUBS 0.132f
C668 xc5_outpb VSUBS 0.114f
C669 bp0 VSUBS 0.188f
C670 cn3 bp4 0.261f
C671 trk0 bn12 0.166f
C672 t1b VSUBS 0.384f
C673 trk1 bp0 0.0407f
C674 bp1 VSUBS 0.116f
C675 rstb_n VSUBS 0.136f
C676 bp7 VSUBS 0.222f
C677 t1b cn6 0.132f
C678 xs1n_cbp VSUBS 0.213f
C679 cn3 xs0n_n10 0.126f
C680 clknb VSUBS 0.0529f
C681 bp7 VSUBS 0.185f
C682 xc5_outpb bp5 0.0849f
C683 xs0n_g cn11 0.17f
C684 vrefl VSUBS 1.56f
C685 bp1 VSUBS 0.372f
C686 xs0n_g xs1n_x 0.0417f
C687 xc4_outnb op 0.14f
C688 vdd VSUBS 0.13f
C689 cn9 VSUBS 0.282f
C690 t1 VSUBS 1.07f
C691 cn10 VSUBS 0.341f
C692 cp1 VSUBS 0.115f
C693 bn4 xs0n_n10 0.085f
C694 xs0p_cbp VSUBS 0.109f
C695 top_p VSUBS 0.0712f
C696 bp3 cp11 0.763f
C697 xc4_lt VSUBS 0.165f
C698 vbp VSUBS 0.0684f
C699 xc4_xs1_tail VSUBS 0.0862f
C700 bn10 VSUBS 0.164f
C701 xs0p_cbn in1p 0.572f
C702 xs1n_n10 VSUBS 0.312f
C703 bp2 VSUBS 0.0775f
C704 bp1 bn1 0.359f
C705 onn VSUBS 0.0987f
C706 xs0p_x xc4_din 0.388f
C707 bn4 VSUBS 0.192f
C708 bn3 vrefl 0.0723f
C709 in1p xs0n_g 0.429f
C710 t0b bp10 0.438f
C711 xs1n_x xs0p_x 0.1f
C712 bp3 VSUBS 0.325f
C713 bp5 cp11 0.27f
C714 t0 VSUBS 0.126f
C715 cn3 VSUBS 0.245f
C716 cp11 vdd 0.164f
C717 cn1 VSUBS 0.569f
C718 bn11 VSUBS 0.0826f
C719 cp12 VSUBS 0.109f
C720 bp3 VSUBS 0.762f
C721 xs0p_n10 op 0.0996f
C722 cp12 cn8 0.14f
C723 vrefl in1p 0.353f
C724 xc5_dip VSUBS 0.281f
C725 xc4_lt VSUBS 0.096f
C726 xs0n_cbp VSUBS 0.062f
C727 rstb_n VSUBS 0.101f
C728 vref vref 0.125f
C729 t0b VSUBS 0.0998f
C730 xs0p_cbp VSUBS 0.0288f
C731 xs0n_n10 VSUBS 0.0331f
C732 bn8 VSUBS 0.0896f
C733 xs0p_x VSUBS 0.106f
C734 xs1n_x clk 0.202f
C735 xs0n_g cn11 0.221f
C736 vref VSUBS 0.147f
C737 xs1n_cbn VSUBS 0.192f
C738 bn0 cn1 0.0793f
C739 xc4_xs1_tail0 bp8 0.234f
C740 bp6 VSUBS 0.153f
C741 xs1n_cbn VSUBS 0.099f
C742 top_n VSUBS 0.109f
C743 cp6 VSUBS 0.153f
C744 top_p VSUBS 0.121f
C745 xs1n_n10 VSUBS 0.304f
C746 cp6 xs0n_g 0.105f
C747 xs0n_cbp VSUBS 0.241f
C748 in0p xs1n_cbn 0.142f
C749 bp3 bn4 0.0749f
C750 bn4 VSUBS 0.781f
C751 bp9 xs0p_g 0.111f
C752 xc4_din VSUBS 0.238f
C753 bp1 VSUBS 0.154f
C754 xs1n_cbn VSUBS 0.141f
C755 cp0 VSUBS 0.193f
C756 bp2 VSUBS 0.0849f
C757 bn3 VSUBS 0.215f
C758 cn1 VSUBS 0.0328f
C759 bp5 VSUBS 0.334f
C760 bp8 bp3 0.103f
C761 cn8 VSUBS 0.0718f
C762 cn11 cp4 0.0932f
C763 bp5 xs1p_cbn 0.309f
C764 gnd VSUBS 0.384f
C765 onp VSUBS 0.101f
C766 top_p VSUBS 0.191f
C767 cp0 VSUBS 0.084f
C768 vbp bp7 0.0599f
C769 bp11 VSUBS 0.214f
C770 xs1p_g VSUBS 0.196f
C771 bp8 VSUBS 0.333f
C772 bp3 VSUBS 0.203f
C773 lsb_n VSUBS 0.241f
C774 xc5_dip onn 0.137f
C775 bn2 VSUBS 0.245f
C776 cp9 VSUBS 0.0822f
C777 top_p xs0p_x 0.192f
C778 rstb cp0 0.202f
C779 xs1p_cbn in0p 0.237f
C780 op bp7 0.183f
C781 gnd bn4 0.161f
C782 xs0p_x trk0 0.143f
C783 xs0n_x VSUBS 0.082f
C784 bn7 in1p 0.13f
C785 vbn VSUBS 0.198f
C786 cn7 VSUBS 0.101f
C787 lsb_p VSUBS 0.0931f
C788 lsb_n in1n 0.382f
C789 xc5_xs1_tail0 VSUBS 0.0754f
C790 vref cn5 0.0644f
C791 gnd VSUBS 0.0761f
C792 cn12 xc4_dip 0.219f
C793 xc4_lt in1n 0.288f
C794 xc4_din VSUBS 0.154f
C795 clk bn6 0.0893f
C796 cn10 xc5_xs1_tail0 0.676f
C797 xs0p_g xc5_dip 0.563f
C798 xs1p_n10 clkb 0.218f
C799 cp4 xs1n_g 0.0374f
C800 cp6 trk1 0.124f
C801 bn9 VSUBS 0.199f
C802 bn3 VSUBS 0.379f
C803 in1n onp 0.141f
C804 xc5_outpb VSUBS 0.259f
C805 lsb_n VSUBS 0.0386f
C806 xc4_lt VSUBS 0.318f
C807 lsb_p cp11 0.0625f
C808 cp2 bn5 0.0615f
C809 xs1n_x VSUBS 0.199f
C810 top_p cp11 0.105f
C811 bp7 VSUBS 0.0401f
C812 gnd xs0n_cbn 0.249f
C813 xc5_din vdd 0.107f
C814 lsb_n VSUBS 0.149f
C815 xs1n_cbp in0p 0.102f
C816 xs1p_x VSUBS 0.0784f
C817 xs1p_g t1 0.0914f
C818 xs1p_cbp bp11 0.0721f
C819 bn1 vrefl 0.366f
C820 trk1 VSUBS 0.182f
C821 cp7 top_n 0.14f
C822 cp11 VSUBS 0.139f
C823 xs1n_g VSUBS 0.11f
C824 cp6 VSUBS 0.306f
C825 cp2 VSUBS 0.19f
C826 cp4 VSUBS 0.859f
C827 bp0 VSUBS 0.112f
C828 xc4_dip VSUBS 0.12f
C829 cp6 xc4_xs1_tail0 0.103f
C830 cn9 VSUBS 0.108f
C831 cp9 VSUBS 0.0506f
C832 cp5 VSUBS 0.0819f
C833 cn12 in1p 0.0829f
C834 xs1n_n10 cn11 0.0639f
C835 lsb_p cp11 0.0179f
C836 xc4_lt VSUBS 0.144f
C837 xs0p_n10 VSUBS 0.0864f
C838 lsb_p bn11 0.193f
C839 t1b xc4_outpb 0.26f
C840 xs0p_cbp bn6 0.114f
C841 xc5_lt VSUBS 0.0523f
C842 cn7 VSUBS 0.108f
C843 t0 in1n 0.274f
C844 bn11 VSUBS 0.578f
C845 nr VSUBS 0.098f
C846 xs1n_cbn VSUBS 0.117f
C847 lsb_n xs0p_cbn 0.333f
C848 bp4 cp12 0.0372f
C849 bn10 VSUBS 0.113f
C850 xc4_dip VSUBS 0.474f
C851 bp8 bn10 0.0627f
C852 top_n VSUBS 0.388f
C853 cp12 VSUBS 0.422f
C854 bp8 VSUBS 1.18f
C855 bn12 VSUBS 0.0375f
C856 cn12 VSUBS 0.0752f
C857 trk1 cn2 0.158f
C858 t0b cp7 0.256f
C859 xc5_lt VSUBS 0.288f
C860 t1b bn4 0.522f
C861 xc5_outpb VSUBS 0.11f
C862 xc5_outpb VSUBS 0.261f
C863 xs1n_cbp VSUBS 0.0857f
C864 xs0n_g VSUBS 0.0646f
C865 bp5 VSUBS 0.22f
C866 xc5_xs1_tail VSUBS 0.0911f
C867 cn0 cn2 0.179f
C868 bp10 VSUBS 0.173f
C869 xs1p_cbn op 0.0681f
C870 xs0p_x xs0n_cbn 0.232f
C871 top_n bn4 0.197f
C872 cn9 VSUBS 0.0928f
C873 rstb VSUBS 0.0702f
C874 gnd xc4_outpb 0.863f
C875 xs0n_g VSUBS 0.224f
C876 bn12 cn5 0.0757f
C877 bn3 bn4 0.0697f
C878 bp0 VSUBS 0.276f
C879 cn12 bp7 0.536f
C880 bp9 VSUBS 0.3f
C881 xc5_dip VSUBS 0.235f
C882 bn9 VSUBS 0.275f
C883 xs0p_g VSUBS 0.183f
C884 cp7 VSUBS 0.117f
C885 xc5_outnb VSUBS 0.171f
C886 vbp xc5_outnb 0.164f
C887 bn10 xc4_xs1_tail 0.065f
C888 rstb xc4_xs1_tail0 0.0305f
C889 cp3 t1 0.247f
C890 cn0 xc5_dip 0.0677f
C891 xc5_xs1_tail xs0n_cbn 0.108f
C892 onp VSUBS 0.0821f
C893 cn9 vbn 0.0675f
C894 xc4_outpb VSUBS 0.135f
C895 in1p VSUBS 0.104f
C896 t1 VSUBS 0.236f
C897 cp6 xc4_lt 0.158f
C898 top_p VSUBS 0.0623f
C899 cp5 xs0p_n10 0.12f
C900 bn11 VSUBS 0.186f
C901 xs0p_n10 VSUBS 0.028f
C902 bp10 VSUBS 0.173f
C903 nr VSUBS 0.422f
C904 bp1 VSUBS 0.227f
C905 top_n cp0 0.0404f
C906 cp12 VSUBS 0.0771f
C907 cn0 VSUBS 0.15f
C908 xs1p_g cp10 0.482f
C909 bn9 VSUBS 0.113f
C910 in0p VSUBS 0.503f
C911 bn3 bn5 0.202f
C912 bn0 VSUBS 0.229f
C913 xs0n_n10 VSUBS 0.11f
C914 clknb VSUBS 0.0147f
C915 cp10 VSUBS 0.303f
C916 bn0 cn2 0.0461f
C917 cp12 VSUBS 0.0602f
C918 xc5_din VSUBS 0.118f
C919 xs1p_n10 VSUBS 0.107f
C920 cn6 xs1n_g 0.154f
C921 bp4 VSUBS 0.168f
C922 on bp8 0.258f
C923 vbp VSUBS 0.111f
C924 cp9 VSUBS 0.0688f
C925 cp2 VSUBS 0.102f
C926 cn12 VSUBS 0.17f
C927 in0n bn3 0.704f
C928 cn1 xc5_xs1_tail 0.222f
C929 rstb VSUBS 0.148f
C930 trk1 VSUBS 0.142f
C931 xs1n_cbn VSUBS 0.0421f
C932 xc5_dip VSUBS 0.772f
C933 cp5 VSUBS 0.0422f
C934 top_p in0p 0.114f
C935 cn4 VSUBS 0.0746f
C936 xs0n_x VSUBS 0.31f
C937 xs0n_g VSUBS 0.108f
C938 bp6 VSUBS 0.469f
C939 xs0p_cbp VSUBS 0.156f
C940 op xc4_xs1_tail 0.334f
C941 xs0n_x VSUBS 0.102f
C942 cn4 VSUBS 0.0407f
C943 vbn xs0n_x 0.0716f
C944 xc4_outpb bn12 0.471f
C945 bp10 rstb 0.212f
C946 xs0n_cbp cp10 0.0731f
C947 xc5_lt VSUBS 0.178f
C948 xc5_dip on 0.101f
C949 bn5 VSUBS 0.188f
C950 cn0 VSUBS 0.18f
C951 xs1n_g xc5_din 0.299f
C952 bn10 VSUBS 0.441f
C953 xc4_xs1_tail cp12 0.0801f
C954 xc4_outpb VSUBS 0.244f
C955 cp5 VSUBS 0.089f
C956 cp4 trk1 0.209f
C957 xc5_outnb bn5 0.0426f
C958 bn4 bn7 0.0585f
C959 cn6 cn0 0.0682f
C960 vdd VSUBS 0.12f
C961 t1b cn0 0.066f
C962 cp9 xc5_outpb 0.56f
C963 onn VSUBS 0.451f
C964 bn10 VSUBS 0.259f
C965 bn1 bp11 0.134f
C966 cp4 VSUBS 0.0299f
C967 t1b VSUBS 0.256f
C968 cn3 VSUBS 0.196f
C969 cn4 VSUBS 0.106f
C970 xc5_outpb VSUBS 0.378f
C971 bn1 VSUBS 0.121f
C972 cn9 VSUBS 0.557f
C973 xc5_xs1_tail0 xc4_lt 0.278f
C974 in1n VSUBS 0.274f
C975 xs1n_n10 VSUBS 0.187f
C976 cp9 VSUBS 0.144f
C977 t1b cp1 0.908f
C978 cn4 bp5 0.0506f
C979 cp6 xc4_outpb 0.447f
C980 trk1 xs1n_n10 0.0899f
C981 bp6 bp12 0.0646f
C982 in0p VSUBS 0.126f
C983 bp6 cn9 0.546f
C984 trk0 cp12 0.382f
C985 xs1n_n10 op 0.0723f
C986 xc5_din VSUBS 0.556f
C987 bp4 VSUBS 0.0754f
C988 xc4_din VSUBS 0.0782f
C989 cn1 VSUBS 0.343f
C990 trk0 VSUBS 0.15f
C991 xs0n_x VSUBS 0.21f
C992 xs0p_g VSUBS 0.325f
C993 bp4 VSUBS 0.145f
C994 cn0 t0 0.488f
C995 cp11 VSUBS 0.197f
C996 cn8 VSUBS 0.0627f
C997 lsb_n VSUBS 0.135f
C998 rstb_n VSUBS 0.0333f
C999 bp12 vdd 0.62f
C1000 bp5 xc4_outpb 0.26f
C1001 lsb_p VSUBS 0.0525f
C1002 vbp cp0 0.0718f
C1003 xs1p_cbp VSUBS 0.227f
C1004 bn7 trk0 0.314f
C1005 in1n VSUBS 0.237f
C1006 bp8 VSUBS 0.241f
C1007 t0b VSUBS 0.0952f
C1008 t0 cn12 0.111f
C1009 bn5 VSUBS 0.188f
C1010 xc4_xs1_tail bp0 0.244f
C1011 xs1n_cbn VSUBS 0.173f
C1012 xs0p_g bn7 0.0517f
C1013 on xs1n_g 0.354f
C1014 xs0n_cbp VSUBS 0.366f
C1015 bn1 VSUBS 0.282f
C1016 cp10 VSUBS 0.089f
C1017 bn1 VSUBS 0.0347f
C1018 t0b cn4 0.143f
C1019 cn0 VSUBS 0.183f
C1020 op VSUBS 0.22f
C1021 xs0n_g VSUBS 0.0584f
C1022 xs0p_g VSUBS 0.299f
C1023 trk0 VSUBS 0.21f
C1024 xs0n_x VSUBS 0.168f
C1025 xs1p_n10 VSUBS 0.0395f
C1026 xc5_xs1_tail0 VSUBS 0.619f
C1027 cp5 VSUBS 0.203f
C1028 xs1n_x xs1p_cbp 0.326f
C1029 cn10 xc5_xs1_tail 0.276f
C1030 xs0p_x VSUBS 0.136f
C1031 xc5_xs1_tail xc4_lt 0.0959f
C1032 xs0n_x VSUBS 0.0904f
C1033 xs1p_x VSUBS 0.262f
C1034 bp3 VSUBS 0.201f
C1035 xc4_outpb top_n 0.228f
C1036 cp2 cn0 0.256f
C1037 rstb VSUBS 0.148f
C1038 xs0n_n10 cn4 0.0721f
C1039 cp8 VSUBS 0.259f
C1040 clkn VSUBS 0.119f
C1041 xc4_xs1_tail top_n 0.0596f
C1042 t1 xc4_outnb 0.588f
C1043 xs0n_x VSUBS 0.0917f
C1044 cn6 VSUBS 0.109f
C1045 bn4 VSUBS 0.19f
C1046 cp10 xs1p_cbn 0.0392f
C1047 cn0 trk1 0.0679f
C1048 lsb_n VSUBS 0.11f
C1049 xs0p_g VSUBS 0.148f
C1050 xs1p_g xc5_xs1_tail0 0.129f
C1051 xs1n_x VSUBS 0.215f
C1052 t0 VSUBS 0.18f
C1053 xs1p_cbn cn6 1.13f
C1054 cp12 xc5_outpb 0.106f
C1055 cn12 VSUBS 0.323f
C1056 cp6 cn3 0.127f
C1057 xs0p_g VSUBS 0.0967f
C1058 trk1 xs0n_cbn 0.236f
C1059 bn2 bp5 0.251f
C1060 on cn5 0.594f
C1061 cp4 VSUBS 0.126f
C1062 bn9 cp1 0.0679f
C1063 cp5 VSUBS 0.34f
C1064 cp4 VSUBS 0.0583f
C1065 cn12 VSUBS 0.376f
C1066 cp2 VSUBS 0.605f
C1067 cp5 VSUBS 0.0866f
C1068 clkb xs0p_cbn 0.204f
C1069 cn2 VSUBS 0.24f
C1070 bp5 xs1p_cbn 0.0917f
C1071 cp1 VSUBS 0.212f
C1072 cn11 VSUBS 0.676f
C1073 op VSUBS 0.244f
C1074 bn5 VSUBS 0.176f
C1075 rstb xc4_xs1_tail0 0.151f
C1076 cn11 bp10 0.0631f
C1077 xc4_lt VSUBS 0.207f
C1078 xs1p_g xs0p_cbn 0.109f
C1079 xs0n_n10 VSUBS 0.177f
C1080 cn4 in0n 0.0698f
C1081 xc5_outpb VSUBS 0.578f
C1082 cn8 VSUBS 0.204f
C1083 xc5_xs1_tail0 vref 0.15f
C1084 cp1 VSUBS 0.237f
C1085 bn4 bn6 0.0481f
C1086 cp10 VSUBS 0.335f
C1087 top_n VSUBS 0.25f
C1088 cp1 trk0 0.205f
C1089 cp0 cn9 0.292f
C1090 xc4_xs1_tail0 VSUBS 0.0681f
C1091 bp0 nr 0.155f
C1092 vrefl VSUBS 0.105f
C1093 bn8 VSUBS 0.0736f
C1094 gnd VSUBS 0.374f
C1095 cp2 VSUBS 0.256f
C1096 xs0n_x VSUBS 0.175f
C1097 xs0p_g VSUBS 0.289f
C1098 xs1n_x VSUBS 0.204f
C1099 cn3 VSUBS 0.236f
C1100 in0p VSUBS 0.109f
C1101 cp10 VSUBS 0.212f
C1102 xs0n_cbp VSUBS 0.197f
C1103 bp12 VSUBS 0.242f
C1104 bn4 VSUBS 0.193f
C1105 cn2 VSUBS 0.252f
C1106 bn8 VSUBS 0.0313f
C1107 xc5_outnb VSUBS 0.137f
C1108 cp2 bp3 0.0817f
C1109 xs0n_cbp VSUBS 0.0767f
C1110 bn7 VSUBS 0.14f
C1111 in0n VSUBS 0.0428f
C1112 bn12 VSUBS 0.816f
C1113 xs0n_x VSUBS 0.223f
C1114 clkn VSUBS 0.595f
C1115 vref VSUBS 0.221f
C1116 vbn bn12 0.31f
C1117 cp4 bn4 0.235f
C1118 bp8 xs0p_x 0.0696f
C1119 xs1p_n10 VSUBS 0.0745f
C1120 cn8 bn5 0.149f
C1121 xs0p_cbn bp9 0.293f
C1122 bn0 xs1n_cbp 0.0549f
C1123 cn1 xc4_dip 0.281f
C1124 bp2 VSUBS 0.153f
C1125 bp6 xs1n_n10 0.155f
C1126 xc5_xs1_tail bn2 0.114f
C1127 cn10 VSUBS 0.11f
C1128 cn11 VSUBS 0.183f
C1129 cp12 VSUBS 0.223f
C1130 cn4 VSUBS 0.178f
C1131 cp12 VSUBS 0.176f
C1132 clknb VSUBS 0.151f
C1133 cp4 VSUBS 0.255f
C1134 cp2 bn7 0.0932f
C1135 xc5_xs1_tail VSUBS 0.0682f
C1136 in1n bp6 0.196f
C1137 bp5 VSUBS 0.0568f
C1138 cp9 cp3 0.0959f
C1139 nr VSUBS 0.188f
C1140 in1n VSUBS 0.119f
C1141 bp1 bn8 0.0723f
C1142 bn11 bn2 0.405f
C1143 onn VSUBS 0.126f
C1144 bn3 VSUBS 0.107f
C1145 onp VSUBS 0.0754f
C1146 xs0n_g xc5_dip 0.17f
C1147 top_n t1 0.0487f
C1148 cp2 VSUBS 0.0463f
C1149 t0b VSUBS 0.203f
C1150 cn1 VSUBS 0.215f
C1151 cn2 cn7 0.102f
C1152 xc5_lt xs1n_x 0.24f
C1153 xs0n_cbn xc5_xs1_tail 0.149f
C1154 clknb VSUBS 0.695f
C1155 trk0 VSUBS 0.0807f
C1156 cp8 VSUBS 0.107f
C1157 cn5 VSUBS 0.276f
C1158 xc4_din top_n 0.171f
C1159 bn7 VSUBS 0.472f
C1160 bp8 VSUBS 0.332f
C1161 cp7 VSUBS 0.0895f
C1162 cn0 VSUBS 0.133f
C1163 bn3 xs1n_g 0.155f
C1164 cp0 VSUBS 0.102f
C1165 xc4_outpb cn7 0.233f
C1166 bn8 VSUBS 0.11f
C1167 cn2 xc5_xs1_tail 0.218f
C1168 xs1n_n10 VSUBS 0.199f
C1169 bn9 VSUBS 0.361f
C1170 clkn VSUBS 0.256f
C1171 xs1n_g xc4_outnb 0.393f
C1172 vbp xc4_xs1_tail 0.169f
C1173 xc5_dip VSUBS 0.0815f
C1174 cn7 bp10 0.0744f
C1175 cn0 cn12 0.0909f
C1176 bp1 vref 0.04f
C1177 bn10 VSUBS 0.123f
C1178 bn10 cp0 0.288f
C1179 cp10 xc5_outnb 0.229f
C1180 cp12 xc4_dip 0.228f
C1181 in1n VSUBS 0.0954f
C1182 cn3 VSUBS 0.053f
C1183 bn12 VSUBS 0.153f
C1184 cp11 VSUBS 0.194f
C1185 cp7 VSUBS 0.104f
C1186 cp9 lsb_n 0.177f
C1187 xs1n_n10 VSUBS 0.09f
C1188 xs0p_cbn trk0 0.0823f
C1189 cp5 xc4_din 0.459f
C1190 bn1 VSUBS 0.42f
C1191 clk cp7 0.0907f
C1192 xs1p_cbn on 0.0162f
C1193 cp9 cp9 0.0726f
C1194 in1p xs0p_n10 0.228f
C1195 bn12 cp2 0.258f
C1196 bn2 VSUBS 0.0755f
C1197 xc4_lt VSUBS 0.11f
C1198 bn2 cn5 0.36f
C1199 xs1p_n10 VSUBS 0.225f
C1200 xs0n_g VSUBS 0.0865f
C1201 trk0 VSUBS 0.255f
C1202 bp5 VSUBS 0.144f
C1203 xc5_dip VSUBS 0.034f
C1204 cp0 VSUBS 0.153f
C1205 in1n vbp 0.0524f
C1206 xs0n_n10 VSUBS 0.191f
C1207 cp6 VSUBS 0.18f
C1208 vbp VSUBS 0.307f
C1209 xs0n_g VSUBS 0.224f
C1210 top_p bn12 0.149f
C1211 cp4 in0n 0.053f
C1212 vrefl cn6 0.0542f
C1213 xs1p_g VSUBS 0.828f
C1214 bn8 VSUBS 0.0486f
C1215 bp5 VSUBS 0.251f
C1216 on cn8 0.12f
C1217 bn3 VSUBS 0.16f
C1218 xc4_xs1_tail VSUBS 0.0146f
C1219 xs1p_cbp VSUBS 0.092f
C1220 cn2 VSUBS 1.03f
C1221 lsb_p VSUBS 0.586f
C1222 clk VSUBS 0.538f
C1223 xs1n_x VSUBS 0.275f
C1224 xs0n_g VSUBS 0.0338f
C1225 bn11 VSUBS 0.66f
C1226 cn6 VSUBS 0.08f
C1227 xc4_lt VSUBS 0.163f
C1228 cp6 VSUBS 0.138f
C1229 bn7 VSUBS 0.696f
C1230 bp10 VSUBS 1.2f
C1231 bp1 VSUBS 0.119f
C1232 bp7 xs0n_cbn 0.0709f
C1233 bn0 bn0 0.158f
C1234 xc5_lt bp5 0.291f
C1235 xs1p_cbp cn4 0.0393f
C1236 xs1n_n10 xs1p_g 0.0999f
C1237 xc5_outnb VSUBS 0.0826f
C1238 xs1p_cbp VSUBS 0.143f
C1239 xs0p_n10 VSUBS 0.179f
C1240 xc5_lt VSUBS 0.272f
C1241 bn0 VSUBS 0.0812f
C1242 cn2 cp3 0.22f
C1243 cp1 VSUBS 0.376f
C1244 xs1n_cbn xs0p_x 0.496f
C1245 bp4 in1n 0.135f
C1246 bn4 xc5_din 0.123f
C1247 xc4_din VSUBS 0.144f
C1248 xs0p_g VSUBS 0.166f
C1249 clk cp5 0.0858f
C1250 bp9 VSUBS 0.0509f
C1251 cn1 cn10 0.287f
C1252 trk0 VSUBS 0.0688f
C1253 bp3 VSUBS 0.109f
C1254 in1p VSUBS 0.0893f
C1255 cn4 VSUBS 0.0702f
C1256 vref VSUBS 0.0494f
C1257 xs1n_n10 xc4_din 0.243f
C1258 vrefl VSUBS 0.125f
C1259 xs1n_n10 xc5_outpb 0.0632f
C1260 bp6 cn6 0.261f
C1261 op VSUBS 0.12f
C1262 t1b VSUBS 0.106f
C1263 vbp VSUBS 0.124f
C1264 clk VSUBS 0.0527f
C1265 cp4 VSUBS 0.16f
C1266 bp8 xs1p_cbn 0.154f
C1267 xc4_xs1_tail0 xc4_outnb 0.0547f
C1268 xc5_din cn6 0.0871f
C1269 bp4 vrefl 0.265f
C1270 cn9 xs1p_n10 0.0901f
C1271 vbp bn7 0.0902f
C1272 in0n cp2 0.247f
C1273 bp3 VSUBS 0.0469f
C1274 xc4_xs1_tail VSUBS 0.267f
C1275 bn4 VSUBS 0.483f
C1276 cn1 VSUBS 0.0177f
C1277 xs1n_cbp cp12 0.209f
C1278 xc4_din VSUBS 0.0614f
C1279 t0 VSUBS 0.207f
C1280 bn10 VSUBS 0.289f
C1281 xs0p_cbp xs1n_cbn 0.414f
C1282 cp12 cn11 0.135f
C1283 top_n cp1 0.169f
C1284 xs0n_n10 VSUBS 0.172f
C1285 on xs0n_g 0.033f
C1286 cp9 VSUBS 0.218f
C1287 cp9 in0p 0.0876f
C1288 cn8 VSUBS 0.132f
C1289 xs1p_cbn cp10 0.228f
C1290 xc5_dip cp3 0.0512f
C1291 cn9 VSUBS 0.0864f
C1292 cn5 VSUBS 0.185f
C1293 cn9 cn9 0.202f
C1294 trk0 VSUBS 0.0895f
C1295 cn7 VSUBS 0.0411f
C1296 t0b xs1n_cbn 0.0585f
C1297 bn12 VSUBS 0.119f
C1298 xc5_dip xs1p_g 0.0276f
C1299 top_n bn5 0.123f
C1300 bn12 bp9 0.39f
C1301 vrefl on 0.191f
C1302 xs0p_x VSUBS 0.17f
C1303 bn3 VSUBS 0.253f
C1304 bn9 in1p 0.0685f
C1305 xs1p_g VSUBS 0.228f
C1306 bp9 VSUBS 0.393f
C1307 cp4 VSUBS 0.444f
C1308 xs0n_cbn VSUBS 0.22f
C1309 xc5_xs1_tail0 xc4_xs1_tail0 0.0173f
C1310 cn5 cp12 0.0839f
C1311 xc4_outnb VSUBS 0.242f
C1312 op xs1p_g 0.202f
C1313 bn9 VSUBS 0.153f
C1314 bp9 VSUBS 0.331f
C1315 cp9 xs1n_cbp 0.275f
C1316 bp8 VSUBS 0.379f
C1317 bn5 cn2 0.162f
C1318 bn5 VSUBS 0.157f
C1319 op VSUBS 0.218f
C1320 xs0n_cbn VSUBS 0.122f
C1321 bn6 xs0p_n10 0.313f
C1322 trk0 lsb_p 0.344f
C1323 cn2 VSUBS 0.516f
C1324 vbp VSUBS 0.175f
C1325 xs0p_cbn VSUBS 0.0919f
C1326 bp1 VSUBS 0.0681f
C1327 clknb bp9 0.204f
C1328 in0n cn5 0.0295f
C1329 trk0 op 0.652f
C1330 cp2 xs0n_n10 0.0664f
C1331 in1p VSUBS 0.135f
C1332 bn5 cn1 0.428f
C1333 t0 xs0p_cbn 0.168f
C1334 bn12 cn0 0.0536f
C1335 cn6 VSUBS 0.158f
C1336 in0n VSUBS 0.0703f
C1337 in0n VSUBS 0.161f
C1338 bp11 cp10 0.262f
C1339 bn1 VSUBS 0.263f
C1340 xs1n_cbn VSUBS 0.0921f
C1341 xs0n_n10 VSUBS 0.0919f
C1342 xs1n_g onp 0.14f
C1343 cn11 VSUBS 0.178f
C1344 in1p VSUBS 0.2f
C1345 lsb_p VSUBS 0.176f
C1346 clknb VSUBS 0.0733f
C1347 t0 VSUBS 0.0369f
C1348 xs1n_g VSUBS 0.376f
C1349 trk0 VSUBS 0.179f
C1350 xs0n_cbp VSUBS 0.0745f
C1351 top_p bp2 0.415f
C1352 xs0n_cbp VSUBS 0.0666f
C1353 xc4_outnb VSUBS 0.201f
C1354 top_p VSUBS 0.0793f
C1355 onn VSUBS 0.153f
C1356 bp12 VSUBS 0.228f
C1357 bn9 bn12 0.0672f
C1358 xc5_lt cn1 0.128f
C1359 cp3 VSUBS 0.264f
C1360 cn3 top_n 0.156f
C1361 xs0n_g VSUBS 0.0783f
C1362 t1b on 0.141f
C1363 xs0p_cbp VSUBS 0.272f
C1364 cn6 VSUBS 0.11f
C1365 bp10 VSUBS 0.112f
C1366 xs0n_cbn VSUBS 0.147f
C1367 xs0p_x VSUBS 0.207f
C1368 xs0p_x VSUBS 0.331f
C1369 xs1p_n10 cn5 0.118f
C1370 cn2 cp6 0.0544f
C1371 xc5_outnb VSUBS 0.151f
C1372 cp8 VSUBS 0.125f
C1373 cn5 VSUBS 0.0912f
C1374 cp10 bn3 0.15f
C1375 xc4_outnb VSUBS 0.0922f
C1376 xc5_xs1_tail cp10 0.0344f
C1377 top_p VSUBS 0.174f
C1378 xs1n_x VSUBS 0.0748f
C1379 xs1p_cbp xc4_xs1_tail0 0.28f
C1380 cp12 VSUBS 0.225f
C1381 onn VSUBS 0.0109f
C1382 xc5_outpb VSUBS 0.071f
C1383 xc4_outpb VSUBS 0.171f
C1384 cn3 cp2 0.0528f
C1385 xc4_din xs0p_x 0.103f
C1386 cn1 trk0 0.1f
C1387 cn3 op 0.12f
C1388 bn10 VSUBS 0.107f
C1389 bp7 VSUBS 0.204f
C1390 xs1p_n10 cp1 0.325f
C1391 bn3 VSUBS 0.051f
C1392 vdd cp8 0.229f
C1393 xs1n_cbn VSUBS 0.368f
C1394 xc5_xs1_tail0 xs0n_x 0.183f
C1395 xs1n_cbn VSUBS 0.0598f
C1396 xs0n_cbp xs1p_cbn 0.128f
C1397 vdd VSUBS 0.401f
C1398 clk VSUBS 0.296f
C1399 xc4_xs1_tail VSUBS 0.0927f
C1400 in0p VSUBS 0.146f
C1401 bp12 VSUBS 0.391f
C1402 cp5 VSUBS 0.102f
C1403 nr VSUBS 0.0996f
C1404 bn8 VSUBS 0.0741f
C1405 top_p VSUBS 0.172f
C1406 bn10 VSUBS 0.799f
C1407 xc5_lt t1 0.17f
C1408 cn5 bn8 0.0798f
C1409 cp7 xs0n_g 0.103f
C1410 vref bp10 0.446f
C1411 xs1n_g VSUBS 0.123f
C1412 bn5 bp1 0.0357f
C1413 rstb xs0p_g 0.361f
C1414 onn VSUBS 0.0977f
C1415 lsb_p cn5 0.108f
C1416 xc5_xs1_tail0 cp8 0.246f
C1417 cp1 cn9 0.0347f
C1418 bn9 VSUBS 0.141f
C1419 xc5_din bp11 0.197f
C1420 xc5_outpb xs1p_g 0.44f
C1421 vref VSUBS 0.128f
C1422 xc4_outpb VSUBS 0.122f
C1423 cp3 VSUBS 0.182f
C1424 cn4 VSUBS 0.0425f
C1425 bn1 VSUBS 0.147f
C1426 vbn cp3 0.543f
C1427 bn3 VSUBS 0.0885f
C1428 trk1 VSUBS 0.487f
C1429 xc4_lt VSUBS 0.0959f
C1430 bp4 VSUBS 0.0702f
C1431 t1 VSUBS 0.477f
C1432 xc4_xs1_tail xs0n_g 0.127f
C1433 xc5_xs1_tail VSUBS 0.162f
C1434 cn10 on 0.284f
C1435 cn2 VSUBS 0.244f
C1436 cp4 cn2 0.0635f
C1437 cp9 VSUBS 0.108f
C1438 in1p xc4_dip 0.0629f
C1439 t1 VSUBS 0.293f
C1440 bp3 bp8 0.138f
C1441 bn12 bn6 0.7f
C1442 cp9 VSUBS 0.118f
C1443 xc4_outnb xs1n_cbp 0.103f
C1444 bn4 VSUBS 0.162f
C1445 bp9 VSUBS 0.21f
C1446 cn4 VSUBS 0.341f
C1447 bp0 cn7 0.026f
C1448 cp5 VSUBS 0.0926f
C1449 xc4_outpb VSUBS 0.0643f
C1450 xc4_din VSUBS 0.0304f
C1451 xc4_din VSUBS 0.0723f
C1452 bp3 xs1p_g 0.248f
C1453 bp6 VSUBS 0.0836f
C1454 t0 cn1 0.169f
C1455 bp0 VSUBS 0.129f
C1456 xc5_xs1_tail xs0p_cbp 0.134f
C1457 bp12 VSUBS 0.741f
C1458 cp6 VSUBS 0.208f
C1459 top_p VSUBS 0.469f
C1460 t0b bp0 0.413f
C1461 bp12 VSUBS 0.028f
C1462 cn5 xc4_lt 0.117f
C1463 cp4 VSUBS 0.0871f
C1464 xs1n_cbn clknb 0.0815f
C1465 in0n VSUBS 0.615f
C1466 cp10 lsb_n 0.508f
C1467 cp12 VSUBS 0.0793f
C1468 on VSUBS 0.0275f
C1469 vbn cn11 1.04f
C1470 bn8 VSUBS 0.245f
C1471 in1p VSUBS 0.107f
C1472 t0b VSUBS 0.553f
C1473 vbn VSUBS 0.207f
C1474 bp4 cp9 0.45f
C1475 bp0 VSUBS 0.118f
C1476 in0p rstb 0.201f
C1477 rstb_n VSUBS 0.317f
C1478 cp7 xs0p_cbn 0.169f
C1479 nr VSUBS 0.135f
C1480 xc5_dip VSUBS 0.172f
C1481 cn11 VSUBS 0.521f
C1482 bp4 VSUBS 0.146f
C1483 cn6 VSUBS 0.489f
C1484 trk0 xs1p_n10 0.258f
C1485 xs0p_cbn VSUBS 1.48f
C1486 bn7 VSUBS 0.44f
C1487 cn3 bp3 0.378f
C1488 bp9 VSUBS 0.137f
C1489 xs0p_cbp cn1 0.0257f
C1490 bp4 VSUBS 0.103f
C1491 cn0 VSUBS 0.0651f
C1492 cp3 VSUBS 0.0978f
C1493 xs0n_x xc5_din 0.237f
C1494 t0b VSUBS 0.24f
C1495 xs1p_g VSUBS 0.389f
C1496 onp VSUBS 0.313f
C1497 bn9 VSUBS 0.0977f
C1498 in0p VSUBS 0.137f
C1499 clkb VSUBS 0.231f
C1500 xs1n_cbn cp2 0.0968f
C1501 in0p VSUBS 0.0702f
C1502 bn2 VSUBS 0.271f
C1503 xs0p_cbn cp8 0.206f
C1504 xc4_xs1_tail VSUBS 0.0852f
C1505 xc5_xs1_tail0 VSUBS 0.139f
C1506 xc5_xs1_tail VSUBS 0.034f
C1507 xs0n_cbn VSUBS 0.428f
C1508 clknb cp5 0.0948f
C1509 in1n bp4 0.0974f
C1510 xs1n_n10 xc5_xs1_tail 0.0484f
C1511 clkb VSUBS 0.361f
C1512 top_n VSUBS 0.472f
C1513 bn4 VSUBS 0.201f
C1514 xs0p_cbn VSUBS 0.0963f
C1515 xc4_lt on 0.133f
C1516 bp1 xs1p_x 0.0875f
C1517 clkn VSUBS 0.239f
C1518 cn1 bn3 0.154f
C1519 xs1n_g bn1 0.184f
C1520 cn11 VSUBS 0.0688f
C1521 xs1n_n10 VSUBS 0.591f
C1522 cp8 VSUBS 0.113f
C1523 xc5_din VSUBS 0.0817f
C1524 in0p vbn 0.0525f
C1525 xc5_xs1_tail0 VSUBS 0.256f
C1526 vbn xs1p_cbp 0.357f
C1527 in0n cn8 0.256f
C1528 cn12 VSUBS 0.13f
C1529 cn12 VSUBS 0.0784f
C1530 bp9 vbn 0.0689f
C1531 t0 cn4 0.144f
C1532 bn0 VSUBS 0.172f
C1533 cn1 VSUBS 0.0798f
C1534 xs1p_g VSUBS 0.0918f
C1535 gnd VSUBS 0.161f
C1536 bp3 VSUBS 0.0306f
C1537 xs1p_cbp VSUBS 0.162f
C1538 vdd xs1p_x 0.29f
C1539 xs0p_g VSUBS 0.283f
C1540 bp5 VSUBS 0.0969f
C1541 cp12 VSUBS 0.372f
C1542 bp3 cn4 0.0712f
C1543 onn lsb_p 0.201f
C1544 bp11 VSUBS 0.482f
C1545 top_n VSUBS 0.568f
C1546 clkn VSUBS 0.171f
C1547 gnd bp2 0.123f
C1548 xs1p_x VSUBS 0.104f
C1549 xs1n_n10 bp12 0.216f
C1550 top_n VSUBS 0.0727f
C1551 xs1n_n10 VSUBS 0.319f
C1552 cn3 xc5_dip 0.692f
C1553 bp4 VSUBS 0.124f
C1554 bp3 xc5_din 0.0584f
C1555 cp1 VSUBS 0.151f
C1556 in1p VSUBS 0.131f
C1557 bn10 cp11 0.256f
C1558 cp9 VSUBS 0.144f
C1559 bp2 VSUBS 0.726f
C1560 xs0n_x cp5 0.297f
C1561 xs0p_cbp VSUBS 0.15f
C1562 cp11 VSUBS 0.278f
C1563 bp6 VSUBS 0.181f
C1564 clk xs0n_n10 1.21f
C1565 cn4 VSUBS 0.0543f
C1566 nr VSUBS 0.089f
C1567 bp3 VSUBS 0.202f
C1568 bp0 VSUBS 0.0474f
C1569 op VSUBS 0.159f
C1570 cn7 VSUBS 0.259f
C1571 xs1n_cbn VSUBS 0.0589f
C1572 cn4 xs0n_cbp 0.218f
C1573 cn1 VSUBS 0.0748f
C1574 xs0n_cbp VSUBS 0.285f
C1575 vdd VSUBS 0.373f
C1576 xc5_outnb xs0p_n10 0.151f
C1577 xs0p_g VSUBS 0.0784f
C1578 xs0n_cbp VSUBS 0.243f
C1579 bn1 VSUBS 0.351f
C1580 bp11 in0n 0.107f
C1581 on xc5_outpb 0.165f
C1582 bp9 VSUBS 0.813f
C1583 xc5_xs1_tail VSUBS 0.11f
C1584 bp2 VSUBS 0.0855f
C1585 bn4 VSUBS 0.0877f
C1586 cp4 bp7 0.111f
C1587 cn10 VSUBS 0.152f
C1588 t1b bn5 0.0237f
C1589 vdd VSUBS 0.251f
C1590 lsb_n xc5_din 0.511f
C1591 vbp VSUBS 0.049f
C1592 t0 bn12 0.34f
C1593 in0p bn0 0.0628f
C1594 bn0 VSUBS 0.273f
C1595 bn2 VSUBS 0.39f
C1596 xs0p_n10 VSUBS 0.0332f
C1597 cn11 VSUBS 0.889f
C1598 xs1n_g VSUBS 0.0434f
C1599 trk1 VSUBS 0.284f
C1600 cn4 VSUBS 0.116f
C1601 bp3 VSUBS 0.0523f
C1602 xs1p_n10 bp4 0.149f
C1603 in1n cn1 0.118f
C1604 onn VSUBS 0.337f
C1605 cp3 onp 0.0896f
C1606 bp4 in1n 0.832f
C1607 trk1 VSUBS 0.0827f
C1608 xs1n_x VSUBS 0.0636f
C1609 bp9 VSUBS 0.0649f
C1610 xs0p_n10 VSUBS 0.077f
C1611 bp2 cp3 0.49f
C1612 onn VSUBS 0.115f
C1613 bn0 VSUBS 0.0827f
C1614 in0n xc4_xs1_tail 0.0306f
C1615 xs1p_cbn xs0n_cbp 0.0731f
C1616 xs1p_n10 bp5 0.029f
C1617 bp2 VSUBS 0.0457f
C1618 trk1 VSUBS 0.109f
C1619 bn5 xs0n_x 0.076f
C1620 t1 VSUBS 0.728f
C1621 xc5_dip t0b 0.233f
C1622 clkn bn7 0.0621f
C1623 xs1p_cbp VSUBS 0.138f
C1624 cp9 onp 0.102f
C1625 bn0 xc4_xs1_tail0 0.393f
C1626 cp4 VSUBS 0.0788f
C1627 xs0p_cbp VSUBS 0.217f
C1628 bp3 VSUBS 0.151f
C1629 xs1p_x vref 0.302f
C1630 bn6 xs1n_n10 0.0778f
C1631 cp11 cn12 0.158f
C1632 cn4 bp1 0.0929f
C1633 bn11 VSUBS 0.0515f
C1634 xs1p_cbn VSUBS 0.213f
C1635 bp2 cn8 0.0728f
C1636 cp8 VSUBS 0.0395f
C1637 cn2 cn12 0.0578f
C1638 xc4_outpb VSUBS 0.0635f
C1639 cn9 bp5 0.332f
C1640 xs1n_x VSUBS 0.126f
C1641 cn4 xc5_din 0.142f
C1642 cp12 VSUBS 0.168f
C1643 bp6 clkn 0.183f
C1644 cn11 t0 0.221f
C1645 cp6 in1n 0.112f
C1646 bn2 VSUBS 0.258f
C1647 clkb xs1p_cbn 0.2f
C1648 xs0p_n10 VSUBS 0.0498f
C1649 xc5_lt cn1 0.131f
C1650 in0p VSUBS 0.0561f
C1651 bp12 xs1n_cbn 0.109f
C1652 cp7 xs1p_cbp 0.0713f
C1653 bn6 VSUBS 0.25f
C1654 vbn xc5_outnb 0.0656f
C1655 cn0 xs0n_cbn 0.0552f
C1656 in0p VSUBS 0.0555f
C1657 xs1p_n10 t1b 0.116f
C1658 clkn VSUBS 0.0365f
C1659 cp5 VSUBS 0.39f
C1660 in0n VSUBS 0.0468f
C1661 bp10 VSUBS 0.257f
C1662 in0n VSUBS 0.126f
C1663 rstb_n VSUBS 0.0365f
C1664 xs1n_x VSUBS 0.167f
C1665 cp6 clkb 0.233f
C1666 xs1n_cbn xs1p_cbn 0.0744f
C1667 vbn xc5_din 0.116f
C1668 vrefl VSUBS 0.518f
C1669 bp7 xs0p_n10 0.295f
C1670 bp7 cn4 0.42f
C1671 onp VSUBS 0.613f
C1672 bp1 cn3 0.129f
C1673 xc5_dip VSUBS 0.601f
C1674 xs0p_n10 VSUBS 0.375f
C1675 xs1n_cbn cp8 0.567f
C1676 xs1p_cbn lsb_n 0.29f
C1677 onp VSUBS 0.104f
C1678 in0n VSUBS 0.26f
C1679 lsb_n VSUBS 0.0783f
C1680 gnd xc4_lt 0.163f
C1681 t1 VSUBS 0.174f
C1682 xc4_din VSUBS 0.336f
C1683 bn7 VSUBS 0.0441f
C1684 cn9 VSUBS 0.216f
C1685 xc4_xs1_tail VSUBS 0.331f
C1686 clkb xs0p_cbn 0.0802f
C1687 bn1 VSUBS 0.139f
C1688 xs1p_x VSUBS 0.279f
C1689 bp4 xs1p_cbp 0.225f
C1690 rstb_n cp0 0.27f
C1691 xs0p_g VSUBS 0.172f
C1692 t0 vbn 0.067f
C1693 clk clkn 0.177f
C1694 t1 VSUBS 0.247f
C1695 bn5 VSUBS 0.0766f
C1696 bp3 VSUBS 0.182f
C1697 xs1p_g VSUBS 0.216f
C1698 on VSUBS 0.135f
C1699 cn4 VSUBS 0.0851f
C1700 bp9 vbn 0.352f
C1701 xc4_xs1_tail0 bn10 0.287f
C1702 xc5_dip VSUBS 0.124f
C1703 xs0n_cbp cn2 0.0517f
C1704 bp0 VSUBS 0.21f
C1705 xs1n_cbp VSUBS 0.11f
C1706 clk VSUBS 0.148f
C1707 cp10 xs1n_cbp 0.0698f
C1708 bn1 VSUBS 0.0574f
C1709 cp9 cn8 0.3f
C1710 xs1p_cbn VSUBS 0.135f
C1711 bp8 vbp 0.374f
C1712 xs1p_g VSUBS 0.101f
C1713 bn0 VSUBS 0.0161f
C1714 bp12 xs1n_cbp 0.283f
C1715 xc4_xs1_tail0 xc4_xs1_tail 0.527f
C1716 t1 VSUBS 0.0993f
C1717 in0p VSUBS 0.109f
C1718 bp8 xc4_outpb 0.316f
C1719 bp1 VSUBS 0.205f
C1720 cp10 VSUBS 0.432f
C1721 bp11 VSUBS 0.0585f
C1722 xc4_outpb xs1p_n10 0.0388f
C1723 cp10 VSUBS 0.093f
C1724 cn6 VSUBS 0.126f
C1725 nr xs0p_cbp 0.779f
C1726 bp6 VSUBS 0.236f
C1727 bn8 VSUBS 0.21f
C1728 clk cn7 0.0546f
C1729 bn0 VSUBS 0.279f
C1730 xs0p_x cp1 0.204f
C1731 bn12 VSUBS 0.135f
C1732 cn3 VSUBS 0.306f
C1733 bp1 VSUBS 0.107f
C1734 cn3 VSUBS 0.172f
C1735 xc5_xs1_tail0 bp3 0.481f
C1736 onn xc5_xs1_tail 0.11f
C1737 xc4_outpb VSUBS 0.0514f
C1738 bn8 bn11 0.0951f
C1739 xc4_outnb VSUBS 0.25f
C1740 lsb_p VSUBS 0.399f
C1741 on lsb_p 0.259f
C1742 t1 cp7 0.0782f
C1743 xs1p_n10 VSUBS 0.0568f
C1744 bn12 VSUBS 0.0542f
C1745 xs1n_x VSUBS 0.0183f
C1746 xs1n_n10 cp9 0.0994f
C1747 vref VSUBS 0.0914f
C1748 cp4 cn8 0.22f
C1749 xs0p_n10 cn11 0.188f
C1750 xc5_din VSUBS 0.503f
C1751 xs0p_cbp VSUBS 0.701f
C1752 xs0n_g xc4_outnb 0.0133f
C1753 bp5 VSUBS 0.115f
C1754 cp6 VSUBS 0.106f
C1755 xc4_dip VSUBS 0.348f
C1756 cp6 VSUBS 0.224f
C1757 bn1 VSUBS 0.284f
C1758 vref cp7 0.141f
C1759 xc5_outpb op 0.237f
C1760 rstb VSUBS 0.0959f
C1761 bp12 VSUBS 0.12f
C1762 clkb VSUBS 0.468f
C1763 cp4 bp5 0.18f
C1764 xs0p_g VSUBS 0.054f
C1765 t1 VSUBS 0.0458f
C1766 in0n xs0p_x 0.414f
C1767 bp3 t0 0.312f
C1768 xc4_xs1_tail0 VSUBS 0.0664f
C1769 bp1 VSUBS 0.376f
C1770 onn VSUBS 0.312f
C1771 cp5 VSUBS 0.215f
C1772 cn8 VSUBS 0.0183f
C1773 cp3 bp1 0.0994f
C1774 op VSUBS 0.111f
C1775 xs1p_g VSUBS 0.112f
C1776 bp2 VSUBS 0.159f
C1777 cp4 xs0p_n10 0.359f
C1778 xs1p_x VSUBS 0.0535f
C1779 vref bp11 0.0491f
C1780 t1 cp2 0.118f
C1781 bn0 VSUBS 0.247f
C1782 cp6 VSUBS 0.227f
C1783 bp11 VSUBS 0.0799f
C1784 bp7 VSUBS 0.586f
C1785 cn11 VSUBS 0.162f
C1786 in0n VSUBS 0.248f
C1787 bp5 VSUBS 0.0688f
C1788 cp0 xc5_outnb 0.131f
C1789 cp8 cp7 0.149f
C1790 t0b VSUBS 0.176f
C1791 xs1n_cbn VSUBS 0.135f
C1792 cn0 VSUBS 0.155f
C1793 in1n VSUBS 0.11f
C1794 rstb VSUBS 0.249f
C1795 cn10 VSUBS 0.283f
C1796 xs1n_g VSUBS 0.185f
C1797 xs0p_x VSUBS 0.17f
C1798 vrefl bp11 0.194f
C1799 clknb xc4_outnb 0.386f
C1800 vdd clk 0.0859f
C1801 bp4 VSUBS 0.125f
C1802 trk1 VSUBS 0.241f
C1803 xc4_lt VSUBS 0.107f
C1804 in1n VSUBS 0.313f
C1805 bn11 VSUBS 0.404f
C1806 cp10 VSUBS 0.097f
C1807 onn VSUBS 0.14f
C1808 xc4_outnb VSUBS 0.602f
C1809 xc4_dip onn 0.267f
C1810 bp9 clkb 0.0538f
C1811 cp3 VSUBS 0.139f
C1812 clkn VSUBS 0.239f
C1813 xs0p_cbp VSUBS 0.159f
C1814 xs1n_cbp VSUBS 0.467f
C1815 cn7 cn9 0.351f
C1816 op xc4_din 0.517f
C1817 cn2 cn1 0.113f
C1818 xs1p_g xs0n_x 0.119f
C1819 bn7 VSUBS 1.31f
C1820 clkn cp1 0.31f
C1821 cn1 VSUBS 0.165f
C1822 cn7 lsb_n 0.0689f
C1823 clk VSUBS 0.0548f
C1824 bp1 VSUBS 0.214f
C1825 trk1 xs0p_n10 0.105f
C1826 xs0n_x VSUBS 0.274f
C1827 bn9 xc4_dip 0.276f
C1828 t1b VSUBS 0.293f
C1829 xc4_xs1_tail VSUBS 0.104f
C1830 bp11 VSUBS 0.0572f
C1831 op VSUBS 0.0211f
C1832 xs1p_g VSUBS 0.279f
C1833 bn5 t1b 0.191f
C1834 xs0p_g cn4 0.252f
C1835 t0b VSUBS 0.173f
C1836 xs1n_g VSUBS 0.0583f
C1837 cp6 bp4 0.0753f
C1838 vref bn0 0.132f
C1839 lsb_p bn12 0.0578f
C1840 in1p VSUBS 0.102f
C1841 bp5 VSUBS 0.105f
C1842 cn11 VSUBS 0.368f
C1843 bn8 VSUBS 0.198f
C1844 onp trk1 0.0588f
C1845 top_p rstb 0.0639f
C1846 bp4 VSUBS 0.0562f
C1847 rstb bp7 0.368f
C1848 xs0n_x VSUBS 0.106f
C1849 lsb_p VSUBS 0.0344f
C1850 xs1p_g VSUBS 0.307f
C1851 xs0n_cbp xs1n_g 0.247f
C1852 cn8 VSUBS 0.0877f
C1853 bp6 t1 0.108f
C1854 cp12 VSUBS 0.17f
C1855 lsb_p VSUBS 0.119f
C1856 xs0p_n10 bn5 0.17f
C1857 xs1p_cbp VSUBS 0.739f
C1858 cn10 VSUBS 0.452f
C1859 bn1 VSUBS 0.076f
C1860 cp0 VSUBS 0.218f
C1861 cp11 bn2 0.128f
C1862 cn3 cp11 0.054f
C1863 bp10 VSUBS 0.163f
C1864 cn0 xs0n_cbp 0.118f
C1865 cn7 VSUBS 0.29f
C1866 xs1p_cbp VSUBS 0.299f
C1867 cp7 bp9 0.161f
C1868 xs0p_n10 cp9 0.387f
C1869 cp0 VSUBS 0.113f
C1870 xc5_xs1_tail VSUBS 0.0734f
C1871 cn3 VSUBS 0.192f
C1872 xs0n_g VSUBS 0.214f
C1873 xc4_dip VSUBS 0.683f
C1874 xs0n_n10 VSUBS 0.177f
C1875 cp5 xs0n_n10 0.16f
C1876 in1p VSUBS 0.204f
C1877 xs0p_cbn VSUBS 0.0242f
C1878 onp VSUBS 0.293f
C1879 bn7 VSUBS 0.382f
C1880 bn4 onp 0.223f
C1881 xs1n_x VSUBS 0.14f
C1882 cp2 cn6 0.333f
C1883 xs1n_cbp op 0.255f
C1884 xs0p_x on 0.118f
C1885 cn5 VSUBS 0.106f
C1886 xc4_outnb VSUBS 0.152f
C1887 cp6 VSUBS 0.356f
C1888 cp1 cn5 0.23f
C1889 xc5_xs1_tail0 VSUBS 0.118f
C1890 xs0p_x VSUBS 0.0513f
C1891 bn12 VSUBS 0.0796f
C1892 trk1 lsb_p 0.0949f
C1893 rstb_n xc4_din 0.101f
C1894 xs1p_n10 bn9 0.198f
C1895 bp7 VSUBS 0.172f
C1896 cp7 VSUBS 0.209f
C1897 xc5_outnb VSUBS 0.117f
C1898 xc5_xs1_tail0 VSUBS 0.115f
C1899 xs0n_g bp7 0.133f
C1900 lsb_p VSUBS 0.123f
C1901 lsb_n VSUBS 0.159f
C1902 xs0n_g VSUBS 0.175f
C1903 bp8 xs0p_cbn 0.155f
C1904 cn11 VSUBS 0.0642f
C1905 on VSUBS 0.4f
C1906 xs1n_x cp7 0.333f
C1907 xc4_xs1_tail VSUBS 0.126f
C1908 clknb xs1p_cbn 0.0611f
C1909 cn0 VSUBS 0.333f
C1910 xs1n_cbp xs0p_cbn 0.123f
C1911 xc4_lt cp0 0.0516f
C1912 in1n VSUBS 0.0205f
C1913 xc5_dip cp3 0.423f
C1914 bp3 VSUBS 0.133f
C1915 bp8 VSUBS 0.297f
C1916 bp5 t0b 0.416f
C1917 cn2 VSUBS 0.0717f
C1918 bp10 cp3 0.0915f
C1919 clkb VSUBS 0.122f
C1920 bn7 VSUBS 0.15f
C1921 cn8 on 0.22f
C1922 cn11 VSUBS 0.512f
C1923 xs0p_cbp VSUBS 0.179f
C1924 lsb_n VSUBS 0.172f
C1925 cp5 VSUBS 0.167f
C1926 bn3 bn12 0.194f
C1927 cp12 VSUBS 0.789f
C1928 xs0n_g VSUBS 0.0236f
C1929 vref VSUBS 0.26f
C1930 in1p xs1n_g 0.061f
C1931 cn2 VSUBS 0.426f
C1932 top_p VSUBS 0.106f
C1933 xc4_outnb VSUBS 0.301f
C1934 xs0n_cbn bn5 0.745f
C1935 bn4 xc5_xs1_tail0 0.308f
C1936 xc4_xs1_tail0 VSUBS 0.405f
C1937 xs0n_cbn VSUBS 0.059f
C1938 xs0n_cbp xs0p_cbp 0.122f
C1939 bp8 VSUBS 0.331f
C1940 top_p cn10 0.183f
C1941 onn VSUBS 0.241f
C1942 bp2 cn1 0.0885f
C1943 vrefl top_p 0.0705f
C1944 bp6 VSUBS 0.437f
C1945 bn2 VSUBS 0.106f
C1946 cn6 xs0n_cbp 0.0468f
C1947 bn7 VSUBS 0.0822f
C1948 xc5_outpb cn0 0.0726f
C1949 xc4_xs1_tail0 VSUBS 0.0479f
C1950 xs0p_g onp 0.219f
C1951 clknb VSUBS 0.514f
C1952 xs0n_n10 VSUBS 0.243f
C1953 bn8 VSUBS 0.106f
C1954 bn4 VSUBS 0.23f
C1955 cn11 VSUBS 0.221f
C1956 in1n VSUBS 0.0832f
C1957 op VSUBS 0.0954f
C1958 in1p VSUBS 0.0232f
C1959 bp11 lsb_p 0.0671f
C1960 bp4 VSUBS 0.0636f
C1961 bp4 VSUBS 0.22f
C1962 cp1 VSUBS 0.149f
C1963 op xs1n_cbp 0.166f
C1964 bn4 VSUBS 0.341f
C1965 cp11 VSUBS 0.27f
C1966 cp8 cp12 0.341f
C1967 bn7 bp5 0.0455f
C1968 cp8 VSUBS 0.26f
C1969 xs1n_n10 xs0p_cbp 0.191f
C1970 bp12 vref 0.0734f
C1971 cp1 VSUBS 0.0949f
C1972 bn3 VSUBS 0.366f
C1973 lsb_n VSUBS 0.0914f
C1974 xc5_outnb VSUBS 0.24f
C1975 trk0 t1 0.131f
C1976 xs0p_n10 xc5_xs1_tail 0.0223f
C1977 nr VSUBS 0.0599f
C1978 gnd VSUBS 0.127f
C1979 bp3 bp12 0.0449f
C1980 vdd VSUBS 0.272f
C1981 t0 VSUBS 0.594f
C1982 cp9 xc5_din 0.0655f
C1983 t0b VSUBS 0.238f
C1984 clkn VSUBS 0.115f
C1985 bn5 VSUBS 0.0931f
C1986 t0 xc5_outpb 0.304f
C1987 xs0p_cbn lsb_n 0.0884f
C1988 bn12 cp0 0.0763f
C1989 xs1n_cbn onp 0.145f
C1990 xs0p_cbp VSUBS 0.0578f
C1991 cp4 VSUBS 0.214f
C1992 cn3 VSUBS 0.131f
C1993 cn0 VSUBS 0.122f
C1994 xs0p_x VSUBS 0.281f
C1995 xs0n_x VSUBS 0.168f
C1996 xs1n_n10 VSUBS 0.0565f
C1997 t1b VSUBS 0.0672f
C1998 xs1p_x cp1 0.117f
C1999 in0n xs1n_x 0.163f
C2000 xs1n_n10 VSUBS 0.148f
C2001 bp5 VSUBS 0.208f
C2002 in1n VSUBS 0.0713f
C2003 t1b VSUBS 0.142f
C2004 clknb vbn 0.822f
C2005 bn7 cn8 0.289f
C2006 top_n cp12 0.043f
C2007 lsb_p VSUBS 0.107f
C2008 onn VSUBS 0.164f
C2009 bn9 xs1n_g 0.0177f
C2010 lsb_p bn4 0.07f
C2011 xc4_outpb VSUBS 0.104f
C2012 xc5_outnb VSUBS 0.106f
C2013 xs0p_x vref 0.132f
C2014 bp6 VSUBS 0.0732f
C2015 xs1n_cbp VSUBS 0.161f
C2016 trk0 VSUBS 0.0588f
C2017 gnd in0p 0.108f
C2018 cp7 VSUBS 0.528f
C2019 cn8 VSUBS 0.075f
C2020 cn4 cn9 0.193f
C2021 bp3 VSUBS 0.214f
C2022 xs1n_n10 VSUBS 0.257f
C2023 xc4_outpb rstb_n 0.588f
C2024 cn12 VSUBS 0.0645f
C2025 cn6 VSUBS 0.111f
C2026 rstb VSUBS 0.285f
C2027 xc4_dip vrefl 0.0702f
C2028 gnd VSUBS 0.045f
C2029 vrefl VSUBS 0.0536f
C2030 xc4_xs1_tail VSUBS 0.197f
C2031 vbp VSUBS 0.287f
C2032 clknb VSUBS 0.0439f
C2033 cn6 VSUBS 0.345f
C2034 xs1p_g VSUBS 0.158f
C2035 xs1p_n10 VSUBS 0.225f
C2036 xc5_lt VSUBS 0.315f
C2037 xs1n_g xs1p_cbp 0.711f
C2038 vbn bp6 0.0444f
C2039 bn3 VSUBS 0.115f
C2040 cp9 VSUBS 0.719f
C2041 cp0 VSUBS 0.11f
C2042 t1 cp8 0.0524f
C2043 bp7 cn9 0.45f
C2044 xs0p_cbn VSUBS 0.106f
C2045 bp6 VSUBS 0.0782f
C2046 vbp VSUBS 0.173f
C2047 top_p VSUBS 0.78f
C2048 cp9 xs0n_n10 0.0897f
C2049 rstb xs0p_x 0.0884f
C2050 bn1 bp1 0.254f
C2051 xs0n_x VSUBS 0.056f
C2052 bn11 bn12 0.146f
C2053 cp5 VSUBS 0.0847f
C2054 bp3 VSUBS 0.0763f
C2055 bn11 cp1 0.116f
C2056 in1n VSUBS 0.0785f
C2057 cp10 VSUBS 0.327f
C2058 lsb_n on 0.394f
C2059 rstb VSUBS 0.0685f
C2060 xs0p_x xs0p_n10 0.23f
C2061 xc4_lt VSUBS 0.118f
C2062 xs0p_cbn VSUBS 0.163f
C2063 xs0p_g VSUBS 0.0953f
C2064 cp4 bn4 0.324f
C2065 in0n cp6 0.13f
C2066 cp4 in1p 0.183f
C2067 xs0n_g xs0n_x 0.408f
C2068 bn9 bn2 0.177f
C2069 on bp9 0.0303f
C2070 vdd VSUBS 0.127f
C2071 on VSUBS 0.134f
C2072 cp1 VSUBS 0.152f
C2073 xc4_dip vrefl 0.136f
C2074 xc4_xs1_tail VSUBS 0.467f
C2075 bn6 bn11 0.54f
C2076 xs0p_n10 VSUBS 0.0342f
C2077 bp6 bp5 0.0246f
C2078 cp7 VSUBS 0.273f
C2079 cp10 VSUBS 0.447f
C2080 xc4_outnb VSUBS 0.0787f
C2081 op VSUBS 0.315f
C2082 xs1p_x VSUBS 0.0424f
C2083 cp8 top_p 0.0744f
C2084 bp5 bn2 1.71f
C2085 xs1n_cbp VSUBS 0.109f
C2086 bn6 VSUBS 0.135f
C2087 bp4 VSUBS 0.138f
C2088 cn10 VSUBS 0.383f
C2089 bp3 xs1p_g 0.0804f
C2090 xc5_xs1_tail xc4_outnb 0.114f
C2091 cn6 xc4_xs1_tail0 0.034f
C2092 top_n cp6 0.162f
C2093 cn4 VSUBS 0.049f
C2094 bp12 VSUBS 0.351f
C2095 in1n VSUBS 0.287f
C2096 cn3 VSUBS 0.0466f
C2097 xc5_outnb cn1 0.0827f
C2098 xc5_lt VSUBS 0.402f
C2099 t0 VSUBS 0.199f
C2100 bp2 trk0 0.312f
C2101 cn0 VSUBS 0.148f
C2102 xc5_xs1_tail VSUBS 0.309f
C2103 cp6 VSUBS 0.129f
C2104 cp7 VSUBS 0.172f
C2105 xs1n_cbn VSUBS 0.165f
C2106 bp11 VSUBS 0.193f
C2107 cn12 bp3 0.177f
C2108 rstb xs1n_cbp 0.204f
C2109 xs1n_cbn VSUBS 0.144f
C2110 bn8 cp7 0.0378f
C2111 xc5_lt cn0 0.668f
C2112 rstb_n VSUBS 0.298f
C2113 t1b bn12 0.216f
C2114 cp11 bn1 0.0641f
C2115 xs1p_cbn VSUBS 0.463f
C2116 bp2 clknb 0.944f
C2117 xs0n_cbp VSUBS 0.0469f
C2118 bn11 VSUBS 0.0774f
C2119 xs1p_cbn lsb_n 0.694f
C2120 vdd VSUBS 0.345f
C2121 xc4_din VSUBS 0.0926f
C2122 t0 VSUBS 0.103f
C2123 vrefl bp0 0.187f
C2124 cn12 VSUBS 0.493f
C2125 xc5_dip VSUBS 0.175f
C2126 xs1p_n10 VSUBS 0.165f
C2127 vrefl t0 0.601f
C2128 cn9 VSUBS 0.462f
C2129 in0n VSUBS 0.0662f
C2130 xs0p_x VSUBS 0.109f
C2131 bp5 VSUBS 0.0451f
C2132 xs0n_x VSUBS 0.445f
C2133 lsb_n bn6 0.241f
C2134 bp0 VSUBS 0.2f
C2135 top_p VSUBS 0.23f
C2136 gnd VSUBS 0.212f
C2137 xs0n_cbn onp 0.0441f
C2138 xc5_outnb VSUBS 0.264f
C2139 xc4_outpb VSUBS 0.0185f
C2140 vbp VSUBS 0.152f
C2141 bn0 VSUBS 0.171f
C2142 xc5_lt VSUBS 0.0913f
C2143 cp7 VSUBS 0.209f
C2144 lsb_p VSUBS 0.0857f
C2145 cp8 bp7 0.376f
C2146 xs1p_cbn clknb 0.138f
C2147 bp3 VSUBS 0.095f
C2148 cn2 VSUBS 0.103f
C2149 vrefl cn9 0.145f
C2150 t0 xc5_outnb 0.487f
C2151 cp6 t1 0.157f
C2152 cn7 cn8 0.0594f
C2153 bp9 VSUBS 0.15f
C2154 bp6 VSUBS 0.131f
C2155 cn5 VSUBS 0.26f
C2156 xs0p_x VSUBS 0.143f
C2157 xc5_lt t1b 0.171f
C2158 vbp VSUBS 0.167f
C2159 xc4_outnb VSUBS 0.0916f
C2160 xs0n_cbn cp9 0.0688f
C2161 xc4_din xc4_outnb 0.19f
C2162 onn VSUBS 0.0312f
C2163 bp11 VSUBS 0.286f
C2164 t1 VSUBS 0.0932f
C2165 vref VSUBS 0.156f
C2166 bn12 VSUBS 0.157f
C2167 cp7 bp9 0.349f
C2168 cn8 bp12 0.0435f
C2169 xc4_outpb cn1 0.349f
C2170 xs0p_x bn3 0.052f
C2171 cn7 VSUBS 0.0745f
C2172 cn6 vrefl 0.106f
C2173 bp8 VSUBS 0.145f
C2174 bp2 top_n 0.227f
C2175 bp7 xs1n_n10 0.0792f
C2176 cp0 VSUBS 0.122f
C2177 vrefl VSUBS 0.019f
C2178 cn4 bn8 0.21f
C2179 xc5_din op 0.108f
C2180 cn5 VSUBS 0.0624f
C2181 xc5_lt VSUBS 0.287f
C2182 rstb VSUBS 0.226f
C2183 bn10 VSUBS 0.125f
C2184 bn5 VSUBS 0.0506f
C2185 xc4_outnb cn0 0.218f
C2186 xs1p_x VSUBS 0.127f
C2187 xs1p_n10 VSUBS 0.0661f
C2188 xs1p_x bp0 0.11f
C2189 cp8 VSUBS 0.147f
C2190 xs0p_n10 VSUBS 0.0567f
C2191 vbp cn4 0.0836f
C2192 vrefl VSUBS 0.0383f
C2193 t1b xc5_din 0.536f
C2194 bn0 VSUBS 0.111f
C2195 cn6 VSUBS 0.573f
C2196 cn12 bp1 0.155f
C2197 xc5_xs1_tail t1 0.0765f
C2198 cp11 VSUBS 0.0361f
C2199 bp5 xs1n_n10 0.0777f
C2200 vbn bp5 0.0888f
C2201 clk VSUBS 0.232f
C2202 bn10 VSUBS 0.317f
C2203 cn11 VSUBS 0.126f
C2204 cn6 VSUBS 0.263f
C2205 bp0 xs0p_n10 0.0223f
C2206 xc4_outnb VSUBS 0.452f
C2207 xs1n_n10 clkb 0.217f
C2208 xc4_outpb bn7 0.103f
C2209 xc5_xs1_tail bp7 0.22f
C2210 xs1p_n10 VSUBS 0.0717f
C2211 vbn VSUBS 0.0524f
C2212 t0b VSUBS 0.238f
C2213 cp4 lsb_p 0.16f
C2214 bn10 VSUBS 0.105f
C2215 xc5_outpb xc4_outnb 0.0847f
C2216 bp8 bn0 0.241f
C2217 xs1n_cbn VSUBS 0.136f
C2218 xc5_xs1_tail0 bp10 0.291f
C2219 cn5 VSUBS 0.171f
C2220 bn3 VSUBS 0.285f
C2221 nr VSUBS 0.0524f
C2222 cn12 VSUBS 0.347f
C2223 in1n VSUBS 0.599f
C2224 on VSUBS 0.27f
C2225 lsb_p cn4 0.172f
C2226 xc5_din VSUBS 0.237f
C2227 bn4 VSUBS 0.215f
C2228 xs0p_n10 VSUBS 0.221f
C2229 cn0 VSUBS 0.12f
C2230 t0b VSUBS 0.104f
C2231 on VSUBS 0.0839f
C2232 bp7 VSUBS 0.0448f
C2233 bn9 bp5 0.041f
C2234 xs1p_g VSUBS 0.0655f
C2235 bn12 VSUBS 0.163f
C2236 bp5 top_n 0.049f
C2237 xc4_xs1_tail VSUBS 0.213f
C2238 on VSUBS 0.0645f
C2239 cp0 VSUBS 0.0366f
C2240 cn2 VSUBS 0.118f
C2241 top_p cn6 0.0412f
C2242 clkn VSUBS 0.222f
C2243 xc5_xs1_tail VSUBS 0.341f
C2244 xc4_xs1_tail0 cp11 0.139f
C2245 xs1p_cbp VSUBS 0.0996f
C2246 lsb_n VSUBS 0.139f
C2247 bn5 xs0n_n10 0.121f
C2248 xc5_lt VSUBS 0.246f
C2249 cp11 VSUBS 0.0534f
C2250 xs0n_cbp VSUBS 0.254f
C2251 lsb_p VSUBS 0.202f
C2252 bn1 VSUBS 0.198f
C2253 cn4 VSUBS 0.095f
C2254 xs0p_x VSUBS 0.272f
C2255 nr VSUBS 0.172f
C2256 cp7 VSUBS 0.143f
C2257 bp11 top_p 0.0385f
C2258 cp12 VSUBS 0.315f
C2259 vdd VSUBS 0.165f
C2260 vbn VSUBS 1.09f
C2261 bn0 clkn 0.149f
C2262 cp10 VSUBS 0.127f
C2263 cp5 VSUBS 0.12f
C2264 cn0 VSUBS 0.233f
C2265 cn6 VSUBS 0.35f
C2266 cp7 bp12 0.16f
C2267 cp7 VSUBS 0.354f
C2268 xc4_din xc5_din 0.0365f
C2269 in0p in0n 0.127f
C2270 rstb_n cp9 0.0704f
C2271 bp0 in1n 0.217f
C2272 t1 bp10 0.0992f
C2273 cp1 VSUBS 0.337f
C2274 in1n VSUBS 0.18f
C2275 cn6 VSUBS 0.217f
C2276 xc5_outpb VSUBS 0.0489f
C2277 cn4 VSUBS 0.0758f
C2278 xc5_xs1_tail0 VSUBS 0.501f
C2279 clk cn8 0.147f
C2280 onp in0p 0.586f
C2281 on bp10 0.13f
C2282 xc4_lt VSUBS 0.0643f
C2283 bp1 vref 0.114f
C2284 t1b VSUBS 0.357f
C2285 cn8 VSUBS 0.503f
C2286 xs1p_n10 VSUBS 0.115f
C2287 rstb VSUBS 0.756f
C2288 bn1 VSUBS 0.134f
C2289 t1 VSUBS 0.173f
C2290 cn2 bn8 0.0796f
C2291 bp6 VSUBS 0.191f
C2292 bp0 VSUBS 0.0754f
C2293 xs0n_cbp xc4_lt 0.276f
C2294 xc4_din in0n 0.128f
C2295 in1p VSUBS 0.0456f
C2296 xs0p_cbp clknb 0.132f
C2297 xc4_xs1_tail0 VSUBS 0.0715f
C2298 bn0 vbn 0.1f
C2299 cn5 VSUBS 0.227f
C2300 t1b top_p 0.037f
C2301 clk VSUBS 0.47f
C2302 bp9 VSUBS 0.151f
C2303 bn7 bn12 0.124f
C2304 cn3 VSUBS 0.131f
C2305 xs1n_cbp VSUBS 0.082f
C2306 bn5 VSUBS 0.453f
C2307 bn12 bp5 0.185f
C2308 xs1p_g VSUBS 0.0455f
C2309 in1p VSUBS 0.52f
C2310 bn11 top_n 0.789f
C2311 op VSUBS 0.0803f
C2312 xs0p_cbp cp12 0.106f
C2313 xc4_lt VSUBS 0.314f
C2314 xs0p_cbp VSUBS 0.276f
C2315 top_n VSUBS 0.0611f
C2316 cp3 VSUBS 0.0904f
C2317 cn7 VSUBS 0.466f
C2318 trk0 VSUBS 0.12f
C2319 onp bp6 0.103f
C2320 cp8 xc4_xs1_tail0 0.252f
C2321 cn10 cn6 0.101f
C2322 xs0n_cbp VSUBS 0.11f
C2323 top_p xc5_outnb 0.0983f
C2324 bn5 VSUBS 0.163f
C2325 xc5_dip VSUBS 0.609f
C2326 cn0 onn 0.521f
C2327 xs0p_x VSUBS 0.301f
C2328 xc5_din VSUBS 0.257f
C2329 cp1 VSUBS 0.0682f
C2330 xs1p_n10 cp2 0.195f
C2331 bp6 clknb 0.641f
C2332 t1 VSUBS 0.0435f
C2333 cn12 VSUBS 0.996f
C2334 xs1n_n10 xs1n_n10 0.199f
C2335 cn12 bp5 0.14f
C2336 cn8 VSUBS 0.186f
C2337 cn2 VSUBS 0.426f
C2338 bp5 VSUBS 0.184f
C2339 xs1n_x cp5 0.139f
C2340 xc4_outpb VSUBS 0.339f
C2341 top_p clknb 0.288f
C2342 bp3 VSUBS 0.247f
C2343 xs0p_g cp1 0.153f
C2344 bp7 clknb 0.0719f
C2345 xs1n_cbp VSUBS 0.266f
C2346 xc4_din VSUBS 0.127f
C2347 cn11 cn6 0.0615f
C2348 bp8 VSUBS 0.434f
C2349 xc5_xs1_tail VSUBS 0.525f
C2350 xc4_outpb xc5_outnb 0.201f
C2351 onp cn3 0.0866f
C2352 t1b xs1p_n10 0.318f
C2353 cp7 VSUBS 0.0942f
C2354 cn9 VSUBS 0.25f
C2355 xs0p_g vbp 0.174f
C2356 cp0 VSUBS 0.127f
C2357 top_p VSUBS 0.155f
C2358 bn6 cp10 0.556f
C2359 bp10 VSUBS 0.67f
C2360 cn0 VSUBS 0.0897f
C2361 clk VSUBS 0.17f
C2362 bn0 VSUBS 0.0557f
C2363 bp1 VSUBS 1f
C2364 xs0n_g xc4_din 0.248f
C2365 xs1n_cbn xs0p_cbp 0.115f
C2366 clkb xc4_outpb 0.082f
C2367 cn6 cp5 0.298f
C2368 rstb VSUBS 0.124f
C2369 in0n VSUBS 0.0311f
C2370 bp11 cn3 0.15f
C2371 cn12 cn8 0.18f
C2372 xs1n_cbn t0b 0.21f
C2373 onp VSUBS 0.0472f
C2374 trk1 VSUBS 0.0807f
C2375 bp8 xs0n_g 0.166f
C2376 bn2 VSUBS 0.153f
C2377 xc4_din VSUBS 0.156f
C2378 bn7 VSUBS 0.111f
C2379 bn11 xs0p_cbn 0.2f
C2380 cn2 VSUBS 0.847f
C2381 xs1n_cbn xs0n_x 0.626f
C2382 cn1 VSUBS 0.257f
C2383 lsb_p rstb_n 0.101f
C2384 trk0 cn0 0.257f
C2385 bp12 VSUBS 0.128f
C2386 cn7 in1p 0.368f
C2387 bp2 VSUBS 0.0523f
C2388 vdd VSUBS 0.115f
C2389 onp bn4 0.251f
C2390 cp4 VSUBS 0.356f
C2391 vbp VSUBS 0.0321f
C2392 clknb cn8 0.35f
C2393 bp5 VSUBS 0.102f
C2394 bp2 VSUBS 0.884f
C2395 clkn VSUBS 0.276f
C2396 op VSUBS 0.124f
C2397 bn1 VSUBS 0.273f
C2398 cp4 VSUBS 0.0772f
C2399 nr VSUBS 0.173f
C2400 t0 VSUBS 0.196f
C2401 onp VSUBS 0.14f
C2402 cp5 cp7 0.191f
C2403 xs0p_cbp onp 0.226f
C2404 vbp xs0n_cbp 0.131f
C2405 xs0p_n10 xc5_outpb 0.105f
C2406 bp6 VSUBS 0.0379f
C2407 clknb VSUBS 0.0872f
C2408 xc5_dip in0p 0.23f
C2409 bp6 cn8 0.0733f
C2410 xs1n_g bp0 0.2f
C2411 cp5 cn3 0.117f
C2412 xs0n_g VSUBS 0.13f
C2413 bn10 xs1p_cbp 0.064f
C2414 bn0 VSUBS 0.169f
C2415 xs1p_cbp VSUBS 0.167f
C2416 xs1p_n10 VSUBS 0.111f
C2417 cn7 cn3 0.337f
C2418 xs1n_cbn xs1n_n10 0.536f
C2419 xs1p_n10 xc4_outnb 0.168f
C2420 bp11 xc5_dip 0.111f
C2421 cn10 bp10 0.0635f
C2422 bp12 bp9 0.616f
C2423 xs0n_cbn VSUBS 0.0847f
C2424 cp3 t0b 0.158f
C2425 trk0 cp0 0.243f
C2426 cp3 VSUBS 0.296f
C2427 cn3 VSUBS 0.176f
C2428 bn9 cp8 0.559f
C2429 bp7 VSUBS 0.204f
C2430 t0 bp8 0.079f
C2431 bp9 on 0.371f
C2432 bp3 VSUBS 0.259f
C2433 vref VSUBS 0.0889f
C2434 cp5 clkn 0.286f
C2435 bn11 VSUBS 0.0888f
C2436 xc4_outpb cp9 0.186f
C2437 trk1 VSUBS 0.309f
C2438 in1p VSUBS 0.171f
C2439 trk0 t1b 0.0493f
C2440 xs1n_g VSUBS 0.197f
C2441 in0p lsb_p 0.0335f
C2442 xs0n_cbn VSUBS 0.215f
C2443 clkn trk1 0.471f
C2444 bp3 VSUBS 0.152f
C2445 bp0 top_n 0.0624f
C2446 xs1n_x xc4_outpb 0.107f
C2447 cp10 clkb 0.298f
C2448 gnd xs0p_n10 0.306f
C2449 cp7 xs0p_cbp 0.223f
C2450 cn2 bn12 0.102f
C2451 top_n VSUBS 0.0656f
C2452 gnd VSUBS 0.148f
C2453 bn2 cp6 0.0572f
C2454 bp7 VSUBS 0.0407f
C2455 cn3 t0b 0.153f
C2456 cn1 VSUBS 0.144f
C2457 cn3 bn5 0.153f
C2458 bn1 bn3 0.115f
C2459 bp12 VSUBS 0.491f
C2460 bn5 VSUBS 0.0676f
C2461 trk1 cn4 0.215f
C2462 cn7 VSUBS 0.142f
C2463 cp10 in0p 0.458f
C2464 bp10 VSUBS 0.202f
C2465 xs0n_cbn VSUBS 0.193f
C2466 bp2 bp8 0.118f
C2467 bn2 VSUBS 0.0671f
C2468 cn9 VSUBS 0.0587f
C2469 bp2 VSUBS 0.368f
C2470 op VSUBS 0.0384f
C2471 xs0p_cbn cp11 0.0401f
C2472 clkb bn5 0.0648f
C2473 on VSUBS 0.187f
C2474 xs1p_x VSUBS 0.0758f
C2475 t1 cn3 0.0461f
C2476 cn9 bn4 0.258f
C2477 xs0p_x xc4_xs1_tail 0.036f
C2478 xc4_lt VSUBS 0.484f
C2479 xc5_din VSUBS 0.0113f
C2480 on cp3 0.37f
C2481 cn8 VSUBS 0.0316f
C2482 trk0 cn8 0.226f
C2483 xs0p_cbn vbn 0.183f
C2484 in0p VSUBS 0.344f
C2485 cn7 cp8 0.026f
C2486 lsb_n VSUBS 0.145f
C2487 t0 VSUBS 0.161f
C2488 bp11 VSUBS 0.0703f
C2489 xc4_outpb VSUBS 0.978f
C2490 bp8 lsb_n 0.0802f
C2491 xs1p_cbp VSUBS 0.106f
C2492 cp11 cp11 0.109f
C2493 cp12 VSUBS 0.173f
C2494 xs1p_g cp12 0.243f
C2495 bp1 cp12 0.197f
C2496 bp8 VSUBS 0.91f
C2497 cn3 VSUBS 0.329f
C2498 bp6 VSUBS 0.069f
C2499 xs1n_x VSUBS 0.593f
C2500 xc5_din cn4 0.128f
C2501 t1b cn9 0.382f
C2502 bp12 xs1n_cbn 0.227f
C2503 xc5_outpb xs0n_g 0.185f
C2504 bn12 xc4_lt 0.0251f
C2505 cp0 VSUBS 0.131f
C2506 bn2 VSUBS 0.139f
C2507 bp12 VSUBS 0.0618f
C2508 bn6 bn0 0.25f
C2509 xs0p_g xs0n_cbp 0.16f
C2510 bn10 cn6 0.239f
C2511 bn5 VSUBS 0.11f
C2512 xs0n_cbp VSUBS 0.049f
C2513 xs1n_n10 xc5_din 0.0756f
C2514 xs1p_g bn6 0.0767f
C2515 bn5 cp12 0.0573f
C2516 bp1 VSUBS 0.101f
C2517 xs0n_g VSUBS 0.186f
C2518 cn9 VSUBS 0.527f
C2519 xs1p_cbn VSUBS 0.185f
C2520 bn7 VSUBS 0.102f
C2521 cp8 VSUBS 0.0827f
C2522 top_n xc5_lt 0.118f
C2523 bn5 VSUBS 0.379f
C2524 bp5 onn 0.199f
C2525 gnd xc5_xs1_tail0 0.0254f
C2526 bp3 VSUBS 0.111f
C2527 xs0p_cbn VSUBS 0.0756f
C2528 bn6 VSUBS 0.165f
C2529 vref bn12 0.143f
C2530 trk0 xs0p_cbn 0.363f
C2531 xs1p_n10 VSUBS 0.0361f
C2532 vdd vrefl 0.0235f
C2533 xs1p_n10 VSUBS 0.147f
C2534 vrefl VSUBS 0.109f
C2535 gnd bp5 0.25f
C2536 cp8 t1b 0.0453f
C2537 xs0n_cbn VSUBS 0.654f
C2538 bn8 VSUBS 0.121f
C2539 trk0 VSUBS 0.127f
C2540 t1b t0 0.0517f
C2541 bn7 VSUBS 0.153f
C2542 xc4_din onp 0.292f
C2543 vbp VSUBS 0.137f
C2544 bp1 VSUBS 0.057f
C2545 cn11 VSUBS 0.494f
C2546 onn bp9 0.277f
C2547 xs1p_cbp bp7 0.574f
C2548 t0b VSUBS 0.501f
C2549 t0 bn1 0.169f
C2550 cp2 VSUBS 1.66f
C2551 bn7 onn 0.222f
C2552 bn7 VSUBS 0.0256f
C2553 bp9 VSUBS 0.166f
C2554 in0p VSUBS 0.353f
C2555 bp8 VSUBS 0.122f
C2556 xc5_outnb lsb_n 0.0579f
C2557 cn0 VSUBS 0.155f
C2558 xs0p_g cn10 0.0576f
C2559 bn3 VSUBS 0.188f
C2560 bn3 xs0p_x 0.0922f
C2561 t0b cp2 0.528f
C2562 xs1p_cbn t1b 0.293f
C2563 bn0 VSUBS 0.153f
C2564 rstb_n cn5 0.165f
C2565 xc4_din VSUBS 0.107f
C2566 bn9 bn5 0.101f
C2567 xs1n_cbn clkn 0.0762f
C2568 cn12 VSUBS 0.198f
C2569 in0n VSUBS 0.248f
C2570 xs0p_g VSUBS 0.289f
C2571 xs0p_n10 in0p 0.0672f
C2572 cn1 bp6 0.158f
C2573 xs0p_cbp VSUBS 0.121f
C2574 xc5_lt VSUBS 0.127f
C2575 vdd VSUBS 0.207f
C2576 xs1p_cbn VSUBS 0.0612f
C2577 bp12 VSUBS 0.0405f
C2578 bp3 VSUBS 0.093f
C2579 bn6 VSUBS 0.0661f
C2580 xs0p_n10 VSUBS 0.187f
C2581 cn5 VSUBS 0.118f
C2582 bn5 VSUBS 0.0892f
C2583 cp0 xs0p_g 0.238f
C2584 xs0n_g VSUBS 0.421f
C2585 xs1n_cbn VSUBS 0.166f
C2586 cp5 xc5_lt 0.0676f
C2587 xc5_outnb xc5_outnb 0.268f
C2588 top_n cp11 0.236f
C2589 bp9 VSUBS 0.314f
C2590 bn10 VSUBS 0.53f
C2591 bn4 VSUBS 0.304f
C2592 cn3 t1b 0.087f
C2593 cn9 onp 0.0313f
C2594 trk0 VSUBS 0.106f
C2595 cp2 VSUBS 0.27f
C2596 bn11 VSUBS 0.165f
C2597 rstb_n VSUBS 0.0814f
C2598 in1n t0b 0.125f
C2599 bp1 VSUBS 0.766f
C2600 top_n vbp 0.127f
C2601 cp7 VSUBS 0.0551f
C2602 bn5 VSUBS 0.0351f
C2603 cn9 VSUBS 0.0423f
C2604 xs1p_x VSUBS 0.0262f
C2605 bn2 in1p 0.266f
C2606 xs0p_cbp VSUBS 0.0545f
C2607 top_p onn 0.0488f
C2608 t0b VSUBS 0.156f
C2609 bn4 cn12 0.192f
C2610 vbp VSUBS 0.444f
C2611 xc4_din VSUBS 0.0958f
C2612 rstb_n VSUBS 0.0536f
C2613 xs0n_n10 VSUBS 0.295f
C2614 xc5_lt VSUBS 0.194f
C2615 lsb_p VSUBS 0.123f
C2616 cp0 VSUBS 0.108f
C2617 t0 VSUBS 0.204f
C2618 xs0n_n10 VSUBS 0.0772f
C2619 t1 VSUBS 0.265f
C2620 in1p VSUBS 0.048f
C2621 cp11 xs1p_cbn 0.033f
C2622 xs0n_x VSUBS 0.288f
C2623 cp0 cp5 0.232f
C2624 clkn VSUBS 0.197f
C2625 op xs1n_cbn 0.242f
C2626 xs0n_g VSUBS 0.0317f
C2627 xs0p_cbn cp8 0.0466f
C2628 rstb_n bn0 0.0339f
C2629 bp1 VSUBS 0.1f
C2630 bp12 VSUBS 0.134f
C2631 cp9 xc4_dip 0.126f
C2632 bn11 VSUBS 0.16f
C2633 vdd in1p 0.255f
C2634 nr VSUBS 0.117f
C2635 bn3 xc5_outpb 0.0777f
C2636 cn0 xc4_xs1_tail 0.136f
C2637 cn12 VSUBS 0.297f
C2638 t0 VSUBS 0.152f
C2639 in0n xs0n_g 0.0255f
C2640 cn1 VSUBS 0.0608f
C2641 op bp8 0.058f
C2642 xs0n_cbn VSUBS 0.216f
C2643 lsb_p VSUBS 0.101f
C2644 xs0n_cbn VSUBS 0.554f
C2645 cp9 VSUBS 0.185f
C2646 onn VSUBS 0.0993f
C2647 bn9 VSUBS 0.128f
C2648 xs1p_g bn2 0.203f
C2649 top_p VSUBS 1.05f
C2650 onp cn7 0.273f
C2651 trk1 VSUBS 0.17f
C2652 vrefl VSUBS 0.343f
C2653 xs0n_cbp xs1n_cbn 0.108f
C2654 bn10 cp2 0.206f
C2655 cp11 VSUBS 0.409f
C2656 cn8 VSUBS 0.0779f
C2657 lsb_n VSUBS 0.253f
C2658 bn6 VSUBS 0.0845f
C2659 bp11 VSUBS 0.16f
C2660 xs0p_n10 VSUBS 0.197f
C2661 xs1n_g bp5 0.0242f
C2662 in1p VSUBS 0.0805f
C2663 xc5_outpb VSUBS 0.236f
C2664 bp1 VSUBS 0.0583f
C2665 bp7 t1b 0.257f
C2666 bp6 VSUBS 0.299f
C2667 bp11 xs0n_x 0.228f
C2668 rstb_n VSUBS 0.108f
C2669 xs1n_g VSUBS 0.0961f
C2670 xc4_outnb vrefl 0.329f
C2671 xs1p_n10 VSUBS 0.209f
C2672 cp2 cn0 0.179f
C2673 vrefl VSUBS 0.229f
C2674 xc4_din VSUBS 0.0651f
C2675 t0 bn2 0.68f
C2676 bn11 VSUBS 0.133f
C2677 in0p cn7 0.128f
C2678 bn11 xc4_outnb 0.113f
C2679 bp5 xs0p_cbn 0.104f
C2680 xs0p_n10 vrefl 0.19f
C2681 cp11 VSUBS 0.129f
C2682 vbn VSUBS 0.198f
C2683 bn7 VSUBS 0.0539f
C2684 on op 0.033f
C2685 bn5 cp4 0.0467f
C2686 bp10 VSUBS 0.0723f
C2687 xs0n_n10 VSUBS 0.0414f
C2688 xc5_dip VSUBS 0.147f
C2689 lsb_p VSUBS 0.087f
C2690 cn11 VSUBS 0.112f
C2691 in1n bn10 0.067f
C2692 xc5_outnb VSUBS 0.294f
C2693 cn5 VSUBS 0.247f
C2694 cn5 xs1n_cbp 0.0954f
C2695 xs0p_g VSUBS 0.28f
C2696 clkn VSUBS 1.08f
C2697 xc5_xs1_tail VSUBS 0.0521f
C2698 trk0 VSUBS 0.0917f
C2699 onn VSUBS 0.349f
C2700 cn12 VSUBS 0.396f
C2701 t0 VSUBS 0.105f
C2702 bn12 VSUBS 0.0696f
C2703 cn6 VSUBS 0.118f
C2704 xc5_dip VSUBS 0.177f
C2705 xc5_lt VSUBS 0.624f
C2706 xc4_outnb bn1 0.0604f
C2707 xs0n_x xs1n_g 0.0802f
C2708 bn0 cp4 0.0916f
C2709 lsb_p vdd 0.164f
C2710 cp3 vrefl 0.0565f
C2711 bp4 VSUBS 0.326f
C2712 bp6 VSUBS 0.166f
C2713 xs0p_cbp xc4_outpb 0.26f
C2714 xc4_dip VSUBS 0.14f
C2715 cp1 cn2 0.276f
C2716 clkn cn0 0.139f
C2717 xc5_lt VSUBS 0.147f
C2718 clk bn9 0.438f
C2719 xc4_lt VSUBS 0.141f
C2720 top_n VSUBS 0.588f
C2721 cn5 VSUBS 0.258f
C2722 xs0n_n10 VSUBS 0.0788f
C2723 cn0 xs1n_n10 0.036f
C2724 bp5 VSUBS 0.377f
C2725 lsb_p VSUBS 0.0932f
C2726 bn10 bp1 0.141f
C2727 bn3 VSUBS 0.286f
C2728 xc4_lt in0n 0.26f
C2729 xs1n_cbp trk1 0.104f
C2730 xc5_outpb cp10 0.257f
C2731 t1 VSUBS 0.052f
C2732 clkb cn3 0.727f
C2733 xc5_din VSUBS 0.0729f
C2734 cp12 VSUBS 0.0847f
C2735 xs1p_n10 VSUBS 0.317f
C2736 cp6 onn 0.27f
C2737 t1 VSUBS 0.127f
C2738 cn2 VSUBS 0.0763f
C2739 cn9 VSUBS 0.053f
C2740 bn5 bn5 0.224f
C2741 xs1n_n10 VSUBS 0.166f
C2742 xc5_xs1_tail bn10 0.105f
C2743 xs1p_n10 xs1p_g 0.0669f
C2744 vbn cp1 0.0757f
C2745 cp9 VSUBS 0.155f
C2746 xs1p_n10 xs1p_n10 0.215f
C2747 bn10 VSUBS 0.108f
C2748 in1p bn2 0.71f
C2749 xc5_outnb xc4_din 0.168f
C2750 t1b VSUBS 0.0409f
C2751 t0 vrefl 0.0617f
C2752 xc5_lt bp7 0.13f
C2753 cp0 VSUBS 0.121f
C2754 cn4 bn4 0.041f
C2755 cp5 VSUBS 0.205f
C2756 cn2 VSUBS 0.0698f
C2757 bp11 in1n 0.127f
C2758 xc5_din VSUBS 0.0544f
C2759 cn8 VSUBS 0.482f
C2760 xs0p_cbp VSUBS 0.231f
C2761 bp6 cn6 0.658f
C2762 nr VSUBS 0.141f
C2763 cn1 VSUBS 0.111f
C2764 bp6 VSUBS 0.113f
C2765 cn7 VSUBS 0.0847f
C2766 xc4_xs1_tail VSUBS 0.454f
C2767 on VSUBS 0.0929f
C2768 rstb VSUBS 0.286f
C2769 cp7 cp0 0.0703f
C2770 vref VSUBS 0.141f
C2771 t0 VSUBS 0.569f
C2772 cp3 VSUBS 0.138f
C2773 xc5_xs1_tail0 VSUBS 0.155f
C2774 cp11 VSUBS 0.167f
C2775 cn0 clk 0.209f
C2776 lsb_n bn5 0.104f
C2777 bn2 VSUBS 0.0613f
C2778 trk1 VSUBS 0.384f
C2779 xc4_outpb VSUBS 0.835f
C2780 clkn VSUBS 0.141f
C2781 cn5 VSUBS 0.0822f
C2782 xs1p_g cp12 0.198f
C2783 vdd VSUBS 0.291f
C2784 cn12 bn12 0.667f
C2785 xc5_din VSUBS 0.0706f
C2786 t0b VSUBS 0.0915f
C2787 xs0n_x xs1n_x 0.0828f
C2788 cp6 vref 0.0546f
C2789 top_n VSUBS 0.182f
C2790 xs0p_n10 xc4_outnb 0.307f
C2791 trk0 VSUBS 0.0869f
C2792 xs1p_n10 VSUBS 0.0847f
C2793 xs0p_cbp VSUBS 0.196f
C2794 xc4_din bp6 0.138f
C2795 xc4_dip xs1p_cbp 0.0739f
C2796 xs0p_g VSUBS 0.245f
C2797 t0 VSUBS 0.0869f
C2798 cn4 VSUBS 0.24f
C2799 clkb VSUBS 0.214f
C2800 cp8 VSUBS 0.0682f
C2801 cp9 VSUBS 0.856f
C2802 xc4_dip in0n 0.102f
C2803 xs1n_g bn0 0.104f
C2804 rstb trk0 0.431f
C2805 t1 VSUBS 0.103f
C2806 cn12 VSUBS 0.0735f
C2807 xs0n_cbp bn1 0.17f
C2808 xs0n_g bp5 0.172f
C2809 clkb xs0p_cbp 0.439f
C2810 xs1n_cbp bp8 0.0599f
C2811 bn3 bn0 0.039f
C2812 trk1 t0b 0.455f
C2813 nr VSUBS 0.762f
C2814 cp7 cn7 0.508f
C2815 rstb VSUBS 0.122f
C2816 xc4_xs1_tail0 VSUBS 0.277f
C2817 t0b xs1n_x 0.117f
C2818 xs1p_cbn VSUBS 0.136f
C2819 vbp bn0 0.211f
C2820 xc5_xs1_tail t1 0.22f
C2821 xs0p_g bn2 0.0887f
C2822 vbp VSUBS 0.0877f
C2823 bn9 VSUBS 0.777f
C2824 trk1 VSUBS 0.0673f
C2825 cn1 cn7 0.0719f
C2826 xs1p_x VSUBS 0.111f
C2827 t0b VSUBS 0.323f
C2828 bn4 cp2 0.134f
C2829 xc4_din VSUBS 0.0787f
C2830 bn3 VSUBS 0.298f
C2831 bn6 bp7 0.127f
C2832 top_p VSUBS 0.687f
C2833 bn2 rstb_n 0.22f
C2834 cn4 cp7 0.147f
C2835 xs1n_cbp xs1p_g 0.14f
C2836 clkb VSUBS 0.645f
C2837 trk0 VSUBS 0.167f
C2838 cp2 t0b 0.0323f
C2839 bn8 VSUBS 0.26f
C2840 bn0 in1p 0.124f
C2841 cn2 xc5_xs1_tail0 0.509f
C2842 bp0 VSUBS 0.176f
C2843 xs1n_x VSUBS 0.26f
C2844 vbp VSUBS 0.419f
C2845 bn2 VSUBS 0.156f
C2846 bp0 VSUBS 0.0981f
C2847 bp9 xc5_outpb 0.218f
C2848 xs0n_cbp xc5_xs1_tail0 0.134f
C2849 cp0 VSUBS 0.176f
C2850 vdd bp3 0.0895f
C2851 xc5_outnb VSUBS 0.337f
C2852 xc5_xs1_tail0 xs0n_x 0.154f
C2853 on in0p 0.0808f
C2854 xs0n_cbn VSUBS 0.123f
C2855 xc5_din cp5 0.0526f
C2856 xc4_xs1_tail VSUBS 0.291f
C2857 cp1 VSUBS 0.237f
C2858 xs0n_g bn11 0.0372f
C2859 cn11 VSUBS 0.0291f
C2860 xc4_din VSUBS 0.211f
C2861 xc5_din VSUBS 0.0944f
C2862 cp2 VSUBS 0.205f
C2863 t1b cp8 0.101f
C2864 cn9 bp0 0.226f
C2865 bp3 cn1 0.245f
C2866 xc5_din VSUBS 0.117f
C2867 in0n VSUBS 0.249f
C2868 xs1n_cbp VSUBS 0.119f
C2869 top_p bp3 0.175f
C2870 bn0 xs1p_n10 0.199f
C2871 xs0p_g VSUBS 0.134f
C2872 cp7 VSUBS 0.0858f
C2873 xc4_outnb xc5_dip 0.217f
C2874 xc4_outnb VSUBS 0.111f
C2875 top_p VSUBS 0.0854f
C2876 cp2 VSUBS 0.144f
C2877 xs1p_cbn VSUBS 0.332f
C2878 xc5_dip bp1 0.0561f
C2879 clk VSUBS 0.253f
C2880 lsb_n bp3 0.284f
C2881 vbn VSUBS 0.329f
C2882 vref xs0p_n10 0.056f
C2883 onn VSUBS 0.0944f
C2884 xs1p_g VSUBS 0.18f
C2885 bp11 VSUBS 0.0466f
C2886 cp9 cp6 0.169f
C2887 xc5_xs1_tail cp1 0.475f
C2888 cn5 VSUBS 0.193f
C2889 t0b VSUBS 0.212f
C2890 xs0p_x VSUBS 0.0515f
C2891 xs1p_n10 xs0p_cbn 0.135f
C2892 onp xc5_lt 0.14f
C2893 bp3 cp8 0.0674f
C2894 t1 VSUBS 0.149f
C2895 cn12 xs1p_n10 0.433f
C2896 xc4_outnb xc5_din 0.152f
C2897 in1p clkb 0.121f
C2898 on bn0 0.0486f
C2899 xc4_outnb bp0 0.0805f
C2900 cn6 VSUBS 0.164f
C2901 xc4_outnb VSUBS 0.0977f
C2902 cn1 VSUBS 0.183f
C2903 xs0n_cbn VSUBS 0.26f
C2904 trk1 VSUBS 0.211f
C2905 cn10 VSUBS 0.236f
C2906 xs0p_cbp clk 0.197f
C2907 trk0 VSUBS 0.0548f
C2908 bn3 xc5_outpb 0.229f
C2909 xs0n_n10 xs1n_g 0.203f
C2910 xs1n_g cn7 0.138f
C2911 xc5_outpb xs0p_cbp 0.19f
C2912 xc4_xs1_tail0 cp0 0.182f
C2913 bn0 xs0p_n10 0.0543f
C2914 xs0n_cbn VSUBS 0.333f
C2915 in1p bn8 0.186f
C2916 bn2 xs1n_cbn 0.32f
C2917 onn VSUBS 0.0289f
C2918 cn1 xs1p_x 0.108f
C2919 cn9 VSUBS 0.199f
C2920 in0p xs1p_g 0.0512f
C2921 lsb_n cn12 0.0972f
C2922 vbn t1b 0.0239f
C2923 bn10 VSUBS 0.22f
C2924 xc4_outpb VSUBS 0.0481f
C2925 cn11 VSUBS 0.472f
C2926 xc5_outpb VSUBS 0.0512f
C2927 cp12 VSUBS 0.165f
C2928 xc4_xs1_tail top_n 0.0543f
C2929 cp8 xs1p_g 0.279f
C2930 cp11 xc4_lt 0.0602f
C2931 xs0p_x VSUBS 0.106f
C2932 rstb clkb 0.212f
C2933 bn6 cn12 0.0812f
C2934 cn0 VSUBS 0.331f
C2935 xc4_outnb cn2 0.115f
C2936 bn2 cp3 0.134f
C2937 xc5_xs1_tail VSUBS 0.123f
C2938 cp11 VSUBS 0.0907f
C2939 bp5 VSUBS 0.141f
C2940 vrefl cn6 0.281f
C2941 bn2 VSUBS 0.162f
C2942 bp12 top_n 0.32f
C2943 bn5 top_p 0.297f
C2944 lsb_n VSUBS 0.0456f
C2945 xs1p_n10 VSUBS 0.122f
C2946 bn4 VSUBS 0.197f
C2947 cn0 cp8 0.333f
C2948 bp3 VSUBS 0.191f
C2949 cn7 VSUBS 0.0659f
C2950 cp10 VSUBS 0.206f
C2951 cp6 VSUBS 0.0901f
C2952 clknb on 0.228f
C2953 cp6 VSUBS 0.0303f
C2954 in1n bn2 0.442f
C2955 cp8 VSUBS 0.0655f
C2956 rstb vbn 0.124f
C2957 cn12 VSUBS 0.221f
C2958 bn1 VSUBS 0.375f
C2959 xc5_xs1_tail0 bp6 0.2f
C2960 top_n VSUBS 0.526f
C2961 xc4_xs1_tail VSUBS 0.114f
C2962 bn2 VSUBS 0.0836f
C2963 bn3 VSUBS 0.0502f
C2964 on VSUBS 0.0371f
C2965 bp0 xs0p_g 0.0639f
C2966 cn0 VSUBS 0.0969f
C2967 bp1 VSUBS 0.0509f
C2968 cp5 VSUBS 0.0681f
C2969 xs0n_n10 VSUBS 0.0786f
C2970 bn5 cp0 0.0927f
C2971 bn9 VSUBS 0.0683f
C2972 cp5 VSUBS 0.0768f
C2973 cp4 xc5_din 0.0815f
C2974 t1 VSUBS 0.0583f
C2975 in0n xs1p_cbp 0.0348f
C2976 cp1 bp3 0.141f
C2977 cn6 VSUBS 0.292f
C2978 cn1 VSUBS 0.0921f
C2979 bn3 VSUBS 0.255f
C2980 lsb_p top_p 0.0487f
C2981 t0b VSUBS 0.0505f
C2982 bp2 VSUBS 0.0976f
C2983 xc4_din VSUBS 0.0864f
C2984 bp2 cn11 0.0529f
C2985 cn2 bp11 0.325f
C2986 cn6 VSUBS 0.0269f
C2987 rstb VSUBS 0.105f
C2988 op vdd 0.182f
C2989 onn VSUBS 0.128f
C2990 xc5_outnb VSUBS 0.07f
C2991 xc4_xs1_tail VSUBS 0.486f
C2992 bn8 VSUBS 0.0506f
C2993 vrefl VSUBS 0.18f
C2994 bp7 cp10 0.0292f
C2995 trk0 xc5_xs1_tail 0.168f
C2996 vbp xs0n_cbp 0.197f
C2997 vbp bp5 0.321f
C2998 cp10 VSUBS 0.0766f
C2999 bn10 VSUBS 0.239f
C3000 bn5 VSUBS 0.166f
C3001 xs0p_cbn VSUBS 0.316f
C3002 xs1p_cbn VSUBS 0.775f
C3003 cp6 VSUBS 0.0508f
C3004 bp9 VSUBS 0.0496f
C3005 t1b VSUBS 0.0874f
C3006 cn1 VSUBS 0.145f
C3007 nr VSUBS 0.0754f
C3008 bp8 t1b 0.163f
C3009 onp VSUBS 0.141f
C3010 xc4_dip VSUBS 0.0922f
C3011 xc5_outpb VSUBS 0.177f
C3012 lsb_p in0p 0.055f
C3013 lsb_p VSUBS 0.417f
C3014 bp10 VSUBS 0.0548f
C3015 in0n VSUBS 0.229f
C3016 trk1 VSUBS 0.113f
C3017 xs1n_g VSUBS 0.264f
C3018 cn7 bn2 0.147f
C3019 cn3 VSUBS 0.54f
C3020 cp1 bn0 0.318f
C3021 cp8 VSUBS 0.519f
C3022 vdd bn4 0.2f
C3023 xc5_din xs0p_n10 0.0834f
C3024 xs0n_g bp5 0.0963f
C3025 vbp t0b 0.171f
C3026 cn11 VSUBS 0.149f
C3027 cp9 cn0 0.0602f
C3028 clkb VSUBS 0.108f
C3029 clknb bn2 0.243f
C3030 cn4 VSUBS 0.25f
C3031 cn5 VSUBS 0.143f
C3032 bn8 VSUBS 0.0483f
C3033 top_n xs1p_n10 0.0998f
C3034 vrefl nr 0.204f
C3035 cp6 VSUBS 0.197f
C3036 cp8 bn8 0.178f
C3037 bp11 VSUBS 0.0648f
C3038 bp0 rstb_n 0.103f
C3039 bp3 bp8 0.122f
C3040 op VSUBS 0.392f
C3041 cn3 cn9 0.354f
C3042 xs1p_cbp cn4 0.427f
C3043 bp7 vrefl 0.15f
C3044 xs0p_cbp VSUBS 0.0588f
C3045 vref VSUBS 0.0665f
C3046 bp8 xs1n_x 0.109f
C3047 bn0 xs1n_x 0.138f
C3048 xs0n_n10 VSUBS 0.0524f
C3049 onp xs1n_g 0.16f
C3050 vdd VSUBS 0.05f
C3051 xc4_xs1_tail vref 0.0555f
C3052 cn12 bn8 0.0246f
C3053 cn5 xs1n_cbn 0.276f
C3054 in1p in0n 0.0787f
C3055 bp2 VSUBS 0.0651f
C3056 rstb_n xs0n_x 0.252f
C3057 xs0p_n10 onn 0.129f
C3058 in1p on 0.0836f
C3059 rstb onn 0.228f
C3060 onn VSUBS 0.0555f
C3061 cp9 xs0n_g 0.645f
C3062 cn5 xc4_din 0.156f
C3063 nr VSUBS 0.0135f
C3064 cp4 VSUBS 0.738f
C3065 xs0n_cbn top_n 0.0787f
C3066 onp bn10 0.591f
C3067 xs1n_x VSUBS 0.132f
C3068 cn3 op 0.113f
C3069 bp11 clkb 0.0799f
C3070 cp5 VSUBS 0.149f
C3071 nr VSUBS 0.0738f
C3072 xc5_dip VSUBS 0.162f
C3073 onn VSUBS 0.0503f
C3074 xc5_xs1_tail0 VSUBS 0.201f
C3075 bn5 VSUBS 0.128f
C3076 on VSUBS 0.053f
C3077 xs1n_cbn cn6 0.15f
C3078 top_p VSUBS 0.334f
C3079 in0p VSUBS 0.365f
C3080 xc5_dip vbp 0.102f
C3081 xs0p_cbp VSUBS 0.313f
C3082 gnd VSUBS 0.238f
C3083 bp7 VSUBS 0.0363f
C3084 bp9 cp4 0.0843f
C3085 in0p clkn 0.134f
C3086 bp4 VSUBS 0.128f
C3087 bp9 VSUBS 0.138f
C3088 bn9 xc4_outnb 0.245f
C3089 bn4 bp7 0.177f
C3090 bp7 cp9 0.143f
C3091 xc5_din VSUBS 0.181f
C3092 bn6 vbn 0.113f
C3093 t0 VSUBS 0.16f
C3094 bp12 cp9 0.396f
C3095 xc5_dip bn11 0.273f
C3096 bp9 bn3 0.112f
C3097 bn2 VSUBS 0.215f
C3098 vbn bn0 0.183f
C3099 bn11 xs1n_g 1.18f
C3100 xs0p_g bp9 0.379f
C3101 bp12 VSUBS 0.535f
C3102 bp4 VSUBS 0.0315f
C3103 op cp6 0.246f
C3104 trk0 xs1p_x 0.104f
C3105 bp12 VSUBS 0.0863f
C3106 xs0p_cbp xc4_dip 0.0773f
C3107 bp4 VSUBS 0.113f
C3108 cp1 VSUBS 0.131f
C3109 xs1n_x rstb_n 0.231f
C3110 onp VSUBS 0.0455f
C3111 bp10 lsb_p 0.0576f
C3112 bp9 in0p 0.0529f
C3113 bp12 xc5_din 0.0779f
C3114 cp6 bn1 0.0549f
C3115 cn5 VSUBS 0.131f
C3116 xc4_xs1_tail xs0p_cbp 0.668f
C3117 xs1n_cbn VSUBS 0.408f
C3118 xc5_outpb VSUBS 0.381f
C3119 bn11 VSUBS 0.142f
C3120 trk1 VSUBS 0.474f
C3121 cn10 cn12 0.142f
C3122 cp8 cp0 0.165f
C3123 xs0p_n10 VSUBS 0.143f
C3124 vref VSUBS 0.625f
C3125 bn3 cp7 0.126f
C3126 vdd vdd 0.073f
C3127 clkn VSUBS 0.0464f
C3128 bn1 VSUBS 0.227f
C3129 nr VSUBS 0.188f
C3130 bn7 VSUBS 0.127f
C3131 xs1n_x VSUBS 0.111f
C3132 bp8 VSUBS 0.378f
C3133 xc5_outnb clkn 0.368f
C3134 cn0 VSUBS 0.462f
C3135 xs1p_cbn VSUBS 0.11f
C3136 cn7 VSUBS 0.117f
C3137 bn7 VSUBS 0.0473f
C3138 in0n cn12 0.213f
C3139 clkn xs1p_g 0.0546f
C3140 xs1n_n10 cp2 0.162f
C3141 cp9 VSUBS 0.116f
C3142 xc5_xs1_tail VSUBS 0.198f
C3143 bp1 vdd 0.327f
C3144 bn11 VSUBS 0.0571f
C3145 xs0n_cbp VSUBS 0.314f
C3146 bn5 clknb 0.133f
C3147 cp1 bp9 0.199f
C3148 clkn t0 0.139f
C3149 cp3 xs0n_cbn 0.0265f
C3150 bp11 VSUBS 0.269f
C3151 cp6 vref 0.472f
C3152 xs0n_x VSUBS 0.0549f
C3153 trk0 VSUBS 0.118f
C3154 top_p VSUBS 0.155f
C3155 cn11 VSUBS 0.201f
C3156 cp8 VSUBS 0.135f
C3157 vbn xs0p_x 0.081f
C3158 xc4_outnb VSUBS 0.306f
C3159 cn1 cn10 0.183f
C3160 cp9 VSUBS 0.398f
C3161 xs0p_cbp t0 0.0731f
C3162 bp5 VSUBS 0.171f
C3163 cp6 VSUBS 0.0533f
C3164 onn bn11 0.124f
C3165 xc5_outnb VSUBS 0.254f
C3166 bn2 VSUBS 0.368f
C3167 bp11 xc5_din 0.138f
C3168 bn12 VSUBS 0.16f
C3169 bp7 VSUBS 0.503f
C3170 bp6 VSUBS 0.331f
C3171 xc5_outnb nr 0.239f
C3172 xs1p_cbn bp9 0.121f
C3173 xs1n_cbp cp10 0.69f
C3174 cn4 VSUBS 0.372f
C3175 cn7 VSUBS 0.285f
C3176 cn6 VSUBS 0.194f
C3177 xs1n_g VSUBS 0.446f
C3178 cp8 VSUBS 0.0889f
C3179 trk0 VSUBS 0.17f
C3180 xs0n_g VSUBS 0.491f
C3181 xc4_lt VSUBS 0.147f
C3182 xs1n_cbp VSUBS 0.0702f
C3183 cn6 cn2 0.248f
C3184 bp6 VSUBS 0.135f
C3185 xs1p_cbn VSUBS 1.07f
C3186 vrefl VSUBS 0.0721f
C3187 bn1 cp9 0.185f
C3188 bn0 xc5_xs1_tail0 0.13f
C3189 in0p VSUBS 0.241f
C3190 lsb_n VSUBS 0.117f
C3191 bp0 xs0p_g 0.102f
C3192 bn6 VSUBS 0.0539f
C3193 bn9 VSUBS 0.241f
C3194 bp6 bn2 0.111f
C3195 xc4_outnb VSUBS 0.161f
C3196 bp12 VSUBS 0.383f
C3197 vref VSUBS 0.417f
C3198 xs1p_cbn bn5 0.197f
C3199 bn4 VSUBS 0.0669f
C3200 clkn VSUBS 0.19f
C3201 clknb cp12 0.462f
C3202 bp7 VSUBS 0.16f
C3203 xc4_outnb VSUBS 0.138f
C3204 xc5_xs1_tail0 VSUBS 0.116f
C3205 vdd VSUBS 0.0969f
C3206 bn11 VSUBS 0.0632f
C3207 vbp VSUBS 0.144f
C3208 cp3 VSUBS 0.131f
C3209 xs0p_cbp VSUBS 0.0777f
C3210 cp12 VSUBS 0.214f
C3211 bn9 VSUBS 0.132f
C3212 bn4 xc4_xs1_tail 0.173f
C3213 xs0p_x VSUBS 0.0728f
C3214 xc5_lt xc4_xs1_tail0 0.123f
C3215 cn4 vref 0.208f
C3216 cn3 bp6 0.0666f
C3217 rstb_n bp1 0.314f
C3218 xc4_outnb VSUBS 0.192f
C3219 cn9 VSUBS 0.062f
C3220 in0p lsb_p 0.184f
C3221 xs0n_cbn xc4_dip 0.0916f
C3222 xs1n_cbn VSUBS 0.0352f
C3223 cp12 VSUBS 0.0546f
C3224 bn2 VSUBS 0.0765f
C3225 xc5_xs1_tail VSUBS 0.337f
C3226 cn0 bp11 0.243f
C3227 xs1p_cbp VSUBS 0.223f
C3228 bp3 xs0p_n10 0.0571f
C3229 cp5 VSUBS 0.278f
C3230 vdd xc4_dip 0.0757f
C3231 xs1n_g t1 0.245f
C3232 cp10 VSUBS 0.392f
C3233 xs1n_cbn cn12 0.411f
C3234 in0p VSUBS 0.0954f
C3235 xs0n_cbp clk 0.438f
C3236 xc4_din VSUBS 0.0643f
C3237 rstb_n bn1 0.0269f
C3238 xc4_outnb vdd 0.0389f
C3239 clk VSUBS 0.319f
C3240 gnd bn2 0.25f
C3241 cn2 VSUBS 0.0365f
C3242 bp1 VSUBS 0.138f
C3243 trk0 VSUBS 0.269f
C3244 xs0n_g VSUBS 0.159f
C3245 xs0p_n10 VSUBS 0.064f
C3246 onp VSUBS 0.749f
C3247 top_p xc4_outnb 0.219f
C3248 xc4_outpb VSUBS 0.464f
C3249 cn7 VSUBS 0.281f
C3250 bn5 bp2 0.044f
C3251 vdd VSUBS 0.433f
C3252 bn5 VSUBS 0.109f
C3253 xs1p_g VSUBS 0.15f
C3254 cp12 VSUBS 0.109f
C3255 bp11 bn11 0.535f
C3256 bn10 xc5_din 0.23f
C3257 cn6 bn12 0.126f
C3258 xc5_outnb xs0p_n10 0.524f
C3259 xs1p_x t1 0.288f
C3260 xs0p_cbp op 0.0773f
C3261 onp xs0n_cbn 0.399f
C3262 cp12 xs1n_g 0.0496f
C3263 onp VSUBS 0.094f
C3264 bn3 t1b 0.317f
C3265 bp5 bp8 0.175f
C3266 bp3 VSUBS 0.15f
C3267 cn10 VSUBS 0.455f
C3268 bn7 VSUBS 0.121f
C3269 cp3 bp0 0.104f
C3270 cn10 VSUBS 0.0597f
C3271 cp9 cn8 0.0932f
C3272 xc4_xs1_tail xc4_dip 0.0714f
C3273 bp3 VSUBS 0.44f
C3274 top_p VSUBS 0.145f
C3275 xc4_din VSUBS 0.0721f
C3276 bp11 VSUBS 0.117f
C3277 bn2 VSUBS 0.105f
C3278 cn3 VSUBS 0.243f
C3279 vbn VSUBS 0.0515f
C3280 xs0p_n10 in0p 0.206f
C3281 cn10 in1n 0.506f
C3282 xc5_lt VSUBS 0.348f
C3283 cn12 VSUBS 0.0901f
C3284 xs1p_cbn trk1 0.124f
C3285 bp8 VSUBS 0.406f
C3286 cp0 cn1 0.132f
C3287 vref xs1p_cbn 0.00932f
C3288 xs0n_cbn bn8 0.167f
C3289 t0b VSUBS 0.162f
C3290 cp10 in0p 0.253f
C3291 bn10 VSUBS 0.223f
C3292 cp1 VSUBS 0.268f
C3293 xc5_xs1_tail VSUBS 0.0938f
C3294 cp3 VSUBS 0.105f
C3295 xc4_xs1_tail0 vbn 0.146f
C3296 cp2 xs1n_cbp 0.195f
C3297 bn4 cp1 0.121f
C3298 top_n VSUBS 0.434f
C3299 rstb_n VSUBS 0.0573f
C3300 vrefl VSUBS 0.0996f
C3301 bn3 bn11 0.0584f
C3302 xs1n_n10 bp6 0.377f
C3303 in1n xs1n_n10 0.333f
C3304 xc5_lt VSUBS 0.135f
C3305 top_p cn5 0.123f
C3306 cp10 VSUBS 0.13f
C3307 cn5 cn3 0.66f
C3308 t1 bp2 0.255f
C3309 xs1p_n10 VSUBS 0.107f
C3310 in0n VSUBS 0.675f
C3311 cn9 bn2 0.133f
C3312 top_p VSUBS 0.0932f
C3313 bp2 VSUBS 0.0225f
C3314 cn5 VSUBS 0.118f
C3315 xs1p_cbn VSUBS 0.149f
C3316 onp VSUBS 0.121f
C3317 bn2 cp12 0.103f
C3318 bp5 VSUBS 0.384f
C3319 xc4_outnb VSUBS 0.133f
C3320 cn11 VSUBS 0.202f
C3321 xc4_outpb xs0n_x 0.142f
C3322 cn10 t1 0.19f
C3323 vbp cp5 0.0567f
C3324 bp2 xs1p_n10 0.45f
C3325 cp11 VSUBS 0.363f
C3326 bp12 VSUBS 0.247f
C3327 bn9 VSUBS 0.393f
C3328 bp11 VSUBS 0.472f
C3329 cn11 VSUBS 0.114f
C3330 bn1 bn6 0.0269f
C3331 bp0 VSUBS 0.345f
C3332 xs1n_x VSUBS 0.0774f
C3333 cn0 VSUBS 0.332f
C3334 cp6 VSUBS 0.381f
C3335 in1n VSUBS 0.0934f
C3336 bn4 nr 0.121f
C3337 cp11 VSUBS 0.301f
C3338 bp12 VSUBS 0.19f
C3339 xs1n_x VSUBS 0.279f
C3340 xc5_lt cp1 0.237f
C3341 xs0p_g cn10 0.114f
C3342 xs1n_g VSUBS 0.228f
C3343 bn11 xc4_outpb 0.0318f
C3344 xs1p_g VSUBS 0.155f
C3345 xs1p_g VSUBS 0.176f
C3346 xc4_xs1_tail0 cp1 0.137f
C3347 clk xs0p_n10 0.0501f
C3348 cn4 cp9 0.127f
C3349 cn9 cn8 0.0476f
C3350 nr cp7 0.187f
C3351 xs0p_cbn VSUBS 0.548f
C3352 vbn bn4 0.133f
C3353 cn10 VSUBS 0.0846f
C3354 cn5 VSUBS 0.101f
C3355 xs0p_g VSUBS 0.216f
C3356 xs1n_cbp VSUBS 0.0668f
C3357 cp7 op 0.188f
C3358 xs0n_cbp VSUBS 0.0651f
C3359 bn6 VSUBS 0.42f
C3360 trk0 VSUBS 0.188f
C3361 bn7 cp11 0.301f
C3362 nr VSUBS 0.495f
C3363 xs0n_cbp cp7 0.211f
C3364 xs0n_g VSUBS 0.0884f
C3365 cp10 VSUBS 0.199f
C3366 xc5_outnb rstb_n 0.111f
C3367 rstb VSUBS 0.0937f
C3368 bn7 VSUBS 0.0777f
C3369 top_n bp3 0.381f
C3370 clknb xc4_xs1_tail 0.165f
C3371 bp1 VSUBS 0.32f
C3372 xc4_xs1_tail VSUBS 0.0868f
C3373 t0 xs1p_cbn 0.15f
C3374 bn11 xc4_din 0.174f
C3375 cp7 vdd 0.104f
C3376 xs0n_x VSUBS 0.0912f
C3377 xs0n_g VSUBS 0.0506f
C3378 xs1p_n10 lsb_n 0.134f
C3379 clk xs1p_x 0.131f
C3380 xc4_xs1_tail0 xs0n_cbp 0.182f
C3381 onn VSUBS 1.59f
C3382 bn3 VSUBS 0.0763f
C3383 xs1p_n10 xc5_outnb 0.332f
C3384 xs0p_n10 VSUBS 0.0713f
C3385 xs0p_g VSUBS 0.159f
C3386 xc4_xs1_tail0 cn12 0.0942f
C3387 xc5_dip VSUBS 0.183f
C3388 xc5_lt VSUBS 0.0759f
C3389 xc4_dip VSUBS 0.114f
C3390 xs0p_n10 xs1n_x 0.115f
C3391 bp6 VSUBS 0.0701f
C3392 cp11 bn3 0.163f
C3393 xc5_din VSUBS 0.0602f
C3394 xs0p_n10 vrefl 0.0516f
C3395 lsb_p cp12 0.0743f
C3396 xs1p_n10 VSUBS 0.643f
C3397 top_p VSUBS 0.13f
C3398 xs0n_x VSUBS 0.0892f
C3399 xc4_dip top_n 0.2f
C3400 cn11 VSUBS 0.0459f
C3401 bp12 VSUBS 0.0302f
C3402 cp9 cn5 0.0233f
C3403 bp4 xc4_dip 0.177f
C3404 lsb_p xc4_lt 0.247f
C3405 cp0 bp4 0.471f
C3406 xs1p_cbn VSUBS 0.702f
C3407 xs0p_x VSUBS 0.354f
C3408 cn0 xs0n_n10 0.271f
C3409 bn11 lsb_n 0.149f
C3410 clkb VSUBS 0.104f
C3411 bn5 VSUBS 0.096f
C3412 nr VSUBS 0.121f
C3413 rstb_n cp0 0.0913f
C3414 cp12 VSUBS 0.25f
C3415 in1p VSUBS 0.153f
C3416 cn10 VSUBS 0.0796f
C3417 bn0 VSUBS 0.235f
C3418 xc5_outnb VSUBS 0.289f
C3419 on VSUBS 0.108f
C3420 bn6 VSUBS 0.243f
C3421 xs0n_cbp bn11 0.0337f
C3422 cn12 xc5_dip 0.2f
C3423 lsb_p cp12 0.265f
C3424 op VSUBS 0.0883f
C3425 rstb_n VSUBS 0.138f
C3426 cp0 VSUBS 0.13f
C3427 bp0 xs1n_n10 0.0911f
C3428 cp11 VSUBS 0.143f
C3429 rstb_n VSUBS 0.129f
C3430 bn6 VSUBS 0.262f
C3431 cn10 bp11 0.0507f
C3432 bn2 VSUBS 0.091f
C3433 bn5 VSUBS 0.078f
C3434 cp10 VSUBS 0.458f
C3435 bn8 VSUBS 0.0653f
C3436 bp3 nr 0.135f
C3437 vref VSUBS 0.18f
C3438 cn11 xs1n_x 0.162f
C3439 in0n xc5_lt 0.157f
C3440 gnd VSUBS 0.438f
C3441 xc4_lt VSUBS 0.0633f
C3442 vdd VSUBS 0.141f
C3443 xs0p_n10 VSUBS 0.449f
C3444 in1n xs0p_g 0.294f
C3445 xs0p_n10 on 0.237f
C3446 onn xc4_outnb 0.134f
C3447 bp8 VSUBS 0.196f
C3448 cn10 VSUBS 0.65f
C3449 vbn VSUBS 0.234f
C3450 xs1p_x VSUBS 0.142f
C3451 clknb VSUBS 0.142f
C3452 xc5_dip in1n 0.165f
C3453 xc4_outnb cn9 0.122f
C3454 gnd cn1 0.106f
C3455 t0b VSUBS 0.121f
C3456 xs1n_g VSUBS 0.0697f
C3457 xc5_outpb VSUBS 0.0234f
C3458 cp2 top_n 0.104f
C3459 cp4 VSUBS 0.114f
C3460 xs0p_cbp VSUBS 0.226f
C3461 onn VSUBS 0.392f
C3462 top_n VSUBS 0.158f
C3463 bp0 VSUBS 0.36f
C3464 lsb_p VSUBS 0.248f
C3465 bp11 bn10 0.291f
C3466 cn11 VSUBS 0.134f
C3467 xc5_din VSUBS 0.329f
C3468 bn1 VSUBS 0.499f
C3469 bn1 rstb 0.0858f
C3470 xc5_din VSUBS 0.0966f
C3471 in0n VSUBS 0.321f
C3472 cn4 VSUBS 0.121f
C3473 cp8 VSUBS 0.218f
C3474 cp12 VSUBS 0.373f
C3475 bn1 VSUBS 0.121f
C3476 cn5 bp11 0.218f
C3477 bp8 VSUBS 0.0321f
C3478 cp4 rstb 0.197f
C3479 bn9 bn7 0.159f
C3480 cn3 VSUBS 0.252f
C3481 xc4_lt VSUBS 0.158f
C3482 lsb_p xs0n_x 0.053f
C3483 trk1 VSUBS 0.263f
C3484 bp6 clknb 0.203f
C3485 xs0n_cbn clkb 0.0365f
C3486 on VSUBS 0.096f
C3487 cp7 VSUBS 0.364f
C3488 cn9 cn9 0.0804f
C3489 cp9 bn1 0.0824f
C3490 cn11 xs0p_n10 0.133f
C3491 nr xs1n_g 0.0896f
C3492 in1n VSUBS 0.108f
C3493 xs0n_cbp VSUBS 0.112f
C3494 lsb_n cn1 0.143f
C3495 cn9 VSUBS 0.259f
C3496 bn5 rstb 0.438f
C3497 xs0p_g xc4_lt 0.501f
C3498 xs1n_n10 VSUBS 0.474f
C3499 bn5 bn2 0.0415f
C3500 cn3 bn2 0.155f
C3501 cn7 nr 0.104f
C3502 cn10 bp10 0.131f
C3503 xc4_outpb VSUBS 0.396f
C3504 on lsb_n 0.124f
C3505 xs0p_x in1n 0.103f
C3506 xs1n_g cn4 0.311f
C3507 cp6 VSUBS 0.24f
C3508 bn3 VSUBS 0.111f
C3509 t1 xs1n_cbn 0.069f
C3510 bn12 VSUBS 0.241f
C3511 xs1p_n10 on 0.102f
C3512 xc4_xs1_tail0 VSUBS 0.264f
C3513 vref VSUBS 0.0794f
C3514 bn11 xs1n_n10 0.0902f
C3515 clk VSUBS 0.21f
C3516 xs0p_cbp cn12 0.255f
C3517 xs1p_x xc4_outnb 0.292f
C3518 top_p VSUBS 0.364f
C3519 cn7 VSUBS 0.0547f
C3520 vref VSUBS 0.352f
C3521 top_n xs0n_g 0.129f
C3522 xc4_xs1_tail0 xc4_outnb 0.0594f
C3523 top_p VSUBS 0.325f
C3524 xs1n_g xc5_outpb 0.0746f
C3525 cn7 VSUBS 0.167f
C3526 cp0 cn4 0.0226f
C3527 bp8 VSUBS 0.226f
C3528 cp7 clkn 0.0936f
C3529 xc5_outpb VSUBS 0.104f
C3530 bp1 xs0n_g 0.202f
C3531 cn10 VSUBS 0.16f
C3532 gnd VSUBS 0.259f
C3533 xc4_outnb VSUBS 0.142f
C3534 t1b cn7 0.0823f
C3535 cn12 VSUBS 0.212f
C3536 bn4 clk 0.0602f
C3537 vbn VSUBS 0.341f
C3538 cp0 VSUBS 0.0805f
C3539 bn5 VSUBS 0.124f
C3540 xc5_xs1_tail0 xc5_lt 0.0571f
C3541 xc5_dip VSUBS 0.0218f
C3542 cp10 VSUBS 0.299f
C3543 bn6 bp12 0.0913f
C3544 bp9 VSUBS 0.236f
C3545 bn7 VSUBS 0.0623f
C3546 xs1n_cbn VSUBS 0.0468f
C3547 xs1n_n10 VSUBS 0.539f
C3548 cp12 VSUBS 0.587f
C3549 clkb VSUBS 0.257f
C3550 xs1p_g VSUBS 0.143f
C3551 xs1p_g VSUBS 0.346f
C3552 cn10 VSUBS 0.146f
C3553 onp VSUBS 0.233f
C3554 xc4_din clk 0.118f
C3555 xc5_din VSUBS 0.113f
C3556 bn12 VSUBS 0.114f
C3557 bn0 cn6 0.257f
C3558 bp11 VSUBS 0.36f
C3559 top_n VSUBS 0.188f
C3560 cp5 cp0 0.321f
C3561 xs1n_cbn cn1 0.806f
C3562 xs0p_g VSUBS 0.47f
C3563 bn11 VSUBS 0.208f
C3564 cn4 VSUBS 0.0875f
C3565 cp12 VSUBS 0.139f
C3566 bp7 cn9 0.079f
C3567 t0 VSUBS 0.0932f
C3568 bn4 VSUBS 0.596f
C3569 vref VSUBS 0.306f
C3570 xs1n_x VSUBS 0.202f
C3571 cp3 t0 0.243f
C3572 xs0n_g vref 0.131f
C3573 xs1p_cbp VSUBS 0.3f
C3574 lsb_n cp9 0.0659f
C3575 bp10 VSUBS 0.177f
C3576 bp4 VSUBS 0.16f
C3577 bp8 bn10 0.0592f
C3578 xs0p_x cp2 0.087f
C3579 cn2 VSUBS 0.185f
C3580 bn11 xc5_lt 0.226f
C3581 lsb_n xs0n_g 0.169f
C3582 cn8 VSUBS 0.095f
C3583 bn5 VSUBS 0.074f
C3584 clknb VSUBS 0.0472f
C3585 vdd VSUBS 0.204f
C3586 t1b VSUBS 0.177f
C3587 cn0 cn1 0.103f
C3588 bp7 VSUBS 0.166f
C3589 cp8 VSUBS 0.0346f
C3590 clk xc5_xs1_tail0 0.162f
C3591 xc5_dip vbn 0.153f
C3592 bp8 VSUBS 0.363f
C3593 cp11 VSUBS 0.102f
C3594 cp2 VSUBS 0.113f
C3595 bp5 rstb_n 0.137f
C3596 bn11 VSUBS 0.11f
C3597 bp7 xc5_dip 0.0497f
C3598 cp7 top_p 0.279f
C3599 vbp bn4 0.056f
C3600 clkn VSUBS 0.596f
C3601 xs1p_x VSUBS 0.955f
C3602 t0b VSUBS 0.135f
C3603 bn9 VSUBS 0.563f
C3604 xs1p_cbn VSUBS 0.595f
C3605 cp6 VSUBS 0.0549f
C3606 clk VSUBS 0.161f
C3607 lsb_p xs0n_cbn 0.196f
C3608 vdd xc5_lt 0.0675f
C3609 vbp cn12 0.18f
C3610 bn2 VSUBS 0.0728f
C3611 lsb_p VSUBS 0.344f
C3612 cn9 VSUBS 0.622f
C3613 cp11 VSUBS 0.0801f
C3614 in0n xs1p_cbn 0.0583f
C3615 xc4_xs1_tail0 rstb_n 0.628f
C3616 bn7 VSUBS 0.378f
C3617 cn0 VSUBS 0.36f
C3618 t1 VSUBS 0.0728f
C3619 xs1p_x t0 0.203f
C3620 cp1 VSUBS 0.0321f
C3621 xc5_lt VSUBS 0.0993f
C3622 xs0p_cbp VSUBS 0.059f
C3623 bp9 cp11 1.03f
C3624 xs0p_cbn xc5_dip 0.409f
C3625 cn5 xc4_din 0.11f
C3626 xs0n_n10 VSUBS 0.287f
C3627 lsb_p on 0.144f
C3628 cn3 VSUBS 0.127f
C3629 xc5_xs1_tail bp0 0.359f
C3630 xs1p_cbp VSUBS 0.185f
C3631 onn VSUBS 0.216f
C3632 cp9 bn9 0.174f
C3633 clk VSUBS 0.0704f
C3634 vbn VSUBS 0.0653f
C3635 clknb rstb_n 0.158f
C3636 xc5_xs1_tail cn1 0.0976f
C3637 bn3 VSUBS 0.109f
C3638 cn12 VSUBS 0.278f
C3639 cn11 t1 0.0669f
C3640 xc5_outpb lsb_p 0.169f
C3641 vref VSUBS 0.0373f
C3642 xs1n_cbp bn10 0.227f
C3643 rstb onn 0.257f
C3644 bp0 VSUBS 0.0637f
C3645 xs1p_n10 cp8 0.199f
C3646 op VSUBS 0.0531f
C3647 top_p VSUBS 0.165f
C3648 xs0n_cbn VSUBS 0.0413f
C3649 xc5_xs1_tail VSUBS 0.803f
C3650 cn5 VSUBS 0.103f
C3651 cp10 VSUBS 0.133f
C3652 bn0 VSUBS 0.219f
C3653 trk0 xs0p_cbp 0.154f
C3654 vbn VSUBS 0.312f
C3655 cn2 cp1 0.0694f
C3656 cp3 bp5 0.0819f
C3657 vbn in1n 0.0134f
C3658 xs1p_cbp top_p 0.385f
C3659 cn1 xc5_lt 0.151f
C3660 xc5_xs1_tail rstb_n 0.153f
C3661 xs1n_n10 cp12 0.252f
C3662 cp4 VSUBS 0.159f
C3663 xs0n_x bn0 0.295f
C3664 cn11 cn10 0.278f
C3665 in1n cp0 0.197f
C3666 xc5_outpb xc4_xs1_tail0 0.182f
C3667 clknb cp4 0.285f
C3668 xs1p_cbp VSUBS 0.188f
C3669 xs1n_cbp cn7 0.0695f
C3670 xc5_din cp6 0.476f
C3671 cp12 xs1n_g 0.0984f
C3672 bn7 vdd 0.156f
C3673 clk xs0n_cbn 0.624f
C3674 cn8 VSUBS 0.2f
C3675 xc5_lt bn2 0.281f
C3676 top_p VSUBS 0.0437f
C3677 cn10 VSUBS 0.189f
C3678 bn10 xs0p_g 0.245f
C3679 clknb bp4 0.427f
C3680 bp9 VSUBS 0.354f
C3681 xs0p_n10 VSUBS 0.474f
C3682 bn8 VSUBS 0.1f
C3683 cn7 VSUBS 0.044f
C3684 vrefl nr 0.0712f
C3685 clk VSUBS 0.0326f
C3686 xs1p_g cn9 0.221f
C3687 xc4_xs1_tail0 bp0 0.245f
C3688 bp3 VSUBS 0.197f
C3689 lsb_p VSUBS 0.301f
C3690 cn9 VSUBS 0.262f
C3691 cn8 VSUBS 0.151f
C3692 xc5_din VSUBS 0.0193f
C3693 cp2 VSUBS 0.0826f
C3694 bn7 bp9 0.331f
C3695 cn1 VSUBS 0.0837f
C3696 bp4 VSUBS 0.101f
C3697 cp1 VSUBS 0.173f
C3698 trk0 VSUBS 0.0944f
C3699 bp6 cp0 0.0486f
C3700 t1b VSUBS 0.236f
C3701 cp6 t1b 0.28f
C3702 cn11 VSUBS 0.0824f
C3703 xs1n_x VSUBS 0.142f
C3704 cp12 VSUBS 0.101f
C3705 clknb VSUBS 0.537f
C3706 cp11 xs1n_g 0.633f
C3707 cp12 onn 0.122f
C3708 bp9 VSUBS 0.553f
C3709 cn9 VSUBS 1.45f
C3710 bp7 rstb_n 0.0721f
C3711 t0b VSUBS 0.0887f
C3712 vdd VSUBS 0.215f
C3713 vrefl VSUBS 0.234f
C3714 xc4_xs1_tail VSUBS 0.178f
C3715 bp5 xc4_dip 0.14f
C3716 cn11 VSUBS 0.0747f
C3717 lsb_n VSUBS 1.24f
C3718 onn VSUBS 0.428f
C3719 on VSUBS 0.379f
C3720 t0b cn3 0.119f
C3721 bn10 VSUBS 0.392f
C3722 cp7 bp10 0.0536f
C3723 t1 VSUBS 0.147f
C3724 top_p VSUBS 0.451f
C3725 vbp bp3 0.31f
C3726 xc5_outpb VSUBS 2.89f
C3727 cp0 VSUBS 0.134f
C3728 xs0p_cbn VSUBS 0.114f
C3729 t1 VSUBS 0.721f
C3730 vrefl in0n 0.16f
C3731 vref VSUBS 0.0574f
C3732 t1 VSUBS 0.145f
C3733 bp3 xc4_xs1_tail0 0.211f
C3734 bn9 xc4_dip 0.154f
C3735 xc4_din VSUBS 0.423f
C3736 clkb VSUBS 0.212f
C3737 bp3 cp3 0.151f
C3738 xc5_din VSUBS 0.177f
C3739 cn12 in0n 0.0793f
C3740 bp4 VSUBS 0.0986f
C3741 cn1 bp9 0.522f
C3742 xc5_dip VSUBS 0.0718f
C3743 xs1p_x in0n 0.125f
C3744 bn10 VSUBS 0.185f
C3745 t0 bp1 0.0794f
C3746 xs1p_cbn xc4_xs1_tail0 0.097f
C3747 vdd VSUBS 0.0726f
C3748 cn5 VSUBS 0.182f
C3749 in1p bn6 0.63f
C3750 xs1p_cbp VSUBS 0.125f
C3751 bp7 xc5_xs1_tail0 0.0805f
C3752 xs1p_cbp VSUBS 0.0849f
C3753 bp3 VSUBS 0.105f
C3754 xc4_xs1_tail vbp 0.539f
C3755 op VSUBS 0.158f
C3756 bn5 VSUBS 0.0434f
C3757 top_p bp6 0.053f
C3758 cp10 VSUBS 0.0449f
C3759 xs0n_n10 VSUBS 0.21f
C3760 nr VSUBS 0.0651f
C3761 xc5_outnb VSUBS 0.105f
C3762 cn3 rstb_n 0.0685f
C3763 cp10 cn1 0.107f
C3764 clkb VSUBS 0.395f
C3765 xc4_din VSUBS 0.221f
C3766 cn3 VSUBS 0.0694f
C3767 cn3 xs0n_cbn 0.0419f
C3768 bn0 VSUBS 0.155f
C3769 top_n bp1 0.296f
C3770 bp5 bp1 0.209f
C3771 gnd VSUBS 0.194f
C3772 onp xs0p_g 0.234f
C3773 cp1 VSUBS 0.258f
C3774 xs0n_cbn clkb 0.349f
C3775 xc4_outnb VSUBS 0.243f
C3776 bp0 VSUBS 0.16f
C3777 xc4_din VSUBS 0.106f
C3778 xs0n_n10 VSUBS 0.288f
C3779 clknb vbn 0.0994f
C3780 lsb_n VSUBS 0.286f
C3781 bp3 VSUBS 0.15f
C3782 cn7 VSUBS 0.214f
C3783 xs0n_cbp VSUBS 0.0728f
C3784 vbp cp6 0.157f
C3785 xs0n_n10 VSUBS 0.658f
C3786 xc5_lt VSUBS 0.0966f
C3787 xc4_outpb cn3 0.0332f
C3788 xc5_din VSUBS 0.48f
C3789 cp10 VSUBS 1.45f
C3790 xc5_lt xc5_xs1_tail 0.433f
C3791 gnd VSUBS 0.188f
C3792 clkn VSUBS 0.127f
C3793 top_n bp7 0.0885f
C3794 rstb_n VSUBS 0.512f
C3795 xs1n_x cp8 0.857f
C3796 xs0n_cbn VSUBS 0.057f
C3797 xs0p_n10 t1b 0.363f
C3798 t1 VSUBS 0.127f
C3799 bp9 bn8 0.169f
C3800 bn5 bp5 0.131f
C3801 bp8 VSUBS 0.0832f
C3802 xc4_dip cp1 0.111f
C3803 top_p VSUBS 0.101f
C3804 gnd VSUBS 0.108f
C3805 bp11 VSUBS 0.172f
C3806 nr VSUBS 0.0363f
C3807 xc5_xs1_tail0 cp7 0.22f
C3808 clkb VSUBS 0.0521f
C3809 cp7 VSUBS 0.0525f
C3810 cp7 VSUBS 0.56f
C3811 bp3 VSUBS 0.132f
C3812 bp6 VSUBS 0.0794f
C3813 bn5 VSUBS 0.249f
C3814 xs0n_cbp bn9 0.137f
C3815 xc4_lt VSUBS 0.106f
C3816 xc5_xs1_tail0 VSUBS 0.254f
C3817 t1 VSUBS 0.158f
C3818 xs0p_cbp VSUBS 0.0536f
C3819 bn9 bp7 0.0478f
C3820 cp2 VSUBS 0.0791f
C3821 in1n VSUBS 0.58f
C3822 t1b bp6 0.235f
C3823 vbp VSUBS 0.12f
C3824 top_p bp10 0.0681f
C3825 t0b cn3 0.167f
C3826 vbp bp8 0.435f
C3827 bp4 VSUBS 0.131f
C3828 xc5_lt xs0p_cbp 0.312f
C3829 cn2 VSUBS 0.0995f
C3830 cn8 VSUBS 0.451f
C3831 bn8 VSUBS 0.21f
C3832 cn10 VSUBS 0.219f
C3833 in1p VSUBS 0.378f
C3834 xc4_xs1_tail0 VSUBS 0.167f
C3835 xs1p_g VSUBS 0.0783f
C3836 cp8 xc4_outpb 0.231f
C3837 xs1n_cbp VSUBS 0.0815f
C3838 vref VSUBS 0.364f
C3839 on VSUBS 0.22f
C3840 trk0 VSUBS 0.399f
C3841 cp1 VSUBS 0.207f
C3842 bp5 xs1n_n10 0.638f
C3843 xs1p_g xs1p_cbp 0.21f
C3844 op VSUBS 0.344f
C3845 cp2 VSUBS 0.0823f
C3846 bn11 cn11 0.419f
C3847 xc4_outnb VSUBS 0.116f
C3848 nr rstb 0.0913f
C3849 xc4_dip VSUBS 0.251f
C3850 bn6 xs1n_cbn 0.157f
C3851 bn3 bp5 0.403f
C3852 in0n VSUBS 0.171f
C3853 cp1 bp8 0.145f
C3854 xs1p_cbn VSUBS 0.0619f
C3855 bp6 bn7 0.433f
C3856 cp2 clkb 0.027f
C3857 rstb VSUBS 0.701f
C3858 xc5_outpb vbn 0.555f
C3859 lsb_n VSUBS 0.318f
C3860 t0b VSUBS 0.375f
C3861 cn7 VSUBS 0.3f
C3862 xs0n_x VSUBS 0.285f
C3863 cp8 cp11 0.163f
C3864 op VSUBS 0.196f
C3865 bp1 xc4_outnb 0.13f
C3866 in1n VSUBS 0.0791f
C3867 cp8 cp2 0.119f
C3868 cp7 VSUBS 0.426f
C3869 bn0 VSUBS 0.0705f
C3870 xs0n_cbp VSUBS 0.0853f
C3871 onn xc5_outnb 0.118f
C3872 xc5_outpb xs1p_n10 0.171f
C3873 clkb VSUBS 0.0557f
C3874 xs0p_cbn bp3 0.825f
C3875 onn VSUBS 0.131f
C3876 bp8 xs0p_n10 0.108f
C3877 clknb xc5_lt 0.0934f
C3878 bn12 VSUBS 0.114f
C3879 bp2 VSUBS 0.0777f
C3880 cn2 clkb 0.165f
C3881 xs1n_cbp VSUBS 0.257f
C3882 op xs0p_cbp 0.0871f
C3883 trk1 VSUBS 0.0478f
C3884 cp0 VSUBS 0.265f
C3885 on nr 1.21f
C3886 bn9 cp12 0.0252f
C3887 clk VSUBS 1.42f
C3888 xc5_xs1_tail0 VSUBS 0.134f
C3889 top_n t0 0.223f
C3890 cp11 t0 0.147f
C3891 op VSUBS 0.0705f
C3892 bp12 VSUBS 0.0485f
C3893 cp11 VSUBS 0.0562f
C3894 bn0 VSUBS 0.13f
C3895 xs0n_g VSUBS 0.2f
C3896 cn1 xc5_lt 0.181f
C3897 xc4_lt VSUBS 0.299f
C3898 cp1 VSUBS 0.0959f
C3899 cn4 VSUBS 1.78f
C3900 clk VSUBS 0.183f
C3901 cp5 vref 0.303f
C3902 bn0 VSUBS 0.221f
C3903 xs1p_cbn bn6 0.28f
C3904 xc4_dip VSUBS 0.0492f
C3905 bn9 VSUBS 0.291f
C3906 xs0n_cbn cp7 0.0986f
C3907 bp0 VSUBS 0.175f
C3908 cn3 VSUBS 0.118f
C3909 xc4_din VSUBS 0.178f
C3910 xs1p_x VSUBS 0.097f
C3911 lsb_p VSUBS 0.101f
C3912 bp8 xc5_outnb 0.227f
C3913 bp10 VSUBS 0.121f
C3914 cp11 top_n 0.243f
C3915 cn5 xc4_outnb 0.4f
C3916 xc5_dip nr 0.308f
C3917 bn5 VSUBS 0.138f
C3918 on xc5_xs1_tail 0.448f
C3919 xs1n_g vbn 0.0947f
C3920 bn10 VSUBS 0.114f
C3921 t0b VSUBS 0.08f
C3922 gnd VSUBS 0.303f
C3923 cn6 bn8 0.132f
C3924 xs1p_x VSUBS 0.126f
C3925 bn5 VSUBS 0.157f
C3926 vrefl VSUBS 0.0815f
C3927 xc4_outpb xs1n_cbn 0.189f
C3928 xc4_din vrefl 0.19f
C3929 t1 bn1 0.145f
C3930 top_n top_p 0.446f
C3931 cp7 VSUBS 0.309f
C3932 cp3 VSUBS 0.167f
C3933 cp8 VSUBS 0.226f
C3934 xs1p_x VSUBS 0.318f
C3935 cn0 vbn 0.058f
C3936 lsb_n VSUBS 0.214f
C3937 xc4_xs1_tail0 vrefl 0.288f
C3938 xs1n_cbn VSUBS 0.19f
C3939 vbp VSUBS 0.04f
C3940 xc4_lt VSUBS 0.25f
C3941 cp9 VSUBS 0.1f
C3942 xs0p_cbn xc5_xs1_tail0 0.131f
C3943 bn7 xs0p_x 0.315f
C3944 bn2 clkb 0.169f
C3945 xs0n_n10 VSUBS 0.0602f
C3946 clkn clkn 0.0386f
C3947 bn4 xc4_din 0.12f
C3948 cp0 xc5_xs1_tail 0.324f
C3949 cp12 VSUBS 0.0361f
C3950 xc5_lt VSUBS 0.216f
C3951 rstb VSUBS 0.0821f
C3952 on VSUBS 0.22f
C3953 cp4 VSUBS 0.209f
C3954 clkn bn5 0.0562f
C3955 bp8 VSUBS 0.329f
C3956 t0b top_p 0.0631f
C3957 clk xs0p_cbn 0.288f
C3958 bn4 cn7 0.235f
C3959 xs1p_g cp6 0.0481f
C3960 cp3 VSUBS 0.154f
C3961 vbp VSUBS 0.561f
C3962 cp11 vref 0.0289f
C3963 xs1n_g vref 0.456f
C3964 xc4_xs1_tail VSUBS 0.944f
C3965 cn9 VSUBS 0.462f
C3966 bp3 cp2 0.172f
C3967 cn3 xc4_dip 0.167f
C3968 bn6 VSUBS 0.429f
C3969 cp3 VSUBS 0.322f
C3970 xs1p_n10 VSUBS 0.0534f
C3971 xc4_outpb bp11 0.134f
C3972 bn6 VSUBS 0.194f
C3973 bn9 rstb_n 0.209f
C3974 cn9 VSUBS 0.0653f
C3975 cp2 cn8 0.282f
C3976 vdd VSUBS 0.281f
C3977 cp8 bp10 0.283f
C3978 bp2 bp5 0.0593f
C3979 xs1p_n10 xs0p_n10 0.0676f
C3980 cp9 VSUBS 0.174f
C3981 in0p xc5_dip 0.382f
C3982 in1p xc4_xs1_tail0 0.381f
C3983 gnd bp5 0.0613f
C3984 t0b VSUBS 1.01f
C3985 t1 VSUBS 0.174f
C3986 onn VSUBS 0.154f
C3987 xs0p_cbp in0p 0.227f
C3988 bn11 VSUBS 0.0648f
C3989 t0 bn5 0.338f
C3990 xs0n_g VSUBS 0.0497f
C3991 bn12 VSUBS 0.131f
C3992 on cn9 0.279f
C3993 top_p VSUBS 0.545f
C3994 xs0n_cbn vref 0.0507f
C3995 cp2 bp6 0.313f
C3996 cp0 VSUBS 0.211f
C3997 xc4_xs1_tail0 cn9 0.0776f
C3998 xs0p_n10 clk 0.091f
C3999 cp10 bn11 0.203f
