* synthetic parasitics (make_synth_pex.py, seed 7): 2000 C, 50 RC ladders of 10
C0 xckg_d1 VSUBS 0.572f
C1 vbn VSUBS 0.153f
C2 vref xckg_d3 0.279f
C3 xckg_x VSUBS 0.209f
C4 vbn xref_ng 0.427f
C5 ibias VSUBS 0.0457f
C6 vbn vdda 0.119f
C7 xckg_d3 VSUBS 0.0337f
C8 xcbias_xrb_s1 VSUBS 0.0669f
C9 vdd xckg_d0 0.302f
C10 vdda VSUBS 0.133f
C11 xcbias_xrb_s1 VSUBS 0.104f
C12 vbn VSUBS 0.0492f
C13 xcbias_xrb_s1 VSUBS 0.0558f
C14 xckg_d3 xcbias_xrb_s1 0.039f
C15 vdd VSUBS 0.704f
C16 xcbiasn_xrb_s2 VSUBS 0.441f
C17 xref_ng VSUBS 0.264f
C18 xcbias_xrb_s3 vbp 0.306f
C19 clk VSUBS 0.179f
C20 xckg_d2 VSUBS 0.218f
C21 xcbiasn_xrb_s3 xckg_x 0.396f
C22 ibias xref_ng 0.0865f
C23 xcbiasn_xrb_s1 xcbiasn_xrb_s2 0.617f
C24 xref_ng xref_ntl 0.216f
C25 xckg_d3 xcbiasn_xrb_s1 0.222f
C26 vdd VSUBS 0.11f
C27 xckg_d3 xckg_x 0.202f
C28 xcbias_xrb_s1 VSUBS 0.147f
C29 xcbias_xrb_s2 VSUBS 0.374f
C30 xckg_d1 VSUBS 0.117f
C31 xref_ntl VSUBS 0.247f
C32 ibias xckg_d2 0.22f
C33 xckg_d3 VSUBS 0.126f
C34 vbn VSUBS 0.193f
C35 xref_ng VSUBS 0.133f
C36 xckg_x VSUBS 0.796f
C37 xref_ng VSUBS 0.319f
C38 vbn xckg_d0 0.146f
C39 xcbiasn_xrb_s2 VSUBS 0.0527f
C40 xckg_d3 VSUBS 0.136f
C41 vdd VSUBS 0.224f
C42 vref_in VSUBS 0.218f
C43 xcbiasn_xrb_s1 VSUBS 0.702f
C44 xcbiasn_xrb_s2 VSUBS 0.19f
C45 vbn VSUBS 0.0718f
C46 xckg_x VSUBS 0.0368f
C47 vdd vref 0.189f
C48 xckg_d2 VSUBS 0.255f
C49 vref VSUBS 0.0797f
C50 sar_mclk VSUBS 0.213f
C51 xckg_d1 xckg_x 0.16f
C52 xcbiasn_xrb_s1 VSUBS 0.163f
C53 vss xckg_d1 0.276f
C54 xcbiasn_xrb_s1 VSUBS 0.049f
C55 xref_ng VSUBS 0.161f
C56 xcbiasn_xrb_s1 VSUBS 0.412f
C57 xcbiasn_xrb_s2 VSUBS 0.901f
C58 xckg_d0 VSUBS 0.0267f
C59 xckg_nn VSUBS 0.11f
C60 xcbias_xrb_s3 xref_na 0.132f
C61 xckg_d0 vref_in 0.348f
C62 vbn VSUBS 0.529f
C63 vbp VSUBS 0.0893f
C64 xckg_x xckg_d0 0.021f
C65 vdd vdd 0.0818f
C66 clk VSUBS 0.254f
C67 xcbias_xrb_s1 VSUBS 0.0852f
C68 xckg_d1 VSUBS 0.142f
C69 xckg_d3 clk 0.0774f
C70 xckg_d3 xref_ng 0.128f
C71 xckg_x VSUBS 0.0722f
C72 vdda sar_mclk 0.258f
C73 vbp xcbias_xrb_s1 0.23f
C74 xcbias_xrb_s2 VSUBS 0.162f
C75 vbn VSUBS 0.0207f
C76 xcbiasn_xrb_s1 VSUBS 0.711f
C77 xref_ng VSUBS 0.136f
C78 xref_ntl VSUBS 0.337f
C79 vrefl xref_ntl 0.264f
C80 xckg_d1 VSUBS 0.23f
C81 vref_in VSUBS 0.2f
C82 xcbiasn_xrb_s3 VSUBS 0.432f
C83 xcbias_xrb_s2 VSUBS 0.0812f
C84 vbp vrefl 0.0544f
C85 vss vdda 0.132f
C86 xcbias_xrb_s2 VSUBS 0.0564f
C87 mclkb VSUBS 0.0815f
C88 vref_in xcbias_xrb_s3 0.449f
C89 xckg_d2 VSUBS 0.217f
C90 xckg_d1 xref_ng 0.758f
C91 vrefl VSUBS 0.377f
C92 vref_in vdd 0.027f
C93 ibias xcbiasn_xrb_s3 0.0444f
C94 sar_mclk VSUBS 0.058f
C95 clk VSUBS 0.136f
C96 xcbiasn_xrb_s1 xcbias_xrb_s1 0.0392f
C97 xcbias_xrb_s3 vbp 0.571f
C98 xcbias_xrb_s2 vbn 0.0897f
C99 xref_ng vdda 0.199f
C100 xcbias_xrb_s1 mclkb 0.1f
C101 vss xcbias_xrb_s3 0.187f
C102 vbp xcbiasn_xrb_s1 0.17f
C103 xref_ng VSUBS 0.195f
C104 vrefl VSUBS 0.0649f
C105 mclkb VSUBS 0.659f
C106 xref_ng VSUBS 0.348f
C107 vrefl VSUBS 0.159f
C108 vrefl xckg_x 0.362f
C109 xcbiasn_xrb_s3 VSUBS 0.382f
C110 vref_in mclkb 0.0798f
C111 sar_mclk VSUBS 0.195f
C112 vref xcbiasn_xrb_s1 0.0516f
C113 clk xcbiasn_xrb_s3 0.272f
C114 vref VSUBS 0.141f
C115 vdda xcbias_xrb_s2 0.0544f
C116 vdd xcbiasn_xrb_s2 2.45f
C117 mclkb VSUBS 0.12f
C118 ibias vbp 0.274f
C119 sar_mclk VSUBS 0.262f
C120 vdd VSUBS 1.27f
C121 vrefl VSUBS 0.167f
C122 vref_in xref_ntl 0.163f
C123 vss xckg_d0 0.211f
C124 xckg_d0 VSUBS 0.192f
C125 xckg_nn VSUBS 0.214f
C126 clk vref_in 0.253f
C127 xckg_d2 xckg_d2 0.132f
C128 xckg_d3 VSUBS 0.165f
C129 ibias VSUBS 0.247f
C130 vdda mclkb 0.0196f
C131 xcbias_xrb_s3 VSUBS 0.124f
C132 sar_mclk VSUBS 0.0848f
C133 vss xckg_d3 0.158f
C134 xcbias_xrb_s1 xckg_x 0.245f
C135 vbn VSUBS 0.103f
C136 ibias VSUBS 0.063f
C137 vss VSUBS 0.238f
C138 vbn VSUBS 0.179f
C139 xcbias_xrb_s2 vbn 0.208f
C140 xref_na vdda 0.269f
C141 vbp VSUBS 0.194f
C142 xcbias_xrb_s3 ibias 0.058f
C143 xcbiasn_xrb_s3 VSUBS 0.386f
C144 xref_ntl xref_ntl 0.258f
C145 vbp xcbiasn_xrb_s3 0.0312f
C146 xref_ng VSUBS 0.157f
C147 xref_ntl ibias 0.0607f
C148 xckg_x VSUBS 0.202f
C149 clk VSUBS 0.0664f
C150 vbp xckg_d0 0.111f
C151 xcbias_xrb_s3 VSUBS 0.204f
C152 xckg_d1 VSUBS 0.0289f
C153 xckg_d2 VSUBS 0.0435f
C154 xcbiasn_xrb_s2 VSUBS 0.671f
C155 xckg_x VSUBS 0.176f
C156 mclkb VSUBS 0.0816f
C157 xckg_d3 clk 0.141f
C158 xref_na vbp 0.0678f
C159 vbp VSUBS 0.341f
C160 xcbias_xrb_s2 VSUBS 0.118f
C161 vrefl VSUBS 0.607f
C162 vss VSUBS 0.435f
C163 mclkb VSUBS 0.089f
C164 vref_in vrefl 1.08f
C165 xref_ntl VSUBS 0.354f
C166 sar_mclk VSUBS 0.161f
C167 vref clk 0.617f
C168 vref_in xcbiasn_xrb_s2 0.0869f
C169 xref_ntl xcbiasn_xrb_s1 0.172f
C170 xckg_d2 xcbias_xrb_s3 0.0575f
C171 xckg_d3 VSUBS 0.16f
C172 clk vrefl 0.171f
C173 xckg_d1 VSUBS 0.161f
C174 vref_in VSUBS 0.0349f
C175 vref VSUBS 0.0464f
C176 xckg_x xcbias_xrb_s2 0.805f
C177 mclkb VSUBS 0.29f
C178 xckg_x VSUBS 0.206f
C179 vbn VSUBS 0.15f
C180 xckg_d3 VSUBS 0.152f
C181 vdda vbn 0.325f
C182 sar_mclk xcbias_xrb_s2 0.702f
C183 xckg_x VSUBS 0.121f
C184 xckg_d2 VSUBS 0.234f
C185 vdda xcbiasn_xrb_s1 0.0471f
C186 vrefl VSUBS 0.0383f
C187 vbn xcbias_xrb_s3 0.139f
C188 vdd VSUBS 1.05f
C189 mclkb xcbiasn_xrb_s1 0.316f
C190 xcbias_xrb_s2 VSUBS 0.166f
C191 xref_ntl VSUBS 0.164f
C192 xref_ntl VSUBS 0.65f
C193 xckg_d0 VSUBS 0.0752f
C194 mclkb VSUBS 0.349f
C195 vss VSUBS 0.192f
C196 mclkb xckg_nn 0.186f
C197 vdd VSUBS 0.0534f
C198 xref_ntl xcbias_xrb_s2 0.627f
C199 xckg_nn VSUBS 0.185f
C200 vdd vref_in 0.0967f
C201 mclkb VSUBS 0.381f
C202 vbn VSUBS 0.166f
C203 ibias VSUBS 0.272f
C204 xckg_x VSUBS 0.437f
C205 xcbiasn_xrb_s1 VSUBS 0.152f
C206 xckg_d3 VSUBS 0.323f
C207 xcbiasn_xrb_s1 VSUBS 0.086f
C208 xckg_d1 xckg_x 0.244f
C209 xref_ng VSUBS 0.174f
C210 xckg_d3 xcbias_xrb_s3 0.245f
C211 mclkb vrefl 0.0464f
C212 ibias sar_mclk 0.112f
C213 vdd VSUBS 0.459f
C214 xckg_d2 VSUBS 0.163f
C215 vref_in VSUBS 0.125f
C216 xckg_d0 mclkb 0.104f
C217 vdda VSUBS 0.0701f
C218 xref_ntl VSUBS 0.699f
C219 xcbias_xrb_s2 vrefl 0.318f
C220 xcbias_xrb_s2 VSUBS 0.143f
C221 mclkb VSUBS 0.28f
C222 vdd xcbias_xrb_s1 0.46f
C223 xckg_d0 VSUBS 0.0994f
C224 xref_na VSUBS 0.132f
C225 xcbias_xrb_s3 VSUBS 0.173f
C226 xckg_x VSUBS 0.0283f
C227 vref_in VSUBS 0.0684f
C228 xref_ng VSUBS 0.328f
C229 sar_mclk VSUBS 0.0354f
C230 xcbiasn_xrb_s2 clk 0.157f
C231 xcbiasn_xrb_s2 VSUBS 0.427f
C232 xckg_d3 VSUBS 0.171f
C233 clk VSUBS 0.174f
C234 xcbiasn_xrb_s1 VSUBS 0.0439f
C235 xcbias_xrb_s2 VSUBS 0.0962f
C236 xckg_d3 VSUBS 0.0569f
C237 sar_mclk VSUBS 0.102f
C238 clk VSUBS 0.0941f
C239 xckg_d0 VSUBS 0.311f
C240 vdda VSUBS 0.559f
C241 xcbias_xrb_s2 VSUBS 0.265f
C242 vdd VSUBS 0.0452f
C243 xref_ntl VSUBS 0.238f
C244 xcbias_xrb_s3 VSUBS 0.205f
C245 vbp xckg_d0 0.173f
C246 vrefl vdd 0.0632f
C247 xckg_nn xcbiasn_xrb_s1 0.191f
C248 xckg_d1 VSUBS 0.107f
C249 xcbiasn_xrb_s1 VSUBS 0.057f
C250 vdd VSUBS 0.233f
C251 vbn VSUBS 0.131f
C252 vref_in VSUBS 0.17f
C253 xckg_d0 VSUBS 0.256f
C254 xref_ng xcbiasn_xrb_s2 0.0576f
C255 xcbiasn_xrb_s1 VSUBS 0.0223f
C256 xckg_d1 xcbiasn_xrb_s1 0.389f
C257 vdda VSUBS 0.124f
C258 vref_in xcbias_xrb_s3 0.38f
C259 xckg_nn VSUBS 0.0825f
C260 vdd mclkb 0.176f
C261 vrefl VSUBS 0.416f
C262 xref_ng VSUBS 0.0676f
C263 xckg_d0 xcbiasn_xrb_s3 0.247f
C264 xckg_x xcbiasn_xrb_s3 0.488f
C265 clk VSUBS 0.147f
C266 vdd VSUBS 0.105f
C267 clk vdd 0.245f
C268 xcbias_xrb_s2 vdd 0.17f
C269 vrefl VSUBS 0.0978f
C270 xref_na VSUBS 0.287f
C271 xckg_d3 VSUBS 0.112f
C272 vbn VSUBS 0.24f
C273 ibias VSUBS 0.287f
C274 xref_ng VSUBS 0.355f
C275 xckg_d3 xref_na 0.045f
C276 xckg_d0 VSUBS 0.111f
C277 xckg_nn VSUBS 0.616f
C278 xcbias_xrb_s1 xckg_d2 0.136f
C279 xcbiasn_xrb_s3 VSUBS 0.0789f
C280 xcbias_xrb_s2 VSUBS 0.105f
C281 vdda xckg_d1 0.749f
C282 ibias VSUBS 0.406f
C283 xcbias_xrb_s3 xcbiasn_xrb_s1 0.0793f
C284 xcbiasn_xrb_s2 VSUBS 0.167f
C285 clk VSUBS 0.304f
C286 xckg_d2 VSUBS 0.492f
C287 vdda VSUBS 0.131f
C288 xref_ntl VSUBS 0.234f
C289 xcbiasn_xrb_s2 VSUBS 0.165f
C290 mclkb xckg_nn 0.163f
C291 vbn VSUBS 0.066f
C292 clk VSUBS 0.127f
C293 vdd VSUBS 0.676f
C294 xref_ng VSUBS 0.195f
C295 vbn xcbiasn_xrb_s1 0.233f
C296 xref_ng xcbiasn_xrb_s2 0.554f
C297 xcbiasn_xrb_s1 VSUBS 0.827f
C298 xckg_nn xref_ntl 0.134f
C299 xckg_d3 VSUBS 0.0495f
C300 xckg_d3 VSUBS 0.0977f
C301 xcbiasn_xrb_s2 ibias 0.0326f
C302 xcbias_xrb_s3 VSUBS 0.187f
C303 vdda VSUBS 0.105f
C304 vref_in VSUBS 0.146f
C305 xref_ng VSUBS 0.338f
C306 vdd VSUBS 0.206f
C307 vref VSUBS 0.153f
C308 vdd VSUBS 0.145f
C309 xcbiasn_xrb_s2 vref 0.0598f
C310 clk xckg_d0 0.306f
C311 clk VSUBS 0.264f
C312 xckg_d2 xcbiasn_xrb_s3 0.371f
C313 clk vdda 0.363f
C314 xcbiasn_xrb_s2 xckg_d2 0.346f
C315 vref xref_ntl 0.158f
C316 vref_in VSUBS 0.298f
C317 xcbiasn_xrb_s2 VSUBS 0.117f
C318 xckg_nn VSUBS 0.31f
C319 vbn sar_mclk 0.264f
C320 xcbias_xrb_s2 ibias 0.101f
C321 vbn xcbiasn_xrb_s1 0.198f
C322 xcbiasn_xrb_s3 VSUBS 0.608f
C323 mclkb clk 0.147f
C324 vbp xckg_nn 0.172f
C325 xcbiasn_xrb_s2 vref_in 0.191f
C326 xref_ng xref_ng 0.146f
C327 xref_ntl xckg_d2 0.0646f
C328 xref_na VSUBS 0.201f
C329 vbn xref_ng 0.188f
C330 mclkb xcbiasn_xrb_s1 0.0461f
C331 xckg_d3 xckg_d3 0.114f
C332 xckg_d0 VSUBS 0.243f
C333 mclkb xckg_x 0.17f
C334 vrefl VSUBS 0.295f
C335 xcbiasn_xrb_s1 VSUBS 0.126f
C336 xcbiasn_xrb_s3 vbn 0.192f
C337 vrefl VSUBS 0.0669f
C338 vdd xref_na 0.121f
C339 xref_ntl VSUBS 0.152f
C340 vdd VSUBS 0.141f
C341 sar_mclk vdd 0.21f
C342 vbn VSUBS 0.0552f
C343 vss VSUBS 0.105f
C344 xckg_d0 vdd 0.0396f
C345 xref_ng VSUBS 0.472f
C346 vref_in VSUBS 0.151f
C347 vdda vbn 0.297f
C348 xcbiasn_xrb_s3 clk 0.269f
C349 xckg_x xckg_d0 0.146f
C350 xckg_x xckg_x 0.0635f
C351 sar_mclk sar_mclk 0.235f
C352 xref_ntl VSUBS 0.0581f
C353 xcbias_xrb_s3 vbn 0.16f
C354 ibias vdda 0.118f
C355 vrefl xckg_nn 0.0404f
C356 mclkb VSUBS 0.0167f
C357 sar_mclk xcbiasn_xrb_s2 0.0812f
C358 vrefl VSUBS 0.246f
C359 xckg_d0 sar_mclk 0.391f
C360 xcbiasn_xrb_s2 xcbias_xrb_s2 0.0583f
C361 xckg_d1 VSUBS 0.117f
C362 xcbias_xrb_s2 VSUBS 0.328f
C363 xcbiasn_xrb_s2 VSUBS 0.486f
C364 xckg_d2 vref_in 0.161f
C365 xckg_d1 vdda 0.179f
C366 xckg_nn VSUBS 0.155f
C367 vbn VSUBS 0.137f
C368 xcbias_xrb_s3 xcbias_xrb_s3 0.0466f
C369 xcbias_xrb_s3 vdda 0.514f
C370 vdd xckg_d0 0.173f
C371 clk VSUBS 0.195f
C372 xckg_d0 xcbias_xrb_s2 0.412f
C373 vss vdda 0.15f
C374 xref_na VSUBS 0.275f
C375 xckg_d3 VSUBS 0.0319f
C376 xref_ng VSUBS 0.281f
C377 xcbias_xrb_s3 VSUBS 1.08f
C378 sar_mclk VSUBS 0.0341f
C379 xcbias_xrb_s2 xcbiasn_xrb_s3 0.0282f
C380 xref_ng VSUBS 0.57f
C381 vref_in VSUBS 0.101f
C382 vbp VSUBS 0.148f
C383 xcbiasn_xrb_s1 VSUBS 0.0864f
C384 xckg_x xckg_d3 0.0546f
C385 xref_na vdda 1.62f
C386 xckg_nn VSUBS 0.204f
C387 xref_na ibias 0.113f
C388 clk xckg_d0 0.577f
C389 xref_ng VSUBS 0.267f
C390 xcbias_xrb_s2 VSUBS 0.139f
C391 xckg_d3 VSUBS 0.0709f
C392 xref_ntl VSUBS 0.59f
C393 clk xcbias_xrb_s1 0.0491f
C394 xref_ntl VSUBS 0.0901f
C395 xcbias_xrb_s3 vdda 0.0702f
C396 vdda VSUBS 0.0267f
C397 xckg_d2 VSUBS 0.0885f
C398 vdd VSUBS 0.0473f
C399 ibias xckg_x 0.0784f
C400 ibias xckg_d3 0.158f
C401 xckg_d2 VSUBS 0.349f
C402 vss VSUBS 0.111f
C403 xref_ntl VSUBS 0.202f
C404 vdda vbp 0.157f
C405 xckg_d0 VSUBS 0.157f
C406 xcbiasn_xrb_s3 clk 0.414f
C407 xckg_d2 xckg_nn 0.415f
C408 xckg_d3 VSUBS 0.446f
C409 xref_na xcbias_xrb_s1 0.129f
C410 vbp VSUBS 0.303f
C411 clk vbn 0.0566f
C412 vref VSUBS 0.92f
C413 xckg_d1 VSUBS 0.0846f
C414 xcbiasn_xrb_s3 vdd 0.249f
C415 xref_ntl VSUBS 0.124f
C416 xckg_d1 VSUBS 0.095f
C417 mclkb VSUBS 0.0204f
C418 xckg_d2 VSUBS 0.0453f
C419 vdda VSUBS 0.287f
C420 sar_mclk mclkb 0.161f
C421 xcbias_xrb_s2 vref 0.31f
C422 xckg_d2 VSUBS 0.77f
C423 clk xref_ng 0.0702f
C424 xref_ntl VSUBS 0.137f
C425 xcbiasn_xrb_s2 VSUBS 0.0506f
C426 xcbias_xrb_s1 vref_in 0.546f
C427 xcbias_xrb_s2 vdd 0.326f
C428 xckg_nn VSUBS 0.27f
C429 xcbiasn_xrb_s1 VSUBS 0.147f
C430 mclkb VSUBS 0.153f
C431 vdd VSUBS 0.24f
C432 xref_na xcbias_xrb_s3 0.161f
C433 xref_ng clk 0.119f
C434 xckg_d3 sar_mclk 0.414f
C435 xckg_d3 VSUBS 0.194f
C436 xcbias_xrb_s3 VSUBS 0.222f
C437 xcbiasn_xrb_s1 VSUBS 0.203f
C438 vdda clk 0.306f
C439 ibias vbn 0.243f
C440 vrefl xckg_d2 0.0538f
C441 xckg_d1 xcbiasn_xrb_s1 0.0458f
C442 xckg_d3 vdda 0.119f
C443 sar_mclk vref_in 0.0685f
C444 xcbiasn_xrb_s1 xcbias_xrb_s1 0.0795f
C445 xckg_nn VSUBS 0.544f
C446 clk VSUBS 0.182f
C447 sar_mclk VSUBS 0.0495f
C448 xckg_d3 VSUBS 0.315f
C449 sar_mclk xckg_d3 0.0319f
C450 mclkb VSUBS 0.105f
C451 xcbiasn_xrb_s1 xcbiasn_xrb_s2 0.0352f
C452 mclkb VSUBS 0.0374f
C453 xckg_d1 VSUBS 0.179f
C454 xcbias_xrb_s1 VSUBS 0.115f
C455 xref_ntl VSUBS 0.0404f
C456 vbp VSUBS 0.243f
C457 xcbiasn_xrb_s3 xref_ng 0.152f
C458 xcbias_xrb_s2 VSUBS 0.21f
C459 xcbiasn_xrb_s2 VSUBS 0.175f
C460 vbn xcbiasn_xrb_s3 0.0871f
C461 xcbiasn_xrb_s2 VSUBS 0.0682f
C462 xref_ng vbp 0.223f
C463 xckg_d1 VSUBS 0.177f
C464 xcbias_xrb_s1 VSUBS 0.11f
C465 vbn ibias 0.235f
C466 xcbias_xrb_s2 VSUBS 0.046f
C467 xref_ntl VSUBS 0.334f
C468 vref xref_na 0.284f
C469 xckg_x VSUBS 0.0204f
C470 vref ibias 0.17f
C471 clk xcbias_xrb_s2 0.22f
C472 xcbiasn_xrb_s2 VSUBS 0.316f
C473 vdda xcbiasn_xrb_s2 0.0823f
C474 mclkb VSUBS 0.261f
C475 xcbias_xrb_s1 mclkb 0.647f
C476 xckg_d2 VSUBS 0.175f
C477 xref_na xckg_x 0.0975f
C478 xcbiasn_xrb_s1 xcbiasn_xrb_s3 0.346f
C479 xckg_d2 VSUBS 0.148f
C480 xref_na mclkb 0.092f
C481 ibias VSUBS 0.116f
C482 xckg_nn xcbiasn_xrb_s2 0.222f
C483 vbn VSUBS 0.0477f
C484 xcbiasn_xrb_s2 VSUBS 0.171f
C485 vbp xref_ng 0.0347f
C486 clk VSUBS 0.123f
C487 ibias VSUBS 0.159f
C488 vref mclkb 0.0475f
C489 vdd VSUBS 0.0576f
C490 xckg_d3 xckg_d0 0.102f
C491 xref_ng clk 0.0959f
C492 xcbiasn_xrb_s3 VSUBS 0.0368f
C493 xref_ng xckg_d3 0.583f
C494 xcbias_xrb_s2 VSUBS 0.189f
C495 xref_na VSUBS 0.0581f
C496 xckg_x VSUBS 0.233f
C497 xckg_x VSUBS 0.471f
C498 vss xckg_d2 0.0472f
C499 clk VSUBS 0.193f
C500 vdd VSUBS 0.319f
C501 xref_na VSUBS 0.142f
C502 xcbiasn_xrb_s1 VSUBS 0.0766f
C503 xckg_d2 VSUBS 0.192f
C504 xcbiasn_xrb_s3 VSUBS 0.108f
C505 xref_ng VSUBS 0.327f
C506 xckg_d1 vbn 0.342f
C507 vbp xckg_d0 0.058f
C508 vss vdd 0.104f
C509 xcbias_xrb_s3 sar_mclk 0.751f
C510 xckg_nn VSUBS 0.639f
C511 xckg_d3 VSUBS 0.104f
C512 ibias VSUBS 0.182f
C513 vref_in VSUBS 0.453f
C514 vref_in VSUBS 0.199f
C515 xcbiasn_xrb_s1 vrefl 0.348f
C516 xcbiasn_xrb_s3 vbn 0.081f
C517 xcbias_xrb_s1 vbp 0.194f
C518 xckg_d2 xckg_x 0.106f
C519 vref_in xref_ng 0.145f
C520 xcbias_xrb_s2 VSUBS 0.116f
C521 ibias xref_na 0.0508f
C522 vbp VSUBS 0.0399f
C523 vrefl vbn 0.263f
C524 vref VSUBS 0.305f
C525 xcbias_xrb_s2 xref_ng 0.264f
C526 vdda VSUBS 0.0774f
C527 xckg_d1 VSUBS 0.164f
C528 vrefl vbn 0.0768f
C529 xckg_x xckg_nn 0.0866f
C530 vss VSUBS 0.084f
C531 xcbiasn_xrb_s2 VSUBS 0.067f
C532 xcbias_xrb_s2 vrefl 0.126f
C533 xckg_x xref_ntl 0.0481f
C534 vss xckg_d2 0.217f
C535 xcbias_xrb_s3 VSUBS 0.0328f
C536 xcbias_xrb_s2 VSUBS 0.0963f
C537 xckg_x vref_in 0.24f
C538 xref_ng xref_ntl 0.612f
C539 xref_na VSUBS 0.0935f
C540 xckg_d1 vref 0.113f
C541 xckg_nn VSUBS 0.201f
C542 xref_ntl xcbiasn_xrb_s1 0.443f
C543 vrefl xckg_d3 0.109f
C544 vbp xref_ng 0.39f
C545 xckg_d1 VSUBS 0.478f
C546 xcbiasn_xrb_s2 xckg_d2 0.169f
C547 xref_ng VSUBS 0.259f
C548 vref ibias 0.179f
C549 xckg_nn VSUBS 0.0909f
C550 vdd VSUBS 0.428f
C551 xckg_x xcbiasn_xrb_s1 0.172f
C552 xref_ng VSUBS 0.157f
C553 xckg_d2 VSUBS 0.234f
C554 vrefl VSUBS 0.913f
C555 vref_in VSUBS 0.177f
C556 xref_ntl VSUBS 1.03f
C557 ibias xcbiasn_xrb_s1 0.274f
C558 xcbiasn_xrb_s2 VSUBS 0.0493f
C559 xckg_d1 VSUBS 0.161f
C560 xckg_nn xckg_nn 1.16f
C561 xcbiasn_xrb_s1 VSUBS 0.517f
C562 vbn VSUBS 0.308f
C563 xcbias_xrb_s1 sar_mclk 0.249f
C564 xcbiasn_xrb_s2 vbn 0.241f
C565 xckg_nn clk 0.0983f
C566 xcbiasn_xrb_s3 VSUBS 0.111f
C567 xcbias_xrb_s3 vbn 0.198f
C568 vdd VSUBS 0.141f
C569 vref_in xcbias_xrb_s1 0.107f
C570 xcbiasn_xrb_s1 VSUBS 0.069f
C571 vbn VSUBS 0.117f
C572 xckg_d3 VSUBS 0.236f
C573 vdda xckg_nn 0.174f
C574 vref xcbias_xrb_s2 0.04f
C575 vref xref_ntl 0.261f
C576 vdd VSUBS 0.638f
C577 xref_na VSUBS 0.14f
C578 xcbias_xrb_s3 VSUBS 0.188f
C579 xcbias_xrb_s1 vdda 0.538f
C580 vss VSUBS 0.143f
C581 vrefl xckg_d1 0.0781f
C582 vbn xckg_nn 0.134f
C583 vbn vdda 0.236f
C584 vbn vbn 0.336f
C585 xcbias_xrb_s3 VSUBS 0.0753f
C586 xckg_nn VSUBS 0.411f
C587 xckg_d1 VSUBS 0.191f
C588 vss VSUBS 0.0677f
C589 xckg_d3 VSUBS 0.0231f
C590 vbp VSUBS 0.0858f
C591 xcbiasn_xrb_s1 vbn 0.0839f
C592 vrefl xref_ng 0.0918f
C593 xcbias_xrb_s2 vbp 0.0534f
C594 sar_mclk VSUBS 0.0975f
C595 xcbiasn_xrb_s3 vref_in 0.257f
C596 xckg_nn xcbiasn_xrb_s1 0.0785f
C597 xcbiasn_xrb_s2 clk 0.0429f
C598 xckg_d0 xcbias_xrb_s2 0.424f
C599 vdd VSUBS 0.0865f
C600 mclkb VSUBS 0.154f
C601 vref_in ibias 0.105f
C602 xckg_d1 sar_mclk 0.0398f
C603 vdda xcbiasn_xrb_s3 0.106f
C604 vrefl VSUBS 0.102f
C605 xcbiasn_xrb_s2 VSUBS 0.364f
C606 xckg_d0 xckg_nn 0.0889f
C607 xref_na vref 0.25f
C608 xcbiasn_xrb_s2 xckg_d3 0.0419f
C609 ibias vdda 0.0914f
C610 xckg_x VSUBS 0.157f
C611 xref_na xckg_d0 0.0359f
C612 vss vbn 0.775f
C613 vbn VSUBS 0.202f
C614 xcbiasn_xrb_s1 VSUBS 0.0927f
C615 xcbiasn_xrb_s3 vbn 0.0616f
C616 xref_na VSUBS 0.0708f
C617 xckg_d2 VSUBS 0.17f
C618 vdda VSUBS 0.317f
C619 vbp vref_in 0.186f
C620 sar_mclk VSUBS 0.125f
C621 xcbias_xrb_s2 xcbias_xrb_s1 0.187f
C622 vrefl VSUBS 0.563f
C623 xcbiasn_xrb_s1 VSUBS 0.349f
C624 xckg_x xcbiasn_xrb_s2 0.25f
C625 clk xcbiasn_xrb_s2 0.071f
C626 xcbiasn_xrb_s2 VSUBS 0.135f
C627 vss VSUBS 0.113f
C628 mclkb VSUBS 0.117f
C629 vbp VSUBS 0.125f
C630 vbn VSUBS 0.344f
C631 xcbiasn_xrb_s2 VSUBS 0.159f
C632 vbp VSUBS 0.709f
C633 xcbias_xrb_s1 VSUBS 0.278f
C634 vbp VSUBS 0.0603f
C635 xckg_d3 VSUBS 0.619f
C636 xref_na xckg_d2 0.189f
C637 ibias vbp 0.182f
C638 xckg_d2 clk 0.486f
C639 vss sar_mclk 0.441f
C640 mclkb VSUBS 0.11f
C641 vref VSUBS 0.0905f
C642 xcbias_xrb_s1 VSUBS 0.181f
C643 vbn VSUBS 0.111f
C644 xckg_d3 xcbias_xrb_s2 0.551f
C645 xckg_nn VSUBS 0.138f
C646 xref_ntl xcbias_xrb_s2 0.0405f
C647 xref_ntl xckg_d0 0.134f
C648 xref_ntl VSUBS 0.177f
C649 vref_in VSUBS 0.714f
C650 ibias VSUBS 0.363f
C651 xcbiasn_xrb_s2 VSUBS 0.185f
C652 xcbias_xrb_s2 xckg_d0 0.128f
C653 mclkb VSUBS 0.351f
C654 ibias vbn 0.0783f
C655 sar_mclk xref_na 0.436f
C656 xckg_d0 VSUBS 0.0398f
C657 vrefl mclkb 0.23f
C658 vss VSUBS 0.0816f
C659 xcbiasn_xrb_s2 VSUBS 0.2f
C660 xref_na VSUBS 0.0983f
C661 vdd VSUBS 0.0778f
C662 mclkb VSUBS 0.122f
C663 sar_mclk VSUBS 0.0545f
C664 xcbiasn_xrb_s3 VSUBS 0.561f
C665 vbn VSUBS 0.166f
C666 xref_ng VSUBS 0.544f
C667 xcbias_xrb_s3 xcbias_xrb_s2 0.15f
C668 vdda VSUBS 0.227f
C669 xref_ng vrefl 0.151f
C670 vdda VSUBS 0.0896f
C671 vss xcbias_xrb_s2 0.146f
C672 vref xref_ng 0.483f
C673 clk VSUBS 0.487f
C674 vref VSUBS 0.0743f
C675 vrefl xcbias_xrb_s3 0.0911f
C676 xckg_d1 xref_na 0.0206f
C677 vbn VSUBS 0.116f
C678 xcbiasn_xrb_s3 VSUBS 0.15f
C679 ibias VSUBS 0.105f
C680 clk VSUBS 0.144f
C681 ibias VSUBS 0.0456f
C682 xcbias_xrb_s2 xref_na 0.128f
C683 xref_ntl xref_ng 0.303f
C684 xref_ntl VSUBS 0.131f
C685 sar_mclk VSUBS 0.75f
C686 xcbiasn_xrb_s1 clk 0.12f
C687 ibias xckg_d1 0.239f
C688 vrefl vbn 0.561f
C689 xref_ng VSUBS 0.311f
C690 xcbias_xrb_s3 VSUBS 0.274f
C691 vss VSUBS 0.164f
C692 xcbias_xrb_s1 xcbiasn_xrb_s3 0.0877f
C693 vrefl xckg_d2 0.079f
C694 vrefl VSUBS 0.0764f
C695 xcbiasn_xrb_s2 xref_na 0.0516f
C696 vbn VSUBS 0.287f
C697 vdd sar_mclk 0.0821f
C698 xcbias_xrb_s3 VSUBS 0.141f
C699 xckg_d1 VSUBS 0.142f
C700 ibias clk 0.136f
C701 mclkb VSUBS 0.211f
C702 clk xckg_nn 0.0722f
C703 vss xcbiasn_xrb_s3 0.794f
C704 mclkb xref_ntl 0.224f
C705 vdd VSUBS 0.214f
C706 vss xref_ntl 0.237f
C707 xref_na xcbiasn_xrb_s1 0.101f
C708 xckg_d2 VSUBS 0.252f
C709 xcbiasn_xrb_s2 VSUBS 0.314f
C710 xckg_d1 VSUBS 0.129f
C711 xcbias_xrb_s1 VSUBS 0.194f
C712 vbp VSUBS 0.62f
C713 ibias vbp 0.0716f
C714 xckg_x VSUBS 0.0966f
C715 vss VSUBS 0.203f
C716 xckg_d3 vdd 0.0313f
C717 xcbiasn_xrb_s3 VSUBS 0.0656f
C718 xcbiasn_xrb_s1 sar_mclk 0.181f
C719 xref_ng VSUBS 0.289f
C720 vbn VSUBS 0.0606f
C721 xcbiasn_xrb_s1 vbp 0.336f
C722 xckg_nn VSUBS 0.266f
C723 xcbias_xrb_s2 VSUBS 0.0866f
C724 clk VSUBS 0.183f
C725 xref_ntl VSUBS 0.423f
C726 mclkb VSUBS 0.253f
C727 xcbias_xrb_s1 VSUBS 0.158f
C728 vss VSUBS 0.283f
C729 clk VSUBS 1.25f
C730 xcbias_xrb_s1 VSUBS 0.314f
C731 xref_ntl VSUBS 0.228f
C732 xckg_d3 xref_na 0.373f
C733 xref_ntl xcbias_xrb_s1 0.113f
C734 mclkb VSUBS 0.495f
C735 sar_mclk VSUBS 0.0244f
C736 vss xref_na 0.0368f
C737 xcbias_xrb_s2 xckg_nn 0.461f
C738 vdda vbp 0.258f
C739 xcbias_xrb_s1 xcbiasn_xrb_s2 0.1f
C740 xcbias_xrb_s2 VSUBS 0.341f
C741 xckg_x VSUBS 0.115f
C742 xcbiasn_xrb_s3 VSUBS 0.148f
C743 vdda VSUBS 0.0733f
C744 xref_ng VSUBS 0.229f
C745 vrefl vbp 0.338f
C746 vbp VSUBS 0.248f
C747 xref_na xckg_nn 0.0277f
C748 xckg_d1 VSUBS 0.116f
C749 xckg_d2 xckg_d3 0.112f
C750 vref_in VSUBS 0.195f
C751 vref VSUBS 0.477f
C752 vref_in VSUBS 0.109f
C753 xckg_d2 VSUBS 0.0449f
C754 vdd VSUBS 0.271f
C755 xcbias_xrb_s3 VSUBS 0.226f
C756 xcbias_xrb_s2 VSUBS 0.167f
C757 xcbias_xrb_s1 VSUBS 0.214f
C758 vbn xref_ntl 0.185f
C759 sar_mclk VSUBS 0.333f
C760 xcbiasn_xrb_s1 VSUBS 0.186f
C761 clk xcbias_xrb_s2 0.299f
C762 xcbiasn_xrb_s3 xckg_d2 0.166f
C763 xref_ng VSUBS 0.175f
C764 clk mclkb 0.0496f
C765 vrefl VSUBS 0.0879f
C766 vbn xckg_d0 0.194f
C767 xckg_d2 VSUBS 0.182f
C768 xcbiasn_xrb_s2 clk 0.179f
C769 xckg_d0 xckg_nn 0.112f
C770 xckg_d2 VSUBS 0.266f
C771 xckg_d1 VSUBS 0.386f
C772 xref_ng VSUBS 0.116f
C773 vref VSUBS 0.144f
C774 xcbiasn_xrb_s3 VSUBS 0.0895f
C775 xckg_d2 vref_in 0.158f
C776 mclkb xckg_nn 0.25f
C777 xckg_d3 VSUBS 0.112f
C778 xref_ntl VSUBS 0.0412f
C779 clk VSUBS 0.272f
C780 xref_na xckg_x 0.0779f
C781 xckg_d3 vbp 0.386f
C782 xckg_d2 VSUBS 0.159f
C783 xcbias_xrb_s1 vbn 0.0303f
C784 xcbias_xrb_s2 VSUBS 0.183f
C785 xcbias_xrb_s1 VSUBS 0.216f
C786 xckg_x VSUBS 0.163f
C787 xcbias_xrb_s2 VSUBS 0.089f
C788 xcbiasn_xrb_s2 VSUBS 0.0703f
C789 xckg_d3 VSUBS 0.0797f
C790 vdda xref_na 0.24f
C791 xref_na VSUBS 0.0413f
C792 vrefl vdda 0.269f
C793 xref_na xcbias_xrb_s2 0.0748f
C794 xref_ng VSUBS 0.0636f
C795 vdd VSUBS 0.159f
C796 vbn xcbiasn_xrb_s1 0.132f
C797 xckg_d2 xcbias_xrb_s2 0.0885f
C798 xref_ntl xref_na 0.162f
C799 vdd clk 0.273f
C800 clk VSUBS 0.0692f
C801 xcbiasn_xrb_s1 vbp 0.0905f
C802 xcbias_xrb_s2 vref_in 0.25f
C803 xckg_d1 VSUBS 0.122f
C804 vbp VSUBS 0.0443f
C805 xcbiasn_xrb_s2 xcbiasn_xrb_s3 0.0701f
C806 xckg_d1 VSUBS 0.422f
C807 ibias xcbiasn_xrb_s1 0.919f
C808 xcbias_xrb_s2 VSUBS 0.163f
C809 xcbiasn_xrb_s2 VSUBS 0.415f
C810 vrefl xcbias_xrb_s1 0.436f
C811 xckg_d1 vref_in 0.0592f
C812 vrefl VSUBS 0.156f
C813 xckg_d1 vref 0.0755f
C814 vss VSUBS 0.113f
C815 xcbias_xrb_s1 VSUBS 0.0196f
C816 xckg_x VSUBS 0.0411f
C817 xckg_d3 sar_mclk 0.0867f
C818 xckg_d2 VSUBS 0.0605f
C819 xckg_d0 VSUBS 0.08f
C820 ibias xcbias_xrb_s1 0.25f
C821 xckg_d3 xckg_nn 0.202f
C822 xref_na VSUBS 0.395f
C823 xckg_d3 VSUBS 0.0715f
C824 vdd xcbiasn_xrb_s2 0.0647f
C825 vbp xcbias_xrb_s3 0.196f
C826 vbp VSUBS 0.129f
C827 xckg_d3 VSUBS 0.0604f
C828 xref_na VSUBS 0.226f
C829 clk vdda 0.202f
C830 ibias VSUBS 0.221f
C831 xref_ng VSUBS 0.0398f
C832 sar_mclk clk 0.2f
C833 sar_mclk xckg_x 0.122f
C834 xref_ng sar_mclk 0.202f
C835 xckg_d0 VSUBS 0.188f
C836 xref_ng VSUBS 0.101f
C837 vdda xref_na 0.187f
C838 xcbiasn_xrb_s3 xcbiasn_xrb_s3 0.106f
C839 xcbias_xrb_s1 xckg_nn 0.0559f
C840 xcbias_xrb_s1 VSUBS 0.335f
C841 xckg_d0 xcbiasn_xrb_s1 0.493f
C842 vbp VSUBS 0.167f
C843 vdda VSUBS 0.1f
C844 ibias VSUBS 0.0703f
C845 xckg_nn xref_ng 0.102f
C846 xckg_x VSUBS 0.221f
C847 sar_mclk VSUBS 0.448f
C848 vdd vdda 0.244f
C849 sar_mclk mclkb 0.121f
C850 xckg_x VSUBS 0.0535f
C851 sar_mclk xcbias_xrb_s2 0.204f
C852 sar_mclk VSUBS 0.539f
C853 vref_in xcbias_xrb_s2 0.3f
C854 xcbias_xrb_s3 VSUBS 0.0888f
C855 xckg_d0 vdd 0.1f
C856 vref VSUBS 0.0888f
C857 sar_mclk VSUBS 0.0556f
C858 xcbias_xrb_s2 xref_na 0.859f
C859 vrefl VSUBS 0.197f
C860 vdd VSUBS 0.783f
C861 xckg_d1 ibias 0.409f
C862 xref_na VSUBS 0.0687f
C863 sar_mclk VSUBS 0.231f
C864 vref_in VSUBS 0.0579f
C865 vrefl VSUBS 0.376f
C866 xckg_d3 VSUBS 0.6f
C867 xref_ng xcbias_xrb_s3 0.119f
C868 xckg_nn VSUBS 0.137f
C869 xref_ng ibias 0.137f
C870 mclkb VSUBS 0.446f
C871 vbp VSUBS 0.328f
C872 xcbias_xrb_s3 VSUBS 0.476f
C873 vdda VSUBS 0.329f
C874 xckg_d3 xckg_x 0.0537f
C875 xcbiasn_xrb_s2 VSUBS 0.114f
C876 xckg_nn clk 0.391f
C877 clk VSUBS 0.389f
C878 xckg_nn VSUBS 0.13f
C879 ibias VSUBS 0.102f
C880 vref_in xcbiasn_xrb_s1 0.0681f
C881 xcbias_xrb_s3 VSUBS 0.0616f
C882 xref_ng vrefl 0.19f
C883 xcbiasn_xrb_s3 VSUBS 0.14f
C884 vss sar_mclk 0.212f
C885 xcbias_xrb_s2 xckg_d2 0.442f
C886 xcbiasn_xrb_s1 VSUBS 0.338f
C887 xckg_d3 mclkb 0.102f
C888 xcbias_xrb_s3 xref_na 0.209f
C889 xcbiasn_xrb_s2 VSUBS 0.572f
C890 vbp xckg_nn 0.175f
C891 vdda xckg_nn 0.296f
C892 xckg_x VSUBS 0.231f
C893 mclkb VSUBS 0.0698f
C894 xckg_d2 VSUBS 0.16f
C895 xcbias_xrb_s1 vref_in 0.177f
C896 xcbias_xrb_s1 VSUBS 0.153f
C897 xcbiasn_xrb_s1 VSUBS 0.201f
C898 xref_ng VSUBS 0.062f
C899 xcbiasn_xrb_s3 sar_mclk 0.18f
C900 vdd VSUBS 0.0618f
C901 clk VSUBS 0.397f
C902 vdda VSUBS 0.0483f
C903 vrefl VSUBS 0.337f
C904 xcbiasn_xrb_s1 VSUBS 0.0925f
C905 clk xckg_nn 0.0337f
C906 xcbiasn_xrb_s2 VSUBS 0.278f
C907 vref_in VSUBS 0.192f
C908 xcbias_xrb_s3 VSUBS 0.43f
C909 vrefl vbp 0.099f
C910 sar_mclk xckg_d2 0.733f
C911 mclkb VSUBS 0.0519f
C912 clk VSUBS 0.0937f
C913 xckg_x ibias 0.0738f
C914 vdda xcbiasn_xrb_s2 0.132f
C915 xckg_x VSUBS 0.118f
C916 xref_ntl VSUBS 0.121f
C917 clk VSUBS 0.168f
C918 vref clk 0.0746f
C919 ibias VSUBS 0.179f
C920 xcbiasn_xrb_s3 xckg_nn 0.11f
C921 vrefl VSUBS 0.413f
C922 xcbiasn_xrb_s3 xckg_x 0.0477f
C923 ibias VSUBS 0.313f
C924 clk xcbiasn_xrb_s2 0.12f
C925 sar_mclk VSUBS 0.174f
C926 xckg_d3 xckg_d2 0.14f
C927 xref_ntl xcbias_xrb_s1 0.138f
C928 xcbiasn_xrb_s2 VSUBS 0.116f
C929 vref_in VSUBS 0.0475f
C930 sar_mclk xckg_nn 0.169f
C931 vdda xckg_d3 0.0725f
C932 xref_na ibias 0.0461f
C933 xckg_d2 VSUBS 0.48f
C934 xref_ng VSUBS 0.718f
C935 mclkb VSUBS 0.228f
C936 vss VSUBS 0.109f
C937 xref_ng xcbias_xrb_s3 0.0631f
C938 xckg_x VSUBS 0.141f
C939 xckg_d0 xckg_nn 0.157f
C940 ibias xref_ntl 0.439f
C941 xcbias_xrb_s1 mclkb 0.157f
C942 xcbias_xrb_s1 xref_na 0.271f
C943 sar_mclk VSUBS 0.113f
C944 vdd xckg_x 0.314f
C945 vrefl VSUBS 0.324f
C946 xcbias_xrb_s2 xcbias_xrb_s1 0.148f
C947 vrefl VSUBS 0.094f
C948 mclkb VSUBS 0.0964f
C949 xckg_nn VSUBS 0.0841f
C950 vbn mclkb 0.414f
C951 vref sar_mclk 0.125f
C952 xref_na VSUBS 0.16f
C953 xref_ng VSUBS 0.255f
C954 vbn xcbiasn_xrb_s3 0.0237f
C955 xref_ntl VSUBS 0.256f
C956 vrefl mclkb 0.399f
C957 vref xcbias_xrb_s1 0.114f
C958 xckg_d1 VSUBS 0.0936f
C959 vref VSUBS 0.157f
C960 xcbiasn_xrb_s3 xcbiasn_xrb_s3 0.0171f
C961 xcbias_xrb_s3 clk 0.127f
C962 xcbias_xrb_s2 vrefl 0.168f
C963 vrefl xckg_d0 0.367f
C964 vref vbp 0.353f
C965 xckg_x VSUBS 0.192f
C966 mclkb xcbiasn_xrb_s1 0.149f
C967 sar_mclk xcbiasn_xrb_s2 0.314f
C968 xcbias_xrb_s1 VSUBS 0.0857f
C969 vref_in vdd 0.133f
C970 xcbiasn_xrb_s2 xckg_nn 0.0251f
C971 xref_na VSUBS 0.109f
C972 xcbias_xrb_s2 vrefl 0.231f
C973 xckg_d3 VSUBS 0.637f
C974 vref_in VSUBS 0.318f
C975 vref xcbiasn_xrb_s2 0.118f
C976 clk vbn 0.0739f
C977 vref VSUBS 0.241f
C978 mclkb VSUBS 0.0488f
C979 xcbiasn_xrb_s1 vdda 0.0514f
C980 xcbias_xrb_s2 VSUBS 0.166f
C981 xckg_d0 VSUBS 0.54f
C982 xcbias_xrb_s3 VSUBS 0.304f
C983 vref_in xcbias_xrb_s1 0.0927f
C984 xckg_d0 VSUBS 0.0788f
C985 xcbias_xrb_s1 VSUBS 0.0316f
C986 xcbiasn_xrb_s1 VSUBS 0.0578f
C987 vbp VSUBS 0.441f
C988 clk VSUBS 0.428f
C989 xcbiasn_xrb_s3 VSUBS 0.298f
C990 xckg_d3 vrefl 0.225f
C991 vref_in xcbias_xrb_s2 0.178f
C992 xckg_d1 VSUBS 0.0858f
C993 vbn VSUBS 0.0729f
C994 vdda VSUBS 0.69f
C995 vrefl VSUBS 0.496f
C996 xckg_d2 xckg_nn 0.105f
C997 vref_in VSUBS 0.0822f
C998 xcbiasn_xrb_s2 VSUBS 0.376f
C999 xcbiasn_xrb_s1 VSUBS 0.513f
C1000 xckg_d2 ibias 0.14f
C1001 vss VSUBS 0.203f
C1002 xcbias_xrb_s2 VSUBS 0.343f
C1003 xref_na VSUBS 0.133f
C1004 clk VSUBS 0.22f
C1005 xckg_nn xckg_d0 0.614f
C1006 xcbiasn_xrb_s2 xckg_d1 0.0284f
C1007 xckg_x xref_na 0.0681f
C1008 vdd VSUBS 0.0547f
C1009 xcbias_xrb_s1 VSUBS 0.189f
C1010 vref VSUBS 0.239f
C1011 vss VSUBS 0.25f
C1012 vdd VSUBS 0.243f
C1013 vss vref_in 0.0606f
C1014 xcbias_xrb_s1 VSUBS 0.132f
C1015 vdd VSUBS 0.287f
C1016 xcbiasn_xrb_s3 xref_na 0.537f
C1017 vrefl vref_in 0.0972f
C1018 vbn VSUBS 0.824f
C1019 xcbiasn_xrb_s1 VSUBS 0.423f
C1020 xckg_x vbn 0.0774f
C1021 xckg_d3 VSUBS 0.344f
C1022 xckg_d2 xcbiasn_xrb_s1 0.118f
C1023 clk VSUBS 0.246f
C1024 xcbias_xrb_s3 sar_mclk 0.29f
C1025 sar_mclk VSUBS 0.057f
C1026 vbn VSUBS 0.338f
C1027 xcbias_xrb_s3 xckg_x 0.0392f
C1028 xref_ntl VSUBS 0.308f
C1029 xcbiasn_xrb_s3 VSUBS 0.391f
C1030 xckg_d2 VSUBS 0.0885f
C1031 vbp VSUBS 0.156f
C1032 vdda vrefl 0.0628f
C1033 xcbiasn_xrb_s1 xref_na 0.716f
C1034 vbn VSUBS 0.142f
C1035 xckg_d3 VSUBS 0.187f
C1036 xref_ng VSUBS 0.255f
C1037 xckg_d0 VSUBS 0.0931f
C1038 clk VSUBS 0.184f
C1039 xckg_d1 xckg_x 0.24f
C1040 vref_in VSUBS 0.0245f
C1041 xcbias_xrb_s2 VSUBS 0.0817f
C1042 vbn VSUBS 0.202f
C1043 xcbias_xrb_s1 VSUBS 0.107f
C1044 clk VSUBS 0.38f
C1045 xcbias_xrb_s1 mclkb 0.0643f
C1046 clk vbn 0.0678f
C1047 vbp xckg_d2 0.133f
C1048 xckg_nn xckg_d2 0.196f
C1049 xckg_d2 VSUBS 0.43f
C1050 vbn VSUBS 0.187f
C1051 vbp vrefl 0.113f
C1052 xckg_x VSUBS 0.117f
C1053 xcbiasn_xrb_s1 VSUBS 0.156f
C1054 xcbias_xrb_s2 VSUBS 0.364f
C1055 xcbiasn_xrb_s3 VSUBS 0.113f
C1056 mclkb xcbias_xrb_s2 0.229f
C1057 xckg_nn VSUBS 0.0684f
C1058 xckg_d1 xref_ng 0.0572f
C1059 xckg_d1 VSUBS 0.671f
C1060 xckg_d2 VSUBS 0.296f
C1061 xcbias_xrb_s1 VSUBS 0.0299f
C1062 vdd VSUBS 0.334f
C1063 vss xckg_nn 0.0674f
C1064 vdda vrefl 0.142f
C1065 xref_na vrefl 0.261f
C1066 xckg_d2 VSUBS 0.0657f
C1067 xcbias_xrb_s3 vref 0.169f
C1068 vref vbn 0.211f
C1069 xckg_d3 VSUBS 0.0681f
C1070 vrefl VSUBS 0.174f
C1071 xcbiasn_xrb_s1 ibias 0.422f
C1072 xckg_d2 vbn 0.163f
C1073 vdda xcbiasn_xrb_s2 0.596f
C1074 xcbiasn_xrb_s2 VSUBS 0.186f
C1075 vdda VSUBS 0.0536f
C1076 xcbias_xrb_s3 VSUBS 0.211f
C1077 xcbiasn_xrb_s2 VSUBS 0.207f
C1078 vbn VSUBS 0.0629f
C1079 vbn xcbiasn_xrb_s1 0.0375f
C1080 xckg_nn VSUBS 0.122f
C1081 vbp VSUBS 0.266f
C1082 vref_in xcbias_xrb_s1 0.116f
C1083 xcbiasn_xrb_s1 xckg_d0 0.148f
C1084 xcbias_xrb_s2 VSUBS 0.509f
C1085 xckg_d1 VSUBS 0.256f
C1086 xref_ng xckg_d0 0.249f
C1087 xckg_d3 VSUBS 0.17f
C1088 xcbiasn_xrb_s1 VSUBS 0.228f
C1089 sar_mclk VSUBS 0.129f
C1090 vbn VSUBS 0.352f
C1091 vbn xckg_x 0.0819f
C1092 xckg_d0 VSUBS 0.0575f
C1093 xref_na VSUBS 0.107f
C1094 xcbiasn_xrb_s3 VSUBS 0.0648f
C1095 xref_na VSUBS 0.0726f
C1096 sar_mclk vdd 0.0753f
C1097 xckg_d3 VSUBS 0.121f
C1098 xckg_nn VSUBS 0.219f
C1099 xcbiasn_xrb_s3 clk 0.638f
C1100 vref_in vbn 0.0512f
C1101 xckg_d3 VSUBS 0.142f
C1102 mclkb VSUBS 0.156f
C1103 vdda VSUBS 0.625f
C1104 xref_ntl VSUBS 0.182f
C1105 xckg_d3 VSUBS 0.0949f
C1106 xckg_d0 VSUBS 0.081f
C1107 vbn VSUBS 0.101f
C1108 vbp xckg_d0 0.187f
C1109 xcbiasn_xrb_s3 VSUBS 0.117f
C1110 ibias VSUBS 0.0527f
C1111 xcbiasn_xrb_s2 xckg_d1 0.42f
C1112 vdd VSUBS 0.188f
C1113 xckg_nn xref_na 0.127f
C1114 xref_ntl VSUBS 0.115f
C1115 vss VSUBS 0.261f
C1116 xref_ng VSUBS 0.0918f
C1117 xcbiasn_xrb_s1 xckg_d2 0.0843f
C1118 vref xref_na 0.0303f
C1119 xcbias_xrb_s3 VSUBS 0.206f
C1120 vss xref_ntl 0.11f
C1121 clk vbn 0.177f
C1122 vref VSUBS 0.434f
C1123 xckg_x VSUBS 0.0693f
C1124 vref_in VSUBS 0.045f
C1125 xckg_d3 vrefl 0.33f
C1126 clk VSUBS 0.079f
C1127 xref_ntl xckg_x 0.165f
C1128 xref_na VSUBS 0.0683f
C1129 xckg_d0 xcbiasn_xrb_s2 0.0708f
C1130 xcbiasn_xrb_s3 VSUBS 0.113f
C1131 vref xckg_d1 0.157f
C1132 ibias vdd 0.234f
C1133 xckg_x vbp 0.13f
C1134 clk VSUBS 0.482f
C1135 xcbias_xrb_s2 vref_in 0.222f
C1136 xckg_d1 VSUBS 0.215f
C1137 vss VSUBS 0.107f
C1138 xcbiasn_xrb_s3 xcbiasn_xrb_s3 0.0813f
C1139 sar_mclk VSUBS 0.389f
C1140 xref_na VSUBS 0.112f
C1141 xckg_d0 VSUBS 0.434f
C1142 xckg_d1 VSUBS 0.326f
C1143 vref_in VSUBS 0.198f
C1144 xckg_nn sar_mclk 0.0767f
C1145 xcbiasn_xrb_s1 clk 0.0578f
C1146 xcbiasn_xrb_s3 xckg_d0 0.169f
C1147 xckg_nn xckg_d3 0.0466f
C1148 xcbiasn_xrb_s2 VSUBS 0.266f
C1149 xref_ntl xref_ntl 0.483f
C1150 xcbias_xrb_s2 VSUBS 0.154f
C1151 xckg_nn xcbiasn_xrb_s2 0.346f
C1152 vrefl VSUBS 0.143f
C1153 xckg_d1 VSUBS 0.128f
C1154 vbp VSUBS 0.328f
C1155 vbp clk 0.0597f
C1156 vdd VSUBS 0.175f
C1157 xcbiasn_xrb_s2 xckg_d3 0.412f
C1158 vdd VSUBS 0.215f
C1159 vref_in xcbiasn_xrb_s1 0.109f
C1160 vss VSUBS 0.355f
C1161 mclkb VSUBS 1.42f
C1162 vrefl xcbias_xrb_s2 0.129f
C1163 xckg_d0 VSUBS 0.207f
C1164 xcbiasn_xrb_s1 VSUBS 0.24f
C1165 xcbias_xrb_s3 VSUBS 0.14f
C1166 xref_ng VSUBS 0.185f
C1167 xref_ng xcbiasn_xrb_s1 0.15f
C1168 xckg_d0 VSUBS 0.228f
C1169 xckg_nn VSUBS 0.358f
C1170 vbn xckg_d1 0.149f
C1171 sar_mclk VSUBS 0.255f
C1172 xckg_nn VSUBS 0.0799f
C1173 xckg_d3 VSUBS 0.289f
C1174 sar_mclk VSUBS 0.171f
C1175 vrefl VSUBS 0.166f
C1176 xref_ng VSUBS 0.403f
C1177 xckg_nn vrefl 0.536f
C1178 xcbiasn_xrb_s3 clk 0.229f
C1179 xckg_d3 VSUBS 0.12f
C1180 xckg_d2 VSUBS 0.0603f
C1181 ibias xckg_d3 0.0978f
C1182 xcbias_xrb_s3 ibias 0.432f
C1183 xcbias_xrb_s3 VSUBS 0.202f
C1184 vref_in xckg_nn 0.543f
C1185 xref_ng VSUBS 0.192f
C1186 xref_ng VSUBS 0.264f
C1187 xref_na VSUBS 0.142f
C1188 xckg_d3 VSUBS 0.0714f
C1189 xref_na ibias 0.18f
C1190 vdda vref_in 0.252f
C1191 xckg_nn VSUBS 0.161f
C1192 vrefl xref_na 0.205f
C1193 mclkb VSUBS 0.695f
C1194 xcbias_xrb_s1 xcbiasn_xrb_s1 0.0862f
C1195 vbn VSUBS 0.398f
C1196 xref_ng xref_ntl 0.189f
C1197 vbp VSUBS 0.221f
C1198 xckg_d1 VSUBS 0.138f
C1199 mclkb VSUBS 0.118f
C1200 vrefl VSUBS 0.424f
C1201 xckg_d1 VSUBS 0.384f
C1202 sar_mclk ibias 0.151f
C1203 clk xcbiasn_xrb_s1 0.107f
C1204 xref_ntl xcbiasn_xrb_s1 0.103f
C1205 vdda vref 0.0989f
C1206 xckg_d0 VSUBS 0.497f
C1207 xckg_d3 VSUBS 0.143f
C1208 ibias VSUBS 0.0665f
C1209 vbn VSUBS 0.151f
C1210 xref_ntl vref_in 0.0402f
C1211 xckg_x VSUBS 0.296f
C1212 xref_ng VSUBS 0.0404f
C1213 xcbiasn_xrb_s3 xckg_d3 0.321f
C1214 vref VSUBS 0.188f
C1215 vref_in VSUBS 0.0636f
C1216 xcbiasn_xrb_s1 VSUBS 0.0389f
C1217 xcbiasn_xrb_s3 VSUBS 0.411f
C1218 vref_in vrefl 0.164f
C1219 xref_na VSUBS 0.171f
C1220 vref_in VSUBS 0.076f
C1221 vss VSUBS 0.217f
C1222 vbp xcbiasn_xrb_s1 0.242f
C1223 xcbias_xrb_s1 vrefl 0.48f
C1224 vss VSUBS 0.0916f
C1225 clk VSUBS 0.342f
C1226 xref_ntl xref_ntl 0.172f
C1227 clk VSUBS 0.557f
C1228 mclkb VSUBS 0.0782f
C1229 ibias vref 0.158f
C1230 xckg_nn VSUBS 0.0797f
C1231 xckg_d1 vref 0.084f
C1232 xckg_d2 VSUBS 0.0908f
C1233 xref_ng xcbiasn_xrb_s3 0.129f
C1234 vdda sar_mclk 0.02f
C1235 vbn VSUBS 0.381f
C1236 xcbias_xrb_s2 VSUBS 0.216f
C1237 xcbiasn_xrb_s1 VSUBS 0.0527f
C1238 vbn VSUBS 0.041f
C1239 xckg_d1 VSUBS 0.219f
C1240 xckg_d1 clk 0.198f
C1241 mclkb mclkb 0.161f
C1242 vref VSUBS 0.0778f
C1243 vbn VSUBS 0.0423f
C1244 xcbias_xrb_s3 VSUBS 0.437f
C1245 xckg_d1 VSUBS 0.13f
C1246 ibias xckg_d2 0.0524f
C1247 xref_na VSUBS 0.0587f
C1248 sar_mclk xckg_d2 0.227f
C1249 vbn VSUBS 0.218f
C1250 vbp VSUBS 0.598f
C1251 xckg_nn mclkb 0.0497f
C1252 vbn xref_ng 0.124f
C1253 sar_mclk xckg_d2 0.0826f
C1254 vref VSUBS 0.209f
C1255 vref_in VSUBS 0.265f
C1256 xckg_d1 VSUBS 0.158f
C1257 sar_mclk sar_mclk 0.123f
C1258 xckg_d1 VSUBS 0.109f
C1259 xref_ng xcbiasn_xrb_s2 0.0672f
C1260 vref VSUBS 0.092f
C1261 xckg_d0 VSUBS 0.13f
C1262 xcbiasn_xrb_s1 xckg_x 0.364f
C1263 vss VSUBS 0.202f
C1264 xckg_d3 VSUBS 0.487f
C1265 vref xcbias_xrb_s1 0.106f
C1266 xckg_d2 VSUBS 0.171f
C1267 sar_mclk xckg_d2 0.228f
C1268 vss VSUBS 0.0789f
C1269 vbp VSUBS 0.0379f
C1270 vbp VSUBS 0.203f
C1271 xcbiasn_xrb_s3 VSUBS 0.103f
C1272 vdd VSUBS 0.125f
C1273 xckg_d1 VSUBS 0.306f
C1274 vss VSUBS 0.477f
C1275 xref_na xref_ng 0.328f
C1276 xcbias_xrb_s3 VSUBS 0.502f
C1277 xcbiasn_xrb_s1 xckg_d1 0.327f
C1278 xref_ntl VSUBS 0.11f
C1279 xckg_d3 VSUBS 0.198f
C1280 xref_ntl xckg_nn 0.531f
C1281 xckg_d3 VSUBS 0.494f
C1282 xcbias_xrb_s1 xref_ng 0.133f
C1283 vdd VSUBS 0.129f
C1284 xckg_x VSUBS 0.529f
C1285 clk VSUBS 0.155f
C1286 ibias xcbiasn_xrb_s2 0.259f
C1287 clk VSUBS 0.152f
C1288 xckg_d3 xref_ng 0.0804f
C1289 xcbias_xrb_s2 VSUBS 0.0571f
C1290 vref VSUBS 0.041f
C1291 vss xckg_d3 0.13f
C1292 vbp vbn 0.0702f
C1293 xckg_x xref_na 0.0417f
C1294 vdda vdda 0.14f
C1295 xckg_d0 vbp 0.159f
C1296 xref_na VSUBS 0.102f
C1297 vdda VSUBS 0.0869f
C1298 vref_in VSUBS 0.214f
C1299 vrefl VSUBS 0.717f
C1300 xcbias_xrb_s3 VSUBS 0.0296f
C1301 vdda xcbiasn_xrb_s3 0.501f
C1302 sar_mclk VSUBS 0.21f
C1303 xref_na xcbiasn_xrb_s2 0.707f
C1304 xckg_d0 clk 0.0905f
C1305 xcbias_xrb_s1 VSUBS 0.347f
C1306 vdd sar_mclk 0.258f
C1307 xref_na vref_in 0.581f
C1308 xcbias_xrb_s3 xcbias_xrb_s3 0.223f
C1309 xcbias_xrb_s3 xckg_nn 0.258f
C1310 xcbiasn_xrb_s2 VSUBS 0.512f
C1311 clk vref_in 0.287f
C1312 xckg_d0 xref_na 0.0843f
C1313 xckg_d1 VSUBS 0.197f
C1314 xckg_d3 VSUBS 0.112f
C1315 vdd VSUBS 0.0497f
C1316 xckg_nn xcbiasn_xrb_s3 0.0841f
C1317 vdd VSUBS 0.295f
C1318 vdd xcbiasn_xrb_s2 0.137f
C1319 vdda VSUBS 0.233f
C1320 vdda VSUBS 0.195f
C1321 xckg_d2 VSUBS 0.491f
C1322 xref_na xckg_x 0.244f
C1323 xckg_nn xckg_d1 0.224f
C1324 vdd xckg_x 0.0861f
C1325 xcbiasn_xrb_s2 VSUBS 0.256f
C1326 xcbias_xrb_s2 vref 0.158f
C1327 vbp mclkb 0.212f
C1328 xref_na VSUBS 0.254f
C1329 xref_na VSUBS 0.232f
C1330 xcbiasn_xrb_s3 vref 0.195f
C1331 vrefl VSUBS 0.0449f
C1332 ibias VSUBS 0.0485f
C1333 xckg_d2 VSUBS 0.144f
C1334 vbn xcbias_xrb_s2 0.372f
C1335 xcbias_xrb_s3 VSUBS 0.145f
C1336 vrefl VSUBS 0.186f
C1337 xref_ntl xcbiasn_xrb_s3 0.1f
C1338 xckg_d3 VSUBS 0.0982f
C1339 vdd xckg_x 0.14f
C1340 xcbiasn_xrb_s3 xckg_d1 0.475f
C1341 xref_na VSUBS 0.135f
C1342 sar_mclk VSUBS 0.204f
C1343 vref_in vref 0.176f
C1344 ibias VSUBS 0.611f
C1345 xckg_d2 xref_na 0.147f
C1346 vref_in VSUBS 0.15f
C1347 xckg_nn vref 0.403f
C1348 xref_ng xref_ng 0.058f
C1349 xckg_d2 VSUBS 0.0453f
C1350 xcbias_xrb_s3 xcbiasn_xrb_s3 0.253f
C1351 vbn VSUBS 0.485f
C1352 xcbiasn_xrb_s3 VSUBS 0.242f
C1353 xcbias_xrb_s3 xckg_d1 0.0212f
C1354 vref_in VSUBS 0.302f
C1355 vdda VSUBS 0.125f
C1356 xcbias_xrb_s2 VSUBS 0.217f
C1357 xckg_d0 xckg_d2 0.439f
C1358 xref_na xckg_d1 0.0444f
C1359 vref xref_ntl 0.0539f
C1360 xckg_nn VSUBS 0.303f
C1361 vdda VSUBS 0.171f
C1362 sar_mclk VSUBS 0.042f
C1363 vss VSUBS 0.215f
C1364 mclkb xref_na 0.0239f
C1365 xcbiasn_xrb_s2 VSUBS 0.0793f
C1366 vdd VSUBS 0.204f
C1367 clk VSUBS 0.0577f
C1368 xref_na VSUBS 0.267f
C1369 xcbias_xrb_s1 xref_ng 0.0547f
C1370 sar_mclk xckg_x 0.555f
C1371 vbn mclkb 0.194f
C1372 vref VSUBS 0.0975f
C1373 xcbiasn_xrb_s2 VSUBS 0.0916f
C1374 xckg_d3 clk 0.191f
C1375 vrefl VSUBS 0.0695f
C1376 xcbiasn_xrb_s3 VSUBS 0.0823f
C1377 vss xckg_d1 0.227f
C1378 vdda xckg_x 0.21f
C1379 xcbiasn_xrb_s1 xcbiasn_xrb_s1 0.358f
C1380 vref mclkb 0.139f
C1381 xckg_d3 VSUBS 0.156f
C1382 xcbiasn_xrb_s3 VSUBS 0.0287f
C1383 vbn VSUBS 0.382f
C1384 xckg_d2 vdda 0.458f
C1385 mclkb xcbiasn_xrb_s3 0.317f
C1386 vdd VSUBS 0.385f
C1387 xckg_nn VSUBS 0.126f
C1388 xcbiasn_xrb_s3 VSUBS 0.153f
C1389 xcbiasn_xrb_s3 VSUBS 0.0419f
C1390 xref_na vref 0.182f
C1391 vdd VSUBS 0.0469f
C1392 vss VSUBS 0.0959f
C1393 xref_ng vrefl 0.293f
C1394 xcbiasn_xrb_s3 VSUBS 0.254f
C1395 xref_ng xref_ntl 0.0709f
C1396 vbp xcbias_xrb_s1 0.16f
C1397 vbp VSUBS 0.115f
C1398 sar_mclk VSUBS 0.0982f
C1399 vrefl xckg_d0 0.18f
C1400 xckg_d2 VSUBS 0.164f
C1401 vbn VSUBS 0.338f
C1402 vdda VSUBS 0.421f
C1403 sar_mclk VSUBS 0.52f
C1404 xcbias_xrb_s1 xcbias_xrb_s2 0.237f
C1405 xref_na xckg_d3 0.13f
C1406 xref_ntl xcbias_xrb_s1 0.101f
C1407 xcbias_xrb_s3 VSUBS 0.165f
C1408 vbn VSUBS 0.181f
C1409 xckg_x VSUBS 0.0635f
C1410 xckg_d0 VSUBS 0.21f
C1411 xckg_nn VSUBS 0.0722f
C1412 xref_ng VSUBS 0.0181f
C1413 xckg_d0 xckg_d3 0.541f
C1414 xcbias_xrb_s3 xref_ntl 0.0487f
C1415 sar_mclk xcbias_xrb_s2 0.114f
C1416 xckg_d1 vrefl 0.173f
C1417 xcbias_xrb_s2 VSUBS 0.351f
C1418 xcbias_xrb_s1 VSUBS 0.265f
C1419 xckg_nn VSUBS 0.21f
C1420 vdda VSUBS 0.084f
C1421 xcbiasn_xrb_s2 VSUBS 0.0368f
C1422 vref_in VSUBS 0.417f
C1423 xref_na VSUBS 0.416f
C1424 vbn VSUBS 0.131f
C1425 xref_ng VSUBS 0.227f
C1426 xckg_x VSUBS 0.154f
C1427 xcbias_xrb_s2 VSUBS 0.115f
C1428 xckg_d2 VSUBS 0.134f
C1429 xcbiasn_xrb_s3 VSUBS 0.368f
C1430 xref_ntl xckg_d3 0.251f
C1431 xref_ntl xref_ntl 0.122f
C1432 xckg_nn VSUBS 0.174f
C1433 xckg_d3 VSUBS 0.081f
C1434 vbp VSUBS 0.18f
C1435 xref_na xckg_d2 0.0276f
C1436 xcbiasn_xrb_s1 VSUBS 0.108f
C1437 vdda xcbiasn_xrb_s3 0.152f
C1438 xckg_x VSUBS 0.0417f
C1439 xcbiasn_xrb_s3 VSUBS 0.115f
C1440 mclkb VSUBS 0.0607f
C1441 vref_in VSUBS 0.149f
C1442 xref_ng mclkb 0.151f
C1443 vbn VSUBS 0.346f
C1444 xcbiasn_xrb_s2 VSUBS 0.0972f
C1445 vss xref_na 0.11f
C1446 xcbias_xrb_s1 vrefl 0.406f
C1447 xckg_x xckg_d2 0.488f
C1448 vbn VSUBS 0.314f
C1449 vdda VSUBS 0.176f
C1450 clk xcbiasn_xrb_s3 0.263f
C1451 xcbias_xrb_s1 VSUBS 0.198f
C1452 sar_mclk vbp 0.239f
C1453 xckg_d1 VSUBS 0.0651f
C1454 vdda VSUBS 0.431f
C1455 vdda VSUBS 0.252f
C1456 vbn clk 0.126f
C1457 xckg_x VSUBS 0.121f
C1458 xcbiasn_xrb_s1 xref_na 0.0829f
C1459 xckg_x VSUBS 0.0272f
C1460 mclkb vrefl 0.102f
C1461 vss vref 0.0584f
C1462 xckg_nn VSUBS 0.183f
C1463 xcbiasn_xrb_s1 xckg_d3 0.257f
C1464 xref_ng vbp 0.0372f
C1465 xref_na VSUBS 0.166f
C1466 xref_ng xcbias_xrb_s3 0.218f
C1467 xref_ntl VSUBS 0.0605f
C1468 xcbias_xrb_s2 xckg_d3 0.252f
C1469 xcbias_xrb_s2 VSUBS 0.261f
C1470 xckg_d3 VSUBS 0.274f
C1471 xcbias_xrb_s1 xcbiasn_xrb_s1 0.485f
C1472 xcbiasn_xrb_s2 VSUBS 0.24f
C1473 xcbiasn_xrb_s3 VSUBS 0.572f
C1474 xcbias_xrb_s3 VSUBS 0.268f
C1475 vref_in xcbias_xrb_s3 0.164f
C1476 mclkb xckg_d0 0.116f
C1477 vss VSUBS 0.224f
C1478 xref_ntl VSUBS 0.233f
C1479 mclkb vbn 0.104f
C1480 mclkb xckg_d1 0.244f
C1481 vref_in VSUBS 0.127f
C1482 xcbias_xrb_s3 VSUBS 0.0631f
C1483 vdda xcbiasn_xrb_s2 0.0549f
C1484 clk xckg_d2 0.134f
C1485 xref_ntl xcbiasn_xrb_s2 0.129f
C1486 vbp VSUBS 0.199f
C1487 xref_ntl VSUBS 0.145f
C1488 vbp VSUBS 0.0567f
C1489 xckg_nn xckg_d0 0.11f
C1490 vref_in xcbias_xrb_s2 0.785f
C1491 xcbiasn_xrb_s1 VSUBS 0.121f
C1492 mclkb VSUBS 0.147f
C1493 vref_in VSUBS 0.113f
C1494 xckg_nn vdda 0.14f
C1495 ibias VSUBS 0.264f
C1496 vbp VSUBS 0.0222f
C1497 vss VSUBS 0.21f
C1498 vref vref 0.0727f
C1499 sar_mclk ibias 0.246f
C1500 xref_ntl VSUBS 0.0976f
C1501 vdd VSUBS 0.0393f
C1502 xckg_x vrefl 0.223f
C1503 clk VSUBS 0.101f
C1504 xcbias_xrb_s2 xref_ng 0.152f
C1505 xckg_d1 VSUBS 0.126f
C1506 xckg_d0 xref_na 0.35f
C1507 xckg_d1 VSUBS 0.218f
C1508 vbn VSUBS 0.085f
C1509 xckg_x xcbias_xrb_s1 0.135f
C1510 vdd VSUBS 0.368f
C1511 xckg_x VSUBS 0.104f
C1512 vss VSUBS 0.431f
C1513 xref_na VSUBS 0.264f
C1514 vrefl VSUBS 0.506f
C1515 xcbiasn_xrb_s3 xcbias_xrb_s1 0.328f
C1516 sar_mclk xckg_d1 0.126f
C1517 vref VSUBS 0.113f
C1518 vref VSUBS 0.221f
C1519 mclkb VSUBS 0.183f
C1520 vdda vbp 0.188f
C1521 sar_mclk VSUBS 0.146f
C1522 xckg_d2 VSUBS 0.259f
C1523 xckg_d3 VSUBS 0.411f
C1524 vss VSUBS 0.0428f
C1525 vbn xckg_d0 0.0707f
C1526 xckg_nn VSUBS 0.158f
C1527 sar_mclk VSUBS 0.0965f
C1528 vss VSUBS 0.167f
C1529 xcbias_xrb_s2 VSUBS 0.235f
C1530 xcbias_xrb_s3 VSUBS 0.175f
C1531 sar_mclk VSUBS 0.203f
C1532 xref_na VSUBS 0.451f
C1533 xcbias_xrb_s1 VSUBS 0.182f
C1534 vdda xref_ntl 0.0379f
C1535 vrefl VSUBS 0.0903f
C1536 xref_ntl VSUBS 0.663f
C1537 xcbias_xrb_s2 vrefl 0.178f
C1538 vdd xref_na 0.158f
C1539 xcbias_xrb_s1 VSUBS 0.184f
C1540 xref_ng VSUBS 0.203f
C1541 vdda VSUBS 0.0758f
C1542 vdda vrefl 0.0694f
C1543 vdd VSUBS 0.801f
C1544 xckg_x vrefl 0.237f
C1545 sar_mclk vref_in 0.61f
C1546 xckg_d2 VSUBS 0.229f
C1547 xckg_d2 VSUBS 0.218f
C1548 vrefl VSUBS 0.0421f
C1549 xcbiasn_xrb_s3 VSUBS 0.241f
C1550 ibias VSUBS 0.0429f
C1551 vref xckg_x 0.228f
C1552 xref_ng xcbias_xrb_s3 0.131f
C1553 ibias VSUBS 0.171f
C1554 xckg_d3 VSUBS 0.199f
C1555 xckg_x VSUBS 0.146f
C1556 vdd VSUBS 0.317f
C1557 xcbiasn_xrb_s1 VSUBS 0.132f
C1558 vref_in VSUBS 0.155f
C1559 xckg_d3 xcbias_xrb_s1 0.317f
C1560 xckg_d3 VSUBS 0.0763f
C1561 xckg_d0 VSUBS 0.0573f
C1562 vdd VSUBS 0.158f
C1563 xref_na vref 0.0795f
C1564 clk VSUBS 0.14f
C1565 xckg_nn VSUBS 0.142f
C1566 vdd VSUBS 0.127f
C1567 xckg_d2 vbn 0.136f
C1568 ibias sar_mclk 0.356f
C1569 vref VSUBS 1.34f
C1570 xcbias_xrb_s1 mclkb 0.237f
C1571 xckg_d3 xckg_d1 0.166f
C1572 sar_mclk VSUBS 0.176f
C1573 vbp xcbias_xrb_s3 0.151f
C1574 xckg_d0 VSUBS 0.0715f
C1575 xcbias_xrb_s3 xckg_d3 0.209f
C1576 vbn VSUBS 0.0757f
C1577 vrefl VSUBS 1.12f
C1578 sar_mclk VSUBS 0.121f
C1579 xref_ng VSUBS 0.385f
C1580 vss VSUBS 0.235f
C1581 sar_mclk VSUBS 0.172f
C1582 vrefl vbp 0.0856f
C1583 xref_na xckg_x 0.274f
C1584 vrefl VSUBS 0.906f
C1585 vrefl VSUBS 0.187f
C1586 xref_ntl VSUBS 0.018f
C1587 xckg_d2 VSUBS 0.286f
C1588 xref_ng xckg_nn 0.0756f
C1589 xref_ntl VSUBS 0.27f
C1590 vbp VSUBS 0.0778f
C1591 vdd VSUBS 0.122f
C1592 xckg_d2 VSUBS 0.53f
C1593 xckg_d0 VSUBS 0.0447f
C1594 xref_ng VSUBS 0.0704f
C1595 xckg_d3 VSUBS 0.179f
C1596 mclkb VSUBS 0.0752f
C1597 vref ibias 0.0729f
C1598 xckg_d3 VSUBS 0.104f
C1599 vbn vbp 0.115f
C1600 clk VSUBS 0.133f
C1601 vdda vrefl 0.232f
C1602 vref clk 0.115f
C1603 xckg_d2 xckg_d2 0.03f
C1604 xcbiasn_xrb_s3 xckg_d1 0.175f
C1605 vbp VSUBS 0.0521f
C1606 vref_in VSUBS 0.141f
C1607 xcbias_xrb_s1 VSUBS 0.143f
C1608 xref_ntl VSUBS 0.0813f
C1609 vdda VSUBS 0.0415f
C1610 xcbiasn_xrb_s3 VSUBS 0.134f
C1611 vref xckg_d2 0.984f
C1612 xref_ntl sar_mclk 0.119f
C1613 clk VSUBS 0.124f
C1614 xcbias_xrb_s2 VSUBS 0.135f
C1615 xckg_d2 VSUBS 0.423f
C1616 vref_in VSUBS 0.12f
C1617 xcbias_xrb_s2 VSUBS 0.101f
C1618 xckg_d2 xref_ntl 0.0344f
C1619 mclkb xckg_d0 0.14f
C1620 mclkb VSUBS 0.057f
C1621 xcbias_xrb_s3 VSUBS 0.105f
C1622 mclkb VSUBS 0.162f
C1623 xckg_d2 VSUBS 0.511f
C1624 vdda VSUBS 0.0819f
C1625 vdda VSUBS 0.0514f
C1626 xcbias_xrb_s2 VSUBS 0.144f
C1627 vrefl VSUBS 0.0612f
C1628 vbn VSUBS 0.718f
C1629 vrefl VSUBS 0.192f
C1630 xref_ng VSUBS 0.0947f
C1631 xckg_d1 VSUBS 0.131f
C1632 xcbias_xrb_s3 VSUBS 0.0189f
C1633 clk xckg_nn 0.392f
C1634 xckg_d1 vref 0.117f
C1635 xckg_nn VSUBS 0.283f
C1636 sar_mclk vbp 0.0973f
C1637 vbp VSUBS 0.139f
C1638 vbp VSUBS 0.337f
C1639 clk xref_ntl 0.821f
C1640 xcbiasn_xrb_s2 VSUBS 0.348f
C1641 xcbiasn_xrb_s1 VSUBS 0.0259f
C1642 xckg_x VSUBS 0.121f
C1643 xcbias_xrb_s2 VSUBS 0.266f
C1644 sar_mclk VSUBS 0.0801f
C1645 sar_mclk mclkb 0.086f
C1646 xcbiasn_xrb_s3 VSUBS 0.145f
C1647 vss xref_ng 0.0649f
C1648 xckg_d0 vdd 0.18f
C1649 xref_ng VSUBS 0.135f
C1650 xcbiasn_xrb_s3 xcbiasn_xrb_s3 0.126f
C1651 xcbiasn_xrb_s3 VSUBS 0.468f
C1652 xref_ntl xcbiasn_xrb_s3 0.2f
C1653 vbn xckg_d3 0.498f
C1654 xckg_d0 VSUBS 0.237f
C1655 xref_ntl VSUBS 0.238f
C1656 vss VSUBS 0.176f
C1657 vbn VSUBS 0.169f
C1658 sar_mclk VSUBS 0.195f
C1659 vref_in xref_ntl 0.0681f
C1660 xref_na xcbiasn_xrb_s2 0.294f
C1661 vref VSUBS 0.16f
C1662 xckg_d2 VSUBS 0.0404f
C1663 xckg_x VSUBS 0.107f
C1664 vbn VSUBS 0.273f
C1665 xckg_d3 xcbias_xrb_s3 0.217f
C1666 vdd VSUBS 0.0499f
C1667 sar_mclk VSUBS 0.0822f
C1668 vdd VSUBS 0.675f
C1669 xref_ntl VSUBS 0.368f
C1670 ibias VSUBS 0.266f
C1671 xckg_d3 xckg_x 0.137f
C1672 xcbias_xrb_s2 xref_na 0.221f
C1673 ibias VSUBS 0.128f
C1674 ibias xckg_d1 0.123f
C1675 xref_ng vref_in 0.069f
C1676 vdd xref_ng 0.0784f
C1677 xckg_d0 xckg_nn 0.227f
C1678 xref_ng xckg_x 0.0527f
C1679 vref_in xref_ng 0.0431f
C1680 mclkb VSUBS 0.266f
C1681 vss VSUBS 0.0842f
C1682 xref_ntl xref_na 0.032f
C1683 xcbias_xrb_s3 VSUBS 0.269f
C1684 vdda mclkb 0.439f
C1685 xckg_nn VSUBS 0.141f
C1686 vref_in VSUBS 0.241f
C1687 xckg_nn xcbias_xrb_s1 0.0926f
C1688 vref VSUBS 0.164f
C1689 vbp ibias 0.0765f
C1690 xref_ng xref_ng 0.0801f
C1691 xcbias_xrb_s2 xref_ntl 0.219f
C1692 xcbiasn_xrb_s2 VSUBS 0.317f
C1693 xcbias_xrb_s1 VSUBS 0.126f
C1694 mclkb xcbias_xrb_s1 0.648f
C1695 xcbiasn_xrb_s2 VSUBS 0.13f
C1696 vdda vref 0.201f
C1697 xckg_d1 xcbias_xrb_s3 0.174f
C1698 clk xcbiasn_xrb_s2 0.434f
C1699 vdd VSUBS 0.0992f
C1700 xref_ntl VSUBS 0.12f
C1701 xckg_x VSUBS 0.172f
C1702 xcbiasn_xrb_s3 VSUBS 0.161f
C1703 mclkb VSUBS 0.0619f
C1704 xcbiasn_xrb_s1 VSUBS 0.201f
C1705 vss vref 0.0325f
C1706 xcbias_xrb_s2 VSUBS 0.0879f
C1707 xckg_d2 VSUBS 0.113f
C1708 xckg_d0 VSUBS 0.215f
C1709 xcbias_xrb_s2 VSUBS 0.131f
C1710 clk VSUBS 0.176f
C1711 vdd vbp 0.196f
C1712 xcbiasn_xrb_s3 vref_in 0.417f
C1713 sar_mclk VSUBS 0.159f
C1714 xcbiasn_xrb_s1 VSUBS 0.024f
C1715 xcbias_xrb_s1 VSUBS 0.0541f
C1716 ibias xckg_x 0.32f
C1717 mclkb mclkb 0.0739f
C1718 ibias VSUBS 0.0693f
C1719 clk VSUBS 0.0568f
C1720 sar_mclk clk 0.148f
C1721 mclkb VSUBS 0.149f
C1722 xckg_d0 VSUBS 0.259f
C1723 xckg_nn xckg_d0 0.278f
C1724 vdda VSUBS 0.0721f
C1725 vref_in xckg_nn 0.0671f
C1726 ibias VSUBS 0.0622f
C1727 vdd VSUBS 0.19f
C1728 clk VSUBS 0.139f
C1729 xckg_nn VSUBS 0.0187f
C1730 xcbiasn_xrb_s1 VSUBS 0.062f
C1731 xref_ng clk 0.46f
C1732 xref_ntl xref_ng 0.0772f
C1733 vbn xcbias_xrb_s1 0.108f
C1734 xref_ng VSUBS 0.559f
C1735 clk xckg_nn 0.13f
C1736 vbn VSUBS 0.12f
C1737 xckg_nn VSUBS 0.248f
C1738 ibias VSUBS 0.38f
C1739 vbn VSUBS 0.232f
C1740 xcbias_xrb_s3 VSUBS 0.123f
C1741 xcbiasn_xrb_s1 VSUBS 0.167f
C1742 xref_na VSUBS 0.179f
C1743 xcbiasn_xrb_s3 VSUBS 0.0382f
C1744 xckg_d2 VSUBS 0.257f
C1745 xref_ng VSUBS 0.164f
C1746 xckg_d1 xcbias_xrb_s1 0.303f
C1747 mclkb VSUBS 0.811f
C1748 vdd xref_ntl 0.161f
C1749 xckg_d3 vref_in 0.385f
C1750 xcbias_xrb_s3 VSUBS 0.0786f
C1751 xckg_x VSUBS 0.0647f
C1752 xcbias_xrb_s3 VSUBS 0.0854f
C1753 xcbiasn_xrb_s2 VSUBS 0.0326f
C1754 clk xcbias_xrb_s2 0.178f
C1755 vbn VSUBS 0.135f
C1756 vref_in VSUBS 0.256f
C1757 xckg_nn ibias 0.0518f
C1758 vref_in VSUBS 0.0923f
C1759 xref_na VSUBS 0.322f
C1760 vss VSUBS 0.24f
C1761 vdda VSUBS 0.0416f
C1762 xckg_d2 VSUBS 0.18f
C1763 vdda VSUBS 0.175f
C1764 clk xckg_x 0.0863f
C1765 xref_ng VSUBS 0.101f
C1766 xckg_nn xref_ng 0.201f
C1767 xcbiasn_xrb_s3 VSUBS 0.726f
C1768 vref_in VSUBS 0.0846f
C1769 xcbiasn_xrb_s1 VSUBS 0.397f
C1770 ibias xref_na 0.237f
C1771 vbn vref 0.165f
C1772 xcbiasn_xrb_s2 xref_na 0.3f
C1773 xref_ng xcbiasn_xrb_s2 0.373f
C1774 clk xcbiasn_xrb_s3 0.245f
C1775 xckg_d2 xcbias_xrb_s3 0.387f
C1776 xcbias_xrb_s3 xref_na 0.104f
C1777 vref_in xckg_d2 0.219f
C1778 vbp VSUBS 2.22f
C1779 vdd xcbias_xrb_s1 0.0343f
C1780 xcbiasn_xrb_s3 VSUBS 0.0769f
C1781 vss VSUBS 0.135f
C1782 xcbias_xrb_s3 VSUBS 0.0298f
C1783 xcbiasn_xrb_s3 xcbiasn_xrb_s3 0.2f
C1784 vrefl xckg_nn 0.131f
C1785 xref_na VSUBS 0.144f
C1786 xcbiasn_xrb_s1 VSUBS 0.365f
C1787 xcbias_xrb_s3 VSUBS 0.43f
C1788 xckg_d3 VSUBS 0.087f
C1789 xckg_nn VSUBS 0.21f
C1790 mclkb mclkb 0.119f
C1791 xcbiasn_xrb_s1 vref 1.14f
C1792 ibias vref_in 0.355f
C1793 vbp VSUBS 0.0532f
C1794 mclkb VSUBS 0.191f
C1795 sar_mclk VSUBS 0.278f
C1796 xckg_d0 VSUBS 0.122f
C1797 vbn vdd 0.33f
C1798 vdda VSUBS 0.327f
C1799 xcbiasn_xrb_s3 VSUBS 0.0608f
C1800 vrefl xckg_d0 0.0558f
C1801 xcbias_xrb_s1 xref_ng 0.149f
C1802 vref_in VSUBS 0.0396f
C1803 vref VSUBS 0.0449f
C1804 xckg_d3 VSUBS 0.165f
C1805 xckg_d3 VSUBS 0.0939f
C1806 vref xckg_nn 0.413f
C1807 ibias xcbiasn_xrb_s2 0.0711f
C1808 vrefl VSUBS 0.0708f
C1809 xckg_x VSUBS 0.349f
C1810 xcbiasn_xrb_s3 VSUBS 0.123f
C1811 xckg_d3 vref_in 0.214f
C1812 xref_ntl VSUBS 0.281f
C1813 vbp VSUBS 0.0763f
C1814 vdda VSUBS 0.0938f
C1815 ibias xcbiasn_xrb_s1 0.038f
C1816 xref_ntl sar_mclk 0.249f
C1817 xckg_d3 xcbias_xrb_s2 0.208f
C1818 xcbiasn_xrb_s2 VSUBS 0.195f
C1819 vref_in VSUBS 0.256f
C1820 xckg_x VSUBS 0.254f
C1821 xckg_d1 clk 0.137f
C1822 ibias VSUBS 0.099f
C1823 xcbias_xrb_s2 vdda 0.104f
C1824 xcbiasn_xrb_s3 VSUBS 0.0604f
C1825 xcbiasn_xrb_s2 vbn 0.0674f
C1826 xcbiasn_xrb_s1 VSUBS 0.0747f
C1827 xcbiasn_xrb_s2 xcbiasn_xrb_s1 0.191f
C1828 vss xckg_x 0.117f
C1829 xcbias_xrb_s2 VSUBS 0.214f
C1830 sar_mclk xcbiasn_xrb_s2 0.0602f
C1831 xcbias_xrb_s2 VSUBS 0.193f
C1832 xref_ng VSUBS 0.0411f
C1833 vdd VSUBS 0.203f
C1834 xref_na VSUBS 0.226f
C1835 vrefl vrefl 0.237f
C1836 xckg_d0 xref_ntl 0.124f
C1837 xref_na xcbiasn_xrb_s2 0.256f
C1838 vref_in VSUBS 0.0856f
C1839 sar_mclk VSUBS 0.205f
C1840 vbn VSUBS 0.425f
C1841 xckg_nn VSUBS 0.0806f
C1842 xref_ntl VSUBS 0.0981f
C1843 vdd vbp 0.221f
C1844 mclkb xckg_d0 0.179f
C1845 xckg_d2 VSUBS 0.582f
C1846 ibias xcbiasn_xrb_s1 1.04f
C1847 vref_in xckg_x 0.543f
C1848 xckg_d2 VSUBS 0.118f
C1849 xcbias_xrb_s2 ibias 0.227f
C1850 xcbiasn_xrb_s2 vref_in 0.644f
C1851 xcbias_xrb_s1 vbn 0.165f
C1852 clk VSUBS 0.0881f
C1853 vbp VSUBS 0.193f
C1854 vbn VSUBS 0.154f
C1855 vss xcbias_xrb_s3 0.223f
C1856 xref_na clk 0.141f
C1857 vref vbn 0.0944f
C1858 xcbiasn_xrb_s3 VSUBS 0.194f
C1859 xref_ntl vref 0.127f
C1860 xcbiasn_xrb_s2 mclkb 0.193f
C1861 xcbiasn_xrb_s1 xref_ntl 0.219f
C1862 mclkb VSUBS 0.0551f
C1863 xcbiasn_xrb_s3 VSUBS 0.288f
C1864 vbp VSUBS 0.191f
C1865 xckg_nn ibias 0.254f
C1866 xckg_d1 xcbias_xrb_s1 0.102f
C1867 vrefl VSUBS 0.317f
C1868 xcbiasn_xrb_s1 sar_mclk 0.222f
C1869 xckg_d0 xckg_d3 0.0945f
C1870 xcbias_xrb_s1 VSUBS 0.0994f
C1871 xckg_d3 VSUBS 0.134f
C1872 xckg_x xckg_d3 0.0166f
C1873 vref sar_mclk 0.157f
C1874 vbp VSUBS 0.199f
C1875 xcbiasn_xrb_s2 VSUBS 0.241f
C1876 xcbias_xrb_s2 VSUBS 0.114f
C1877 xref_ntl xcbiasn_xrb_s2 0.378f
C1878 xckg_d3 vdd 0.0664f
C1879 ibias xcbiasn_xrb_s3 0.0697f
C1880 sar_mclk VSUBS 0.0974f
C1881 vref_in xcbiasn_xrb_s2 0.286f
C1882 xcbiasn_xrb_s1 VSUBS 0.0765f
C1883 clk xckg_x 0.117f
C1884 xcbias_xrb_s3 VSUBS 0.296f
C1885 vdd xref_ng 0.19f
C1886 vref VSUBS 0.0352f
C1887 ibias VSUBS 0.121f
C1888 xcbias_xrb_s1 xcbias_xrb_s3 0.265f
C1889 ibias VSUBS 0.0966f
C1890 xckg_d3 VSUBS 0.0586f
C1891 clk VSUBS 0.141f
C1892 mclkb mclkb 0.0537f
C1893 xcbiasn_xrb_s3 VSUBS 0.205f
C1894 xckg_d3 VSUBS 0.0334f
C1895 clk VSUBS 0.0735f
C1896 vdda VSUBS 0.184f
C1897 xref_na VSUBS 0.268f
C1898 xcbiasn_xrb_s3 VSUBS 0.245f
C1899 vbn xref_na 0.457f
C1900 clk ibias 0.0885f
C1901 vrefl VSUBS 0.0819f
C1902 xckg_d0 VSUBS 0.2f
C1903 xcbiasn_xrb_s3 xref_na 1f
C1904 vdda VSUBS 0.132f
C1905 xcbias_xrb_s1 VSUBS 0.351f
C1906 xcbiasn_xrb_s1 VSUBS 0.147f
C1907 xckg_d0 xref_ng 0.773f
C1908 vref VSUBS 0.5f
C1909 xckg_d1 vref 0.0854f
C1910 xckg_d1 xckg_d3 0.142f
C1911 xckg_d1 VSUBS 0.182f
C1912 xckg_x ibias 0.255f
C1913 xckg_nn VSUBS 0.146f
C1914 xckg_x VSUBS 0.132f
C1915 xref_ng VSUBS 0.0365f
C1916 xcbiasn_xrb_s1 xcbiasn_xrb_s2 0.165f
C1917 xcbiasn_xrb_s3 VSUBS 0.163f
C1918 xckg_nn VSUBS 0.0927f
C1919 vrefl VSUBS 0.999f
C1920 vdd VSUBS 0.118f
C1921 xckg_nn VSUBS 0.229f
C1922 sar_mclk VSUBS 0.088f
C1923 xckg_d1 sar_mclk 0.0339f
C1924 ibias VSUBS 0.0674f
C1925 vrefl xckg_x 0.095f
C1926 vss VSUBS 0.159f
C1927 xckg_d0 xckg_x 0.572f
C1928 mclkb VSUBS 0.314f
C1929 xckg_x xref_ng 1.73f
C1930 xcbiasn_xrb_s1 xref_na 0.0381f
C1931 mclkb VSUBS 0.175f
C1932 xcbiasn_xrb_s2 VSUBS 0.0632f
C1933 vrefl VSUBS 0.0812f
C1934 xckg_d0 VSUBS 0.0478f
C1935 xref_ntl ibias 0.0831f
C1936 vdd xckg_nn 0.16f
C1937 xref_na xckg_nn 0.314f
C1938 xcbias_xrb_s2 xckg_nn 0.421f
C1939 xckg_x VSUBS 0.093f
C1940 vdd VSUBS 0.72f
C1941 vref_in VSUBS 0.247f
C1942 xcbiasn_xrb_s3 VSUBS 0.0702f
C1943 xckg_nn VSUBS 0.0653f
C1944 vref_in VSUBS 0.144f
C1945 xcbias_xrb_s1 vdd 0.282f
C1946 xref_na VSUBS 0.04f
C1947 xckg_d0 VSUBS 0.0758f
C1948 vref_in xckg_x 0.27f
C1949 xckg_x VSUBS 0.33f
C1950 xcbiasn_xrb_s1 vbn 0.33f
C1951 xref_ng VSUBS 0.208f
C1952 xcbiasn_xrb_s2 vdda 0.0484f
C1953 xcbiasn_xrb_s1 VSUBS 0.0917f
C1954 xcbias_xrb_s2 VSUBS 0.0824f
C1955 xckg_x VSUBS 0.586f
C1956 xckg_d1 VSUBS 0.247f
C1957 vbp VSUBS 0.22f
C1958 xckg_nn vbp 0.299f
C1959 xcbiasn_xrb_s1 VSUBS 0.0926f
C1960 vbn VSUBS 0.207f
C1961 vref ibias 0.371f
C1962 ibias xref_ng 0.175f
C1963 xcbiasn_xrb_s3 VSUBS 0.231f
C1964 mclkb vref 0.556f
C1965 vbp mclkb 0.226f
C1966 xckg_x VSUBS 0.114f
C1967 xcbias_xrb_s3 xckg_nn 0.139f
C1968 sar_mclk VSUBS 0.164f
C1969 xckg_d2 VSUBS 0.407f
C1970 mclkb vbn 0.627f
C1971 xcbiasn_xrb_s3 VSUBS 0.307f
C1972 xref_ntl clk 0.111f
C1973 sar_mclk xckg_d3 0.291f
C1974 sar_mclk VSUBS 0.102f
C1975 vref_in vdda 0.362f
C1976 mclkb VSUBS 0.0572f
C1977 vrefl VSUBS 0.0504f
C1978 xcbiasn_xrb_s1 vbp 0.314f
C1979 xckg_d1 xckg_d2 0.132f
C1980 xcbias_xrb_s3 VSUBS 0.583f
C1981 xref_ng xref_ntl 0.114f
C1982 xcbiasn_xrb_s1 VSUBS 0.149f
C1983 xckg_d2 VSUBS 0.0954f
C1984 xref_ng VSUBS 0.301f
C1985 xref_ng VSUBS 0.161f
C1986 xcbias_xrb_s1 xckg_x 0.0406f
C1987 vref_in mclkb 0.0638f
C1988 xcbiasn_xrb_s1 VSUBS 0.148f
C1989 clk xckg_d3 0.0476f
C1990 vref VSUBS 0.0598f
C1991 xcbiasn_xrb_s1 VSUBS 0.185f
C1992 vss VSUBS 0.149f
C1993 vss VSUBS 0.0724f
C1994 vbp VSUBS 0.191f
C1995 xcbias_xrb_s2 VSUBS 0.0617f
C1996 xref_ntl xref_na 0.352f
C1997 vbp VSUBS 0.17f
C1998 xcbias_xrb_s1 VSUBS 0.208f
C1999 xckg_d1 VSUBS 0.019f
Rl0_0 xckg_x lad0_0 15.8
Cl0_0 lad0_0 VSUBS 0.1f
Rl0_1 lad0_0 lad0_1 3.34
Cl0_1 lad0_1 VSUBS 0.1f
Rl0_2 lad0_1 lad0_2 7.83
Cl0_2 lad0_2 VSUBS 0.1f
Rl0_3 lad0_2 lad0_3 17.4
Cl0_3 lad0_3 VSUBS 0.1f
Rl0_4 lad0_3 lad0_4 1.91
Cl0_4 lad0_4 VSUBS 0.1f
Rl0_5 lad0_4 lad0_5 2.42
Cl0_5 lad0_5 VSUBS 0.1f
Rl0_6 lad0_5 lad0_6 5.31
Cl0_6 lad0_6 VSUBS 0.1f
Rl0_7 lad0_6 lad0_7 7.68
Cl0_7 lad0_7 VSUBS 0.1f
Rl0_8 lad0_7 lad0_8 12.5
Cl0_8 lad0_8 VSUBS 0.1f
Rl0_9 lad0_8 lad0_9 19.9
Cl0_9 lad0_9 VSUBS 0.1f
Rl1_0 xcbiasn_xrb_s1 lad1_0 19.4
Cl1_0 lad1_0 VSUBS 0.1f
Rl1_1 lad1_0 lad1_1 9.84
Cl1_1 lad1_1 VSUBS 0.1f
Rl1_2 lad1_1 lad1_2 3.76
Cl1_2 lad1_2 VSUBS 0.1f
Rl1_3 lad1_2 lad1_3 4.3
Cl1_3 lad1_3 VSUBS 0.1f
Rl1_4 lad1_3 lad1_4 13.5
Cl1_4 lad1_4 VSUBS 0.1f
Rl1_5 lad1_4 lad1_5 3.99
Cl1_5 lad1_5 VSUBS 0.1f
Rl1_6 lad1_5 lad1_6 7.94
Cl1_6 lad1_6 VSUBS 0.1f
Rl1_7 lad1_6 lad1_7 17
Cl1_7 lad1_7 VSUBS 0.1f
Rl1_8 lad1_7 lad1_8 11.6
Cl1_8 lad1_8 VSUBS 0.1f
Rl1_9 lad1_8 lad1_9 2.63
Cl1_9 lad1_9 VSUBS 0.1f
Rl2_0 xref_ng lad2_0 18.5
Cl2_0 lad2_0 VSUBS 0.1f
Rl2_1 lad2_0 lad2_1 12.2
Cl2_1 lad2_1 VSUBS 0.1f
Rl2_2 lad2_1 lad2_2 17.5
Cl2_2 lad2_2 VSUBS 0.1f
Rl2_3 lad2_2 lad2_3 16.1
Cl2_3 lad2_3 VSUBS 0.1f
Rl2_4 lad2_3 lad2_4 8.84
Cl2_4 lad2_4 VSUBS 0.1f
Rl2_5 lad2_4 lad2_5 16.5
Cl2_5 lad2_5 VSUBS 0.1f
Rl2_6 lad2_5 lad2_6 17.6
Cl2_6 lad2_6 VSUBS 0.1f
Rl2_7 lad2_6 lad2_7 8.04
Cl2_7 lad2_7 VSUBS 0.1f
Rl2_8 lad2_7 lad2_8 5.87
Cl2_8 lad2_8 VSUBS 0.1f
Rl2_9 lad2_8 lad2_9 8.77
Cl2_9 lad2_9 VSUBS 0.1f
Rl3_0 vref lad3_0 12.8
Cl3_0 lad3_0 VSUBS 0.1f
Rl3_1 lad3_0 lad3_1 10.1
Cl3_1 lad3_1 VSUBS 0.1f
Rl3_2 lad3_1 lad3_2 3.77
Cl3_2 lad3_2 VSUBS 0.1f
Rl3_3 lad3_2 lad3_3 19.5
Cl3_3 lad3_3 VSUBS 0.1f
Rl3_4 lad3_3 lad3_4 18
Cl3_4 lad3_4 VSUBS 0.1f
Rl3_5 lad3_4 lad3_5 17.8
Cl3_5 lad3_5 VSUBS 0.1f
Rl3_6 lad3_5 lad3_6 17.4
Cl3_6 lad3_6 VSUBS 0.1f
Rl3_7 lad3_6 lad3_7 4.66
Cl3_7 lad3_7 VSUBS 0.1f
Rl3_8 lad3_7 lad3_8 15
Cl3_8 lad3_8 VSUBS 0.1f
Rl3_9 lad3_8 lad3_9 9.22
Cl3_9 lad3_9 VSUBS 0.1f
Rl4_0 xcbiasn_xrb_s1 lad4_0 15.2
Cl4_0 lad4_0 VSUBS 0.1f
Rl4_1 lad4_0 lad4_1 14.7
Cl4_1 lad4_1 VSUBS 0.1f
Rl4_2 lad4_1 lad4_2 13.8
Cl4_2 lad4_2 VSUBS 0.1f
Rl4_3 lad4_2 lad4_3 10.7
Cl4_3 lad4_3 VSUBS 0.1f
Rl4_4 lad4_3 lad4_4 14.8
Cl4_4 lad4_4 VSUBS 0.1f
Rl4_5 lad4_4 lad4_5 11.9
Cl4_5 lad4_5 VSUBS 0.1f
Rl4_6 lad4_5 lad4_6 19.7
Cl4_6 lad4_6 VSUBS 0.1f
Rl4_7 lad4_6 lad4_7 3.58
Cl4_7 lad4_7 VSUBS 0.1f
Rl4_8 lad4_7 lad4_8 1.16
Cl4_8 lad4_8 VSUBS 0.1f
Rl4_9 lad4_8 lad4_9 7.01
Cl4_9 lad4_9 VSUBS 0.1f
Rl5_0 xckg_d0 lad5_0 7.61
Cl5_0 lad5_0 VSUBS 0.1f
Rl5_1 lad5_0 lad5_1 9.95
Cl5_1 lad5_1 VSUBS 0.1f
Rl5_2 lad5_1 lad5_2 11.1
Cl5_2 lad5_2 VSUBS 0.1f
Rl5_3 lad5_2 lad5_3 13.8
Cl5_3 lad5_3 VSUBS 0.1f
Rl5_4 lad5_3 lad5_4 16.3
Cl5_4 lad5_4 VSUBS 0.1f
Rl5_5 lad5_4 lad5_5 14.1
Cl5_5 lad5_5 VSUBS 0.1f
Rl5_6 lad5_5 lad5_6 7.37
Cl5_6 lad5_6 VSUBS 0.1f
Rl5_7 lad5_6 lad5_7 19.6
Cl5_7 lad5_7 VSUBS 0.1f
Rl5_8 lad5_7 lad5_8 2.01
Cl5_8 lad5_8 VSUBS 0.1f
Rl5_9 lad5_8 lad5_9 9.24
Cl5_9 lad5_9 VSUBS 0.1f
Rl6_0 xcbiasn_xrb_s3 lad6_0 17.2
Cl6_0 lad6_0 VSUBS 0.1f
Rl6_1 lad6_0 lad6_1 6.89
Cl6_1 lad6_1 VSUBS 0.1f
Rl6_2 lad6_1 lad6_2 9.07
Cl6_2 lad6_2 VSUBS 0.1f
Rl6_3 lad6_2 lad6_3 11.3
Cl6_3 lad6_3 VSUBS 0.1f
Rl6_4 lad6_3 lad6_4 9.5
Cl6_4 lad6_4 VSUBS 0.1f
Rl6_5 lad6_4 lad6_5 5.67
Cl6_5 lad6_5 VSUBS 0.1f
Rl6_6 lad6_5 lad6_6 19.9
Cl6_6 lad6_6 VSUBS 0.1f
Rl6_7 lad6_6 lad6_7 5.12
Cl6_7 lad6_7 VSUBS 0.1f
Rl6_8 lad6_7 lad6_8 17
Cl6_8 lad6_8 VSUBS 0.1f
Rl6_9 lad6_8 lad6_9 3.07
Cl6_9 lad6_9 VSUBS 0.1f
Rl7_0 xcbias_xrb_s3 lad7_0 7
Cl7_0 lad7_0 VSUBS 0.1f
Rl7_1 lad7_0 lad7_1 15.9
Cl7_1 lad7_1 VSUBS 0.1f
Rl7_2 lad7_1 lad7_2 15
Cl7_2 lad7_2 VSUBS 0.1f
Rl7_3 lad7_2 lad7_3 16.8
Cl7_3 lad7_3 VSUBS 0.1f
Rl7_4 lad7_3 lad7_4 14.1
Cl7_4 lad7_4 VSUBS 0.1f
Rl7_5 lad7_4 lad7_5 12.4
Cl7_5 lad7_5 VSUBS 0.1f
Rl7_6 lad7_5 lad7_6 18.3
Cl7_6 lad7_6 VSUBS 0.1f
Rl7_7 lad7_6 lad7_7 10.4
Cl7_7 lad7_7 VSUBS 0.1f
Rl7_8 lad7_7 lad7_8 16.2
Cl7_8 lad7_8 VSUBS 0.1f
Rl7_9 lad7_8 lad7_9 13.9
Cl7_9 lad7_9 VSUBS 0.1f
Rl8_0 xcbiasn_xrb_s2 lad8_0 1.94
Cl8_0 lad8_0 VSUBS 0.1f
Rl8_1 lad8_0 lad8_1 4.1
Cl8_1 lad8_1 VSUBS 0.1f
Rl8_2 lad8_1 lad8_2 18.8
Cl8_2 lad8_2 VSUBS 0.1f
Rl8_3 lad8_2 lad8_3 2.17
Cl8_3 lad8_3 VSUBS 0.1f
Rl8_4 lad8_3 lad8_4 16.2
Cl8_4 lad8_4 VSUBS 0.1f
Rl8_5 lad8_4 lad8_5 2.9
Cl8_5 lad8_5 VSUBS 0.1f
Rl8_6 lad8_5 lad8_6 19.1
Cl8_6 lad8_6 VSUBS 0.1f
Rl8_7 lad8_6 lad8_7 1.19
Cl8_7 lad8_7 VSUBS 0.1f
Rl8_8 lad8_7 lad8_8 7.66
Cl8_8 lad8_8 VSUBS 0.1f
Rl8_9 lad8_8 lad8_9 3.76
Cl8_9 lad8_9 VSUBS 0.1f
Rl9_0 clk lad9_0 2.3
Cl9_0 lad9_0 VSUBS 0.1f
Rl9_1 lad9_0 lad9_1 17.8
Cl9_1 lad9_1 VSUBS 0.1f
Rl9_2 lad9_1 lad9_2 19.2
Cl9_2 lad9_2 VSUBS 0.1f
Rl9_3 lad9_2 lad9_3 14.4
Cl9_3 lad9_3 VSUBS 0.1f
Rl9_4 lad9_3 lad9_4 9.91
Cl9_4 lad9_4 VSUBS 0.1f
Rl9_5 lad9_4 lad9_5 17.8
Cl9_5 lad9_5 VSUBS 0.1f
Rl9_6 lad9_5 lad9_6 10.1
Cl9_6 lad9_6 VSUBS 0.1f
Rl9_7 lad9_6 lad9_7 11.2
Cl9_7 lad9_7 VSUBS 0.1f
Rl9_8 lad9_7 lad9_8 15.8
Cl9_8 lad9_8 VSUBS 0.1f
Rl9_9 lad9_8 lad9_9 12.8
Cl9_9 lad9_9 VSUBS 0.1f
Rl10_0 vss lad10_0 17.7
Cl10_0 lad10_0 VSUBS 0.1f
Rl10_1 lad10_0 lad10_1 11.4
Cl10_1 lad10_1 VSUBS 0.1f
Rl10_2 lad10_1 lad10_2 11.6
Cl10_2 lad10_2 VSUBS 0.1f
Rl10_3 lad10_2 lad10_3 2.25
Cl10_3 lad10_3 VSUBS 0.1f
Rl10_4 lad10_3 lad10_4 2.41
Cl10_4 lad10_4 VSUBS 0.1f
Rl10_5 lad10_4 lad10_5 15.4
Cl10_5 lad10_5 VSUBS 0.1f
Rl10_6 lad10_5 lad10_6 12.9
Cl10_6 lad10_6 VSUBS 0.1f
Rl10_7 lad10_6 lad10_7 14.5
Cl10_7 lad10_7 VSUBS 0.1f
Rl10_8 lad10_7 lad10_8 14.5
Cl10_8 lad10_8 VSUBS 0.1f
Rl10_9 lad10_8 lad10_9 14
Cl10_9 lad10_9 VSUBS 0.1f
Rl11_0 xcbias_xrb_s1 lad11_0 19.4
Cl11_0 lad11_0 VSUBS 0.1f
Rl11_1 lad11_0 lad11_1 12.5
Cl11_1 lad11_1 VSUBS 0.1f
Rl11_2 lad11_1 lad11_2 12.7
Cl11_2 lad11_2 VSUBS 0.1f
Rl11_3 lad11_2 lad11_3 12.5
Cl11_3 lad11_3 VSUBS 0.1f
Rl11_4 lad11_3 lad11_4 5.76
Cl11_4 lad11_4 VSUBS 0.1f
Rl11_5 lad11_4 lad11_5 4.72
Cl11_5 lad11_5 VSUBS 0.1f
Rl11_6 lad11_5 lad11_6 10.3
Cl11_6 lad11_6 VSUBS 0.1f
Rl11_7 lad11_6 lad11_7 15.1
Cl11_7 lad11_7 VSUBS 0.1f
Rl11_8 lad11_7 lad11_8 18.6
Cl11_8 lad11_8 VSUBS 0.1f
Rl11_9 lad11_8 lad11_9 3.23
Cl11_9 lad11_9 VSUBS 0.1f
Rl12_0 mclkb lad12_0 14.1
Cl12_0 lad12_0 VSUBS 0.1f
Rl12_1 lad12_0 lad12_1 14.7
Cl12_1 lad12_1 VSUBS 0.1f
Rl12_2 lad12_1 lad12_2 4.56
Cl12_2 lad12_2 VSUBS 0.1f
Rl12_3 lad12_2 lad12_3 19.2
Cl12_3 lad12_3 VSUBS 0.1f
Rl12_4 lad12_3 lad12_4 3.22
Cl12_4 lad12_4 VSUBS 0.1f
Rl12_5 lad12_4 lad12_5 15.1
Cl12_5 lad12_5 VSUBS 0.1f
Rl12_6 lad12_5 lad12_6 1.7
Cl12_6 lad12_6 VSUBS 0.1f
Rl12_7 lad12_6 lad12_7 12.5
Cl12_7 lad12_7 VSUBS 0.1f
Rl12_8 lad12_7 lad12_8 5.02
Cl12_8 lad12_8 VSUBS 0.1f
Rl12_9 lad12_8 lad12_9 14.2
Cl12_9 lad12_9 VSUBS 0.1f
Rl13_0 xckg_nn lad13_0 19
Cl13_0 lad13_0 VSUBS 0.1f
Rl13_1 lad13_0 lad13_1 3.46
Cl13_1 lad13_1 VSUBS 0.1f
Rl13_2 lad13_1 lad13_2 15.1
Cl13_2 lad13_2 VSUBS 0.1f
Rl13_3 lad13_2 lad13_3 11.8
Cl13_3 lad13_3 VSUBS 0.1f
Rl13_4 lad13_3 lad13_4 17.6
Cl13_4 lad13_4 VSUBS 0.1f
Rl13_5 lad13_4 lad13_5 2.14
Cl13_5 lad13_5 VSUBS 0.1f
Rl13_6 lad13_5 lad13_6 4.95
Cl13_6 lad13_6 VSUBS 0.1f
Rl13_7 lad13_6 lad13_7 6.21
Cl13_7 lad13_7 VSUBS 0.1f
Rl13_8 lad13_7 lad13_8 1.21
Cl13_8 lad13_8 VSUBS 0.1f
Rl13_9 lad13_8 lad13_9 16.7
Cl13_9 lad13_9 VSUBS 0.1f
Rl14_0 xckg_nn lad14_0 13.9
Cl14_0 lad14_0 VSUBS 0.1f
Rl14_1 lad14_0 lad14_1 18.7
Cl14_1 lad14_1 VSUBS 0.1f
Rl14_2 lad14_1 lad14_2 7.95
Cl14_2 lad14_2 VSUBS 0.1f
Rl14_3 lad14_2 lad14_3 14.5
Cl14_3 lad14_3 VSUBS 0.1f
Rl14_4 lad14_3 lad14_4 19.8
Cl14_4 lad14_4 VSUBS 0.1f
Rl14_5 lad14_4 lad14_5 19.9
Cl14_5 lad14_5 VSUBS 0.1f
Rl14_6 lad14_5 lad14_6 5.74
Cl14_6 lad14_6 VSUBS 0.1f
Rl14_7 lad14_6 lad14_7 6.12
Cl14_7 lad14_7 VSUBS 0.1f
Rl14_8 lad14_7 lad14_8 13.8
Cl14_8 lad14_8 VSUBS 0.1f
Rl14_9 lad14_8 lad14_9 18.2
Cl14_9 lad14_9 VSUBS 0.1f
Rl15_0 xcbias_xrb_s1 lad15_0 10.9
Cl15_0 lad15_0 VSUBS 0.1f
Rl15_1 lad15_0 lad15_1 2.44
Cl15_1 lad15_1 VSUBS 0.1f
Rl15_2 lad15_1 lad15_2 15.8
Cl15_2 lad15_2 VSUBS 0.1f
Rl15_3 lad15_2 lad15_3 19.4
Cl15_3 lad15_3 VSUBS 0.1f
Rl15_4 lad15_3 lad15_4 18.2
Cl15_4 lad15_4 VSUBS 0.1f
Rl15_5 lad15_4 lad15_5 4.54
Cl15_5 lad15_5 VSUBS 0.1f
Rl15_6 lad15_5 lad15_6 4.38
Cl15_6 lad15_6 VSUBS 0.1f
Rl15_7 lad15_6 lad15_7 15.6
Cl15_7 lad15_7 VSUBS 0.1f
Rl15_8 lad15_7 lad15_8 11.4
Cl15_8 lad15_8 VSUBS 0.1f
Rl15_9 lad15_8 lad15_9 10.6
Cl15_9 lad15_9 VSUBS 0.1f
Rl16_0 xref_ntl lad16_0 6.2
Cl16_0 lad16_0 VSUBS 0.1f
Rl16_1 lad16_0 lad16_1 5.19
Cl16_1 lad16_1 VSUBS 0.1f
Rl16_2 lad16_1 lad16_2 11.9
Cl16_2 lad16_2 VSUBS 0.1f
Rl16_3 lad16_2 lad16_3 8.01
Cl16_3 lad16_3 VSUBS 0.1f
Rl16_4 lad16_3 lad16_4 3.66
Cl16_4 lad16_4 VSUBS 0.1f
Rl16_5 lad16_4 lad16_5 7.14
Cl16_5 lad16_5 VSUBS 0.1f
Rl16_6 lad16_5 lad16_6 11.6
Cl16_6 lad16_6 VSUBS 0.1f
Rl16_7 lad16_6 lad16_7 7.73
Cl16_7 lad16_7 VSUBS 0.1f
Rl16_8 lad16_7 lad16_8 3.56
Cl16_8 lad16_8 VSUBS 0.1f
Rl16_9 lad16_8 lad16_9 4.42
Cl16_9 lad16_9 VSUBS 0.1f
Rl17_0 vbn lad17_0 8.45
Cl17_0 lad17_0 VSUBS 0.1f
Rl17_1 lad17_0 lad17_1 9.67
Cl17_1 lad17_1 VSUBS 0.1f
Rl17_2 lad17_1 lad17_2 16.9
Cl17_2 lad17_2 VSUBS 0.1f
Rl17_3 lad17_2 lad17_3 12.7
Cl17_3 lad17_3 VSUBS 0.1f
Rl17_4 lad17_3 lad17_4 13.4
Cl17_4 lad17_4 VSUBS 0.1f
Rl17_5 lad17_4 lad17_5 6.14
Cl17_5 lad17_5 VSUBS 0.1f
Rl17_6 lad17_5 lad17_6 1.78
Cl17_6 lad17_6 VSUBS 0.1f
Rl17_7 lad17_6 lad17_7 5.3
Cl17_7 lad17_7 VSUBS 0.1f
Rl17_8 lad17_7 lad17_8 8.87
Cl17_8 lad17_8 VSUBS 0.1f
Rl17_9 lad17_8 lad17_9 3.19
Cl17_9 lad17_9 VSUBS 0.1f
Rl18_0 xckg_x lad18_0 18.6
Cl18_0 lad18_0 VSUBS 0.1f
Rl18_1 lad18_0 lad18_1 18.5
Cl18_1 lad18_1 VSUBS 0.1f
Rl18_2 lad18_1 lad18_2 10.2
Cl18_2 lad18_2 VSUBS 0.1f
Rl18_3 lad18_2 lad18_3 1.53
Cl18_3 lad18_3 VSUBS 0.1f
Rl18_4 lad18_3 lad18_4 19.4
Cl18_4 lad18_4 VSUBS 0.1f
Rl18_5 lad18_4 lad18_5 6.84
Cl18_5 lad18_5 VSUBS 0.1f
Rl18_6 lad18_5 lad18_6 13.7
Cl18_6 lad18_6 VSUBS 0.1f
Rl18_7 lad18_6 lad18_7 16.9
Cl18_7 lad18_7 VSUBS 0.1f
Rl18_8 lad18_7 lad18_8 18.2
Cl18_8 lad18_8 VSUBS 0.1f
Rl18_9 lad18_8 lad18_9 11.2
Cl18_9 lad18_9 VSUBS 0.1f
Rl19_0 xcbiasn_xrb_s2 lad19_0 1.87
Cl19_0 lad19_0 VSUBS 0.1f
Rl19_1 lad19_0 lad19_1 16.8
Cl19_1 lad19_1 VSUBS 0.1f
Rl19_2 lad19_1 lad19_2 8.64
Cl19_2 lad19_2 VSUBS 0.1f
Rl19_3 lad19_2 lad19_3 5.66
Cl19_3 lad19_3 VSUBS 0.1f
Rl19_4 lad19_3 lad19_4 3.91
Cl19_4 lad19_4 VSUBS 0.1f
Rl19_5 lad19_4 lad19_5 6.81
Cl19_5 lad19_5 VSUBS 0.1f
Rl19_6 lad19_5 lad19_6 3.13
Cl19_6 lad19_6 VSUBS 0.1f
Rl19_7 lad19_6 lad19_7 7.03
Cl19_7 lad19_7 VSUBS 0.1f
Rl19_8 lad19_7 lad19_8 18.5
Cl19_8 lad19_8 VSUBS 0.1f
Rl19_9 lad19_8 lad19_9 3.12
Cl19_9 lad19_9 VSUBS 0.1f
Rl20_0 vbp lad20_0 1.25
Cl20_0 lad20_0 VSUBS 0.1f
Rl20_1 lad20_0 lad20_1 3.15
Cl20_1 lad20_1 VSUBS 0.1f
Rl20_2 lad20_1 lad20_2 2.37
Cl20_2 lad20_2 VSUBS 0.1f
Rl20_3 lad20_2 lad20_3 11.7
Cl20_3 lad20_3 VSUBS 0.1f
Rl20_4 lad20_3 lad20_4 15.4
Cl20_4 lad20_4 VSUBS 0.1f
Rl20_5 lad20_4 lad20_5 13
Cl20_5 lad20_5 VSUBS 0.1f
Rl20_6 lad20_5 lad20_6 3.74
Cl20_6 lad20_6 VSUBS 0.1f
Rl20_7 lad20_6 lad20_7 17
Cl20_7 lad20_7 VSUBS 0.1f
Rl20_8 lad20_7 lad20_8 14.3
Cl20_8 lad20_8 VSUBS 0.1f
Rl20_9 lad20_8 lad20_9 19.4
Cl20_9 lad20_9 VSUBS 0.1f
Rl21_0 ibias lad21_0 14.3
Cl21_0 lad21_0 VSUBS 0.1f
Rl21_1 lad21_0 lad21_1 11.8
Cl21_1 lad21_1 VSUBS 0.1f
Rl21_2 lad21_1 lad21_2 10.9
Cl21_2 lad21_2 VSUBS 0.1f
Rl21_3 lad21_2 lad21_3 3.59
Cl21_3 lad21_3 VSUBS 0.1f
Rl21_4 lad21_3 lad21_4 3.73
Cl21_4 lad21_4 VSUBS 0.1f
Rl21_5 lad21_4 lad21_5 8.22
Cl21_5 lad21_5 VSUBS 0.1f
Rl21_6 lad21_5 lad21_6 19.8
Cl21_6 lad21_6 VSUBS 0.1f
Rl21_7 lad21_6 lad21_7 1.03
Cl21_7 lad21_7 VSUBS 0.1f
Rl21_8 lad21_7 lad21_8 9.05
Cl21_8 lad21_8 VSUBS 0.1f
Rl21_9 lad21_8 lad21_9 1.72
Cl21_9 lad21_9 VSUBS 0.1f
Rl22_0 xckg_d1 lad22_0 15.1
Cl22_0 lad22_0 VSUBS 0.1f
Rl22_1 lad22_0 lad22_1 10.4
Cl22_1 lad22_1 VSUBS 0.1f
Rl22_2 lad22_1 lad22_2 3.9
Cl22_2 lad22_2 VSUBS 0.1f
Rl22_3 lad22_2 lad22_3 18.5
Cl22_3 lad22_3 VSUBS 0.1f
Rl22_4 lad22_3 lad22_4 14.5
Cl22_4 lad22_4 VSUBS 0.1f
Rl22_5 lad22_4 lad22_5 5.57
Cl22_5 lad22_5 VSUBS 0.1f
Rl22_6 lad22_5 lad22_6 2.63
Cl22_6 lad22_6 VSUBS 0.1f
Rl22_7 lad22_6 lad22_7 1.82
Cl22_7 lad22_7 VSUBS 0.1f
Rl22_8 lad22_7 lad22_8 10.3
Cl22_8 lad22_8 VSUBS 0.1f
Rl22_9 lad22_8 lad22_9 6.2
Cl22_9 lad22_9 VSUBS 0.1f
Rl23_0 vref lad23_0 18.1
Cl23_0 lad23_0 VSUBS 0.1f
Rl23_1 lad23_0 lad23_1 1.49
Cl23_1 lad23_1 VSUBS 0.1f
Rl23_2 lad23_1 lad23_2 1.83
Cl23_2 lad23_2 VSUBS 0.1f
Rl23_3 lad23_2 lad23_3 15.8
Cl23_3 lad23_3 VSUBS 0.1f
Rl23_4 lad23_3 lad23_4 18.1
Cl23_4 lad23_4 VSUBS 0.1f
Rl23_5 lad23_4 lad23_5 14.6
Cl23_5 lad23_5 VSUBS 0.1f
Rl23_6 lad23_5 lad23_6 10.8
Cl23_6 lad23_6 VSUBS 0.1f
Rl23_7 lad23_6 lad23_7 15.2
Cl23_7 lad23_7 VSUBS 0.1f
Rl23_8 lad23_7 lad23_8 12.6
Cl23_8 lad23_8 VSUBS 0.1f
Rl23_9 lad23_8 lad23_9 13
Cl23_9 lad23_9 VSUBS 0.1f
Rl24_0 sar_mclk lad24_0 18.7
Cl24_0 lad24_0 VSUBS 0.1f
Rl24_1 lad24_0 lad24_1 10.3
Cl24_1 lad24_1 VSUBS 0.1f
Rl24_2 lad24_1 lad24_2 18.8
Cl24_2 lad24_2 VSUBS 0.1f
Rl24_3 lad24_2 lad24_3 9.6
Cl24_3 lad24_3 VSUBS 0.1f
Rl24_4 lad24_3 lad24_4 14.8
Cl24_4 lad24_4 VSUBS 0.1f
Rl24_5 lad24_4 lad24_5 11.6
Cl24_5 lad24_5 VSUBS 0.1f
Rl24_6 lad24_5 lad24_6 8.59
Cl24_6 lad24_6 VSUBS 0.1f
Rl24_7 lad24_6 lad24_7 16
Cl24_7 lad24_7 VSUBS 0.1f
Rl24_8 lad24_7 lad24_8 3.48
Cl24_8 lad24_8 VSUBS 0.1f
Rl24_9 lad24_8 lad24_9 7.45
Cl24_9 lad24_9 VSUBS 0.1f
Rl25_0 xckg_d0 lad25_0 15
Cl25_0 lad25_0 VSUBS 0.1f
Rl25_1 lad25_0 lad25_1 15.1
Cl25_1 lad25_1 VSUBS 0.1f
Rl25_2 lad25_1 lad25_2 1.94
Cl25_2 lad25_2 VSUBS 0.1f
Rl25_3 lad25_2 lad25_3 14.2
Cl25_3 lad25_3 VSUBS 0.1f
Rl25_4 lad25_3 lad25_4 6.02
Cl25_4 lad25_4 VSUBS 0.1f
Rl25_5 lad25_4 lad25_5 4.97
Cl25_5 lad25_5 VSUBS 0.1f
Rl25_6 lad25_5 lad25_6 18.8
Cl25_6 lad25_6 VSUBS 0.1f
Rl25_7 lad25_6 lad25_7 20
Cl25_7 lad25_7 VSUBS 0.1f
Rl25_8 lad25_7 lad25_8 14.1
Cl25_8 lad25_8 VSUBS 0.1f
Rl25_9 lad25_8 lad25_9 14
Cl25_9 lad25_9 VSUBS 0.1f
Rl26_0 vdd lad26_0 10.9
Cl26_0 lad26_0 VSUBS 0.1f
Rl26_1 lad26_0 lad26_1 2.54
Cl26_1 lad26_1 VSUBS 0.1f
Rl26_2 lad26_1 lad26_2 2.57
Cl26_2 lad26_2 VSUBS 0.1f
Rl26_3 lad26_2 lad26_3 8.25
Cl26_3 lad26_3 VSUBS 0.1f
Rl26_4 lad26_3 lad26_4 9.57
Cl26_4 lad26_4 VSUBS 0.1f
Rl26_5 lad26_4 lad26_5 4.81
Cl26_5 lad26_5 VSUBS 0.1f
Rl26_6 lad26_5 lad26_6 7.45
Cl26_6 lad26_6 VSUBS 0.1f
Rl26_7 lad26_6 lad26_7 11.1
Cl26_7 lad26_7 VSUBS 0.1f
Rl26_8 lad26_7 lad26_8 14.4
Cl26_8 lad26_8 VSUBS 0.1f
Rl26_9 lad26_8 lad26_9 15.8
Cl26_9 lad26_9 VSUBS 0.1f
Rl27_0 xckg_d2 lad27_0 5.6
Cl27_0 lad27_0 VSUBS 0.1f
Rl27_1 lad27_0 lad27_1 14.1
Cl27_1 lad27_1 VSUBS 0.1f
Rl27_2 lad27_1 lad27_2 17.2
Cl27_2 lad27_2 VSUBS 0.1f
Rl27_3 lad27_2 lad27_3 5.9
Cl27_3 lad27_3 VSUBS 0.1f
Rl27_4 lad27_3 lad27_4 8.71
Cl27_4 lad27_4 VSUBS 0.1f
Rl27_5 lad27_4 lad27_5 9.31
Cl27_5 lad27_5 VSUBS 0.1f
Rl27_6 lad27_5 lad27_6 15.2
Cl27_6 lad27_6 VSUBS 0.1f
Rl27_7 lad27_6 lad27_7 1.59
Cl27_7 lad27_7 VSUBS 0.1f
Rl27_8 lad27_7 lad27_8 3.44
Cl27_8 lad27_8 VSUBS 0.1f
Rl27_9 lad27_8 lad27_9 17.2
Cl27_9 lad27_9 VSUBS 0.1f
Rl28_0 xcbias_xrb_s1 lad28_0 1.03
Cl28_0 lad28_0 VSUBS 0.1f
Rl28_1 lad28_0 lad28_1 17.4
Cl28_1 lad28_1 VSUBS 0.1f
Rl28_2 lad28_1 lad28_2 13.3
Cl28_2 lad28_2 VSUBS 0.1f
Rl28_3 lad28_2 lad28_3 12
Cl28_3 lad28_3 VSUBS 0.1f
Rl28_4 lad28_3 lad28_4 15.3
Cl28_4 lad28_4 VSUBS 0.1f
Rl28_5 lad28_4 lad28_5 2.38
Cl28_5 lad28_5 VSUBS 0.1f
Rl28_6 lad28_5 lad28_6 2.09
Cl28_6 lad28_6 VSUBS 0.1f
Rl28_7 lad28_6 lad28_7 17
Cl28_7 lad28_7 VSUBS 0.1f
Rl28_8 lad28_7 lad28_8 12.5
Cl28_8 lad28_8 VSUBS 0.1f
Rl28_9 lad28_8 lad28_9 4.21
Cl28_9 lad28_9 VSUBS 0.1f
Rl29_0 vbp lad29_0 11.6
Cl29_0 lad29_0 VSUBS 0.1f
Rl29_1 lad29_0 lad29_1 6.63
Cl29_1 lad29_1 VSUBS 0.1f
Rl29_2 lad29_1 lad29_2 9
Cl29_2 lad29_2 VSUBS 0.1f
Rl29_3 lad29_2 lad29_3 10.6
Cl29_3 lad29_3 VSUBS 0.1f
Rl29_4 lad29_3 lad29_4 1.71
Cl29_4 lad29_4 VSUBS 0.1f
Rl29_5 lad29_4 lad29_5 6.66
Cl29_5 lad29_5 VSUBS 0.1f
Rl29_6 lad29_5 lad29_6 14.2
Cl29_6 lad29_6 VSUBS 0.1f
Rl29_7 lad29_6 lad29_7 7.77
Cl29_7 lad29_7 VSUBS 0.1f
Rl29_8 lad29_7 lad29_8 4.69
Cl29_8 lad29_8 VSUBS 0.1f
Rl29_9 lad29_8 lad29_9 1
Cl29_9 lad29_9 VSUBS 0.1f
Rl30_0 vdda lad30_0 15.7
Cl30_0 lad30_0 VSUBS 0.1f
Rl30_1 lad30_0 lad30_1 2.36
Cl30_1 lad30_1 VSUBS 0.1f
Rl30_2 lad30_1 lad30_2 12.1
Cl30_2 lad30_2 VSUBS 0.1f
Rl30_3 lad30_2 lad30_3 12.1
Cl30_3 lad30_3 VSUBS 0.1f
Rl30_4 lad30_3 lad30_4 14.9
Cl30_4 lad30_4 VSUBS 0.1f
Rl30_5 lad30_4 lad30_5 19.1
Cl30_5 lad30_5 VSUBS 0.1f
Rl30_6 lad30_5 lad30_6 13.1
Cl30_6 lad30_6 VSUBS 0.1f
Rl30_7 lad30_6 lad30_7 11.7
Cl30_7 lad30_7 VSUBS 0.1f
Rl30_8 lad30_7 lad30_8 6.35
Cl30_8 lad30_8 VSUBS 0.1f
Rl30_9 lad30_8 lad30_9 10.8
Cl30_9 lad30_9 VSUBS 0.1f
Rl31_0 vref lad31_0 8.92
Cl31_0 lad31_0 VSUBS 0.1f
Rl31_1 lad31_0 lad31_1 16
Cl31_1 lad31_1 VSUBS 0.1f
Rl31_2 lad31_1 lad31_2 1.42
Cl31_2 lad31_2 VSUBS 0.1f
Rl31_3 lad31_2 lad31_3 1.93
Cl31_3 lad31_3 VSUBS 0.1f
Rl31_4 lad31_3 lad31_4 4.58
Cl31_4 lad31_4 VSUBS 0.1f
Rl31_5 lad31_4 lad31_5 3.86
Cl31_5 lad31_5 VSUBS 0.1f
Rl31_6 lad31_5 lad31_6 5.27
Cl31_6 lad31_6 VSUBS 0.1f
Rl31_7 lad31_6 lad31_7 5.76
Cl31_7 lad31_7 VSUBS 0.1f
Rl31_8 lad31_7 lad31_8 12.1
Cl31_8 lad31_8 VSUBS 0.1f
Rl31_9 lad31_8 lad31_9 19.2
Cl31_9 lad31_9 VSUBS 0.1f
Rl32_0 vbp lad32_0 17.9
Cl32_0 lad32_0 VSUBS 0.1f
Rl32_1 lad32_0 lad32_1 18.6
Cl32_1 lad32_1 VSUBS 0.1f
Rl32_2 lad32_1 lad32_2 17.4
Cl32_2 lad32_2 VSUBS 0.1f
Rl32_3 lad32_2 lad32_3 17.1
Cl32_3 lad32_3 VSUBS 0.1f
Rl32_4 lad32_3 lad32_4 5.42
Cl32_4 lad32_4 VSUBS 0.1f
Rl32_5 lad32_4 lad32_5 9.99
Cl32_5 lad32_5 VSUBS 0.1f
Rl32_6 lad32_5 lad32_6 7.15
Cl32_6 lad32_6 VSUBS 0.1f
Rl32_7 lad32_6 lad32_7 16.1
Cl32_7 lad32_7 VSUBS 0.1f
Rl32_8 lad32_7 lad32_8 9.11
Cl32_8 lad32_8 VSUBS 0.1f
Rl32_9 lad32_8 lad32_9 12.7
Cl32_9 lad32_9 VSUBS 0.1f
Rl33_0 xcbiasn_xrb_s2 lad33_0 13.8
Cl33_0 lad33_0 VSUBS 0.1f
Rl33_1 lad33_0 lad33_1 11.7
Cl33_1 lad33_1 VSUBS 0.1f
Rl33_2 lad33_1 lad33_2 11.4
Cl33_2 lad33_2 VSUBS 0.1f
Rl33_3 lad33_2 lad33_3 12
Cl33_3 lad33_3 VSUBS 0.1f
Rl33_4 lad33_3 lad33_4 2.97
Cl33_4 lad33_4 VSUBS 0.1f
Rl33_5 lad33_4 lad33_5 2.36
Cl33_5 lad33_5 VSUBS 0.1f
Rl33_6 lad33_5 lad33_6 12.1
Cl33_6 lad33_6 VSUBS 0.1f
Rl33_7 lad33_6 lad33_7 4.68
Cl33_7 lad33_7 VSUBS 0.1f
Rl33_8 lad33_7 lad33_8 1.58
Cl33_8 lad33_8 VSUBS 0.1f
Rl33_9 lad33_8 lad33_9 14.3
Cl33_9 lad33_9 VSUBS 0.1f
Rl34_0 vss lad34_0 2.68
Cl34_0 lad34_0 VSUBS 0.1f
Rl34_1 lad34_0 lad34_1 18.8
Cl34_1 lad34_1 VSUBS 0.1f
Rl34_2 lad34_1 lad34_2 2.49
Cl34_2 lad34_2 VSUBS 0.1f
Rl34_3 lad34_2 lad34_3 6.94
Cl34_3 lad34_3 VSUBS 0.1f
Rl34_4 lad34_3 lad34_4 12.2
Cl34_4 lad34_4 VSUBS 0.1f
Rl34_5 lad34_4 lad34_5 1.32
Cl34_5 lad34_5 VSUBS 0.1f
Rl34_6 lad34_5 lad34_6 13.8
Cl34_6 lad34_6 VSUBS 0.1f
Rl34_7 lad34_6 lad34_7 4.68
Cl34_7 lad34_7 VSUBS 0.1f
Rl34_8 lad34_7 lad34_8 5.43
Cl34_8 lad34_8 VSUBS 0.1f
Rl34_9 lad34_8 lad34_9 9.13
Cl34_9 lad34_9 VSUBS 0.1f
Rl35_0 xcbiasn_xrb_s2 lad35_0 17.2
Cl35_0 lad35_0 VSUBS 0.1f
Rl35_1 lad35_0 lad35_1 5.6
Cl35_1 lad35_1 VSUBS 0.1f
Rl35_2 lad35_1 lad35_2 5.62
Cl35_2 lad35_2 VSUBS 0.1f
Rl35_3 lad35_2 lad35_3 17.8
Cl35_3 lad35_3 VSUBS 0.1f
Rl35_4 lad35_3 lad35_4 12.2
Cl35_4 lad35_4 VSUBS 0.1f
Rl35_5 lad35_4 lad35_5 3.07
Cl35_5 lad35_5 VSUBS 0.1f
Rl35_6 lad35_5 lad35_6 10.8
Cl35_6 lad35_6 VSUBS 0.1f
Rl35_7 lad35_6 lad35_7 4.17
Cl35_7 lad35_7 VSUBS 0.1f
Rl35_8 lad35_7 lad35_8 7.13
Cl35_8 lad35_8 VSUBS 0.1f
Rl35_9 lad35_8 lad35_9 3.44
Cl35_9 lad35_9 VSUBS 0.1f
Rl36_0 clk lad36_0 3.68
Cl36_0 lad36_0 VSUBS 0.1f
Rl36_1 lad36_0 lad36_1 13.3
Cl36_1 lad36_1 VSUBS 0.1f
Rl36_2 lad36_1 lad36_2 18.8
Cl36_2 lad36_2 VSUBS 0.1f
Rl36_3 lad36_2 lad36_3 1.45
Cl36_3 lad36_3 VSUBS 0.1f
Rl36_4 lad36_3 lad36_4 7.69
Cl36_4 lad36_4 VSUBS 0.1f
Rl36_5 lad36_4 lad36_5 17.6
Cl36_5 lad36_5 VSUBS 0.1f
Rl36_6 lad36_5 lad36_6 6.33
Cl36_6 lad36_6 VSUBS 0.1f
Rl36_7 lad36_6 lad36_7 18.9
Cl36_7 lad36_7 VSUBS 0.1f
Rl36_8 lad36_7 lad36_8 7.95
Cl36_8 lad36_8 VSUBS 0.1f
Rl36_9 lad36_8 lad36_9 12.3
Cl36_9 lad36_9 VSUBS 0.1f
Rl37_0 vref_in lad37_0 1.97
Cl37_0 lad37_0 VSUBS 0.1f
Rl37_1 lad37_0 lad37_1 11.1
Cl37_1 lad37_1 VSUBS 0.1f
Rl37_2 lad37_1 lad37_2 13.4
Cl37_2 lad37_2 VSUBS 0.1f
Rl37_3 lad37_2 lad37_3 12.7
Cl37_3 lad37_3 VSUBS 0.1f
Rl37_4 lad37_3 lad37_4 19.9
Cl37_4 lad37_4 VSUBS 0.1f
Rl37_5 lad37_4 lad37_5 8.81
Cl37_5 lad37_5 VSUBS 0.1f
Rl37_6 lad37_5 lad37_6 6.49
Cl37_6 lad37_6 VSUBS 0.1f
Rl37_7 lad37_6 lad37_7 7.66
Cl37_7 lad37_7 VSUBS 0.1f
Rl37_8 lad37_7 lad37_8 10.9
Cl37_8 lad37_8 VSUBS 0.1f
Rl37_9 lad37_8 lad37_9 19.9
Cl37_9 lad37_9 VSUBS 0.1f
Rl38_0 xckg_d0 lad38_0 9.29
Cl38_0 lad38_0 VSUBS 0.1f
Rl38_1 lad38_0 lad38_1 15.9
Cl38_1 lad38_1 VSUBS 0.1f
Rl38_2 lad38_1 lad38_2 16
Cl38_2 lad38_2 VSUBS 0.1f
Rl38_3 lad38_2 lad38_3 13.9
Cl38_3 lad38_3 VSUBS 0.1f
Rl38_4 lad38_3 lad38_4 7.78
Cl38_4 lad38_4 VSUBS 0.1f
Rl38_5 lad38_4 lad38_5 11.7
Cl38_5 lad38_5 VSUBS 0.1f
Rl38_6 lad38_5 lad38_6 7.83
Cl38_6 lad38_6 VSUBS 0.1f
Rl38_7 lad38_6 lad38_7 10.5
Cl38_7 lad38_7 VSUBS 0.1f
Rl38_8 lad38_7 lad38_8 14.6
Cl38_8 lad38_8 VSUBS 0.1f
Rl38_9 lad38_8 lad38_9 15.9
Cl38_9 lad38_9 VSUBS 0.1f
Rl39_0 xckg_d2 lad39_0 8.75
Cl39_0 lad39_0 VSUBS 0.1f
Rl39_1 lad39_0 lad39_1 4.94
Cl39_1 lad39_1 VSUBS 0.1f
Rl39_2 lad39_1 lad39_2 6.99
Cl39_2 lad39_2 VSUBS 0.1f
Rl39_3 lad39_2 lad39_3 15.8
Cl39_3 lad39_3 VSUBS 0.1f
Rl39_4 lad39_3 lad39_4 1.32
Cl39_4 lad39_4 VSUBS 0.1f
Rl39_5 lad39_4 lad39_5 19.7
Cl39_5 lad39_5 VSUBS 0.1f
Rl39_6 lad39_5 lad39_6 1.49
Cl39_6 lad39_6 VSUBS 0.1f
Rl39_7 lad39_6 lad39_7 9.32
Cl39_7 lad39_7 VSUBS 0.1f
Rl39_8 lad39_7 lad39_8 19.5
Cl39_8 lad39_8 VSUBS 0.1f
Rl39_9 lad39_8 lad39_9 8.74
Cl39_9 lad39_9 VSUBS 0.1f
Rl40_0 vref lad40_0 16.8
Cl40_0 lad40_0 VSUBS 0.1f
Rl40_1 lad40_0 lad40_1 7.16
Cl40_1 lad40_1 VSUBS 0.1f
Rl40_2 lad40_1 lad40_2 5.78
Cl40_2 lad40_2 VSUBS 0.1f
Rl40_3 lad40_2 lad40_3 15
Cl40_3 lad40_3 VSUBS 0.1f
Rl40_4 lad40_3 lad40_4 11.9
Cl40_4 lad40_4 VSUBS 0.1f
Rl40_5 lad40_4 lad40_5 13.1
Cl40_5 lad40_5 VSUBS 0.1f
Rl40_6 lad40_5 lad40_6 14.6
Cl40_6 lad40_6 VSUBS 0.1f
Rl40_7 lad40_6 lad40_7 10.6
Cl40_7 lad40_7 VSUBS 0.1f
Rl40_8 lad40_7 lad40_8 7.87
Cl40_8 lad40_8 VSUBS 0.1f
Rl40_9 lad40_8 lad40_9 17.8
Cl40_9 lad40_9 VSUBS 0.1f
Rl41_0 ibias lad41_0 19.4
Cl41_0 lad41_0 VSUBS 0.1f
Rl41_1 lad41_0 lad41_1 11.9
Cl41_1 lad41_1 VSUBS 0.1f
Rl41_2 lad41_1 lad41_2 5.53
Cl41_2 lad41_2 VSUBS 0.1f
Rl41_3 lad41_2 lad41_3 15.9
Cl41_3 lad41_3 VSUBS 0.1f
Rl41_4 lad41_3 lad41_4 18.4
Cl41_4 lad41_4 VSUBS 0.1f
Rl41_5 lad41_4 lad41_5 11.2
Cl41_5 lad41_5 VSUBS 0.1f
Rl41_6 lad41_5 lad41_6 5.94
Cl41_6 lad41_6 VSUBS 0.1f
Rl41_7 lad41_6 lad41_7 18.9
Cl41_7 lad41_7 VSUBS 0.1f
Rl41_8 lad41_7 lad41_8 18.3
Cl41_8 lad41_8 VSUBS 0.1f
Rl41_9 lad41_8 lad41_9 16.3
Cl41_9 lad41_9 VSUBS 0.1f
Rl42_0 xckg_d0 lad42_0 1.55
Cl42_0 lad42_0 VSUBS 0.1f
Rl42_1 lad42_0 lad42_1 1.37
Cl42_1 lad42_1 VSUBS 0.1f
Rl42_2 lad42_1 lad42_2 14.4
Cl42_2 lad42_2 VSUBS 0.1f
Rl42_3 lad42_2 lad42_3 17.1
Cl42_3 lad42_3 VSUBS 0.1f
Rl42_4 lad42_3 lad42_4 2.63
Cl42_4 lad42_4 VSUBS 0.1f
Rl42_5 lad42_4 lad42_5 17.7
Cl42_5 lad42_5 VSUBS 0.1f
Rl42_6 lad42_5 lad42_6 10
Cl42_6 lad42_6 VSUBS 0.1f
Rl42_7 lad42_6 lad42_7 16.4
Cl42_7 lad42_7 VSUBS 0.1f
Rl42_8 lad42_7 lad42_8 12.1
Cl42_8 lad42_8 VSUBS 0.1f
Rl42_9 lad42_8 lad42_9 13
Cl42_9 lad42_9 VSUBS 0.1f
Rl43_0 xcbiasn_xrb_s2 lad43_0 6.39
Cl43_0 lad43_0 VSUBS 0.1f
Rl43_1 lad43_0 lad43_1 1.56
Cl43_1 lad43_1 VSUBS 0.1f
Rl43_2 lad43_1 lad43_2 19.7
Cl43_2 lad43_2 VSUBS 0.1f
Rl43_3 lad43_2 lad43_3 9
Cl43_3 lad43_3 VSUBS 0.1f
Rl43_4 lad43_3 lad43_4 12.3
Cl43_4 lad43_4 VSUBS 0.1f
Rl43_5 lad43_4 lad43_5 6.16
Cl43_5 lad43_5 VSUBS 0.1f
Rl43_6 lad43_5 lad43_6 8.1
Cl43_6 lad43_6 VSUBS 0.1f
Rl43_7 lad43_6 lad43_7 1.96
Cl43_7 lad43_7 VSUBS 0.1f
Rl43_8 lad43_7 lad43_8 11.4
Cl43_8 lad43_8 VSUBS 0.1f
Rl43_9 lad43_8 lad43_9 6.77
Cl43_9 lad43_9 VSUBS 0.1f
Rl44_0 vdda lad44_0 8.29
Cl44_0 lad44_0 VSUBS 0.1f
Rl44_1 lad44_0 lad44_1 10.3
Cl44_1 lad44_1 VSUBS 0.1f
Rl44_2 lad44_1 lad44_2 5.79
Cl44_2 lad44_2 VSUBS 0.1f
Rl44_3 lad44_2 lad44_3 17.7
Cl44_3 lad44_3 VSUBS 0.1f
Rl44_4 lad44_3 lad44_4 15.2
Cl44_4 lad44_4 VSUBS 0.1f
Rl44_5 lad44_4 lad44_5 12.2
Cl44_5 lad44_5 VSUBS 0.1f
Rl44_6 lad44_5 lad44_6 16.1
Cl44_6 lad44_6 VSUBS 0.1f
Rl44_7 lad44_6 lad44_7 4.62
Cl44_7 lad44_7 VSUBS 0.1f
Rl44_8 lad44_7 lad44_8 19
Cl44_8 lad44_8 VSUBS 0.1f
Rl44_9 lad44_8 lad44_9 8.63
Cl44_9 lad44_9 VSUBS 0.1f
Rl45_0 xref_ntl lad45_0 3.61
Cl45_0 lad45_0 VSUBS 0.1f
Rl45_1 lad45_0 lad45_1 5.62
Cl45_1 lad45_1 VSUBS 0.1f
Rl45_2 lad45_1 lad45_2 11.6
Cl45_2 lad45_2 VSUBS 0.1f
Rl45_3 lad45_2 lad45_3 8.57
Cl45_3 lad45_3 VSUBS 0.1f
Rl45_4 lad45_3 lad45_4 4.97
Cl45_4 lad45_4 VSUBS 0.1f
Rl45_5 lad45_4 lad45_5 15
Cl45_5 lad45_5 VSUBS 0.1f
Rl45_6 lad45_5 lad45_6 15
Cl45_6 lad45_6 VSUBS 0.1f
Rl45_7 lad45_6 lad45_7 16.8
Cl45_7 lad45_7 VSUBS 0.1f
Rl45_8 lad45_7 lad45_8 2.1
Cl45_8 lad45_8 VSUBS 0.1f
Rl45_9 lad45_8 lad45_9 6.95
Cl45_9 lad45_9 VSUBS 0.1f
Rl46_0 xcbiasn_xrb_s3 lad46_0 16.1
Cl46_0 lad46_0 VSUBS 0.1f
Rl46_1 lad46_0 lad46_1 3.16
Cl46_1 lad46_1 VSUBS 0.1f
Rl46_2 lad46_1 lad46_2 3.09
Cl46_2 lad46_2 VSUBS 0.1f
Rl46_3 lad46_2 lad46_3 12.8
Cl46_3 lad46_3 VSUBS 0.1f
Rl46_4 lad46_3 lad46_4 8.25
Cl46_4 lad46_4 VSUBS 0.1f
Rl46_5 lad46_4 lad46_5 10.2
Cl46_5 lad46_5 VSUBS 0.1f
Rl46_6 lad46_5 lad46_6 11.4
Cl46_6 lad46_6 VSUBS 0.1f
Rl46_7 lad46_6 lad46_7 2.91
Cl46_7 lad46_7 VSUBS 0.1f
Rl46_8 lad46_7 lad46_8 10.2
Cl46_8 lad46_8 VSUBS 0.1f
Rl46_9 lad46_8 lad46_9 16.8
Cl46_9 lad46_9 VSUBS 0.1f
Rl47_0 xcbias_xrb_s1 lad47_0 13.4
Cl47_0 lad47_0 VSUBS 0.1f
Rl47_1 lad47_0 lad47_1 10.2
Cl47_1 lad47_1 VSUBS 0.1f
Rl47_2 lad47_1 lad47_2 6.17
Cl47_2 lad47_2 VSUBS 0.1f
Rl47_3 lad47_2 lad47_3 19.3
Cl47_3 lad47_3 VSUBS 0.1f
Rl47_4 lad47_3 lad47_4 11.2
Cl47_4 lad47_4 VSUBS 0.1f
Rl47_5 lad47_4 lad47_5 12.3
Cl47_5 lad47_5 VSUBS 0.1f
Rl47_6 lad47_5 lad47_6 3.11
Cl47_6 lad47_6 VSUBS 0.1f
Rl47_7 lad47_6 lad47_7 13.3
Cl47_7 lad47_7 VSUBS 0.1f
Rl47_8 lad47_7 lad47_8 10.4
Cl47_8 lad47_8 VSUBS 0.1f
Rl47_9 lad47_8 lad47_9 8.2
Cl47_9 lad47_9 VSUBS 0.1f
Rl48_0 xcbias_xrb_s1 lad48_0 10.3
Cl48_0 lad48_0 VSUBS 0.1f
Rl48_1 lad48_0 lad48_1 7
Cl48_1 lad48_1 VSUBS 0.1f
Rl48_2 lad48_1 lad48_2 18.7
Cl48_2 lad48_2 VSUBS 0.1f
Rl48_3 lad48_2 lad48_3 9.24
Cl48_3 lad48_3 VSUBS 0.1f
Rl48_4 lad48_3 lad48_4 11.5
Cl48_4 lad48_4 VSUBS 0.1f
Rl48_5 lad48_4 lad48_5 15.5
Cl48_5 lad48_5 VSUBS 0.1f
Rl48_6 lad48_5 lad48_6 12.6
Cl48_6 lad48_6 VSUBS 0.1f
Rl48_7 lad48_6 lad48_7 1.67
Cl48_7 lad48_7 VSUBS 0.1f
Rl48_8 lad48_7 lad48_8 13.7
Cl48_8 lad48_8 VSUBS 0.1f
Rl48_9 lad48_8 lad48_9 2.03
Cl48_9 lad48_9 VSUBS 0.1f
Rl49_0 xref_na lad49_0 8.24
Cl49_0 lad49_0 VSUBS 0.1f
Rl49_1 lad49_0 lad49_1 2.06
Cl49_1 lad49_1 VSUBS 0.1f
Rl49_2 lad49_1 lad49_2 3.94
Cl49_2 lad49_2 VSUBS 0.1f
Rl49_3 lad49_2 lad49_3 14.9
Cl49_3 lad49_3 VSUBS 0.1f
Rl49_4 lad49_3 lad49_4 13.4
Cl49_4 lad49_4 VSUBS 0.1f
Rl49_5 lad49_4 lad49_5 4.71
Cl49_5 lad49_5 VSUBS 0.1f
Rl49_6 lad49_5 lad49_6 8.7
Cl49_6 lad49_6 VSUBS 0.1f
Rl49_7 lad49_6 lad49_7 7.46
Cl49_7 lad49_7 VSUBS 0.1f
Rl49_8 lad49_7 lad49_8 14.2
Cl49_8 lad49_8 VSUBS 0.1f
Rl49_9 lad49_8 lad49_9 2.53
Cl49_9 lad49_9 VSUBS 0.1f
