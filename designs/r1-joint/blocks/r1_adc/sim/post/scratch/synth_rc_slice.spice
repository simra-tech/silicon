* synthetic parasitics (make_synth_pex.py, seed 7): 4000 C, 150 RC ladders of 10
C0 cp12 VSUBS 0.0333f
C1 bp7 VSUBS 0.106f
C2 xs1n_n10 VSUBS 0.152f
C3 cp2 cp1 0.113f
C4 bn0 VSUBS 0.225f
C5 cp1 VSUBS 0.122f
C6 gnd cp7 0.0771f
C7 cn12 VSUBS 0.297f
C8 vbn xs1n_n10 0.159f
C9 t1 VSUBS 0.0619f
C10 bn1 VSUBS 0.145f
C11 xc5_lt bp7 0.047f
C12 bn7 VSUBS 0.236f
C13 xc5_lt VSUBS 0.142f
C14 bp5 VSUBS 0.0333f
C15 xs0n_cbn VSUBS 0.218f
C16 bn12 VSUBS 0.181f
C17 t1b VSUBS 0.145f
C18 cn1 VSUBS 0.69f
C19 op VSUBS 0.0651f
C20 cp12 VSUBS 0.186f
C21 trk0 bp1 0.0986f
C22 bp4 bp10 0.21f
C23 cp0 VSUBS 0.0687f
C24 cp8 xc4_outpb 0.413f
C25 clknb VSUBS 0.407f
C26 vbp VSUBS 0.564f
C27 vref VSUBS 0.0738f
C28 rstb_n xs0p_n10 0.0521f
C29 lsb_p bn9 0.0265f
C30 bn3 VSUBS 0.199f
C31 xs1p_cbp xs0p_x 0.184f
C32 bp12 VSUBS 0.0497f
C33 xs0p_g VSUBS 0.0436f
C34 cp12 VSUBS 0.212f
C35 trk0 VSUBS 0.227f
C36 bn3 VSUBS 0.26f
C37 xc5_lt cp9 0.145f
C38 bn9 VSUBS 0.0619f
C39 cn8 VSUBS 0.0221f
C40 cp0 nr 0.0547f
C41 trk1 VSUBS 0.198f
C42 xc4_outpb VSUBS 0.177f
C43 bp1 VSUBS 0.463f
C44 cn9 xc5_xs1_tail 0.154f
C45 bn6 VSUBS 0.0992f
C46 xc4_lt VSUBS 0.593f
C47 on VSUBS 0.104f
C48 bn7 clkb 0.0559f
C49 xs0n_n10 VSUBS 0.174f
C50 cp5 VSUBS 0.219f
C51 bn0 VSUBS 0.361f
C52 xs1n_cbp cp1 0.691f
C53 cp2 VSUBS 0.182f
C54 bn2 VSUBS 0.25f
C55 cn7 clkn 0.167f
C56 xs1n_cbn VSUBS 0.0573f
C57 xs1p_cbn xc5_lt 0.0824f
C58 xs1n_x cp2 0.34f
C59 bp8 cp3 0.0252f
C60 xs0p_x top_p 0.0815f
C61 xs1p_cbp VSUBS 0.238f
C62 vbn trk0 0.0849f
C63 xc5_xs1_tail0 xs0n_cbn 0.223f
C64 bn5 xs0n_cbn 0.121f
C65 cp9 cp3 0.0776f
C66 bp2 cp4 0.128f
C67 xs0p_cbp VSUBS 0.262f
C68 bn2 clknb 0.0409f
C69 rstb trk1 0.159f
C70 onp xc4_xs1_tail 0.0711f
C71 cp9 VSUBS 0.0733f
C72 t0 VSUBS 0.0693f
C73 bn6 VSUBS 0.313f
C74 bp4 VSUBS 0.204f
C75 xc4_dip onp 0.0795f
C76 bn8 VSUBS 0.193f
C77 t0b bp5 0.0879f
C78 bp3 cp10 0.191f
C79 cn11 VSUBS 0.398f
C80 vbp xc5_dip 0.0815f
C81 bn9 VSUBS 0.2f
C82 op VSUBS 0.232f
C83 cn4 VSUBS 0.116f
C84 xs1p_cbn VSUBS 0.17f
C85 onp VSUBS 0.644f
C86 lsb_p VSUBS 0.179f
C87 xs1n_g op 0.304f
C88 cn8 vbp 0.388f
C89 xs0p_n10 VSUBS 0.0403f
C90 cn7 cn3 0.105f
C91 bn11 VSUBS 0.131f
C92 xc4_outnb VSUBS 0.101f
C93 cn4 VSUBS 0.077f
C94 xc4_outpb bn8 0.263f
C95 cn8 VSUBS 0.134f
C96 nr rstb 0.173f
C97 xs0p_x VSUBS 0.604f
C98 bn10 VSUBS 0.152f
C99 cn1 xs1p_cbn 0.0732f
C100 xs0p_x xs1p_g 0.128f
C101 bp4 VSUBS 0.149f
C102 bn0 VSUBS 0.327f
C103 cn8 VSUBS 0.162f
C104 xs0p_cbn VSUBS 0.161f
C105 xs1p_n10 bn8 0.16f
C106 bp6 VSUBS 0.413f
C107 cp8 VSUBS 0.00893f
C108 bn5 bp12 0.135f
C109 bn12 VSUBS 0.0937f
C110 op VSUBS 0.129f
C111 cn1 bp5 0.213f
C112 in1n clkn 0.505f
C113 trk0 xc4_xs1_tail0 0.0299f
C114 cp6 VSUBS 0.148f
C115 xs1n_cbn bp9 0.248f
C116 rstb cn10 0.254f
C117 trk1 VSUBS 0.22f
C118 cn5 VSUBS 0.118f
C119 vrefl bp12 0.24f
C120 bn10 onp 0.565f
C121 cn8 VSUBS 0.0332f
C122 bp2 VSUBS 0.131f
C123 vbp VSUBS 0.369f
C124 on VSUBS 0.0237f
C125 cp12 bn1 0.309f
C126 xc4_dip VSUBS 0.238f
C127 cn2 VSUBS 0.0576f
C128 xs1p_x VSUBS 0.149f
C129 cn0 VSUBS 0.129f
C130 in0n VSUBS 0.223f
C131 in1n clkb 0.161f
C132 bn10 xs1n_cbn 0.504f
C133 bn12 VSUBS 0.139f
C134 top_p VSUBS 0.0299f
C135 trk1 VSUBS 0.222f
C136 xs0p_cbp VSUBS 0.178f
C137 xc5_xs1_tail0 VSUBS 0.0828f
C138 xs1n_cbn VSUBS 0.303f
C139 cn5 bn12 0.0326f
C140 xc5_dip clk 0.143f
C141 xs1p_n10 xc4_xs1_tail0 0.0493f
C142 nr VSUBS 0.373f
C143 xs0n_cbn cp3 0.113f
C144 vrefl cp9 0.0702f
C145 trk1 VSUBS 0.46f
C146 rstb_n cp5 0.0798f
C147 cn10 t0b 0.265f
C148 bn12 VSUBS 0.0866f
C149 cp12 VSUBS 0.051f
C150 t1b VSUBS 0.26f
C151 cp6 VSUBS 0.165f
C152 top_p VSUBS 0.624f
C153 t0b t0 0.064f
C154 bn4 bn10 0.175f
C155 xs0n_x bp8 0.221f
C156 on VSUBS 0.127f
C157 vbp xs1n_n10 0.024f
C158 clkb top_n 0.0238f
C159 xs1n_g bn0 0.159f
C160 cp10 VSUBS 0.0439f
C161 xc4_din cp6 0.0688f
C162 bp8 VSUBS 0.133f
C163 xc4_dip VSUBS 0.175f
C164 bn2 VSUBS 0.0956f
C165 bn12 onn 0.0255f
C166 bp4 VSUBS 0.209f
C167 bn8 xs0p_n10 0.194f
C168 xs1p_cbp VSUBS 0.123f
C169 cn11 vbn 0.0744f
C170 onp VSUBS 0.125f
C171 cp4 VSUBS 0.0225f
C172 vref VSUBS 0.31f
C173 xc4_dip VSUBS 0.241f
C174 bp6 xs0n_cbn 0.0448f
C175 cp0 VSUBS 0.559f
C176 bp2 VSUBS 0.0207f
C177 cp10 VSUBS 0.0575f
C178 cp11 vrefl 0.0432f
C179 bp3 VSUBS 0.166f
C180 cp1 VSUBS 0.596f
C181 cp2 cn6 0.0314f
C182 bp1 xs1p_cbp 0.115f
C183 cp1 VSUBS 0.091f
C184 vdd VSUBS 0.111f
C185 xc5_xs1_tail0 VSUBS 0.0918f
C186 trk1 bn8 0.0881f
C187 clk cn5 0.0496f
C188 cp5 VSUBS 0.0463f
C189 top_n VSUBS 0.148f
C190 bn10 cn1 0.137f
C191 bn3 VSUBS 0.228f
C192 bp6 cn1 0.618f
C193 xs0n_x in0p 0.183f
C194 t1 VSUBS 0.05f
C195 xc5_xs1_tail0 in1n 0.251f
C196 cn0 VSUBS 0.124f
C197 in1n VSUBS 0.173f
C198 bn10 VSUBS 0.127f
C199 clkn lsb_p 0.0681f
C200 cp12 cn6 0.687f
C201 bp1 bn4 0.0157f
C202 lsb_n cn2 0.0508f
C203 cn0 cp10 0.0706f
C204 gnd VSUBS 0.142f
C205 cn2 VSUBS 0.204f
C206 rstb_n VSUBS 0.263f
C207 bn8 VSUBS 0.273f
C208 on VSUBS 0.202f
C209 cp9 VSUBS 0.0689f
C210 xs0n_cbp bn3 0.443f
C211 xs1n_n10 nr 0.335f
C212 xc5_outnb VSUBS 0.0879f
C213 gnd VSUBS 0.0469f
C214 cn1 VSUBS 0.0917f
C215 xs0p_x cp1 0.277f
C216 cp3 VSUBS 0.373f
C217 t1 cn3 0.132f
C218 cp6 VSUBS 0.508f
C219 xs0p_cbn xs1p_cbp 0.0334f
C220 trk0 VSUBS 0.125f
C221 rstb VSUBS 0.0663f
C222 bp12 xc4_lt 0.168f
C223 nr cp3 0.165f
C224 bn3 VSUBS 0.0769f
C225 trk1 xs0p_cbn 0.171f
C226 rstb VSUBS 0.0639f
C227 nr vbp 0.115f
C228 in1p VSUBS 0.604f
C229 bn10 xs1n_cbn 0.172f
C230 xc5_outpb VSUBS 0.0523f
C231 xs1n_cbn VSUBS 0.552f
C232 xc5_xs1_tail vbp 0.306f
C233 bp9 VSUBS 0.0499f
C234 xc4_outnb rstb 0.173f
C235 bp10 VSUBS 0.0582f
C236 bp5 VSUBS 0.115f
C237 in1p VSUBS 0.0666f
C238 t0b xc4_dip 0.073f
C239 bp0 VSUBS 0.047f
C240 bp1 clkn 0.284f
C241 bn12 VSUBS 0.0734f
C242 xs0p_cbp op 0.226f
C243 nr VSUBS 0.783f
C244 onp VSUBS 0.491f
C245 cn1 t1 0.206f
C246 xc5_xs1_tail0 VSUBS 1.12f
C247 xs0n_x cp2 0.219f
C248 cp6 xc5_outnb 0.148f
C249 bp3 VSUBS 0.02f
C250 xc5_dip bp7 0.255f
C251 xs0p_cbn xc5_outpb 0.418f
C252 xc4_lt VSUBS 0.225f
C253 top_p VSUBS 0.0706f
C254 bp2 VSUBS 0.225f
C255 cn3 VSUBS 0.232f
C256 bp10 cn2 0.131f
C257 vbn VSUBS 0.278f
C258 clknb VSUBS 0.0458f
C259 xs1p_n10 VSUBS 0.764f
C260 cp6 VSUBS 0.302f
C261 bp6 VSUBS 0.266f
C262 xc5_dip t1b 0.586f
C263 t1 VSUBS 0.0995f
C264 xc4_dip VSUBS 0.0487f
C265 xc4_xs1_tail0 bn2 0.294f
C266 cp9 VSUBS 0.129f
C267 xs1n_n10 VSUBS 0.246f
C268 xs1n_cbn clknb 0.122f
C269 bn8 VSUBS 0.956f
C270 xc5_dip VSUBS 0.285f
C271 bn3 VSUBS 0.0495f
C272 bn7 VSUBS 0.0648f
C273 vref VSUBS 0.37f
C274 cp8 VSUBS 0.0736f
C275 bp1 vref 0.267f
C276 xs0n_cbp xs1p_n10 0.502f
C277 bn2 cn7 0.111f
C278 onn VSUBS 0.127f
C279 bn6 bn10 0.342f
C280 cn5 VSUBS 0.103f
C281 vref bn4 0.237f
C282 bn12 cp12 0.147f
C283 xc5_outnb VSUBS 0.426f
C284 xs0n_cbn VSUBS 0.0808f
C285 bp11 VSUBS 0.272f
C286 trk0 VSUBS 0.264f
C287 vbn VSUBS 0.0923f
C288 bn4 VSUBS 0.22f
C289 top_p cp2 0.0353f
C290 in0p bp10 0.414f
C291 clknb cp12 0.0312f
C292 cp11 VSUBS 0.0657f
C293 in1n vdd 0.144f
C294 cp7 VSUBS 0.217f
C295 trk1 bp2 0.273f
C296 bn6 VSUBS 0.144f
C297 onp VSUBS 0.248f
C298 onp VSUBS 0.105f
C299 cn5 VSUBS 0.0892f
C300 top_n VSUBS 0.186f
C301 t1b xc4_lt 0.0432f
C302 cp7 VSUBS 0.417f
C303 xc4_lt cp8 0.233f
C304 bp6 cn2 0.0804f
C305 t0 VSUBS 0.133f
C306 xc4_outpb VSUBS 0.261f
C307 bn12 bn10 0.0416f
C308 rstb_n bp6 0.444f
C309 xc4_dip VSUBS 0.1f
C310 onn lsb_n 0.0186f
C311 cn1 xs1n_n10 0.171f
C312 cn10 VSUBS 0.14f
C313 clkb VSUBS 0.0557f
C314 vref VSUBS 0.481f
C315 in0n onp 0.109f
C316 bn0 xs0p_cbn 0.131f
C317 bn2 VSUBS 0.189f
C318 bn10 bn2 0.0729f
C319 cn5 VSUBS 0.0969f
C320 bp4 rstb 0.82f
C321 cp12 VSUBS 0.171f
C322 xs1n_cbn bn8 0.175f
C323 clknb clknb 0.297f
C324 cp5 VSUBS 0.342f
C325 cp8 top_n 0.0744f
C326 bp6 xs0n_cbp 0.211f
C327 cp4 lsb_n 0.262f
C328 xs1p_x xs0n_g 0.143f
C329 cn8 xc5_lt 0.592f
C330 bn12 cp2 0.142f
C331 xs0p_cbp VSUBS 0.199f
C332 clk VSUBS 0.0657f
C333 xs0n_x vbp 0.397f
C334 xc5_lt VSUBS 0.181f
C335 xc5_xs1_tail0 VSUBS 0.315f
C336 op VSUBS 0.0233f
C337 gnd VSUBS 0.226f
C338 xs0n_cbp xc4_outpb 0.245f
C339 op VSUBS 0.15f
C340 xc5_din VSUBS 0.154f
C341 xc4_outnb VSUBS 0.338f
C342 xc4_lt bp1 0.0873f
C343 t1b VSUBS 0.145f
C344 bp7 VSUBS 0.351f
C345 xs1n_n10 VSUBS 0.174f
C346 xs0p_x clkb 0.182f
C347 bn11 cn6 0.156f
C348 xc5_din cp7 0.135f
C349 clk VSUBS 0.134f
C350 lsb_n VSUBS 0.428f
C351 bp5 VSUBS 0.247f
C352 cp9 rstb_n 0.789f
C353 cp8 VSUBS 0.128f
C354 cn2 bn8 0.298f
C355 cp2 VSUBS 0.15f
C356 xs0p_cbp VSUBS 0.0493f
C357 cn5 op 0.47f
C358 in0p nr 0.31f
C359 vref VSUBS 0.0797f
C360 onn cp2 0.0452f
C361 xc5_lt VSUBS 0.0276f
C362 bn8 VSUBS 0.154f
C363 xs1p_g top_n 0.22f
C364 xc4_xs1_tail VSUBS 0.894f
C365 xs1p_g VSUBS 0.107f
C366 xs1p_n10 VSUBS 0.54f
C367 t1b clk 0.28f
C368 cp1 VSUBS 0.165f
C369 xs0n_cbp VSUBS 0.146f
C370 xs1p_x VSUBS 0.084f
C371 bp3 VSUBS 0.0949f
C372 bn7 VSUBS 0.197f
C373 xs1n_cbp VSUBS 0.104f
C374 cn6 bn9 0.218f
C375 bn5 vdd 0.0955f
C376 xc4_outpb cp12 0.449f
C377 cn8 VSUBS 0.642f
C378 cp5 VSUBS 0.0652f
C379 vbn VSUBS 0.0851f
C380 t0b VSUBS 0.035f
C381 vref vref 0.155f
C382 clk VSUBS 0.102f
C383 bn0 VSUBS 0.0444f
C384 cp4 xs1n_cbn 0.164f
C385 vrefl VSUBS 0.306f
C386 bn0 cp2 0.0445f
C387 xc5_lt vbp 0.032f
C388 top_p VSUBS 0.225f
C389 bn11 VSUBS 0.154f
C390 bn3 VSUBS 0.139f
C391 xs1p_cbn VSUBS 0.08f
C392 cp8 VSUBS 0.0586f
C393 xc4_lt lsb_n 0.238f
C394 cp6 VSUBS 0.302f
C395 bp11 xc4_din 0.131f
C396 trk1 bp12 0.127f
C397 bn5 cp8 0.137f
C398 xc5_din VSUBS 0.0891f
C399 bp2 VSUBS 0.0667f
C400 cn3 VSUBS 0.205f
C401 cn7 VSUBS 0.0273f
C402 bn7 VSUBS 0.0669f
C403 bn11 VSUBS 0.0942f
C404 cp10 VSUBS 0.083f
C405 lsb_p VSUBS 0.134f
C406 clknb VSUBS 0.178f
C407 onp bn1 0.0733f
C408 xs1p_n10 bn12 0.0628f
C409 xs1n_cbn bn3 0.0385f
C410 cp11 bn12 0.164f
C411 bn0 xc4_dip 0.105f
C412 cn6 VSUBS 0.197f
C413 cn2 t1 0.19f
C414 bp3 VSUBS 0.115f
C415 t0b xc5_din 0.285f
C416 t1b VSUBS 0.215f
C417 bp5 VSUBS 0.056f
C418 rstb_n xs1n_cbn 0.0964f
C419 gnd clknb 0.0323f
C420 in1p VSUBS 0.408f
C421 bp0 VSUBS 0.579f
C422 vdd VSUBS 0.103f
C423 bn7 bp2 0.228f
C424 xs0p_cbn VSUBS 0.456f
C425 cp6 VSUBS 0.247f
C426 xs0p_g VSUBS 0.151f
C427 cn3 cn11 0.306f
C428 xs1n_g cp2 0.166f
C429 xs1n_cbp VSUBS 0.409f
C430 bp2 t0b 0.355f
C431 bp4 VSUBS 0.166f
C432 trk1 VSUBS 0.426f
C433 t0b VSUBS 0.303f
C434 vrefl xs0p_cbn 0.0669f
C435 op VSUBS 0.0368f
C436 bp3 xs1n_g 0.634f
C437 xs1p_cbn VSUBS 0.244f
C438 xs0n_cbp vbp 0.178f
C439 xc4_dip xs0p_cbp 0.0997f
C440 gnd vref 0.517f
C441 xs0p_n10 trk0 0.361f
C442 bn0 VSUBS 0.104f
C443 lsb_p VSUBS 0.0518f
C444 bn7 VSUBS 0.101f
C445 bp9 VSUBS 0.0723f
C446 in1p xc5_outpb 0.259f
C447 bp7 VSUBS 0.047f
C448 cp11 VSUBS 0.068f
C449 bn9 cp4 0.277f
C450 cp3 VSUBS 0.186f
C451 xs0p_n10 t1b 0.231f
C452 cp6 VSUBS 0.285f
C453 cn1 xs1n_n10 0.213f
C454 vdd VSUBS 0.257f
C455 cp9 xc4_outnb 0.19f
C456 xs1n_x VSUBS 0.0781f
C457 xc5_xs1_tail xs1p_cbp 0.141f
C458 xc5_dip VSUBS 0.0415f
C459 cp7 VSUBS 0.0687f
C460 nr VSUBS 0.114f
C461 xs1n_cbn VSUBS 0.035f
C462 cp12 VSUBS 0.13f
C463 t0 VSUBS 0.327f
C464 cn5 cp12 0.0892f
C465 xs0p_cbp VSUBS 0.132f
C466 bn5 xs1p_g 0.179f
C467 cp0 VSUBS 0.0796f
C468 cp9 VSUBS 0.597f
C469 gnd bn6 0.195f
C470 xc5_xs1_tail0 VSUBS 0.126f
C471 top_n VSUBS 0.0111f
C472 top_n VSUBS 0.0837f
C473 xc4_din xs0p_g 0.648f
C474 cn8 xc4_outpb 0.105f
C475 cn7 clkn 0.197f
C476 bp5 VSUBS 0.535f
C477 bn5 clknb 0.121f
C478 clk cn4 0.151f
C479 cp10 VSUBS 0.263f
C480 vbp bp12 0.194f
C481 t0b xc5_din 0.896f
C482 xs0p_n10 VSUBS 0.207f
C483 top_n VSUBS 0.078f
C484 lsb_p cp10 0.394f
C485 xc5_xs1_tail VSUBS 0.389f
C486 bp4 trk0 0.238f
C487 lsb_p VSUBS 0.131f
C488 cn1 bn12 0.323f
C489 cp6 VSUBS 0.0689f
C490 bp3 VSUBS 0.291f
C491 bn6 bp0 0.223f
C492 cn5 VSUBS 0.196f
C493 bn9 cn7 0.0989f
C494 t1b VSUBS 0.432f
C495 cn1 VSUBS 0.181f
C496 bn12 in1n 0.301f
C497 bn8 VSUBS 0.112f
C498 bn11 VSUBS 0.0887f
C499 vrefl nr 0.999f
C500 xs0n_cbn cp6 0.0548f
C501 nr VSUBS 0.673f
C502 cn10 cn3 1.01f
C503 xs1p_cbp VSUBS 0.595f
C504 vdd VSUBS 0.161f
C505 xs0p_g lsb_n 0.0774f
C506 xc4_din bn0 0.0433f
C507 bn5 VSUBS 0.325f
C508 top_p VSUBS 0.152f
C509 clknb VSUBS 0.274f
C510 cp11 clknb 0.155f
C511 t1b xc4_lt 0.0621f
C512 in1n cp8 0.399f
C513 xs1p_cbp bn10 0.185f
C514 bn12 VSUBS 0.664f
C515 bp9 VSUBS 0.198f
C516 in1n bp3 0.159f
C517 bn1 VSUBS 0.0454f
C518 bp2 in1p 0.117f
C519 clkn VSUBS 0.0508f
C520 op cn8 0.0543f
C521 onn VSUBS 0.0478f
C522 clkb bn6 0.0535f
C523 lsb_p cp7 0.155f
C524 bp1 bp1 0.204f
C525 lsb_n cn4 0.0423f
C526 xc4_outpb VSUBS 0.0366f
C527 clknb VSUBS 0.17f
C528 top_n VSUBS 0.388f
C529 cn6 bp3 0.218f
C530 bn8 VSUBS 0.0328f
C531 xs0n_cbn lsb_p 0.107f
C532 bn3 VSUBS 0.0637f
C533 bn1 xs0p_x 1.54f
C534 bn7 VSUBS 0.169f
C535 xc4_outpb VSUBS 0.234f
C536 bp4 VSUBS 0.23f
C537 in1n VSUBS 0.0384f
C538 bn9 bn9 0.241f
C539 xs1n_g VSUBS 0.179f
C540 xs0p_cbn trk1 0.461f
C541 bn7 bp9 0.154f
C542 xs0p_n10 trk0 0.1f
C543 bn12 VSUBS 0.477f
C544 xs0n_x VSUBS 0.0671f
C545 xs0p_g VSUBS 0.114f
C546 vref VSUBS 0.691f
C547 in0n VSUBS 0.0529f
C548 xs0p_cbp VSUBS 0.387f
C549 bp11 bp0 0.0718f
C550 bp6 xc4_outnb 0.108f
C551 xs1p_cbn cn8 0.06f
C552 cn1 VSUBS 0.171f
C553 bp1 cn6 0.159f
C554 t0b bp0 0.295f
C555 xs1p_cbn VSUBS 0.0444f
C556 xc4_lt clkb 0.0595f
C557 cp9 cn1 0.498f
C558 bp9 VSUBS 0.12f
C559 cp12 VSUBS 0.0397f
C560 cp4 bn4 0.102f
C561 cp6 bn4 0.452f
C562 xs0p_g in1p 0.0452f
C563 cn10 bp9 0.402f
C564 bn10 VSUBS 0.175f
C565 xc4_outpb VSUBS 0.0673f
C566 lsb_n VSUBS 0.261f
C567 gnd bn3 0.086f
C568 xc4_dip VSUBS 0.668f
C569 nr VSUBS 0.139f
C570 bp7 VSUBS 0.121f
C571 bn11 t0b 0.153f
C572 cn9 VSUBS 0.115f
C573 cn10 VSUBS 0.0569f
C574 bp0 VSUBS 0.105f
C575 xs1p_x VSUBS 0.241f
C576 xc5_xs1_tail0 cp7 0.421f
C577 cp12 VSUBS 0.0661f
C578 xs1p_n10 cn3 0.0428f
C579 cn7 VSUBS 0.237f
C580 bp3 xs0n_cbp 0.0279f
C581 xs1n_x VSUBS 0.227f
C582 on VSUBS 0.114f
C583 cp12 VSUBS 0.12f
C584 in0n VSUBS 0.543f
C585 xs1n_x bn4 0.12f
C586 bn12 VSUBS 0.203f
C587 bp6 VSUBS 0.0612f
C588 cn12 VSUBS 0.0433f
C589 xs1p_g VSUBS 0.0584f
C590 xs1n_n10 bn4 0.291f
C591 bp1 VSUBS 0.489f
C592 bn5 xc4_din 0.432f
C593 top_n xc4_xs1_tail0 0.0319f
C594 xs0p_cbn VSUBS 0.286f
C595 cn3 lsb_n 0.167f
C596 bp3 VSUBS 0.124f
C597 cp5 VSUBS 0.152f
C598 rstb_n VSUBS 0.218f
C599 cp12 VSUBS 0.279f
C600 bn7 VSUBS 0.0944f
C601 in0p cp3 0.388f
C602 cn10 bp12 0.39f
C603 bn8 VSUBS 0.107f
C604 vbp VSUBS 0.123f
C605 bp4 VSUBS 0.111f
C606 cp2 VSUBS 0.379f
C607 xc4_xs1_tail xs1n_g 0.337f
C608 cp6 bp10 0.259f
C609 xs1n_cbn xc4_dip 0.0432f
C610 bp12 VSUBS 0.23f
C611 bp12 VSUBS 0.161f
C612 cn9 bp6 0.0574f
C613 on vrefl 0.313f
C614 cp3 VSUBS 0.0968f
C615 cp9 VSUBS 0.077f
C616 bp9 cp5 0.134f
C617 vbp VSUBS 0.0968f
C618 bp5 VSUBS 0.0361f
C619 rstb VSUBS 0.118f
C620 vrefl xs0p_g 0.0411f
C621 lsb_n VSUBS 0.0754f
C622 cp8 nr 0.117f
C623 bn3 VSUBS 0.0204f
C624 bp7 VSUBS 0.132f
C625 xs1n_g bp1 0.0356f
C626 t1 in1p 0.117f
C627 cp7 VSUBS 0.553f
C628 trk0 cp10 0.174f
C629 bp9 bp0 0.149f
C630 bn2 VSUBS 0.107f
C631 bp3 VSUBS 0.169f
C632 xs1n_cbn VSUBS 0.858f
C633 xc5_dip vref 0.325f
C634 xc4_xs1_tail VSUBS 0.439f
C635 bp0 VSUBS 0.0904f
C636 vrefl VSUBS 0.135f
C637 cn6 VSUBS 0.158f
C638 t1 op 0.0852f
C639 xs1p_n10 bn12 0.158f
C640 xs1p_n10 VSUBS 0.114f
C641 on VSUBS 0.215f
C642 bp8 VSUBS 0.163f
C643 cn2 VSUBS 0.151f
C644 bn4 bp5 0.133f
C645 xc4_xs1_tail VSUBS 0.105f
C646 trk0 VSUBS 0.176f
C647 xs1p_x VSUBS 0.0539f
C648 bp1 VSUBS 0.333f
C649 bp6 VSUBS 0.385f
C650 cp12 xc4_xs1_tail0 0.0609f
C651 bp9 VSUBS 0.0693f
C652 rstb_n xc4_outpb 0.16f
C653 t0b bn12 0.0992f
C654 rstb VSUBS 0.126f
C655 on VSUBS 0.0819f
C656 xc4_xs1_tail xs0n_cbp 0.116f
C657 xc5_din VSUBS 0.136f
C658 clk VSUBS 0.0749f
C659 cn2 VSUBS 0.154f
C660 xc4_outpb VSUBS 0.0233f
C661 xs0n_n10 VSUBS 0.193f
C662 onn bn7 0.375f
C663 top_n VSUBS 0.0326f
C664 cn2 cn4 0.0576f
C665 cp0 cn6 0.129f
C666 cn4 VSUBS 0.0627f
C667 onn VSUBS 0.132f
C668 xc5_outpb VSUBS 0.114f
C669 bp0 VSUBS 0.188f
C670 cn3 bp4 0.261f
C671 trk0 bn12 0.166f
C672 t1b VSUBS 0.384f
C673 trk1 bp0 0.0407f
C674 bp1 VSUBS 0.116f
C675 rstb_n VSUBS 0.136f
C676 bp7 VSUBS 0.222f
C677 t1b cn6 0.132f
C678 xs1n_cbp VSUBS 0.213f
C679 cn3 xs0n_n10 0.126f
C680 clknb VSUBS 0.0529f
C681 bp7 VSUBS 0.185f
C682 xc5_outpb bp5 0.0849f
C683 xs0n_g cn11 0.17f
C684 vrefl VSUBS 1.56f
C685 bp1 VSUBS 0.372f
C686 xs0n_g xs1n_x 0.0417f
C687 xc4_outnb op 0.14f
C688 vdd VSUBS 0.13f
C689 cn9 VSUBS 0.282f
C690 t1 VSUBS 1.07f
C691 cn10 VSUBS 0.341f
C692 cp1 VSUBS 0.115f
C693 bn4 xs0n_n10 0.085f
C694 xs0p_cbp VSUBS 0.109f
C695 top_p VSUBS 0.0712f
C696 bp3 cp11 0.763f
C697 xc4_lt VSUBS 0.165f
C698 vbp VSUBS 0.0684f
C699 xc4_xs1_tail VSUBS 0.0862f
C700 bn10 VSUBS 0.164f
C701 xs0p_cbn in1p 0.572f
C702 xs1n_n10 VSUBS 0.312f
C703 bp2 VSUBS 0.0775f
C704 bp1 bn1 0.359f
C705 onn VSUBS 0.0987f
C706 xs0p_x xc4_din 0.388f
C707 bn4 VSUBS 0.192f
C708 bn3 vrefl 0.0723f
C709 in1p xs0n_g 0.429f
C710 t0b bp10 0.438f
C711 xs1n_x xs0p_x 0.1f
C712 bp3 VSUBS 0.325f
C713 bp5 cp11 0.27f
C714 t0 VSUBS 0.126f
C715 cn3 VSUBS 0.245f
C716 cp11 vdd 0.164f
C717 cn1 VSUBS 0.569f
C718 bn11 VSUBS 0.0826f
C719 cp12 VSUBS 0.109f
C720 bp3 VSUBS 0.762f
C721 xs0p_n10 op 0.0996f
C722 cp12 cn8 0.14f
C723 vrefl in1p 0.353f
C724 xc5_dip VSUBS 0.281f
C725 xc4_lt VSUBS 0.096f
C726 xs0n_cbp VSUBS 0.062f
C727 rstb_n VSUBS 0.101f
C728 vref vref 0.125f
C729 t0b VSUBS 0.0998f
C730 xs0p_cbp VSUBS 0.0288f
C731 xs0n_n10 VSUBS 0.0331f
C732 bn8 VSUBS 0.0896f
C733 xs0p_x VSUBS 0.106f
C734 xs1n_x clk 0.202f
C735 xs0n_g cn11 0.221f
C736 vref VSUBS 0.147f
C737 xs1n_cbn VSUBS 0.192f
C738 bn0 cn1 0.0793f
C739 xc4_xs1_tail0 bp8 0.234f
C740 bp6 VSUBS 0.153f
C741 xs1n_cbn VSUBS 0.099f
C742 top_n VSUBS 0.109f
C743 cp6 VSUBS 0.153f
C744 top_p VSUBS 0.121f
C745 xs1n_n10 VSUBS 0.304f
C746 cp6 xs0n_g 0.105f
C747 xs0n_cbp VSUBS 0.241f
C748 in0p xs1n_cbn 0.142f
C749 bp3 bn4 0.0749f
C750 bn4 VSUBS 0.781f
C751 bp9 xs0p_g 0.111f
C752 xc4_din VSUBS 0.238f
C753 bp1 VSUBS 0.154f
C754 xs1n_cbn VSUBS 0.141f
C755 cp0 VSUBS 0.193f
C756 bp2 VSUBS 0.0849f
C757 bn3 VSUBS 0.215f
C758 cn1 VSUBS 0.0328f
C759 bp5 VSUBS 0.334f
C760 bp8 bp3 0.103f
C761 cn8 VSUBS 0.0718f
C762 cn11 cp4 0.0932f
C763 bp5 xs1p_cbn 0.309f
C764 gnd VSUBS 0.384f
C765 onp VSUBS 0.101f
C766 top_p VSUBS 0.191f
C767 cp0 VSUBS 0.084f
C768 vbp bp7 0.0599f
C769 bp11 VSUBS 0.214f
C770 xs1p_g VSUBS 0.196f
C771 bp8 VSUBS 0.333f
C772 bp3 VSUBS 0.203f
C773 lsb_n VSUBS 0.241f
C774 xc5_dip onn 0.137f
C775 bn2 VSUBS 0.245f
C776 cp9 VSUBS 0.0822f
C777 top_p xs0p_x 0.192f
C778 rstb cp0 0.202f
C779 xs1p_cbn in0p 0.237f
C780 op bp7 0.183f
C781 gnd bn4 0.161f
C782 xs0p_x trk0 0.143f
C783 xs0n_x VSUBS 0.082f
C784 bn7 in1p 0.13f
C785 vbn VSUBS 0.198f
C786 cn7 VSUBS 0.101f
C787 lsb_p VSUBS 0.0931f
C788 lsb_n in1n 0.382f
C789 xc5_xs1_tail0 VSUBS 0.0754f
C790 vref cn5 0.0644f
C791 gnd VSUBS 0.0761f
C792 cn12 xc4_dip 0.219f
C793 xc4_lt in1n 0.288f
C794 xc4_din VSUBS 0.154f
C795 clk bn6 0.0893f
C796 cn10 xc5_xs1_tail0 0.676f
C797 xs0p_g xc5_dip 0.563f
C798 xs1p_n10 clkb 0.218f
C799 cp4 xs1n_g 0.0374f
C800 cp6 trk1 0.124f
C801 bn9 VSUBS 0.199f
C802 bn3 VSUBS 0.379f
C803 in1n onp 0.141f
C804 xc5_outpb VSUBS 0.259f
C805 lsb_n VSUBS 0.0386f
C806 xc4_lt VSUBS 0.318f
C807 lsb_p cp11 0.0625f
C808 cp2 bn5 0.0615f
C809 xs1n_x VSUBS 0.199f
C810 top_p cp11 0.105f
C811 bp7 VSUBS 0.0401f
C812 gnd xs0n_cbn 0.249f
C813 xc5_din vdd 0.107f
C814 lsb_n VSUBS 0.149f
C815 xs1n_cbp in0p 0.102f
C816 xs1p_x VSUBS 0.0784f
C817 xs1p_g t1 0.0914f
C818 xs1p_cbp bp11 0.0721f
C819 bn1 vrefl 0.366f
C820 trk1 VSUBS 0.182f
C821 cp7 top_n 0.14f
C822 cp11 VSUBS 0.139f
C823 xs1n_g VSUBS 0.11f
C824 cp6 VSUBS 0.306f
C825 cp2 VSUBS 0.19f
C826 cp4 VSUBS 0.859f
C827 bp0 VSUBS 0.112f
C828 xc4_dip VSUBS 0.12f
C829 cp6 xc4_xs1_tail0 0.103f
C830 cn9 VSUBS 0.108f
C831 cp9 VSUBS 0.0506f
C832 cp5 VSUBS 0.0819f
C833 cn12 in1p 0.0829f
C834 xs1n_n10 cn11 0.0639f
C835 lsb_p cp11 0.0179f
C836 xc4_lt VSUBS 0.144f
C837 xs0p_n10 VSUBS 0.0864f
C838 lsb_p bn11 0.193f
C839 t1b xc4_outpb 0.26f
C840 xs0p_cbp bn6 0.114f
C841 xc5_lt VSUBS 0.0523f
C842 cn7 VSUBS 0.108f
C843 t0 in1n 0.274f
C844 bn11 VSUBS 0.578f
C845 nr VSUBS 0.098f
C846 xs1n_cbn VSUBS 0.117f
C847 lsb_n xs0p_cbn 0.333f
C848 bp4 cp12 0.0372f
C849 bn10 VSUBS 0.113f
C850 xc4_dip VSUBS 0.474f
C851 bp8 bn10 0.0627f
C852 top_n VSUBS 0.388f
C853 cp12 VSUBS 0.422f
C854 bp8 VSUBS 1.18f
C855 bn12 VSUBS 0.0375f
C856 cn12 VSUBS 0.0752f
C857 trk1 cn2 0.158f
C858 t0b cp7 0.256f
C859 xc5_lt VSUBS 0.288f
C860 t1b bn4 0.522f
C861 xc5_outpb VSUBS 0.11f
C862 xc5_outpb VSUBS 0.261f
C863 xs1n_cbp VSUBS 0.0857f
C864 xs0n_g VSUBS 0.0646f
C865 bp5 VSUBS 0.22f
C866 xc5_xs1_tail VSUBS 0.0911f
C867 cn0 cn2 0.179f
C868 bp10 VSUBS 0.173f
C869 xs1p_cbn op 0.0681f
C870 xs0p_x xs0n_cbn 0.232f
C871 top_n bn4 0.197f
C872 cn9 VSUBS 0.0928f
C873 rstb VSUBS 0.0702f
C874 gnd xc4_outpb 0.863f
C875 xs0n_g VSUBS 0.224f
C876 bn12 cn5 0.0757f
C877 bn3 bn4 0.0697f
C878 bp0 VSUBS 0.276f
C879 cn12 bp7 0.536f
C880 bp9 VSUBS 0.3f
C881 xc5_dip VSUBS 0.235f
C882 bn9 VSUBS 0.275f
C883 xs0p_g VSUBS 0.183f
C884 cp7 VSUBS 0.117f
C885 xc5_outnb VSUBS 0.171f
C886 vbp xc5_outnb 0.164f
C887 bn10 xc4_xs1_tail 0.065f
C888 rstb xc4_xs1_tail0 0.0305f
C889 cp3 t1 0.247f
C890 cn0 xc5_dip 0.0677f
C891 xc5_xs1_tail xs0n_cbn 0.108f
C892 onp VSUBS 0.0821f
C893 cn9 vbn 0.0675f
C894 xc4_outpb VSUBS 0.135f
C895 in1p VSUBS 0.104f
C896 t1 VSUBS 0.236f
C897 cp6 xc4_lt 0.158f
C898 top_p VSUBS 0.0623f
C899 cp5 xs0p_n10 0.12f
C900 bn11 VSUBS 0.186f
C901 xs0p_n10 VSUBS 0.028f
C902 bp10 VSUBS 0.173f
C903 nr VSUBS 0.422f
C904 bp1 VSUBS 0.227f
C905 top_n cp0 0.0404f
C906 cp12 VSUBS 0.0771f
C907 cn0 VSUBS 0.15f
C908 xs1p_g cp10 0.482f
C909 bn9 VSUBS 0.113f
C910 in0p VSUBS 0.503f
C911 bn3 bn5 0.202f
C912 bn0 VSUBS 0.229f
C913 xs0n_n10 VSUBS 0.11f
C914 clknb VSUBS 0.0147f
C915 cp10 VSUBS 0.303f
C916 bn0 cn2 0.0461f
C917 cp12 VSUBS 0.0602f
C918 xc5_din VSUBS 0.118f
C919 xs1p_n10 VSUBS 0.107f
C920 cn6 xs1n_g 0.154f
C921 bp4 VSUBS 0.168f
C922 on bp8 0.258f
C923 vbp VSUBS 0.111f
C924 cp9 VSUBS 0.0688f
C925 cp2 VSUBS 0.102f
C926 cn12 VSUBS 0.17f
C927 in0n bn3 0.704f
C928 cn1 xc5_xs1_tail 0.222f
C929 rstb VSUBS 0.148f
C930 trk1 VSUBS 0.142f
C931 xs1n_cbn VSUBS 0.0421f
C932 xc5_dip VSUBS 0.772f
C933 cp5 VSUBS 0.0422f
C934 top_p in0p 0.114f
C935 cn4 VSUBS 0.0746f
C936 xs0n_x VSUBS 0.31f
C937 xs0n_g VSUBS 0.108f
C938 bp6 VSUBS 0.469f
C939 xs0p_cbp VSUBS 0.156f
C940 op xc4_xs1_tail 0.334f
C941 xs0n_x VSUBS 0.102f
C942 cn4 VSUBS 0.0407f
C943 vbn xs0n_x 0.0716f
C944 xc4_outpb bn12 0.471f
C945 bp10 rstb 0.212f
C946 xs0n_cbp cp10 0.0731f
C947 xc5_lt VSUBS 0.178f
C948 xc5_dip on 0.101f
C949 bn5 VSUBS 0.188f
C950 cn0 VSUBS 0.18f
C951 xs1n_g xc5_din 0.299f
C952 bn10 VSUBS 0.441f
C953 xc4_xs1_tail cp12 0.0801f
C954 xc4_outpb VSUBS 0.244f
C955 cp5 VSUBS 0.089f
C956 cp4 trk1 0.209f
C957 xc5_outnb bn5 0.0426f
C958 bn4 bn7 0.0585f
C959 cn6 cn0 0.0682f
C960 vdd VSUBS 0.12f
C961 t1b cn0 0.066f
C962 cp9 xc5_outpb 0.56f
C963 onn VSUBS 0.451f
C964 bn10 VSUBS 0.259f
C965 bn1 bp11 0.134f
C966 cp4 VSUBS 0.0299f
C967 t1b VSUBS 0.256f
C968 cn3 VSUBS 0.196f
C969 cn4 VSUBS 0.106f
C970 xc5_outpb VSUBS 0.378f
C971 bn1 VSUBS 0.121f
C972 cn9 VSUBS 0.557f
C973 xc5_xs1_tail0 xc4_lt 0.278f
C974 in1n VSUBS 0.274f
C975 xs1n_n10 VSUBS 0.187f
C976 cp9 VSUBS 0.144f
C977 t1b cp1 0.908f
C978 cn4 bp5 0.0506f
C979 cp6 xc4_outpb 0.447f
C980 trk1 xs1n_n10 0.0899f
C981 bp6 bp12 0.0646f
C982 in0p VSUBS 0.126f
C983 bp6 cn9 0.546f
C984 trk0 cp12 0.382f
C985 xs1n_n10 op 0.0723f
C986 xc5_din VSUBS 0.556f
C987 bp4 VSUBS 0.0754f
C988 xc4_din VSUBS 0.0782f
C989 cn1 VSUBS 0.343f
C990 trk0 VSUBS 0.15f
C991 xs0n_x VSUBS 0.21f
C992 xs0p_g VSUBS 0.325f
C993 bp4 VSUBS 0.145f
C994 cn0 t0 0.488f
C995 cp11 VSUBS 0.197f
C996 cn8 VSUBS 0.0627f
C997 lsb_n VSUBS 0.135f
C998 rstb_n VSUBS 0.0333f
C999 bp12 vdd 0.62f
C1000 bp5 xc4_outpb 0.26f
C1001 lsb_p VSUBS 0.0525f
C1002 vbp cp0 0.0718f
C1003 xs1p_cbp VSUBS 0.227f
C1004 bn7 trk0 0.314f
C1005 in1n VSUBS 0.237f
C1006 bp8 VSUBS 0.241f
C1007 t0b VSUBS 0.0952f
C1008 t0 cn12 0.111f
C1009 bn5 VSUBS 0.188f
C1010 xc4_xs1_tail bp0 0.244f
C1011 xs1n_cbn VSUBS 0.173f
C1012 xs0p_g bn7 0.0517f
C1013 on xs1n_g 0.354f
C1014 xs0n_cbp VSUBS 0.366f
C1015 bn1 VSUBS 0.282f
C1016 cp10 VSUBS 0.089f
C1017 bn1 VSUBS 0.0347f
C1018 t0b cn4 0.143f
C1019 cn0 VSUBS 0.183f
C1020 op VSUBS 0.22f
C1021 xs0n_g VSUBS 0.0584f
C1022 xs0p_g VSUBS 0.299f
C1023 trk0 VSUBS 0.21f
C1024 xs0n_x VSUBS 0.168f
C1025 xs1p_n10 VSUBS 0.0395f
C1026 xc5_xs1_tail0 VSUBS 0.619f
C1027 cp5 VSUBS 0.203f
C1028 xs1n_x xs1p_cbp 0.326f
C1029 cn10 xc5_xs1_tail 0.276f
C1030 xs0p_x VSUBS 0.136f
C1031 xc5_xs1_tail xc4_lt 0.0959f
C1032 xs0n_x VSUBS 0.0904f
C1033 xs1p_x VSUBS 0.262f
C1034 bp3 VSUBS 0.201f
C1035 xc4_outpb top_n 0.228f
C1036 cp2 cn0 0.256f
C1037 rstb VSUBS 0.148f
C1038 xs0n_n10 cn4 0.0721f
C1039 cp8 VSUBS 0.259f
C1040 clkn VSUBS 0.119f
C1041 xc4_xs1_tail top_n 0.0596f
C1042 t1 xc4_outnb 0.588f
C1043 xs0n_x VSUBS 0.0917f
C1044 cn6 VSUBS 0.109f
C1045 bn4 VSUBS 0.19f
C1046 cp10 xs1p_cbn 0.0392f
C1047 cn0 trk1 0.0679f
C1048 lsb_n VSUBS 0.11f
C1049 xs0p_g VSUBS 0.148f
C1050 xs1p_g xc5_xs1_tail0 0.129f
C1051 xs1n_x VSUBS 0.215f
C1052 t0 VSUBS 0.18f
C1053 xs1p_cbn cn6 1.13f
C1054 cp12 xc5_outpb 0.106f
C1055 cn12 VSUBS 0.323f
C1056 cp6 cn3 0.127f
C1057 xs0p_g VSUBS 0.0967f
C1058 trk1 xs0n_cbn 0.236f
C1059 bn2 bp5 0.251f
C1060 on cn5 0.594f
C1061 cp4 VSUBS 0.126f
C1062 bn9 cp1 0.0679f
C1063 cp5 VSUBS 0.34f
C1064 cp4 VSUBS 0.0583f
C1065 cn12 VSUBS 0.376f
C1066 cp2 VSUBS 0.605f
C1067 cp5 VSUBS 0.0866f
C1068 clkb xs0p_cbn 0.204f
C1069 cn2 VSUBS 0.24f
C1070 bp5 xs1p_cbn 0.0917f
C1071 cp1 VSUBS 0.212f
C1072 cn11 VSUBS 0.676f
C1073 op VSUBS 0.244f
C1074 bn5 VSUBS 0.176f
C1075 rstb xc4_xs1_tail0 0.151f
C1076 cn11 bp10 0.0631f
C1077 xc4_lt VSUBS 0.207f
C1078 xs1p_g xs0p_cbn 0.109f
C1079 xs0n_n10 VSUBS 0.177f
C1080 cn4 in0n 0.0698f
C1081 xc5_outpb VSUBS 0.578f
C1082 cn8 VSUBS 0.204f
C1083 xc5_xs1_tail0 vref 0.15f
C1084 cp1 VSUBS 0.237f
C1085 bn4 bn6 0.0481f
C1086 cp10 VSUBS 0.335f
C1087 top_n VSUBS 0.25f
C1088 cp1 trk0 0.205f
C1089 cp0 cn9 0.292f
C1090 xc4_xs1_tail0 VSUBS 0.0681f
C1091 bp0 nr 0.155f
C1092 vrefl VSUBS 0.105f
C1093 bn8 VSUBS 0.0736f
C1094 gnd VSUBS 0.374f
C1095 cp2 VSUBS 0.256f
C1096 xs0n_x VSUBS 0.175f
C1097 xs0p_g VSUBS 0.289f
C1098 xs1n_x VSUBS 0.204f
C1099 cn3 VSUBS 0.236f
C1100 in0p VSUBS 0.109f
C1101 cp10 VSUBS 0.212f
C1102 xs0n_cbp VSUBS 0.197f
C1103 bp12 VSUBS 0.242f
C1104 bn4 VSUBS 0.193f
C1105 cn2 VSUBS 0.252f
C1106 bn8 VSUBS 0.0313f
C1107 xc5_outnb VSUBS 0.137f
C1108 cp2 bp3 0.0817f
C1109 xs0n_cbp VSUBS 0.0767f
C1110 bn7 VSUBS 0.14f
C1111 in0n VSUBS 0.0428f
C1112 bn12 VSUBS 0.816f
C1113 xs0n_x VSUBS 0.223f
C1114 clkn VSUBS 0.595f
C1115 vref VSUBS 0.221f
C1116 vbn bn12 0.31f
C1117 cp4 bn4 0.235f
C1118 bp8 xs0p_x 0.0696f
C1119 xs1p_n10 VSUBS 0.0745f
C1120 cn8 bn5 0.149f
C1121 xs0p_cbn bp9 0.293f
C1122 bn0 xs1n_cbp 0.0549f
C1123 cn1 xc4_dip 0.281f
C1124 bp2 VSUBS 0.153f
C1125 bp6 xs1n_n10 0.155f
C1126 xc5_xs1_tail bn2 0.114f
C1127 cn10 VSUBS 0.11f
C1128 cn11 VSUBS 0.183f
C1129 cp12 VSUBS 0.223f
C1130 cn4 VSUBS 0.178f
C1131 cp12 VSUBS 0.176f
C1132 clknb VSUBS 0.151f
C1133 cp4 VSUBS 0.255f
C1134 cp2 bn7 0.0932f
C1135 xc5_xs1_tail VSUBS 0.0682f
C1136 in1n bp6 0.196f
C1137 bp5 VSUBS 0.0568f
C1138 cp9 cp3 0.0959f
C1139 nr VSUBS 0.188f
C1140 in1n VSUBS 0.119f
C1141 bp1 bn8 0.0723f
C1142 bn11 bn2 0.405f
C1143 onn VSUBS 0.126f
C1144 bn3 VSUBS 0.107f
C1145 onp VSUBS 0.0754f
C1146 xs0n_g xc5_dip 0.17f
C1147 top_n t1 0.0487f
C1148 cp2 VSUBS 0.0463f
C1149 t0b VSUBS 0.203f
C1150 cn1 VSUBS 0.215f
C1151 cn2 cn7 0.102f
C1152 xc5_lt xs1n_x 0.24f
C1153 xs0n_cbn xc5_xs1_tail 0.149f
C1154 clknb VSUBS 0.695f
C1155 trk0 VSUBS 0.0807f
C1156 cp8 VSUBS 0.107f
C1157 cn5 VSUBS 0.276f
C1158 xc4_din top_n 0.171f
C1159 bn7 VSUBS 0.472f
C1160 bp8 VSUBS 0.332f
C1161 cp7 VSUBS 0.0895f
C1162 cn0 VSUBS 0.133f
C1163 bn3 xs1n_g 0.155f
C1164 cp0 VSUBS 0.102f
C1165 xc4_outpb cn7 0.233f
C1166 bn8 VSUBS 0.11f
C1167 cn2 xc5_xs1_tail 0.218f
C1168 xs1n_n10 VSUBS 0.199f
C1169 bn9 VSUBS 0.361f
C1170 clkn VSUBS 0.256f
C1171 xs1n_g xc4_outnb 0.393f
C1172 vbp xc4_xs1_tail 0.169f
C1173 xc5_dip VSUBS 0.0815f
C1174 cn7 bp10 0.0744f
C1175 cn0 cn12 0.0909f
C1176 bp1 vref 0.04f
C1177 bn10 VSUBS 0.123f
C1178 bn10 cp0 0.288f
C1179 cp10 xc5_outnb 0.229f
C1180 cp12 xc4_dip 0.228f
C1181 in1n VSUBS 0.0954f
C1182 cn3 VSUBS 0.053f
C1183 bn12 VSUBS 0.153f
C1184 cp11 VSUBS 0.194f
C1185 cp7 VSUBS 0.104f
C1186 cp9 lsb_n 0.177f
C1187 xs1n_n10 VSUBS 0.09f
C1188 xs0p_cbn trk0 0.0823f
C1189 cp5 xc4_din 0.459f
C1190 bn1 VSUBS 0.42f
C1191 clk cp7 0.0907f
C1192 xs1p_cbn on 0.0162f
C1193 cp9 cp9 0.0726f
C1194 in1p xs0p_n10 0.228f
C1195 bn12 cp2 0.258f
C1196 bn2 VSUBS 0.0755f
C1197 xc4_lt VSUBS 0.11f
C1198 bn2 cn5 0.36f
C1199 xs1p_n10 VSUBS 0.225f
C1200 xs0n_g VSUBS 0.0865f
C1201 trk0 VSUBS 0.255f
C1202 bp5 VSUBS 0.144f
C1203 xc5_dip VSUBS 0.034f
C1204 cp0 VSUBS 0.153f
C1205 in1n vbp 0.0524f
C1206 xs0n_n10 VSUBS 0.191f
C1207 cp6 VSUBS 0.18f
C1208 vbp VSUBS 0.307f
C1209 xs0n_g VSUBS 0.224f
C1210 top_p bn12 0.149f
C1211 cp4 in0n 0.053f
C1212 vrefl cn6 0.0542f
C1213 xs1p_g VSUBS 0.828f
C1214 bn8 VSUBS 0.0486f
C1215 bp5 VSUBS 0.251f
C1216 on cn8 0.12f
C1217 bn3 VSUBS 0.16f
C1218 xc4_xs1_tail VSUBS 0.0146f
C1219 xs1p_cbp VSUBS 0.092f
C1220 cn2 VSUBS 1.03f
C1221 lsb_p VSUBS 0.586f
C1222 clk VSUBS 0.538f
C1223 xs1n_x VSUBS 0.275f
C1224 xs0n_g VSUBS 0.0338f
C1225 bn11 VSUBS 0.66f
C1226 cn6 VSUBS 0.08f
C1227 xc4_lt VSUBS 0.163f
C1228 cp6 VSUBS 0.138f
C1229 bn7 VSUBS 0.696f
C1230 bp10 VSUBS 1.2f
C1231 bp1 VSUBS 0.119f
C1232 bp7 xs0n_cbn 0.0709f
C1233 bn0 bn0 0.158f
C1234 xc5_lt bp5 0.291f
C1235 xs1p_cbp cn4 0.0393f
C1236 xs1n_n10 xs1p_g 0.0999f
C1237 xc5_outnb VSUBS 0.0826f
C1238 xs1p_cbp VSUBS 0.143f
C1239 xs0p_n10 VSUBS 0.179f
C1240 xc5_lt VSUBS 0.272f
C1241 bn0 VSUBS 0.0812f
C1242 cn2 cp3 0.22f
C1243 cp1 VSUBS 0.376f
C1244 xs1n_cbn xs0p_x 0.496f
C1245 bp4 in1n 0.135f
C1246 bn4 xc5_din 0.123f
C1247 xc4_din VSUBS 0.144f
C1248 xs0p_g VSUBS 0.166f
C1249 clk cp5 0.0858f
C1250 bp9 VSUBS 0.0509f
C1251 cn1 cn10 0.287f
C1252 trk0 VSUBS 0.0688f
C1253 bp3 VSUBS 0.109f
C1254 in1p VSUBS 0.0893f
C1255 cn4 VSUBS 0.0702f
C1256 vref VSUBS 0.0494f
C1257 xs1n_n10 xc4_din 0.243f
C1258 vrefl VSUBS 0.125f
C1259 xs1n_n10 xc5_outpb 0.0632f
C1260 bp6 cn6 0.261f
C1261 op VSUBS 0.12f
C1262 t1b VSUBS 0.106f
C1263 vbp VSUBS 0.124f
C1264 clk VSUBS 0.0527f
C1265 cp4 VSUBS 0.16f
C1266 bp8 xs1p_cbn 0.154f
C1267 xc4_xs1_tail0 xc4_outnb 0.0547f
C1268 xc5_din cn6 0.0871f
C1269 bp4 vrefl 0.265f
C1270 cn9 xs1p_n10 0.0901f
C1271 vbp bn7 0.0902f
C1272 in0n cp2 0.247f
C1273 bp3 VSUBS 0.0469f
C1274 xc4_xs1_tail VSUBS 0.267f
C1275 bn4 VSUBS 0.483f
C1276 cn1 VSUBS 0.0177f
C1277 xs1n_cbp cp12 0.209f
C1278 xc4_din VSUBS 0.0614f
C1279 t0 VSUBS 0.207f
C1280 bn10 VSUBS 0.289f
C1281 xs0p_cbp xs1n_cbn 0.414f
C1282 cp12 cn11 0.135f
C1283 top_n cp1 0.169f
C1284 xs0n_n10 VSUBS 0.172f
C1285 on xs0n_g 0.033f
C1286 cp9 VSUBS 0.218f
C1287 cp9 in0p 0.0876f
C1288 cn8 VSUBS 0.132f
C1289 xs1p_cbn cp10 0.228f
C1290 xc5_dip cp3 0.0512f
C1291 cn9 VSUBS 0.0864f
C1292 cn5 VSUBS 0.185f
C1293 cn9 cn9 0.202f
C1294 trk0 VSUBS 0.0895f
C1295 cn7 VSUBS 0.0411f
C1296 t0b xs1n_cbn 0.0585f
C1297 bn12 VSUBS 0.119f
C1298 xc5_dip xs1p_g 0.0276f
C1299 top_n bn5 0.123f
C1300 bn12 bp9 0.39f
C1301 vrefl on 0.191f
C1302 xs0p_x VSUBS 0.17f
C1303 bn3 VSUBS 0.253f
C1304 bn9 in1p 0.0685f
C1305 xs1p_g VSUBS 0.228f
C1306 bp9 VSUBS 0.393f
C1307 cp4 VSUBS 0.444f
C1308 xs0n_cbn VSUBS 0.22f
C1309 xc5_xs1_tail0 xc4_xs1_tail0 0.0173f
C1310 cn5 cp12 0.0839f
C1311 xc4_outnb VSUBS 0.242f
C1312 op xs1p_g 0.202f
C1313 bn9 VSUBS 0.153f
C1314 bp9 VSUBS 0.331f
C1315 cp9 xs1n_cbp 0.275f
C1316 bp8 VSUBS 0.379f
C1317 bn5 cn2 0.162f
C1318 bn5 VSUBS 0.157f
C1319 op VSUBS 0.218f
C1320 xs0n_cbn VSUBS 0.122f
C1321 bn6 xs0p_n10 0.313f
C1322 trk0 lsb_p 0.344f
C1323 cn2 VSUBS 0.516f
C1324 vbp VSUBS 0.175f
C1325 xs0p_cbn VSUBS 0.0919f
C1326 bp1 VSUBS 0.0681f
C1327 clknb bp9 0.204f
C1328 in0n cn5 0.0295f
C1329 trk0 op 0.652f
C1330 cp2 xs0n_n10 0.0664f
C1331 in1p VSUBS 0.135f
C1332 bn5 cn1 0.428f
C1333 t0 xs0p_cbn 0.168f
C1334 bn12 cn0 0.0536f
C1335 cn6 VSUBS 0.158f
C1336 in0n VSUBS 0.0703f
C1337 in0n VSUBS 0.161f
C1338 bp11 cp10 0.262f
C1339 bn1 VSUBS 0.263f
C1340 xs1n_cbn VSUBS 0.0921f
C1341 xs0n_n10 VSUBS 0.0919f
C1342 xs1n_g onp 0.14f
C1343 cn11 VSUBS 0.178f
C1344 in1p VSUBS 0.2f
C1345 lsb_p VSUBS 0.176f
C1346 clknb VSUBS 0.0733f
C1347 t0 VSUBS 0.0369f
C1348 xs1n_g VSUBS 0.376f
C1349 trk0 VSUBS 0.179f
C1350 xs0n_cbp VSUBS 0.0745f
C1351 top_p bp2 0.415f
C1352 xs0n_cbp VSUBS 0.0666f
C1353 xc4_outnb VSUBS 0.201f
C1354 top_p VSUBS 0.0793f
C1355 onn VSUBS 0.153f
C1356 bp12 VSUBS 0.228f
C1357 bn9 bn12 0.0672f
C1358 xc5_lt cn1 0.128f
C1359 cp3 VSUBS 0.264f
C1360 cn3 top_n 0.156f
C1361 xs0n_g VSUBS 0.0783f
C1362 t1b on 0.141f
C1363 xs0p_cbp VSUBS 0.272f
C1364 cn6 VSUBS 0.11f
C1365 bp10 VSUBS 0.112f
C1366 xs0n_cbn VSUBS 0.147f
C1367 xs0p_x VSUBS 0.207f
C1368 xs0p_x VSUBS 0.331f
C1369 xs1p_n10 cn5 0.118f
C1370 cn2 cp6 0.0544f
C1371 xc5_outnb VSUBS 0.151f
C1372 cp8 VSUBS 0.125f
C1373 cn5 VSUBS 0.0912f
C1374 cp10 bn3 0.15f
C1375 xc4_outnb VSUBS 0.0922f
C1376 xc5_xs1_tail cp10 0.0344f
C1377 top_p VSUBS 0.174f
C1378 xs1n_x VSUBS 0.0748f
C1379 xs1p_cbp xc4_xs1_tail0 0.28f
C1380 cp12 VSUBS 0.225f
C1381 onn VSUBS 0.0109f
C1382 xc5_outpb VSUBS 0.071f
C1383 xc4_outpb VSUBS 0.171f
C1384 cn3 cp2 0.0528f
C1385 xc4_din xs0p_x 0.103f
C1386 cn1 trk0 0.1f
C1387 cn3 op 0.12f
C1388 bn10 VSUBS 0.107f
C1389 bp7 VSUBS 0.204f
C1390 xs1p_n10 cp1 0.325f
C1391 bn3 VSUBS 0.051f
C1392 vdd cp8 0.229f
C1393 xs1n_cbn VSUBS 0.368f
C1394 xc5_xs1_tail0 xs0n_x 0.183f
C1395 xs1n_cbn VSUBS 0.0598f
C1396 xs0n_cbp xs1p_cbn 0.128f
C1397 vdd VSUBS 0.401f
C1398 clk VSUBS 0.296f
C1399 xc4_xs1_tail VSUBS 0.0927f
C1400 in0p VSUBS 0.146f
C1401 bp12 VSUBS 0.391f
C1402 cp5 VSUBS 0.102f
C1403 nr VSUBS 0.0996f
C1404 bn8 VSUBS 0.0741f
C1405 top_p VSUBS 0.172f
C1406 bn10 VSUBS 0.799f
C1407 xc5_lt t1 0.17f
C1408 cn5 bn8 0.0798f
C1409 cp7 xs0n_g 0.103f
C1410 vref bp10 0.446f
C1411 xs1n_g VSUBS 0.123f
C1412 bn5 bp1 0.0357f
C1413 rstb xs0p_g 0.361f
C1414 onn VSUBS 0.0977f
C1415 lsb_p cn5 0.108f
C1416 xc5_xs1_tail0 cp8 0.246f
C1417 cp1 cn9 0.0347f
C1418 bn9 VSUBS 0.141f
C1419 xc5_din bp11 0.197f
C1420 xc5_outpb xs1p_g 0.44f
C1421 vref VSUBS 0.128f
C1422 xc4_outpb VSUBS 0.122f
C1423 cp3 VSUBS 0.182f
C1424 cn4 VSUBS 0.0425f
C1425 bn1 VSUBS 0.147f
C1426 vbn cp3 0.543f
C1427 bn3 VSUBS 0.0885f
C1428 trk1 VSUBS 0.487f
C1429 xc4_lt VSUBS 0.0959f
C1430 bp4 VSUBS 0.0702f
C1431 t1 VSUBS 0.477f
C1432 xc4_xs1_tail xs0n_g 0.127f
C1433 xc5_xs1_tail VSUBS 0.162f
C1434 cn10 on 0.284f
C1435 cn2 VSUBS 0.244f
C1436 cp4 cn2 0.0635f
C1437 cp9 VSUBS 0.108f
C1438 in1p xc4_dip 0.0629f
C1439 t1 VSUBS 0.293f
C1440 bp3 bp8 0.138f
C1441 bn12 bn6 0.7f
C1442 cp9 VSUBS 0.118f
C1443 xc4_outnb xs1n_cbp 0.103f
C1444 bn4 VSUBS 0.162f
C1445 bp9 VSUBS 0.21f
C1446 cn4 VSUBS 0.341f
C1447 bp0 cn7 0.026f
C1448 cp5 VSUBS 0.0926f
C1449 xc4_outpb VSUBS 0.0643f
C1450 xc4_din VSUBS 0.0304f
C1451 xc4_din VSUBS 0.0723f
C1452 bp3 xs1p_g 0.248f
C1453 bp6 VSUBS 0.0836f
C1454 t0 cn1 0.169f
C1455 bp0 VSUBS 0.129f
C1456 xc5_xs1_tail xs0p_cbp 0.134f
C1457 bp12 VSUBS 0.741f
C1458 cp6 VSUBS 0.208f
C1459 top_p VSUBS 0.469f
C1460 t0b bp0 0.413f
C1461 bp12 VSUBS 0.028f
C1462 cn5 xc4_lt 0.117f
C1463 cp4 VSUBS 0.0871f
C1464 xs1n_cbn clknb 0.0815f
C1465 in0n VSUBS 0.615f
C1466 cp10 lsb_n 0.508f
C1467 cp12 VSUBS 0.0793f
C1468 on VSUBS 0.0275f
C1469 vbn cn11 1.04f
C1470 bn8 VSUBS 0.245f
C1471 in1p VSUBS 0.107f
C1472 t0b VSUBS 0.553f
C1473 vbn VSUBS 0.207f
C1474 bp4 cp9 0.45f
C1475 bp0 VSUBS 0.118f
C1476 in0p rstb 0.201f
C1477 rstb_n VSUBS 0.317f
C1478 cp7 xs0p_cbn 0.169f
C1479 nr VSUBS 0.135f
C1480 xc5_dip VSUBS 0.172f
C1481 cn11 VSUBS 0.521f
C1482 bp4 VSUBS 0.146f
C1483 cn6 VSUBS 0.489f
C1484 trk0 xs1p_n10 0.258f
C1485 xs0p_cbn VSUBS 1.48f
C1486 bn7 VSUBS 0.44f
C1487 cn3 bp3 0.378f
C1488 bp9 VSUBS 0.137f
C1489 xs0p_cbp cn1 0.0257f
C1490 bp4 VSUBS 0.103f
C1491 cn0 VSUBS 0.0651f
C1492 cp3 VSUBS 0.0978f
C1493 xs0n_x xc5_din 0.237f
C1494 t0b VSUBS 0.24f
C1495 xs1p_g VSUBS 0.389f
C1496 onp VSUBS 0.313f
C1497 bn9 VSUBS 0.0977f
C1498 in0p VSUBS 0.137f
C1499 clkb VSUBS 0.231f
C1500 xs1n_cbn cp2 0.0968f
C1501 in0p VSUBS 0.0702f
C1502 bn2 VSUBS 0.271f
C1503 xs0p_cbn cp8 0.206f
C1504 xc4_xs1_tail VSUBS 0.0852f
C1505 xc5_xs1_tail0 VSUBS 0.139f
C1506 xc5_xs1_tail VSUBS 0.034f
C1507 xs0n_cbn VSUBS 0.428f
C1508 clknb cp5 0.0948f
C1509 in1n bp4 0.0974f
C1510 xs1n_n10 xc5_xs1_tail 0.0484f
C1511 clkb VSUBS 0.361f
C1512 top_n VSUBS 0.472f
C1513 bn4 VSUBS 0.201f
C1514 xs0p_cbn VSUBS 0.0963f
C1515 xc4_lt on 0.133f
C1516 bp1 xs1p_x 0.0875f
C1517 clkn VSUBS 0.239f
C1518 cn1 bn3 0.154f
C1519 xs1n_g bn1 0.184f
C1520 cn11 VSUBS 0.0688f
C1521 xs1n_n10 VSUBS 0.591f
C1522 cp8 VSUBS 0.113f
C1523 xc5_din VSUBS 0.0817f
C1524 in0p vbn 0.0525f
C1525 xc5_xs1_tail0 VSUBS 0.256f
C1526 vbn xs1p_cbp 0.357f
C1527 in0n cn8 0.256f
C1528 cn12 VSUBS 0.13f
C1529 cn12 VSUBS 0.0784f
C1530 bp9 vbn 0.0689f
C1531 t0 cn4 0.144f
C1532 bn0 VSUBS 0.172f
C1533 cn1 VSUBS 0.0798f
C1534 xs1p_g VSUBS 0.0918f
C1535 gnd VSUBS 0.161f
C1536 bp3 VSUBS 0.0306f
C1537 xs1p_cbp VSUBS 0.162f
C1538 vdd xs1p_x 0.29f
C1539 xs0p_g VSUBS 0.283f
C1540 bp5 VSUBS 0.0969f
C1541 cp12 VSUBS 0.372f
C1542 bp3 cn4 0.0712f
C1543 onn lsb_p 0.201f
C1544 bp11 VSUBS 0.482f
C1545 top_n VSUBS 0.568f
C1546 clkn VSUBS 0.171f
C1547 gnd bp2 0.123f
C1548 xs1p_x VSUBS 0.104f
C1549 xs1n_n10 bp12 0.216f
C1550 top_n VSUBS 0.0727f
C1551 xs1n_n10 VSUBS 0.319f
C1552 cn3 xc5_dip 0.692f
C1553 bp4 VSUBS 0.124f
C1554 bp3 xc5_din 0.0584f
C1555 cp1 VSUBS 0.151f
C1556 in1p VSUBS 0.131f
C1557 bn10 cp11 0.256f
C1558 cp9 VSUBS 0.144f
C1559 bp2 VSUBS 0.726f
C1560 xs0n_x cp5 0.297f
C1561 xs0p_cbp VSUBS 0.15f
C1562 cp11 VSUBS 0.278f
C1563 bp6 VSUBS 0.181f
C1564 clk xs0n_n10 1.21f
C1565 cn4 VSUBS 0.0543f
C1566 nr VSUBS 0.089f
C1567 bp3 VSUBS 0.202f
C1568 bp0 VSUBS 0.0474f
C1569 op VSUBS 0.159f
C1570 cn7 VSUBS 0.259f
C1571 xs1n_cbn VSUBS 0.0589f
C1572 cn4 xs0n_cbp 0.218f
C1573 cn1 VSUBS 0.0748f
C1574 xs0n_cbp VSUBS 0.285f
C1575 vdd VSUBS 0.373f
C1576 xc5_outnb xs0p_n10 0.151f
C1577 xs0p_g VSUBS 0.0784f
C1578 xs0n_cbp VSUBS 0.243f
C1579 bn1 VSUBS 0.351f
C1580 bp11 in0n 0.107f
C1581 on xc5_outpb 0.165f
C1582 bp9 VSUBS 0.813f
C1583 xc5_xs1_tail VSUBS 0.11f
C1584 bp2 VSUBS 0.0855f
C1585 bn4 VSUBS 0.0877f
C1586 cp4 bp7 0.111f
C1587 cn10 VSUBS 0.152f
C1588 t1b bn5 0.0237f
C1589 vdd VSUBS 0.251f
C1590 lsb_n xc5_din 0.511f
C1591 vbp VSUBS 0.049f
C1592 t0 bn12 0.34f
C1593 in0p bn0 0.0628f
C1594 bn0 VSUBS 0.273f
C1595 bn2 VSUBS 0.39f
C1596 xs0p_n10 VSUBS 0.0332f
C1597 cn11 VSUBS 0.889f
C1598 xs1n_g VSUBS 0.0434f
C1599 trk1 VSUBS 0.284f
C1600 cn4 VSUBS 0.116f
C1601 bp3 VSUBS 0.0523f
C1602 xs1p_n10 bp4 0.149f
C1603 in1n cn1 0.118f
C1604 onn VSUBS 0.337f
C1605 cp3 onp 0.0896f
C1606 bp4 in1n 0.832f
C1607 trk1 VSUBS 0.0827f
C1608 xs1n_x VSUBS 0.0636f
C1609 bp9 VSUBS 0.0649f
C1610 xs0p_n10 VSUBS 0.077f
C1611 bp2 cp3 0.49f
C1612 onn VSUBS 0.115f
C1613 bn0 VSUBS 0.0827f
C1614 in0n xc4_xs1_tail 0.0306f
C1615 xs1p_cbn xs0n_cbp 0.0731f
C1616 xs1p_n10 bp5 0.029f
C1617 bp2 VSUBS 0.0457f
C1618 trk1 VSUBS 0.109f
C1619 bn5 xs0n_x 0.076f
C1620 t1 VSUBS 0.728f
C1621 xc5_dip t0b 0.233f
C1622 clkn bn7 0.0621f
C1623 xs1p_cbp VSUBS 0.138f
C1624 cp9 onp 0.102f
C1625 bn0 xc4_xs1_tail0 0.393f
C1626 cp4 VSUBS 0.0788f
C1627 xs0p_cbp VSUBS 0.217f
C1628 bp3 VSUBS 0.151f
C1629 xs1p_x vref 0.302f
C1630 bn6 xs1n_n10 0.0778f
C1631 cp11 cn12 0.158f
C1632 cn4 bp1 0.0929f
C1633 bn11 VSUBS 0.0515f
C1634 xs1p_cbn VSUBS 0.213f
C1635 bp2 cn8 0.0728f
C1636 cp8 VSUBS 0.0395f
C1637 cn2 cn12 0.0578f
C1638 xc4_outpb VSUBS 0.0635f
C1639 cn9 bp5 0.332f
C1640 xs1n_x VSUBS 0.126f
C1641 cn4 xc5_din 0.142f
C1642 cp12 VSUBS 0.168f
C1643 bp6 clkn 0.183f
C1644 cn11 t0 0.221f
C1645 cp6 in1n 0.112f
C1646 bn2 VSUBS 0.258f
C1647 clkb xs1p_cbn 0.2f
C1648 xs0p_n10 VSUBS 0.0498f
C1649 xc5_lt cn1 0.131f
C1650 in0p VSUBS 0.0561f
C1651 bp12 xs1n_cbn 0.109f
C1652 cp7 xs1p_cbp 0.0713f
C1653 bn6 VSUBS 0.25f
C1654 vbn xc5_outnb 0.0656f
C1655 cn0 xs0n_cbn 0.0552f
C1656 in0p VSUBS 0.0555f
C1657 xs1p_n10 t1b 0.116f
C1658 clkn VSUBS 0.0365f
C1659 cp5 VSUBS 0.39f
C1660 in0n VSUBS 0.0468f
C1661 bp10 VSUBS 0.257f
C1662 in0n VSUBS 0.126f
C1663 rstb_n VSUBS 0.0365f
C1664 xs1n_x VSUBS 0.167f
C1665 cp6 clkb 0.233f
C1666 xs1n_cbn xs1p_cbn 0.0744f
C1667 vbn xc5_din 0.116f
C1668 vrefl VSUBS 0.518f
C1669 bp7 xs0p_n10 0.295f
C1670 bp7 cn4 0.42f
C1671 onp VSUBS 0.613f
C1672 bp1 cn3 0.129f
C1673 xc5_dip VSUBS 0.601f
C1674 xs0p_n10 VSUBS 0.375f
C1675 xs1n_cbn cp8 0.567f
C1676 xs1p_cbn lsb_n 0.29f
C1677 onp VSUBS 0.104f
C1678 in0n VSUBS 0.26f
C1679 lsb_n VSUBS 0.0783f
C1680 gnd xc4_lt 0.163f
C1681 t1 VSUBS 0.174f
C1682 xc4_din VSUBS 0.336f
C1683 bn7 VSUBS 0.0441f
C1684 cn9 VSUBS 0.216f
C1685 xc4_xs1_tail VSUBS 0.331f
C1686 clkb xs0p_cbn 0.0802f
C1687 bn1 VSUBS 0.139f
C1688 xs1p_x VSUBS 0.279f
C1689 bp4 xs1p_cbp 0.225f
C1690 rstb_n cp0 0.27f
C1691 xs0p_g VSUBS 0.172f
C1692 t0 vbn 0.067f
C1693 clk clkn 0.177f
C1694 t1 VSUBS 0.247f
C1695 bn5 VSUBS 0.0766f
C1696 bp3 VSUBS 0.182f
C1697 xs1p_g VSUBS 0.216f
C1698 on VSUBS 0.135f
C1699 cn4 VSUBS 0.0851f
C1700 bp9 vbn 0.352f
C1701 xc4_xs1_tail0 bn10 0.287f
C1702 xc5_dip VSUBS 0.124f
C1703 xs0n_cbp cn2 0.0517f
C1704 bp0 VSUBS 0.21f
C1705 xs1n_cbp VSUBS 0.11f
C1706 clk VSUBS 0.148f
C1707 cp10 xs1n_cbp 0.0698f
C1708 bn1 VSUBS 0.0574f
C1709 cp9 cn8 0.3f
C1710 xs1p_cbn VSUBS 0.135f
C1711 bp8 vbp 0.374f
C1712 xs1p_g VSUBS 0.101f
C1713 bn0 VSUBS 0.0161f
C1714 bp12 xs1n_cbp 0.283f
C1715 xc4_xs1_tail0 xc4_xs1_tail 0.527f
C1716 t1 VSUBS 0.0993f
C1717 in0p VSUBS 0.109f
C1718 bp8 xc4_outpb 0.316f
C1719 bp1 VSUBS 0.205f
C1720 cp10 VSUBS 0.432f
C1721 bp11 VSUBS 0.0585f
C1722 xc4_outpb xs1p_n10 0.0388f
C1723 cp10 VSUBS 0.093f
C1724 cn6 VSUBS 0.126f
C1725 nr xs0p_cbp 0.779f
C1726 bp6 VSUBS 0.236f
C1727 bn8 VSUBS 0.21f
C1728 clk cn7 0.0546f
C1729 bn0 VSUBS 0.279f
C1730 xs0p_x cp1 0.204f
C1731 bn12 VSUBS 0.135f
C1732 cn3 VSUBS 0.306f
C1733 bp1 VSUBS 0.107f
C1734 cn3 VSUBS 0.172f
C1735 xc5_xs1_tail0 bp3 0.481f
C1736 onn xc5_xs1_tail 0.11f
C1737 xc4_outpb VSUBS 0.0514f
C1738 bn8 bn11 0.0951f
C1739 xc4_outnb VSUBS 0.25f
C1740 lsb_p VSUBS 0.399f
C1741 on lsb_p 0.259f
C1742 t1 cp7 0.0782f
C1743 xs1p_n10 VSUBS 0.0568f
C1744 bn12 VSUBS 0.0542f
C1745 xs1n_x VSUBS 0.0183f
C1746 xs1n_n10 cp9 0.0994f
C1747 vref VSUBS 0.0914f
C1748 cp4 cn8 0.22f
C1749 xs0p_n10 cn11 0.188f
C1750 xc5_din VSUBS 0.503f
C1751 xs0p_cbp VSUBS 0.701f
C1752 xs0n_g xc4_outnb 0.0133f
C1753 bp5 VSUBS 0.115f
C1754 cp6 VSUBS 0.106f
C1755 xc4_dip VSUBS 0.348f
C1756 cp6 VSUBS 0.224f
C1757 bn1 VSUBS 0.284f
C1758 vref cp7 0.141f
C1759 xc5_outpb op 0.237f
C1760 rstb VSUBS 0.0959f
C1761 bp12 VSUBS 0.12f
C1762 clkb VSUBS 0.468f
C1763 cp4 bp5 0.18f
C1764 xs0p_g VSUBS 0.054f
C1765 t1 VSUBS 0.0458f
C1766 in0n xs0p_x 0.414f
C1767 bp3 t0 0.312f
C1768 xc4_xs1_tail0 VSUBS 0.0664f
C1769 bp1 VSUBS 0.376f
C1770 onn VSUBS 0.312f
C1771 cp5 VSUBS 0.215f
C1772 cn8 VSUBS 0.0183f
C1773 cp3 bp1 0.0994f
C1774 op VSUBS 0.111f
C1775 xs1p_g VSUBS 0.112f
C1776 bp2 VSUBS 0.159f
C1777 cp4 xs0p_n10 0.359f
C1778 xs1p_x VSUBS 0.0535f
C1779 vref bp11 0.0491f
C1780 t1 cp2 0.118f
C1781 bn0 VSUBS 0.247f
C1782 cp6 VSUBS 0.227f
C1783 bp11 VSUBS 0.0799f
C1784 bp7 VSUBS 0.586f
C1785 cn11 VSUBS 0.162f
C1786 in0n VSUBS 0.248f
C1787 bp5 VSUBS 0.0688f
C1788 cp0 xc5_outnb 0.131f
C1789 cp8 cp7 0.149f
C1790 t0b VSUBS 0.176f
C1791 xs1n_cbn VSUBS 0.135f
C1792 cn0 VSUBS 0.155f
C1793 in1n VSUBS 0.11f
C1794 rstb VSUBS 0.249f
C1795 cn10 VSUBS 0.283f
C1796 xs1n_g VSUBS 0.185f
C1797 xs0p_x VSUBS 0.17f
C1798 vrefl bp11 0.194f
C1799 clknb xc4_outnb 0.386f
C1800 vdd clk 0.0859f
C1801 bp4 VSUBS 0.125f
C1802 trk1 VSUBS 0.241f
C1803 xc4_lt VSUBS 0.107f
C1804 in1n VSUBS 0.313f
C1805 bn11 VSUBS 0.404f
C1806 cp10 VSUBS 0.097f
C1807 onn VSUBS 0.14f
C1808 xc4_outnb VSUBS 0.602f
C1809 xc4_dip onn 0.267f
C1810 bp9 clkb 0.0538f
C1811 cp3 VSUBS 0.139f
C1812 clkn VSUBS 0.239f
C1813 xs0p_cbp VSUBS 0.159f
C1814 xs1n_cbp VSUBS 0.467f
C1815 cn7 cn9 0.351f
C1816 op xc4_din 0.517f
C1817 cn2 cn1 0.113f
C1818 xs1p_g xs0n_x 0.119f
C1819 bn7 VSUBS 1.31f
C1820 clkn cp1 0.31f
C1821 cn1 VSUBS 0.165f
C1822 cn7 lsb_n 0.0689f
C1823 clk VSUBS 0.0548f
C1824 bp1 VSUBS 0.214f
C1825 trk1 xs0p_n10 0.105f
C1826 xs0n_x VSUBS 0.274f
C1827 bn9 xc4_dip 0.276f
C1828 t1b VSUBS 0.293f
C1829 xc4_xs1_tail VSUBS 0.104f
C1830 bp11 VSUBS 0.0572f
C1831 op VSUBS 0.0211f
C1832 xs1p_g VSUBS 0.279f
C1833 bn5 t1b 0.191f
C1834 xs0p_g cn4 0.252f
C1835 t0b VSUBS 0.173f
C1836 xs1n_g VSUBS 0.0583f
C1837 cp6 bp4 0.0753f
C1838 vref bn0 0.132f
C1839 lsb_p bn12 0.0578f
C1840 in1p VSUBS 0.102f
C1841 bp5 VSUBS 0.105f
C1842 cn11 VSUBS 0.368f
C1843 bn8 VSUBS 0.198f
C1844 onp trk1 0.0588f
C1845 top_p rstb 0.0639f
C1846 bp4 VSUBS 0.0562f
C1847 rstb bp7 0.368f
C1848 xs0n_x VSUBS 0.106f
C1849 lsb_p VSUBS 0.0344f
C1850 xs1p_g VSUBS 0.307f
C1851 xs0n_cbp xs1n_g 0.247f
C1852 cn8 VSUBS 0.0877f
C1853 bp6 t1 0.108f
C1854 cp12 VSUBS 0.17f
C1855 lsb_p VSUBS 0.119f
C1856 xs0p_n10 bn5 0.17f
C1857 xs1p_cbp VSUBS 0.739f
C1858 cn10 VSUBS 0.452f
C1859 bn1 VSUBS 0.076f
C1860 cp0 VSUBS 0.218f
C1861 cp11 bn2 0.128f
C1862 cn3 cp11 0.054f
C1863 bp10 VSUBS 0.163f
C1864 cn0 xs0n_cbp 0.118f
C1865 cn7 VSUBS 0.29f
C1866 xs1p_cbp VSUBS 0.299f
C1867 cp7 bp9 0.161f
C1868 xs0p_n10 cp9 0.387f
C1869 cp0 VSUBS 0.113f
C1870 xc5_xs1_tail VSUBS 0.0734f
C1871 cn3 VSUBS 0.192f
C1872 xs0n_g VSUBS 0.214f
C1873 xc4_dip VSUBS 0.683f
C1874 xs0n_n10 VSUBS 0.177f
C1875 cp5 xs0n_n10 0.16f
C1876 in1p VSUBS 0.204f
C1877 xs0p_cbn VSUBS 0.0242f
C1878 onp VSUBS 0.293f
C1879 bn7 VSUBS 0.382f
C1880 bn4 onp 0.223f
C1881 xs1n_x VSUBS 0.14f
C1882 cp2 cn6 0.333f
C1883 xs1n_cbp op 0.255f
C1884 xs0p_x on 0.118f
C1885 cn5 VSUBS 0.106f
C1886 xc4_outnb VSUBS 0.152f
C1887 cp6 VSUBS 0.356f
C1888 cp1 cn5 0.23f
C1889 xc5_xs1_tail0 VSUBS 0.118f
C1890 xs0p_x VSUBS 0.0513f
C1891 bn12 VSUBS 0.0796f
C1892 trk1 lsb_p 0.0949f
C1893 rstb_n xc4_din 0.101f
C1894 xs1p_n10 bn9 0.198f
C1895 bp7 VSUBS 0.172f
C1896 cp7 VSUBS 0.209f
C1897 xc5_outnb VSUBS 0.117f
C1898 xc5_xs1_tail0 VSUBS 0.115f
C1899 xs0n_g bp7 0.133f
C1900 lsb_p VSUBS 0.123f
C1901 lsb_n VSUBS 0.159f
C1902 xs0n_g VSUBS 0.175f
C1903 bp8 xs0p_cbn 0.155f
C1904 cn11 VSUBS 0.0642f
C1905 on VSUBS 0.4f
C1906 xs1n_x cp7 0.333f
C1907 xc4_xs1_tail VSUBS 0.126f
C1908 clknb xs1p_cbn 0.0611f
C1909 cn0 VSUBS 0.333f
C1910 xs1n_cbp xs0p_cbn 0.123f
C1911 xc4_lt cp0 0.0516f
C1912 in1n VSUBS 0.0205f
C1913 xc5_dip cp3 0.423f
C1914 bp3 VSUBS 0.133f
C1915 bp8 VSUBS 0.297f
C1916 bp5 t0b 0.416f
C1917 cn2 VSUBS 0.0717f
C1918 bp10 cp3 0.0915f
C1919 clkb VSUBS 0.122f
C1920 bn7 VSUBS 0.15f
C1921 cn8 on 0.22f
C1922 cn11 VSUBS 0.512f
C1923 xs0p_cbp VSUBS 0.179f
C1924 lsb_n VSUBS 0.172f
C1925 cp5 VSUBS 0.167f
C1926 bn3 bn12 0.194f
C1927 cp12 VSUBS 0.789f
C1928 xs0n_g VSUBS 0.0236f
C1929 vref VSUBS 0.26f
C1930 in1p xs1n_g 0.061f
C1931 cn2 VSUBS 0.426f
C1932 top_p VSUBS 0.106f
C1933 xc4_outnb VSUBS 0.301f
C1934 xs0n_cbn bn5 0.745f
C1935 bn4 xc5_xs1_tail0 0.308f
C1936 xc4_xs1_tail0 VSUBS 0.405f
C1937 xs0n_cbn VSUBS 0.059f
C1938 xs0n_cbp xs0p_cbp 0.122f
C1939 bp8 VSUBS 0.331f
C1940 top_p cn10 0.183f
C1941 onn VSUBS 0.241f
C1942 bp2 cn1 0.0885f
C1943 vrefl top_p 0.0705f
C1944 bp6 VSUBS 0.437f
C1945 bn2 VSUBS 0.106f
C1946 cn6 xs0n_cbp 0.0468f
C1947 bn7 VSUBS 0.0822f
C1948 xc5_outpb cn0 0.0726f
C1949 xc4_xs1_tail0 VSUBS 0.0479f
C1950 xs0p_g onp 0.219f
C1951 clknb VSUBS 0.514f
C1952 xs0n_n10 VSUBS 0.243f
C1953 bn8 VSUBS 0.106f
C1954 bn4 VSUBS 0.23f
C1955 cn11 VSUBS 0.221f
C1956 in1n VSUBS 0.0832f
C1957 op VSUBS 0.0954f
C1958 in1p VSUBS 0.0232f
C1959 bp11 lsb_p 0.0671f
C1960 bp4 VSUBS 0.0636f
C1961 bp4 VSUBS 0.22f
C1962 cp1 VSUBS 0.149f
C1963 op xs1n_cbp 0.166f
C1964 bn4 VSUBS 0.341f
C1965 cp11 VSUBS 0.27f
C1966 cp8 cp12 0.341f
C1967 bn7 bp5 0.0455f
C1968 cp8 VSUBS 0.26f
C1969 xs1n_n10 xs0p_cbp 0.191f
C1970 bp12 vref 0.0734f
C1971 cp1 VSUBS 0.0949f
C1972 bn3 VSUBS 0.366f
C1973 lsb_n VSUBS 0.0914f
C1974 xc5_outnb VSUBS 0.24f
C1975 trk0 t1 0.131f
C1976 xs0p_n10 xc5_xs1_tail 0.0223f
C1977 nr VSUBS 0.0599f
C1978 gnd VSUBS 0.127f
C1979 bp3 bp12 0.0449f
C1980 vdd VSUBS 0.272f
C1981 t0 VSUBS 0.594f
C1982 cp9 xc5_din 0.0655f
C1983 t0b VSUBS 0.238f
C1984 clkn VSUBS 0.115f
C1985 bn5 VSUBS 0.0931f
C1986 t0 xc5_outpb 0.304f
C1987 xs0p_cbn lsb_n 0.0884f
C1988 bn12 cp0 0.0763f
C1989 xs1n_cbn onp 0.145f
C1990 xs0p_cbp VSUBS 0.0578f
C1991 cp4 VSUBS 0.214f
C1992 cn3 VSUBS 0.131f
C1993 cn0 VSUBS 0.122f
C1994 xs0p_x VSUBS 0.281f
C1995 xs0n_x VSUBS 0.168f
C1996 xs1n_n10 VSUBS 0.0565f
C1997 t1b VSUBS 0.0672f
C1998 xs1p_x cp1 0.117f
C1999 in0n xs1n_x 0.163f
C2000 xs1n_n10 VSUBS 0.148f
C2001 bp5 VSUBS 0.208f
C2002 in1n VSUBS 0.0713f
C2003 t1b VSUBS 0.142f
C2004 clknb vbn 0.822f
C2005 bn7 cn8 0.289f
C2006 top_n cp12 0.043f
C2007 lsb_p VSUBS 0.107f
C2008 onn VSUBS 0.164f
C2009 bn9 xs1n_g 0.0177f
C2010 lsb_p bn4 0.07f
C2011 xc4_outpb VSUBS 0.104f
C2012 xc5_outnb VSUBS 0.106f
C2013 xs0p_x vref 0.132f
C2014 bp6 VSUBS 0.0732f
C2015 xs1n_cbp VSUBS 0.161f
C2016 trk0 VSUBS 0.0588f
C2017 gnd in0p 0.108f
C2018 cp7 VSUBS 0.528f
C2019 cn8 VSUBS 0.075f
C2020 cn4 cn9 0.193f
C2021 bp3 VSUBS 0.214f
C2022 xs1n_n10 VSUBS 0.257f
C2023 xc4_outpb rstb_n 0.588f
C2024 cn12 VSUBS 0.0645f
C2025 cn6 VSUBS 0.111f
C2026 rstb VSUBS 0.285f
C2027 xc4_dip vrefl 0.0702f
C2028 gnd VSUBS 0.045f
C2029 vrefl VSUBS 0.0536f
C2030 xc4_xs1_tail VSUBS 0.197f
C2031 vbp VSUBS 0.287f
C2032 clknb VSUBS 0.0439f
C2033 cn6 VSUBS 0.345f
C2034 xs1p_g VSUBS 0.158f
C2035 xs1p_n10 VSUBS 0.225f
C2036 xc5_lt VSUBS 0.315f
C2037 xs1n_g xs1p_cbp 0.711f
C2038 vbn bp6 0.0444f
C2039 bn3 VSUBS 0.115f
C2040 cp9 VSUBS 0.719f
C2041 cp0 VSUBS 0.11f
C2042 t1 cp8 0.0524f
C2043 bp7 cn9 0.45f
C2044 xs0p_cbn VSUBS 0.106f
C2045 bp6 VSUBS 0.0782f
C2046 vbp VSUBS 0.173f
C2047 top_p VSUBS 0.78f
C2048 cp9 xs0n_n10 0.0897f
C2049 rstb xs0p_x 0.0884f
C2050 bn1 bp1 0.254f
C2051 xs0n_x VSUBS 0.056f
C2052 bn11 bn12 0.146f
C2053 cp5 VSUBS 0.0847f
C2054 bp3 VSUBS 0.0763f
C2055 bn11 cp1 0.116f
C2056 in1n VSUBS 0.0785f
C2057 cp10 VSUBS 0.327f
C2058 lsb_n on 0.394f
C2059 rstb VSUBS 0.0685f
C2060 xs0p_x xs0p_n10 0.23f
C2061 xc4_lt VSUBS 0.118f
C2062 xs0p_cbn VSUBS 0.163f
C2063 xs0p_g VSUBS 0.0953f
C2064 cp4 bn4 0.324f
C2065 in0n cp6 0.13f
C2066 cp4 in1p 0.183f
C2067 xs0n_g xs0n_x 0.408f
C2068 bn9 bn2 0.177f
C2069 on bp9 0.0303f
C2070 vdd VSUBS 0.127f
C2071 on VSUBS 0.134f
C2072 cp1 VSUBS 0.152f
C2073 xc4_dip vrefl 0.136f
C2074 xc4_xs1_tail VSUBS 0.467f
C2075 bn6 bn11 0.54f
C2076 xs0p_n10 VSUBS 0.0342f
C2077 bp6 bp5 0.0246f
C2078 cp7 VSUBS 0.273f
C2079 cp10 VSUBS 0.447f
C2080 xc4_outnb VSUBS 0.0787f
C2081 op VSUBS 0.315f
C2082 xs1p_x VSUBS 0.0424f
C2083 cp8 top_p 0.0744f
C2084 bp5 bn2 1.71f
C2085 xs1n_cbp VSUBS 0.109f
C2086 bn6 VSUBS 0.135f
C2087 bp4 VSUBS 0.138f
C2088 cn10 VSUBS 0.383f
C2089 bp3 xs1p_g 0.0804f
C2090 xc5_xs1_tail xc4_outnb 0.114f
C2091 cn6 xc4_xs1_tail0 0.034f
C2092 top_n cp6 0.162f
C2093 cn4 VSUBS 0.049f
C2094 bp12 VSUBS 0.351f
C2095 in1n VSUBS 0.287f
C2096 cn3 VSUBS 0.0466f
C2097 xc5_outnb cn1 0.0827f
C2098 xc5_lt VSUBS 0.402f
C2099 t0 VSUBS 0.199f
C2100 bp2 trk0 0.312f
C2101 cn0 VSUBS 0.148f
C2102 xc5_xs1_tail VSUBS 0.309f
C2103 cp6 VSUBS 0.129f
C2104 cp7 VSUBS 0.172f
C2105 xs1n_cbn VSUBS 0.165f
C2106 bp11 VSUBS 0.193f
C2107 cn12 bp3 0.177f
C2108 rstb xs1n_cbp 0.204f
C2109 xs1n_cbn VSUBS 0.144f
C2110 bn8 cp7 0.0378f
C2111 xc5_lt cn0 0.668f
C2112 rstb_n VSUBS 0.298f
C2113 t1b bn12 0.216f
C2114 cp11 bn1 0.0641f
C2115 xs1p_cbn VSUBS 0.463f
C2116 bp2 clknb 0.944f
C2117 xs0n_cbp VSUBS 0.0469f
C2118 bn11 VSUBS 0.0774f
C2119 xs1p_cbn lsb_n 0.694f
C2120 vdd VSUBS 0.345f
C2121 xc4_din VSUBS 0.0926f
C2122 t0 VSUBS 0.103f
C2123 vrefl bp0 0.187f
C2124 cn12 VSUBS 0.493f
C2125 xc5_dip VSUBS 0.175f
C2126 xs1p_n10 VSUBS 0.165f
C2127 vrefl t0 0.601f
C2128 cn9 VSUBS 0.462f
C2129 in0n VSUBS 0.0662f
C2130 xs0p_x VSUBS 0.109f
C2131 bp5 VSUBS 0.0451f
C2132 xs0n_x VSUBS 0.445f
C2133 lsb_n bn6 0.241f
C2134 bp0 VSUBS 0.2f
C2135 top_p VSUBS 0.23f
C2136 gnd VSUBS 0.212f
C2137 xs0n_cbn onp 0.0441f
C2138 xc5_outnb VSUBS 0.264f
C2139 xc4_outpb VSUBS 0.0185f
C2140 vbp VSUBS 0.152f
C2141 bn0 VSUBS 0.171f
C2142 xc5_lt VSUBS 0.0913f
C2143 cp7 VSUBS 0.209f
C2144 lsb_p VSUBS 0.0857f
C2145 cp8 bp7 0.376f
C2146 xs1p_cbn clknb 0.138f
C2147 bp3 VSUBS 0.095f
C2148 cn2 VSUBS 0.103f
C2149 vrefl cn9 0.145f
C2150 t0 xc5_outnb 0.487f
C2151 cp6 t1 0.157f
C2152 cn7 cn8 0.0594f
C2153 bp9 VSUBS 0.15f
C2154 bp6 VSUBS 0.131f
C2155 cn5 VSUBS 0.26f
C2156 xs0p_x VSUBS 0.143f
C2157 xc5_lt t1b 0.171f
C2158 vbp VSUBS 0.167f
C2159 xc4_outnb VSUBS 0.0916f
C2160 xs0n_cbn cp9 0.0688f
C2161 xc4_din xc4_outnb 0.19f
C2162 onn VSUBS 0.0312f
C2163 bp11 VSUBS 0.286f
C2164 t1 VSUBS 0.0932f
C2165 vref VSUBS 0.156f
C2166 bn12 VSUBS 0.157f
C2167 cp7 bp9 0.349f
C2168 cn8 bp12 0.0435f
C2169 xc4_outpb cn1 0.349f
C2170 xs0p_x bn3 0.052f
C2171 cn7 VSUBS 0.0745f
C2172 cn6 vrefl 0.106f
C2173 bp8 VSUBS 0.145f
C2174 bp2 top_n 0.227f
C2175 bp7 xs1n_n10 0.0792f
C2176 cp0 VSUBS 0.122f
C2177 vrefl VSUBS 0.019f
C2178 cn4 bn8 0.21f
C2179 xc5_din op 0.108f
C2180 cn5 VSUBS 0.0624f
C2181 xc5_lt VSUBS 0.287f
C2182 rstb VSUBS 0.226f
C2183 bn10 VSUBS 0.125f
C2184 bn5 VSUBS 0.0506f
C2185 xc4_outnb cn0 0.218f
C2186 xs1p_x VSUBS 0.127f
C2187 xs1p_n10 VSUBS 0.0661f
C2188 xs1p_x bp0 0.11f
C2189 cp8 VSUBS 0.147f
C2190 xs0p_n10 VSUBS 0.0567f
C2191 vbp cn4 0.0836f
C2192 vrefl VSUBS 0.0383f
C2193 t1b xc5_din 0.536f
C2194 bn0 VSUBS 0.111f
C2195 cn6 VSUBS 0.573f
C2196 cn12 bp1 0.155f
C2197 xc5_xs1_tail t1 0.0765f
C2198 cp11 VSUBS 0.0361f
C2199 bp5 xs1n_n10 0.0777f
C2200 vbn bp5 0.0888f
C2201 clk VSUBS 0.232f
C2202 bn10 VSUBS 0.317f
C2203 cn11 VSUBS 0.126f
C2204 cn6 VSUBS 0.263f
C2205 bp0 xs0p_n10 0.0223f
C2206 xc4_outnb VSUBS 0.452f
C2207 xs1n_n10 clkb 0.217f
C2208 xc4_outpb bn7 0.103f
C2209 xc5_xs1_tail bp7 0.22f
C2210 xs1p_n10 VSUBS 0.0717f
C2211 vbn VSUBS 0.0524f
C2212 t0b VSUBS 0.238f
C2213 cp4 lsb_p 0.16f
C2214 bn10 VSUBS 0.105f
C2215 xc5_outpb xc4_outnb 0.0847f
C2216 bp8 bn0 0.241f
C2217 xs1n_cbn VSUBS 0.136f
C2218 xc5_xs1_tail0 bp10 0.291f
C2219 cn5 VSUBS 0.171f
C2220 bn3 VSUBS 0.285f
C2221 nr VSUBS 0.0524f
C2222 cn12 VSUBS 0.347f
C2223 in1n VSUBS 0.599f
C2224 on VSUBS 0.27f
C2225 lsb_p cn4 0.172f
C2226 xc5_din VSUBS 0.237f
C2227 bn4 VSUBS 0.215f
C2228 xs0p_n10 VSUBS 0.221f
C2229 cn0 VSUBS 0.12f
C2230 t0b VSUBS 0.104f
C2231 on VSUBS 0.0839f
C2232 bp7 VSUBS 0.0448f
C2233 bn9 bp5 0.041f
C2234 xs1p_g VSUBS 0.0655f
C2235 bn12 VSUBS 0.163f
C2236 bp5 top_n 0.049f
C2237 xc4_xs1_tail VSUBS 0.213f
C2238 on VSUBS 0.0645f
C2239 cp0 VSUBS 0.0366f
C2240 cn2 VSUBS 0.118f
C2241 top_p cn6 0.0412f
C2242 clkn VSUBS 0.222f
C2243 xc5_xs1_tail VSUBS 0.341f
C2244 xc4_xs1_tail0 cp11 0.139f
C2245 xs1p_cbp VSUBS 0.0996f
C2246 lsb_n VSUBS 0.139f
C2247 bn5 xs0n_n10 0.121f
C2248 xc5_lt VSUBS 0.246f
C2249 cp11 VSUBS 0.0534f
C2250 xs0n_cbp VSUBS 0.254f
C2251 lsb_p VSUBS 0.202f
C2252 bn1 VSUBS 0.198f
C2253 cn4 VSUBS 0.095f
C2254 xs0p_x VSUBS 0.272f
C2255 nr VSUBS 0.172f
C2256 cp7 VSUBS 0.143f
C2257 bp11 top_p 0.0385f
C2258 cp12 VSUBS 0.315f
C2259 vdd VSUBS 0.165f
C2260 vbn VSUBS 1.09f
C2261 bn0 clkn 0.149f
C2262 cp10 VSUBS 0.127f
C2263 cp5 VSUBS 0.12f
C2264 cn0 VSUBS 0.233f
C2265 cn6 VSUBS 0.35f
C2266 cp7 bp12 0.16f
C2267 cp7 VSUBS 0.354f
C2268 xc4_din xc5_din 0.0365f
C2269 in0p in0n 0.127f
C2270 rstb_n cp9 0.0704f
C2271 bp0 in1n 0.217f
C2272 t1 bp10 0.0992f
C2273 cp1 VSUBS 0.337f
C2274 in1n VSUBS 0.18f
C2275 cn6 VSUBS 0.217f
C2276 xc5_outpb VSUBS 0.0489f
C2277 cn4 VSUBS 0.0758f
C2278 xc5_xs1_tail0 VSUBS 0.501f
C2279 clk cn8 0.147f
C2280 onp in0p 0.586f
C2281 on bp10 0.13f
C2282 xc4_lt VSUBS 0.0643f
C2283 bp1 vref 0.114f
C2284 t1b VSUBS 0.357f
C2285 cn8 VSUBS 0.503f
C2286 xs1p_n10 VSUBS 0.115f
C2287 rstb VSUBS 0.756f
C2288 bn1 VSUBS 0.134f
C2289 t1 VSUBS 0.173f
C2290 cn2 bn8 0.0796f
C2291 bp6 VSUBS 0.191f
C2292 bp0 VSUBS 0.0754f
C2293 xs0n_cbp xc4_lt 0.276f
C2294 xc4_din in0n 0.128f
C2295 in1p VSUBS 0.0456f
C2296 xs0p_cbp clknb 0.132f
C2297 xc4_xs1_tail0 VSUBS 0.0715f
C2298 bn0 vbn 0.1f
C2299 cn5 VSUBS 0.227f
C2300 t1b top_p 0.037f
C2301 clk VSUBS 0.47f
C2302 bp9 VSUBS 0.151f
C2303 bn7 bn12 0.124f
C2304 cn3 VSUBS 0.131f
C2305 xs1n_cbp VSUBS 0.082f
C2306 bn5 VSUBS 0.453f
C2307 bn12 bp5 0.185f
C2308 xs1p_g VSUBS 0.0455f
C2309 in1p VSUBS 0.52f
C2310 bn11 top_n 0.789f
C2311 op VSUBS 0.0803f
C2312 xs0p_cbp cp12 0.106f
C2313 xc4_lt VSUBS 0.314f
C2314 xs0p_cbp VSUBS 0.276f
C2315 top_n VSUBS 0.0611f
C2316 cp3 VSUBS 0.0904f
C2317 cn7 VSUBS 0.466f
C2318 trk0 VSUBS 0.12f
C2319 onp bp6 0.103f
C2320 cp8 xc4_xs1_tail0 0.252f
C2321 cn10 cn6 0.101f
C2322 xs0n_cbp VSUBS 0.11f
C2323 top_p xc5_outnb 0.0983f
C2324 bn5 VSUBS 0.163f
C2325 xc5_dip VSUBS 0.609f
C2326 cn0 onn 0.521f
C2327 xs0p_x VSUBS 0.301f
C2328 xc5_din VSUBS 0.257f
C2329 cp1 VSUBS 0.0682f
C2330 xs1p_n10 cp2 0.195f
C2331 bp6 clknb 0.641f
C2332 t1 VSUBS 0.0435f
C2333 cn12 VSUBS 0.996f
C2334 xs1n_n10 xs1n_n10 0.199f
C2335 cn12 bp5 0.14f
C2336 cn8 VSUBS 0.186f
C2337 cn2 VSUBS 0.426f
C2338 bp5 VSUBS 0.184f
C2339 xs1n_x cp5 0.139f
C2340 xc4_outpb VSUBS 0.339f
C2341 top_p clknb 0.288f
C2342 bp3 VSUBS 0.247f
C2343 xs0p_g cp1 0.153f
C2344 bp7 clknb 0.0719f
C2345 xs1n_cbp VSUBS 0.266f
C2346 xc4_din VSUBS 0.127f
C2347 cn11 cn6 0.0615f
C2348 bp8 VSUBS 0.434f
C2349 xc5_xs1_tail VSUBS 0.525f
C2350 xc4_outpb xc5_outnb 0.201f
C2351 onp cn3 0.0866f
C2352 t1b xs1p_n10 0.318f
C2353 cp7 VSUBS 0.0942f
C2354 cn9 VSUBS 0.25f
C2355 xs0p_g vbp 0.174f
C2356 cp0 VSUBS 0.127f
C2357 top_p VSUBS 0.155f
C2358 bn6 cp10 0.556f
C2359 bp10 VSUBS 0.67f
C2360 cn0 VSUBS 0.0897f
C2361 clk VSUBS 0.17f
C2362 bn0 VSUBS 0.0557f
C2363 bp1 VSUBS 1f
C2364 xs0n_g xc4_din 0.248f
C2365 xs1n_cbn xs0p_cbp 0.115f
C2366 clkb xc4_outpb 0.082f
C2367 cn6 cp5 0.298f
C2368 rstb VSUBS 0.124f
C2369 in0n VSUBS 0.0311f
C2370 bp11 cn3 0.15f
C2371 cn12 cn8 0.18f
C2372 xs1n_cbn t0b 0.21f
C2373 onp VSUBS 0.0472f
C2374 trk1 VSUBS 0.0807f
C2375 bp8 xs0n_g 0.166f
C2376 bn2 VSUBS 0.153f
C2377 xc4_din VSUBS 0.156f
C2378 bn7 VSUBS 0.111f
C2379 bn11 xs0p_cbn 0.2f
C2380 cn2 VSUBS 0.847f
C2381 xs1n_cbn xs0n_x 0.626f
C2382 cn1 VSUBS 0.257f
C2383 lsb_p rstb_n 0.101f
C2384 trk0 cn0 0.257f
C2385 bp12 VSUBS 0.128f
C2386 cn7 in1p 0.368f
C2387 bp2 VSUBS 0.0523f
C2388 vdd VSUBS 0.115f
C2389 onp bn4 0.251f
C2390 cp4 VSUBS 0.356f
C2391 vbp VSUBS 0.0321f
C2392 clknb cn8 0.35f
C2393 bp5 VSUBS 0.102f
C2394 bp2 VSUBS 0.884f
C2395 clkn VSUBS 0.276f
C2396 op VSUBS 0.124f
C2397 bn1 VSUBS 0.273f
C2398 cp4 VSUBS 0.0772f
C2399 nr VSUBS 0.173f
C2400 t0 VSUBS 0.196f
C2401 onp VSUBS 0.14f
C2402 cp5 cp7 0.191f
C2403 xs0p_cbp onp 0.226f
C2404 vbp xs0n_cbp 0.131f
C2405 xs0p_n10 xc5_outpb 0.105f
C2406 bp6 VSUBS 0.0379f
C2407 clknb VSUBS 0.0872f
C2408 xc5_dip in0p 0.23f
C2409 bp6 cn8 0.0733f
C2410 xs1n_g bp0 0.2f
C2411 cp5 cn3 0.117f
C2412 xs0n_g VSUBS 0.13f
C2413 bn10 xs1p_cbp 0.064f
C2414 bn0 VSUBS 0.169f
C2415 xs1p_cbp VSUBS 0.167f
C2416 xs1p_n10 VSUBS 0.111f
C2417 cn7 cn3 0.337f
C2418 xs1n_cbn xs1n_n10 0.536f
C2419 xs1p_n10 xc4_outnb 0.168f
C2420 bp11 xc5_dip 0.111f
C2421 cn10 bp10 0.0635f
C2422 bp12 bp9 0.616f
C2423 xs0n_cbn VSUBS 0.0847f
C2424 cp3 t0b 0.158f
C2425 trk0 cp0 0.243f
C2426 cp3 VSUBS 0.296f
C2427 cn3 VSUBS 0.176f
C2428 bn9 cp8 0.559f
C2429 bp7 VSUBS 0.204f
C2430 t0 bp8 0.079f
C2431 bp9 on 0.371f
C2432 bp3 VSUBS 0.259f
C2433 vref VSUBS 0.0889f
C2434 cp5 clkn 0.286f
C2435 bn11 VSUBS 0.0888f
C2436 xc4_outpb cp9 0.186f
C2437 trk1 VSUBS 0.309f
C2438 in1p VSUBS 0.171f
C2439 trk0 t1b 0.0493f
C2440 xs1n_g VSUBS 0.197f
C2441 in0p lsb_p 0.0335f
C2442 xs0n_cbn VSUBS 0.215f
C2443 clkn trk1 0.471f
C2444 bp3 VSUBS 0.152f
C2445 bp0 top_n 0.0624f
C2446 xs1n_x xc4_outpb 0.107f
C2447 cp10 clkb 0.298f
C2448 gnd xs0p_n10 0.306f
C2449 cp7 xs0p_cbp 0.223f
C2450 cn2 bn12 0.102f
C2451 top_n VSUBS 0.0656f
C2452 gnd VSUBS 0.148f
C2453 bn2 cp6 0.0572f
C2454 bp7 VSUBS 0.0407f
C2455 cn3 t0b 0.153f
C2456 cn1 VSUBS 0.144f
C2457 cn3 bn5 0.153f
C2458 bn1 bn3 0.115f
C2459 bp12 VSUBS 0.491f
C2460 bn5 VSUBS 0.0676f
C2461 trk1 cn4 0.215f
C2462 cn7 VSUBS 0.142f
C2463 cp10 in0p 0.458f
C2464 bp10 VSUBS 0.202f
C2465 xs0n_cbn VSUBS 0.193f
C2466 bp2 bp8 0.118f
C2467 bn2 VSUBS 0.0671f
C2468 cn9 VSUBS 0.0587f
C2469 bp2 VSUBS 0.368f
C2470 op VSUBS 0.0384f
C2471 xs0p_cbn cp11 0.0401f
C2472 clkb bn5 0.0648f
C2473 on VSUBS 0.187f
C2474 xs1p_x VSUBS 0.0758f
C2475 t1 cn3 0.0461f
C2476 cn9 bn4 0.258f
C2477 xs0p_x xc4_xs1_tail 0.036f
C2478 xc4_lt VSUBS 0.484f
C2479 xc5_din VSUBS 0.0113f
C2480 on cp3 0.37f
C2481 cn8 VSUBS 0.0316f
C2482 trk0 cn8 0.226f
C2483 xs0p_cbn vbn 0.183f
C2484 in0p VSUBS 0.344f
C2485 cn7 cp8 0.026f
C2486 lsb_n VSUBS 0.145f
C2487 t0 VSUBS 0.161f
C2488 bp11 VSUBS 0.0703f
C2489 xc4_outpb VSUBS 0.978f
C2490 bp8 lsb_n 0.0802f
C2491 xs1p_cbp VSUBS 0.106f
C2492 cp11 cp11 0.109f
C2493 cp12 VSUBS 0.173f
C2494 xs1p_g cp12 0.243f
C2495 bp1 cp12 0.197f
C2496 bp8 VSUBS 0.91f
C2497 cn3 VSUBS 0.329f
C2498 bp6 VSUBS 0.069f
C2499 xs1n_x VSUBS 0.593f
C2500 xc5_din cn4 0.128f
C2501 t1b cn9 0.382f
C2502 bp12 xs1n_cbn 0.227f
C2503 xc5_outpb xs0n_g 0.185f
C2504 bn12 xc4_lt 0.0251f
C2505 cp0 VSUBS 0.131f
C2506 bn2 VSUBS 0.139f
C2507 bp12 VSUBS 0.0618f
C2508 bn6 bn0 0.25f
C2509 xs0p_g xs0n_cbp 0.16f
C2510 bn10 cn6 0.239f
C2511 bn5 VSUBS 0.11f
C2512 xs0n_cbp VSUBS 0.049f
C2513 xs1n_n10 xc5_din 0.0756f
C2514 xs1p_g bn6 0.0767f
C2515 bn5 cp12 0.0573f
C2516 bp1 VSUBS 0.101f
C2517 xs0n_g VSUBS 0.186f
C2518 cn9 VSUBS 0.527f
C2519 xs1p_cbn VSUBS 0.185f
C2520 bn7 VSUBS 0.102f
C2521 cp8 VSUBS 0.0827f
C2522 top_n xc5_lt 0.118f
C2523 bn5 VSUBS 0.379f
C2524 bp5 onn 0.199f
C2525 gnd xc5_xs1_tail0 0.0254f
C2526 bp3 VSUBS 0.111f
C2527 xs0p_cbn VSUBS 0.0756f
C2528 bn6 VSUBS 0.165f
C2529 vref bn12 0.143f
C2530 trk0 xs0p_cbn 0.363f
C2531 xs1p_n10 VSUBS 0.0361f
C2532 vdd vrefl 0.0235f
C2533 xs1p_n10 VSUBS 0.147f
C2534 vrefl VSUBS 0.109f
C2535 gnd bp5 0.25f
C2536 cp8 t1b 0.0453f
C2537 xs0n_cbn VSUBS 0.654f
C2538 bn8 VSUBS 0.121f
C2539 trk0 VSUBS 0.127f
C2540 t1b t0 0.0517f
C2541 bn7 VSUBS 0.153f
C2542 xc4_din onp 0.292f
C2543 vbp VSUBS 0.137f
C2544 bp1 VSUBS 0.057f
C2545 cn11 VSUBS 0.494f
C2546 onn bp9 0.277f
C2547 xs1p_cbp bp7 0.574f
C2548 t0b VSUBS 0.501f
C2549 t0 bn1 0.169f
C2550 cp2 VSUBS 1.66f
C2551 bn7 onn 0.222f
C2552 bn7 VSUBS 0.0256f
C2553 bp9 VSUBS 0.166f
C2554 in0p VSUBS 0.353f
C2555 bp8 VSUBS 0.122f
C2556 xc5_outnb lsb_n 0.0579f
C2557 cn0 VSUBS 0.155f
C2558 xs0p_g cn10 0.0576f
C2559 bn3 VSUBS 0.188f
C2560 bn3 xs0p_x 0.0922f
C2561 t0b cp2 0.528f
C2562 xs1p_cbn t1b 0.293f
C2563 bn0 VSUBS 0.153f
C2564 rstb_n cn5 0.165f
C2565 xc4_din VSUBS 0.107f
C2566 bn9 bn5 0.101f
C2567 xs1n_cbn clkn 0.0762f
C2568 cn12 VSUBS 0.198f
C2569 in0n VSUBS 0.248f
C2570 xs0p_g VSUBS 0.289f
C2571 xs0p_n10 in0p 0.0672f
C2572 cn1 bp6 0.158f
C2573 xs0p_cbp VSUBS 0.121f
C2574 xc5_lt VSUBS 0.127f
C2575 vdd VSUBS 0.207f
C2576 xs1p_cbn VSUBS 0.0612f
C2577 bp12 VSUBS 0.0405f
C2578 bp3 VSUBS 0.093f
C2579 bn6 VSUBS 0.0661f
C2580 xs0p_n10 VSUBS 0.187f
C2581 cn5 VSUBS 0.118f
C2582 bn5 VSUBS 0.0892f
C2583 cp0 xs0p_g 0.238f
C2584 xs0n_g VSUBS 0.421f
C2585 xs1n_cbn VSUBS 0.166f
C2586 cp5 xc5_lt 0.0676f
C2587 xc5_outnb xc5_outnb 0.268f
C2588 top_n cp11 0.236f
C2589 bp9 VSUBS 0.314f
C2590 bn10 VSUBS 0.53f
C2591 bn4 VSUBS 0.304f
C2592 cn3 t1b 0.087f
C2593 cn9 onp 0.0313f
C2594 trk0 VSUBS 0.106f
C2595 cp2 VSUBS 0.27f
C2596 bn11 VSUBS 0.165f
C2597 rstb_n VSUBS 0.0814f
C2598 in1n t0b 0.125f
C2599 bp1 VSUBS 0.766f
C2600 top_n vbp 0.127f
C2601 cp7 VSUBS 0.0551f
C2602 bn5 VSUBS 0.0351f
C2603 cn9 VSUBS 0.0423f
C2604 xs1p_x VSUBS 0.0262f
C2605 bn2 in1p 0.266f
C2606 xs0p_cbp VSUBS 0.0545f
C2607 top_p onn 0.0488f
C2608 t0b VSUBS 0.156f
C2609 bn4 cn12 0.192f
C2610 vbp VSUBS 0.444f
C2611 xc4_din VSUBS 0.0958f
C2612 rstb_n VSUBS 0.0536f
C2613 xs0n_n10 VSUBS 0.295f
C2614 xc5_lt VSUBS 0.194f
C2615 lsb_p VSUBS 0.123f
C2616 cp0 VSUBS 0.108f
C2617 t0 VSUBS 0.204f
C2618 xs0n_n10 VSUBS 0.0772f
C2619 t1 VSUBS 0.265f
C2620 in1p VSUBS 0.048f
C2621 cp11 xs1p_cbn 0.033f
C2622 xs0n_x VSUBS 0.288f
C2623 cp0 cp5 0.232f
C2624 clkn VSUBS 0.197f
C2625 op xs1n_cbn 0.242f
C2626 xs0n_g VSUBS 0.0317f
C2627 xs0p_cbn cp8 0.0466f
C2628 rstb_n bn0 0.0339f
C2629 bp1 VSUBS 0.1f
C2630 bp12 VSUBS 0.134f
C2631 cp9 xc4_dip 0.126f
C2632 bn11 VSUBS 0.16f
C2633 vdd in1p 0.255f
C2634 nr VSUBS 0.117f
C2635 bn3 xc5_outpb 0.0777f
C2636 cn0 xc4_xs1_tail 0.136f
C2637 cn12 VSUBS 0.297f
C2638 t0 VSUBS 0.152f
C2639 in0n xs0n_g 0.0255f
C2640 cn1 VSUBS 0.0608f
C2641 op bp8 0.058f
C2642 xs0n_cbn VSUBS 0.216f
C2643 lsb_p VSUBS 0.101f
C2644 xs0n_cbn VSUBS 0.554f
C2645 cp9 VSUBS 0.185f
C2646 onn VSUBS 0.0993f
C2647 bn9 VSUBS 0.128f
C2648 xs1p_g bn2 0.203f
C2649 top_p VSUBS 1.05f
C2650 onp cn7 0.273f
C2651 trk1 VSUBS 0.17f
C2652 vrefl VSUBS 0.343f
C2653 xs0n_cbp xs1n_cbn 0.108f
C2654 bn10 cp2 0.206f
C2655 cp11 VSUBS 0.409f
C2656 cn8 VSUBS 0.0779f
C2657 lsb_n VSUBS 0.253f
C2658 bn6 VSUBS 0.0845f
C2659 bp11 VSUBS 0.16f
C2660 xs0p_n10 VSUBS 0.197f
C2661 xs1n_g bp5 0.0242f
C2662 in1p VSUBS 0.0805f
C2663 xc5_outpb VSUBS 0.236f
C2664 bp1 VSUBS 0.0583f
C2665 bp7 t1b 0.257f
C2666 bp6 VSUBS 0.299f
C2667 bp11 xs0n_x 0.228f
C2668 rstb_n VSUBS 0.108f
C2669 xs1n_g VSUBS 0.0961f
C2670 xc4_outnb vrefl 0.329f
C2671 xs1p_n10 VSUBS 0.209f
C2672 cp2 cn0 0.179f
C2673 vrefl VSUBS 0.229f
C2674 xc4_din VSUBS 0.0651f
C2675 t0 bn2 0.68f
C2676 bn11 VSUBS 0.133f
C2677 in0p cn7 0.128f
C2678 bn11 xc4_outnb 0.113f
C2679 bp5 xs0p_cbn 0.104f
C2680 xs0p_n10 vrefl 0.19f
C2681 cp11 VSUBS 0.129f
C2682 vbn VSUBS 0.198f
C2683 bn7 VSUBS 0.0539f
C2684 on op 0.033f
C2685 bn5 cp4 0.0467f
C2686 bp10 VSUBS 0.0723f
C2687 xs0n_n10 VSUBS 0.0414f
C2688 xc5_dip VSUBS 0.147f
C2689 lsb_p VSUBS 0.087f
C2690 cn11 VSUBS 0.112f
C2691 in1n bn10 0.067f
C2692 xc5_outnb VSUBS 0.294f
C2693 cn5 VSUBS 0.247f
C2694 cn5 xs1n_cbp 0.0954f
C2695 xs0p_g VSUBS 0.28f
C2696 clkn VSUBS 1.08f
C2697 xc5_xs1_tail VSUBS 0.0521f
C2698 trk0 VSUBS 0.0917f
C2699 onn VSUBS 0.349f
C2700 cn12 VSUBS 0.396f
C2701 t0 VSUBS 0.105f
C2702 bn12 VSUBS 0.0696f
C2703 cn6 VSUBS 0.118f
C2704 xc5_dip VSUBS 0.177f
C2705 xc5_lt VSUBS 0.624f
C2706 xc4_outnb bn1 0.0604f
C2707 xs0n_x xs1n_g 0.0802f
C2708 bn0 cp4 0.0916f
C2709 lsb_p vdd 0.164f
C2710 cp3 vrefl 0.0565f
C2711 bp4 VSUBS 0.326f
C2712 bp6 VSUBS 0.166f
C2713 xs0p_cbp xc4_outpb 0.26f
C2714 xc4_dip VSUBS 0.14f
C2715 cp1 cn2 0.276f
C2716 clkn cn0 0.139f
C2717 xc5_lt VSUBS 0.147f
C2718 clk bn9 0.438f
C2719 xc4_lt VSUBS 0.141f
C2720 top_n VSUBS 0.588f
C2721 cn5 VSUBS 0.258f
C2722 xs0n_n10 VSUBS 0.0788f
C2723 cn0 xs1n_n10 0.036f
C2724 bp5 VSUBS 0.377f
C2725 lsb_p VSUBS 0.0932f
C2726 bn10 bp1 0.141f
C2727 bn3 VSUBS 0.286f
C2728 xc4_lt in0n 0.26f
C2729 xs1n_cbp trk1 0.104f
C2730 xc5_outpb cp10 0.257f
C2731 t1 VSUBS 0.052f
C2732 clkb cn3 0.727f
C2733 xc5_din VSUBS 0.0729f
C2734 cp12 VSUBS 0.0847f
C2735 xs1p_n10 VSUBS 0.317f
C2736 cp6 onn 0.27f
C2737 t1 VSUBS 0.127f
C2738 cn2 VSUBS 0.0763f
C2739 cn9 VSUBS 0.053f
C2740 bn5 bn5 0.224f
C2741 xs1n_n10 VSUBS 0.166f
C2742 xc5_xs1_tail bn10 0.105f
C2743 xs1p_n10 xs1p_g 0.0669f
C2744 vbn cp1 0.0757f
C2745 cp9 VSUBS 0.155f
C2746 xs1p_n10 xs1p_n10 0.215f
C2747 bn10 VSUBS 0.108f
C2748 in1p bn2 0.71f
C2749 xc5_outnb xc4_din 0.168f
C2750 t1b VSUBS 0.0409f
C2751 t0 vrefl 0.0617f
C2752 xc5_lt bp7 0.13f
C2753 cp0 VSUBS 0.121f
C2754 cn4 bn4 0.041f
C2755 cp5 VSUBS 0.205f
C2756 cn2 VSUBS 0.0698f
C2757 bp11 in1n 0.127f
C2758 xc5_din VSUBS 0.0544f
C2759 cn8 VSUBS 0.482f
C2760 xs0p_cbp VSUBS 0.231f
C2761 bp6 cn6 0.658f
C2762 nr VSUBS 0.141f
C2763 cn1 VSUBS 0.111f
C2764 bp6 VSUBS 0.113f
C2765 cn7 VSUBS 0.0847f
C2766 xc4_xs1_tail VSUBS 0.454f
C2767 on VSUBS 0.0929f
C2768 rstb VSUBS 0.286f
C2769 cp7 cp0 0.0703f
C2770 vref VSUBS 0.141f
C2771 t0 VSUBS 0.569f
C2772 cp3 VSUBS 0.138f
C2773 xc5_xs1_tail0 VSUBS 0.155f
C2774 cp11 VSUBS 0.167f
C2775 cn0 clk 0.209f
C2776 lsb_n bn5 0.104f
C2777 bn2 VSUBS 0.0613f
C2778 trk1 VSUBS 0.384f
C2779 xc4_outpb VSUBS 0.835f
C2780 clkn VSUBS 0.141f
C2781 cn5 VSUBS 0.0822f
C2782 xs1p_g cp12 0.198f
C2783 vdd VSUBS 0.291f
C2784 cn12 bn12 0.667f
C2785 xc5_din VSUBS 0.0706f
C2786 t0b VSUBS 0.0915f
C2787 xs0n_x xs1n_x 0.0828f
C2788 cp6 vref 0.0546f
C2789 top_n VSUBS 0.182f
C2790 xs0p_n10 xc4_outnb 0.307f
C2791 trk0 VSUBS 0.0869f
C2792 xs1p_n10 VSUBS 0.0847f
C2793 xs0p_cbp VSUBS 0.196f
C2794 xc4_din bp6 0.138f
C2795 xc4_dip xs1p_cbp 0.0739f
C2796 xs0p_g VSUBS 0.245f
C2797 t0 VSUBS 0.0869f
C2798 cn4 VSUBS 0.24f
C2799 clkb VSUBS 0.214f
C2800 cp8 VSUBS 0.0682f
C2801 cp9 VSUBS 0.856f
C2802 xc4_dip in0n 0.102f
C2803 xs1n_g bn0 0.104f
C2804 rstb trk0 0.431f
C2805 t1 VSUBS 0.103f
C2806 cn12 VSUBS 0.0735f
C2807 xs0n_cbp bn1 0.17f
C2808 xs0n_g bp5 0.172f
C2809 clkb xs0p_cbp 0.439f
C2810 xs1n_cbp bp8 0.0599f
C2811 bn3 bn0 0.039f
C2812 trk1 t0b 0.455f
C2813 nr VSUBS 0.762f
C2814 cp7 cn7 0.508f
C2815 rstb VSUBS 0.122f
C2816 xc4_xs1_tail0 VSUBS 0.277f
C2817 t0b xs1n_x 0.117f
C2818 xs1p_cbn VSUBS 0.136f
C2819 vbp bn0 0.211f
C2820 xc5_xs1_tail t1 0.22f
C2821 xs0p_g bn2 0.0887f
C2822 vbp VSUBS 0.0877f
C2823 bn9 VSUBS 0.777f
C2824 trk1 VSUBS 0.0673f
C2825 cn1 cn7 0.0719f
C2826 xs1p_x VSUBS 0.111f
C2827 t0b VSUBS 0.323f
C2828 bn4 cp2 0.134f
C2829 xc4_din VSUBS 0.0787f
C2830 bn3 VSUBS 0.298f
C2831 bn6 bp7 0.127f
C2832 top_p VSUBS 0.687f
C2833 bn2 rstb_n 0.22f
C2834 cn4 cp7 0.147f
C2835 xs1n_cbp xs1p_g 0.14f
C2836 clkb VSUBS 0.645f
C2837 trk0 VSUBS 0.167f
C2838 cp2 t0b 0.0323f
C2839 bn8 VSUBS 0.26f
C2840 bn0 in1p 0.124f
C2841 cn2 xc5_xs1_tail0 0.509f
C2842 bp0 VSUBS 0.176f
C2843 xs1n_x VSUBS 0.26f
C2844 vbp VSUBS 0.419f
C2845 bn2 VSUBS 0.156f
C2846 bp0 VSUBS 0.0981f
C2847 bp9 xc5_outpb 0.218f
C2848 xs0n_cbp xc5_xs1_tail0 0.134f
C2849 cp0 VSUBS 0.176f
C2850 vdd bp3 0.0895f
C2851 xc5_outnb VSUBS 0.337f
C2852 xc5_xs1_tail0 xs0n_x 0.154f
C2853 on in0p 0.0808f
C2854 xs0n_cbn VSUBS 0.123f
C2855 xc5_din cp5 0.0526f
C2856 xc4_xs1_tail VSUBS 0.291f
C2857 cp1 VSUBS 0.237f
C2858 xs0n_g bn11 0.0372f
C2859 cn11 VSUBS 0.0291f
C2860 xc4_din VSUBS 0.211f
C2861 xc5_din VSUBS 0.0944f
C2862 cp2 VSUBS 0.205f
C2863 t1b cp8 0.101f
C2864 cn9 bp0 0.226f
C2865 bp3 cn1 0.245f
C2866 xc5_din VSUBS 0.117f
C2867 in0n VSUBS 0.249f
C2868 xs1n_cbp VSUBS 0.119f
C2869 top_p bp3 0.175f
C2870 bn0 xs1p_n10 0.199f
C2871 xs0p_g VSUBS 0.134f
C2872 cp7 VSUBS 0.0858f
C2873 xc4_outnb xc5_dip 0.217f
C2874 xc4_outnb VSUBS 0.111f
C2875 top_p VSUBS 0.0854f
C2876 cp2 VSUBS 0.144f
C2877 xs1p_cbn VSUBS 0.332f
C2878 xc5_dip bp1 0.0561f
C2879 clk VSUBS 0.253f
C2880 lsb_n bp3 0.284f
C2881 vbn VSUBS 0.329f
C2882 vref xs0p_n10 0.056f
C2883 onn VSUBS 0.0944f
C2884 xs1p_g VSUBS 0.18f
C2885 bp11 VSUBS 0.0466f
C2886 cp9 cp6 0.169f
C2887 xc5_xs1_tail cp1 0.475f
C2888 cn5 VSUBS 0.193f
C2889 t0b VSUBS 0.212f
C2890 xs0p_x VSUBS 0.0515f
C2891 xs1p_n10 xs0p_cbn 0.135f
C2892 onp xc5_lt 0.14f
C2893 bp3 cp8 0.0674f
C2894 t1 VSUBS 0.149f
C2895 cn12 xs1p_n10 0.433f
C2896 xc4_outnb xc5_din 0.152f
C2897 in1p clkb 0.121f
C2898 on bn0 0.0486f
C2899 xc4_outnb bp0 0.0805f
C2900 cn6 VSUBS 0.164f
C2901 xc4_outnb VSUBS 0.0977f
C2902 cn1 VSUBS 0.183f
C2903 xs0n_cbn VSUBS 0.26f
C2904 trk1 VSUBS 0.211f
C2905 cn10 VSUBS 0.236f
C2906 xs0p_cbp clk 0.197f
C2907 trk0 VSUBS 0.0548f
C2908 bn3 xc5_outpb 0.229f
C2909 xs0n_n10 xs1n_g 0.203f
C2910 xs1n_g cn7 0.138f
C2911 xc5_outpb xs0p_cbp 0.19f
C2912 xc4_xs1_tail0 cp0 0.182f
C2913 bn0 xs0p_n10 0.0543f
C2914 xs0n_cbn VSUBS 0.333f
C2915 in1p bn8 0.186f
C2916 bn2 xs1n_cbn 0.32f
C2917 onn VSUBS 0.0289f
C2918 cn1 xs1p_x 0.108f
C2919 cn9 VSUBS 0.199f
C2920 in0p xs1p_g 0.0512f
C2921 lsb_n cn12 0.0972f
C2922 vbn t1b 0.0239f
C2923 bn10 VSUBS 0.22f
C2924 xc4_outpb VSUBS 0.0481f
C2925 cn11 VSUBS 0.472f
C2926 xc5_outpb VSUBS 0.0512f
C2927 cp12 VSUBS 0.165f
C2928 xc4_xs1_tail top_n 0.0543f
C2929 cp8 xs1p_g 0.279f
C2930 cp11 xc4_lt 0.0602f
C2931 xs0p_x VSUBS 0.106f
C2932 rstb clkb 0.212f
C2933 bn6 cn12 0.0812f
C2934 cn0 VSUBS 0.331f
C2935 xc4_outnb cn2 0.115f
C2936 bn2 cp3 0.134f
C2937 xc5_xs1_tail VSUBS 0.123f
C2938 cp11 VSUBS 0.0907f
C2939 bp5 VSUBS 0.141f
C2940 vrefl cn6 0.281f
C2941 bn2 VSUBS 0.162f
C2942 bp12 top_n 0.32f
C2943 bn5 top_p 0.297f
C2944 lsb_n VSUBS 0.0456f
C2945 xs1p_n10 VSUBS 0.122f
C2946 bn4 VSUBS 0.197f
C2947 cn0 cp8 0.333f
C2948 bp3 VSUBS 0.191f
C2949 cn7 VSUBS 0.0659f
C2950 cp10 VSUBS 0.206f
C2951 cp6 VSUBS 0.0901f
C2952 clknb on 0.228f
C2953 cp6 VSUBS 0.0303f
C2954 in1n bn2 0.442f
C2955 cp8 VSUBS 0.0655f
C2956 rstb vbn 0.124f
C2957 cn12 VSUBS 0.221f
C2958 bn1 VSUBS 0.375f
C2959 xc5_xs1_tail0 bp6 0.2f
C2960 top_n VSUBS 0.526f
C2961 xc4_xs1_tail VSUBS 0.114f
C2962 bn2 VSUBS 0.0836f
C2963 bn3 VSUBS 0.0502f
C2964 on VSUBS 0.0371f
C2965 bp0 xs0p_g 0.0639f
C2966 cn0 VSUBS 0.0969f
C2967 bp1 VSUBS 0.0509f
C2968 cp5 VSUBS 0.0681f
C2969 xs0n_n10 VSUBS 0.0786f
C2970 bn5 cp0 0.0927f
C2971 bn9 VSUBS 0.0683f
C2972 cp5 VSUBS 0.0768f
C2973 cp4 xc5_din 0.0815f
C2974 t1 VSUBS 0.0583f
C2975 in0n xs1p_cbp 0.0348f
C2976 cp1 bp3 0.141f
C2977 cn6 VSUBS 0.292f
C2978 cn1 VSUBS 0.0921f
C2979 bn3 VSUBS 0.255f
C2980 lsb_p top_p 0.0487f
C2981 t0b VSUBS 0.0505f
C2982 bp2 VSUBS 0.0976f
C2983 xc4_din VSUBS 0.0864f
C2984 bp2 cn11 0.0529f
C2985 cn2 bp11 0.325f
C2986 cn6 VSUBS 0.0269f
C2987 rstb VSUBS 0.105f
C2988 op vdd 0.182f
C2989 onn VSUBS 0.128f
C2990 xc5_outnb VSUBS 0.07f
C2991 xc4_xs1_tail VSUBS 0.486f
C2992 bn8 VSUBS 0.0506f
C2993 vrefl VSUBS 0.18f
C2994 bp7 cp10 0.0292f
C2995 trk0 xc5_xs1_tail 0.168f
C2996 vbp xs0n_cbp 0.197f
C2997 vbp bp5 0.321f
C2998 cp10 VSUBS 0.0766f
C2999 bn10 VSUBS 0.239f
C3000 bn5 VSUBS 0.166f
C3001 xs0p_cbn VSUBS 0.316f
C3002 xs1p_cbn VSUBS 0.775f
C3003 cp6 VSUBS 0.0508f
C3004 bp9 VSUBS 0.0496f
C3005 t1b VSUBS 0.0874f
C3006 cn1 VSUBS 0.145f
C3007 nr VSUBS 0.0754f
C3008 bp8 t1b 0.163f
C3009 onp VSUBS 0.141f
C3010 xc4_dip VSUBS 0.0922f
C3011 xc5_outpb VSUBS 0.177f
C3012 lsb_p in0p 0.055f
C3013 lsb_p VSUBS 0.417f
C3014 bp10 VSUBS 0.0548f
C3015 in0n VSUBS 0.229f
C3016 trk1 VSUBS 0.113f
C3017 xs1n_g VSUBS 0.264f
C3018 cn7 bn2 0.147f
C3019 cn3 VSUBS 0.54f
C3020 cp1 bn0 0.318f
C3021 cp8 VSUBS 0.519f
C3022 vdd bn4 0.2f
C3023 xc5_din xs0p_n10 0.0834f
C3024 xs0n_g bp5 0.0963f
C3025 vbp t0b 0.171f
C3026 cn11 VSUBS 0.149f
C3027 cp9 cn0 0.0602f
C3028 clkb VSUBS 0.108f
C3029 clknb bn2 0.243f
C3030 cn4 VSUBS 0.25f
C3031 cn5 VSUBS 0.143f
C3032 bn8 VSUBS 0.0483f
C3033 top_n xs1p_n10 0.0998f
C3034 vrefl nr 0.204f
C3035 cp6 VSUBS 0.197f
C3036 cp8 bn8 0.178f
C3037 bp11 VSUBS 0.0648f
C3038 bp0 rstb_n 0.103f
C3039 bp3 bp8 0.122f
C3040 op VSUBS 0.392f
C3041 cn3 cn9 0.354f
C3042 xs1p_cbp cn4 0.427f
C3043 bp7 vrefl 0.15f
C3044 xs0p_cbp VSUBS 0.0588f
C3045 vref VSUBS 0.0665f
C3046 bp8 xs1n_x 0.109f
C3047 bn0 xs1n_x 0.138f
C3048 xs0n_n10 VSUBS 0.0524f
C3049 onp xs1n_g 0.16f
C3050 vdd VSUBS 0.05f
C3051 xc4_xs1_tail vref 0.0555f
C3052 cn12 bn8 0.0246f
C3053 cn5 xs1n_cbn 0.276f
C3054 in1p in0n 0.0787f
C3055 bp2 VSUBS 0.0651f
C3056 rstb_n xs0n_x 0.252f
C3057 xs0p_n10 onn 0.129f
C3058 in1p on 0.0836f
C3059 rstb onn 0.228f
C3060 onn VSUBS 0.0555f
C3061 cp9 xs0n_g 0.645f
C3062 cn5 xc4_din 0.156f
C3063 nr VSUBS 0.0135f
C3064 cp4 VSUBS 0.738f
C3065 xs0n_cbn top_n 0.0787f
C3066 onp bn10 0.591f
C3067 xs1n_x VSUBS 0.132f
C3068 cn3 op 0.113f
C3069 bp11 clkb 0.0799f
C3070 cp5 VSUBS 0.149f
C3071 nr VSUBS 0.0738f
C3072 xc5_dip VSUBS 0.162f
C3073 onn VSUBS 0.0503f
C3074 xc5_xs1_tail0 VSUBS 0.201f
C3075 bn5 VSUBS 0.128f
C3076 on VSUBS 0.053f
C3077 xs1n_cbn cn6 0.15f
C3078 top_p VSUBS 0.334f
C3079 in0p VSUBS 0.365f
C3080 xc5_dip vbp 0.102f
C3081 xs0p_cbp VSUBS 0.313f
C3082 gnd VSUBS 0.238f
C3083 bp7 VSUBS 0.0363f
C3084 bp9 cp4 0.0843f
C3085 in0p clkn 0.134f
C3086 bp4 VSUBS 0.128f
C3087 bp9 VSUBS 0.138f
C3088 bn9 xc4_outnb 0.245f
C3089 bn4 bp7 0.177f
C3090 bp7 cp9 0.143f
C3091 xc5_din VSUBS 0.181f
C3092 bn6 vbn 0.113f
C3093 t0 VSUBS 0.16f
C3094 bp12 cp9 0.396f
C3095 xc5_dip bn11 0.273f
C3096 bp9 bn3 0.112f
C3097 bn2 VSUBS 0.215f
C3098 vbn bn0 0.183f
C3099 bn11 xs1n_g 1.18f
C3100 xs0p_g bp9 0.379f
C3101 bp12 VSUBS 0.535f
C3102 bp4 VSUBS 0.0315f
C3103 op cp6 0.246f
C3104 trk0 xs1p_x 0.104f
C3105 bp12 VSUBS 0.0863f
C3106 xs0p_cbp xc4_dip 0.0773f
C3107 bp4 VSUBS 0.113f
C3108 cp1 VSUBS 0.131f
C3109 xs1n_x rstb_n 0.231f
C3110 onp VSUBS 0.0455f
C3111 bp10 lsb_p 0.0576f
C3112 bp9 in0p 0.0529f
C3113 bp12 xc5_din 0.0779f
C3114 cp6 bn1 0.0549f
C3115 cn5 VSUBS 0.131f
C3116 xc4_xs1_tail xs0p_cbp 0.668f
C3117 xs1n_cbn VSUBS 0.408f
C3118 xc5_outpb VSUBS 0.381f
C3119 bn11 VSUBS 0.142f
C3120 trk1 VSUBS 0.474f
C3121 cn10 cn12 0.142f
C3122 cp8 cp0 0.165f
C3123 xs0p_n10 VSUBS 0.143f
C3124 vref VSUBS 0.625f
C3125 bn3 cp7 0.126f
C3126 vdd vdd 0.073f
C3127 clkn VSUBS 0.0464f
C3128 bn1 VSUBS 0.227f
C3129 nr VSUBS 0.188f
C3130 bn7 VSUBS 0.127f
C3131 xs1n_x VSUBS 0.111f
C3132 bp8 VSUBS 0.378f
C3133 xc5_outnb clkn 0.368f
C3134 cn0 VSUBS 0.462f
C3135 xs1p_cbn VSUBS 0.11f
C3136 cn7 VSUBS 0.117f
C3137 bn7 VSUBS 0.0473f
C3138 in0n cn12 0.213f
C3139 clkn xs1p_g 0.0546f
C3140 xs1n_n10 cp2 0.162f
C3141 cp9 VSUBS 0.116f
C3142 xc5_xs1_tail VSUBS 0.198f
C3143 bp1 vdd 0.327f
C3144 bn11 VSUBS 0.0571f
C3145 xs0n_cbp VSUBS 0.314f
C3146 bn5 clknb 0.133f
C3147 cp1 bp9 0.199f
C3148 clkn t0 0.139f
C3149 cp3 xs0n_cbn 0.0265f
C3150 bp11 VSUBS 0.269f
C3151 cp6 vref 0.472f
C3152 xs0n_x VSUBS 0.0549f
C3153 trk0 VSUBS 0.118f
C3154 top_p VSUBS 0.155f
C3155 cn11 VSUBS 0.201f
C3156 cp8 VSUBS 0.135f
C3157 vbn xs0p_x 0.081f
C3158 xc4_outnb VSUBS 0.306f
C3159 cn1 cn10 0.183f
C3160 cp9 VSUBS 0.398f
C3161 xs0p_cbp t0 0.0731f
C3162 bp5 VSUBS 0.171f
C3163 cp6 VSUBS 0.0533f
C3164 onn bn11 0.124f
C3165 xc5_outnb VSUBS 0.254f
C3166 bn2 VSUBS 0.368f
C3167 bp11 xc5_din 0.138f
C3168 bn12 VSUBS 0.16f
C3169 bp7 VSUBS 0.503f
C3170 bp6 VSUBS 0.331f
C3171 xc5_outnb nr 0.239f
C3172 xs1p_cbn bp9 0.121f
C3173 xs1n_cbp cp10 0.69f
C3174 cn4 VSUBS 0.372f
C3175 cn7 VSUBS 0.285f
C3176 cn6 VSUBS 0.194f
C3177 xs1n_g VSUBS 0.446f
C3178 cp8 VSUBS 0.0889f
C3179 trk0 VSUBS 0.17f
C3180 xs0n_g VSUBS 0.491f
C3181 xc4_lt VSUBS 0.147f
C3182 xs1n_cbp VSUBS 0.0702f
C3183 cn6 cn2 0.248f
C3184 bp6 VSUBS 0.135f
C3185 xs1p_cbn VSUBS 1.07f
C3186 vrefl VSUBS 0.0721f
C3187 bn1 cp9 0.185f
C3188 bn0 xc5_xs1_tail0 0.13f
C3189 in0p VSUBS 0.241f
C3190 lsb_n VSUBS 0.117f
C3191 bp0 xs0p_g 0.102f
C3192 bn6 VSUBS 0.0539f
C3193 bn9 VSUBS 0.241f
C3194 bp6 bn2 0.111f
C3195 xc4_outnb VSUBS 0.161f
C3196 bp12 VSUBS 0.383f
C3197 vref VSUBS 0.417f
C3198 xs1p_cbn bn5 0.197f
C3199 bn4 VSUBS 0.0669f
C3200 clkn VSUBS 0.19f
C3201 clknb cp12 0.462f
C3202 bp7 VSUBS 0.16f
C3203 xc4_outnb VSUBS 0.138f
C3204 xc5_xs1_tail0 VSUBS 0.116f
C3205 vdd VSUBS 0.0969f
C3206 bn11 VSUBS 0.0632f
C3207 vbp VSUBS 0.144f
C3208 cp3 VSUBS 0.131f
C3209 xs0p_cbp VSUBS 0.0777f
C3210 cp12 VSUBS 0.214f
C3211 bn9 VSUBS 0.132f
C3212 bn4 xc4_xs1_tail 0.173f
C3213 xs0p_x VSUBS 0.0728f
C3214 xc5_lt xc4_xs1_tail0 0.123f
C3215 cn4 vref 0.208f
C3216 cn3 bp6 0.0666f
C3217 rstb_n bp1 0.314f
C3218 xc4_outnb VSUBS 0.192f
C3219 cn9 VSUBS 0.062f
C3220 in0p lsb_p 0.184f
C3221 xs0n_cbn xc4_dip 0.0916f
C3222 xs1n_cbn VSUBS 0.0352f
C3223 cp12 VSUBS 0.0546f
C3224 bn2 VSUBS 0.0765f
C3225 xc5_xs1_tail VSUBS 0.337f
C3226 cn0 bp11 0.243f
C3227 xs1p_cbp VSUBS 0.223f
C3228 bp3 xs0p_n10 0.0571f
C3229 cp5 VSUBS 0.278f
C3230 vdd xc4_dip 0.0757f
C3231 xs1n_g t1 0.245f
C3232 cp10 VSUBS 0.392f
C3233 xs1n_cbn cn12 0.411f
C3234 in0p VSUBS 0.0954f
C3235 xs0n_cbp clk 0.438f
C3236 xc4_din VSUBS 0.0643f
C3237 rstb_n bn1 0.0269f
C3238 xc4_outnb vdd 0.0389f
C3239 clk VSUBS 0.319f
C3240 gnd bn2 0.25f
C3241 cn2 VSUBS 0.0365f
C3242 bp1 VSUBS 0.138f
C3243 trk0 VSUBS 0.269f
C3244 xs0n_g VSUBS 0.159f
C3245 xs0p_n10 VSUBS 0.064f
C3246 onp VSUBS 0.749f
C3247 top_p xc4_outnb 0.219f
C3248 xc4_outpb VSUBS 0.464f
C3249 cn7 VSUBS 0.281f
C3250 bn5 bp2 0.044f
C3251 vdd VSUBS 0.433f
C3252 bn5 VSUBS 0.109f
C3253 xs1p_g VSUBS 0.15f
C3254 cp12 VSUBS 0.109f
C3255 bp11 bn11 0.535f
C3256 bn10 xc5_din 0.23f
C3257 cn6 bn12 0.126f
C3258 xc5_outnb xs0p_n10 0.524f
C3259 xs1p_x t1 0.288f
C3260 xs0p_cbp op 0.0773f
C3261 onp xs0n_cbn 0.399f
C3262 cp12 xs1n_g 0.0496f
C3263 onp VSUBS 0.094f
C3264 bn3 t1b 0.317f
C3265 bp5 bp8 0.175f
C3266 bp3 VSUBS 0.15f
C3267 cn10 VSUBS 0.455f
C3268 bn7 VSUBS 0.121f
C3269 cp3 bp0 0.104f
C3270 cn10 VSUBS 0.0597f
C3271 cp9 cn8 0.0932f
C3272 xc4_xs1_tail xc4_dip 0.0714f
C3273 bp3 VSUBS 0.44f
C3274 top_p VSUBS 0.145f
C3275 xc4_din VSUBS 0.0721f
C3276 bp11 VSUBS 0.117f
C3277 bn2 VSUBS 0.105f
C3278 cn3 VSUBS 0.243f
C3279 vbn VSUBS 0.0515f
C3280 xs0p_n10 in0p 0.206f
C3281 cn10 in1n 0.506f
C3282 xc5_lt VSUBS 0.348f
C3283 cn12 VSUBS 0.0901f
C3284 xs1p_cbn trk1 0.124f
C3285 bp8 VSUBS 0.406f
C3286 cp0 cn1 0.132f
C3287 vref xs1p_cbn 0.00932f
C3288 xs0n_cbn bn8 0.167f
C3289 t0b VSUBS 0.162f
C3290 cp10 in0p 0.253f
C3291 bn10 VSUBS 0.223f
C3292 cp1 VSUBS 0.268f
C3293 xc5_xs1_tail VSUBS 0.0938f
C3294 cp3 VSUBS 0.105f
C3295 xc4_xs1_tail0 vbn 0.146f
C3296 cp2 xs1n_cbp 0.195f
C3297 bn4 cp1 0.121f
C3298 top_n VSUBS 0.434f
C3299 rstb_n VSUBS 0.0573f
C3300 vrefl VSUBS 0.0996f
C3301 bn3 bn11 0.0584f
C3302 xs1n_n10 bp6 0.377f
C3303 in1n xs1n_n10 0.333f
C3304 xc5_lt VSUBS 0.135f
C3305 top_p cn5 0.123f
C3306 cp10 VSUBS 0.13f
C3307 cn5 cn3 0.66f
C3308 t1 bp2 0.255f
C3309 xs1p_n10 VSUBS 0.107f
C3310 in0n VSUBS 0.675f
C3311 cn9 bn2 0.133f
C3312 top_p VSUBS 0.0932f
C3313 bp2 VSUBS 0.0225f
C3314 cn5 VSUBS 0.118f
C3315 xs1p_cbn VSUBS 0.149f
C3316 onp VSUBS 0.121f
C3317 bn2 cp12 0.103f
C3318 bp5 VSUBS 0.384f
C3319 xc4_outnb VSUBS 0.133f
C3320 cn11 VSUBS 0.202f
C3321 xc4_outpb xs0n_x 0.142f
C3322 cn10 t1 0.19f
C3323 vbp cp5 0.0567f
C3324 bp2 xs1p_n10 0.45f
C3325 cp11 VSUBS 0.363f
C3326 bp12 VSUBS 0.247f
C3327 bn9 VSUBS 0.393f
C3328 bp11 VSUBS 0.472f
C3329 cn11 VSUBS 0.114f
C3330 bn1 bn6 0.0269f
C3331 bp0 VSUBS 0.345f
C3332 xs1n_x VSUBS 0.0774f
C3333 cn0 VSUBS 0.332f
C3334 cp6 VSUBS 0.381f
C3335 in1n VSUBS 0.0934f
C3336 bn4 nr 0.121f
C3337 cp11 VSUBS 0.301f
C3338 bp12 VSUBS 0.19f
C3339 xs1n_x VSUBS 0.279f
C3340 xc5_lt cp1 0.237f
C3341 xs0p_g cn10 0.114f
C3342 xs1n_g VSUBS 0.228f
C3343 bn11 xc4_outpb 0.0318f
C3344 xs1p_g VSUBS 0.155f
C3345 xs1p_g VSUBS 0.176f
C3346 xc4_xs1_tail0 cp1 0.137f
C3347 clk xs0p_n10 0.0501f
C3348 cn4 cp9 0.127f
C3349 cn9 cn8 0.0476f
C3350 nr cp7 0.187f
C3351 xs0p_cbn VSUBS 0.548f
C3352 vbn bn4 0.133f
C3353 cn10 VSUBS 0.0846f
C3354 cn5 VSUBS 0.101f
C3355 xs0p_g VSUBS 0.216f
C3356 xs1n_cbp VSUBS 0.0668f
C3357 cp7 op 0.188f
C3358 xs0n_cbp VSUBS 0.0651f
C3359 bn6 VSUBS 0.42f
C3360 trk0 VSUBS 0.188f
C3361 bn7 cp11 0.301f
C3362 nr VSUBS 0.495f
C3363 xs0n_cbp cp7 0.211f
C3364 xs0n_g VSUBS 0.0884f
C3365 cp10 VSUBS 0.199f
C3366 xc5_outnb rstb_n 0.111f
C3367 rstb VSUBS 0.0937f
C3368 bn7 VSUBS 0.0777f
C3369 top_n bp3 0.381f
C3370 clknb xc4_xs1_tail 0.165f
C3371 bp1 VSUBS 0.32f
C3372 xc4_xs1_tail VSUBS 0.0868f
C3373 t0 xs1p_cbn 0.15f
C3374 bn11 xc4_din 0.174f
C3375 cp7 vdd 0.104f
C3376 xs0n_x VSUBS 0.0912f
C3377 xs0n_g VSUBS 0.0506f
C3378 xs1p_n10 lsb_n 0.134f
C3379 clk xs1p_x 0.131f
C3380 xc4_xs1_tail0 xs0n_cbp 0.182f
C3381 onn VSUBS 1.59f
C3382 bn3 VSUBS 0.0763f
C3383 xs1p_n10 xc5_outnb 0.332f
C3384 xs0p_n10 VSUBS 0.0713f
C3385 xs0p_g VSUBS 0.159f
C3386 xc4_xs1_tail0 cn12 0.0942f
C3387 xc5_dip VSUBS 0.183f
C3388 xc5_lt VSUBS 0.0759f
C3389 xc4_dip VSUBS 0.114f
C3390 xs0p_n10 xs1n_x 0.115f
C3391 bp6 VSUBS 0.0701f
C3392 cp11 bn3 0.163f
C3393 xc5_din VSUBS 0.0602f
C3394 xs0p_n10 vrefl 0.0516f
C3395 lsb_p cp12 0.0743f
C3396 xs1p_n10 VSUBS 0.643f
C3397 top_p VSUBS 0.13f
C3398 xs0n_x VSUBS 0.0892f
C3399 xc4_dip top_n 0.2f
C3400 cn11 VSUBS 0.0459f
C3401 bp12 VSUBS 0.0302f
C3402 cp9 cn5 0.0233f
C3403 bp4 xc4_dip 0.177f
C3404 lsb_p xc4_lt 0.247f
C3405 cp0 bp4 0.471f
C3406 xs1p_cbn VSUBS 0.702f
C3407 xs0p_x VSUBS 0.354f
C3408 cn0 xs0n_n10 0.271f
C3409 bn11 lsb_n 0.149f
C3410 clkb VSUBS 0.104f
C3411 bn5 VSUBS 0.096f
C3412 nr VSUBS 0.121f
C3413 rstb_n cp0 0.0913f
C3414 cp12 VSUBS 0.25f
C3415 in1p VSUBS 0.153f
C3416 cn10 VSUBS 0.0796f
C3417 bn0 VSUBS 0.235f
C3418 xc5_outnb VSUBS 0.289f
C3419 on VSUBS 0.108f
C3420 bn6 VSUBS 0.243f
C3421 xs0n_cbp bn11 0.0337f
C3422 cn12 xc5_dip 0.2f
C3423 lsb_p cp12 0.265f
C3424 op VSUBS 0.0883f
C3425 rstb_n VSUBS 0.138f
C3426 cp0 VSUBS 0.13f
C3427 bp0 xs1n_n10 0.0911f
C3428 cp11 VSUBS 0.143f
C3429 rstb_n VSUBS 0.129f
C3430 bn6 VSUBS 0.262f
C3431 cn10 bp11 0.0507f
C3432 bn2 VSUBS 0.091f
C3433 bn5 VSUBS 0.078f
C3434 cp10 VSUBS 0.458f
C3435 bn8 VSUBS 0.0653f
C3436 bp3 nr 0.135f
C3437 vref VSUBS 0.18f
C3438 cn11 xs1n_x 0.162f
C3439 in0n xc5_lt 0.157f
C3440 gnd VSUBS 0.438f
C3441 xc4_lt VSUBS 0.0633f
C3442 vdd VSUBS 0.141f
C3443 xs0p_n10 VSUBS 0.449f
C3444 in1n xs0p_g 0.294f
C3445 xs0p_n10 on 0.237f
C3446 onn xc4_outnb 0.134f
C3447 bp8 VSUBS 0.196f
C3448 cn10 VSUBS 0.65f
C3449 vbn VSUBS 0.234f
C3450 xs1p_x VSUBS 0.142f
C3451 clknb VSUBS 0.142f
C3452 xc5_dip in1n 0.165f
C3453 xc4_outnb cn9 0.122f
C3454 gnd cn1 0.106f
C3455 t0b VSUBS 0.121f
C3456 xs1n_g VSUBS 0.0697f
C3457 xc5_outpb VSUBS 0.0234f
C3458 cp2 top_n 0.104f
C3459 cp4 VSUBS 0.114f
C3460 xs0p_cbp VSUBS 0.226f
C3461 onn VSUBS 0.392f
C3462 top_n VSUBS 0.158f
C3463 bp0 VSUBS 0.36f
C3464 lsb_p VSUBS 0.248f
C3465 bp11 bn10 0.291f
C3466 cn11 VSUBS 0.134f
C3467 xc5_din VSUBS 0.329f
C3468 bn1 VSUBS 0.499f
C3469 bn1 rstb 0.0858f
C3470 xc5_din VSUBS 0.0966f
C3471 in0n VSUBS 0.321f
C3472 cn4 VSUBS 0.121f
C3473 cp8 VSUBS 0.218f
C3474 cp12 VSUBS 0.373f
C3475 bn1 VSUBS 0.121f
C3476 cn5 bp11 0.218f
C3477 bp8 VSUBS 0.0321f
C3478 cp4 rstb 0.197f
C3479 bn9 bn7 0.159f
C3480 cn3 VSUBS 0.252f
C3481 xc4_lt VSUBS 0.158f
C3482 lsb_p xs0n_x 0.053f
C3483 trk1 VSUBS 0.263f
C3484 bp6 clknb 0.203f
C3485 xs0n_cbn clkb 0.0365f
C3486 on VSUBS 0.096f
C3487 cp7 VSUBS 0.364f
C3488 cn9 cn9 0.0804f
C3489 cp9 bn1 0.0824f
C3490 cn11 xs0p_n10 0.133f
C3491 nr xs1n_g 0.0896f
C3492 in1n VSUBS 0.108f
C3493 xs0n_cbp VSUBS 0.112f
C3494 lsb_n cn1 0.143f
C3495 cn9 VSUBS 0.259f
C3496 bn5 rstb 0.438f
C3497 xs0p_g xc4_lt 0.501f
C3498 xs1n_n10 VSUBS 0.474f
C3499 bn5 bn2 0.0415f
C3500 cn3 bn2 0.155f
C3501 cn7 nr 0.104f
C3502 cn10 bp10 0.131f
C3503 xc4_outpb VSUBS 0.396f
C3504 on lsb_n 0.124f
C3505 xs0p_x in1n 0.103f
C3506 xs1n_g cn4 0.311f
C3507 cp6 VSUBS 0.24f
C3508 bn3 VSUBS 0.111f
C3509 t1 xs1n_cbn 0.069f
C3510 bn12 VSUBS 0.241f
C3511 xs1p_n10 on 0.102f
C3512 xc4_xs1_tail0 VSUBS 0.264f
C3513 vref VSUBS 0.0794f
C3514 bn11 xs1n_n10 0.0902f
C3515 clk VSUBS 0.21f
C3516 xs0p_cbp cn12 0.255f
C3517 xs1p_x xc4_outnb 0.292f
C3518 top_p VSUBS 0.364f
C3519 cn7 VSUBS 0.0547f
C3520 vref VSUBS 0.352f
C3521 top_n xs0n_g 0.129f
C3522 xc4_xs1_tail0 xc4_outnb 0.0594f
C3523 top_p VSUBS 0.325f
C3524 xs1n_g xc5_outpb 0.0746f
C3525 cn7 VSUBS 0.167f
C3526 cp0 cn4 0.0226f
C3527 bp8 VSUBS 0.226f
C3528 cp7 clkn 0.0936f
C3529 xc5_outpb VSUBS 0.104f
C3530 bp1 xs0n_g 0.202f
C3531 cn10 VSUBS 0.16f
C3532 gnd VSUBS 0.259f
C3533 xc4_outnb VSUBS 0.142f
C3534 t1b cn7 0.0823f
C3535 cn12 VSUBS 0.212f
C3536 bn4 clk 0.0602f
C3537 vbn VSUBS 0.341f
C3538 cp0 VSUBS 0.0805f
C3539 bn5 VSUBS 0.124f
C3540 xc5_xs1_tail0 xc5_lt 0.0571f
C3541 xc5_dip VSUBS 0.0218f
C3542 cp10 VSUBS 0.299f
C3543 bn6 bp12 0.0913f
C3544 bp9 VSUBS 0.236f
C3545 bn7 VSUBS 0.0623f
C3546 xs1n_cbn VSUBS 0.0468f
C3547 xs1n_n10 VSUBS 0.539f
C3548 cp12 VSUBS 0.587f
C3549 clkb VSUBS 0.257f
C3550 xs1p_g VSUBS 0.143f
C3551 xs1p_g VSUBS 0.346f
C3552 cn10 VSUBS 0.146f
C3553 onp VSUBS 0.233f
C3554 xc4_din clk 0.118f
C3555 xc5_din VSUBS 0.113f
C3556 bn12 VSUBS 0.114f
C3557 bn0 cn6 0.257f
C3558 bp11 VSUBS 0.36f
C3559 top_n VSUBS 0.188f
C3560 cp5 cp0 0.321f
C3561 xs1n_cbn cn1 0.806f
C3562 xs0p_g VSUBS 0.47f
C3563 bn11 VSUBS 0.208f
C3564 cn4 VSUBS 0.0875f
C3565 cp12 VSUBS 0.139f
C3566 bp7 cn9 0.079f
C3567 t0 VSUBS 0.0932f
C3568 bn4 VSUBS 0.596f
C3569 vref VSUBS 0.306f
C3570 xs1n_x VSUBS 0.202f
C3571 cp3 t0 0.243f
C3572 xs0n_g vref 0.131f
C3573 xs1p_cbp VSUBS 0.3f
C3574 lsb_n cp9 0.0659f
C3575 bp10 VSUBS 0.177f
C3576 bp4 VSUBS 0.16f
C3577 bp8 bn10 0.0592f
C3578 xs0p_x cp2 0.087f
C3579 cn2 VSUBS 0.185f
C3580 bn11 xc5_lt 0.226f
C3581 lsb_n xs0n_g 0.169f
C3582 cn8 VSUBS 0.095f
C3583 bn5 VSUBS 0.074f
C3584 clknb VSUBS 0.0472f
C3585 vdd VSUBS 0.204f
C3586 t1b VSUBS 0.177f
C3587 cn0 cn1 0.103f
C3588 bp7 VSUBS 0.166f
C3589 cp8 VSUBS 0.0346f
C3590 clk xc5_xs1_tail0 0.162f
C3591 xc5_dip vbn 0.153f
C3592 bp8 VSUBS 0.363f
C3593 cp11 VSUBS 0.102f
C3594 cp2 VSUBS 0.113f
C3595 bp5 rstb_n 0.137f
C3596 bn11 VSUBS 0.11f
C3597 bp7 xc5_dip 0.0497f
C3598 cp7 top_p 0.279f
C3599 vbp bn4 0.056f
C3600 clkn VSUBS 0.596f
C3601 xs1p_x VSUBS 0.955f
C3602 t0b VSUBS 0.135f
C3603 bn9 VSUBS 0.563f
C3604 xs1p_cbn VSUBS 0.595f
C3605 cp6 VSUBS 0.0549f
C3606 clk VSUBS 0.161f
C3607 lsb_p xs0n_cbn 0.196f
C3608 vdd xc5_lt 0.0675f
C3609 vbp cn12 0.18f
C3610 bn2 VSUBS 0.0728f
C3611 lsb_p VSUBS 0.344f
C3612 cn9 VSUBS 0.622f
C3613 cp11 VSUBS 0.0801f
C3614 in0n xs1p_cbn 0.0583f
C3615 xc4_xs1_tail0 rstb_n 0.628f
C3616 bn7 VSUBS 0.378f
C3617 cn0 VSUBS 0.36f
C3618 t1 VSUBS 0.0728f
C3619 xs1p_x t0 0.203f
C3620 cp1 VSUBS 0.0321f
C3621 xc5_lt VSUBS 0.0993f
C3622 xs0p_cbp VSUBS 0.059f
C3623 bp9 cp11 1.03f
C3624 xs0p_cbn xc5_dip 0.409f
C3625 cn5 xc4_din 0.11f
C3626 xs0n_n10 VSUBS 0.287f
C3627 lsb_p on 0.144f
C3628 cn3 VSUBS 0.127f
C3629 xc5_xs1_tail bp0 0.359f
C3630 xs1p_cbp VSUBS 0.185f
C3631 onn VSUBS 0.216f
C3632 cp9 bn9 0.174f
C3633 clk VSUBS 0.0704f
C3634 vbn VSUBS 0.0653f
C3635 clknb rstb_n 0.158f
C3636 xc5_xs1_tail cn1 0.0976f
C3637 bn3 VSUBS 0.109f
C3638 cn12 VSUBS 0.278f
C3639 cn11 t1 0.0669f
C3640 xc5_outpb lsb_p 0.169f
C3641 vref VSUBS 0.0373f
C3642 xs1n_cbp bn10 0.227f
C3643 rstb onn 0.257f
C3644 bp0 VSUBS 0.0637f
C3645 xs1p_n10 cp8 0.199f
C3646 op VSUBS 0.0531f
C3647 top_p VSUBS 0.165f
C3648 xs0n_cbn VSUBS 0.0413f
C3649 xc5_xs1_tail VSUBS 0.803f
C3650 cn5 VSUBS 0.103f
C3651 cp10 VSUBS 0.133f
C3652 bn0 VSUBS 0.219f
C3653 trk0 xs0p_cbp 0.154f
C3654 vbn VSUBS 0.312f
C3655 cn2 cp1 0.0694f
C3656 cp3 bp5 0.0819f
C3657 vbn in1n 0.0134f
C3658 xs1p_cbp top_p 0.385f
C3659 cn1 xc5_lt 0.151f
C3660 xc5_xs1_tail rstb_n 0.153f
C3661 xs1n_n10 cp12 0.252f
C3662 cp4 VSUBS 0.159f
C3663 xs0n_x bn0 0.295f
C3664 cn11 cn10 0.278f
C3665 in1n cp0 0.197f
C3666 xc5_outpb xc4_xs1_tail0 0.182f
C3667 clknb cp4 0.285f
C3668 xs1p_cbp VSUBS 0.188f
C3669 xs1n_cbp cn7 0.0695f
C3670 xc5_din cp6 0.476f
C3671 cp12 xs1n_g 0.0984f
C3672 bn7 vdd 0.156f
C3673 clk xs0n_cbn 0.624f
C3674 cn8 VSUBS 0.2f
C3675 xc5_lt bn2 0.281f
C3676 top_p VSUBS 0.0437f
C3677 cn10 VSUBS 0.189f
C3678 bn10 xs0p_g 0.245f
C3679 clknb bp4 0.427f
C3680 bp9 VSUBS 0.354f
C3681 xs0p_n10 VSUBS 0.474f
C3682 bn8 VSUBS 0.1f
C3683 cn7 VSUBS 0.044f
C3684 vrefl nr 0.0712f
C3685 clk VSUBS 0.0326f
C3686 xs1p_g cn9 0.221f
C3687 xc4_xs1_tail0 bp0 0.245f
C3688 bp3 VSUBS 0.197f
C3689 lsb_p VSUBS 0.301f
C3690 cn9 VSUBS 0.262f
C3691 cn8 VSUBS 0.151f
C3692 xc5_din VSUBS 0.0193f
C3693 cp2 VSUBS 0.0826f
C3694 bn7 bp9 0.331f
C3695 cn1 VSUBS 0.0837f
C3696 bp4 VSUBS 0.101f
C3697 cp1 VSUBS 0.173f
C3698 trk0 VSUBS 0.0944f
C3699 bp6 cp0 0.0486f
C3700 t1b VSUBS 0.236f
C3701 cp6 t1b 0.28f
C3702 cn11 VSUBS 0.0824f
C3703 xs1n_x VSUBS 0.142f
C3704 cp12 VSUBS 0.101f
C3705 clknb VSUBS 0.537f
C3706 cp11 xs1n_g 0.633f
C3707 cp12 onn 0.122f
C3708 bp9 VSUBS 0.553f
C3709 cn9 VSUBS 1.45f
C3710 bp7 rstb_n 0.0721f
C3711 t0b VSUBS 0.0887f
C3712 vdd VSUBS 0.215f
C3713 vrefl VSUBS 0.234f
C3714 xc4_xs1_tail VSUBS 0.178f
C3715 bp5 xc4_dip 0.14f
C3716 cn11 VSUBS 0.0747f
C3717 lsb_n VSUBS 1.24f
C3718 onn VSUBS 0.428f
C3719 on VSUBS 0.379f
C3720 t0b cn3 0.119f
C3721 bn10 VSUBS 0.392f
C3722 cp7 bp10 0.0536f
C3723 t1 VSUBS 0.147f
C3724 top_p VSUBS 0.451f
C3725 vbp bp3 0.31f
C3726 xc5_outpb VSUBS 2.89f
C3727 cp0 VSUBS 0.134f
C3728 xs0p_cbn VSUBS 0.114f
C3729 t1 VSUBS 0.721f
C3730 vrefl in0n 0.16f
C3731 vref VSUBS 0.0574f
C3732 t1 VSUBS 0.145f
C3733 bp3 xc4_xs1_tail0 0.211f
C3734 bn9 xc4_dip 0.154f
C3735 xc4_din VSUBS 0.423f
C3736 clkb VSUBS 0.212f
C3737 bp3 cp3 0.151f
C3738 xc5_din VSUBS 0.177f
C3739 cn12 in0n 0.0793f
C3740 bp4 VSUBS 0.0986f
C3741 cn1 bp9 0.522f
C3742 xc5_dip VSUBS 0.0718f
C3743 xs1p_x in0n 0.125f
C3744 bn10 VSUBS 0.185f
C3745 t0 bp1 0.0794f
C3746 xs1p_cbn xc4_xs1_tail0 0.097f
C3747 vdd VSUBS 0.0726f
C3748 cn5 VSUBS 0.182f
C3749 in1p bn6 0.63f
C3750 xs1p_cbp VSUBS 0.125f
C3751 bp7 xc5_xs1_tail0 0.0805f
C3752 xs1p_cbp VSUBS 0.0849f
C3753 bp3 VSUBS 0.105f
C3754 xc4_xs1_tail vbp 0.539f
C3755 op VSUBS 0.158f
C3756 bn5 VSUBS 0.0434f
C3757 top_p bp6 0.053f
C3758 cp10 VSUBS 0.0449f
C3759 xs0n_n10 VSUBS 0.21f
C3760 nr VSUBS 0.0651f
C3761 xc5_outnb VSUBS 0.105f
C3762 cn3 rstb_n 0.0685f
C3763 cp10 cn1 0.107f
C3764 clkb VSUBS 0.395f
C3765 xc4_din VSUBS 0.221f
C3766 cn3 VSUBS 0.0694f
C3767 cn3 xs0n_cbn 0.0419f
C3768 bn0 VSUBS 0.155f
C3769 top_n bp1 0.296f
C3770 bp5 bp1 0.209f
C3771 gnd VSUBS 0.194f
C3772 onp xs0p_g 0.234f
C3773 cp1 VSUBS 0.258f
C3774 xs0n_cbn clkb 0.349f
C3775 xc4_outnb VSUBS 0.243f
C3776 bp0 VSUBS 0.16f
C3777 xc4_din VSUBS 0.106f
C3778 xs0n_n10 VSUBS 0.288f
C3779 clknb vbn 0.0994f
C3780 lsb_n VSUBS 0.286f
C3781 bp3 VSUBS 0.15f
C3782 cn7 VSUBS 0.214f
C3783 xs0n_cbp VSUBS 0.0728f
C3784 vbp cp6 0.157f
C3785 xs0n_n10 VSUBS 0.658f
C3786 xc5_lt VSUBS 0.0966f
C3787 xc4_outpb cn3 0.0332f
C3788 xc5_din VSUBS 0.48f
C3789 cp10 VSUBS 1.45f
C3790 xc5_lt xc5_xs1_tail 0.433f
C3791 gnd VSUBS 0.188f
C3792 clkn VSUBS 0.127f
C3793 top_n bp7 0.0885f
C3794 rstb_n VSUBS 0.512f
C3795 xs1n_x cp8 0.857f
C3796 xs0n_cbn VSUBS 0.057f
C3797 xs0p_n10 t1b 0.363f
C3798 t1 VSUBS 0.127f
C3799 bp9 bn8 0.169f
C3800 bn5 bp5 0.131f
C3801 bp8 VSUBS 0.0832f
C3802 xc4_dip cp1 0.111f
C3803 top_p VSUBS 0.101f
C3804 gnd VSUBS 0.108f
C3805 bp11 VSUBS 0.172f
C3806 nr VSUBS 0.0363f
C3807 xc5_xs1_tail0 cp7 0.22f
C3808 clkb VSUBS 0.0521f
C3809 cp7 VSUBS 0.0525f
C3810 cp7 VSUBS 0.56f
C3811 bp3 VSUBS 0.132f
C3812 bp6 VSUBS 0.0794f
C3813 bn5 VSUBS 0.249f
C3814 xs0n_cbp bn9 0.137f
C3815 xc4_lt VSUBS 0.106f
C3816 xc5_xs1_tail0 VSUBS 0.254f
C3817 t1 VSUBS 0.158f
C3818 xs0p_cbp VSUBS 0.0536f
C3819 bn9 bp7 0.0478f
C3820 cp2 VSUBS 0.0791f
C3821 in1n VSUBS 0.58f
C3822 t1b bp6 0.235f
C3823 vbp VSUBS 0.12f
C3824 top_p bp10 0.0681f
C3825 t0b cn3 0.167f
C3826 vbp bp8 0.435f
C3827 bp4 VSUBS 0.131f
C3828 xc5_lt xs0p_cbp 0.312f
C3829 cn2 VSUBS 0.0995f
C3830 cn8 VSUBS 0.451f
C3831 bn8 VSUBS 0.21f
C3832 cn10 VSUBS 0.219f
C3833 in1p VSUBS 0.378f
C3834 xc4_xs1_tail0 VSUBS 0.167f
C3835 xs1p_g VSUBS 0.0783f
C3836 cp8 xc4_outpb 0.231f
C3837 xs1n_cbp VSUBS 0.0815f
C3838 vref VSUBS 0.364f
C3839 on VSUBS 0.22f
C3840 trk0 VSUBS 0.399f
C3841 cp1 VSUBS 0.207f
C3842 bp5 xs1n_n10 0.638f
C3843 xs1p_g xs1p_cbp 0.21f
C3844 op VSUBS 0.344f
C3845 cp2 VSUBS 0.0823f
C3846 bn11 cn11 0.419f
C3847 xc4_outnb VSUBS 0.116f
C3848 nr rstb 0.0913f
C3849 xc4_dip VSUBS 0.251f
C3850 bn6 xs1n_cbn 0.157f
C3851 bn3 bp5 0.403f
C3852 in0n VSUBS 0.171f
C3853 cp1 bp8 0.145f
C3854 xs1p_cbn VSUBS 0.0619f
C3855 bp6 bn7 0.433f
C3856 cp2 clkb 0.027f
C3857 rstb VSUBS 0.701f
C3858 xc5_outpb vbn 0.555f
C3859 lsb_n VSUBS 0.318f
C3860 t0b VSUBS 0.375f
C3861 cn7 VSUBS 0.3f
C3862 xs0n_x VSUBS 0.285f
C3863 cp8 cp11 0.163f
C3864 op VSUBS 0.196f
C3865 bp1 xc4_outnb 0.13f
C3866 in1n VSUBS 0.0791f
C3867 cp8 cp2 0.119f
C3868 cp7 VSUBS 0.426f
C3869 bn0 VSUBS 0.0705f
C3870 xs0n_cbp VSUBS 0.0853f
C3871 onn xc5_outnb 0.118f
C3872 xc5_outpb xs1p_n10 0.171f
C3873 clkb VSUBS 0.0557f
C3874 xs0p_cbn bp3 0.825f
C3875 onn VSUBS 0.131f
C3876 bp8 xs0p_n10 0.108f
C3877 clknb xc5_lt 0.0934f
C3878 bn12 VSUBS 0.114f
C3879 bp2 VSUBS 0.0777f
C3880 cn2 clkb 0.165f
C3881 xs1n_cbp VSUBS 0.257f
C3882 op xs0p_cbp 0.0871f
C3883 trk1 VSUBS 0.0478f
C3884 cp0 VSUBS 0.265f
C3885 on nr 1.21f
C3886 bn9 cp12 0.0252f
C3887 clk VSUBS 1.42f
C3888 xc5_xs1_tail0 VSUBS 0.134f
C3889 top_n t0 0.223f
C3890 cp11 t0 0.147f
C3891 op VSUBS 0.0705f
C3892 bp12 VSUBS 0.0485f
C3893 cp11 VSUBS 0.0562f
C3894 bn0 VSUBS 0.13f
C3895 xs0n_g VSUBS 0.2f
C3896 cn1 xc5_lt 0.181f
C3897 xc4_lt VSUBS 0.299f
C3898 cp1 VSUBS 0.0959f
C3899 cn4 VSUBS 1.78f
C3900 clk VSUBS 0.183f
C3901 cp5 vref 0.303f
C3902 bn0 VSUBS 0.221f
C3903 xs1p_cbn bn6 0.28f
C3904 xc4_dip VSUBS 0.0492f
C3905 bn9 VSUBS 0.291f
C3906 xs0n_cbn cp7 0.0986f
C3907 bp0 VSUBS 0.175f
C3908 cn3 VSUBS 0.118f
C3909 xc4_din VSUBS 0.178f
C3910 xs1p_x VSUBS 0.097f
C3911 lsb_p VSUBS 0.101f
C3912 bp8 xc5_outnb 0.227f
C3913 bp10 VSUBS 0.121f
C3914 cp11 top_n 0.243f
C3915 cn5 xc4_outnb 0.4f
C3916 xc5_dip nr 0.308f
C3917 bn5 VSUBS 0.138f
C3918 on xc5_xs1_tail 0.448f
C3919 xs1n_g vbn 0.0947f
C3920 bn10 VSUBS 0.114f
C3921 t0b VSUBS 0.08f
C3922 gnd VSUBS 0.303f
C3923 cn6 bn8 0.132f
C3924 xs1p_x VSUBS 0.126f
C3925 bn5 VSUBS 0.157f
C3926 vrefl VSUBS 0.0815f
C3927 xc4_outpb xs1n_cbn 0.189f
C3928 xc4_din vrefl 0.19f
C3929 t1 bn1 0.145f
C3930 top_n top_p 0.446f
C3931 cp7 VSUBS 0.309f
C3932 cp3 VSUBS 0.167f
C3933 cp8 VSUBS 0.226f
C3934 xs1p_x VSUBS 0.318f
C3935 cn0 vbn 0.058f
C3936 lsb_n VSUBS 0.214f
C3937 xc4_xs1_tail0 vrefl 0.288f
C3938 xs1n_cbn VSUBS 0.19f
C3939 vbp VSUBS 0.04f
C3940 xc4_lt VSUBS 0.25f
C3941 cp9 VSUBS 0.1f
C3942 xs0p_cbn xc5_xs1_tail0 0.131f
C3943 bn7 xs0p_x 0.315f
C3944 bn2 clkb 0.169f
C3945 xs0n_n10 VSUBS 0.0602f
C3946 clkn clkn 0.0386f
C3947 bn4 xc4_din 0.12f
C3948 cp0 xc5_xs1_tail 0.324f
C3949 cp12 VSUBS 0.0361f
C3950 xc5_lt VSUBS 0.216f
C3951 rstb VSUBS 0.0821f
C3952 on VSUBS 0.22f
C3953 cp4 VSUBS 0.209f
C3954 clkn bn5 0.0562f
C3955 bp8 VSUBS 0.329f
C3956 t0b top_p 0.0631f
C3957 clk xs0p_cbn 0.288f
C3958 bn4 cn7 0.235f
C3959 xs1p_g cp6 0.0481f
C3960 cp3 VSUBS 0.154f
C3961 vbp VSUBS 0.561f
C3962 cp11 vref 0.0289f
C3963 xs1n_g vref 0.456f
C3964 xc4_xs1_tail VSUBS 0.944f
C3965 cn9 VSUBS 0.462f
C3966 bp3 cp2 0.172f
C3967 cn3 xc4_dip 0.167f
C3968 bn6 VSUBS 0.429f
C3969 cp3 VSUBS 0.322f
C3970 xs1p_n10 VSUBS 0.0534f
C3971 xc4_outpb bp11 0.134f
C3972 bn6 VSUBS 0.194f
C3973 bn9 rstb_n 0.209f
C3974 cn9 VSUBS 0.0653f
C3975 cp2 cn8 0.282f
C3976 vdd VSUBS 0.281f
C3977 cp8 bp10 0.283f
C3978 bp2 bp5 0.0593f
C3979 xs1p_n10 xs0p_n10 0.0676f
C3980 cp9 VSUBS 0.174f
C3981 in0p xc5_dip 0.382f
C3982 in1p xc4_xs1_tail0 0.381f
C3983 gnd bp5 0.0613f
C3984 t0b VSUBS 1.01f
C3985 t1 VSUBS 0.174f
C3986 onn VSUBS 0.154f
C3987 xs0p_cbp in0p 0.227f
C3988 bn11 VSUBS 0.0648f
C3989 t0 bn5 0.338f
C3990 xs0n_g VSUBS 0.0497f
C3991 bn12 VSUBS 0.131f
C3992 on cn9 0.279f
C3993 top_p VSUBS 0.545f
C3994 xs0n_cbn vref 0.0507f
C3995 cp2 bp6 0.313f
C3996 cp0 VSUBS 0.211f
C3997 xc4_xs1_tail0 cn9 0.0776f
C3998 xs0p_n10 clk 0.091f
C3999 cp10 bn11 0.203f
Rl0_0 cn4 lad0_0 19.2
Cl0_0 lad0_0 VSUBS 0.1f
Rl0_1 lad0_0 lad0_1 10.4
Cl0_1 lad0_1 VSUBS 0.1f
Rl0_2 lad0_1 lad0_2 1.15
Cl0_2 lad0_2 VSUBS 0.1f
Rl0_3 lad0_2 lad0_3 9.67
Cl0_3 lad0_3 VSUBS 0.1f
Rl0_4 lad0_3 lad0_4 12.5
Cl0_4 lad0_4 VSUBS 0.1f
Rl0_5 lad0_4 lad0_5 16.1
Cl0_5 lad0_5 VSUBS 0.1f
Rl0_6 lad0_5 lad0_6 11.1
Cl0_6 lad0_6 VSUBS 0.1f
Rl0_7 lad0_6 lad0_7 7.43
Cl0_7 lad0_7 VSUBS 0.1f
Rl0_8 lad0_7 lad0_8 17.3
Cl0_8 lad0_8 VSUBS 0.1f
Rl0_9 lad0_8 lad0_9 5.94
Cl0_9 lad0_9 VSUBS 0.1f
Rl1_0 xs0p_x lad1_0 12.2
Cl1_0 lad1_0 VSUBS 0.1f
Rl1_1 lad1_0 lad1_1 17.6
Cl1_1 lad1_1 VSUBS 0.1f
Rl1_2 lad1_1 lad1_2 7.68
Cl1_2 lad1_2 VSUBS 0.1f
Rl1_3 lad1_2 lad1_3 2.25
Cl1_3 lad1_3 VSUBS 0.1f
Rl1_4 lad1_3 lad1_4 8.49
Cl1_4 lad1_4 VSUBS 0.1f
Rl1_5 lad1_4 lad1_5 16.3
Cl1_5 lad1_5 VSUBS 0.1f
Rl1_6 lad1_5 lad1_6 19.9
Cl1_6 lad1_6 VSUBS 0.1f
Rl1_7 lad1_6 lad1_7 11.5
Cl1_7 lad1_7 VSUBS 0.1f
Rl1_8 lad1_7 lad1_8 5.33
Cl1_8 lad1_8 VSUBS 0.1f
Rl1_9 lad1_8 lad1_9 9.72
Cl1_9 lad1_9 VSUBS 0.1f
Rl2_0 rstb_n lad2_0 13.5
Cl2_0 lad2_0 VSUBS 0.1f
Rl2_1 lad2_0 lad2_1 1.61
Cl2_1 lad2_1 VSUBS 0.1f
Rl2_2 lad2_1 lad2_2 2.24
Cl2_2 lad2_2 VSUBS 0.1f
Rl2_3 lad2_2 lad2_3 2.54
Cl2_3 lad2_3 VSUBS 0.1f
Rl2_4 lad2_3 lad2_4 9.82
Cl2_4 lad2_4 VSUBS 0.1f
Rl2_5 lad2_4 lad2_5 12.3
Cl2_5 lad2_5 VSUBS 0.1f
Rl2_6 lad2_5 lad2_6 13
Cl2_6 lad2_6 VSUBS 0.1f
Rl2_7 lad2_6 lad2_7 1.82
Cl2_7 lad2_7 VSUBS 0.1f
Rl2_8 lad2_7 lad2_8 19.6
Cl2_8 lad2_8 VSUBS 0.1f
Rl2_9 lad2_8 lad2_9 14.1
Cl2_9 lad2_9 VSUBS 0.1f
Rl3_0 rstb lad3_0 7.64
Cl3_0 lad3_0 VSUBS 0.1f
Rl3_1 lad3_0 lad3_1 16.5
Cl3_1 lad3_1 VSUBS 0.1f
Rl3_2 lad3_1 lad3_2 11
Cl3_2 lad3_2 VSUBS 0.1f
Rl3_3 lad3_2 lad3_3 6.41
Cl3_3 lad3_3 VSUBS 0.1f
Rl3_4 lad3_3 lad3_4 4.12
Cl3_4 lad3_4 VSUBS 0.1f
Rl3_5 lad3_4 lad3_5 2.69
Cl3_5 lad3_5 VSUBS 0.1f
Rl3_6 lad3_5 lad3_6 9.82
Cl3_6 lad3_6 VSUBS 0.1f
Rl3_7 lad3_6 lad3_7 3.5
Cl3_7 lad3_7 VSUBS 0.1f
Rl3_8 lad3_7 lad3_8 8.47
Cl3_8 lad3_8 VSUBS 0.1f
Rl3_9 lad3_8 lad3_9 11.4
Cl3_9 lad3_9 VSUBS 0.1f
Rl4_0 rstb lad4_0 8.17
Cl4_0 lad4_0 VSUBS 0.1f
Rl4_1 lad4_0 lad4_1 14.5
Cl4_1 lad4_1 VSUBS 0.1f
Rl4_2 lad4_1 lad4_2 2.47
Cl4_2 lad4_2 VSUBS 0.1f
Rl4_3 lad4_2 lad4_3 5.86
Cl4_3 lad4_3 VSUBS 0.1f
Rl4_4 lad4_3 lad4_4 1.7
Cl4_4 lad4_4 VSUBS 0.1f
Rl4_5 lad4_4 lad4_5 9.39
Cl4_5 lad4_5 VSUBS 0.1f
Rl4_6 lad4_5 lad4_6 10
Cl4_6 lad4_6 VSUBS 0.1f
Rl4_7 lad4_6 lad4_7 13.3
Cl4_7 lad4_7 VSUBS 0.1f
Rl4_8 lad4_7 lad4_8 15.8
Cl4_8 lad4_8 VSUBS 0.1f
Rl4_9 lad4_8 lad4_9 19.9
Cl4_9 lad4_9 VSUBS 0.1f
Rl5_0 lsb_p lad5_0 10.3
Cl5_0 lad5_0 VSUBS 0.1f
Rl5_1 lad5_0 lad5_1 9.23
Cl5_1 lad5_1 VSUBS 0.1f
Rl5_2 lad5_1 lad5_2 9.9
Cl5_2 lad5_2 VSUBS 0.1f
Rl5_3 lad5_2 lad5_3 10.2
Cl5_3 lad5_3 VSUBS 0.1f
Rl5_4 lad5_3 lad5_4 14.6
Cl5_4 lad5_4 VSUBS 0.1f
Rl5_5 lad5_4 lad5_5 15.9
Cl5_5 lad5_5 VSUBS 0.1f
Rl5_6 lad5_5 lad5_6 9.13
Cl5_6 lad5_6 VSUBS 0.1f
Rl5_7 lad5_6 lad5_7 12.6
Cl5_7 lad5_7 VSUBS 0.1f
Rl5_8 lad5_7 lad5_8 18.2
Cl5_8 lad5_8 VSUBS 0.1f
Rl5_9 lad5_8 lad5_9 17.7
Cl5_9 lad5_9 VSUBS 0.1f
Rl6_0 bp8 lad6_0 2.92
Cl6_0 lad6_0 VSUBS 0.1f
Rl6_1 lad6_0 lad6_1 12.6
Cl6_1 lad6_1 VSUBS 0.1f
Rl6_2 lad6_1 lad6_2 19
Cl6_2 lad6_2 VSUBS 0.1f
Rl6_3 lad6_2 lad6_3 4.53
Cl6_3 lad6_3 VSUBS 0.1f
Rl6_4 lad6_3 lad6_4 3.63
Cl6_4 lad6_4 VSUBS 0.1f
Rl6_5 lad6_4 lad6_5 8.46
Cl6_5 lad6_5 VSUBS 0.1f
Rl6_6 lad6_5 lad6_6 10.4
Cl6_6 lad6_6 VSUBS 0.1f
Rl6_7 lad6_6 lad6_7 2.44
Cl6_7 lad6_7 VSUBS 0.1f
Rl6_8 lad6_7 lad6_8 14.6
Cl6_8 lad6_8 VSUBS 0.1f
Rl6_9 lad6_8 lad6_9 12
Cl6_9 lad6_9 VSUBS 0.1f
Rl7_0 t1 lad7_0 13.8
Cl7_0 lad7_0 VSUBS 0.1f
Rl7_1 lad7_0 lad7_1 11.1
Cl7_1 lad7_1 VSUBS 0.1f
Rl7_2 lad7_1 lad7_2 15.1
Cl7_2 lad7_2 VSUBS 0.1f
Rl7_3 lad7_2 lad7_3 11.3
Cl7_3 lad7_3 VSUBS 0.1f
Rl7_4 lad7_3 lad7_4 7.34
Cl7_4 lad7_4 VSUBS 0.1f
Rl7_5 lad7_4 lad7_5 19
Cl7_5 lad7_5 VSUBS 0.1f
Rl7_6 lad7_5 lad7_6 15.9
Cl7_6 lad7_6 VSUBS 0.1f
Rl7_7 lad7_6 lad7_7 17.4
Cl7_7 lad7_7 VSUBS 0.1f
Rl7_8 lad7_7 lad7_8 12.3
Cl7_8 lad7_8 VSUBS 0.1f
Rl7_9 lad7_8 lad7_9 9.4
Cl7_9 lad7_9 VSUBS 0.1f
Rl8_0 cp6 lad8_0 16.7
Cl8_0 lad8_0 VSUBS 0.1f
Rl8_1 lad8_0 lad8_1 10.1
Cl8_1 lad8_1 VSUBS 0.1f
Rl8_2 lad8_1 lad8_2 6.05
Cl8_2 lad8_2 VSUBS 0.1f
Rl8_3 lad8_2 lad8_3 7.76
Cl8_3 lad8_3 VSUBS 0.1f
Rl8_4 lad8_3 lad8_4 10.6
Cl8_4 lad8_4 VSUBS 0.1f
Rl8_5 lad8_4 lad8_5 3.26
Cl8_5 lad8_5 VSUBS 0.1f
Rl8_6 lad8_5 lad8_6 5.37
Cl8_6 lad8_6 VSUBS 0.1f
Rl8_7 lad8_6 lad8_7 11.7
Cl8_7 lad8_7 VSUBS 0.1f
Rl8_8 lad8_7 lad8_8 12.7
Cl8_8 lad8_8 VSUBS 0.1f
Rl8_9 lad8_8 lad8_9 5.67
Cl8_9 lad8_9 VSUBS 0.1f
Rl9_0 bn3 lad9_0 16.4
Cl9_0 lad9_0 VSUBS 0.1f
Rl9_1 lad9_0 lad9_1 5.85
Cl9_1 lad9_1 VSUBS 0.1f
Rl9_2 lad9_1 lad9_2 3.48
Cl9_2 lad9_2 VSUBS 0.1f
Rl9_3 lad9_2 lad9_3 15.8
Cl9_3 lad9_3 VSUBS 0.1f
Rl9_4 lad9_3 lad9_4 8.01
Cl9_4 lad9_4 VSUBS 0.1f
Rl9_5 lad9_4 lad9_5 6.38
Cl9_5 lad9_5 VSUBS 0.1f
Rl9_6 lad9_5 lad9_6 2.76
Cl9_6 lad9_6 VSUBS 0.1f
Rl9_7 lad9_6 lad9_7 8.12
Cl9_7 lad9_7 VSUBS 0.1f
Rl9_8 lad9_7 lad9_8 16.2
Cl9_8 lad9_8 VSUBS 0.1f
Rl9_9 lad9_8 lad9_9 2
Cl9_9 lad9_9 VSUBS 0.1f
Rl10_0 xs0n_cbp lad10_0 3.47
Cl10_0 lad10_0 VSUBS 0.1f
Rl10_1 lad10_0 lad10_1 1.29
Cl10_1 lad10_1 VSUBS 0.1f
Rl10_2 lad10_1 lad10_2 19.8
Cl10_2 lad10_2 VSUBS 0.1f
Rl10_3 lad10_2 lad10_3 8.64
Cl10_3 lad10_3 VSUBS 0.1f
Rl10_4 lad10_3 lad10_4 3.81
Cl10_4 lad10_4 VSUBS 0.1f
Rl10_5 lad10_4 lad10_5 5.19
Cl10_5 lad10_5 VSUBS 0.1f
Rl10_6 lad10_5 lad10_6 11.7
Cl10_6 lad10_6 VSUBS 0.1f
Rl10_7 lad10_6 lad10_7 15.7
Cl10_7 lad10_7 VSUBS 0.1f
Rl10_8 lad10_7 lad10_8 7.17
Cl10_8 lad10_8 VSUBS 0.1f
Rl10_9 lad10_8 lad10_9 18.7
Cl10_9 lad10_9 VSUBS 0.1f
Rl11_0 xs0n_n10 lad11_0 6.32
Cl11_0 lad11_0 VSUBS 0.1f
Rl11_1 lad11_0 lad11_1 18.5
Cl11_1 lad11_1 VSUBS 0.1f
Rl11_2 lad11_1 lad11_2 9.63
Cl11_2 lad11_2 VSUBS 0.1f
Rl11_3 lad11_2 lad11_3 19.7
Cl11_3 lad11_3 VSUBS 0.1f
Rl11_4 lad11_3 lad11_4 10.9
Cl11_4 lad11_4 VSUBS 0.1f
Rl11_5 lad11_4 lad11_5 11.3
Cl11_5 lad11_5 VSUBS 0.1f
Rl11_6 lad11_5 lad11_6 11.6
Cl11_6 lad11_6 VSUBS 0.1f
Rl11_7 lad11_6 lad11_7 5.18
Cl11_7 lad11_7 VSUBS 0.1f
Rl11_8 lad11_7 lad11_8 11.9
Cl11_8 lad11_8 VSUBS 0.1f
Rl11_9 lad11_8 lad11_9 4.04
Cl11_9 lad11_9 VSUBS 0.1f
Rl12_0 xs0p_n10 lad12_0 5.66
Cl12_0 lad12_0 VSUBS 0.1f
Rl12_1 lad12_0 lad12_1 3.95
Cl12_1 lad12_1 VSUBS 0.1f
Rl12_2 lad12_1 lad12_2 9.72
Cl12_2 lad12_2 VSUBS 0.1f
Rl12_3 lad12_2 lad12_3 15.3
Cl12_3 lad12_3 VSUBS 0.1f
Rl12_4 lad12_3 lad12_4 19.1
Cl12_4 lad12_4 VSUBS 0.1f
Rl12_5 lad12_4 lad12_5 12.1
Cl12_5 lad12_5 VSUBS 0.1f
Rl12_6 lad12_5 lad12_6 4.66
Cl12_6 lad12_6 VSUBS 0.1f
Rl12_7 lad12_6 lad12_7 3.64
Cl12_7 lad12_7 VSUBS 0.1f
Rl12_8 lad12_7 lad12_8 8.91
Cl12_8 lad12_8 VSUBS 0.1f
Rl12_9 lad12_8 lad12_9 13.1
Cl12_9 lad12_9 VSUBS 0.1f
Rl13_0 clk lad13_0 17.4
Cl13_0 lad13_0 VSUBS 0.1f
Rl13_1 lad13_0 lad13_1 16.5
Cl13_1 lad13_1 VSUBS 0.1f
Rl13_2 lad13_1 lad13_2 3.22
Cl13_2 lad13_2 VSUBS 0.1f
Rl13_3 lad13_2 lad13_3 2.21
Cl13_3 lad13_3 VSUBS 0.1f
Rl13_4 lad13_3 lad13_4 15.5
Cl13_4 lad13_4 VSUBS 0.1f
Rl13_5 lad13_4 lad13_5 9.48
Cl13_5 lad13_5 VSUBS 0.1f
Rl13_6 lad13_5 lad13_6 13.7
Cl13_6 lad13_6 VSUBS 0.1f
Rl13_7 lad13_6 lad13_7 18.1
Cl13_7 lad13_7 VSUBS 0.1f
Rl13_8 lad13_7 lad13_8 13.7
Cl13_8 lad13_8 VSUBS 0.1f
Rl13_9 lad13_8 lad13_9 4.65
Cl13_9 lad13_9 VSUBS 0.1f
Rl14_0 xc4_outnb lad14_0 19.5
Cl14_0 lad14_0 VSUBS 0.1f
Rl14_1 lad14_0 lad14_1 11.5
Cl14_1 lad14_1 VSUBS 0.1f
Rl14_2 lad14_1 lad14_2 4.3
Cl14_2 lad14_2 VSUBS 0.1f
Rl14_3 lad14_2 lad14_3 13.8
Cl14_3 lad14_3 VSUBS 0.1f
Rl14_4 lad14_3 lad14_4 3.1
Cl14_4 lad14_4 VSUBS 0.1f
Rl14_5 lad14_4 lad14_5 19.2
Cl14_5 lad14_5 VSUBS 0.1f
Rl14_6 lad14_5 lad14_6 13
Cl14_6 lad14_6 VSUBS 0.1f
Rl14_7 lad14_6 lad14_7 7.93
Cl14_7 lad14_7 VSUBS 0.1f
Rl14_8 lad14_7 lad14_8 1.56
Cl14_8 lad14_8 VSUBS 0.1f
Rl14_9 lad14_8 lad14_9 8.32
Cl14_9 lad14_9 VSUBS 0.1f
Rl15_0 xs0n_cbn lad15_0 16.1
Cl15_0 lad15_0 VSUBS 0.1f
Rl15_1 lad15_0 lad15_1 13
Cl15_1 lad15_1 VSUBS 0.1f
Rl15_2 lad15_1 lad15_2 1.9
Cl15_2 lad15_2 VSUBS 0.1f
Rl15_3 lad15_2 lad15_3 12.3
Cl15_3 lad15_3 VSUBS 0.1f
Rl15_4 lad15_3 lad15_4 2.25
Cl15_4 lad15_4 VSUBS 0.1f
Rl15_5 lad15_4 lad15_5 3.87
Cl15_5 lad15_5 VSUBS 0.1f
Rl15_6 lad15_5 lad15_6 6.86
Cl15_6 lad15_6 VSUBS 0.1f
Rl15_7 lad15_6 lad15_7 7.38
Cl15_7 lad15_7 VSUBS 0.1f
Rl15_8 lad15_7 lad15_8 7.09
Cl15_8 lad15_8 VSUBS 0.1f
Rl15_9 lad15_8 lad15_9 16.5
Cl15_9 lad15_9 VSUBS 0.1f
Rl16_0 bp1 lad16_0 8.41
Cl16_0 lad16_0 VSUBS 0.1f
Rl16_1 lad16_0 lad16_1 13.5
Cl16_1 lad16_1 VSUBS 0.1f
Rl16_2 lad16_1 lad16_2 6.23
Cl16_2 lad16_2 VSUBS 0.1f
Rl16_3 lad16_2 lad16_3 17.6
Cl16_3 lad16_3 VSUBS 0.1f
Rl16_4 lad16_3 lad16_4 3.74
Cl16_4 lad16_4 VSUBS 0.1f
Rl16_5 lad16_4 lad16_5 7.29
Cl16_5 lad16_5 VSUBS 0.1f
Rl16_6 lad16_5 lad16_6 4.23
Cl16_6 lad16_6 VSUBS 0.1f
Rl16_7 lad16_6 lad16_7 15.9
Cl16_7 lad16_7 VSUBS 0.1f
Rl16_8 lad16_7 lad16_8 3.82
Cl16_8 lad16_8 VSUBS 0.1f
Rl16_9 lad16_8 lad16_9 17.5
Cl16_9 lad16_9 VSUBS 0.1f
Rl17_0 cp6 lad17_0 15.9
Cl17_0 lad17_0 VSUBS 0.1f
Rl17_1 lad17_0 lad17_1 5.26
Cl17_1 lad17_1 VSUBS 0.1f
Rl17_2 lad17_1 lad17_2 12.5
Cl17_2 lad17_2 VSUBS 0.1f
Rl17_3 lad17_2 lad17_3 9.95
Cl17_3 lad17_3 VSUBS 0.1f
Rl17_4 lad17_3 lad17_4 10.4
Cl17_4 lad17_4 VSUBS 0.1f
Rl17_5 lad17_4 lad17_5 12.5
Cl17_5 lad17_5 VSUBS 0.1f
Rl17_6 lad17_5 lad17_6 11.5
Cl17_6 lad17_6 VSUBS 0.1f
Rl17_7 lad17_6 lad17_7 6.98
Cl17_7 lad17_7 VSUBS 0.1f
Rl17_8 lad17_7 lad17_8 7.36
Cl17_8 lad17_8 VSUBS 0.1f
Rl17_9 lad17_8 lad17_9 12.4
Cl17_9 lad17_9 VSUBS 0.1f
Rl18_0 lsb_n lad18_0 6.25
Cl18_0 lad18_0 VSUBS 0.1f
Rl18_1 lad18_0 lad18_1 6.18
Cl18_1 lad18_1 VSUBS 0.1f
Rl18_2 lad18_1 lad18_2 15
Cl18_2 lad18_2 VSUBS 0.1f
Rl18_3 lad18_2 lad18_3 19.2
Cl18_3 lad18_3 VSUBS 0.1f
Rl18_4 lad18_3 lad18_4 4.8
Cl18_4 lad18_4 VSUBS 0.1f
Rl18_5 lad18_4 lad18_5 11.7
Cl18_5 lad18_5 VSUBS 0.1f
Rl18_6 lad18_5 lad18_6 7.13
Cl18_6 lad18_6 VSUBS 0.1f
Rl18_7 lad18_6 lad18_7 14.9
Cl18_7 lad18_7 VSUBS 0.1f
Rl18_8 lad18_7 lad18_8 4.74
Cl18_8 lad18_8 VSUBS 0.1f
Rl18_9 lad18_8 lad18_9 18.5
Cl18_9 lad18_9 VSUBS 0.1f
Rl19_0 xc5_lt lad19_0 17.8
Cl19_0 lad19_0 VSUBS 0.1f
Rl19_1 lad19_0 lad19_1 9.85
Cl19_1 lad19_1 VSUBS 0.1f
Rl19_2 lad19_1 lad19_2 8.96
Cl19_2 lad19_2 VSUBS 0.1f
Rl19_3 lad19_2 lad19_3 19.6
Cl19_3 lad19_3 VSUBS 0.1f
Rl19_4 lad19_3 lad19_4 18.1
Cl19_4 lad19_4 VSUBS 0.1f
Rl19_5 lad19_4 lad19_5 17.4
Cl19_5 lad19_5 VSUBS 0.1f
Rl19_6 lad19_5 lad19_6 9.7
Cl19_6 lad19_6 VSUBS 0.1f
Rl19_7 lad19_6 lad19_7 6.82
Cl19_7 lad19_7 VSUBS 0.1f
Rl19_8 lad19_7 lad19_8 11.9
Cl19_8 lad19_8 VSUBS 0.1f
Rl19_9 lad19_8 lad19_9 4.39
Cl19_9 lad19_9 VSUBS 0.1f
Rl20_0 bn7 lad20_0 6.87
Cl20_0 lad20_0 VSUBS 0.1f
Rl20_1 lad20_0 lad20_1 1.95
Cl20_1 lad20_1 VSUBS 0.1f
Rl20_2 lad20_1 lad20_2 4.05
Cl20_2 lad20_2 VSUBS 0.1f
Rl20_3 lad20_2 lad20_3 12.3
Cl20_3 lad20_3 VSUBS 0.1f
Rl20_4 lad20_3 lad20_4 12.3
Cl20_4 lad20_4 VSUBS 0.1f
Rl20_5 lad20_4 lad20_5 4.74
Cl20_5 lad20_5 VSUBS 0.1f
Rl20_6 lad20_5 lad20_6 14
Cl20_6 lad20_6 VSUBS 0.1f
Rl20_7 lad20_6 lad20_7 16.7
Cl20_7 lad20_7 VSUBS 0.1f
Rl20_8 lad20_7 lad20_8 6.53
Cl20_8 lad20_8 VSUBS 0.1f
Rl20_9 lad20_8 lad20_9 5.8
Cl20_9 lad20_9 VSUBS 0.1f
Rl21_0 xs0n_cbn lad21_0 2.96
Cl21_0 lad21_0 VSUBS 0.1f
Rl21_1 lad21_0 lad21_1 13.6
Cl21_1 lad21_1 VSUBS 0.1f
Rl21_2 lad21_1 lad21_2 12.5
Cl21_2 lad21_2 VSUBS 0.1f
Rl21_3 lad21_2 lad21_3 3.85
Cl21_3 lad21_3 VSUBS 0.1f
Rl21_4 lad21_3 lad21_4 13.8
Cl21_4 lad21_4 VSUBS 0.1f
Rl21_5 lad21_4 lad21_5 17.1
Cl21_5 lad21_5 VSUBS 0.1f
Rl21_6 lad21_5 lad21_6 18.7
Cl21_6 lad21_6 VSUBS 0.1f
Rl21_7 lad21_6 lad21_7 18.2
Cl21_7 lad21_7 VSUBS 0.1f
Rl21_8 lad21_7 lad21_8 20
Cl21_8 lad21_8 VSUBS 0.1f
Rl21_9 lad21_8 lad21_9 2.14
Cl21_9 lad21_9 VSUBS 0.1f
Rl22_0 cn3 lad22_0 8.94
Cl22_0 lad22_0 VSUBS 0.1f
Rl22_1 lad22_0 lad22_1 2.3
Cl22_1 lad22_1 VSUBS 0.1f
Rl22_2 lad22_1 lad22_2 5.73
Cl22_2 lad22_2 VSUBS 0.1f
Rl22_3 lad22_2 lad22_3 7.01
Cl22_3 lad22_3 VSUBS 0.1f
Rl22_4 lad22_3 lad22_4 12.5
Cl22_4 lad22_4 VSUBS 0.1f
Rl22_5 lad22_4 lad22_5 14.6
Cl22_5 lad22_5 VSUBS 0.1f
Rl22_6 lad22_5 lad22_6 18
Cl22_6 lad22_6 VSUBS 0.1f
Rl22_7 lad22_6 lad22_7 10.8
Cl22_7 lad22_7 VSUBS 0.1f
Rl22_8 lad22_7 lad22_8 5.46
Cl22_8 lad22_8 VSUBS 0.1f
Rl22_9 lad22_8 lad22_9 9.8
Cl22_9 lad22_9 VSUBS 0.1f
Rl23_0 lsb_n lad23_0 5.69
Cl23_0 lad23_0 VSUBS 0.1f
Rl23_1 lad23_0 lad23_1 11.3
Cl23_1 lad23_1 VSUBS 0.1f
Rl23_2 lad23_1 lad23_2 6.86
Cl23_2 lad23_2 VSUBS 0.1f
Rl23_3 lad23_2 lad23_3 4.11
Cl23_3 lad23_3 VSUBS 0.1f
Rl23_4 lad23_3 lad23_4 10.2
Cl23_4 lad23_4 VSUBS 0.1f
Rl23_5 lad23_4 lad23_5 10
Cl23_5 lad23_5 VSUBS 0.1f
Rl23_6 lad23_5 lad23_6 16.6
Cl23_6 lad23_6 VSUBS 0.1f
Rl23_7 lad23_6 lad23_7 12.1
Cl23_7 lad23_7 VSUBS 0.1f
Rl23_8 lad23_7 lad23_8 3.1
Cl23_8 lad23_8 VSUBS 0.1f
Rl23_9 lad23_8 lad23_9 10.7
Cl23_9 lad23_9 VSUBS 0.1f
Rl24_0 t0b lad24_0 15.5
Cl24_0 lad24_0 VSUBS 0.1f
Rl24_1 lad24_0 lad24_1 11.9
Cl24_1 lad24_1 VSUBS 0.1f
Rl24_2 lad24_1 lad24_2 13.2
Cl24_2 lad24_2 VSUBS 0.1f
Rl24_3 lad24_2 lad24_3 10.1
Cl24_3 lad24_3 VSUBS 0.1f
Rl24_4 lad24_3 lad24_4 15.5
Cl24_4 lad24_4 VSUBS 0.1f
Rl24_5 lad24_4 lad24_5 17.9
Cl24_5 lad24_5 VSUBS 0.1f
Rl24_6 lad24_5 lad24_6 19.8
Cl24_6 lad24_6 VSUBS 0.1f
Rl24_7 lad24_6 lad24_7 7.38
Cl24_7 lad24_7 VSUBS 0.1f
Rl24_8 lad24_7 lad24_8 12.6
Cl24_8 lad24_8 VSUBS 0.1f
Rl24_9 lad24_8 lad24_9 7.71
Cl24_9 lad24_9 VSUBS 0.1f
Rl25_0 cp12 lad25_0 10.6
Cl25_0 lad25_0 VSUBS 0.1f
Rl25_1 lad25_0 lad25_1 16.1
Cl25_1 lad25_1 VSUBS 0.1f
Rl25_2 lad25_1 lad25_2 19.7
Cl25_2 lad25_2 VSUBS 0.1f
Rl25_3 lad25_2 lad25_3 17.7
Cl25_3 lad25_3 VSUBS 0.1f
Rl25_4 lad25_3 lad25_4 10.7
Cl25_4 lad25_4 VSUBS 0.1f
Rl25_5 lad25_4 lad25_5 14.7
Cl25_5 lad25_5 VSUBS 0.1f
Rl25_6 lad25_5 lad25_6 4.52
Cl25_6 lad25_6 VSUBS 0.1f
Rl25_7 lad25_6 lad25_7 15.8
Cl25_7 lad25_7 VSUBS 0.1f
Rl25_8 lad25_7 lad25_8 11.1
Cl25_8 lad25_8 VSUBS 0.1f
Rl25_9 lad25_8 lad25_9 19.9
Cl25_9 lad25_9 VSUBS 0.1f
Rl26_0 xc4_xs1_tail0 lad26_0 11.4
Cl26_0 lad26_0 VSUBS 0.1f
Rl26_1 lad26_0 lad26_1 4.37
Cl26_1 lad26_1 VSUBS 0.1f
Rl26_2 lad26_1 lad26_2 18.6
Cl26_2 lad26_2 VSUBS 0.1f
Rl26_3 lad26_2 lad26_3 17.1
Cl26_3 lad26_3 VSUBS 0.1f
Rl26_4 lad26_3 lad26_4 11.5
Cl26_4 lad26_4 VSUBS 0.1f
Rl26_5 lad26_4 lad26_5 17.6
Cl26_5 lad26_5 VSUBS 0.1f
Rl26_6 lad26_5 lad26_6 11.9
Cl26_6 lad26_6 VSUBS 0.1f
Rl26_7 lad26_6 lad26_7 11.2
Cl26_7 lad26_7 VSUBS 0.1f
Rl26_8 lad26_7 lad26_8 16
Cl26_8 lad26_8 VSUBS 0.1f
Rl26_9 lad26_8 lad26_9 11.2
Cl26_9 lad26_9 VSUBS 0.1f
Rl27_0 xc5_xs1_tail lad27_0 16.4
Cl27_0 lad27_0 VSUBS 0.1f
Rl27_1 lad27_0 lad27_1 12.1
Cl27_1 lad27_1 VSUBS 0.1f
Rl27_2 lad27_1 lad27_2 1.85
Cl27_2 lad27_2 VSUBS 0.1f
Rl27_3 lad27_2 lad27_3 5.92
Cl27_3 lad27_3 VSUBS 0.1f
Rl27_4 lad27_3 lad27_4 13.9
Cl27_4 lad27_4 VSUBS 0.1f
Rl27_5 lad27_4 lad27_5 15.5
Cl27_5 lad27_5 VSUBS 0.1f
Rl27_6 lad27_5 lad27_6 1.25
Cl27_6 lad27_6 VSUBS 0.1f
Rl27_7 lad27_6 lad27_7 11.7
Cl27_7 lad27_7 VSUBS 0.1f
Rl27_8 lad27_7 lad27_8 8.39
Cl27_8 lad27_8 VSUBS 0.1f
Rl27_9 lad27_8 lad27_9 2.21
Cl27_9 lad27_9 VSUBS 0.1f
Rl28_0 t0 lad28_0 7.27
Cl28_0 lad28_0 VSUBS 0.1f
Rl28_1 lad28_0 lad28_1 17.7
Cl28_1 lad28_1 VSUBS 0.1f
Rl28_2 lad28_1 lad28_2 5.68
Cl28_2 lad28_2 VSUBS 0.1f
Rl28_3 lad28_2 lad28_3 6.85
Cl28_3 lad28_3 VSUBS 0.1f
Rl28_4 lad28_3 lad28_4 16.6
Cl28_4 lad28_4 VSUBS 0.1f
Rl28_5 lad28_4 lad28_5 17.4
Cl28_5 lad28_5 VSUBS 0.1f
Rl28_6 lad28_5 lad28_6 1.17
Cl28_6 lad28_6 VSUBS 0.1f
Rl28_7 lad28_6 lad28_7 16.3
Cl28_7 lad28_7 VSUBS 0.1f
Rl28_8 lad28_7 lad28_8 5.31
Cl28_8 lad28_8 VSUBS 0.1f
Rl28_9 lad28_8 lad28_9 17.5
Cl28_9 lad28_9 VSUBS 0.1f
Rl29_0 xc4_xs1_tail0 lad29_0 18.5
Cl29_0 lad29_0 VSUBS 0.1f
Rl29_1 lad29_0 lad29_1 13
Cl29_1 lad29_1 VSUBS 0.1f
Rl29_2 lad29_1 lad29_2 12.6
Cl29_2 lad29_2 VSUBS 0.1f
Rl29_3 lad29_2 lad29_3 1.39
Cl29_3 lad29_3 VSUBS 0.1f
Rl29_4 lad29_3 lad29_4 17.2
Cl29_4 lad29_4 VSUBS 0.1f
Rl29_5 lad29_4 lad29_5 8.72
Cl29_5 lad29_5 VSUBS 0.1f
Rl29_6 lad29_5 lad29_6 19.9
Cl29_6 lad29_6 VSUBS 0.1f
Rl29_7 lad29_6 lad29_7 16.1
Cl29_7 lad29_7 VSUBS 0.1f
Rl29_8 lad29_7 lad29_8 18.7
Cl29_8 lad29_8 VSUBS 0.1f
Rl29_9 lad29_8 lad29_9 4.08
Cl29_9 lad29_9 VSUBS 0.1f
Rl30_0 bp12 lad30_0 17.1
Cl30_0 lad30_0 VSUBS 0.1f
Rl30_1 lad30_0 lad30_1 10.2
Cl30_1 lad30_1 VSUBS 0.1f
Rl30_2 lad30_1 lad30_2 3.34
Cl30_2 lad30_2 VSUBS 0.1f
Rl30_3 lad30_2 lad30_3 12.1
Cl30_3 lad30_3 VSUBS 0.1f
Rl30_4 lad30_3 lad30_4 13.2
Cl30_4 lad30_4 VSUBS 0.1f
Rl30_5 lad30_4 lad30_5 6.65
Cl30_5 lad30_5 VSUBS 0.1f
Rl30_6 lad30_5 lad30_6 3.26
Cl30_6 lad30_6 VSUBS 0.1f
Rl30_7 lad30_6 lad30_7 18.8
Cl30_7 lad30_7 VSUBS 0.1f
Rl30_8 lad30_7 lad30_8 13
Cl30_8 lad30_8 VSUBS 0.1f
Rl30_9 lad30_8 lad30_9 8.94
Cl30_9 lad30_9 VSUBS 0.1f
Rl31_0 in1p lad31_0 9.06
Cl31_0 lad31_0 VSUBS 0.1f
Rl31_1 lad31_0 lad31_1 19.7
Cl31_1 lad31_1 VSUBS 0.1f
Rl31_2 lad31_1 lad31_2 9.72
Cl31_2 lad31_2 VSUBS 0.1f
Rl31_3 lad31_2 lad31_3 14
Cl31_3 lad31_3 VSUBS 0.1f
Rl31_4 lad31_3 lad31_4 17.6
Cl31_4 lad31_4 VSUBS 0.1f
Rl31_5 lad31_4 lad31_5 12.1
Cl31_5 lad31_5 VSUBS 0.1f
Rl31_6 lad31_5 lad31_6 11
Cl31_6 lad31_6 VSUBS 0.1f
Rl31_7 lad31_6 lad31_7 7.37
Cl31_7 lad31_7 VSUBS 0.1f
Rl31_8 lad31_7 lad31_8 15.9
Cl31_8 lad31_8 VSUBS 0.1f
Rl31_9 lad31_8 lad31_9 8.6
Cl31_9 lad31_9 VSUBS 0.1f
Rl32_0 xc5_lt lad32_0 9.72
Cl32_0 lad32_0 VSUBS 0.1f
Rl32_1 lad32_0 lad32_1 6.37
Cl32_1 lad32_1 VSUBS 0.1f
Rl32_2 lad32_1 lad32_2 2.09
Cl32_2 lad32_2 VSUBS 0.1f
Rl32_3 lad32_2 lad32_3 11.2
Cl32_3 lad32_3 VSUBS 0.1f
Rl32_4 lad32_3 lad32_4 10.2
Cl32_4 lad32_4 VSUBS 0.1f
Rl32_5 lad32_4 lad32_5 7.17
Cl32_5 lad32_5 VSUBS 0.1f
Rl32_6 lad32_5 lad32_6 6.13
Cl32_6 lad32_6 VSUBS 0.1f
Rl32_7 lad32_6 lad32_7 16.1
Cl32_7 lad32_7 VSUBS 0.1f
Rl32_8 lad32_7 lad32_8 19.4
Cl32_8 lad32_8 VSUBS 0.1f
Rl32_9 lad32_8 lad32_9 17.3
Cl32_9 lad32_9 VSUBS 0.1f
Rl33_0 xs1p_g lad33_0 2.31
Cl33_0 lad33_0 VSUBS 0.1f
Rl33_1 lad33_0 lad33_1 11.3
Cl33_1 lad33_1 VSUBS 0.1f
Rl33_2 lad33_1 lad33_2 19.9
Cl33_2 lad33_2 VSUBS 0.1f
Rl33_3 lad33_2 lad33_3 2.68
Cl33_3 lad33_3 VSUBS 0.1f
Rl33_4 lad33_3 lad33_4 11.2
Cl33_4 lad33_4 VSUBS 0.1f
Rl33_5 lad33_4 lad33_5 11
Cl33_5 lad33_5 VSUBS 0.1f
Rl33_6 lad33_5 lad33_6 2.58
Cl33_6 lad33_6 VSUBS 0.1f
Rl33_7 lad33_6 lad33_7 1.6
Cl33_7 lad33_7 VSUBS 0.1f
Rl33_8 lad33_7 lad33_8 5.74
Cl33_8 lad33_8 VSUBS 0.1f
Rl33_9 lad33_8 lad33_9 6.25
Cl33_9 lad33_9 VSUBS 0.1f
Rl34_0 xs0p_n10 lad34_0 16
Cl34_0 lad34_0 VSUBS 0.1f
Rl34_1 lad34_0 lad34_1 2.84
Cl34_1 lad34_1 VSUBS 0.1f
Rl34_2 lad34_1 lad34_2 10.4
Cl34_2 lad34_2 VSUBS 0.1f
Rl34_3 lad34_2 lad34_3 13.7
Cl34_3 lad34_3 VSUBS 0.1f
Rl34_4 lad34_3 lad34_4 4.09
Cl34_4 lad34_4 VSUBS 0.1f
Rl34_5 lad34_4 lad34_5 5.12
Cl34_5 lad34_5 VSUBS 0.1f
Rl34_6 lad34_5 lad34_6 15.2
Cl34_6 lad34_6 VSUBS 0.1f
Rl34_7 lad34_6 lad34_7 5.41
Cl34_7 lad34_7 VSUBS 0.1f
Rl34_8 lad34_7 lad34_8 1.28
Cl34_8 lad34_8 VSUBS 0.1f
Rl34_9 lad34_8 lad34_9 4.27
Cl34_9 lad34_9 VSUBS 0.1f
Rl35_0 cn12 lad35_0 14.3
Cl35_0 lad35_0 VSUBS 0.1f
Rl35_1 lad35_0 lad35_1 6.27
Cl35_1 lad35_1 VSUBS 0.1f
Rl35_2 lad35_1 lad35_2 16.2
Cl35_2 lad35_2 VSUBS 0.1f
Rl35_3 lad35_2 lad35_3 5.72
Cl35_3 lad35_3 VSUBS 0.1f
Rl35_4 lad35_3 lad35_4 2.77
Cl35_4 lad35_4 VSUBS 0.1f
Rl35_5 lad35_4 lad35_5 15.9
Cl35_5 lad35_5 VSUBS 0.1f
Rl35_6 lad35_5 lad35_6 4.23
Cl35_6 lad35_6 VSUBS 0.1f
Rl35_7 lad35_6 lad35_7 5
Cl35_7 lad35_7 VSUBS 0.1f
Rl35_8 lad35_7 lad35_8 16.3
Cl35_8 lad35_8 VSUBS 0.1f
Rl35_9 lad35_8 lad35_9 14
Cl35_9 lad35_9 VSUBS 0.1f
Rl36_0 cn6 lad36_0 8.59
Cl36_0 lad36_0 VSUBS 0.1f
Rl36_1 lad36_0 lad36_1 6.52
Cl36_1 lad36_1 VSUBS 0.1f
Rl36_2 lad36_1 lad36_2 6.41
Cl36_2 lad36_2 VSUBS 0.1f
Rl36_3 lad36_2 lad36_3 15.1
Cl36_3 lad36_3 VSUBS 0.1f
Rl36_4 lad36_3 lad36_4 1.63
Cl36_4 lad36_4 VSUBS 0.1f
Rl36_5 lad36_4 lad36_5 13
Cl36_5 lad36_5 VSUBS 0.1f
Rl36_6 lad36_5 lad36_6 9.49
Cl36_6 lad36_6 VSUBS 0.1f
Rl36_7 lad36_6 lad36_7 10.9
Cl36_7 lad36_7 VSUBS 0.1f
Rl36_8 lad36_7 lad36_8 1.45
Cl36_8 lad36_8 VSUBS 0.1f
Rl36_9 lad36_8 lad36_9 13.3
Cl36_9 lad36_9 VSUBS 0.1f
Rl37_0 cp12 lad37_0 8.58
Cl37_0 lad37_0 VSUBS 0.1f
Rl37_1 lad37_0 lad37_1 17.4
Cl37_1 lad37_1 VSUBS 0.1f
Rl37_2 lad37_1 lad37_2 17.5
Cl37_2 lad37_2 VSUBS 0.1f
Rl37_3 lad37_2 lad37_3 19.9
Cl37_3 lad37_3 VSUBS 0.1f
Rl37_4 lad37_3 lad37_4 19.3
Cl37_4 lad37_4 VSUBS 0.1f
Rl37_5 lad37_4 lad37_5 13.7
Cl37_5 lad37_5 VSUBS 0.1f
Rl37_6 lad37_5 lad37_6 14.5
Cl37_6 lad37_6 VSUBS 0.1f
Rl37_7 lad37_6 lad37_7 7.96
Cl37_7 lad37_7 VSUBS 0.1f
Rl37_8 lad37_7 lad37_8 9.31
Cl37_8 lad37_8 VSUBS 0.1f
Rl37_9 lad37_8 lad37_9 2.22
Cl37_9 lad37_9 VSUBS 0.1f
Rl38_0 xs1p_g lad38_0 15.2
Cl38_0 lad38_0 VSUBS 0.1f
Rl38_1 lad38_0 lad38_1 19.8
Cl38_1 lad38_1 VSUBS 0.1f
Rl38_2 lad38_1 lad38_2 1.54
Cl38_2 lad38_2 VSUBS 0.1f
Rl38_3 lad38_2 lad38_3 15.8
Cl38_3 lad38_3 VSUBS 0.1f
Rl38_4 lad38_3 lad38_4 4.77
Cl38_4 lad38_4 VSUBS 0.1f
Rl38_5 lad38_4 lad38_5 19.9
Cl38_5 lad38_5 VSUBS 0.1f
Rl38_6 lad38_5 lad38_6 4.2
Cl38_6 lad38_6 VSUBS 0.1f
Rl38_7 lad38_6 lad38_7 6.46
Cl38_7 lad38_7 VSUBS 0.1f
Rl38_8 lad38_7 lad38_8 7.27
Cl38_8 lad38_8 VSUBS 0.1f
Rl38_9 lad38_8 lad38_9 4.56
Cl38_9 lad38_9 VSUBS 0.1f
Rl39_0 cp11 lad39_0 1.88
Cl39_0 lad39_0 VSUBS 0.1f
Rl39_1 lad39_0 lad39_1 13
Cl39_1 lad39_1 VSUBS 0.1f
Rl39_2 lad39_1 lad39_2 14.3
Cl39_2 lad39_2 VSUBS 0.1f
Rl39_3 lad39_2 lad39_3 8.76
Cl39_3 lad39_3 VSUBS 0.1f
Rl39_4 lad39_3 lad39_4 1.29
Cl39_4 lad39_4 VSUBS 0.1f
Rl39_5 lad39_4 lad39_5 15.5
Cl39_5 lad39_5 VSUBS 0.1f
Rl39_6 lad39_5 lad39_6 5.82
Cl39_6 lad39_6 VSUBS 0.1f
Rl39_7 lad39_6 lad39_7 3.72
Cl39_7 lad39_7 VSUBS 0.1f
Rl39_8 lad39_7 lad39_8 6.05
Cl39_8 lad39_8 VSUBS 0.1f
Rl39_9 lad39_8 lad39_9 15.7
Cl39_9 lad39_9 VSUBS 0.1f
Rl40_0 bn11 lad40_0 19.5
Cl40_0 lad40_0 VSUBS 0.1f
Rl40_1 lad40_0 lad40_1 16.3
Cl40_1 lad40_1 VSUBS 0.1f
Rl40_2 lad40_1 lad40_2 2.16
Cl40_2 lad40_2 VSUBS 0.1f
Rl40_3 lad40_2 lad40_3 14.6
Cl40_3 lad40_3 VSUBS 0.1f
Rl40_4 lad40_3 lad40_4 10.4
Cl40_4 lad40_4 VSUBS 0.1f
Rl40_5 lad40_4 lad40_5 9.08
Cl40_5 lad40_5 VSUBS 0.1f
Rl40_6 lad40_5 lad40_6 19.4
Cl40_6 lad40_6 VSUBS 0.1f
Rl40_7 lad40_6 lad40_7 18.7
Cl40_7 lad40_7 VSUBS 0.1f
Rl40_8 lad40_7 lad40_8 3.76
Cl40_8 lad40_8 VSUBS 0.1f
Rl40_9 lad40_8 lad40_9 8.08
Cl40_9 lad40_9 VSUBS 0.1f
Rl41_0 bp7 lad41_0 16.3
Cl41_0 lad41_0 VSUBS 0.1f
Rl41_1 lad41_0 lad41_1 19.9
Cl41_1 lad41_1 VSUBS 0.1f
Rl41_2 lad41_1 lad41_2 13.4
Cl41_2 lad41_2 VSUBS 0.1f
Rl41_3 lad41_2 lad41_3 16.6
Cl41_3 lad41_3 VSUBS 0.1f
Rl41_4 lad41_3 lad41_4 11.3
Cl41_4 lad41_4 VSUBS 0.1f
Rl41_5 lad41_4 lad41_5 1.02
Cl41_5 lad41_5 VSUBS 0.1f
Rl41_6 lad41_5 lad41_6 2.35
Cl41_6 lad41_6 VSUBS 0.1f
Rl41_7 lad41_6 lad41_7 3.28
Cl41_7 lad41_7 VSUBS 0.1f
Rl41_8 lad41_7 lad41_8 18.5
Cl41_8 lad41_8 VSUBS 0.1f
Rl41_9 lad41_8 lad41_9 1.27
Cl41_9 lad41_9 VSUBS 0.1f
Rl42_0 xc4_xs1_tail0 lad42_0 7.74
Cl42_0 lad42_0 VSUBS 0.1f
Rl42_1 lad42_0 lad42_1 9.98
Cl42_1 lad42_1 VSUBS 0.1f
Rl42_2 lad42_1 lad42_2 2.98
Cl42_2 lad42_2 VSUBS 0.1f
Rl42_3 lad42_2 lad42_3 4.71
Cl42_3 lad42_3 VSUBS 0.1f
Rl42_4 lad42_3 lad42_4 13.1
Cl42_4 lad42_4 VSUBS 0.1f
Rl42_5 lad42_4 lad42_5 4.03
Cl42_5 lad42_5 VSUBS 0.1f
Rl42_6 lad42_5 lad42_6 18.3
Cl42_6 lad42_6 VSUBS 0.1f
Rl42_7 lad42_6 lad42_7 7.62
Cl42_7 lad42_7 VSUBS 0.1f
Rl42_8 lad42_7 lad42_8 19.3
Cl42_8 lad42_8 VSUBS 0.1f
Rl42_9 lad42_8 lad42_9 3.76
Cl42_9 lad42_9 VSUBS 0.1f
Rl43_0 xc5_xs1_tail lad43_0 12.2
Cl43_0 lad43_0 VSUBS 0.1f
Rl43_1 lad43_0 lad43_1 13.7
Cl43_1 lad43_1 VSUBS 0.1f
Rl43_2 lad43_1 lad43_2 7
Cl43_2 lad43_2 VSUBS 0.1f
Rl43_3 lad43_2 lad43_3 1.67
Cl43_3 lad43_3 VSUBS 0.1f
Rl43_4 lad43_3 lad43_4 14.7
Cl43_4 lad43_4 VSUBS 0.1f
Rl43_5 lad43_4 lad43_5 2.36
Cl43_5 lad43_5 VSUBS 0.1f
Rl43_6 lad43_5 lad43_6 13.7
Cl43_6 lad43_6 VSUBS 0.1f
Rl43_7 lad43_6 lad43_7 19.1
Cl43_7 lad43_7 VSUBS 0.1f
Rl43_8 lad43_7 lad43_8 8.89
Cl43_8 lad43_8 VSUBS 0.1f
Rl43_9 lad43_8 lad43_9 19.3
Cl43_9 lad43_9 VSUBS 0.1f
Rl44_0 trk0 lad44_0 6.35
Cl44_0 lad44_0 VSUBS 0.1f
Rl44_1 lad44_0 lad44_1 8.58
Cl44_1 lad44_1 VSUBS 0.1f
Rl44_2 lad44_1 lad44_2 9.89
Cl44_2 lad44_2 VSUBS 0.1f
Rl44_3 lad44_2 lad44_3 12.7
Cl44_3 lad44_3 VSUBS 0.1f
Rl44_4 lad44_3 lad44_4 12.4
Cl44_4 lad44_4 VSUBS 0.1f
Rl44_5 lad44_4 lad44_5 3.39
Cl44_5 lad44_5 VSUBS 0.1f
Rl44_6 lad44_5 lad44_6 11
Cl44_6 lad44_6 VSUBS 0.1f
Rl44_7 lad44_6 lad44_7 19.8
Cl44_7 lad44_7 VSUBS 0.1f
Rl44_8 lad44_7 lad44_8 4.36
Cl44_8 lad44_8 VSUBS 0.1f
Rl44_9 lad44_8 lad44_9 11.1
Cl44_9 lad44_9 VSUBS 0.1f
Rl45_0 bn1 lad45_0 1.43
Cl45_0 lad45_0 VSUBS 0.1f
Rl45_1 lad45_0 lad45_1 19.1
Cl45_1 lad45_1 VSUBS 0.1f
Rl45_2 lad45_1 lad45_2 9.9
Cl45_2 lad45_2 VSUBS 0.1f
Rl45_3 lad45_2 lad45_3 5.75
Cl45_3 lad45_3 VSUBS 0.1f
Rl45_4 lad45_3 lad45_4 11.7
Cl45_4 lad45_4 VSUBS 0.1f
Rl45_5 lad45_4 lad45_5 8.15
Cl45_5 lad45_5 VSUBS 0.1f
Rl45_6 lad45_5 lad45_6 15.6
Cl45_6 lad45_6 VSUBS 0.1f
Rl45_7 lad45_6 lad45_7 7.33
Cl45_7 lad45_7 VSUBS 0.1f
Rl45_8 lad45_7 lad45_8 16.3
Cl45_8 lad45_8 VSUBS 0.1f
Rl45_9 lad45_8 lad45_9 4.9
Cl45_9 lad45_9 VSUBS 0.1f
Rl46_0 t0b lad46_0 10.7
Cl46_0 lad46_0 VSUBS 0.1f
Rl46_1 lad46_0 lad46_1 20
Cl46_1 lad46_1 VSUBS 0.1f
Rl46_2 lad46_1 lad46_2 16.7
Cl46_2 lad46_2 VSUBS 0.1f
Rl46_3 lad46_2 lad46_3 13.4
Cl46_3 lad46_3 VSUBS 0.1f
Rl46_4 lad46_3 lad46_4 19.7
Cl46_4 lad46_4 VSUBS 0.1f
Rl46_5 lad46_4 lad46_5 1.85
Cl46_5 lad46_5 VSUBS 0.1f
Rl46_6 lad46_5 lad46_6 8.62
Cl46_6 lad46_6 VSUBS 0.1f
Rl46_7 lad46_6 lad46_7 5.65
Cl46_7 lad46_7 VSUBS 0.1f
Rl46_8 lad46_7 lad46_8 11.7
Cl46_8 lad46_8 VSUBS 0.1f
Rl46_9 lad46_8 lad46_9 10.3
Cl46_9 lad46_9 VSUBS 0.1f
Rl47_0 cn11 lad47_0 3.02
Cl47_0 lad47_0 VSUBS 0.1f
Rl47_1 lad47_0 lad47_1 15.6
Cl47_1 lad47_1 VSUBS 0.1f
Rl47_2 lad47_1 lad47_2 16
Cl47_2 lad47_2 VSUBS 0.1f
Rl47_3 lad47_2 lad47_3 19.1
Cl47_3 lad47_3 VSUBS 0.1f
Rl47_4 lad47_3 lad47_4 16.4
Cl47_4 lad47_4 VSUBS 0.1f
Rl47_5 lad47_4 lad47_5 8.51
Cl47_5 lad47_5 VSUBS 0.1f
Rl47_6 lad47_5 lad47_6 9.44
Cl47_6 lad47_6 VSUBS 0.1f
Rl47_7 lad47_6 lad47_7 18.3
Cl47_7 lad47_7 VSUBS 0.1f
Rl47_8 lad47_7 lad47_8 12.2
Cl47_8 lad47_8 VSUBS 0.1f
Rl47_9 lad47_8 lad47_9 11.8
Cl47_9 lad47_9 VSUBS 0.1f
Rl48_0 bn10 lad48_0 14.6
Cl48_0 lad48_0 VSUBS 0.1f
Rl48_1 lad48_0 lad48_1 7.43
Cl48_1 lad48_1 VSUBS 0.1f
Rl48_2 lad48_1 lad48_2 9.24
Cl48_2 lad48_2 VSUBS 0.1f
Rl48_3 lad48_2 lad48_3 3.22
Cl48_3 lad48_3 VSUBS 0.1f
Rl48_4 lad48_3 lad48_4 11.5
Cl48_4 lad48_4 VSUBS 0.1f
Rl48_5 lad48_4 lad48_5 10.6
Cl48_5 lad48_5 VSUBS 0.1f
Rl48_6 lad48_5 lad48_6 12.1
Cl48_6 lad48_6 VSUBS 0.1f
Rl48_7 lad48_6 lad48_7 18
Cl48_7 lad48_7 VSUBS 0.1f
Rl48_8 lad48_7 lad48_8 15.3
Cl48_8 lad48_8 VSUBS 0.1f
Rl48_9 lad48_8 lad48_9 5.82
Cl48_9 lad48_9 VSUBS 0.1f
Rl49_0 bp1 lad49_0 1.34
Cl49_0 lad49_0 VSUBS 0.1f
Rl49_1 lad49_0 lad49_1 4.04
Cl49_1 lad49_1 VSUBS 0.1f
Rl49_2 lad49_1 lad49_2 19.7
Cl49_2 lad49_2 VSUBS 0.1f
Rl49_3 lad49_2 lad49_3 10.2
Cl49_3 lad49_3 VSUBS 0.1f
Rl49_4 lad49_3 lad49_4 6.22
Cl49_4 lad49_4 VSUBS 0.1f
Rl49_5 lad49_4 lad49_5 19
Cl49_5 lad49_5 VSUBS 0.1f
Rl49_6 lad49_5 lad49_6 6.08
Cl49_6 lad49_6 VSUBS 0.1f
Rl49_7 lad49_6 lad49_7 15.2
Cl49_7 lad49_7 VSUBS 0.1f
Rl49_8 lad49_7 lad49_8 15.6
Cl49_8 lad49_8 VSUBS 0.1f
Rl49_9 lad49_8 lad49_9 7.13
Cl49_9 lad49_9 VSUBS 0.1f
Rl50_0 xs0n_cbp lad50_0 8.76
Cl50_0 lad50_0 VSUBS 0.1f
Rl50_1 lad50_0 lad50_1 19.8
Cl50_1 lad50_1 VSUBS 0.1f
Rl50_2 lad50_1 lad50_2 4.09
Cl50_2 lad50_2 VSUBS 0.1f
Rl50_3 lad50_2 lad50_3 15.3
Cl50_3 lad50_3 VSUBS 0.1f
Rl50_4 lad50_3 lad50_4 1.2
Cl50_4 lad50_4 VSUBS 0.1f
Rl50_5 lad50_4 lad50_5 18.6
Cl50_5 lad50_5 VSUBS 0.1f
Rl50_6 lad50_5 lad50_6 1.43
Cl50_6 lad50_6 VSUBS 0.1f
Rl50_7 lad50_6 lad50_7 11.9
Cl50_7 lad50_7 VSUBS 0.1f
Rl50_8 lad50_7 lad50_8 1.53
Cl50_8 lad50_8 VSUBS 0.1f
Rl50_9 lad50_8 lad50_9 14.5
Cl50_9 lad50_9 VSUBS 0.1f
Rl51_0 cn7 lad51_0 2.53
Cl51_0 lad51_0 VSUBS 0.1f
Rl51_1 lad51_0 lad51_1 12.5
Cl51_1 lad51_1 VSUBS 0.1f
Rl51_2 lad51_1 lad51_2 6.41
Cl51_2 lad51_2 VSUBS 0.1f
Rl51_3 lad51_2 lad51_3 11.8
Cl51_3 lad51_3 VSUBS 0.1f
Rl51_4 lad51_3 lad51_4 19.9
Cl51_4 lad51_4 VSUBS 0.1f
Rl51_5 lad51_4 lad51_5 14.8
Cl51_5 lad51_5 VSUBS 0.1f
Rl51_6 lad51_5 lad51_6 17.3
Cl51_6 lad51_6 VSUBS 0.1f
Rl51_7 lad51_6 lad51_7 10.8
Cl51_7 lad51_7 VSUBS 0.1f
Rl51_8 lad51_7 lad51_8 5.84
Cl51_8 lad51_8 VSUBS 0.1f
Rl51_9 lad51_8 lad51_9 13.2
Cl51_9 lad51_9 VSUBS 0.1f
Rl52_0 trk0 lad52_0 8.72
Cl52_0 lad52_0 VSUBS 0.1f
Rl52_1 lad52_0 lad52_1 6.8
Cl52_1 lad52_1 VSUBS 0.1f
Rl52_2 lad52_1 lad52_2 18.2
Cl52_2 lad52_2 VSUBS 0.1f
Rl52_3 lad52_2 lad52_3 6.8
Cl52_3 lad52_3 VSUBS 0.1f
Rl52_4 lad52_3 lad52_4 14.8
Cl52_4 lad52_4 VSUBS 0.1f
Rl52_5 lad52_4 lad52_5 12.9
Cl52_5 lad52_5 VSUBS 0.1f
Rl52_6 lad52_5 lad52_6 10.9
Cl52_6 lad52_6 VSUBS 0.1f
Rl52_7 lad52_6 lad52_7 10.5
Cl52_7 lad52_7 VSUBS 0.1f
Rl52_8 lad52_7 lad52_8 18.1
Cl52_8 lad52_8 VSUBS 0.1f
Rl52_9 lad52_8 lad52_9 6.39
Cl52_9 lad52_9 VSUBS 0.1f
Rl53_0 bp0 lad53_0 1.84
Cl53_0 lad53_0 VSUBS 0.1f
Rl53_1 lad53_0 lad53_1 8
Cl53_1 lad53_1 VSUBS 0.1f
Rl53_2 lad53_1 lad53_2 3.28
Cl53_2 lad53_2 VSUBS 0.1f
Rl53_3 lad53_2 lad53_3 1.93
Cl53_3 lad53_3 VSUBS 0.1f
Rl53_4 lad53_3 lad53_4 17.8
Cl53_4 lad53_4 VSUBS 0.1f
Rl53_5 lad53_4 lad53_5 12.4
Cl53_5 lad53_5 VSUBS 0.1f
Rl53_6 lad53_5 lad53_6 9.96
Cl53_6 lad53_6 VSUBS 0.1f
Rl53_7 lad53_6 lad53_7 8.46
Cl53_7 lad53_7 VSUBS 0.1f
Rl53_8 lad53_7 lad53_8 7.16
Cl53_8 lad53_8 VSUBS 0.1f
Rl53_9 lad53_8 lad53_9 8.61
Cl53_9 lad53_9 VSUBS 0.1f
Rl54_0 nr lad54_0 1.45
Cl54_0 lad54_0 VSUBS 0.1f
Rl54_1 lad54_0 lad54_1 15.5
Cl54_1 lad54_1 VSUBS 0.1f
Rl54_2 lad54_1 lad54_2 17.8
Cl54_2 lad54_2 VSUBS 0.1f
Rl54_3 lad54_2 lad54_3 3.39
Cl54_3 lad54_3 VSUBS 0.1f
Rl54_4 lad54_3 lad54_4 6.8
Cl54_4 lad54_4 VSUBS 0.1f
Rl54_5 lad54_4 lad54_5 11.6
Cl54_5 lad54_5 VSUBS 0.1f
Rl54_6 lad54_5 lad54_6 2.6
Cl54_6 lad54_6 VSUBS 0.1f
Rl54_7 lad54_6 lad54_7 9.55
Cl54_7 lad54_7 VSUBS 0.1f
Rl54_8 lad54_7 lad54_8 7.15
Cl54_8 lad54_8 VSUBS 0.1f
Rl54_9 lad54_8 lad54_9 1.35
Cl54_9 lad54_9 VSUBS 0.1f
Rl55_0 bn11 lad55_0 6.45
Cl55_0 lad55_0 VSUBS 0.1f
Rl55_1 lad55_0 lad55_1 5.52
Cl55_1 lad55_1 VSUBS 0.1f
Rl55_2 lad55_1 lad55_2 13.9
Cl55_2 lad55_2 VSUBS 0.1f
Rl55_3 lad55_2 lad55_3 16.3
Cl55_3 lad55_3 VSUBS 0.1f
Rl55_4 lad55_3 lad55_4 2.66
Cl55_4 lad55_4 VSUBS 0.1f
Rl55_5 lad55_4 lad55_5 6.6
Cl55_5 lad55_5 VSUBS 0.1f
Rl55_6 lad55_5 lad55_6 12.5
Cl55_6 lad55_6 VSUBS 0.1f
Rl55_7 lad55_6 lad55_7 7.26
Cl55_7 lad55_7 VSUBS 0.1f
Rl55_8 lad55_7 lad55_8 2.31
Cl55_8 lad55_8 VSUBS 0.1f
Rl55_9 lad55_8 lad55_9 17.5
Cl55_9 lad55_9 VSUBS 0.1f
Rl56_0 onn lad56_0 3.16
Cl56_0 lad56_0 VSUBS 0.1f
Rl56_1 lad56_0 lad56_1 16.2
Cl56_1 lad56_1 VSUBS 0.1f
Rl56_2 lad56_1 lad56_2 7.88
Cl56_2 lad56_2 VSUBS 0.1f
Rl56_3 lad56_2 lad56_3 1.69
Cl56_3 lad56_3 VSUBS 0.1f
Rl56_4 lad56_3 lad56_4 3.03
Cl56_4 lad56_4 VSUBS 0.1f
Rl56_5 lad56_4 lad56_5 9.47
Cl56_5 lad56_5 VSUBS 0.1f
Rl56_6 lad56_5 lad56_6 19.2
Cl56_6 lad56_6 VSUBS 0.1f
Rl56_7 lad56_6 lad56_7 6.18
Cl56_7 lad56_7 VSUBS 0.1f
Rl56_8 lad56_7 lad56_8 11.3
Cl56_8 lad56_8 VSUBS 0.1f
Rl56_9 lad56_8 lad56_9 4.64
Cl56_9 lad56_9 VSUBS 0.1f
Rl57_0 xs1n_cbp lad57_0 8.46
Cl57_0 lad57_0 VSUBS 0.1f
Rl57_1 lad57_0 lad57_1 2.98
Cl57_1 lad57_1 VSUBS 0.1f
Rl57_2 lad57_1 lad57_2 1.79
Cl57_2 lad57_2 VSUBS 0.1f
Rl57_3 lad57_2 lad57_3 15.3
Cl57_3 lad57_3 VSUBS 0.1f
Rl57_4 lad57_3 lad57_4 18.9
Cl57_4 lad57_4 VSUBS 0.1f
Rl57_5 lad57_4 lad57_5 11.7
Cl57_5 lad57_5 VSUBS 0.1f
Rl57_6 lad57_5 lad57_6 9.18
Cl57_6 lad57_6 VSUBS 0.1f
Rl57_7 lad57_6 lad57_7 8
Cl57_7 lad57_7 VSUBS 0.1f
Rl57_8 lad57_7 lad57_8 5.07
Cl57_8 lad57_8 VSUBS 0.1f
Rl57_9 lad57_8 lad57_9 3
Cl57_9 lad57_9 VSUBS 0.1f
Rl58_0 cn9 lad58_0 7.64
Cl58_0 lad58_0 VSUBS 0.1f
Rl58_1 lad58_0 lad58_1 6.33
Cl58_1 lad58_1 VSUBS 0.1f
Rl58_2 lad58_1 lad58_2 16.8
Cl58_2 lad58_2 VSUBS 0.1f
Rl58_3 lad58_2 lad58_3 19.4
Cl58_3 lad58_3 VSUBS 0.1f
Rl58_4 lad58_3 lad58_4 15.6
Cl58_4 lad58_4 VSUBS 0.1f
Rl58_5 lad58_4 lad58_5 13.2
Cl58_5 lad58_5 VSUBS 0.1f
Rl58_6 lad58_5 lad58_6 8.14
Cl58_6 lad58_6 VSUBS 0.1f
Rl58_7 lad58_6 lad58_7 19.7
Cl58_7 lad58_7 VSUBS 0.1f
Rl58_8 lad58_7 lad58_8 17.9
Cl58_8 lad58_8 VSUBS 0.1f
Rl58_9 lad58_8 lad58_9 6.31
Cl58_9 lad58_9 VSUBS 0.1f
Rl59_0 cp4 lad59_0 9.42
Cl59_0 lad59_0 VSUBS 0.1f
Rl59_1 lad59_0 lad59_1 2.6
Cl59_1 lad59_1 VSUBS 0.1f
Rl59_2 lad59_1 lad59_2 15.1
Cl59_2 lad59_2 VSUBS 0.1f
Rl59_3 lad59_2 lad59_3 17
Cl59_3 lad59_3 VSUBS 0.1f
Rl59_4 lad59_3 lad59_4 4.57
Cl59_4 lad59_4 VSUBS 0.1f
Rl59_5 lad59_4 lad59_5 4.73
Cl59_5 lad59_5 VSUBS 0.1f
Rl59_6 lad59_5 lad59_6 19.7
Cl59_6 lad59_6 VSUBS 0.1f
Rl59_7 lad59_6 lad59_7 17.4
Cl59_7 lad59_7 VSUBS 0.1f
Rl59_8 lad59_7 lad59_8 2.26
Cl59_8 lad59_8 VSUBS 0.1f
Rl59_9 lad59_8 lad59_9 16.9
Cl59_9 lad59_9 VSUBS 0.1f
Rl60_0 cn7 lad60_0 13.4
Cl60_0 lad60_0 VSUBS 0.1f
Rl60_1 lad60_0 lad60_1 9.65
Cl60_1 lad60_1 VSUBS 0.1f
Rl60_2 lad60_1 lad60_2 15.2
Cl60_2 lad60_2 VSUBS 0.1f
Rl60_3 lad60_2 lad60_3 2.46
Cl60_3 lad60_3 VSUBS 0.1f
Rl60_4 lad60_3 lad60_4 1.36
Cl60_4 lad60_4 VSUBS 0.1f
Rl60_5 lad60_4 lad60_5 19
Cl60_5 lad60_5 VSUBS 0.1f
Rl60_6 lad60_5 lad60_6 2.15
Cl60_6 lad60_6 VSUBS 0.1f
Rl60_7 lad60_6 lad60_7 13
Cl60_7 lad60_7 VSUBS 0.1f
Rl60_8 lad60_7 lad60_8 13.6
Cl60_8 lad60_8 VSUBS 0.1f
Rl60_9 lad60_8 lad60_9 6.61
Cl60_9 lad60_9 VSUBS 0.1f
Rl61_0 t0 lad61_0 3.83
Cl61_0 lad61_0 VSUBS 0.1f
Rl61_1 lad61_0 lad61_1 13.8
Cl61_1 lad61_1 VSUBS 0.1f
Rl61_2 lad61_1 lad61_2 15.9
Cl61_2 lad61_2 VSUBS 0.1f
Rl61_3 lad61_2 lad61_3 13.5
Cl61_3 lad61_3 VSUBS 0.1f
Rl61_4 lad61_3 lad61_4 5.21
Cl61_4 lad61_4 VSUBS 0.1f
Rl61_5 lad61_4 lad61_5 3.14
Cl61_5 lad61_5 VSUBS 0.1f
Rl61_6 lad61_5 lad61_6 3.58
Cl61_6 lad61_6 VSUBS 0.1f
Rl61_7 lad61_6 lad61_7 1.38
Cl61_7 lad61_7 VSUBS 0.1f
Rl61_8 lad61_7 lad61_8 3.42
Cl61_8 lad61_8 VSUBS 0.1f
Rl61_9 lad61_8 lad61_9 18.7
Cl61_9 lad61_9 VSUBS 0.1f
Rl62_0 bn0 lad62_0 4.61
Cl62_0 lad62_0 VSUBS 0.1f
Rl62_1 lad62_0 lad62_1 15
Cl62_1 lad62_1 VSUBS 0.1f
Rl62_2 lad62_1 lad62_2 8.6
Cl62_2 lad62_2 VSUBS 0.1f
Rl62_3 lad62_2 lad62_3 7.99
Cl62_3 lad62_3 VSUBS 0.1f
Rl62_4 lad62_3 lad62_4 1.44
Cl62_4 lad62_4 VSUBS 0.1f
Rl62_5 lad62_4 lad62_5 1.61
Cl62_5 lad62_5 VSUBS 0.1f
Rl62_6 lad62_5 lad62_6 9.76
Cl62_6 lad62_6 VSUBS 0.1f
Rl62_7 lad62_6 lad62_7 9.78
Cl62_7 lad62_7 VSUBS 0.1f
Rl62_8 lad62_7 lad62_8 14
Cl62_8 lad62_8 VSUBS 0.1f
Rl62_9 lad62_8 lad62_9 3.55
Cl62_9 lad62_9 VSUBS 0.1f
Rl63_0 cn12 lad63_0 12.6
Cl63_0 lad63_0 VSUBS 0.1f
Rl63_1 lad63_0 lad63_1 14.5
Cl63_1 lad63_1 VSUBS 0.1f
Rl63_2 lad63_1 lad63_2 16
Cl63_2 lad63_2 VSUBS 0.1f
Rl63_3 lad63_2 lad63_3 16.5
Cl63_3 lad63_3 VSUBS 0.1f
Rl63_4 lad63_3 lad63_4 1.96
Cl63_4 lad63_4 VSUBS 0.1f
Rl63_5 lad63_4 lad63_5 16.4
Cl63_5 lad63_5 VSUBS 0.1f
Rl63_6 lad63_5 lad63_6 13.4
Cl63_6 lad63_6 VSUBS 0.1f
Rl63_7 lad63_6 lad63_7 4.51
Cl63_7 lad63_7 VSUBS 0.1f
Rl63_8 lad63_7 lad63_8 7.71
Cl63_8 lad63_8 VSUBS 0.1f
Rl63_9 lad63_8 lad63_9 15.1
Cl63_9 lad63_9 VSUBS 0.1f
Rl64_0 xs1n_g lad64_0 10.6
Cl64_0 lad64_0 VSUBS 0.1f
Rl64_1 lad64_0 lad64_1 8.56
Cl64_1 lad64_1 VSUBS 0.1f
Rl64_2 lad64_1 lad64_2 13.1
Cl64_2 lad64_2 VSUBS 0.1f
Rl64_3 lad64_2 lad64_3 3.98
Cl64_3 lad64_3 VSUBS 0.1f
Rl64_4 lad64_3 lad64_4 10.8
Cl64_4 lad64_4 VSUBS 0.1f
Rl64_5 lad64_4 lad64_5 17.7
Cl64_5 lad64_5 VSUBS 0.1f
Rl64_6 lad64_5 lad64_6 17.4
Cl64_6 lad64_6 VSUBS 0.1f
Rl64_7 lad64_6 lad64_7 10.3
Cl64_7 lad64_7 VSUBS 0.1f
Rl64_8 lad64_7 lad64_8 11.3
Cl64_8 lad64_8 VSUBS 0.1f
Rl64_9 lad64_8 lad64_9 10.3
Cl64_9 lad64_9 VSUBS 0.1f
Rl65_0 bn12 lad65_0 1.87
Cl65_0 lad65_0 VSUBS 0.1f
Rl65_1 lad65_0 lad65_1 8.6
Cl65_1 lad65_1 VSUBS 0.1f
Rl65_2 lad65_1 lad65_2 12.9
Cl65_2 lad65_2 VSUBS 0.1f
Rl65_3 lad65_2 lad65_3 7.61
Cl65_3 lad65_3 VSUBS 0.1f
Rl65_4 lad65_3 lad65_4 15.1
Cl65_4 lad65_4 VSUBS 0.1f
Rl65_5 lad65_4 lad65_5 9.38
Cl65_5 lad65_5 VSUBS 0.1f
Rl65_6 lad65_5 lad65_6 6.23
Cl65_6 lad65_6 VSUBS 0.1f
Rl65_7 lad65_6 lad65_7 9.54
Cl65_7 lad65_7 VSUBS 0.1f
Rl65_8 lad65_7 lad65_8 6.07
Cl65_8 lad65_8 VSUBS 0.1f
Rl65_9 lad65_8 lad65_9 6.24
Cl65_9 lad65_9 VSUBS 0.1f
Rl66_0 cn12 lad66_0 13.7
Cl66_0 lad66_0 VSUBS 0.1f
Rl66_1 lad66_0 lad66_1 9.86
Cl66_1 lad66_1 VSUBS 0.1f
Rl66_2 lad66_1 lad66_2 7.62
Cl66_2 lad66_2 VSUBS 0.1f
Rl66_3 lad66_2 lad66_3 17
Cl66_3 lad66_3 VSUBS 0.1f
Rl66_4 lad66_3 lad66_4 16.5
Cl66_4 lad66_4 VSUBS 0.1f
Rl66_5 lad66_4 lad66_5 3.33
Cl66_5 lad66_5 VSUBS 0.1f
Rl66_6 lad66_5 lad66_6 18.1
Cl66_6 lad66_6 VSUBS 0.1f
Rl66_7 lad66_6 lad66_7 11.4
Cl66_7 lad66_7 VSUBS 0.1f
Rl66_8 lad66_7 lad66_8 12
Cl66_8 lad66_8 VSUBS 0.1f
Rl66_9 lad66_8 lad66_9 16.1
Cl66_9 lad66_9 VSUBS 0.1f
Rl67_0 cn3 lad67_0 11.7
Cl67_0 lad67_0 VSUBS 0.1f
Rl67_1 lad67_0 lad67_1 7.81
Cl67_1 lad67_1 VSUBS 0.1f
Rl67_2 lad67_1 lad67_2 19.6
Cl67_2 lad67_2 VSUBS 0.1f
Rl67_3 lad67_2 lad67_3 7.56
Cl67_3 lad67_3 VSUBS 0.1f
Rl67_4 lad67_3 lad67_4 18.8
Cl67_4 lad67_4 VSUBS 0.1f
Rl67_5 lad67_4 lad67_5 17.6
Cl67_5 lad67_5 VSUBS 0.1f
Rl67_6 lad67_5 lad67_6 4.97
Cl67_6 lad67_6 VSUBS 0.1f
Rl67_7 lad67_6 lad67_7 10.5
Cl67_7 lad67_7 VSUBS 0.1f
Rl67_8 lad67_7 lad67_8 4.87
Cl67_8 lad67_8 VSUBS 0.1f
Rl67_9 lad67_8 lad67_9 12.9
Cl67_9 lad67_9 VSUBS 0.1f
Rl68_0 clkn lad68_0 3.39
Cl68_0 lad68_0 VSUBS 0.1f
Rl68_1 lad68_0 lad68_1 15
Cl68_1 lad68_1 VSUBS 0.1f
Rl68_2 lad68_1 lad68_2 9.47
Cl68_2 lad68_2 VSUBS 0.1f
Rl68_3 lad68_2 lad68_3 16.7
Cl68_3 lad68_3 VSUBS 0.1f
Rl68_4 lad68_3 lad68_4 2.72
Cl68_4 lad68_4 VSUBS 0.1f
Rl68_5 lad68_4 lad68_5 12.9
Cl68_5 lad68_5 VSUBS 0.1f
Rl68_6 lad68_5 lad68_6 1.86
Cl68_6 lad68_6 VSUBS 0.1f
Rl68_7 lad68_6 lad68_7 1.32
Cl68_7 lad68_7 VSUBS 0.1f
Rl68_8 lad68_7 lad68_8 13.7
Cl68_8 lad68_8 VSUBS 0.1f
Rl68_9 lad68_8 lad68_9 12.1
Cl68_9 lad68_9 VSUBS 0.1f
Rl69_0 t1b lad69_0 14.8
Cl69_0 lad69_0 VSUBS 0.1f
Rl69_1 lad69_0 lad69_1 4.28
Cl69_1 lad69_1 VSUBS 0.1f
Rl69_2 lad69_1 lad69_2 11.4
Cl69_2 lad69_2 VSUBS 0.1f
Rl69_3 lad69_2 lad69_3 8.18
Cl69_3 lad69_3 VSUBS 0.1f
Rl69_4 lad69_3 lad69_4 12.2
Cl69_4 lad69_4 VSUBS 0.1f
Rl69_5 lad69_4 lad69_5 18.2
Cl69_5 lad69_5 VSUBS 0.1f
Rl69_6 lad69_5 lad69_6 5.77
Cl69_6 lad69_6 VSUBS 0.1f
Rl69_7 lad69_6 lad69_7 12.7
Cl69_7 lad69_7 VSUBS 0.1f
Rl69_8 lad69_7 lad69_8 1.06
Cl69_8 lad69_8 VSUBS 0.1f
Rl69_9 lad69_8 lad69_9 14.9
Cl69_9 lad69_9 VSUBS 0.1f
Rl70_0 xs1n_cbp lad70_0 2.91
Cl70_0 lad70_0 VSUBS 0.1f
Rl70_1 lad70_0 lad70_1 9.11
Cl70_1 lad70_1 VSUBS 0.1f
Rl70_2 lad70_1 lad70_2 1.5
Cl70_2 lad70_2 VSUBS 0.1f
Rl70_3 lad70_2 lad70_3 10.6
Cl70_3 lad70_3 VSUBS 0.1f
Rl70_4 lad70_3 lad70_4 19
Cl70_4 lad70_4 VSUBS 0.1f
Rl70_5 lad70_4 lad70_5 1.51
Cl70_5 lad70_5 VSUBS 0.1f
Rl70_6 lad70_5 lad70_6 13.5
Cl70_6 lad70_6 VSUBS 0.1f
Rl70_7 lad70_6 lad70_7 8.42
Cl70_7 lad70_7 VSUBS 0.1f
Rl70_8 lad70_7 lad70_8 17.3
Cl70_8 lad70_8 VSUBS 0.1f
Rl70_9 lad70_8 lad70_9 6.36
Cl70_9 lad70_9 VSUBS 0.1f
Rl71_0 xc4_outpb lad71_0 19.2
Cl71_0 lad71_0 VSUBS 0.1f
Rl71_1 lad71_0 lad71_1 16.3
Cl71_1 lad71_1 VSUBS 0.1f
Rl71_2 lad71_1 lad71_2 7.45
Cl71_2 lad71_2 VSUBS 0.1f
Rl71_3 lad71_2 lad71_3 4.71
Cl71_3 lad71_3 VSUBS 0.1f
Rl71_4 lad71_3 lad71_4 10
Cl71_4 lad71_4 VSUBS 0.1f
Rl71_5 lad71_4 lad71_5 10.1
Cl71_5 lad71_5 VSUBS 0.1f
Rl71_6 lad71_5 lad71_6 1.12
Cl71_6 lad71_6 VSUBS 0.1f
Rl71_7 lad71_6 lad71_7 15.9
Cl71_7 lad71_7 VSUBS 0.1f
Rl71_8 lad71_7 lad71_8 6.81
Cl71_8 lad71_8 VSUBS 0.1f
Rl71_9 lad71_8 lad71_9 18.2
Cl71_9 lad71_9 VSUBS 0.1f
Rl72_0 bp10 lad72_0 6.37
Cl72_0 lad72_0 VSUBS 0.1f
Rl72_1 lad72_0 lad72_1 19.6
Cl72_1 lad72_1 VSUBS 0.1f
Rl72_2 lad72_1 lad72_2 11.4
Cl72_2 lad72_2 VSUBS 0.1f
Rl72_3 lad72_2 lad72_3 17.7
Cl72_3 lad72_3 VSUBS 0.1f
Rl72_4 lad72_3 lad72_4 14.7
Cl72_4 lad72_4 VSUBS 0.1f
Rl72_5 lad72_4 lad72_5 1.42
Cl72_5 lad72_5 VSUBS 0.1f
Rl72_6 lad72_5 lad72_6 11.8
Cl72_6 lad72_6 VSUBS 0.1f
Rl72_7 lad72_6 lad72_7 2.03
Cl72_7 lad72_7 VSUBS 0.1f
Rl72_8 lad72_7 lad72_8 19.9
Cl72_8 lad72_8 VSUBS 0.1f
Rl72_9 lad72_8 lad72_9 2.42
Cl72_9 lad72_9 VSUBS 0.1f
Rl73_0 xc5_outpb lad73_0 19.7
Cl73_0 lad73_0 VSUBS 0.1f
Rl73_1 lad73_0 lad73_1 2.92
Cl73_1 lad73_1 VSUBS 0.1f
Rl73_2 lad73_1 lad73_2 8.33
Cl73_2 lad73_2 VSUBS 0.1f
Rl73_3 lad73_2 lad73_3 18.9
Cl73_3 lad73_3 VSUBS 0.1f
Rl73_4 lad73_3 lad73_4 4.9
Cl73_4 lad73_4 VSUBS 0.1f
Rl73_5 lad73_4 lad73_5 18.9
Cl73_5 lad73_5 VSUBS 0.1f
Rl73_6 lad73_5 lad73_6 15.2
Cl73_6 lad73_6 VSUBS 0.1f
Rl73_7 lad73_6 lad73_7 1.58
Cl73_7 lad73_7 VSUBS 0.1f
Rl73_8 lad73_7 lad73_8 13
Cl73_8 lad73_8 VSUBS 0.1f
Rl73_9 lad73_8 lad73_9 5.96
Cl73_9 lad73_9 VSUBS 0.1f
Rl74_0 bp2 lad74_0 12.8
Cl74_0 lad74_0 VSUBS 0.1f
Rl74_1 lad74_0 lad74_1 2.21
Cl74_1 lad74_1 VSUBS 0.1f
Rl74_2 lad74_1 lad74_2 2.71
Cl74_2 lad74_2 VSUBS 0.1f
Rl74_3 lad74_2 lad74_3 6.83
Cl74_3 lad74_3 VSUBS 0.1f
Rl74_4 lad74_3 lad74_4 12.4
Cl74_4 lad74_4 VSUBS 0.1f
Rl74_5 lad74_4 lad74_5 12.3
Cl74_5 lad74_5 VSUBS 0.1f
Rl74_6 lad74_5 lad74_6 4.8
Cl74_6 lad74_6 VSUBS 0.1f
Rl74_7 lad74_6 lad74_7 11.2
Cl74_7 lad74_7 VSUBS 0.1f
Rl74_8 lad74_7 lad74_8 14.6
Cl74_8 lad74_8 VSUBS 0.1f
Rl74_9 lad74_8 lad74_9 16.4
Cl74_9 lad74_9 VSUBS 0.1f
Rl75_0 bp8 lad75_0 13.5
Cl75_0 lad75_0 VSUBS 0.1f
Rl75_1 lad75_0 lad75_1 1.14
Cl75_1 lad75_1 VSUBS 0.1f
Rl75_2 lad75_1 lad75_2 4.24
Cl75_2 lad75_2 VSUBS 0.1f
Rl75_3 lad75_2 lad75_3 12.1
Cl75_3 lad75_3 VSUBS 0.1f
Rl75_4 lad75_3 lad75_4 19.1
Cl75_4 lad75_4 VSUBS 0.1f
Rl75_5 lad75_4 lad75_5 16.8
Cl75_5 lad75_5 VSUBS 0.1f
Rl75_6 lad75_5 lad75_6 13.2
Cl75_6 lad75_6 VSUBS 0.1f
Rl75_7 lad75_6 lad75_7 17.4
Cl75_7 lad75_7 VSUBS 0.1f
Rl75_8 lad75_7 lad75_8 14.2
Cl75_8 lad75_8 VSUBS 0.1f
Rl75_9 lad75_8 lad75_9 11
Cl75_9 lad75_9 VSUBS 0.1f
Rl76_0 cp11 lad76_0 7.33
Cl76_0 lad76_0 VSUBS 0.1f
Rl76_1 lad76_0 lad76_1 1.18
Cl76_1 lad76_1 VSUBS 0.1f
Rl76_2 lad76_1 lad76_2 8.32
Cl76_2 lad76_2 VSUBS 0.1f
Rl76_3 lad76_2 lad76_3 2.92
Cl76_3 lad76_3 VSUBS 0.1f
Rl76_4 lad76_3 lad76_4 9.12
Cl76_4 lad76_4 VSUBS 0.1f
Rl76_5 lad76_4 lad76_5 4.03
Cl76_5 lad76_5 VSUBS 0.1f
Rl76_6 lad76_5 lad76_6 4.45
Cl76_6 lad76_6 VSUBS 0.1f
Rl76_7 lad76_6 lad76_7 3.11
Cl76_7 lad76_7 VSUBS 0.1f
Rl76_8 lad76_7 lad76_8 10.5
Cl76_8 lad76_8 VSUBS 0.1f
Rl76_9 lad76_8 lad76_9 11.4
Cl76_9 lad76_9 VSUBS 0.1f
Rl77_0 xc4_outnb lad77_0 16.6
Cl77_0 lad77_0 VSUBS 0.1f
Rl77_1 lad77_0 lad77_1 3.94
Cl77_1 lad77_1 VSUBS 0.1f
Rl77_2 lad77_1 lad77_2 16.2
Cl77_2 lad77_2 VSUBS 0.1f
Rl77_3 lad77_2 lad77_3 1.41
Cl77_3 lad77_3 VSUBS 0.1f
Rl77_4 lad77_3 lad77_4 17.9
Cl77_4 lad77_4 VSUBS 0.1f
Rl77_5 lad77_4 lad77_5 7.11
Cl77_5 lad77_5 VSUBS 0.1f
Rl77_6 lad77_5 lad77_6 12.1
Cl77_6 lad77_6 VSUBS 0.1f
Rl77_7 lad77_6 lad77_7 8.48
Cl77_7 lad77_7 VSUBS 0.1f
Rl77_8 lad77_7 lad77_8 13.6
Cl77_8 lad77_8 VSUBS 0.1f
Rl77_9 lad77_8 lad77_9 1.54
Cl77_9 lad77_9 VSUBS 0.1f
Rl78_0 cp6 lad78_0 12.4
Cl78_0 lad78_0 VSUBS 0.1f
Rl78_1 lad78_0 lad78_1 10.8
Cl78_1 lad78_1 VSUBS 0.1f
Rl78_2 lad78_1 lad78_2 1.68
Cl78_2 lad78_2 VSUBS 0.1f
Rl78_3 lad78_2 lad78_3 7.8
Cl78_3 lad78_3 VSUBS 0.1f
Rl78_4 lad78_3 lad78_4 6.46
Cl78_4 lad78_4 VSUBS 0.1f
Rl78_5 lad78_4 lad78_5 17.1
Cl78_5 lad78_5 VSUBS 0.1f
Rl78_6 lad78_5 lad78_6 6.5
Cl78_6 lad78_6 VSUBS 0.1f
Rl78_7 lad78_6 lad78_7 14.5
Cl78_7 lad78_7 VSUBS 0.1f
Rl78_8 lad78_7 lad78_8 16.7
Cl78_8 lad78_8 VSUBS 0.1f
Rl78_9 lad78_8 lad78_9 7.27
Cl78_9 lad78_9 VSUBS 0.1f
Rl79_0 cp2 lad79_0 3.56
Cl79_0 lad79_0 VSUBS 0.1f
Rl79_1 lad79_0 lad79_1 6.78
Cl79_1 lad79_1 VSUBS 0.1f
Rl79_2 lad79_1 lad79_2 3.68
Cl79_2 lad79_2 VSUBS 0.1f
Rl79_3 lad79_2 lad79_3 18.4
Cl79_3 lad79_3 VSUBS 0.1f
Rl79_4 lad79_3 lad79_4 5.77
Cl79_4 lad79_4 VSUBS 0.1f
Rl79_5 lad79_4 lad79_5 7.16
Cl79_5 lad79_5 VSUBS 0.1f
Rl79_6 lad79_5 lad79_6 12.7
Cl79_6 lad79_6 VSUBS 0.1f
Rl79_7 lad79_6 lad79_7 5.63
Cl79_7 lad79_7 VSUBS 0.1f
Rl79_8 lad79_7 lad79_8 5.29
Cl79_8 lad79_8 VSUBS 0.1f
Rl79_9 lad79_8 lad79_9 2.27
Cl79_9 lad79_9 VSUBS 0.1f
Rl80_0 bn0 lad80_0 16
Cl80_0 lad80_0 VSUBS 0.1f
Rl80_1 lad80_0 lad80_1 8.93
Cl80_1 lad80_1 VSUBS 0.1f
Rl80_2 lad80_1 lad80_2 2.52
Cl80_2 lad80_2 VSUBS 0.1f
Rl80_3 lad80_2 lad80_3 7.33
Cl80_3 lad80_3 VSUBS 0.1f
Rl80_4 lad80_3 lad80_4 1.57
Cl80_4 lad80_4 VSUBS 0.1f
Rl80_5 lad80_4 lad80_5 14.9
Cl80_5 lad80_5 VSUBS 0.1f
Rl80_6 lad80_5 lad80_6 7.67
Cl80_6 lad80_6 VSUBS 0.1f
Rl80_7 lad80_6 lad80_7 11.4
Cl80_7 lad80_7 VSUBS 0.1f
Rl80_8 lad80_7 lad80_8 8.69
Cl80_8 lad80_8 VSUBS 0.1f
Rl80_9 lad80_8 lad80_9 3.9
Cl80_9 lad80_9 VSUBS 0.1f
Rl81_0 cn3 lad81_0 8.57
Cl81_0 lad81_0 VSUBS 0.1f
Rl81_1 lad81_0 lad81_1 2.2
Cl81_1 lad81_1 VSUBS 0.1f
Rl81_2 lad81_1 lad81_2 13.8
Cl81_2 lad81_2 VSUBS 0.1f
Rl81_3 lad81_2 lad81_3 19.5
Cl81_3 lad81_3 VSUBS 0.1f
Rl81_4 lad81_3 lad81_4 12.6
Cl81_4 lad81_4 VSUBS 0.1f
Rl81_5 lad81_4 lad81_5 16.3
Cl81_5 lad81_5 VSUBS 0.1f
Rl81_6 lad81_5 lad81_6 18.7
Cl81_6 lad81_6 VSUBS 0.1f
Rl81_7 lad81_6 lad81_7 3.92
Cl81_7 lad81_7 VSUBS 0.1f
Rl81_8 lad81_7 lad81_8 19.9
Cl81_8 lad81_8 VSUBS 0.1f
Rl81_9 lad81_8 lad81_9 15.7
Cl81_9 lad81_9 VSUBS 0.1f
Rl82_0 cp6 lad82_0 7.36
Cl82_0 lad82_0 VSUBS 0.1f
Rl82_1 lad82_0 lad82_1 18.8
Cl82_1 lad82_1 VSUBS 0.1f
Rl82_2 lad82_1 lad82_2 18.2
Cl82_2 lad82_2 VSUBS 0.1f
Rl82_3 lad82_2 lad82_3 15.8
Cl82_3 lad82_3 VSUBS 0.1f
Rl82_4 lad82_3 lad82_4 16.4
Cl82_4 lad82_4 VSUBS 0.1f
Rl82_5 lad82_4 lad82_5 17
Cl82_5 lad82_5 VSUBS 0.1f
Rl82_6 lad82_5 lad82_6 2.24
Cl82_6 lad82_6 VSUBS 0.1f
Rl82_7 lad82_6 lad82_7 9.36
Cl82_7 lad82_7 VSUBS 0.1f
Rl82_8 lad82_7 lad82_8 3.95
Cl82_8 lad82_8 VSUBS 0.1f
Rl82_9 lad82_8 lad82_9 18.8
Cl82_9 lad82_9 VSUBS 0.1f
Rl83_0 bn0 lad83_0 4.28
Cl83_0 lad83_0 VSUBS 0.1f
Rl83_1 lad83_0 lad83_1 12.2
Cl83_1 lad83_1 VSUBS 0.1f
Rl83_2 lad83_1 lad83_2 5.43
Cl83_2 lad83_2 VSUBS 0.1f
Rl83_3 lad83_2 lad83_3 1.29
Cl83_3 lad83_3 VSUBS 0.1f
Rl83_4 lad83_3 lad83_4 8.08
Cl83_4 lad83_4 VSUBS 0.1f
Rl83_5 lad83_4 lad83_5 9.55
Cl83_5 lad83_5 VSUBS 0.1f
Rl83_6 lad83_5 lad83_6 10.5
Cl83_6 lad83_6 VSUBS 0.1f
Rl83_7 lad83_6 lad83_7 9.24
Cl83_7 lad83_7 VSUBS 0.1f
Rl83_8 lad83_7 lad83_8 6.8
Cl83_8 lad83_8 VSUBS 0.1f
Rl83_9 lad83_8 lad83_9 8.07
Cl83_9 lad83_9 VSUBS 0.1f
Rl84_0 xc5_din lad84_0 6.83
Cl84_0 lad84_0 VSUBS 0.1f
Rl84_1 lad84_0 lad84_1 6.62
Cl84_1 lad84_1 VSUBS 0.1f
Rl84_2 lad84_1 lad84_2 20
Cl84_2 lad84_2 VSUBS 0.1f
Rl84_3 lad84_2 lad84_3 12.7
Cl84_3 lad84_3 VSUBS 0.1f
Rl84_4 lad84_3 lad84_4 11.7
Cl84_4 lad84_4 VSUBS 0.1f
Rl84_5 lad84_4 lad84_5 19.8
Cl84_5 lad84_5 VSUBS 0.1f
Rl84_6 lad84_5 lad84_6 19.9
Cl84_6 lad84_6 VSUBS 0.1f
Rl84_7 lad84_6 lad84_7 2.36
Cl84_7 lad84_7 VSUBS 0.1f
Rl84_8 lad84_7 lad84_8 8.41
Cl84_8 lad84_8 VSUBS 0.1f
Rl84_9 lad84_8 lad84_9 16.1
Cl84_9 lad84_9 VSUBS 0.1f
Rl85_0 xc5_xs1_tail0 lad85_0 3.64
Cl85_0 lad85_0 VSUBS 0.1f
Rl85_1 lad85_0 lad85_1 2.17
Cl85_1 lad85_1 VSUBS 0.1f
Rl85_2 lad85_1 lad85_2 8.6
Cl85_2 lad85_2 VSUBS 0.1f
Rl85_3 lad85_2 lad85_3 9.85
Cl85_3 lad85_3 VSUBS 0.1f
Rl85_4 lad85_3 lad85_4 4.97
Cl85_4 lad85_4 VSUBS 0.1f
Rl85_5 lad85_4 lad85_5 19.9
Cl85_5 lad85_5 VSUBS 0.1f
Rl85_6 lad85_5 lad85_6 18.1
Cl85_6 lad85_6 VSUBS 0.1f
Rl85_7 lad85_6 lad85_7 14.3
Cl85_7 lad85_7 VSUBS 0.1f
Rl85_8 lad85_7 lad85_8 15.7
Cl85_8 lad85_8 VSUBS 0.1f
Rl85_9 lad85_8 lad85_9 3.3
Cl85_9 lad85_9 VSUBS 0.1f
Rl86_0 bp7 lad86_0 13.2
Cl86_0 lad86_0 VSUBS 0.1f
Rl86_1 lad86_0 lad86_1 10.2
Cl86_1 lad86_1 VSUBS 0.1f
Rl86_2 lad86_1 lad86_2 6
Cl86_2 lad86_2 VSUBS 0.1f
Rl86_3 lad86_2 lad86_3 12.5
Cl86_3 lad86_3 VSUBS 0.1f
Rl86_4 lad86_3 lad86_4 1.69
Cl86_4 lad86_4 VSUBS 0.1f
Rl86_5 lad86_4 lad86_5 4.53
Cl86_5 lad86_5 VSUBS 0.1f
Rl86_6 lad86_5 lad86_6 8.51
Cl86_6 lad86_6 VSUBS 0.1f
Rl86_7 lad86_6 lad86_7 15.9
Cl86_7 lad86_7 VSUBS 0.1f
Rl86_8 lad86_7 lad86_8 17.5
Cl86_8 lad86_8 VSUBS 0.1f
Rl86_9 lad86_8 lad86_9 18.2
Cl86_9 lad86_9 VSUBS 0.1f
Rl87_0 bn2 lad87_0 1.51
Cl87_0 lad87_0 VSUBS 0.1f
Rl87_1 lad87_0 lad87_1 6.94
Cl87_1 lad87_1 VSUBS 0.1f
Rl87_2 lad87_1 lad87_2 10.8
Cl87_2 lad87_2 VSUBS 0.1f
Rl87_3 lad87_2 lad87_3 13.1
Cl87_3 lad87_3 VSUBS 0.1f
Rl87_4 lad87_3 lad87_4 6.32
Cl87_4 lad87_4 VSUBS 0.1f
Rl87_5 lad87_4 lad87_5 2.53
Cl87_5 lad87_5 VSUBS 0.1f
Rl87_6 lad87_5 lad87_6 13.9
Cl87_6 lad87_6 VSUBS 0.1f
Rl87_7 lad87_6 lad87_7 8.19
Cl87_7 lad87_7 VSUBS 0.1f
Rl87_8 lad87_7 lad87_8 3.47
Cl87_8 lad87_8 VSUBS 0.1f
Rl87_9 lad87_8 lad87_9 6.93
Cl87_9 lad87_9 VSUBS 0.1f
Rl88_0 t0b lad88_0 15.6
Cl88_0 lad88_0 VSUBS 0.1f
Rl88_1 lad88_0 lad88_1 17.2
Cl88_1 lad88_1 VSUBS 0.1f
Rl88_2 lad88_1 lad88_2 4.53
Cl88_2 lad88_2 VSUBS 0.1f
Rl88_3 lad88_2 lad88_3 14.4
Cl88_3 lad88_3 VSUBS 0.1f
Rl88_4 lad88_3 lad88_4 17.8
Cl88_4 lad88_4 VSUBS 0.1f
Rl88_5 lad88_4 lad88_5 18
Cl88_5 lad88_5 VSUBS 0.1f
Rl88_6 lad88_5 lad88_6 2.63
Cl88_6 lad88_6 VSUBS 0.1f
Rl88_7 lad88_6 lad88_7 7.82
Cl88_7 lad88_7 VSUBS 0.1f
Rl88_8 lad88_7 lad88_8 4.89
Cl88_8 lad88_8 VSUBS 0.1f
Rl88_9 lad88_8 lad88_9 5.31
Cl88_9 lad88_9 VSUBS 0.1f
Rl89_0 bp1 lad89_0 7.15
Cl89_0 lad89_0 VSUBS 0.1f
Rl89_1 lad89_0 lad89_1 1.2
Cl89_1 lad89_1 VSUBS 0.1f
Rl89_2 lad89_1 lad89_2 10.4
Cl89_2 lad89_2 VSUBS 0.1f
Rl89_3 lad89_2 lad89_3 14.7
Cl89_3 lad89_3 VSUBS 0.1f
Rl89_4 lad89_3 lad89_4 16.7
Cl89_4 lad89_4 VSUBS 0.1f
Rl89_5 lad89_4 lad89_5 16.2
Cl89_5 lad89_5 VSUBS 0.1f
Rl89_6 lad89_5 lad89_6 11.5
Cl89_6 lad89_6 VSUBS 0.1f
Rl89_7 lad89_6 lad89_7 17.8
Cl89_7 lad89_7 VSUBS 0.1f
Rl89_8 lad89_7 lad89_8 14.1
Cl89_8 lad89_8 VSUBS 0.1f
Rl89_9 lad89_8 lad89_9 16.1
Cl89_9 lad89_9 VSUBS 0.1f
Rl90_0 bp10 lad90_0 7.61
Cl90_0 lad90_0 VSUBS 0.1f
Rl90_1 lad90_0 lad90_1 12.7
Cl90_1 lad90_1 VSUBS 0.1f
Rl90_2 lad90_1 lad90_2 14.6
Cl90_2 lad90_2 VSUBS 0.1f
Rl90_3 lad90_2 lad90_3 6.05
Cl90_3 lad90_3 VSUBS 0.1f
Rl90_4 lad90_3 lad90_4 8.24
Cl90_4 lad90_4 VSUBS 0.1f
Rl90_5 lad90_4 lad90_5 3.01
Cl90_5 lad90_5 VSUBS 0.1f
Rl90_6 lad90_5 lad90_6 3.3
Cl90_6 lad90_6 VSUBS 0.1f
Rl90_7 lad90_6 lad90_7 3.93
Cl90_7 lad90_7 VSUBS 0.1f
Rl90_8 lad90_7 lad90_8 19
Cl90_8 lad90_8 VSUBS 0.1f
Rl90_9 lad90_8 lad90_9 16.9
Cl90_9 lad90_9 VSUBS 0.1f
Rl91_0 bp2 lad91_0 8.38
Cl91_0 lad91_0 VSUBS 0.1f
Rl91_1 lad91_0 lad91_1 8.99
Cl91_1 lad91_1 VSUBS 0.1f
Rl91_2 lad91_1 lad91_2 3.94
Cl91_2 lad91_2 VSUBS 0.1f
Rl91_3 lad91_2 lad91_3 15.7
Cl91_3 lad91_3 VSUBS 0.1f
Rl91_4 lad91_3 lad91_4 1.8
Cl91_4 lad91_4 VSUBS 0.1f
Rl91_5 lad91_4 lad91_5 2.57
Cl91_5 lad91_5 VSUBS 0.1f
Rl91_6 lad91_5 lad91_6 13.4
Cl91_6 lad91_6 VSUBS 0.1f
Rl91_7 lad91_6 lad91_7 11.5
Cl91_7 lad91_7 VSUBS 0.1f
Rl91_8 lad91_7 lad91_8 5.91
Cl91_8 lad91_8 VSUBS 0.1f
Rl91_9 lad91_8 lad91_9 13.7
Cl91_9 lad91_9 VSUBS 0.1f
Rl92_0 bn2 lad92_0 5.01
Cl92_0 lad92_0 VSUBS 0.1f
Rl92_1 lad92_0 lad92_1 1.74
Cl92_1 lad92_1 VSUBS 0.1f
Rl92_2 lad92_1 lad92_2 14
Cl92_2 lad92_2 VSUBS 0.1f
Rl92_3 lad92_2 lad92_3 19.9
Cl92_3 lad92_3 VSUBS 0.1f
Rl92_4 lad92_3 lad92_4 7.83
Cl92_4 lad92_4 VSUBS 0.1f
Rl92_5 lad92_4 lad92_5 1.53
Cl92_5 lad92_5 VSUBS 0.1f
Rl92_6 lad92_5 lad92_6 18.6
Cl92_6 lad92_6 VSUBS 0.1f
Rl92_7 lad92_6 lad92_7 2.67
Cl92_7 lad92_7 VSUBS 0.1f
Rl92_8 lad92_7 lad92_8 6
Cl92_8 lad92_8 VSUBS 0.1f
Rl92_9 lad92_8 lad92_9 6.6
Cl92_9 lad92_9 VSUBS 0.1f
Rl93_0 xs0n_x lad93_0 18.4
Cl93_0 lad93_0 VSUBS 0.1f
Rl93_1 lad93_0 lad93_1 13.9
Cl93_1 lad93_1 VSUBS 0.1f
Rl93_2 lad93_1 lad93_2 13.5
Cl93_2 lad93_2 VSUBS 0.1f
Rl93_3 lad93_2 lad93_3 9.2
Cl93_3 lad93_3 VSUBS 0.1f
Rl93_4 lad93_3 lad93_4 2.75
Cl93_4 lad93_4 VSUBS 0.1f
Rl93_5 lad93_4 lad93_5 6.68
Cl93_5 lad93_5 VSUBS 0.1f
Rl93_6 lad93_5 lad93_6 10.5
Cl93_6 lad93_6 VSUBS 0.1f
Rl93_7 lad93_6 lad93_7 2.78
Cl93_7 lad93_7 VSUBS 0.1f
Rl93_8 lad93_7 lad93_8 4.19
Cl93_8 lad93_8 VSUBS 0.1f
Rl93_9 lad93_8 lad93_9 14.8
Cl93_9 lad93_9 VSUBS 0.1f
Rl94_0 clkn lad94_0 17
Cl94_0 lad94_0 VSUBS 0.1f
Rl94_1 lad94_0 lad94_1 14.3
Cl94_1 lad94_1 VSUBS 0.1f
Rl94_2 lad94_1 lad94_2 17.4
Cl94_2 lad94_2 VSUBS 0.1f
Rl94_3 lad94_2 lad94_3 14.3
Cl94_3 lad94_3 VSUBS 0.1f
Rl94_4 lad94_3 lad94_4 17.2
Cl94_4 lad94_4 VSUBS 0.1f
Rl94_5 lad94_4 lad94_5 9.89
Cl94_5 lad94_5 VSUBS 0.1f
Rl94_6 lad94_5 lad94_6 20
Cl94_6 lad94_6 VSUBS 0.1f
Rl94_7 lad94_6 lad94_7 14.4
Cl94_7 lad94_7 VSUBS 0.1f
Rl94_8 lad94_7 lad94_8 17.9
Cl94_8 lad94_8 VSUBS 0.1f
Rl94_9 lad94_8 lad94_9 10.2
Cl94_9 lad94_9 VSUBS 0.1f
Rl95_0 cp12 lad95_0 9.74
Cl95_0 lad95_0 VSUBS 0.1f
Rl95_1 lad95_0 lad95_1 2.59
Cl95_1 lad95_1 VSUBS 0.1f
Rl95_2 lad95_1 lad95_2 14.9
Cl95_2 lad95_2 VSUBS 0.1f
Rl95_3 lad95_2 lad95_3 7.04
Cl95_3 lad95_3 VSUBS 0.1f
Rl95_4 lad95_3 lad95_4 7.75
Cl95_4 lad95_4 VSUBS 0.1f
Rl95_5 lad95_4 lad95_5 15.2
Cl95_5 lad95_5 VSUBS 0.1f
Rl95_6 lad95_5 lad95_6 4.61
Cl95_6 lad95_6 VSUBS 0.1f
Rl95_7 lad95_6 lad95_7 2.36
Cl95_7 lad95_7 VSUBS 0.1f
Rl95_8 lad95_7 lad95_8 7.75
Cl95_8 lad95_8 VSUBS 0.1f
Rl95_9 lad95_8 lad95_9 7.62
Cl95_9 lad95_9 VSUBS 0.1f
Rl96_0 top_p lad96_0 19.7
Cl96_0 lad96_0 VSUBS 0.1f
Rl96_1 lad96_0 lad96_1 1.85
Cl96_1 lad96_1 VSUBS 0.1f
Rl96_2 lad96_1 lad96_2 11.4
Cl96_2 lad96_2 VSUBS 0.1f
Rl96_3 lad96_2 lad96_3 19.8
Cl96_3 lad96_3 VSUBS 0.1f
Rl96_4 lad96_3 lad96_4 18.7
Cl96_4 lad96_4 VSUBS 0.1f
Rl96_5 lad96_4 lad96_5 1.46
Cl96_5 lad96_5 VSUBS 0.1f
Rl96_6 lad96_5 lad96_6 7.73
Cl96_6 lad96_6 VSUBS 0.1f
Rl96_7 lad96_6 lad96_7 8.58
Cl96_7 lad96_7 VSUBS 0.1f
Rl96_8 lad96_7 lad96_8 5.03
Cl96_8 lad96_8 VSUBS 0.1f
Rl96_9 lad96_8 lad96_9 8.91
Cl96_9 lad96_9 VSUBS 0.1f
Rl97_0 cn7 lad97_0 7.63
Cl97_0 lad97_0 VSUBS 0.1f
Rl97_1 lad97_0 lad97_1 14.8
Cl97_1 lad97_1 VSUBS 0.1f
Rl97_2 lad97_1 lad97_2 14.3
Cl97_2 lad97_2 VSUBS 0.1f
Rl97_3 lad97_2 lad97_3 15.5
Cl97_3 lad97_3 VSUBS 0.1f
Rl97_4 lad97_3 lad97_4 17.4
Cl97_4 lad97_4 VSUBS 0.1f
Rl97_5 lad97_4 lad97_5 19.2
Cl97_5 lad97_5 VSUBS 0.1f
Rl97_6 lad97_5 lad97_6 16.3
Cl97_6 lad97_6 VSUBS 0.1f
Rl97_7 lad97_6 lad97_7 4.75
Cl97_7 lad97_7 VSUBS 0.1f
Rl97_8 lad97_7 lad97_8 3.39
Cl97_8 lad97_8 VSUBS 0.1f
Rl97_9 lad97_8 lad97_9 3.45
Cl97_9 lad97_9 VSUBS 0.1f
Rl98_0 xs1p_g lad98_0 8.72
Cl98_0 lad98_0 VSUBS 0.1f
Rl98_1 lad98_0 lad98_1 6.7
Cl98_1 lad98_1 VSUBS 0.1f
Rl98_2 lad98_1 lad98_2 13.4
Cl98_2 lad98_2 VSUBS 0.1f
Rl98_3 lad98_2 lad98_3 14.8
Cl98_3 lad98_3 VSUBS 0.1f
Rl98_4 lad98_3 lad98_4 1.36
Cl98_4 lad98_4 VSUBS 0.1f
Rl98_5 lad98_4 lad98_5 9.7
Cl98_5 lad98_5 VSUBS 0.1f
Rl98_6 lad98_5 lad98_6 18
Cl98_6 lad98_6 VSUBS 0.1f
Rl98_7 lad98_6 lad98_7 19.9
Cl98_7 lad98_7 VSUBS 0.1f
Rl98_8 lad98_7 lad98_8 11.6
Cl98_8 lad98_8 VSUBS 0.1f
Rl98_9 lad98_8 lad98_9 12.1
Cl98_9 lad98_9 VSUBS 0.1f
Rl99_0 rstb lad99_0 14
Cl99_0 lad99_0 VSUBS 0.1f
Rl99_1 lad99_0 lad99_1 3.53
Cl99_1 lad99_1 VSUBS 0.1f
Rl99_2 lad99_1 lad99_2 12.9
Cl99_2 lad99_2 VSUBS 0.1f
Rl99_3 lad99_2 lad99_3 10.9
Cl99_3 lad99_3 VSUBS 0.1f
Rl99_4 lad99_3 lad99_4 7.32
Cl99_4 lad99_4 VSUBS 0.1f
Rl99_5 lad99_4 lad99_5 9.54
Cl99_5 lad99_5 VSUBS 0.1f
Rl99_6 lad99_5 lad99_6 17.4
Cl99_6 lad99_6 VSUBS 0.1f
Rl99_7 lad99_6 lad99_7 14.9
Cl99_7 lad99_7 VSUBS 0.1f
Rl99_8 lad99_7 lad99_8 2.75
Cl99_8 lad99_8 VSUBS 0.1f
Rl99_9 lad99_8 lad99_9 7.92
Cl99_9 lad99_9 VSUBS 0.1f
Rl100_0 vdd lad100_0 15.1
Cl100_0 lad100_0 VSUBS 0.1f
Rl100_1 lad100_0 lad100_1 17.4
Cl100_1 lad100_1 VSUBS 0.1f
Rl100_2 lad100_1 lad100_2 7.09
Cl100_2 lad100_2 VSUBS 0.1f
Rl100_3 lad100_2 lad100_3 18.8
Cl100_3 lad100_3 VSUBS 0.1f
Rl100_4 lad100_3 lad100_4 19.9
Cl100_4 lad100_4 VSUBS 0.1f
Rl100_5 lad100_4 lad100_5 3.03
Cl100_5 lad100_5 VSUBS 0.1f
Rl100_6 lad100_5 lad100_6 16.3
Cl100_6 lad100_6 VSUBS 0.1f
Rl100_7 lad100_6 lad100_7 7.61
Cl100_7 lad100_7 VSUBS 0.1f
Rl100_8 lad100_7 lad100_8 5.24
Cl100_8 lad100_8 VSUBS 0.1f
Rl100_9 lad100_8 lad100_9 15.6
Cl100_9 lad100_9 VSUBS 0.1f
Rl101_0 xc4_dip lad101_0 9.87
Cl101_0 lad101_0 VSUBS 0.1f
Rl101_1 lad101_0 lad101_1 15.2
Cl101_1 lad101_1 VSUBS 0.1f
Rl101_2 lad101_1 lad101_2 9.78
Cl101_2 lad101_2 VSUBS 0.1f
Rl101_3 lad101_2 lad101_3 3.37
Cl101_3 lad101_3 VSUBS 0.1f
Rl101_4 lad101_3 lad101_4 1.81
Cl101_4 lad101_4 VSUBS 0.1f
Rl101_5 lad101_4 lad101_5 19.7
Cl101_5 lad101_5 VSUBS 0.1f
Rl101_6 lad101_5 lad101_6 1.37
Cl101_6 lad101_6 VSUBS 0.1f
Rl101_7 lad101_6 lad101_7 14
Cl101_7 lad101_7 VSUBS 0.1f
Rl101_8 lad101_7 lad101_8 17.6
Cl101_8 lad101_8 VSUBS 0.1f
Rl101_9 lad101_8 lad101_9 16.4
Cl101_9 lad101_9 VSUBS 0.1f
Rl102_0 bp3 lad102_0 14.6
Cl102_0 lad102_0 VSUBS 0.1f
Rl102_1 lad102_0 lad102_1 13.9
Cl102_1 lad102_1 VSUBS 0.1f
Rl102_2 lad102_1 lad102_2 18.7
Cl102_2 lad102_2 VSUBS 0.1f
Rl102_3 lad102_2 lad102_3 19.6
Cl102_3 lad102_3 VSUBS 0.1f
Rl102_4 lad102_3 lad102_4 17.7
Cl102_4 lad102_4 VSUBS 0.1f
Rl102_5 lad102_4 lad102_5 15
Cl102_5 lad102_5 VSUBS 0.1f
Rl102_6 lad102_5 lad102_6 9.06
Cl102_6 lad102_6 VSUBS 0.1f
Rl102_7 lad102_6 lad102_7 3.05
Cl102_7 lad102_7 VSUBS 0.1f
Rl102_8 lad102_7 lad102_8 11.2
Cl102_8 lad102_8 VSUBS 0.1f
Rl102_9 lad102_8 lad102_9 18.9
Cl102_9 lad102_9 VSUBS 0.1f
Rl103_0 on lad103_0 7.8
Cl103_0 lad103_0 VSUBS 0.1f
Rl103_1 lad103_0 lad103_1 6.58
Cl103_1 lad103_1 VSUBS 0.1f
Rl103_2 lad103_1 lad103_2 2.3
Cl103_2 lad103_2 VSUBS 0.1f
Rl103_3 lad103_2 lad103_3 9
Cl103_3 lad103_3 VSUBS 0.1f
Rl103_4 lad103_3 lad103_4 15
Cl103_4 lad103_4 VSUBS 0.1f
Rl103_5 lad103_4 lad103_5 2.07
Cl103_5 lad103_5 VSUBS 0.1f
Rl103_6 lad103_5 lad103_6 9.83
Cl103_6 lad103_6 VSUBS 0.1f
Rl103_7 lad103_6 lad103_7 2.9
Cl103_7 lad103_7 VSUBS 0.1f
Rl103_8 lad103_7 lad103_8 2.97
Cl103_8 lad103_8 VSUBS 0.1f
Rl103_9 lad103_8 lad103_9 14.6
Cl103_9 lad103_9 VSUBS 0.1f
Rl104_0 xc5_dip lad104_0 12.4
Cl104_0 lad104_0 VSUBS 0.1f
Rl104_1 lad104_0 lad104_1 8.17
Cl104_1 lad104_1 VSUBS 0.1f
Rl104_2 lad104_1 lad104_2 8.44
Cl104_2 lad104_2 VSUBS 0.1f
Rl104_3 lad104_2 lad104_3 8.5
Cl104_3 lad104_3 VSUBS 0.1f
Rl104_4 lad104_3 lad104_4 11.9
Cl104_4 lad104_4 VSUBS 0.1f
Rl104_5 lad104_4 lad104_5 3.07
Cl104_5 lad104_5 VSUBS 0.1f
Rl104_6 lad104_5 lad104_6 13.1
Cl104_6 lad104_6 VSUBS 0.1f
Rl104_7 lad104_6 lad104_7 5
Cl104_7 lad104_7 VSUBS 0.1f
Rl104_8 lad104_7 lad104_8 13.8
Cl104_8 lad104_8 VSUBS 0.1f
Rl104_9 lad104_8 lad104_9 14.4
Cl104_9 lad104_9 VSUBS 0.1f
Rl105_0 onp lad105_0 6.62
Cl105_0 lad105_0 VSUBS 0.1f
Rl105_1 lad105_0 lad105_1 7.67
Cl105_1 lad105_1 VSUBS 0.1f
Rl105_2 lad105_1 lad105_2 6.29
Cl105_2 lad105_2 VSUBS 0.1f
Rl105_3 lad105_2 lad105_3 3.83
Cl105_3 lad105_3 VSUBS 0.1f
Rl105_4 lad105_3 lad105_4 1.96
Cl105_4 lad105_4 VSUBS 0.1f
Rl105_5 lad105_4 lad105_5 8.42
Cl105_5 lad105_5 VSUBS 0.1f
Rl105_6 lad105_5 lad105_6 11.5
Cl105_6 lad105_6 VSUBS 0.1f
Rl105_7 lad105_6 lad105_7 9.77
Cl105_7 lad105_7 VSUBS 0.1f
Rl105_8 lad105_7 lad105_8 8.61
Cl105_8 lad105_8 VSUBS 0.1f
Rl105_9 lad105_8 lad105_9 1.65
Cl105_9 lad105_9 VSUBS 0.1f
Rl106_0 clkb lad106_0 10.6
Cl106_0 lad106_0 VSUBS 0.1f
Rl106_1 lad106_0 lad106_1 19.4
Cl106_1 lad106_1 VSUBS 0.1f
Rl106_2 lad106_1 lad106_2 10.7
Cl106_2 lad106_2 VSUBS 0.1f
Rl106_3 lad106_2 lad106_3 19.7
Cl106_3 lad106_3 VSUBS 0.1f
Rl106_4 lad106_3 lad106_4 4.59
Cl106_4 lad106_4 VSUBS 0.1f
Rl106_5 lad106_4 lad106_5 12.4
Cl106_5 lad106_5 VSUBS 0.1f
Rl106_6 lad106_5 lad106_6 10.1
Cl106_6 lad106_6 VSUBS 0.1f
Rl106_7 lad106_6 lad106_7 8.97
Cl106_7 lad106_7 VSUBS 0.1f
Rl106_8 lad106_7 lad106_8 8.69
Cl106_8 lad106_8 VSUBS 0.1f
Rl106_9 lad106_8 lad106_9 14.8
Cl106_9 lad106_9 VSUBS 0.1f
Rl107_0 xc5_xs1_tail lad107_0 5.54
Cl107_0 lad107_0 VSUBS 0.1f
Rl107_1 lad107_0 lad107_1 7.51
Cl107_1 lad107_1 VSUBS 0.1f
Rl107_2 lad107_1 lad107_2 18.4
Cl107_2 lad107_2 VSUBS 0.1f
Rl107_3 lad107_2 lad107_3 9.38
Cl107_3 lad107_3 VSUBS 0.1f
Rl107_4 lad107_3 lad107_4 2.12
Cl107_4 lad107_4 VSUBS 0.1f
Rl107_5 lad107_4 lad107_5 15.4
Cl107_5 lad107_5 VSUBS 0.1f
Rl107_6 lad107_5 lad107_6 19.6
Cl107_6 lad107_6 VSUBS 0.1f
Rl107_7 lad107_6 lad107_7 5.78
Cl107_7 lad107_7 VSUBS 0.1f
Rl107_8 lad107_7 lad107_8 1.19
Cl107_8 lad107_8 VSUBS 0.1f
Rl107_9 lad107_8 lad107_9 10.6
Cl107_9 lad107_9 VSUBS 0.1f
Rl108_0 bp9 lad108_0 17.1
Cl108_0 lad108_0 VSUBS 0.1f
Rl108_1 lad108_0 lad108_1 8.09
Cl108_1 lad108_1 VSUBS 0.1f
Rl108_2 lad108_1 lad108_2 11.9
Cl108_2 lad108_2 VSUBS 0.1f
Rl108_3 lad108_2 lad108_3 15.6
Cl108_3 lad108_3 VSUBS 0.1f
Rl108_4 lad108_3 lad108_4 10.2
Cl108_4 lad108_4 VSUBS 0.1f
Rl108_5 lad108_4 lad108_5 7.73
Cl108_5 lad108_5 VSUBS 0.1f
Rl108_6 lad108_5 lad108_6 13
Cl108_6 lad108_6 VSUBS 0.1f
Rl108_7 lad108_6 lad108_7 19.8
Cl108_7 lad108_7 VSUBS 0.1f
Rl108_8 lad108_7 lad108_8 15.4
Cl108_8 lad108_8 VSUBS 0.1f
Rl108_9 lad108_8 lad108_9 5.11
Cl108_9 lad108_9 VSUBS 0.1f
Rl109_0 cp6 lad109_0 12.2
Cl109_0 lad109_0 VSUBS 0.1f
Rl109_1 lad109_0 lad109_1 4.51
Cl109_1 lad109_1 VSUBS 0.1f
Rl109_2 lad109_1 lad109_2 2.23
Cl109_2 lad109_2 VSUBS 0.1f
Rl109_3 lad109_2 lad109_3 7.58
Cl109_3 lad109_3 VSUBS 0.1f
Rl109_4 lad109_3 lad109_4 15.5
Cl109_4 lad109_4 VSUBS 0.1f
Rl109_5 lad109_4 lad109_5 13.9
Cl109_5 lad109_5 VSUBS 0.1f
Rl109_6 lad109_5 lad109_6 2.12
Cl109_6 lad109_6 VSUBS 0.1f
Rl109_7 lad109_6 lad109_7 4.38
Cl109_7 lad109_7 VSUBS 0.1f
Rl109_8 lad109_7 lad109_8 19.7
Cl109_8 lad109_8 VSUBS 0.1f
Rl109_9 lad109_8 lad109_9 15.6
Cl109_9 lad109_9 VSUBS 0.1f
Rl110_0 onp lad110_0 13.8
Cl110_0 lad110_0 VSUBS 0.1f
Rl110_1 lad110_0 lad110_1 11.2
Cl110_1 lad110_1 VSUBS 0.1f
Rl110_2 lad110_1 lad110_2 2.48
Cl110_2 lad110_2 VSUBS 0.1f
Rl110_3 lad110_2 lad110_3 12.6
Cl110_3 lad110_3 VSUBS 0.1f
Rl110_4 lad110_3 lad110_4 9.93
Cl110_4 lad110_4 VSUBS 0.1f
Rl110_5 lad110_4 lad110_5 12.8
Cl110_5 lad110_5 VSUBS 0.1f
Rl110_6 lad110_5 lad110_6 18.9
Cl110_6 lad110_6 VSUBS 0.1f
Rl110_7 lad110_6 lad110_7 1.66
Cl110_7 lad110_7 VSUBS 0.1f
Rl110_8 lad110_7 lad110_8 4.76
Cl110_8 lad110_8 VSUBS 0.1f
Rl110_9 lad110_8 lad110_9 4.55
Cl110_9 lad110_9 VSUBS 0.1f
Rl111_0 rstb lad111_0 6.41
Cl111_0 lad111_0 VSUBS 0.1f
Rl111_1 lad111_0 lad111_1 1.43
Cl111_1 lad111_1 VSUBS 0.1f
Rl111_2 lad111_1 lad111_2 17.2
Cl111_2 lad111_2 VSUBS 0.1f
Rl111_3 lad111_2 lad111_3 9.02
Cl111_3 lad111_3 VSUBS 0.1f
Rl111_4 lad111_3 lad111_4 18.9
Cl111_4 lad111_4 VSUBS 0.1f
Rl111_5 lad111_4 lad111_5 18.5
Cl111_5 lad111_5 VSUBS 0.1f
Rl111_6 lad111_5 lad111_6 4.57
Cl111_6 lad111_6 VSUBS 0.1f
Rl111_7 lad111_6 lad111_7 2.04
Cl111_7 lad111_7 VSUBS 0.1f
Rl111_8 lad111_7 lad111_8 11.5
Cl111_8 lad111_8 VSUBS 0.1f
Rl111_9 lad111_8 lad111_9 5.44
Cl111_9 lad111_9 VSUBS 0.1f
Rl112_0 in0n lad112_0 16.8
Cl112_0 lad112_0 VSUBS 0.1f
Rl112_1 lad112_0 lad112_1 15
Cl112_1 lad112_1 VSUBS 0.1f
Rl112_2 lad112_1 lad112_2 3.69
Cl112_2 lad112_2 VSUBS 0.1f
Rl112_3 lad112_2 lad112_3 14.2
Cl112_3 lad112_3 VSUBS 0.1f
Rl112_4 lad112_3 lad112_4 6.86
Cl112_4 lad112_4 VSUBS 0.1f
Rl112_5 lad112_4 lad112_5 10.5
Cl112_5 lad112_5 VSUBS 0.1f
Rl112_6 lad112_5 lad112_6 2.5
Cl112_6 lad112_6 VSUBS 0.1f
Rl112_7 lad112_6 lad112_7 3.92
Cl112_7 lad112_7 VSUBS 0.1f
Rl112_8 lad112_7 lad112_8 1.39
Cl112_8 lad112_8 VSUBS 0.1f
Rl112_9 lad112_8 lad112_9 5.62
Cl112_9 lad112_9 VSUBS 0.1f
Rl113_0 bp10 lad113_0 14.8
Cl113_0 lad113_0 VSUBS 0.1f
Rl113_1 lad113_0 lad113_1 8.26
Cl113_1 lad113_1 VSUBS 0.1f
Rl113_2 lad113_1 lad113_2 8.45
Cl113_2 lad113_2 VSUBS 0.1f
Rl113_3 lad113_2 lad113_3 19.6
Cl113_3 lad113_3 VSUBS 0.1f
Rl113_4 lad113_3 lad113_4 7.03
Cl113_4 lad113_4 VSUBS 0.1f
Rl113_5 lad113_4 lad113_5 15.3
Cl113_5 lad113_5 VSUBS 0.1f
Rl113_6 lad113_5 lad113_6 13.7
Cl113_6 lad113_6 VSUBS 0.1f
Rl113_7 lad113_6 lad113_7 11.8
Cl113_7 lad113_7 VSUBS 0.1f
Rl113_8 lad113_7 lad113_8 17.4
Cl113_8 lad113_8 VSUBS 0.1f
Rl113_9 lad113_8 lad113_9 5.6
Cl113_9 lad113_9 VSUBS 0.1f
Rl114_0 op lad114_0 9.42
Cl114_0 lad114_0 VSUBS 0.1f
Rl114_1 lad114_0 lad114_1 9.49
Cl114_1 lad114_1 VSUBS 0.1f
Rl114_2 lad114_1 lad114_2 16.3
Cl114_2 lad114_2 VSUBS 0.1f
Rl114_3 lad114_2 lad114_3 3.26
Cl114_3 lad114_3 VSUBS 0.1f
Rl114_4 lad114_3 lad114_4 9.48
Cl114_4 lad114_4 VSUBS 0.1f
Rl114_5 lad114_4 lad114_5 2.39
Cl114_5 lad114_5 VSUBS 0.1f
Rl114_6 lad114_5 lad114_6 4.24
Cl114_6 lad114_6 VSUBS 0.1f
Rl114_7 lad114_6 lad114_7 13
Cl114_7 lad114_7 VSUBS 0.1f
Rl114_8 lad114_7 lad114_8 14.9
Cl114_8 lad114_8 VSUBS 0.1f
Rl114_9 lad114_8 lad114_9 17.1
Cl114_9 lad114_9 VSUBS 0.1f
Rl115_0 xc5_outnb lad115_0 11.4
Cl115_0 lad115_0 VSUBS 0.1f
Rl115_1 lad115_0 lad115_1 11.6
Cl115_1 lad115_1 VSUBS 0.1f
Rl115_2 lad115_1 lad115_2 6.64
Cl115_2 lad115_2 VSUBS 0.1f
Rl115_3 lad115_2 lad115_3 6.46
Cl115_3 lad115_3 VSUBS 0.1f
Rl115_4 lad115_3 lad115_4 2.22
Cl115_4 lad115_4 VSUBS 0.1f
Rl115_5 lad115_4 lad115_5 13.1
Cl115_5 lad115_5 VSUBS 0.1f
Rl115_6 lad115_5 lad115_6 19
Cl115_6 lad115_6 VSUBS 0.1f
Rl115_7 lad115_6 lad115_7 19.3
Cl115_7 lad115_7 VSUBS 0.1f
Rl115_8 lad115_7 lad115_8 8.01
Cl115_8 lad115_8 VSUBS 0.1f
Rl115_9 lad115_8 lad115_9 17
Cl115_9 lad115_9 VSUBS 0.1f
Rl116_0 cp6 lad116_0 3.67
Cl116_0 lad116_0 VSUBS 0.1f
Rl116_1 lad116_0 lad116_1 9.03
Cl116_1 lad116_1 VSUBS 0.1f
Rl116_2 lad116_1 lad116_2 4.19
Cl116_2 lad116_2 VSUBS 0.1f
Rl116_3 lad116_2 lad116_3 9.81
Cl116_3 lad116_3 VSUBS 0.1f
Rl116_4 lad116_3 lad116_4 9.86
Cl116_4 lad116_4 VSUBS 0.1f
Rl116_5 lad116_4 lad116_5 3.28
Cl116_5 lad116_5 VSUBS 0.1f
Rl116_6 lad116_5 lad116_6 7.66
Cl116_6 lad116_6 VSUBS 0.1f
Rl116_7 lad116_6 lad116_7 13.9
Cl116_7 lad116_7 VSUBS 0.1f
Rl116_8 lad116_7 lad116_8 10.5
Cl116_8 lad116_8 VSUBS 0.1f
Rl116_9 lad116_8 lad116_9 19.6
Cl116_9 lad116_9 VSUBS 0.1f
Rl117_0 xs0n_g lad117_0 7.7
Cl117_0 lad117_0 VSUBS 0.1f
Rl117_1 lad117_0 lad117_1 4.29
Cl117_1 lad117_1 VSUBS 0.1f
Rl117_2 lad117_1 lad117_2 8.96
Cl117_2 lad117_2 VSUBS 0.1f
Rl117_3 lad117_2 lad117_3 3.29
Cl117_3 lad117_3 VSUBS 0.1f
Rl117_4 lad117_3 lad117_4 7.72
Cl117_4 lad117_4 VSUBS 0.1f
Rl117_5 lad117_4 lad117_5 15.1
Cl117_5 lad117_5 VSUBS 0.1f
Rl117_6 lad117_5 lad117_6 17
Cl117_6 lad117_6 VSUBS 0.1f
Rl117_7 lad117_6 lad117_7 9.7
Cl117_7 lad117_7 VSUBS 0.1f
Rl117_8 lad117_7 lad117_8 16.5
Cl117_8 lad117_8 VSUBS 0.1f
Rl117_9 lad117_8 lad117_9 14.8
Cl117_9 lad117_9 VSUBS 0.1f
Rl118_0 xc5_dip lad118_0 6.41
Cl118_0 lad118_0 VSUBS 0.1f
Rl118_1 lad118_0 lad118_1 2.9
Cl118_1 lad118_1 VSUBS 0.1f
Rl118_2 lad118_1 lad118_2 19.3
Cl118_2 lad118_2 VSUBS 0.1f
Rl118_3 lad118_2 lad118_3 4.59
Cl118_3 lad118_3 VSUBS 0.1f
Rl118_4 lad118_3 lad118_4 18.2
Cl118_4 lad118_4 VSUBS 0.1f
Rl118_5 lad118_4 lad118_5 1.12
Cl118_5 lad118_5 VSUBS 0.1f
Rl118_6 lad118_5 lad118_6 6.44
Cl118_6 lad118_6 VSUBS 0.1f
Rl118_7 lad118_6 lad118_7 8.1
Cl118_7 lad118_7 VSUBS 0.1f
Rl118_8 lad118_7 lad118_8 11.9
Cl118_8 lad118_8 VSUBS 0.1f
Rl118_9 lad118_8 lad118_9 8.85
Cl118_9 lad118_9 VSUBS 0.1f
Rl119_0 lsb_p lad119_0 7.79
Cl119_0 lad119_0 VSUBS 0.1f
Rl119_1 lad119_0 lad119_1 11.2
Cl119_1 lad119_1 VSUBS 0.1f
Rl119_2 lad119_1 lad119_2 17.1
Cl119_2 lad119_2 VSUBS 0.1f
Rl119_3 lad119_2 lad119_3 18
Cl119_3 lad119_3 VSUBS 0.1f
Rl119_4 lad119_3 lad119_4 5.9
Cl119_4 lad119_4 VSUBS 0.1f
Rl119_5 lad119_4 lad119_5 7.31
Cl119_5 lad119_5 VSUBS 0.1f
Rl119_6 lad119_5 lad119_6 2.19
Cl119_6 lad119_6 VSUBS 0.1f
Rl119_7 lad119_6 lad119_7 6.02
Cl119_7 lad119_7 VSUBS 0.1f
Rl119_8 lad119_7 lad119_8 4.69
Cl119_8 lad119_8 VSUBS 0.1f
Rl119_9 lad119_8 lad119_9 6.11
Cl119_9 lad119_9 VSUBS 0.1f
Rl120_0 bp11 lad120_0 12.3
Cl120_0 lad120_0 VSUBS 0.1f
Rl120_1 lad120_0 lad120_1 12.7
Cl120_1 lad120_1 VSUBS 0.1f
Rl120_2 lad120_1 lad120_2 6.74
Cl120_2 lad120_2 VSUBS 0.1f
Rl120_3 lad120_2 lad120_3 9.76
Cl120_3 lad120_3 VSUBS 0.1f
Rl120_4 lad120_3 lad120_4 7.43
Cl120_4 lad120_4 VSUBS 0.1f
Rl120_5 lad120_4 lad120_5 2.21
Cl120_5 lad120_5 VSUBS 0.1f
Rl120_6 lad120_5 lad120_6 16.5
Cl120_6 lad120_6 VSUBS 0.1f
Rl120_7 lad120_6 lad120_7 18.2
Cl120_7 lad120_7 VSUBS 0.1f
Rl120_8 lad120_7 lad120_8 10.1
Cl120_8 lad120_8 VSUBS 0.1f
Rl120_9 lad120_8 lad120_9 5.41
Cl120_9 lad120_9 VSUBS 0.1f
Rl121_0 xs1p_cbp lad121_0 11.4
Cl121_0 lad121_0 VSUBS 0.1f
Rl121_1 lad121_0 lad121_1 16.4
Cl121_1 lad121_1 VSUBS 0.1f
Rl121_2 lad121_1 lad121_2 1.55
Cl121_2 lad121_2 VSUBS 0.1f
Rl121_3 lad121_2 lad121_3 3.09
Cl121_3 lad121_3 VSUBS 0.1f
Rl121_4 lad121_3 lad121_4 6.49
Cl121_4 lad121_4 VSUBS 0.1f
Rl121_5 lad121_4 lad121_5 1.26
Cl121_5 lad121_5 VSUBS 0.1f
Rl121_6 lad121_5 lad121_6 9.24
Cl121_6 lad121_6 VSUBS 0.1f
Rl121_7 lad121_6 lad121_7 4.21
Cl121_7 lad121_7 VSUBS 0.1f
Rl121_8 lad121_7 lad121_8 16.4
Cl121_8 lad121_8 VSUBS 0.1f
Rl121_9 lad121_8 lad121_9 3.22
Cl121_9 lad121_9 VSUBS 0.1f
Rl122_0 xs0n_n10 lad122_0 1.9
Cl122_0 lad122_0 VSUBS 0.1f
Rl122_1 lad122_0 lad122_1 11.6
Cl122_1 lad122_1 VSUBS 0.1f
Rl122_2 lad122_1 lad122_2 16.4
Cl122_2 lad122_2 VSUBS 0.1f
Rl122_3 lad122_2 lad122_3 9.42
Cl122_3 lad122_3 VSUBS 0.1f
Rl122_4 lad122_3 lad122_4 11.6
Cl122_4 lad122_4 VSUBS 0.1f
Rl122_5 lad122_4 lad122_5 14.7
Cl122_5 lad122_5 VSUBS 0.1f
Rl122_6 lad122_5 lad122_6 13.1
Cl122_6 lad122_6 VSUBS 0.1f
Rl122_7 lad122_6 lad122_7 4.53
Cl122_7 lad122_7 VSUBS 0.1f
Rl122_8 lad122_7 lad122_8 1.19
Cl122_8 lad122_8 VSUBS 0.1f
Rl122_9 lad122_8 lad122_9 5.98
Cl122_9 lad122_9 VSUBS 0.1f
Rl123_0 bn6 lad123_0 10
Cl123_0 lad123_0 VSUBS 0.1f
Rl123_1 lad123_0 lad123_1 7.51
Cl123_1 lad123_1 VSUBS 0.1f
Rl123_2 lad123_1 lad123_2 18.3
Cl123_2 lad123_2 VSUBS 0.1f
Rl123_3 lad123_2 lad123_3 4.52
Cl123_3 lad123_3 VSUBS 0.1f
Rl123_4 lad123_3 lad123_4 12.5
Cl123_4 lad123_4 VSUBS 0.1f
Rl123_5 lad123_4 lad123_5 13.7
Cl123_5 lad123_5 VSUBS 0.1f
Rl123_6 lad123_5 lad123_6 19.9
Cl123_6 lad123_6 VSUBS 0.1f
Rl123_7 lad123_6 lad123_7 2.37
Cl123_7 lad123_7 VSUBS 0.1f
Rl123_8 lad123_7 lad123_8 5.01
Cl123_8 lad123_8 VSUBS 0.1f
Rl123_9 lad123_8 lad123_9 15.6
Cl123_9 lad123_9 VSUBS 0.1f
Rl124_0 bn6 lad124_0 16.3
Cl124_0 lad124_0 VSUBS 0.1f
Rl124_1 lad124_0 lad124_1 14.4
Cl124_1 lad124_1 VSUBS 0.1f
Rl124_2 lad124_1 lad124_2 14.9
Cl124_2 lad124_2 VSUBS 0.1f
Rl124_3 lad124_2 lad124_3 17.1
Cl124_3 lad124_3 VSUBS 0.1f
Rl124_4 lad124_3 lad124_4 16.6
Cl124_4 lad124_4 VSUBS 0.1f
Rl124_5 lad124_4 lad124_5 9.87
Cl124_5 lad124_5 VSUBS 0.1f
Rl124_6 lad124_5 lad124_6 8.16
Cl124_6 lad124_6 VSUBS 0.1f
Rl124_7 lad124_6 lad124_7 9.33
Cl124_7 lad124_7 VSUBS 0.1f
Rl124_8 lad124_7 lad124_8 9.45
Cl124_8 lad124_8 VSUBS 0.1f
Rl124_9 lad124_8 lad124_9 15
Cl124_9 lad124_9 VSUBS 0.1f
Rl125_0 bp4 lad125_0 15.5
Cl125_0 lad125_0 VSUBS 0.1f
Rl125_1 lad125_0 lad125_1 2.88
Cl125_1 lad125_1 VSUBS 0.1f
Rl125_2 lad125_1 lad125_2 1.62
Cl125_2 lad125_2 VSUBS 0.1f
Rl125_3 lad125_2 lad125_3 7.35
Cl125_3 lad125_3 VSUBS 0.1f
Rl125_4 lad125_3 lad125_4 12.7
Cl125_4 lad125_4 VSUBS 0.1f
Rl125_5 lad125_4 lad125_5 13.4
Cl125_5 lad125_5 VSUBS 0.1f
Rl125_6 lad125_5 lad125_6 2.79
Cl125_6 lad125_6 VSUBS 0.1f
Rl125_7 lad125_6 lad125_7 10.6
Cl125_7 lad125_7 VSUBS 0.1f
Rl125_8 lad125_7 lad125_8 15.3
Cl125_8 lad125_8 VSUBS 0.1f
Rl125_9 lad125_8 lad125_9 6.85
Cl125_9 lad125_9 VSUBS 0.1f
Rl126_0 bp3 lad126_0 10.6
Cl126_0 lad126_0 VSUBS 0.1f
Rl126_1 lad126_0 lad126_1 11
Cl126_1 lad126_1 VSUBS 0.1f
Rl126_2 lad126_1 lad126_2 4.8
Cl126_2 lad126_2 VSUBS 0.1f
Rl126_3 lad126_2 lad126_3 4.89
Cl126_3 lad126_3 VSUBS 0.1f
Rl126_4 lad126_3 lad126_4 19.6
Cl126_4 lad126_4 VSUBS 0.1f
Rl126_5 lad126_4 lad126_5 2.32
Cl126_5 lad126_5 VSUBS 0.1f
Rl126_6 lad126_5 lad126_6 1.93
Cl126_6 lad126_6 VSUBS 0.1f
Rl126_7 lad126_6 lad126_7 17.4
Cl126_7 lad126_7 VSUBS 0.1f
Rl126_8 lad126_7 lad126_8 17.4
Cl126_8 lad126_8 VSUBS 0.1f
Rl126_9 lad126_8 lad126_9 18.5
Cl126_9 lad126_9 VSUBS 0.1f
Rl127_0 bp9 lad127_0 7.51
Cl127_0 lad127_0 VSUBS 0.1f
Rl127_1 lad127_0 lad127_1 3.07
Cl127_1 lad127_1 VSUBS 0.1f
Rl127_2 lad127_1 lad127_2 13.7
Cl127_2 lad127_2 VSUBS 0.1f
Rl127_3 lad127_2 lad127_3 14.4
Cl127_3 lad127_3 VSUBS 0.1f
Rl127_4 lad127_3 lad127_4 9.58
Cl127_4 lad127_4 VSUBS 0.1f
Rl127_5 lad127_4 lad127_5 18.9
Cl127_5 lad127_5 VSUBS 0.1f
Rl127_6 lad127_5 lad127_6 3.41
Cl127_6 lad127_6 VSUBS 0.1f
Rl127_7 lad127_6 lad127_7 11.6
Cl127_7 lad127_7 VSUBS 0.1f
Rl127_8 lad127_7 lad127_8 11.7
Cl127_8 lad127_8 VSUBS 0.1f
Rl127_9 lad127_8 lad127_9 3.33
Cl127_9 lad127_9 VSUBS 0.1f
Rl128_0 bp2 lad128_0 17.9
Cl128_0 lad128_0 VSUBS 0.1f
Rl128_1 lad128_0 lad128_1 6.66
Cl128_1 lad128_1 VSUBS 0.1f
Rl128_2 lad128_1 lad128_2 5.41
Cl128_2 lad128_2 VSUBS 0.1f
Rl128_3 lad128_2 lad128_3 4.62
Cl128_3 lad128_3 VSUBS 0.1f
Rl128_4 lad128_3 lad128_4 16.1
Cl128_4 lad128_4 VSUBS 0.1f
Rl128_5 lad128_4 lad128_5 3.75
Cl128_5 lad128_5 VSUBS 0.1f
Rl128_6 lad128_5 lad128_6 1.31
Cl128_6 lad128_6 VSUBS 0.1f
Rl128_7 lad128_6 lad128_7 3.17
Cl128_7 lad128_7 VSUBS 0.1f
Rl128_8 lad128_7 lad128_8 2.32
Cl128_8 lad128_8 VSUBS 0.1f
Rl128_9 lad128_8 lad128_9 5.28
Cl128_9 lad128_9 VSUBS 0.1f
Rl129_0 xs0n_cbn lad129_0 14.6
Cl129_0 lad129_0 VSUBS 0.1f
Rl129_1 lad129_0 lad129_1 15.2
Cl129_1 lad129_1 VSUBS 0.1f
Rl129_2 lad129_1 lad129_2 16.8
Cl129_2 lad129_2 VSUBS 0.1f
Rl129_3 lad129_2 lad129_3 15.4
Cl129_3 lad129_3 VSUBS 0.1f
Rl129_4 lad129_3 lad129_4 16.3
Cl129_4 lad129_4 VSUBS 0.1f
Rl129_5 lad129_4 lad129_5 11.8
Cl129_5 lad129_5 VSUBS 0.1f
Rl129_6 lad129_5 lad129_6 12.8
Cl129_6 lad129_6 VSUBS 0.1f
Rl129_7 lad129_6 lad129_7 9.3
Cl129_7 lad129_7 VSUBS 0.1f
Rl129_8 lad129_7 lad129_8 5.45
Cl129_8 lad129_8 VSUBS 0.1f
Rl129_9 lad129_8 lad129_9 13
Cl129_9 lad129_9 VSUBS 0.1f
Rl130_0 xs1n_n10 lad130_0 8.05
Cl130_0 lad130_0 VSUBS 0.1f
Rl130_1 lad130_0 lad130_1 20
Cl130_1 lad130_1 VSUBS 0.1f
Rl130_2 lad130_1 lad130_2 14.4
Cl130_2 lad130_2 VSUBS 0.1f
Rl130_3 lad130_2 lad130_3 3.54
Cl130_3 lad130_3 VSUBS 0.1f
Rl130_4 lad130_3 lad130_4 16.2
Cl130_4 lad130_4 VSUBS 0.1f
Rl130_5 lad130_4 lad130_5 5
Cl130_5 lad130_5 VSUBS 0.1f
Rl130_6 lad130_5 lad130_6 7.29
Cl130_6 lad130_6 VSUBS 0.1f
Rl130_7 lad130_6 lad130_7 8.25
Cl130_7 lad130_7 VSUBS 0.1f
Rl130_8 lad130_7 lad130_8 15.1
Cl130_8 lad130_8 VSUBS 0.1f
Rl130_9 lad130_8 lad130_9 2.75
Cl130_9 lad130_9 VSUBS 0.1f
Rl131_0 bn1 lad131_0 14.2
Cl131_0 lad131_0 VSUBS 0.1f
Rl131_1 lad131_0 lad131_1 19.1
Cl131_1 lad131_1 VSUBS 0.1f
Rl131_2 lad131_1 lad131_2 1.37
Cl131_2 lad131_2 VSUBS 0.1f
Rl131_3 lad131_2 lad131_3 16.5
Cl131_3 lad131_3 VSUBS 0.1f
Rl131_4 lad131_3 lad131_4 16.3
Cl131_4 lad131_4 VSUBS 0.1f
Rl131_5 lad131_4 lad131_5 18.4
Cl131_5 lad131_5 VSUBS 0.1f
Rl131_6 lad131_5 lad131_6 19.4
Cl131_6 lad131_6 VSUBS 0.1f
Rl131_7 lad131_6 lad131_7 2.02
Cl131_7 lad131_7 VSUBS 0.1f
Rl131_8 lad131_7 lad131_8 13.1
Cl131_8 lad131_8 VSUBS 0.1f
Rl131_9 lad131_8 lad131_9 10.5
Cl131_9 lad131_9 VSUBS 0.1f
Rl132_0 xs0n_g lad132_0 16.1
Cl132_0 lad132_0 VSUBS 0.1f
Rl132_1 lad132_0 lad132_1 1.98
Cl132_1 lad132_1 VSUBS 0.1f
Rl132_2 lad132_1 lad132_2 15.9
Cl132_2 lad132_2 VSUBS 0.1f
Rl132_3 lad132_2 lad132_3 13.3
Cl132_3 lad132_3 VSUBS 0.1f
Rl132_4 lad132_3 lad132_4 12
Cl132_4 lad132_4 VSUBS 0.1f
Rl132_5 lad132_4 lad132_5 19.7
Cl132_5 lad132_5 VSUBS 0.1f
Rl132_6 lad132_5 lad132_6 9.21
Cl132_6 lad132_6 VSUBS 0.1f
Rl132_7 lad132_6 lad132_7 1.59
Cl132_7 lad132_7 VSUBS 0.1f
Rl132_8 lad132_7 lad132_8 7.67
Cl132_8 lad132_8 VSUBS 0.1f
Rl132_9 lad132_8 lad132_9 16.3
Cl132_9 lad132_9 VSUBS 0.1f
Rl133_0 xs1n_n10 lad133_0 4.87
Cl133_0 lad133_0 VSUBS 0.1f
Rl133_1 lad133_0 lad133_1 2.14
Cl133_1 lad133_1 VSUBS 0.1f
Rl133_2 lad133_1 lad133_2 12.2
Cl133_2 lad133_2 VSUBS 0.1f
Rl133_3 lad133_2 lad133_3 17.9
Cl133_3 lad133_3 VSUBS 0.1f
Rl133_4 lad133_3 lad133_4 7.52
Cl133_4 lad133_4 VSUBS 0.1f
Rl133_5 lad133_4 lad133_5 16.3
Cl133_5 lad133_5 VSUBS 0.1f
Rl133_6 lad133_5 lad133_6 18.2
Cl133_6 lad133_6 VSUBS 0.1f
Rl133_7 lad133_6 lad133_7 9.87
Cl133_7 lad133_7 VSUBS 0.1f
Rl133_8 lad133_7 lad133_8 4.47
Cl133_8 lad133_8 VSUBS 0.1f
Rl133_9 lad133_8 lad133_9 4.64
Cl133_9 lad133_9 VSUBS 0.1f
Rl134_0 onp lad134_0 1.79
Cl134_0 lad134_0 VSUBS 0.1f
Rl134_1 lad134_0 lad134_1 7.43
Cl134_1 lad134_1 VSUBS 0.1f
Rl134_2 lad134_1 lad134_2 2.72
Cl134_2 lad134_2 VSUBS 0.1f
Rl134_3 lad134_2 lad134_3 1.24
Cl134_3 lad134_3 VSUBS 0.1f
Rl134_4 lad134_3 lad134_4 15.7
Cl134_4 lad134_4 VSUBS 0.1f
Rl134_5 lad134_4 lad134_5 3.48
Cl134_5 lad134_5 VSUBS 0.1f
Rl134_6 lad134_5 lad134_6 1.1
Cl134_6 lad134_6 VSUBS 0.1f
Rl134_7 lad134_6 lad134_7 17.6
Cl134_7 lad134_7 VSUBS 0.1f
Rl134_8 lad134_7 lad134_8 1.15
Cl134_8 lad134_8 VSUBS 0.1f
Rl134_9 lad134_8 lad134_9 6.81
Cl134_9 lad134_9 VSUBS 0.1f
Rl135_0 cn7 lad135_0 11.3
Cl135_0 lad135_0 VSUBS 0.1f
Rl135_1 lad135_0 lad135_1 3.33
Cl135_1 lad135_1 VSUBS 0.1f
Rl135_2 lad135_1 lad135_2 16.1
Cl135_2 lad135_2 VSUBS 0.1f
Rl135_3 lad135_2 lad135_3 1.03
Cl135_3 lad135_3 VSUBS 0.1f
Rl135_4 lad135_3 lad135_4 19.1
Cl135_4 lad135_4 VSUBS 0.1f
Rl135_5 lad135_4 lad135_5 16.5
Cl135_5 lad135_5 VSUBS 0.1f
Rl135_6 lad135_5 lad135_6 17
Cl135_6 lad135_6 VSUBS 0.1f
Rl135_7 lad135_6 lad135_7 18.3
Cl135_7 lad135_7 VSUBS 0.1f
Rl135_8 lad135_7 lad135_8 5.98
Cl135_8 lad135_8 VSUBS 0.1f
Rl135_9 lad135_8 lad135_9 7.07
Cl135_9 lad135_9 VSUBS 0.1f
Rl136_0 xs1n_n10 lad136_0 7.54
Cl136_0 lad136_0 VSUBS 0.1f
Rl136_1 lad136_0 lad136_1 8.83
Cl136_1 lad136_1 VSUBS 0.1f
Rl136_2 lad136_1 lad136_2 6.8
Cl136_2 lad136_2 VSUBS 0.1f
Rl136_3 lad136_2 lad136_3 12.4
Cl136_3 lad136_3 VSUBS 0.1f
Rl136_4 lad136_3 lad136_4 10.4
Cl136_4 lad136_4 VSUBS 0.1f
Rl136_5 lad136_4 lad136_5 13.1
Cl136_5 lad136_5 VSUBS 0.1f
Rl136_6 lad136_5 lad136_6 8.32
Cl136_6 lad136_6 VSUBS 0.1f
Rl136_7 lad136_6 lad136_7 16.8
Cl136_7 lad136_7 VSUBS 0.1f
Rl136_8 lad136_7 lad136_8 8.93
Cl136_8 lad136_8 VSUBS 0.1f
Rl136_9 lad136_8 lad136_9 1.66
Cl136_9 lad136_9 VSUBS 0.1f
Rl137_0 cn1 lad137_0 15
Cl137_0 lad137_0 VSUBS 0.1f
Rl137_1 lad137_0 lad137_1 11.2
Cl137_1 lad137_1 VSUBS 0.1f
Rl137_2 lad137_1 lad137_2 2.04
Cl137_2 lad137_2 VSUBS 0.1f
Rl137_3 lad137_2 lad137_3 7.75
Cl137_3 lad137_3 VSUBS 0.1f
Rl137_4 lad137_3 lad137_4 16
Cl137_4 lad137_4 VSUBS 0.1f
Rl137_5 lad137_4 lad137_5 1.07
Cl137_5 lad137_5 VSUBS 0.1f
Rl137_6 lad137_5 lad137_6 4.18
Cl137_6 lad137_6 VSUBS 0.1f
Rl137_7 lad137_6 lad137_7 13.6
Cl137_7 lad137_7 VSUBS 0.1f
Rl137_8 lad137_7 lad137_8 13
Cl137_8 lad137_8 VSUBS 0.1f
Rl137_9 lad137_8 lad137_9 16.8
Cl137_9 lad137_9 VSUBS 0.1f
Rl138_0 cp12 lad138_0 9.05
Cl138_0 lad138_0 VSUBS 0.1f
Rl138_1 lad138_0 lad138_1 6.12
Cl138_1 lad138_1 VSUBS 0.1f
Rl138_2 lad138_1 lad138_2 14.4
Cl138_2 lad138_2 VSUBS 0.1f
Rl138_3 lad138_2 lad138_3 19.1
Cl138_3 lad138_3 VSUBS 0.1f
Rl138_4 lad138_3 lad138_4 17.7
Cl138_4 lad138_4 VSUBS 0.1f
Rl138_5 lad138_4 lad138_5 6.38
Cl138_5 lad138_5 VSUBS 0.1f
Rl138_6 lad138_5 lad138_6 3.5
Cl138_6 lad138_6 VSUBS 0.1f
Rl138_7 lad138_6 lad138_7 1.26
Cl138_7 lad138_7 VSUBS 0.1f
Rl138_8 lad138_7 lad138_8 7.44
Cl138_8 lad138_8 VSUBS 0.1f
Rl138_9 lad138_8 lad138_9 18.2
Cl138_9 lad138_9 VSUBS 0.1f
Rl139_0 cn3 lad139_0 11.8
Cl139_0 lad139_0 VSUBS 0.1f
Rl139_1 lad139_0 lad139_1 3.76
Cl139_1 lad139_1 VSUBS 0.1f
Rl139_2 lad139_1 lad139_2 4.38
Cl139_2 lad139_2 VSUBS 0.1f
Rl139_3 lad139_2 lad139_3 2.98
Cl139_3 lad139_3 VSUBS 0.1f
Rl139_4 lad139_3 lad139_4 17.7
Cl139_4 lad139_4 VSUBS 0.1f
Rl139_5 lad139_4 lad139_5 12.6
Cl139_5 lad139_5 VSUBS 0.1f
Rl139_6 lad139_5 lad139_6 1.24
Cl139_6 lad139_6 VSUBS 0.1f
Rl139_7 lad139_6 lad139_7 2.19
Cl139_7 lad139_7 VSUBS 0.1f
Rl139_8 lad139_7 lad139_8 3.31
Cl139_8 lad139_8 VSUBS 0.1f
Rl139_9 lad139_8 lad139_9 11
Cl139_9 lad139_9 VSUBS 0.1f
Rl140_0 bp10 lad140_0 13.9
Cl140_0 lad140_0 VSUBS 0.1f
Rl140_1 lad140_0 lad140_1 3.53
Cl140_1 lad140_1 VSUBS 0.1f
Rl140_2 lad140_1 lad140_2 6.11
Cl140_2 lad140_2 VSUBS 0.1f
Rl140_3 lad140_2 lad140_3 9.4
Cl140_3 lad140_3 VSUBS 0.1f
Rl140_4 lad140_3 lad140_4 14
Cl140_4 lad140_4 VSUBS 0.1f
Rl140_5 lad140_4 lad140_5 14.2
Cl140_5 lad140_5 VSUBS 0.1f
Rl140_6 lad140_5 lad140_6 5.55
Cl140_6 lad140_6 VSUBS 0.1f
Rl140_7 lad140_6 lad140_7 17.5
Cl140_7 lad140_7 VSUBS 0.1f
Rl140_8 lad140_7 lad140_8 9.62
Cl140_8 lad140_8 VSUBS 0.1f
Rl140_9 lad140_8 lad140_9 8.7
Cl140_9 lad140_9 VSUBS 0.1f
Rl141_0 cn6 lad141_0 16.8
Cl141_0 lad141_0 VSUBS 0.1f
Rl141_1 lad141_0 lad141_1 7.38
Cl141_1 lad141_1 VSUBS 0.1f
Rl141_2 lad141_1 lad141_2 3.64
Cl141_2 lad141_2 VSUBS 0.1f
Rl141_3 lad141_2 lad141_3 15.7
Cl141_3 lad141_3 VSUBS 0.1f
Rl141_4 lad141_3 lad141_4 13.1
Cl141_4 lad141_4 VSUBS 0.1f
Rl141_5 lad141_4 lad141_5 14.8
Cl141_5 lad141_5 VSUBS 0.1f
Rl141_6 lad141_5 lad141_6 19.1
Cl141_6 lad141_6 VSUBS 0.1f
Rl141_7 lad141_6 lad141_7 17
Cl141_7 lad141_7 VSUBS 0.1f
Rl141_8 lad141_7 lad141_8 14.7
Cl141_8 lad141_8 VSUBS 0.1f
Rl141_9 lad141_8 lad141_9 4.33
Cl141_9 lad141_9 VSUBS 0.1f
Rl142_0 vbp lad142_0 3.02
Cl142_0 lad142_0 VSUBS 0.1f
Rl142_1 lad142_0 lad142_1 2.64
Cl142_1 lad142_1 VSUBS 0.1f
Rl142_2 lad142_1 lad142_2 13.9
Cl142_2 lad142_2 VSUBS 0.1f
Rl142_3 lad142_2 lad142_3 12.2
Cl142_3 lad142_3 VSUBS 0.1f
Rl142_4 lad142_3 lad142_4 5.83
Cl142_4 lad142_4 VSUBS 0.1f
Rl142_5 lad142_4 lad142_5 18.6
Cl142_5 lad142_5 VSUBS 0.1f
Rl142_6 lad142_5 lad142_6 5.43
Cl142_6 lad142_6 VSUBS 0.1f
Rl142_7 lad142_6 lad142_7 14.3
Cl142_7 lad142_7 VSUBS 0.1f
Rl142_8 lad142_7 lad142_8 12.5
Cl142_8 lad142_8 VSUBS 0.1f
Rl142_9 lad142_8 lad142_9 2.52
Cl142_9 lad142_9 VSUBS 0.1f
Rl143_0 xs1n_x lad143_0 5.89
Cl143_0 lad143_0 VSUBS 0.1f
Rl143_1 lad143_0 lad143_1 14.4
Cl143_1 lad143_1 VSUBS 0.1f
Rl143_2 lad143_1 lad143_2 18.6
Cl143_2 lad143_2 VSUBS 0.1f
Rl143_3 lad143_2 lad143_3 2.55
Cl143_3 lad143_3 VSUBS 0.1f
Rl143_4 lad143_3 lad143_4 19.7
Cl143_4 lad143_4 VSUBS 0.1f
Rl143_5 lad143_4 lad143_5 16.6
Cl143_5 lad143_5 VSUBS 0.1f
Rl143_6 lad143_5 lad143_6 2.29
Cl143_6 lad143_6 VSUBS 0.1f
Rl143_7 lad143_6 lad143_7 18.2
Cl143_7 lad143_7 VSUBS 0.1f
Rl143_8 lad143_7 lad143_8 7.96
Cl143_8 lad143_8 VSUBS 0.1f
Rl143_9 lad143_8 lad143_9 5.58
Cl143_9 lad143_9 VSUBS 0.1f
Rl144_0 bp6 lad144_0 11.9
Cl144_0 lad144_0 VSUBS 0.1f
Rl144_1 lad144_0 lad144_1 19.7
Cl144_1 lad144_1 VSUBS 0.1f
Rl144_2 lad144_1 lad144_2 3.54
Cl144_2 lad144_2 VSUBS 0.1f
Rl144_3 lad144_2 lad144_3 15.6
Cl144_3 lad144_3 VSUBS 0.1f
Rl144_4 lad144_3 lad144_4 3.36
Cl144_4 lad144_4 VSUBS 0.1f
Rl144_5 lad144_4 lad144_5 16
Cl144_5 lad144_5 VSUBS 0.1f
Rl144_6 lad144_5 lad144_6 4.17
Cl144_6 lad144_6 VSUBS 0.1f
Rl144_7 lad144_6 lad144_7 3.07
Cl144_7 lad144_7 VSUBS 0.1f
Rl144_8 lad144_7 lad144_8 2.36
Cl144_8 lad144_8 VSUBS 0.1f
Rl144_9 lad144_8 lad144_9 12
Cl144_9 lad144_9 VSUBS 0.1f
Rl145_0 cp6 lad145_0 16.5
Cl145_0 lad145_0 VSUBS 0.1f
Rl145_1 lad145_0 lad145_1 6.11
Cl145_1 lad145_1 VSUBS 0.1f
Rl145_2 lad145_1 lad145_2 12.1
Cl145_2 lad145_2 VSUBS 0.1f
Rl145_3 lad145_2 lad145_3 2.72
Cl145_3 lad145_3 VSUBS 0.1f
Rl145_4 lad145_3 lad145_4 16.3
Cl145_4 lad145_4 VSUBS 0.1f
Rl145_5 lad145_4 lad145_5 11.3
Cl145_5 lad145_5 VSUBS 0.1f
Rl145_6 lad145_5 lad145_6 5.96
Cl145_6 lad145_6 VSUBS 0.1f
Rl145_7 lad145_6 lad145_7 14.1
Cl145_7 lad145_7 VSUBS 0.1f
Rl145_8 lad145_7 lad145_8 9.95
Cl145_8 lad145_8 VSUBS 0.1f
Rl145_9 lad145_8 lad145_9 17.9
Cl145_9 lad145_9 VSUBS 0.1f
Rl146_0 rstb_n lad146_0 17.7
Cl146_0 lad146_0 VSUBS 0.1f
Rl146_1 lad146_0 lad146_1 11
Cl146_1 lad146_1 VSUBS 0.1f
Rl146_2 lad146_1 lad146_2 5.75
Cl146_2 lad146_2 VSUBS 0.1f
Rl146_3 lad146_2 lad146_3 1.69
Cl146_3 lad146_3 VSUBS 0.1f
Rl146_4 lad146_3 lad146_4 14
Cl146_4 lad146_4 VSUBS 0.1f
Rl146_5 lad146_4 lad146_5 6.16
Cl146_5 lad146_5 VSUBS 0.1f
Rl146_6 lad146_5 lad146_6 11.9
Cl146_6 lad146_6 VSUBS 0.1f
Rl146_7 lad146_6 lad146_7 7.93
Cl146_7 lad146_7 VSUBS 0.1f
Rl146_8 lad146_7 lad146_8 5.99
Cl146_8 lad146_8 VSUBS 0.1f
Rl146_9 lad146_8 lad146_9 3.39
Cl146_9 lad146_9 VSUBS 0.1f
Rl147_0 clkn lad147_0 1.34
Cl147_0 lad147_0 VSUBS 0.1f
Rl147_1 lad147_0 lad147_1 16.5
Cl147_1 lad147_1 VSUBS 0.1f
Rl147_2 lad147_1 lad147_2 1.85
Cl147_2 lad147_2 VSUBS 0.1f
Rl147_3 lad147_2 lad147_3 1.35
Cl147_3 lad147_3 VSUBS 0.1f
Rl147_4 lad147_3 lad147_4 12.4
Cl147_4 lad147_4 VSUBS 0.1f
Rl147_5 lad147_4 lad147_5 19
Cl147_5 lad147_5 VSUBS 0.1f
Rl147_6 lad147_5 lad147_6 15.2
Cl147_6 lad147_6 VSUBS 0.1f
Rl147_7 lad147_6 lad147_7 4.48
Cl147_7 lad147_7 VSUBS 0.1f
Rl147_8 lad147_7 lad147_8 18.6
Cl147_8 lad147_8 VSUBS 0.1f
Rl147_9 lad147_8 lad147_9 1.13
Cl147_9 lad147_9 VSUBS 0.1f
Rl148_0 clknb lad148_0 16.5
Cl148_0 lad148_0 VSUBS 0.1f
Rl148_1 lad148_0 lad148_1 9.68
Cl148_1 lad148_1 VSUBS 0.1f
Rl148_2 lad148_1 lad148_2 3.75
Cl148_2 lad148_2 VSUBS 0.1f
Rl148_3 lad148_2 lad148_3 11.6
Cl148_3 lad148_3 VSUBS 0.1f
Rl148_4 lad148_3 lad148_4 7.23
Cl148_4 lad148_4 VSUBS 0.1f
Rl148_5 lad148_4 lad148_5 10.3
Cl148_5 lad148_5 VSUBS 0.1f
Rl148_6 lad148_5 lad148_6 9.85
Cl148_6 lad148_6 VSUBS 0.1f
Rl148_7 lad148_6 lad148_7 14.4
Cl148_7 lad148_7 VSUBS 0.1f
Rl148_8 lad148_7 lad148_8 1.85
Cl148_8 lad148_8 VSUBS 0.1f
Rl148_9 lad148_8 lad148_9 8.67
Cl148_9 lad148_9 VSUBS 0.1f
Rl149_0 clk lad149_0 20
Cl149_0 lad149_0 VSUBS 0.1f
Rl149_1 lad149_0 lad149_1 10.9
Cl149_1 lad149_1 VSUBS 0.1f
Rl149_2 lad149_1 lad149_2 9.04
Cl149_2 lad149_2 VSUBS 0.1f
Rl149_3 lad149_2 lad149_3 1.05
Cl149_3 lad149_3 VSUBS 0.1f
Rl149_4 lad149_3 lad149_4 7.72
Cl149_4 lad149_4 VSUBS 0.1f
Rl149_5 lad149_4 lad149_5 18.5
Cl149_5 lad149_5 VSUBS 0.1f
Rl149_6 lad149_5 lad149_6 2.41
Cl149_6 lad149_6 VSUBS 0.1f
Rl149_7 lad149_6 lad149_7 7.55
Cl149_7 lad149_7 VSUBS 0.1f
Rl149_8 lad149_7 lad149_8 4.95
Cl149_8 lad149_8 VSUBS 0.1f
Rl149_9 lad149_8 lad149_9 5.45
Cl149_9 lad149_9 VSUBS 0.1f
