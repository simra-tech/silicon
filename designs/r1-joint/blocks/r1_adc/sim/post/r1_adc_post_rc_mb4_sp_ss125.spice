* r1_adc_post_rc_mb4_sp_ss125.spice: r1_adc_post_rc_mb4.spice with ideal slice references from op run postb4-op-ss125-rc (sim/post/make_sp_netlist.py)
* merged by sim/post/merge_parallel.py from ../../pex/r1_adc_post_rc_b4.spice (sha256 3b9e4d7a1ea280cb): 668 -> 295 device instances (identical parallel devices as m = count)
* r1_adc post-layout netlist, layout B (RC), written by pex/pex_build.py; see its docstring
* devices: LVS reference of layout/r1_adc_netlist.py; R: KLayout RNetExtractor Metal1-5/Via1-4; C: kpex 0.3.12 2.5D CC
* requires cornerMOSlv/hv.lib, cornerCAP.lib, cornerRES.lib
.subckt r1_adc_slice_post in0p in0n in1p in1n trk0 trk1 cp0 cp1 cp2 cp3 cp4 cp5 cp6 cp7 cp8 cp9 cp10 cp11 cp12 cn0 cn1 cn2 cn3 cn4 cn5 cn6 cn7 cn8 cn9 cn10 cn11 cn12 clk clkb clkn clknb op on onp onn vbp vbn vref vref__p11 vref__p12 vrefl vrefl__p19 top_p top_n vdd vdd__p36 vdd__p37 vdd__p38 gnd gnd__p59 gnd__p60 gnd__p61 gnd__p62 gnd__p63 gnd__p64 gnd__p65
Xxpt0a t0b__p7 trk0__p1 vdd__p12 vdd sg13_lv_pmos w=2u l=0.13u ng=1 m=1
Xxnt0a t0b__p4 trk0 gnd__p36 gnd sg13_lv_nmos w=1u l=0.13u ng=1 m=1
Xxpt0b t0__p5 t0b__p8 vdd__p13 vdd sg13_lv_pmos w=4u l=0.13u ng=1 m=1
Xxnt0b t0__p4 t0b__p5 gnd__p37 gnd sg13_lv_nmos w=2u l=0.13u ng=1 m=1
Xxpt1a t1b__p7 trk1__p1 vdd__p14 vdd sg13_lv_pmos w=2u l=0.13u ng=1 m=1
Xxnt1a t1b__p4 trk1 gnd__p38 gnd sg13_lv_nmos w=1u l=0.13u ng=1 m=1
Xxpt1b t1__p5 t1b__p8 vdd__p15 vdd sg13_lv_pmos w=4u l=0.13u ng=1 m=1
Xxnt1b t1__p4 t1b__p5 gnd__p39 gnd sg13_lv_nmos w=2u l=0.13u ng=1 m=1
Xxs0p_xms in0p__p0 xs0p_g top_p__p2 gnd sg13_lv_nmos w=6u l=0.13u ng=2 m=1
Xxs0p_cboot xs0p_cbp__p2 xs0p_cbn__p4 cap_cmim w=11.49u l=11.49u m=1
Xxs0p_xm1 xs0p_cbn__p1 t0b__p2 gnd__p30 gnd sg13_lv_nmos w=1u l=0.13u ng=1 m=1
Xxs0p_xm3 xs0p_cbp xs0p_g__p4 vdd__p4 xs0p_cbp sg13_lv_pmos w=1u l=0.13u ng=1 m=1
Xxs0p_xm8 xs0p_g__p5 xs0p_x__p2 xs0p_cbp__p1 xs0p_cbp sg13_lv_pmos w=2u l=0.13u ng=1 m=1
Xxs0p_xm4 xs0p_x__p3 t0__p3 vdd__p5 vdd sg13_lv_pmos w=0.5u l=0.13u ng=1 m=1
Xxs0p_xm5 xs0p_x t0__p2 xs0p_cbn__p2 gnd sg13_lv_nmos w=1u l=0.13u ng=1 m=1
Xxs0p_xm7 xs0p_x__p1 xs0p_g__p2 xs0p_cbn__p3 gnd sg13_lv_nmos w=0.5u l=0.13u ng=1 m=1
Xxs0p_xm9 xs0p_cbn xs0p_g__p1 in0p__p1 gnd sg13_lv_nmos w=2u l=0.13u ng=1 m=1
Xxs0p_xm10 xs0p_g__p3 vdd__p3 xs0p_n10 gnd sg13_lv_nmos w=2u l=0.13u ng=1 m=1
Xxs0p_xm11 xs0p_n10__p1 t0b__p3 gnd__p31 gnd sg13_lv_nmos w=2u l=0.13u ng=1 m=1
Xxs0n_xms in0n__p0 xs0n_g top_n__p2 gnd sg13_lv_nmos w=6u l=0.13u ng=2 m=1
Xxs0n_cboot xs0n_cbp__p2 xs0n_cbn__p4 cap_cmim w=11.49u l=11.49u m=1
Xxs0n_xm1 xs0n_cbn__p1 t0b gnd__p28 gnd sg13_lv_nmos w=1u l=0.13u ng=1 m=1
Xxs0n_xm3 xs0n_cbp xs0n_g__p4 vdd__p1 xs0n_cbp sg13_lv_pmos w=1u l=0.13u ng=1 m=1
Xxs0n_xm8 xs0n_g__p5 xs0n_x__p2 xs0n_cbp__p1 xs0n_cbp sg13_lv_pmos w=2u l=0.13u ng=1 m=1
Xxs0n_xm4 xs0n_x__p3 t0__p1 vdd__p2 vdd sg13_lv_pmos w=0.5u l=0.13u ng=1 m=1
Xxs0n_xm5 xs0n_x t0 xs0n_cbn__p2 gnd sg13_lv_nmos w=1u l=0.13u ng=1 m=1
Xxs0n_xm7 xs0n_x__p1 xs0n_g__p2 xs0n_cbn__p3 gnd sg13_lv_nmos w=0.5u l=0.13u ng=1 m=1
Xxs0n_xm9 xs0n_cbn xs0n_g__p1 in0n__p1 gnd sg13_lv_nmos w=2u l=0.13u ng=1 m=1
Xxs0n_xm10 xs0n_g__p3 vdd__p0 xs0n_n10 gnd sg13_lv_nmos w=2u l=0.13u ng=1 m=1
Xxs0n_xm11 xs0n_n10__p1 t0b__p1 gnd__p29 gnd sg13_lv_nmos w=2u l=0.13u ng=1 m=1
Xxs1p_xms in1p__p0 xs1p_g top_p__p3 gnd sg13_lv_nmos w=6u l=0.13u ng=2 m=1
Xxs1p_cboot xs1p_cbp__p2 xs1p_cbn__p4 cap_cmim w=11.49u l=11.49u m=1
Xxs1p_xm1 xs1p_cbn__p1 t1b__p2 gnd__p34 gnd sg13_lv_nmos w=1u l=0.13u ng=1 m=1
Xxs1p_xm3 xs1p_cbp xs1p_g__p4 vdd__p10 xs1p_cbp sg13_lv_pmos w=1u l=0.13u ng=1 m=1
Xxs1p_xm8 xs1p_g__p5 xs1p_x__p2 xs1p_cbp__p1 xs1p_cbp sg13_lv_pmos w=2u l=0.13u ng=1 m=1
Xxs1p_xm4 xs1p_x__p3 t1__p3 vdd__p11 vdd sg13_lv_pmos w=0.5u l=0.13u ng=1 m=1
Xxs1p_xm5 xs1p_x t1__p2 xs1p_cbn__p2 gnd sg13_lv_nmos w=1u l=0.13u ng=1 m=1
Xxs1p_xm7 xs1p_x__p1 xs1p_g__p2 xs1p_cbn__p3 gnd sg13_lv_nmos w=0.5u l=0.13u ng=1 m=1
Xxs1p_xm9 xs1p_cbn xs1p_g__p1 in1p__p1 gnd sg13_lv_nmos w=2u l=0.13u ng=1 m=1
Xxs1p_xm10 xs1p_g__p3 vdd__p9 xs1p_n10 gnd sg13_lv_nmos w=2u l=0.13u ng=1 m=1
Xxs1p_xm11 xs1p_n10__p1 t1b__p3 gnd__p35 gnd sg13_lv_nmos w=2u l=0.13u ng=1 m=1
Xxs1n_xms in1n__p0 xs1n_g top_n__p3 gnd sg13_lv_nmos w=6u l=0.13u ng=2 m=1
Xxs1n_cboot xs1n_cbp__p2 xs1n_cbn__p4 cap_cmim w=11.49u l=11.49u m=1
Xxs1n_xm1 xs1n_cbn__p1 t1b gnd__p32 gnd sg13_lv_nmos w=1u l=0.13u ng=1 m=1
Xxs1n_xm3 xs1n_cbp xs1n_g__p4 vdd__p7 xs1n_cbp sg13_lv_pmos w=1u l=0.13u ng=1 m=1
Xxs1n_xm8 xs1n_g__p5 xs1n_x__p2 xs1n_cbp__p1 xs1n_cbp sg13_lv_pmos w=2u l=0.13u ng=1 m=1
Xxs1n_xm4 xs1n_x__p3 t1__p1 vdd__p8 vdd sg13_lv_pmos w=0.5u l=0.13u ng=1 m=1
Xxs1n_xm5 xs1n_x t1 xs1n_cbn__p2 gnd sg13_lv_nmos w=1u l=0.13u ng=1 m=1
Xxs1n_xm7 xs1n_x__p1 xs1n_g__p2 xs1n_cbn__p3 gnd sg13_lv_nmos w=0.5u l=0.13u ng=1 m=1
Xxs1n_xm9 xs1n_cbn xs1n_g__p1 in1n__p1 gnd sg13_lv_nmos w=2u l=0.13u ng=1 m=1
Xxs1n_xm10 xs1n_g__p3 vdd__p6 xs1n_n10 gnd sg13_lv_nmos w=2u l=0.13u ng=1 m=1
Xxs1n_xm11 xs1n_n10__p1 t1b__p1 gnd__p33 gnd sg13_lv_nmos w=2u l=0.13u ng=1 m=1
Xxpr1 rstb_n__p2 t0b__p9 vdd__p16 vdd sg13_lv_pmos w=1u l=0.13u ng=1 m=1
Xxpr2 rstb_n__p3 t1b__p9 vdd__p17 vdd sg13_lv_pmos w=1u l=0.13u ng=1 m=1
Xxnr1 rstb_n t0b__p6 nr gnd sg13_lv_nmos w=1u l=0.13u ng=1 m=1
Xxnr2 nr__p1 t1b__p6 gnd__p40 gnd sg13_lv_nmos w=1u l=0.13u ng=1 m=1
Xxpr3 rstb__p3 rstb_n__p4 vdd__p18 vdd sg13_lv_pmos w=1u l=0.13u ng=1 m=1
Xxnr3 rstb__p2 rstb_n__p1 gnd__p41 gnd sg13_lv_nmos w=0.5u l=0.13u ng=1 m=1
Xxlrp lsb_p rstb__p1 vrefl__p9 vrefl sg13_lv_pmos w=1u l=0.13u ng=1 m=1
Xxlrn lsb_n rstb vrefl__p8 vrefl sg13_lv_pmos w=1u l=0.13u ng=1 m=1
Xxdp12_xmp bp12 cp12 vref__p5 vref sg13_lv_pmos w=2u l=0.13u ng=1 m=1
Xxdp12_xmn bp12__p1 cp12__p1 gnd__p13 gnd sg13_lv_nmos w=1u l=0.13u ng=1 m=1
Xxdp11_xmp bp11 cp11 vref__p6 vref sg13_lv_pmos w=2u l=0.13u ng=1 m=1
Xxdp11_xmn bp11__p1 cp11__p1 gnd__p14 gnd sg13_lv_nmos w=1u l=0.13u ng=1 m=1
Xxdp10_xmp bp10 cp10 vref__p7 vref sg13_lv_pmos w=2u l=0.13u ng=1 m=1
Xxdp10_xmn bp10__p1 cp10__p1 gnd__p15 gnd sg13_lv_nmos w=1u l=0.13u ng=1 m=1
Xxdp9_xmp bp9 cp9 vref__p8 vref sg13_lv_pmos w=1u l=0.13u ng=1 m=1
Xxdp9_xmn bp9__p1 cp9__p1 gnd__p16 gnd sg13_lv_nmos w=0.5u l=0.13u ng=1 m=1
Xxdp8_xmp bp8 cp8 vref__p9 vref sg13_lv_pmos w=1u l=0.13u ng=1 m=1
Xxdp8_xmn bp8__p1 cp8__p1 gnd__p17 gnd sg13_lv_nmos w=0.5u l=0.13u ng=1 m=1
Xxdp7_xmp bp7 cp7 vrefl__p10 vrefl sg13_lv_pmos w=1u l=0.13u ng=1 m=1
Xxdp7_xmn bp7__p1 cp7__p1 gnd__p18 gnd sg13_lv_nmos w=0.5u l=0.13u ng=1 m=1
Xxdp6_xmp bp6 cp6 vrefl__p11 vrefl sg13_lv_pmos w=1u l=0.13u ng=1 m=1
Xxdp6_xmn bp6__p1 cp6__p1 gnd__p19 gnd sg13_lv_nmos w=0.5u l=0.13u ng=1 m=1
Xxdp5_xmp bp5 cp5 vrefl__p12 vrefl sg13_lv_pmos w=1u l=0.13u ng=1 m=1
Xxdp5_xmn bp5__p1 cp5__p1 gnd__p20 gnd sg13_lv_nmos w=0.5u l=0.13u ng=1 m=1
Xxdp4_xmp bp4 cp4 vrefl__p13 vrefl sg13_lv_pmos w=1u l=0.13u ng=1 m=1
Xxdp4_xmn bp4__p1 cp4__p1 gnd__p21 gnd sg13_lv_nmos w=0.5u l=0.13u ng=1 m=1
Xxdp3_xmp bp3 cp3 vrefl__p14 vrefl sg13_lv_pmos w=1u l=0.13u ng=1 m=1
Xxdp3_xmn bp3__p1 cp3__p1 gnd__p22 gnd sg13_lv_nmos w=0.5u l=0.13u ng=1 m=1
Xxdp2_xmp bp2 cp2 vrefl__p15 vrefl sg13_lv_pmos w=1u l=0.13u ng=1 m=1
Xxdp2_xmn bp2__p1 cp2__p1 gnd__p23 gnd sg13_lv_nmos w=0.5u l=0.13u ng=1 m=1
Xxdp1_xmp bp1 cp1 vrefl__p16 vrefl sg13_lv_pmos w=1u l=0.13u ng=1 m=1
Xxdp1_xmn bp1__p1 cp1__p1 gnd__p24 gnd sg13_lv_nmos w=0.5u l=0.13u ng=1 m=1
Xxdp0_xmp bp0 cp0 vrefl__p17 vrefl sg13_lv_pmos w=1u l=0.13u ng=1 m=1
Xxdp0_xmn bp0__p1 cp0__p1 gnd__p25 gnd sg13_lv_nmos w=0.5u l=0.13u ng=1 m=1
Xxdn12_xmp bn12 cn12 vref__p4 vref sg13_lv_pmos w=2u l=0.13u ng=1 m=1
Xxdn12_xmn bn12__p1 cn12__p1 gnd__p12 gnd sg13_lv_nmos w=1u l=0.13u ng=1 m=1
Xxdn11_xmp bn11 cn11 vref__p3 vref sg13_lv_pmos w=2u l=0.13u ng=1 m=1
Xxdn11_xmn bn11__p1 cn11__p1 gnd__p11 gnd sg13_lv_nmos w=1u l=0.13u ng=1 m=1
Xxdn10_xmp bn10 cn10 vref__p2 vref sg13_lv_pmos w=2u l=0.13u ng=1 m=1
Xxdn10_xmn bn10__p1 cn10__p1 gnd__p10 gnd sg13_lv_nmos w=1u l=0.13u ng=1 m=1
Xxdn9_xmp bn9 cn9 vref__p1 vref sg13_lv_pmos w=1u l=0.13u ng=1 m=1
Xxdn9_xmn bn9__p1 cn9__p1 gnd__p9 gnd sg13_lv_nmos w=0.5u l=0.13u ng=1 m=1
Xxdn8_xmp bn8 cn8 vref__p0 vref sg13_lv_pmos w=1u l=0.13u ng=1 m=1
Xxdn8_xmn bn8__p1 cn8__p1 gnd__p8 gnd sg13_lv_nmos w=0.5u l=0.13u ng=1 m=1
Xxdn7_xmp bn7 cn7 vrefl__p7 vrefl sg13_lv_pmos w=1u l=0.13u ng=1 m=1
Xxdn7_xmn bn7__p1 cn7__p1 gnd__p7 gnd sg13_lv_nmos w=0.5u l=0.13u ng=1 m=1
Xxdn6_xmp bn6 cn6 vrefl__p6 vrefl sg13_lv_pmos w=1u l=0.13u ng=1 m=1
Xxdn6_xmn bn6__p1 cn6__p1 gnd__p6 gnd sg13_lv_nmos w=0.5u l=0.13u ng=1 m=1
Xxdn5_xmp bn5 cn5 vrefl__p5 vrefl sg13_lv_pmos w=1u l=0.13u ng=1 m=1
Xxdn5_xmn bn5__p1 cn5__p1 gnd__p5 gnd sg13_lv_nmos w=0.5u l=0.13u ng=1 m=1
Xxdn4_xmp bn4 cn4 vrefl__p4 vrefl sg13_lv_pmos w=1u l=0.13u ng=1 m=1
Xxdn4_xmn bn4__p1 cn4__p1 gnd__p4 gnd sg13_lv_nmos w=0.5u l=0.13u ng=1 m=1
Xxdn3_xmp bn3 cn3 vrefl__p3 vrefl sg13_lv_pmos w=1u l=0.13u ng=1 m=1
Xxdn3_xmn bn3__p1 cn3__p1 gnd__p3 gnd sg13_lv_nmos w=0.5u l=0.13u ng=1 m=1
Xxdn2_xmp bn2 cn2 vrefl__p2 vrefl sg13_lv_pmos w=1u l=0.13u ng=1 m=1
Xxdn2_xmn bn2__p1 cn2__p1 gnd__p2 gnd sg13_lv_nmos w=0.5u l=0.13u ng=1 m=1
Xxdn1_xmp bn1 cn1 vrefl__p1 vrefl sg13_lv_pmos w=1u l=0.13u ng=1 m=1
Xxdn1_xmn bn1__p1 cn1__p1 gnd__p1 gnd sg13_lv_nmos w=0.5u l=0.13u ng=1 m=1
Xxdn0_xmp bn0 cn0 vrefl__p0 vrefl sg13_lv_pmos w=1u l=0.13u ng=1 m=1
Xxdn0_xmn bn0__p1 cn0__p1 gnd__p0 gnd sg13_lv_nmos w=0.5u l=0.13u ng=1 m=1
Xxc4_xs1_xmt1 xc4_xs1_tail0 clkb__p2 vdd__p28 vdd sg13_lv_pmos w=16u l=0.13u ng=4 m=1
Xxc4_xs1_xmtc xc4_xs1_tail__p2 vbp xc4_xs1_tail0__p1 vdd sg13_lv_pmos w=16u l=0.5u ng=4 m=1
Xxc4_xs1_xm1 xc4_dip top_p__p4 xc4_xs1_tail vdd sg13_lv_pmos w=48u l=0.3u ng=12 m=1
Xxc4_xs1_xm2 xc4_din top_n__p4 xc4_xs1_tail__p1 vdd sg13_lv_pmos w=48u l=0.3u ng=12 m=1
Xxc4_xci1 vdd__p23 xc4_dip vdd__p22 vdd sg13_lv_pmos w=80u l=4u ng=8 m=1
Xxc4_xci2 vdd__p25 xc4_din vdd__p24 vdd sg13_lv_pmos w=80u l=4u ng=8 m=1
Xxc4_xmr1 xc4_dip__p1 clkb gnd__p49 gnd sg13_lv_nmos w=20u l=0.13u ng=2 m=1
Xxc4_xmr2 xc4_din__p1 clkb__p1 gnd__p50 gnd sg13_lv_nmos w=20u l=0.13u ng=2 m=1
Xxc4_xmt2 xc4_lt clk gnd__p55 gnd sg13_lv_nmos w=4u l=0.13u ng=1 m=1
Xxc4_xmn1 op on xc4_lt__p1 gnd sg13_lv_nmos w=2u l=0.13u ng=1 m=1
Xxc4_xmn2 on__p1 op__p1 xc4_lt__p2 gnd sg13_lv_nmos w=2u l=0.13u ng=1 m=1
Xxc4_xmp1 op__p4 on__p4 vdd__p31 vdd sg13_lv_pmos w=2u l=0.13u ng=1 m=1
Xxc4_xmp2 on__p5 op__p5 vdd__p32 vdd sg13_lv_pmos w=2u l=0.13u ng=1 m=1
Xxc4_xmh1 op__p3 xc4_dip__p2 vdd__p29 vdd sg13_lv_pmos w=8u l=0.13u ng=2 m=1
Xxc4_xmh2 on__p3 xc4_din__p2 vdd__p30 vdd sg13_lv_pmos w=8u l=0.13u ng=2 m=1
Xxc4_xbp1 xc4_outpb__p1 op__p6 vdd__p33 vdd sg13_lv_pmos w=1u l=0.13u ng=1 m=1
Xxc4_xbn1 xc4_outpb op__p2 gnd__p56 gnd sg13_lv_nmos w=0.5u l=0.13u ng=1 m=1
Xxc4_xbp2 xc4_outnb__p1 on__p6 vdd__p34 vdd sg13_lv_pmos w=1u l=0.13u ng=1 m=1
Xxc4_xbn2 xc4_outnb on__p2 gnd__p57 gnd sg13_lv_nmos w=0.5u l=0.13u ng=1 m=1
Xxc5_xs1_xmt1 xc5_xs1_tail0 clkn__p2 gnd__p46 gnd sg13_lv_nmos w=8u l=0.13u ng=2 m=1
Xxc5_xs1_xmtc xc5_xs1_tail vbn xc5_xs1_tail0__p1 gnd sg13_lv_nmos w=4u l=0.5u ng=1 m=1
Xxc5_xs1_xm1 xc5_dip__p2 top_p xc5_xs1_tail__p1 gnd sg13_lv_nmos w=16u l=0.5u ng=4 m=1
Xxc5_xs1_xm2 xc5_din__p2 top_n xc5_xs1_tail__p2 gnd sg13_lv_nmos w=16u l=0.5u ng=4 m=1
Xxc5_xci1 gnd__p43 xc5_dip gnd__p42 gnd sg13_lv_nmos w=30u l=4u ng=4 m=1
Xxc5_xci2 gnd__p45 xc5_din gnd__p44 gnd sg13_lv_nmos w=30u l=4u ng=4 m=1
Xxc5_xmr1 xc5_dip clkn vdd__p19 vdd sg13_lv_pmos w=16u l=0.13u ng=2 m=1
Xxc5_xmr2 xc5_din clkn__p1 vdd__p20 vdd sg13_lv_pmos w=16u l=0.13u ng=2 m=1
Xxc5_xmt2 xc5_lt clknb vdd__p21 vdd sg13_lv_pmos w=8u l=0.13u ng=1 m=1
Xxc5_xmp1 onp__p4 onn__p4 xc5_lt__p1 vdd sg13_lv_pmos w=4u l=0.13u ng=1 m=1
Xxc5_xmp2 onn__p5 onp__p5 xc5_lt__p2 vdd sg13_lv_pmos w=4u l=0.13u ng=1 m=1
Xxc5_xmn1 onp__p1 onn__p1 gnd__p51 gnd sg13_lv_nmos w=1u l=0.13u ng=1 m=1
Xxc5_xmn2 onn__p2 onp__p2 gnd__p52 gnd sg13_lv_nmos w=1u l=0.13u ng=1 m=1
Xxc5_xmh1 onp xc5_dip__p1 gnd__p47 gnd sg13_lv_nmos w=8u l=0.13u ng=1 m=1
Xxc5_xmh2 onn xc5_din__p1 gnd__p48 gnd sg13_lv_nmos w=8u l=0.13u ng=1 m=1
Xxc5_xbp1 xc5_outpb__p1 onp__p6 vdd__p26 vdd sg13_lv_pmos w=1u l=0.13u ng=1 m=1
Xxc5_xbn1 xc5_outpb onp__p3 gnd__p53 gnd sg13_lv_nmos w=0.5u l=0.13u ng=1 m=1
Xxc5_xbp2 xc5_outnb__p1 onn__p6 vdd__p27 vdd sg13_lv_pmos w=1u l=0.13u ng=1 m=1
Xxc5_xbn2 xc5_outnb onn__p3 gnd__p54 gnd sg13_lv_nmos w=0.5u l=0.13u ng=1 m=1
Xxdacp_xc12_u0 top_p__p1 bp12__p2 cap_cmim w=3.78u l=3.78u m=16
Xxdacp_xc11_u0 top_p__p1 bp11__p2 cap_cmim w=3.78u l=3.78u m=8
Xxdacp_xc10_u0 top_p__p1 bp10__p2 cap_cmim w=3.78u l=3.78u m=4
Xxdacp_xc9_u0 top_p__p1 bp9__p2 cap_cmim w=3.78u l=3.78u m=2
Xxdacp_xc8_u0 top_p__p1 bp8__p2 cap_cmim w=3.78u l=3.78u m=1
Xxdacp_xcb top_p__p1 lsb_p__p1 cap_cmim w=4.23u l=4.23u m=1
Xxdacp_xc7_u0 lsb_p__p1 bp7__p2 cap_cmim w=3.78u l=3.78u m=64
Xxdacp_xc6_u0 lsb_p__p1 bp6__p2 cap_cmim w=3.78u l=3.78u m=32
Xxdacp_xc5_u0 lsb_p__p1 bp5__p2 cap_cmim w=3.78u l=3.78u m=16
Xxdacp_xc4_u0 lsb_p__p1 bp4__p2 cap_cmim w=3.78u l=3.78u m=8
Xxdacp_xc3_u0 lsb_p__p1 bp3__p2 cap_cmim w=3.78u l=3.78u m=4
Xxdacp_xc2_u0 lsb_p__p1 bp2__p2 cap_cmim w=3.78u l=3.78u m=2
Xxdacp_xc1_u0 lsb_p__p1 bp1__p2 cap_cmim w=3.78u l=3.78u m=1
Xxdacp_xc0 lsb_p__p1 bp0__p2 cap_cmim w=2.67u l=2.67u m=1
Xxdacn_xc12_u0 top_n__p1 bn12__p2 cap_cmim w=3.78u l=3.78u m=16
Xxdacn_xc11_u0 top_n__p1 bn11__p2 cap_cmim w=3.78u l=3.78u m=8
Xxdacn_xc10_u0 top_n__p1 bn10__p2 cap_cmim w=3.78u l=3.78u m=4
Xxdacn_xc9_u0 top_n__p1 bn9__p2 cap_cmim w=3.78u l=3.78u m=2
Xxdacn_xc8_u0 top_n__p1 bn8__p2 cap_cmim w=3.78u l=3.78u m=1
Xxdacn_xcb top_n__p1 lsb_n__p1 cap_cmim w=4.23u l=4.23u m=1
Xxdacn_xc7_u0 lsb_n__p1 bn7__p2 cap_cmim w=3.78u l=3.78u m=64
Xxdacn_xc6_u0 lsb_n__p1 bn6__p2 cap_cmim w=3.78u l=3.78u m=32
Xxdacn_xc5_u0 lsb_n__p1 bn5__p2 cap_cmim w=3.78u l=3.78u m=16
Xxdacn_xc4_u0 lsb_n__p1 bn4__p2 cap_cmim w=3.78u l=3.78u m=8
Xxdacn_xc3_u0 lsb_n__p1 bn3__p2 cap_cmim w=3.78u l=3.78u m=4
Xxdacn_xc2_u0 lsb_n__p1 bn2__p2 cap_cmim w=3.78u l=3.78u m=2
Xxdacn_xc1_u0 lsb_n__p1 bn1__p2 cap_cmim w=3.78u l=3.78u m=1
Xxdacn_xc0 lsb_n__p1 bn0__p2 cap_cmim w=2.67u l=2.67u m=1
Xxdmy_u0 gnd__p27 gnd__p27 cap_cmim w=3.78u l=3.78u m=82
Cld_xc4_outpb xc4_outpb gnd 3f
Cld_xc4_outnb xc4_outnb gnd 3f
Cld_xc5_outpb xc5_outpb gnd 3f
Cld_xc5_outnb xc5_outnb gnd 3f
Rw0 bn0 bn0__p1 30.5072
Rw1 bn0 bn0__p2 26.3744
Rw2 bn0__p1 bn0__p2 32.1711
Rw3 bn1 bn1__p1 30.9128
Rw4 bn1 bn1__p2 26.3943
Rw5 bn1__p1 bn1__p2 31.4474
Rw6 bn10 bn10__p1 39.3614
Rw7 bn10 bn10__p2 18.5632
Rw8 bn11 bn11__p1 70.3916
Rw9 bn11 bn11__p2 21.1283
Rw10 bn11__p1 bn11__p2 70.2615
Rw11 bn12 bn12__p1 34.5729
Rw12 bn12 bn12__p2 25.0457
Rw13 bn12__p1 bn12__p2 34.5729
Rw14 bn2 bn2__p1 19.8494
Rw15 bn2 bn2__p2 18.7725
Rw16 bn2__p1 bn2__p2 10547.3
Rw17 bn3 bn3__p1 30.9128
Rw18 bn3 bn3__p2 26.3943
Rw19 bn3__p1 bn3__p2 31.4474
Rw20 bn4 bn4__p1 31.7277
Rw21 bn4 bn4__p2 26.1343
Rw22 bn4__p1 bn4__p2 32.3351
Rw23 bn5 bn5__p1 30.9128
Rw24 bn5 bn5__p2 26.3943
Rw25 bn5__p1 bn5__p2 31.4474
Rw26 bn6 bn6__p1 30.9128
Rw27 bn6 bn6__p2 26.3943
Rw28 bn6__p1 bn6__p2 31.4474
Rw29 bn7 bn7__p1 19.8494
Rw30 bn7 bn7__p2 18.7725
Rw31 bn7__p1 bn7__p2 10547.3
Rw32 bn8 bn8__p2 18.5632
Rw33 bn8__p1 bn8__p2 21.7312
Rw34 bn9 bn9__p1 69.727
Rw35 bn9 bn9__p2 21.3809
Rw36 bn9__p1 bn9__p2 71.0619
Rw37 bp0 bp0__p1 71.4321
Rw38 bp0 bp0__p2 21.5346
Rw39 bp0__p1 bp0__p2 76.2555
Rw40 bp1 bp1__p1 73.1946
Rw41 bp1 bp1__p2 21.2087
Rw42 bp1__p1 bp1__p2 74.4606
Rw43 bp10 bp10__p1 72.2589
Rw44 bp10 bp10__p2 21.2753
Rw45 bp10__p1 bp10__p2 73.3635
Rw46 bp11 bp11__p1 70.5049
Rw47 bp11 bp11__p2 21.1428
Rw48 bp11__p1 bp11__p2 70.5049
Rw49 bp12 bp12__p1 71.2007
Rw50 bp12 bp12__p2 21.0923
Rw51 bp12__p1 bp12__p2 71.0691
Rw52 bp2 bp2__p1 116.13
Rw53 bp2 bp2__p2 20.3536
Rw54 bp2__p1 bp2__p2 120.124
Rw55 bp3 bp3__p2 18.545
Rw56 bp3__p1 bp3__p2 43.3872
Rw57 bp4 bp4__p2 18.545
Rw58 bp4__p1 bp4__p2 43.085
Rw59 bp5 bp5__p2 18.545
Rw60 bp5__p1 bp5__p2 43.0352
Rw61 bp6 bp6__p1 41.399
Rw62 bp6 bp6__p2 18.484
Rw63 bp7 bp7__p1 108.594
Rw64 bp7 bp7__p2 20.2787
Rw65 bp7__p1 bp7__p2 110.674
Rw66 bp8 bp8__p1 71.1891
Rw67 bp8 bp8__p2 21.3144
Rw68 bp8__p1 bp8__p2 72.5521
Rw69 bp9 bp9__p1 108.943
Rw70 bp9 bp9__p2 20.2727
Rw71 bp9__p1 bp9__p2 111.029
Rw72 clkb clkb__p1 0.72754
Rw73 clkb clkb__p2 65.656
Rw74 clkn clkn__p1 0.756667
Rw75 clkn clkn__p2 57.1313
Rw76 clkn__p1 clkn__p2 348.939
Rw77 cn0 cn0__p1 19.6116
Rw78 cn1 cn1__p1 19.6179
Rw79 cn10 cn10__p1 39.202
Rw80 cn11 cn11__p1 39.2019
Rw81 cn12 cn12__p1 39.236
Rw82 cn2 cn2__p1 19.6179
Rw83 cn3 cn3__p1 19.6179
Rw84 cn4 cn4__p1 20.3219
Rw85 cn5 cn5__p1 19.6179
Rw86 cn6 cn6__p1 19.6179
Rw87 cn7 cn7__p1 19.6179
Rw88 cn8 cn8__p1 39.1744
Rw89 cn9 cn9__p1 39.2019
Rw90 cp0 cp0__p1 40.752
Rw91 cp1 cp1__p1 40.752
Rw92 cp10 cp10__p1 39.5541
Rw93 cp11 cp11__p1 39.168
Rw94 cp12 cp12__p1 39.4861
Rw95 cp2 cp2__p1 40.752
Rw96 cp3 cp3__p1 40.7859
Rw97 cp4 cp4__p1 40.7521
Rw98 cp5 cp5__p1 59.0701
Rw99 cp6 cp6__p1 58.82
Rw100 cp7 cp7__p1 40.82
Rw101 cp8 cp8__p1 39.236
Rw102 cp9 cp9__p1 39.168
Rw103 gnd__i5 gnd__i6 9
Rw104 gnd__i8 gnd__i9 9
Rw105 gnd__i12 gnd__i13 9
Rw106 gnd__i15 gnd__i16 9
Rw107 gnd__i18 gnd__i19 9
Rw108 gnd__i21 gnd__i22 9
Rw109 gnd__i26 gnd__i27 9
Rw110 gnd__i37 gnd__i38 9
Rw111 gnd__i40 gnd__i41 9
Rw112 gnd__i43 gnd__i44 9
Rw113 gnd__i46 gnd__i47 9
Rw114 gnd__i66 gnd__i67 9
Rw115 gnd__i69 gnd__i70 9
Rw116 gnd__i72 gnd__i73 9
Rw117 gnd__i75 gnd__i76 9
Rw118 gnd__i78 gnd__i79 9
Rw119 gnd__i86 gnd__i87 9
Rw120 gnd__i89 gnd__i90 9
Rw121 gnd__i138 gnd__i139 9
Rw122 gnd__i144 gnd__i145 9
Rw123 gnd__i147 gnd__i148 9
Rw124 gnd__i151 gnd__i152 9
Rw125 gnd__i154 gnd__i155 9
Rw126 gnd__i157 gnd__i158 9
Rw127 gnd__i160 gnd__i161 9
Rw128 gnd__i163 gnd__i164 9
Rw129 gnd__i166 gnd__i167 9
Rw130 gnd__i169 gnd__i170 9
Rw131 gnd__i172 gnd__i173 9
Rw132 gnd__i175 gnd__i176 9
Rw133 gnd__i177 gnd__i178 9
Rw134 gnd__i180 gnd__i181 9
Rw135 gnd__i183 gnd__i184 9
Rw136 gnd__i186 gnd__i187 9
Rw137 gnd__i208 gnd__i209 9
Rw138 gnd__i218 gnd__i219 9
Rw139 gnd__i221 gnd__i222 9
Rw140 gnd__i224 gnd__i225 9
Rw141 gnd__i227 gnd__i228 9
Rw142 gnd__i234 gnd__i235 9
Rw143 gnd__i238 gnd__i239 9
Rw144 gnd__i243 gnd__i244 9
Rw145 gnd__i246 gnd__i247 9
Rw146 gnd__i249 gnd__i250 9
Rw147 gnd__i252 gnd__i253 9
Rw148 gnd__i95 gnd__i64 10.7969
Rw149 gnd__i54 gnd__i53 1.32
Rw150 gnd__i55 gnd__i54 4.02769
Rw151 gnd__i61 gnd__i60 0.981538
Rw152 gnd__i61 gnd__i62 3.01231
Rw153 gnd__i58 gnd__i57 1.32
Rw154 gnd__i59 gnd__i58 1.32
Rw155 gnd__i59 gnd__i60 1.32
Rw156 gnd__i265 gnd__i89 0.12692
Rw157 gnd__i89 gnd__p23 0.0306538
Rw158 gnd__i265 gnd__i93 0.0444966
Rw159 gnd__i93 gnd__p23 0.0159287
Rw160 gnd__i266 gnd__i26 0.12692
Rw161 gnd__i26 gnd__p1 0.0306538
Rw162 gnd__i266 gnd__i63 0.0444966
Rw163 gnd__i63 gnd__p1 0.0159287
Rw164 gnd__i267 gnd__i29 0.12692
Rw165 gnd__i29 gnd__p2 0.0306538
Rw166 gnd__i267 gnd__i5 0.0444966
Rw167 gnd__i5 gnd__p2 0.0159287
Rw168 gnd__i268 gnd__i30 0.12692
Rw169 gnd__i30 gnd__p3 0.0306538
Rw170 gnd__i268 gnd__i8 0.0444966
Rw171 gnd__i8 gnd__p3 0.0159287
Rw172 gnd__i269 gnd__i32 0.12692
Rw173 gnd__i32 gnd__p6 0.0306538
Rw174 gnd__i269 gnd__i12 0.0444966
Rw175 gnd__i12 gnd__p6 0.0159287
Rw176 gnd__i270 gnd__i33 0.12692
Rw177 gnd__i33 gnd__p7 0.0306538
Rw178 gnd__i270 gnd__i15 0.0444966
Rw179 gnd__i15 gnd__p7 0.0159287
Rw180 gnd__i271 gnd__i34 0.12692
Rw181 gnd__i34 gnd__p8 0.0306538
Rw182 gnd__i271 gnd__i18 0.0444966
Rw183 gnd__i18 gnd__p8 0.0159287
Rw184 gnd__i272 gnd__i35 0.12692
Rw185 gnd__i35 gnd__p9 0.0306538
Rw186 gnd__i272 gnd__i21 0.0444966
Rw187 gnd__i21 gnd__p9 0.0159287
Rw188 gnd__i273 gnd__i86 0.12692
Rw189 gnd__i86 gnd__p22 0.0306538
Rw190 gnd__i273 gnd__i92 0.0444966
Rw191 gnd__i92 gnd__p22 0.0159287
Rw192 gnd__i274 gnd__i85 0.12692
Rw193 gnd__i85 gnd__p21 0.0306538
Rw194 gnd__i274 gnd__i78 0.0444966
Rw195 gnd__i78 gnd__p21 0.0159287
Rw196 gnd__i275 gnd__i84 0.12692
Rw197 gnd__i84 gnd__p20 0.0306538
Rw198 gnd__i275 gnd__i75 0.0444966
Rw199 gnd__i75 gnd__p20 0.0159287
Rw200 gnd__i276 gnd__i83 0.12692
Rw201 gnd__i83 gnd__p19 0.0306538
Rw202 gnd__i276 gnd__i72 0.0444966
Rw203 gnd__i72 gnd__p19 0.0159287
Rw204 gnd__i277 gnd__i82 0.12692
Rw205 gnd__i82 gnd__p18 0.0306538
Rw206 gnd__i277 gnd__i69 0.0444966
Rw207 gnd__i69 gnd__p18 0.0159287
Rw208 gnd__i278 gnd__i81 0.12692
Rw209 gnd__i81 gnd__p16 0.0306538
Rw210 gnd__i278 gnd__i66 0.0444966
Rw211 gnd__i66 gnd__p16 0.0159287
Rw212 gnd__i279 gnd__i49 0.12692
Rw213 gnd__i49 gnd__p10 0.0306538
Rw214 gnd__i279 gnd__i37 0.0444966
Rw215 gnd__i37 gnd__p10 0.0159287
Rw216 gnd__i280 gnd__i50 0.12692
Rw217 gnd__i50 gnd__p11 0.0306538
Rw218 gnd__i280 gnd__i40 0.0444966
Rw219 gnd__i40 gnd__p11 0.0159287
Rw220 gnd__i281 gnd__i51 0.12692
Rw221 gnd__i51 gnd__p12 0.0306538
Rw222 gnd__i281 gnd__i43 0.0444966
Rw223 gnd__i43 gnd__p12 0.0159287
Rw224 gnd__i282 gnd__i52 0.12692
Rw225 gnd__i52 gnd__p14 0.0306538
Rw226 gnd__i282 gnd__i46 0.0444966
Rw227 gnd__i46 gnd__p14 0.0159287
Rw228 gnd__i234 gnd__i137 0.176
Rw229 gnd__i136 gnd__i243 0.134858
Rw230 gnd__i212 gnd__i210 0.0465127
Rw231 gnd__i123 gnd__i207 0.185778
Rw232 gnd__i139 gnd__i246 0.185778
Rw233 gnd__i127 gnd__i134 0.0564431
Rw234 gnd__i128 gnd__i127 0.0874829
Rw235 gnd__i239 gnd__i240 0.0586667
Rw236 gnd__i240 gnd__i241 0.0586667
Rw237 gnd__i241 gnd__i242 0.0586667
Rw238 gnd__i242 gnd__i244 0.0586667
Rw239 gnd gnd__i214 0.17985
Rw240 gnd__i214 gnd__p59 0.539
Rw241 gnd__p59 gnd__p60 0.7876
Rw242 gnd__p60 gnd__p61 0.71885
Rw243 gnd__p61 gnd__i213 0.17655
Rw244 gnd__i213 gnd__i284 0.022
Rw245 gnd__i284 gnd__p62 0.58905
Rw246 gnd__p62 gnd__i237 0.09295
Rw247 gnd__i237 gnd__p63 0.6259
Rw248 gnd__p63 gnd__i236 0.3861
Rw249 gnd__i236 gnd__p64 0.4015
Rw250 gnd__p64 gnd__p65 0.71885
Rw251 gnd__i285 gnd__i176 0.1925
Rw252 gnd__i285 gnd__i284 0.132
Rw253 gnd__i211 gnd__p26 0.2464
Rw254 gnd__i150 gnd__p27 0.1408
Rw255 gnd__i91 gnd__p25 9
Rw256 gnd__i31 gnd__p5 9
Rw257 gnd__i94 gnd__i91 0.11
Rw258 gnd__i135 gnd__i94 9
Rw259 gnd__i127 gnd__i88 9
Rw260 gnd__i134 gnd__i88 9
Rw261 gnd__i90 gnd__i88 0.0488889
Rw262 gnd__i93 gnd__i90 9
Rw263 gnd__i128 gnd__i90 9
Rw264 gnd__i106 gnd__i23 9
Rw265 gnd__i24 gnd__i23 0.0488889
Rw266 gnd__i97 gnd__i24 9
Rw267 gnd__i98 gnd__i25 9
Rw268 gnd__i107 gnd__i25 9
Rw269 gnd__i27 gnd__i25 0.0488889
Rw270 gnd__i63 gnd__i27 9
Rw271 gnd__i99 gnd__i28 9
Rw272 gnd__i108 gnd__i28 9
Rw273 gnd__i6 gnd__i28 0.0488889
Rw274 gnd__i29 gnd__i6 9
Rw275 gnd__i100 gnd__i7 9
Rw276 gnd__i109 gnd__i7 9
Rw277 gnd__i9 gnd__i7 0.0488889
Rw278 gnd__i30 gnd__i9 9
Rw279 gnd__i126 gnd__i80 9
Rw280 gnd__i133 gnd__i80 9
Rw281 gnd__i87 gnd__i80 0.0488889
Rw282 gnd__i92 gnd__i87 9
Rw283 gnd__i102 gnd__i11 9
Rw284 gnd__i110 gnd__i11 9
Rw285 gnd__i13 gnd__i11 0.0488889
Rw286 gnd__i32 gnd__i13 9
Rw287 gnd__i103 gnd__i14 9
Rw288 gnd__i111 gnd__i14 9
Rw289 gnd__i16 gnd__i14 0.0488889
Rw290 gnd__i33 gnd__i16 9
Rw291 gnd__i104 gnd__i17 9
Rw292 gnd__i112 gnd__i17 9
Rw293 gnd__i19 gnd__i17 0.0488889
Rw294 gnd__i34 gnd__i19 9
Rw295 gnd__i105 gnd__i20 9
Rw296 gnd__i113 gnd__i20 9
Rw297 gnd__i22 gnd__i20 0.0488889
Rw298 gnd__i35 gnd__i22 9
Rw299 gnd__i125 gnd__i77 9
Rw300 gnd__i132 gnd__i77 9
Rw301 gnd__i79 gnd__i77 0.0488889
Rw302 gnd__i85 gnd__i79 9
Rw303 gnd__i131 gnd__i74 9
Rw304 gnd__i76 gnd__i74 0.0488889
Rw305 gnd__i84 gnd__i76 9
Rw306 gnd__i124 gnd__i76 9
Rw307 gnd__i130 gnd__i71 9
Rw308 gnd__i143 gnd__i71 9
Rw309 gnd__i73 gnd__i71 0.0488889
Rw310 gnd__i83 gnd__i73 9
Rw311 gnd__i142 gnd__i68 9
Rw312 gnd__i70 gnd__i68 0.0488889
Rw313 gnd__i82 gnd__i70 9
Rw314 gnd__i129 gnd__i70 9
Rw315 gnd__i140 gnd__i65 9
Rw316 gnd__i141 gnd__i65 9
Rw317 gnd__i67 gnd__i65 0.0488889
Rw318 gnd__i81 gnd__i67 9
Rw319 gnd__i10 gnd__i31 0.11
Rw320 gnd__i101 gnd__i10 9
Rw321 gnd__i114 gnd__i36 9
Rw322 gnd__i118 gnd__i36 9
Rw323 gnd__i38 gnd__i36 0.0488889
Rw324 gnd__i49 gnd__i38 9
Rw325 gnd__i115 gnd__i39 9
Rw326 gnd__i119 gnd__i39 9
Rw327 gnd__i41 gnd__i39 0.0488889
Rw328 gnd__i50 gnd__i41 9
Rw329 gnd__i116 gnd__i42 9
Rw330 gnd__i120 gnd__i42 9
Rw331 gnd__i44 gnd__i42 0.0488889
Rw332 gnd__i51 gnd__i44 9
Rw333 gnd__i117 gnd__i45 9
Rw334 gnd__i121 gnd__i45 9
Rw335 gnd__i47 gnd__i45 0.0488889
Rw336 gnd__i52 gnd__i47 9
Rw337 gnd__i240 gnd__i238 9
Rw338 gnd__i241 gnd__i238 9
Rw339 gnd__i211 gnd__i210 9
Rw340 gnd__i208 gnd__i210 0.0432458
Rw341 gnd__i97 gnd__i106 0.0488889
Rw342 gnd__i24 gnd__i106 9
Rw343 gnd__i196 gnd__i97 0.371556
Rw344 gnd__i23 gnd__i97 9
Rw345 gnd__i177 gnd__i196 0.0488889
Rw346 gnd__i179 gnd__i177 9
Rw347 gnd__i215 gnd__i177 0.0488889
Rw348 gnd__i98 gnd__i107 0.0488889
Rw349 gnd__i27 gnd__i107 9
Rw350 gnd__i197 gnd__i98 0.371556
Rw351 gnd__i27 gnd__i98 9
Rw352 gnd__i180 gnd__i197 0.0488889
Rw353 gnd__i182 gnd__i180 9
Rw354 gnd__i216 gnd__i180 0.0488889
Rw355 gnd__i99 gnd__i108 0.0488889
Rw356 gnd__i6 gnd__i108 9
Rw357 gnd__i198 gnd__i99 0.371556
Rw358 gnd__i6 gnd__i99 9
Rw359 gnd__i183 gnd__i198 0.0488889
Rw360 gnd__i185 gnd__i183 9
Rw361 gnd__i217 gnd__i183 0.0488889
Rw362 gnd__i100 gnd__i109 0.0488889
Rw363 gnd__i9 gnd__i109 9
Rw364 gnd__i199 gnd__i100 0.371556
Rw365 gnd__i9 gnd__i100 9
Rw366 gnd__i186 gnd__i199 0.0488889
Rw367 gnd__i151 gnd__i186 0.0488889
Rw368 gnd__i102 gnd__i110 0.0488889
Rw369 gnd__i13 gnd__i110 9
Rw370 gnd__i200 gnd__i102 0.371556
Rw371 gnd__i13 gnd__i102 9
Rw372 gnd__i188 gnd__i200 0.0488889
Rw373 gnd__i154 gnd__i188 0.0488889
Rw374 gnd__i156 gnd__i154 9
Rw375 gnd__i103 gnd__i111 0.0488889
Rw376 gnd__i16 gnd__i111 9
Rw377 gnd__i201 gnd__i103 0.371556
Rw378 gnd__i16 gnd__i103 9
Rw379 gnd__i189 gnd__i201 0.0488889
Rw380 gnd__i157 gnd__i189 0.0488889
Rw381 gnd__i159 gnd__i157 9
Rw382 gnd__i104 gnd__i112 0.0488889
Rw383 gnd__i19 gnd__i112 9
Rw384 gnd__i202 gnd__i104 0.371556
Rw385 gnd__i19 gnd__i104 9
Rw386 gnd__i190 gnd__i202 0.0488889
Rw387 gnd__i160 gnd__i190 0.0488889
Rw388 gnd__i162 gnd__i160 9
Rw389 gnd__i105 gnd__i113 0.0488889
Rw390 gnd__i22 gnd__i113 9
Rw391 gnd__i203 gnd__i105 0.371556
Rw392 gnd__i22 gnd__i105 9
Rw393 gnd__i191 gnd__i203 0.0488889
Rw394 gnd__i163 gnd__i191 0.0488889
Rw395 gnd__i165 gnd__i163 9
Rw396 gnd__i114 gnd__i118 0.0488889
Rw397 gnd__i38 gnd__i118 9
Rw398 gnd__i204 gnd__i114 0.449778
Rw399 gnd__i38 gnd__i114 9
Rw400 gnd__i192 gnd__i204 0.0488889
Rw401 gnd__i166 gnd__i192 0.0488889
Rw402 gnd__i168 gnd__i166 9
Rw403 gnd__i115 gnd__i119 0.0488889
Rw404 gnd__i41 gnd__i119 9
Rw405 gnd__i205 gnd__i115 0.449778
Rw406 gnd__i41 gnd__i115 9
Rw407 gnd__i193 gnd__i205 0.0488889
Rw408 gnd__i169 gnd__i193 0.0488889
Rw409 gnd__i171 gnd__i169 9
Rw410 gnd__i116 gnd__i120 0.0488889
Rw411 gnd__i44 gnd__i120 9
Rw412 gnd__i206 gnd__i116 0.449778
Rw413 gnd__i44 gnd__i116 9
Rw414 gnd__i194 gnd__i206 0.0488889
Rw415 gnd__i172 gnd__i194 0.0488889
Rw416 gnd__i174 gnd__i172 9
Rw417 gnd__i117 gnd__i121 0.0488889
Rw418 gnd__i47 gnd__i121 9
Rw419 gnd__i123 gnd__i117 0.264
Rw420 gnd__i47 gnd__i117 9
Rw421 gnd__i245 gnd__i207 9
Rw422 gnd__i195 gnd__i207 0.0488889
Rw423 gnd__i175 gnd__i195 0.0488889
Rw424 gnd__i140 gnd__i141 0.0488889
Rw425 gnd__i67 gnd__i141 9
Rw426 gnd__i139 gnd__i140 0.185778
Rw427 gnd__i67 gnd__i140 9
Rw428 gnd__i248 gnd__i246 9
Rw429 gnd__i262 gnd__i246 0.0488889
Rw430 gnd__i259 gnd__i262 0.0488889
Rw431 gnd__i129 gnd__i142 0.0488889
Rw432 gnd__i70 gnd__i142 9
Rw433 gnd__i249 gnd__i129 0.371556
Rw434 gnd__i68 gnd__i129 9
Rw435 gnd__i251 gnd__i249 9
Rw436 gnd__i263 gnd__i249 0.0488889
Rw437 gnd__i260 gnd__i263 0.0488889
Rw438 gnd__i130 gnd__i143 0.0488889
Rw439 gnd__i73 gnd__i143 9
Rw440 gnd__i252 gnd__i130 0.371556
Rw441 gnd__i73 gnd__i130 9
Rw442 gnd__i254 gnd__i252 9
Rw443 gnd__i264 gnd__i252 0.0488889
Rw444 gnd__i261 gnd__i264 0.0488889
Rw445 gnd__i131 gnd__i124 0.0488889
Rw446 gnd__i74 gnd__i124 9
Rw447 gnd__i255 gnd__i131 0.371556
Rw448 gnd__i76 gnd__i131 9
Rw449 gnd__i218 gnd__i255 0.0488889
Rw450 gnd__i220 gnd__i218 9
Rw451 gnd__i230 gnd__i218 0.0488889
Rw452 gnd__i132 gnd__i125 0.0488889
Rw453 gnd__i79 gnd__i125 9
Rw454 gnd__i256 gnd__i132 0.371556
Rw455 gnd__i79 gnd__i132 9
Rw456 gnd__i221 gnd__i256 0.0488889
Rw457 gnd__i223 gnd__i221 9
Rw458 gnd__i231 gnd__i221 0.0488889
Rw459 gnd__i133 gnd__i126 0.0488889
Rw460 gnd__i87 gnd__i126 9
Rw461 gnd__i257 gnd__i133 0.371556
Rw462 gnd__i87 gnd__i133 9
Rw463 gnd__i224 gnd__i257 0.0488889
Rw464 gnd__i226 gnd__i224 9
Rw465 gnd__i232 gnd__i224 0.0488889
Rw466 gnd__i258 gnd__i134 0.371556
Rw467 gnd__i90 gnd__i134 9
Rw468 gnd__i227 gnd__i258 0.0488889
Rw469 gnd__i229 gnd__i227 9
Rw470 gnd__i233 gnd__i227 0.0488889
Rw471 gnd__i146 gnd__i96 9
Rw472 gnd__i144 gnd__i96 0.0653048
Rw473 gnd__i150 gnd__i149 9
Rw474 gnd__i147 gnd__i149 0.0361467
Rw475 gnd__i137 gnd__i235 9
Rw476 gnd__i196 gnd__i178 9
Rw477 gnd__i215 gnd__i178 9
Rw478 gnd__i179 gnd__i178 0.0275
Rw479 gnd__i196 gnd__i179 9
Rw480 gnd__i181 gnd__i179 0.1485
Rw481 gnd__i215 gnd__i179 9
Rw482 gnd__i197 gnd__i181 9
Rw483 gnd__i216 gnd__i181 9
Rw484 gnd__i182 gnd__i181 0.0275
Rw485 gnd__i197 gnd__i182 9
Rw486 gnd__i184 gnd__i182 0.1485
Rw487 gnd__i216 gnd__i182 9
Rw488 gnd__i198 gnd__i184 9
Rw489 gnd__i217 gnd__i184 9
Rw490 gnd__i185 gnd__i184 0.0275
Rw491 gnd__i198 gnd__i185 9
Rw492 gnd__i187 gnd__i185 0.1485
Rw493 gnd__i217 gnd__i185 9
Rw494 gnd__i199 gnd__i187 9
Rw495 gnd__i152 gnd__i187 0.0275
Rw496 gnd__i151 gnd__i187 9
Rw497 gnd__i186 gnd__i152 9
Rw498 gnd__i153 gnd__i152 0.352
Rw499 gnd__i199 gnd__i152 9
Rw500 gnd__i155 gnd__i153 0.1485
Rw501 gnd__i188 gnd__i155 9
Rw502 gnd__i200 gnd__i155 9
Rw503 gnd__i156 gnd__i155 0.0275
Rw504 gnd__i188 gnd__i156 9
Rw505 gnd__i158 gnd__i156 0.1485
Rw506 gnd__i200 gnd__i156 9
Rw507 gnd__i189 gnd__i158 9
Rw508 gnd__i201 gnd__i158 9
Rw509 gnd__i159 gnd__i158 0.0275
Rw510 gnd__i189 gnd__i159 9
Rw511 gnd__i161 gnd__i159 0.1485
Rw512 gnd__i201 gnd__i159 9
Rw513 gnd__i190 gnd__i161 9
Rw514 gnd__i202 gnd__i161 9
Rw515 gnd__i162 gnd__i161 0.0275
Rw516 gnd__i190 gnd__i162 9
Rw517 gnd__i164 gnd__i162 0.1485
Rw518 gnd__i202 gnd__i162 9
Rw519 gnd__i191 gnd__i164 9
Rw520 gnd__i203 gnd__i164 9
Rw521 gnd__i165 gnd__i164 0.0275
Rw522 gnd__i191 gnd__i165 9
Rw523 gnd__i167 gnd__i165 0.1485
Rw524 gnd__i203 gnd__i165 9
Rw525 gnd__i192 gnd__i167 9
Rw526 gnd__i204 gnd__i167 9
Rw527 gnd__i168 gnd__i167 0.0275
Rw528 gnd__i192 gnd__i168 9
Rw529 gnd__i170 gnd__i168 0.1485
Rw530 gnd__i204 gnd__i168 9
Rw531 gnd__i193 gnd__i170 9
Rw532 gnd__i205 gnd__i170 9
Rw533 gnd__i171 gnd__i170 0.0275
Rw534 gnd__i193 gnd__i171 9
Rw535 gnd__i173 gnd__i171 0.1485
Rw536 gnd__i205 gnd__i171 9
Rw537 gnd__i194 gnd__i173 9
Rw538 gnd__i206 gnd__i173 9
Rw539 gnd__i174 gnd__i173 0.0275
Rw540 gnd__i194 gnd__i174 9
Rw541 gnd__i285 gnd__i174 0.132
Rw542 gnd__i206 gnd__i174 9
Rw543 gnd__i195 gnd__i176 9
Rw544 gnd__i207 gnd__i176 9
Rw545 gnd__i245 gnd__i176 0.0275
Rw546 gnd__i175 gnd__i245 9
Rw547 gnd__i247 gnd__i245 0.3245
Rw548 gnd__i195 gnd__i245 9
Rw549 gnd__i259 gnd__i247 9
Rw550 gnd__i262 gnd__i247 9
Rw551 gnd__i248 gnd__i247 0.0275
Rw552 gnd__i259 gnd__i248 9
Rw553 gnd__i250 gnd__i248 0.3245
Rw554 gnd__i262 gnd__i248 9
Rw555 gnd__i260 gnd__i250 9
Rw556 gnd__i263 gnd__i250 9
Rw557 gnd__i251 gnd__i250 0.0275
Rw558 gnd__i260 gnd__i251 9
Rw559 gnd__i253 gnd__i251 0.1485
Rw560 gnd__i263 gnd__i251 9
Rw561 gnd__i261 gnd__i253 9
Rw562 gnd__i264 gnd__i253 9
Rw563 gnd__i254 gnd__i253 0.0275
Rw564 gnd__i261 gnd__i254 9
Rw565 gnd__i219 gnd__i254 0.1485
Rw566 gnd__i264 gnd__i254 9
Rw567 gnd__i255 gnd__i219 9
Rw568 gnd__i220 gnd__i219 0.0275
Rw569 gnd__i230 gnd__i219 9
Rw570 gnd__i230 gnd__i220 9
Rw571 gnd__i222 gnd__i220 0.1485
Rw572 gnd__i255 gnd__i220 9
Rw573 gnd__i231 gnd__i222 9
Rw574 gnd__i256 gnd__i222 9
Rw575 gnd__i223 gnd__i222 0.0275
Rw576 gnd__i231 gnd__i223 9
Rw577 gnd__i225 gnd__i223 0.1485
Rw578 gnd__i256 gnd__i223 9
Rw579 gnd__i232 gnd__i225 9
Rw580 gnd__i257 gnd__i225 9
Rw581 gnd__i226 gnd__i225 0.0275
Rw582 gnd__i232 gnd__i226 9
Rw583 gnd__i228 gnd__i226 0.1485
Rw584 gnd__i257 gnd__i226 9
Rw585 gnd__i233 gnd__i228 9
Rw586 gnd__i258 gnd__i228 9
Rw587 gnd__i229 gnd__i228 0.0275
Rw588 gnd__i233 gnd__i229 9
Rw589 gnd__i258 gnd__i229 9
Rw590 gnd__i210 gnd__i209 9
Rw591 gnd__i212 gnd__i209 9
Rw592 gnd__i211 gnd__i209 0.0352
Rw593 gnd__i146 gnd__i145 0.0432373
Rw594 gnd__i96 gnd__i145 9
Rw595 gnd__i149 gnd__i148 9
Rw596 gnd__i150 gnd__i148 0.0352
Rw597 gnd__i1 gnd__p34 9.10676
Rw598 gnd__i2 gnd__p30 9.06632
Rw599 gnd__i3 gnd__p28 9.06632
Rw600 gnd__i4 gnd__p29 9.07441
Rw601 gnd__i7 gnd__i268 4.53823
Rw602 gnd__i10 gnd__p5 9.18301
Rw603 gnd__i11 gnd__i269 4.53823
Rw604 gnd__i14 gnd__i270 4.53823
Rw605 gnd__i17 gnd__i271 4.53823
Rw606 gnd__i20 gnd__i272 4.53823
Rw607 gnd__i23 gnd__p0 4.56519
Rw608 gnd__i24 gnd__p0 4.50634
Rw609 gnd__i25 gnd__i266 4.53823
Rw610 gnd__i28 gnd__i267 4.53823
Rw611 gnd__i36 gnd__i279 4.53823
Rw612 gnd__i39 gnd__i280 4.53823
Rw613 gnd__i42 gnd__i281 4.53823
Rw614 gnd__i45 gnd__i282 4.53823
Rw615 gnd__i48 gnd__p52 9.07603
Rw616 gnd__i54 gnd__i56 9.88
Rw617 gnd__i56 gnd__p38 9.10676
Rw618 gnd__i65 gnd__i278 4.53823
Rw619 gnd__i68 gnd__i277 4.53823
Rw620 gnd__i71 gnd__i276 4.53823
Rw621 gnd__i74 gnd__i275 4.53823
Rw622 gnd__i77 gnd__i274 4.53823
Rw623 gnd__i80 gnd__i273 4.53823
Rw624 gnd__i88 gnd__i265 4.53823
Rw625 gnd__i94 gnd__p25 9.18301
Rw626 gnd__i101 gnd__i31 9.11
Rw627 gnd__i135 gnd__i91 9.11
Rw628 gnd__i236 gnd__i234 10.408
Rw629 gnd__i242 gnd__i243 9.06433
Rw630 gnd__i0 gnd__p32 9.66876
Rw631 gnd__p31 gnd__i96 18.2504
Rw632 gnd__p54 gnd__i59 18.7784
Rw633 gnd__i31 gnd__p4 10.5828
Rw634 gnd__p13 gnd__i123 19.5488
Rw635 gnd__p36 gnd__i122 18.4183
Rw636 gnd__i56 gnd__p39 10.4068
Rw637 gnd__p49 gnd__i136 18.3378
Rw638 gnd__p50 gnd__i137 18.3928
Rw639 gnd__p44 gnd__i95 18.4814
Rw640 gnd__i138 gnd__p15 10.5488
Rw641 gnd__i138 gnd__p17 10.4068
Rw642 gnd__p27 gnd__p26 19.4416
Rw643 gnd__i4 gnd__i3 20.728
Rw644 gnd__i2 gnd__i144 29.461
Rw645 gnd__p42 gnd__i95 31.6436
Rw646 gnd__i57 gnd__p51 20.2026
Rw647 gnd__i62 gnd__p57 20.0984
Rw648 gnd__i283 gnd__i0 28.3415
Rw649 gnd__i283 gnd__p33 18.2747
Rw650 gnd__p55 gnd__i60 37.0748
Rw651 gnd__i208 gnd__i48 10.0237
Rw652 gnd__i122 gnd__i53 20.515
Rw653 gnd__p40 gnd__i55 36.9498
Rw654 gnd__p37 gnd__i53 37.1371
Rw655 gnd__i213 gnd__p43 27.9299
Rw656 gnd__i57 gnd__i48 27.843
Rw657 gnd__p53 gnd__i58 36.7784
Rw658 gnd__p56 gnd__i62 36.7784
Rw659 gnd__i238 gnd__p48 18.356
Rw660 gnd__i128 gnd__p24 19.6565
Rw661 gnd__i147 gnd__i146 5.91
Rw662 gnd__i101 gnd__i153 3.89642
Rw663 gnd gnd__i122 8.37032
Rw664 gnd__i214 gnd__i61 27.3872
Rw665 gnd__i235 gnd__i244 0.293333
Rw666 gnd__p35 gnd__i1 47.6482
Rw667 gnd__i212 gnd__i3 30.658
Rw668 gnd__p41 gnd__i55 38.1308
Rw669 gnd__i64 gnd__p46 36.8356
Rw670 gnd__i239 gnd__p47 23.1084
Rw671 gnd__i237 gnd__p45 27.986
Rw672 gnd__i135 gnd__i229 4.24842
Rw673 gnd__i4 gnd__i2 80.1262
Rw674 gnd__i0 gnd__p65 95.5579
Rw675 gnd__i283 gnd__i1 63.3238
Rw676 gnd__i64 gnd__i136 20.1397
Rw677 in0n in0n__p0 30.3747
Rw678 in0n in0n__p1 1228.71
Rw679 in0n__p0 in0n__p1 9.97289
Rw680 in0p in0p__p0 56.0447
Rw681 in0p in0p__p1 897.293
Rw682 in0p__p0 in0p__p1 9.95162
Rw683 in1n in1n__p0 55.5315
Rw684 in1n in1n__p1 2549.47
Rw685 in1n__p0 in1n__p1 9.94528
Rw686 in1p in1p__p0 32.6056
Rw687 in1p in1p__p1 495.158
Rw688 in1p__p0 in1p__p1 10.1323
Rw689 lsb_n lsb_n__p1 20.3059
Rw690 lsb_n lsb_n__p2 106.011
Rw691 lsb_n__p1 lsb_n__p2 107.844
Rw692 lsb_p lsb_p__p1 18.545
Rw693 lsb_p__p1 lsb_p__p2 109.874
Rw694 nr nr__p1 46.253
Rw695 on on__p1 57.7376
Rw696 on on__p2 80.5426
Rw697 on on__p3 818.264
Rw698 on on__p4 939.811
Rw699 on on__p5 644.18
Rw700 on on__p6 730.893
Rw701 on__p1 on__p2 74.757
Rw702 on__p1 on__p3 759.485
Rw703 on__p1 on__p4 872.302
Rw704 on__p1 on__p5 597.906
Rw705 on__p1 on__p6 678.391
Rw706 on__p2 on__p3 177.85
Rw707 on__p2 on__p4 204.268
Rw708 on__p2 on__p5 140.013
Rw709 on__p2 on__p6 158.86
Rw710 on__p3 on__p4 25.6479
Rw711 on__p3 on__p5 114.639
Rw712 on__p3 on__p6 130.071
Rw713 on__p4 on__p5 131.668
Rw714 on__p4 on__p6 149.392
Rw715 on__p5 on__p6 79.8554
Rw716 onn onn__p1 3752.06
Rw717 onn onn__p2 3657.87
Rw718 onn onn__p3 850.277
Rw719 onn onn__p4 510.969
Rw720 onn onn__p5 482.293
Rw721 onn onn__p6 92.6442
Rw722 onn__p1 onn__p2 58.262
Rw723 onn__p1 onn__p3 76.7857
Rw724 onn__p1 onn__p4 496.879
Rw725 onn__p1 onn__p5 559.603
Rw726 onn__p1 onn__p6 631.688
Rw727 onn__p2 onn__p3 74.858
Rw728 onn__p2 onn__p4 484.405
Rw729 onn__p2 onn__p5 545.554
Rw730 onn__p2 onn__p6 615.829
Rw731 onn__p3 onn__p4 112.601
Rw732 onn__p3 onn__p5 126.815
Rw733 onn__p3 onn__p6 143.151
Rw734 onn__p4 onn__p5 76.2088
Rw735 onn__p4 onn__p6 86.0256
Rw736 onn__p5 onn__p6 81.1976
Rw737 onp onp__p5 261.417
Rw738 onp onp__p6 83.8305
Rw739 onp__p1 onp__p2 19.2467
Rw740 onp__p2 onp__p3 0.715378
Rw741 onp__p3 onp__p4 71.8466
Rw742 onp__p3 onp__p5 82.2692
Rw743 onp__p4 onp__p5 22.742
Rw744 onp__p5 onp__p6 0.705438
Rw745 op op__p1 19.4601
Rw746 op__p1 op__p2 0.704
Rw747 op__p2 op__p3 57.2805
Rw748 op__p2 op__p4 278.03
Rw749 op__p2 op__p5 321.488
Rw750 op__p3 op__p4 75.7907
Rw751 op__p3 op__p5 87.6374
Rw752 op__p4 op__p5 23.4413
Rw753 op__p5 op__p6 0.704
Rw754 rstb rstb__p1 147.299
Rw755 rstb rstb__p2 127.888
Rw756 rstb rstb__p3 105.677
Rw757 rstb__p1 rstb__p2 582
Rw758 rstb__p1 rstb__p3 480.921
Rw759 rstb__p2 rstb__p3 22.7803
Rw760 rstb_n rstb_n__p1 88.824
Rw761 rstb_n rstb_n__p3 101.63
Rw762 rstb_n rstb_n__p4 96.0304
Rw763 rstb_n__p1 rstb_n__p3 37.1031
Rw764 rstb_n__p1 rstb_n__p4 35.059
Rw765 rstb_n__p2 rstb_n__p3 0.6534
Rw766 rstb_n__p3 rstb_n__p4 30.359
Rw767 t0 t0__p1 75.6109
Rw768 t0 t0__p2 342.012
Rw769 t0 t0__p3 148.019
Rw770 t0 t0__p4 391.687
Rw771 t0 t0__p5 318.63
Rw772 t0__p1 t0__p2 93.531
Rw773 t0__p1 t0__p3 40.4792
Rw774 t0__p1 t0__p4 188.995
Rw775 t0__p1 t0__p5 153.744
Rw776 t0__p2 t0__p3 78.2282
Rw777 t0__p2 t0__p4 854.883
Rw778 t0__p2 t0__p5 695.431
Rw779 t0__p3 t0__p4 369.985
Rw780 t0__p3 t0__p5 300.975
Rw781 t0__p4 t0__p5 23.6755
Rw782 t0b t0b__p1 35.0173
Rw783 t0b t0b__p2 80.151
Rw784 t0b t0b__p3 91.917
Rw785 t0b t0b__p7 54.8425
Rw786 t0b__p1 t0b__p2 63.8068
Rw787 t0b__p1 t0b__p3 73.1736
Rw788 t0b__p1 t0b__p7 66.6206
Rw789 t0b__p2 t0b__p3 29.7746
Rw790 t0b__p2 t0b__p7 152.488
Rw791 t0b__p3 t0b__p7 174.873
Rw792 t0b__p4 t0b__p5 36.6424
Rw793 t0b__p4 t0b__p6 265.156
Rw794 t0b__p4 t0b__p7 49.4116
Rw795 t0b__p4 t0b__p8 44.1235
Rw796 t0b__p4 t0b__p9 221.176
Rw797 t0b__p5 t0b__p6 289.099
Rw798 t0b__p5 t0b__p7 53.8734
Rw799 t0b__p5 t0b__p8 48.1077
Rw800 t0b__p5 t0b__p9 241.148
Rw801 t0b__p6 t0b__p7 232.691
Rw802 t0b__p6 t0b__p8 207.788
Rw803 t0b__p6 t0b__p9 24.6537
Rw804 t0b__p7 t0b__p8 38.7211
Rw805 t0b__p7 t0b__p9 194.096
Rw806 t0b__p8 t0b__p9 173.323
Rw807 t1 t1__p1 67.2933
Rw808 t1 t1__p2 309.568
Rw809 t1 t1__p3 132.904
Rw810 t1 t1__p4 992.265
Rw811 t1 t1__p5 835.599
Rw812 t1__p1 t1__p2 88.7548
Rw813 t1__p1 t1__p3 38.1043
Rw814 t1__p1 t1__p4 478.027
Rw815 t1__p1 t1__p5 402.553
Rw816 t1__p2 t1__p3 74.2198
Rw817 t1__p2 t1__p4 2199.06
Rw818 t1__p2 t1__p5 1851.86
Rw819 t1__p3 t1__p4 944.101
Rw820 t1__p3 t1__p5 795.04
Rw821 t1__p4 t1__p5 21.6477
Rw822 t1b t1b__p1 22.2717
Rw823 t1b t1b__p2 207.755
Rw824 t1b t1b__p3 218.438
Rw825 t1b t1b__p5 759.438
Rw826 t1b t1b__p6 253.71
Rw827 t1b t1b__p7 1125.06
Rw828 t1b t1b__p8 964.188
Rw829 t1b t1b__p9 192.304
Rw830 t1b__p1 t1b__p2 176.575
Rw831 t1b__p1 t1b__p3 185.655
Rw832 t1b__p2 t1b__p3 48.2268
Rw833 t1b__p4 t1b__p5 1.26262
Rw834 t1b__p5 t1b__p6 70.0358
Rw835 t1b__p5 t1b__p7 506.324
Rw836 t1b__p5 t1b__p8 433.926
Rw837 t1b__p5 t1b__p9 90.8017
Rw838 t1b__p6 t1b__p7 169.151
Rw839 t1b__p6 t1b__p8 144.964
Rw840 t1b__p6 t1b__p9 30.3347
Rw841 t1b__p7 t1b__p8 24.0048
Rw842 t1b__p7 t1b__p9 134.517
Rw843 t1b__p8 t1b__p9 115.283
Rw844 top_n top_n__p1 0.001
Rw845 top_n top_n__p2 0.001
Rw846 top_n__p1 top_n__p3 86.378
Rw847 top_n__p1 top_n__p4 92.5143
Rw848 top_n__p3 top_n__p4 49.7283
Rw849 top_p top_p__p1 0.001
Rw850 top_p top_p__p2 0.001
Rw851 top_p__p1 top_p__p3 31.2837
Rw852 top_p__p1 top_p__p4 82.8984
Rw853 top_p__p3 top_p__p4 163.124
Rw854 trk0 trk0__p1 20.4429
Rw855 trk1 trk1__p1 19.7939
Rw856 vdd vdd__p0 111.57
Rw857 vdd vdd__p1 1455.94
Rw858 vdd vdd__p10 42159.3
Rw859 vdd vdd__p11 27505.2
Rw860 vdd vdd__p12 61.2779
Rw861 vdd vdd__p13 59.5884
Rw862 vdd vdd__p14 59.5937
Rw863 vdd vdd__p15 27.3341
Rw864 vdd vdd__p16 62.3715
Rw865 vdd vdd__p17 65.2596
Rw866 vdd vdd__p18 69.0257
Rw867 vdd vdd__p19 2153.98
Rw868 vdd vdd__p2 285.705
Rw869 vdd vdd__p20 1929.17
Rw870 vdd vdd__p21 1854.71
Rw871 vdd vdd__p22 1472.81
Rw872 vdd vdd__p24 3664.99
Rw873 vdd vdd__p26 84.2413
Rw874 vdd vdd__p27 88.9852
Rw875 vdd vdd__p28 96.4396
Rw876 vdd vdd__p29 120.323
Rw877 vdd vdd__p3 1169.06
Rw878 vdd vdd__p30 140.999
Rw879 vdd vdd__p31 139.853
Rw880 vdd vdd__p32 150.535
Rw881 vdd vdd__p33 160.238
Rw882 vdd vdd__p34 172.898
Rw883 vdd vdd__p36 9.81703
Rw884 vdd vdd__p37 39.052
Rw885 vdd vdd__p38 70.7645
Rw886 vdd vdd__p4 12325.9
Rw887 vdd vdd__p5 2423.41
Rw888 vdd vdd__p6 1964.49
Rw889 vdd vdd__p7 22320.1
Rw890 vdd vdd__p8 4903.13
Rw891 vdd vdd__p9 32475.3
Rw892 vdd__p0 vdd__p1 795.922
Rw893 vdd__p0 vdd__p11 866868
Rw894 vdd__p0 vdd__p12 2052
Rw895 vdd__p0 vdd__p13 1995.43
Rw896 vdd__p0 vdd__p14 1995.6
Rw897 vdd__p0 vdd__p15 2192.85
Rw898 vdd__p0 vdd__p16 1965.74
Rw899 vdd__p0 vdd__p17 2056.76
Rw900 vdd__p0 vdd__p18 2175.45
Rw901 vdd__p0 vdd__p19 67886.1
Rw902 vdd__p0 vdd__p2 156.187
Rw903 vdd__p0 vdd__p20 60800.7
Rw904 vdd__p0 vdd__p21 58454.2
Rw905 vdd__p0 vdd__p22 46418
Rw906 vdd__p0 vdd__p24 115508
Rw907 vdd__p0 vdd__p26 2655
Rw908 vdd__p0 vdd__p27 2804.51
Rw909 vdd__p0 vdd__p28 3039.44
Rw910 vdd__p0 vdd__p29 3792.18
Rw911 vdd__p0 vdd__p3 639.094
Rw912 vdd__p0 vdd__p30 4443.82
Rw913 vdd__p0 vdd__p31 4407.7
Rw914 vdd__p0 vdd__p32 4744.35
Rw915 vdd__p0 vdd__p33 5050.16
Rw916 vdd__p0 vdd__p34 5449.14
Rw917 vdd__p0 vdd__p36 309.399
Rw918 vdd__p0 vdd__p37 1230.79
Rw919 vdd__p0 vdd__p38 2230.26
Rw920 vdd__p0 vdd__p4 6738.2
Rw921 vdd__p0 vdd__p5 1324.81
Rw922 vdd__p0 vdd__p6 61914.1
Rw923 vdd__p0 vdd__p7 703452
Rw924 vdd__p0 vdd__p8 154530
Rw925 vdd__p1 vdd__p12 26777.9
Rw926 vdd__p1 vdd__p13 26039.6
Rw927 vdd__p1 vdd__p14 26041.9
Rw928 vdd__p1 vdd__p15 28615.9
Rw929 vdd__p1 vdd__p16 25652.1
Rw930 vdd__p1 vdd__p17 26839.9
Rw931 vdd__p1 vdd__p18 28388.9
Rw932 vdd__p1 vdd__p19 885888
Rw933 vdd__p1 vdd__p2 83.6589
Rw934 vdd__p1 vdd__p20 793426
Rw935 vdd__p1 vdd__p21 762805
Rw936 vdd__p1 vdd__p22 605738
Rw937 vdd__p1 vdd__p26 34646.7
Rw938 vdd__p1 vdd__p27 36597.8
Rw939 vdd__p1 vdd__p28 39663.6
Rw940 vdd__p1 vdd__p29 49486.5
Rw941 vdd__p1 vdd__p3 342.32
Rw942 vdd__p1 vdd__p30 57990.2
Rw943 vdd__p1 vdd__p31 57518.8
Rw944 vdd__p1 vdd__p32 61911.9
Rw945 vdd__p1 vdd__p33 65902.7
Rw946 vdd__p1 vdd__p34 71109.2
Rw947 vdd__p1 vdd__p36 4037.54
Rw948 vdd__p1 vdd__p37 16061.3
Rw949 vdd__p1 vdd__p38 29104
Rw950 vdd__p1 vdd__p4 3609.21
Rw951 vdd__p1 vdd__p5 709.612
Rw952 vdd__p1 vdd__p6 807955
Rw953 vdd__p10 vdd__p11 103.693
Rw954 vdd__p10 vdd__p12 775399
Rw955 vdd__p10 vdd__p13 754020
Rw956 vdd__p10 vdd__p14 754086
Rw957 vdd__p10 vdd__p15 828622
Rw958 vdd__p10 vdd__p16 699298
Rw959 vdd__p10 vdd__p17 669012
Rw960 vdd__p10 vdd__p18 611151
Rw961 vdd__p10 vdd__p19 57811.1
Rw962 vdd__p10 vdd__p20 51777.2
Rw963 vdd__p10 vdd__p21 45944.6
Rw964 vdd__p10 vdd__p26 486849
Rw965 vdd__p10 vdd__p27 459216
Rw966 vdd__p10 vdd__p28 431856
Rw967 vdd__p10 vdd__p29 359711
Rw968 vdd__p10 vdd__p30 373883
Rw969 vdd__p10 vdd__p31 328059
Rw970 vdd__p10 vdd__p32 311478
Rw971 vdd__p10 vdd__p33 291530
Rw972 vdd__p10 vdd__p34 275658
Rw973 vdd__p10 vdd__p36 15651.7
Rw974 vdd__p10 vdd__p37 3387.37
Rw975 vdd__p10 vdd__p38 1752.97
Rw976 vdd__p10 vdd__p6 1693.17
Rw977 vdd__p10 vdd__p7 699.385
Rw978 vdd__p10 vdd__p8 148.124
Rw979 vdd__p10 vdd__p9 77.1175
Rw980 vdd__p11 vdd__p12 505879
Rw981 vdd__p11 vdd__p13 491931
Rw982 vdd__p11 vdd__p14 491974
Rw983 vdd__p11 vdd__p15 540602
Rw984 vdd__p11 vdd__p16 456230
Rw985 vdd__p11 vdd__p17 436471
Rw986 vdd__p11 vdd__p18 398722
Rw987 vdd__p11 vdd__p19 37716.6
Rw988 vdd__p11 vdd__p20 33780
Rw989 vdd__p11 vdd__p21 29974.8
Rw990 vdd__p11 vdd__p26 317626
Rw991 vdd__p11 vdd__p27 299598
Rw992 vdd__p11 vdd__p28 281748
Rw993 vdd__p11 vdd__p29 234679
Rw994 vdd__p11 vdd__p30 243926
Rw995 vdd__p11 vdd__p31 214029
Rw996 vdd__p11 vdd__p32 203211
Rw997 vdd__p11 vdd__p33 190197
Rw998 vdd__p11 vdd__p34 179842
Rw999 vdd__p11 vdd__p36 10211.3
Rw1000 vdd__p11 vdd__p37 2209.96
Rw1001 vdd__p11 vdd__p38 1143.66
Rw1002 vdd__p11 vdd__p6 1104.64
Rw1003 vdd__p11 vdd__p7 456.286
Rw1004 vdd__p11 vdd__p8 96.6377
Rw1005 vdd__p11 vdd__p9 79.8743
Rw1006 vdd__p12 vdd__p13 877.988
Rw1007 vdd__p12 vdd__p14 975.953
Rw1008 vdd__p12 vdd__p15 1204.39
Rw1009 vdd__p12 vdd__p16 1147.15
Rw1010 vdd__p12 vdd__p17 1200.26
Rw1011 vdd__p12 vdd__p18 1269.53
Rw1012 vdd__p12 vdd__p19 39616.3
Rw1013 vdd__p12 vdd__p2 5254.73
Rw1014 vdd__p12 vdd__p20 35481.5
Rw1015 vdd__p12 vdd__p21 34112.1
Rw1016 vdd__p12 vdd__p22 27088.2
Rw1017 vdd__p12 vdd__p24 67407.1
Rw1018 vdd__p12 vdd__p26 1549.38
Rw1019 vdd__p12 vdd__p27 1636.63
Rw1020 vdd__p12 vdd__p28 1773.73
Rw1021 vdd__p12 vdd__p29 2213
Rw1022 vdd__p12 vdd__p3 21501.6
Rw1023 vdd__p12 vdd__p30 2593.28
Rw1024 vdd__p12 vdd__p31 2572.2
Rw1025 vdd__p12 vdd__p32 2768.66
Rw1026 vdd__p12 vdd__p33 2947.12
Rw1027 vdd__p12 vdd__p34 3179.96
Rw1028 vdd__p12 vdd__p36 180.556
Rw1029 vdd__p12 vdd__p37 718.25
Rw1030 vdd__p12 vdd__p38 1301.51
Rw1031 vdd__p12 vdd__p4 226699
Rw1032 vdd__p12 vdd__p5 44571.7
Rw1033 vdd__p12 vdd__p6 36131.2
Rw1034 vdd__p12 vdd__p7 410514
Rw1035 vdd__p12 vdd__p8 90179
Rw1036 vdd__p12 vdd__p9 597289
Rw1037 vdd__p13 vdd__p14 949.045
Rw1038 vdd__p13 vdd__p15 1171.18
Rw1039 vdd__p13 vdd__p16 1115.52
Rw1040 vdd__p13 vdd__p17 1167.17
Rw1041 vdd__p13 vdd__p18 1234.53
Rw1042 vdd__p13 vdd__p19 38524
Rw1043 vdd__p13 vdd__p2 5109.85
Rw1044 vdd__p13 vdd__p20 34503.2
Rw1045 vdd__p13 vdd__p21 33171.6
Rw1046 vdd__p13 vdd__p22 26341.3
Rw1047 vdd__p13 vdd__p24 65548.6
Rw1048 vdd__p13 vdd__p26 1506.66
Rw1049 vdd__p13 vdd__p27 1591.5
Rw1050 vdd__p13 vdd__p28 1724.83
Rw1051 vdd__p13 vdd__p29 2151.99
Rw1052 vdd__p13 vdd__p3 20908.7
Rw1053 vdd__p13 vdd__p30 2521.78
Rw1054 vdd__p13 vdd__p31 2501.28
Rw1055 vdd__p13 vdd__p32 2692.32
Rw1056 vdd__p13 vdd__p33 2865.87
Rw1057 vdd__p13 vdd__p34 3092.28
Rw1058 vdd__p13 vdd__p36 175.578
Rw1059 vdd__p13 vdd__p37 698.446
Rw1060 vdd__p13 vdd__p38 1265.63
Rw1061 vdd__p13 vdd__p4 220449
Rw1062 vdd__p13 vdd__p5 43342.8
Rw1063 vdd__p13 vdd__p6 35135
Rw1064 vdd__p13 vdd__p7 399195
Rw1065 vdd__p13 vdd__p8 87692.6
Rw1066 vdd__p13 vdd__p9 580821
Rw1067 vdd__p14 vdd__p15 1171.29
Rw1068 vdd__p14 vdd__p16 1115.62
Rw1069 vdd__p14 vdd__p17 1167.27
Rw1070 vdd__p14 vdd__p18 1234.64
Rw1071 vdd__p14 vdd__p19 38527.4
Rw1072 vdd__p14 vdd__p2 5110.3
Rw1073 vdd__p14 vdd__p20 34506.2
Rw1074 vdd__p14 vdd__p21 33174.5
Rw1075 vdd__p14 vdd__p22 26343.6
Rw1076 vdd__p14 vdd__p24 65554.3
Rw1077 vdd__p14 vdd__p26 1506.79
Rw1078 vdd__p14 vdd__p27 1591.64
Rw1079 vdd__p14 vdd__p28 1724.98
Rw1080 vdd__p14 vdd__p29 2152.18
Rw1081 vdd__p14 vdd__p3 20910.6
Rw1082 vdd__p14 vdd__p30 2522
Rw1083 vdd__p14 vdd__p31 2501.5
Rw1084 vdd__p14 vdd__p32 2692.56
Rw1085 vdd__p14 vdd__p33 2866.12
Rw1086 vdd__p14 vdd__p34 3092.55
Rw1087 vdd__p14 vdd__p36 175.593
Rw1088 vdd__p14 vdd__p37 698.508
Rw1089 vdd__p14 vdd__p38 1265.74
Rw1090 vdd__p14 vdd__p4 220468
Rw1091 vdd__p14 vdd__p5 43346.6
Rw1092 vdd__p14 vdd__p6 35138.1
Rw1093 vdd__p14 vdd__p7 399231
Rw1094 vdd__p14 vdd__p8 87700.4
Rw1095 vdd__p14 vdd__p9 580872
Rw1096 vdd__p15 vdd__p16 1225.89
Rw1097 vdd__p15 vdd__p17 1282.65
Rw1098 vdd__p15 vdd__p18 1356.67
Rw1099 vdd__p15 vdd__p19 42335.6
Rw1100 vdd__p15 vdd__p2 5615.41
Rw1101 vdd__p15 vdd__p20 37916.9
Rw1102 vdd__p15 vdd__p21 36453.6
Rw1103 vdd__p15 vdd__p22 28947.5
Rw1104 vdd__p15 vdd__p24 72033.9
Rw1105 vdd__p15 vdd__p26 1655.73
Rw1106 vdd__p15 vdd__p27 1748.97
Rw1107 vdd__p15 vdd__p28 1895.48
Rw1108 vdd__p15 vdd__p29 2364.9
Rw1109 vdd__p15 vdd__p3 22977.4
Rw1110 vdd__p15 vdd__p30 2771.28
Rw1111 vdd__p15 vdd__p31 2748.76
Rw1112 vdd__p15 vdd__p32 2958.7
Rw1113 vdd__p15 vdd__p33 3149.41
Rw1114 vdd__p15 vdd__p34 3398.23
Rw1115 vdd__p15 vdd__p36 192.949
Rw1116 vdd__p15 vdd__p37 767.55
Rw1117 vdd__p15 vdd__p38 1390.85
Rw1118 vdd__p15 vdd__p4 242260
Rw1119 vdd__p15 vdd__p5 47631.1
Rw1120 vdd__p15 vdd__p6 38611.2
Rw1121 vdd__p15 vdd__p7 438691
Rw1122 vdd__p15 vdd__p8 96368.8
Rw1123 vdd__p15 vdd__p9 638287
Rw1124 vdd__p16 vdd__p17 1082.46
Rw1125 vdd__p16 vdd__p18 1144.93
Rw1126 vdd__p16 vdd__p19 35728.2
Rw1127 vdd__p16 vdd__p2 5033.82
Rw1128 vdd__p16 vdd__p20 31999.2
Rw1129 vdd__p16 vdd__p21 30764.2
Rw1130 vdd__p16 vdd__p22 24429.6
Rw1131 vdd__p16 vdd__p24 60791.5
Rw1132 vdd__p16 vdd__p26 1397.32
Rw1133 vdd__p16 vdd__p27 1476
Rw1134 vdd__p16 vdd__p28 1599.65
Rw1135 vdd__p16 vdd__p29 1995.81
Rw1136 vdd__p16 vdd__p3 20597.6
Rw1137 vdd__p16 vdd__p30 2338.77
Rw1138 vdd__p16 vdd__p31 2319.76
Rw1139 vdd__p16 vdd__p32 2496.93
Rw1140 vdd__p16 vdd__p33 2657.88
Rw1141 vdd__p16 vdd__p34 2867.86
Rw1142 vdd__p16 vdd__p36 162.836
Rw1143 vdd__p16 vdd__p37 647.758
Rw1144 vdd__p16 vdd__p38 1173.78
Rw1145 vdd__p16 vdd__p4 217169
Rw1146 vdd__p16 vdd__p5 42697.9
Rw1147 vdd__p16 vdd__p6 32585.1
Rw1148 vdd__p16 vdd__p7 370224
Rw1149 vdd__p16 vdd__p8 81328.5
Rw1150 vdd__p16 vdd__p9 538669
Rw1151 vdd__p17 vdd__p18 1095.35
Rw1152 vdd__p17 vdd__p19 34180.9
Rw1153 vdd__p17 vdd__p2 5266.9
Rw1154 vdd__p17 vdd__p20 30613.3
Rw1155 vdd__p17 vdd__p21 29431.9
Rw1156 vdd__p17 vdd__p22 23371.6
Rw1157 vdd__p17 vdd__p24 58158.7
Rw1158 vdd__p17 vdd__p26 1336.8
Rw1159 vdd__p17 vdd__p27 1412.08
Rw1160 vdd__p17 vdd__p28 1530.37
Rw1161 vdd__p17 vdd__p29 1909.38
Rw1162 vdd__p17 vdd__p3 21551.4
Rw1163 vdd__p17 vdd__p30 2237.48
Rw1164 vdd__p17 vdd__p31 2219.29
Rw1165 vdd__p17 vdd__p32 2388.79
Rw1166 vdd__p17 vdd__p33 2542.77
Rw1167 vdd__p17 vdd__p34 2743.66
Rw1168 vdd__p17 vdd__p36 155.783
Rw1169 vdd__p17 vdd__p37 619.704
Rw1170 vdd__p17 vdd__p38 1122.94
Rw1171 vdd__p17 vdd__p4 227224
Rw1172 vdd__p17 vdd__p5 44675
Rw1173 vdd__p17 vdd__p6 31173.9
Rw1174 vdd__p17 vdd__p7 354190
Rw1175 vdd__p17 vdd__p8 77806.2
Rw1176 vdd__p17 vdd__p9 515340
Rw1177 vdd__p18 vdd__p19 31224.7
Rw1178 vdd__p18 vdd__p2 5570.86
Rw1179 vdd__p18 vdd__p20 27965.7
Rw1180 vdd__p18 vdd__p21 26886.4
Rw1181 vdd__p18 vdd__p22 21350.3
Rw1182 vdd__p18 vdd__p24 53128.7
Rw1183 vdd__p18 vdd__p26 1221.18
Rw1184 vdd__p18 vdd__p27 1289.95
Rw1185 vdd__p18 vdd__p28 1398.01
Rw1186 vdd__p18 vdd__p29 1744.24
Rw1187 vdd__p18 vdd__p3 22795.1
Rw1188 vdd__p18 vdd__p30 2043.96
Rw1189 vdd__p18 vdd__p31 2027.35
Rw1190 vdd__p18 vdd__p32 2182.19
Rw1191 vdd__p18 vdd__p33 2322.86
Rw1192 vdd__p18 vdd__p34 2506.37
Rw1193 vdd__p18 vdd__p36 142.31
Rw1194 vdd__p18 vdd__p37 566.108
Rw1195 vdd__p18 vdd__p38 1025.82
Rw1196 vdd__p18 vdd__p4 240338
Rw1197 vdd__p18 vdd__p5 47253.2
Rw1198 vdd__p18 vdd__p6 28477.8
Rw1199 vdd__p18 vdd__p7 323558
Rw1200 vdd__p18 vdd__p8 71077
Rw1201 vdd__p18 vdd__p9 470770
Rw1202 vdd__p19 vdd__p2 173841
Rw1203 vdd__p19 vdd__p20 25.2411
Rw1204 vdd__p19 vdd__p21 2543.28
Rw1205 vdd__p19 vdd__p22 199533
Rw1206 vdd__p19 vdd__p24 496525
Rw1207 vdd__p19 vdd__p26 24873.9
Rw1208 vdd__p19 vdd__p27 23462.1
Rw1209 vdd__p19 vdd__p28 22064.2
Rw1210 vdd__p19 vdd__p29 18378.2
Rw1211 vdd__p19 vdd__p3 711333
Rw1212 vdd__p19 vdd__p30 19102.3
Rw1213 vdd__p19 vdd__p31 16761.1
Rw1214 vdd__p19 vdd__p32 15913.9
Rw1215 vdd__p19 vdd__p33 14894.7
Rw1216 vdd__p19 vdd__p34 14083.8
Rw1217 vdd__p19 vdd__p36 799.67
Rw1218 vdd__p19 vdd__p37 173.066
Rw1219 vdd__p19 vdd__p38 97.0363
Rw1220 vdd__p19 vdd__p6 2693.82
Rw1221 vdd__p19 vdd__p7 30606.5
Rw1222 vdd__p19 vdd__p8 6723.44
Rw1223 vdd__p19 vdd__p9 44531.9
Rw1224 vdd__p2 vdd__p20 155697
Rw1225 vdd__p2 vdd__p21 149688
Rw1226 vdd__p2 vdd__p22 118866
Rw1227 vdd__p2 vdd__p24 295791
Rw1228 vdd__p2 vdd__p26 6798.86
Rw1229 vdd__p2 vdd__p27 7181.73
Rw1230 vdd__p2 vdd__p28 7783.35
Rw1231 vdd__p2 vdd__p29 9710.94
Rw1232 vdd__p2 vdd__p3 67.1748
Rw1233 vdd__p2 vdd__p30 11379.6
Rw1234 vdd__p2 vdd__p31 11287.1
Rw1235 vdd__p2 vdd__p32 12149.2
Rw1236 vdd__p2 vdd__p33 12932.3
Rw1237 vdd__p2 vdd__p34 13954
Rw1238 vdd__p2 vdd__p36 792.303
Rw1239 vdd__p2 vdd__p37 3151.77
Rw1240 vdd__p2 vdd__p38 5711.19
Rw1241 vdd__p2 vdd__p4 708.249
Rw1242 vdd__p2 vdd__p5 139.25
Rw1243 vdd__p2 vdd__p6 158548
Rw1244 vdd__p2 vdd__p8 395717
Rw1245 vdd__p20 vdd__p21 2277.84
Rw1246 vdd__p20 vdd__p22 178708
Rw1247 vdd__p20 vdd__p24 444701
Rw1248 vdd__p20 vdd__p26 22277.7
Rw1249 vdd__p20 vdd__p27 21013.3
Rw1250 vdd__p20 vdd__p28 19761.3
Rw1251 vdd__p20 vdd__p29 16460
Rw1252 vdd__p20 vdd__p3 637090
Rw1253 vdd__p20 vdd__p30 17108.5
Rw1254 vdd__p20 vdd__p31 15011.7
Rw1255 vdd__p20 vdd__p32 14252.9
Rw1256 vdd__p20 vdd__p33 13340.1
Rw1257 vdd__p20 vdd__p34 12613.8
Rw1258 vdd__p20 vdd__p36 716.206
Rw1259 vdd__p20 vdd__p37 155.003
Rw1260 vdd__p20 vdd__p38 86.9083
Rw1261 vdd__p20 vdd__p6 2412.66
Rw1262 vdd__p20 vdd__p7 27412
Rw1263 vdd__p20 vdd__p8 6021.7
Rw1264 vdd__p20 vdd__p9 39884
Rw1265 vdd__p21 vdd__p22 171811
Rw1266 vdd__p21 vdd__p24 427539
Rw1267 vdd__p21 vdd__p26 21417.9
Rw1268 vdd__p21 vdd__p27 20202.3
Rw1269 vdd__p21 vdd__p28 18998.6
Rw1270 vdd__p21 vdd__p29 15824.8
Rw1271 vdd__p21 vdd__p3 612502
Rw1272 vdd__p21 vdd__p30 16448.3
Rw1273 vdd__p21 vdd__p31 14432.3
Rw1274 vdd__p21 vdd__p32 13702.8
Rw1275 vdd__p21 vdd__p33 12825.3
Rw1276 vdd__p21 vdd__p34 12127
Rw1277 vdd__p21 vdd__p36 688.565
Rw1278 vdd__p21 vdd__p37 149.021
Rw1279 vdd__p21 vdd__p38 23.9961
Rw1280 vdd__p21 vdd__p6 2140.88
Rw1281 vdd__p21 vdd__p7 24324.1
Rw1282 vdd__p21 vdd__p8 5343.37
Rw1283 vdd__p21 vdd__p9 35391.1
Rw1284 vdd__p22 vdd__p23 21.6623
Rw1285 vdd__p22 vdd__p24 76.9106
Rw1286 vdd__p22 vdd__p26 17007.8
Rw1287 vdd__p22 vdd__p27 16042.5
Rw1288 vdd__p22 vdd__p28 15086.7
Rw1289 vdd__p22 vdd__p29 12566.3
Rw1290 vdd__p22 vdd__p3 486383
Rw1291 vdd__p22 vdd__p30 154.384
Rw1292 vdd__p22 vdd__p31 12955.3
Rw1293 vdd__p22 vdd__p32 13944.8
Rw1294 vdd__p22 vdd__p33 14843.6
Rw1295 vdd__p22 vdd__p34 16016.3
Rw1296 vdd__p22 vdd__p36 909.397
Rw1297 vdd__p22 vdd__p37 3617.57
Rw1298 vdd__p22 vdd__p38 6555.25
Rw1299 vdd__p22 vdd__p6 181980
Rw1300 vdd__p22 vdd__p8 454200
Rw1301 vdd__p24 vdd__p25 21.8792
Rw1302 vdd__p24 vdd__p26 42322.8
Rw1303 vdd__p24 vdd__p27 39920.6
Rw1304 vdd__p24 vdd__p28 37542.2
Rw1305 vdd__p24 vdd__p29 31270.4
Rw1306 vdd__p24 vdd__p30 384.174
Rw1307 vdd__p24 vdd__p31 32238.3
Rw1308 vdd__p24 vdd__p32 34700.6
Rw1309 vdd__p24 vdd__p33 36937.3
Rw1310 vdd__p24 vdd__p34 39855.5
Rw1311 vdd__p24 vdd__p36 2262.97
Rw1312 vdd__p24 vdd__p37 9002.07
Rw1313 vdd__p24 vdd__p38 16312.3
Rw1314 vdd__p24 vdd__p6 452845
Rw1315 vdd__p26 vdd__p27 1027.59
Rw1316 vdd__p26 vdd__p28 1113.67
Rw1317 vdd__p26 vdd__p29 1389.48
Rw1318 vdd__p26 vdd__p3 27819.9
Rw1319 vdd__p26 vdd__p30 1628.24
Rw1320 vdd__p26 vdd__p31 1615.01
Rw1321 vdd__p26 vdd__p32 1738.36
Rw1322 vdd__p26 vdd__p33 1850.41
Rw1323 vdd__p26 vdd__p34 1996.6
Rw1324 vdd__p26 vdd__p36 113.366
Rw1325 vdd__p26 vdd__p37 450.967
Rw1326 vdd__p26 vdd__p38 817.178
Rw1327 vdd__p26 vdd__p4 293316
Rw1328 vdd__p26 vdd__p5 57669.4
Rw1329 vdd__p26 vdd__p6 22685.7
Rw1330 vdd__p26 vdd__p7 257749
Rw1331 vdd__p26 vdd__p8 56620.6
Rw1332 vdd__p26 vdd__p9 375019
Rw1333 vdd__p27 vdd__p28 1050.46
Rw1334 vdd__p27 vdd__p29 1310.61
Rw1335 vdd__p27 vdd__p3 29386.6
Rw1336 vdd__p27 vdd__p30 1535.82
Rw1337 vdd__p27 vdd__p31 1523.34
Rw1338 vdd__p27 vdd__p32 1639.69
Rw1339 vdd__p27 vdd__p33 1745.38
Rw1340 vdd__p27 vdd__p34 1883.27
Rw1341 vdd__p27 vdd__p36 106.931
Rw1342 vdd__p27 vdd__p37 425.37
Rw1343 vdd__p27 vdd__p38 770.796
Rw1344 vdd__p27 vdd__p4 309833
Rw1345 vdd__p27 vdd__p5 60916.9
Rw1346 vdd__p27 vdd__p6 21398.1
Rw1347 vdd__p27 vdd__p7 243119
Rw1348 vdd__p27 vdd__p8 53406.9
Rw1349 vdd__p27 vdd__p9 353734
Rw1350 vdd__p28 vdd__p29 1232.53
Rw1351 vdd__p28 vdd__p3 31848.3
Rw1352 vdd__p28 vdd__p30 1444.32
Rw1353 vdd__p28 vdd__p31 1432.58
Rw1354 vdd__p28 vdd__p32 1542
Rw1355 vdd__p28 vdd__p33 1641.39
Rw1356 vdd__p28 vdd__p34 1771.07
Rw1357 vdd__p28 vdd__p36 100.56
Rw1358 vdd__p28 vdd__p37 400.027
Rw1359 vdd__p28 vdd__p38 724.873
Rw1360 vdd__p28 vdd__p4 335788
Rw1361 vdd__p28 vdd__p5 66019.9
Rw1362 vdd__p28 vdd__p6 20123.2
Rw1363 vdd__p28 vdd__p7 228634
Rw1364 vdd__p28 vdd__p8 50224.9
Rw1365 vdd__p28 vdd__p9 332658
Rw1366 vdd__p29 vdd__p3 39735.7
Rw1367 vdd__p29 vdd__p30 1203.03
Rw1368 vdd__p29 vdd__p31 1193.26
Rw1369 vdd__p29 vdd__p32 1284.39
Rw1370 vdd__p29 vdd__p33 1367.18
Rw1371 vdd__p29 vdd__p34 1475.2
Rw1372 vdd__p29 vdd__p36 83.7608
Rw1373 vdd__p29 vdd__p37 333.199
Rw1374 vdd__p29 vdd__p38 603.776
Rw1375 vdd__p29 vdd__p4 418949
Rw1376 vdd__p29 vdd__p5 82370.2
Rw1377 vdd__p29 vdd__p6 16761.4
Rw1378 vdd__p29 vdd__p7 190439
Rw1379 vdd__p29 vdd__p8 41834.4
Rw1380 vdd__p29 vdd__p9 277085
Rw1381 vdd__p3 vdd__p30 46563.8
Rw1382 vdd__p3 vdd__p31 46185.3
Rw1383 vdd__p3 vdd__p32 49712.8
Rw1384 vdd__p3 vdd__p33 52917.3
Rw1385 vdd__p3 vdd__p34 57097.9
Rw1386 vdd__p3 vdd__p36 3241.99
Rw1387 vdd__p3 vdd__p37 12896.6
Rw1388 vdd__p3 vdd__p38 23369.4
Rw1389 vdd__p3 vdd__p4 618.874
Rw1390 vdd__p3 vdd__p5 121.678
Rw1391 vdd__p3 vdd__p6 648756
Rw1392 vdd__p30 vdd__p31 1240.27
Rw1393 vdd__p30 vdd__p32 1335
Rw1394 vdd__p30 vdd__p33 1421.05
Rw1395 vdd__p30 vdd__p34 1533.32
Rw1396 vdd__p30 vdd__p36 87.0609
Rw1397 vdd__p30 vdd__p37 346.327
Rw1398 vdd__p30 vdd__p38 627.565
Rw1399 vdd__p30 vdd__p4 490939
Rw1400 vdd__p30 vdd__p5 96524.4
Rw1401 vdd__p30 vdd__p6 17421.8
Rw1402 vdd__p30 vdd__p7 197942
Rw1403 vdd__p30 vdd__p8 43482.7
Rw1404 vdd__p30 vdd__p9 288002
Rw1405 vdd__p31 vdd__p32 1171.38
Rw1406 vdd__p31 vdd__p33 1246.88
Rw1407 vdd__p31 vdd__p34 1345.39
Rw1408 vdd__p31 vdd__p36 76.3905
Rw1409 vdd__p31 vdd__p37 303.88
Rw1410 vdd__p31 vdd__p38 550.649
Rw1411 vdd__p31 vdd__p4 486949
Rw1412 vdd__p31 vdd__p5 95739.8
Rw1413 vdd__p31 vdd__p6 15286.6
Rw1414 vdd__p31 vdd__p7 173682
Rw1415 vdd__p31 vdd__p8 38153.3
Rw1416 vdd__p31 vdd__p9 252704
Rw1417 vdd__p32 vdd__p33 1183.86
Rw1418 vdd__p32 vdd__p34 1277.39
Rw1419 vdd__p32 vdd__p36 72.5294
Rw1420 vdd__p32 vdd__p37 288.521
Rw1421 vdd__p32 vdd__p38 522.817
Rw1422 vdd__p32 vdd__p4 524141
Rw1423 vdd__p32 vdd__p5 103052
Rw1424 vdd__p32 vdd__p6 14513.9
Rw1425 vdd__p32 vdd__p7 164903
Rw1426 vdd__p32 vdd__p8 36224.9
Rw1427 vdd__p32 vdd__p9 239931
Rw1428 vdd__p33 vdd__p34 1195.58
Rw1429 vdd__p33 vdd__p36 67.8845
Rw1430 vdd__p33 vdd__p37 270.043
Rw1431 vdd__p33 vdd__p38 489.335
Rw1432 vdd__p33 vdd__p4 557926
Rw1433 vdd__p33 vdd__p5 109695
Rw1434 vdd__p33 vdd__p6 13584.4
Rw1435 vdd__p33 vdd__p7 154343
Rw1436 vdd__p33 vdd__p8 33905
Rw1437 vdd__p33 vdd__p9 224565
Rw1438 vdd__p34 vdd__p36 31.309
Rw1439 vdd__p34 vdd__p37 255.341
Rw1440 vdd__p34 vdd__p38 462.693
Rw1441 vdd__p34 vdd__p4 602004
Rw1442 vdd__p34 vdd__p5 118361
Rw1443 vdd__p34 vdd__p6 12844.8
Rw1444 vdd__p34 vdd__p7 145940
Rw1445 vdd__p34 vdd__p8 32059.1
Rw1446 vdd__p34 vdd__p9 212339
Rw1447 vdd__p36 vdd__p37 14.4981
Rw1448 vdd__p36 vdd__p38 26.2715
Rw1449 vdd__p36 vdd__p4 34181.5
Rw1450 vdd__p36 vdd__p5 6720.47
Rw1451 vdd__p36 vdd__p6 729.322
Rw1452 vdd__p36 vdd__p7 8286.37
Rw1453 vdd__p36 vdd__p8 1820.3
Rw1454 vdd__p36 vdd__p9 12056.5
Rw1455 vdd__p37 vdd__p38 5.68572
Rw1456 vdd__p37 vdd__p4 135973
Rw1457 vdd__p37 vdd__p5 26733.9
Rw1458 vdd__p37 vdd__p6 157.841
Rw1459 vdd__p37 vdd__p7 1793.35
Rw1460 vdd__p37 vdd__p8 393.952
Rw1461 vdd__p37 vdd__p9 2609.29
Rw1462 vdd__p38 vdd__p4 246392
Rw1463 vdd__p38 vdd__p5 48443.5
Rw1464 vdd__p38 vdd__p6 81.6829
Rw1465 vdd__p38 vdd__p7 928.061
Rw1466 vdd__p38 vdd__p8 203.87
Rw1467 vdd__p38 vdd__p9 1350.31
Rw1468 vdd__p4 vdd__p5 66.266
Rw1469 vdd__p6 vdd__p7 896.401
Rw1470 vdd__p6 vdd__p8 196.916
Rw1471 vdd__p6 vdd__p9 1304.25
Rw1472 vdd__p7 vdd__p8 81.3386
Rw1473 vdd__p7 vdd__p9 538.736
Rw1474 vdd__p8 vdd__p9 114.1
Rw1475 vref vref__p0 37.8501
Rw1476 vref vref__p1 36.462
Rw1477 vref vref__p11 36.7663
Rw1478 vref vref__p12 47.8742
Rw1479 vref vref__p2 34.0556
Rw1480 vref vref__p3 19.1317
Rw1481 vref vref__p4 39.0922
Rw1482 vref vref__p5 146.284
Rw1483 vref vref__p6 53.0763
Rw1484 vref vref__p7 188.985
Rw1485 vref vref__p8 63.294
Rw1486 vref vref__p9 65.7068
Rw1487 vref__p0 vref__p1 31.9297
Rw1488 vref__p0 vref__p11 53.8972
Rw1489 vref__p0 vref__p12 70.1805
Rw1490 vref__p0 vref__p2 39.3748
Rw1491 vref__p0 vref__p3 151.241
Rw1492 vref__p0 vref__p4 57.3067
Rw1493 vref__p0 vref__p5 214.444
Rw1494 vref__p0 vref__p6 77.8066
Rw1495 vref__p0 vref__p7 277.04
Rw1496 vref__p0 vref__p8 92.7851
Rw1497 vref__p0 vref__p9 96.322
Rw1498 vref__p1 vref__p11 51.9206
Rw1499 vref__p1 vref__p12 67.6068
Rw1500 vref__p1 vref__p2 37.9308
Rw1501 vref__p1 vref__p3 145.695
Rw1502 vref__p1 vref__p4 55.2051
Rw1503 vref__p1 vref__p5 206.579
Rw1504 vref__p1 vref__p6 74.9532
Rw1505 vref__p1 vref__p7 266.88
Rw1506 vref__p1 vref__p8 89.3824
Rw1507 vref__p1 vref__p9 92.7896
Rw1508 vref__p11 vref__p12 35.5995
Rw1509 vref__p11 vref__p2 48.494
Rw1510 vref__p11 vref__p3 141.005
Rw1511 vref__p11 vref__p4 37.6875
Rw1512 vref__p11 vref__p5 19.3163
Rw1513 vref__p11 vref__p6 39.4679
Rw1514 vref__p11 vref__p7 140.531
Rw1515 vref__p11 vref__p8 47.0658
Rw1516 vref__p11 vref__p9 48.86
Rw1517 vref__p12 vref__p2 63.145
Rw1518 vref__p12 vref__p3 183.605
Rw1519 vref__p12 vref__p4 49.0736
Rw1520 vref__p12 vref__p5 135.651
Rw1521 vref__p12 vref__p6 34.6862
Rw1522 vref__p12 vref__p7 18.9097
Rw1523 vref__p12 vref__p8 32.4965
Rw1524 vref__p12 vref__p9 33.7353
Rw1525 vref__p2 vref__p3 136.08
Rw1526 vref__p2 vref__p4 51.5617
Rw1527 vref__p2 vref__p5 192.946
Rw1528 vref__p2 vref__p6 70.0066
Rw1529 vref__p2 vref__p7 249.267
Rw1530 vref__p2 vref__p8 83.4835
Rw1531 vref__p2 vref__p9 86.6658
Rw1532 vref__p3 vref__p4 149.925
Rw1533 vref__p3 vref__p5 561.025
Rw1534 vref__p3 vref__p6 203.557
Rw1535 vref__p3 vref__p7 724.789
Rw1536 vref__p3 vref__p8 242.743
Rw1537 vref__p3 vref__p9 251.996
Rw1538 vref__p4 vref__p5 149.949
Rw1539 vref__p4 vref__p6 54.4061
Rw1540 vref__p4 vref__p7 193.72
Rw1541 vref__p4 vref__p8 64.8798
Rw1542 vref__p4 vref__p9 67.353
Rw1543 vref__p5 vref__p6 150.392
Rw1544 vref__p5 vref__p7 535.489
Rw1545 vref__p5 vref__p8 179.344
Rw1546 vref__p5 vref__p9 186.18
Rw1547 vref__p6 vref__p7 136.925
Rw1548 vref__p6 vref__p8 45.8584
Rw1549 vref__p6 vref__p9 47.6065
Rw1550 vref__p7 vref__p8 123.42
Rw1551 vref__p7 vref__p9 128.124
Rw1552 vref__p8 vref__p9 31.9637
Rw1553 vrefl vrefl__p0 36.1912
Rw1554 vrefl vrefl__p1 34.864
Rw1555 vrefl vrefl__p10 10873
Rw1556 vrefl vrefl__p11 10115.9
Rw1557 vrefl vrefl__p12 9688.32
Rw1558 vrefl vrefl__p13 11145.8
Rw1559 vrefl vrefl__p14 12654.8
Rw1560 vrefl vrefl__p15 14018.3
Rw1561 vrefl vrefl__p16 15067.5
Rw1562 vrefl vrefl__p17 15641.8
Rw1563 vrefl vrefl__p19 23.5375
Rw1564 vrefl vrefl__p2 32.4364
Rw1565 vrefl vrefl__p3 29.2813
Rw1566 vrefl vrefl__p4 34.6149
Rw1567 vrefl vrefl__p5 54.1611
Rw1568 vrefl vrefl__p6 29.6978
Rw1569 vrefl vrefl__p7 31.9204
Rw1570 vrefl vrefl__p8 33.1372
Rw1571 vrefl vrefl__p9 11286.9
Rw1572 vrefl__p0 vrefl__p1 28.5577
Rw1573 vrefl__p0 vrefl__p19 12228.9
Rw1574 vrefl__p0 vrefl__p2 33.8538
Rw1575 vrefl__p0 vrefl__p3 39.7034
Rw1576 vrefl__p0 vrefl__p4 371.992
Rw1577 vrefl__p0 vrefl__p5 105.073
Rw1578 vrefl__p0 vrefl__p6 57.614
Rw1579 vrefl__p0 vrefl__p7 61.9258
Rw1580 vrefl__p0 vrefl__p8 64.2864
Rw1581 vrefl__p1 vrefl__p19 11780.5
Rw1582 vrefl__p1 vrefl__p2 32.6123
Rw1583 vrefl__p1 vrefl__p3 38.2473
Rw1584 vrefl__p1 vrefl__p4 358.35
Rw1585 vrefl__p1 vrefl__p5 101.22
Rw1586 vrefl__p1 vrefl__p6 55.5011
Rw1587 vrefl__p1 vrefl__p7 59.6548
Rw1588 vrefl__p1 vrefl__p8 61.9288
Rw1589 vrefl__p10 vrefl__p11 34.923
Rw1590 vrefl__p10 vrefl__p12 155.608
Rw1591 vrefl__p10 vrefl__p13 47.5836
Rw1592 vrefl__p10 vrefl__p14 54.0259
Rw1593 vrefl__p10 vrefl__p15 59.8471
Rw1594 vrefl__p10 vrefl__p16 64.3261
Rw1595 vrefl__p10 vrefl__p17 66.7782
Rw1596 vrefl__p10 vrefl__p19 32.2863
Rw1597 vrefl__p10 vrefl__p9 30.1219
Rw1598 vrefl__p11 vrefl__p12 144.773
Rw1599 vrefl__p11 vrefl__p13 44.2704
Rw1600 vrefl__p11 vrefl__p14 50.264
Rw1601 vrefl__p11 vrefl__p15 55.6799
Rw1602 vrefl__p11 vrefl__p16 59.847
Rw1603 vrefl__p11 vrefl__p17 62.1284
Rw1604 vrefl__p11 vrefl__p19 30.0382
Rw1605 vrefl__p11 vrefl__p9 36.2525
Rw1606 vrefl__p12 vrefl__p13 149.347
Rw1607 vrefl__p12 vrefl__p14 169.567
Rw1608 vrefl__p12 vrefl__p15 187.838
Rw1609 vrefl__p12 vrefl__p16 201.896
Rw1610 vrefl__p12 vrefl__p17 209.592
Rw1611 vrefl__p12 vrefl__p19 28.7686
Rw1612 vrefl__p12 vrefl__p9 161.532
Rw1613 vrefl__p13 vrefl__p14 39.159
Rw1614 vrefl__p13 vrefl__p15 43.3783
Rw1615 vrefl__p13 vrefl__p16 46.6247
Rw1616 vrefl__p13 vrefl__p17 48.4021
Rw1617 vrefl__p13 vrefl__p19 33.0964
Rw1618 vrefl__p13 vrefl__p9 49.3951
Rw1619 vrefl__p14 vrefl__p15 37.0529
Rw1620 vrefl__p14 vrefl__p16 39.826
Rw1621 vrefl__p14 vrefl__p17 41.3441
Rw1622 vrefl__p14 vrefl__p19 37.5772
Rw1623 vrefl__p14 vrefl__p9 56.0826
Rw1624 vrefl__p15 vrefl__p16 33.6385
Rw1625 vrefl__p15 vrefl__p17 34.9208
Rw1626 vrefl__p15 vrefl__p19 41.6261
Rw1627 vrefl__p15 vrefl__p9 62.1254
Rw1628 vrefl__p16 vrefl__p17 29.2596
Rw1629 vrefl__p16 vrefl__p19 44.7414
Rw1630 vrefl__p16 vrefl__p9 66.7749
Rw1631 vrefl__p17 vrefl__p19 46.447
Rw1632 vrefl__p17 vrefl__p9 69.3204
Rw1633 vrefl__p19 vrefl__p2 10960.2
Rw1634 vrefl__p19 vrefl__p3 9894.09
Rw1635 vrefl__p19 vrefl__p4 11696.3
Rw1636 vrefl__p19 vrefl__p5 18300.9
Rw1637 vrefl__p19 vrefl__p6 10034.8
Rw1638 vrefl__p19 vrefl__p7 10785.8
Rw1639 vrefl__p19 vrefl__p8 11197
Rw1640 vrefl__p19 vrefl__p9 33.5155
Rw1641 vrefl__p2 vrefl__p3 35.5842
Rw1642 vrefl__p2 vrefl__p4 333.398
Rw1643 vrefl__p2 vrefl__p5 94.1716
Rw1644 vrefl__p2 vrefl__p6 51.6365
Rw1645 vrefl__p2 vrefl__p7 55.501
Rw1646 vrefl__p2 vrefl__p8 57.6167
Rw1647 vrefl__p3 vrefl__p4 300.968
Rw1648 vrefl__p3 vrefl__p5 85.0116
Rw1649 vrefl__p3 vrefl__p6 46.6139
Rw1650 vrefl__p3 vrefl__p7 50.1025
Rw1651 vrefl__p3 vrefl__p8 52.0124
Rw1652 vrefl__p4 vrefl__p5 556.696
Rw1653 vrefl__p4 vrefl__p6 305.25
Rw1654 vrefl__p4 vrefl__p7 328.094
Rw1655 vrefl__p4 vrefl__p8 340.601
Rw1656 vrefl__p5 vrefl__p6 70.567
Rw1657 vrefl__p5 vrefl__p7 75.8482
Rw1658 vrefl__p5 vrefl__p8 78.7396
Rw1659 vrefl__p6 vrefl__p7 32.6227
Rw1660 vrefl__p6 vrefl__p8 33.8663
Rw1661 vrefl__p7 vrefl__p8 28.5662
Rw1662 xc4_din xc4_din__p1 51.0242
Rw1663 xc4_din xc4_din__p2 346.175
Rw1664 xc4_din__p1 xc4_din__p2 86.0265
Rw1665 xc4_dip xc4_dip__p1 49.3969
Rw1666 xc4_dip xc4_dip__p2 330.069
Rw1667 xc4_dip__p1 xc4_dip__p2 87.235
Rw1668 xc4_lt xc4_lt__p1 10.8365
Rw1669 xc4_lt xc4_lt__p2 12.6193
Rw1670 xc4_lt__p1 xc4_lt__p2 120.796
Rw1671 xc4_outnb xc4_outnb__p1 47.7242
Rw1672 xc4_outpb xc4_outpb__p1 47.3722
Rw1673 xc4_xs1_tail xc4_xs1_tail__p1 71.5986
Rw1674 xc4_xs1_tail xc4_xs1_tail__p2 142.261
Rw1675 xc4_xs1_tail__p1 xc4_xs1_tail__p2 154.206
Rw1676 xc4_xs1_tail0 xc4_xs1_tail0__p1 29.2884
Rw1677 xc5_din xc5_din__p1 130.063
Rw1678 xc5_din xc5_din__p2 74.042
Rw1679 xc5_din__p1 xc5_din__p2 66.6396
Rw1680 xc5_dip xc5_dip__p1 129.665
Rw1681 xc5_dip xc5_dip__p2 75.5526
Rw1682 xc5_dip__p1 xc5_dip__p2 65.1387
Rw1683 xc5_lt xc5_lt__p1 165.919
Rw1684 xc5_lt xc5_lt__p2 166.056
Rw1685 xc5_lt__p1 xc5_lt__p2 20.8871
Rw1686 xc5_outnb xc5_outnb__p1 44.1702
Rw1687 xc5_outpb xc5_outpb__p1 44.1702
Rw1688 xc5_xs1_tail xc5_xs1_tail__p1 59.2156
Rw1689 xc5_xs1_tail__p1 xc5_xs1_tail__p2 19.0185
Rw1690 xc5_xs1_tail0 xc5_xs1_tail0__p1 29.0295
Rw1691 xs0n_cbn xs0n_cbn__p1 1089.56
Rw1692 xs0n_cbn xs0n_cbn__p2 16589.4
Rw1693 xs0n_cbn xs0n_cbn__p3 784.446
Rw1694 xs0n_cbn xs0n_cbn__p4 21.0451
Rw1695 xs0n_cbn__p1 xs0n_cbn__p2 9.96169
Rw1696 xs0n_cbn__p1 xs0n_cbn__p3 1561.64
Rw1697 xs0n_cbn__p1 xs0n_cbn__p4 21.0507
Rw1698 xs0n_cbn__p2 xs0n_cbn__p3 23777.3
Rw1699 xs0n_cbn__p2 xs0n_cbn__p4 320.514
Rw1700 xs0n_cbn__p3 xs0n_cbn__p4 30.1636
Rw1701 xs0n_cbp xs0n_cbp__p1 9.57598
Rw1702 xs0n_cbp xs0n_cbp__p2 59.1671
Rw1703 xs0n_cbp__p1 xs0n_cbp__p2 1243.71
Rw1704 xs0n_g xs0n_g__p1 0.67694
Rw1705 xs0n_g__p1 xs0n_g__p2 25.2118
Rw1706 xs0n_g__p1 xs0n_g__p3 209.923
Rw1707 xs0n_g__p1 xs0n_g__p4 198.15
Rw1708 xs0n_g__p1 xs0n_g__p5 133.079
Rw1709 xs0n_g__p2 xs0n_g__p3 167.588
Rw1710 xs0n_g__p2 xs0n_g__p4 158.189
Rw1711 xs0n_g__p2 xs0n_g__p5 106.241
Rw1712 xs0n_g__p3 xs0n_g__p4 23.6529
Rw1713 xs0n_g__p3 xs0n_g__p5 102.437
Rw1714 xs0n_g__p4 xs0n_g__p5 96.6917
Rw1715 xs0n_n10 xs0n_n10__p1 46.1685
Rw1716 xs0n_x xs0n_x__p1 1.00108
Rw1717 xs0n_x xs0n_x__p2 42.4395
Rw1718 xs0n_x xs0n_x__p3 126.624
Rw1719 xs0n_x__p1 xs0n_x__p2 60.0491
Rw1720 xs0n_x__p1 xs0n_x__p3 179.165
Rw1721 xs0n_x__p2 xs0n_x__p3 61.5879
Rw1722 xs0p_cbn xs0p_cbn__p1 90.3104
Rw1723 xs0p_cbn xs0p_cbn__p2 2073.02
Rw1724 xs0p_cbn xs0p_cbn__p3 36.3159
Rw1725 xs0p_cbn xs0p_cbn__p4 107.321
Rw1726 xs0p_cbn__p1 xs0p_cbn__p2 9.87285
Rw1727 xs0p_cbn__p1 xs0p_cbn__p3 160.393
Rw1728 xs0p_cbn__p1 xs0p_cbn__p4 26.4214
Rw1729 xs0p_cbn__p2 xs0p_cbn__p3 3681.73
Rw1730 xs0p_cbn__p2 xs0p_cbn__p4 606.486
Rw1731 xs0p_cbn__p3 xs0p_cbn__p4 190.604
Rw1732 xs0p_cbp xs0p_cbp__p1 9.5749
Rw1733 xs0p_cbp xs0p_cbp__p2 60.089
Rw1734 xs0p_cbp__p1 xs0p_cbp__p2 1263.09
Rw1735 xs0p_g xs0p_g__p1 0.67694
Rw1736 xs0p_g__p1 xs0p_g__p2 25.2118
Rw1737 xs0p_g__p1 xs0p_g__p3 209.923
Rw1738 xs0p_g__p1 xs0p_g__p4 198.15
Rw1739 xs0p_g__p1 xs0p_g__p5 133.079
Rw1740 xs0p_g__p2 xs0p_g__p3 167.588
Rw1741 xs0p_g__p2 xs0p_g__p4 158.189
Rw1742 xs0p_g__p2 xs0p_g__p5 106.241
Rw1743 xs0p_g__p3 xs0p_g__p4 23.6529
Rw1744 xs0p_g__p3 xs0p_g__p5 102.437
Rw1745 xs0p_g__p4 xs0p_g__p5 96.6917
Rw1746 xs0p_n10 xs0p_n10__p1 46.1685
Rw1747 xs0p_x xs0p_x__p1 1.00105
Rw1748 xs0p_x xs0p_x__p2 42.5398
Rw1749 xs0p_x xs0p_x__p3 126.923
Rw1750 xs0p_x__p1 xs0p_x__p2 60.1909
Rw1751 xs0p_x__p1 xs0p_x__p3 179.588
Rw1752 xs0p_x__p2 xs0p_x__p3 61.4978
Rw1753 xs1n_cbn xs1n_cbn__p1 31.9914
Rw1754 xs1n_cbn xs1n_cbn__p2 1328.66
Rw1755 xs1n_cbn xs1n_cbn__p3 4662.46
Rw1756 xs1n_cbn xs1n_cbn__p4 31.3431
Rw1757 xs1n_cbn__p1 xs1n_cbn__p2 9.86002
Rw1758 xs1n_cbn__p1 xs1n_cbn__p3 4007.11
Rw1759 xs1n_cbn__p1 xs1n_cbn__p4 26.9375
Rw1760 xs1n_cbn__p2 xs1n_cbn__p3 166422
Rw1761 xs1n_cbn__p2 xs1n_cbn__p4 1118.76
Rw1762 xs1n_cbn__p3 xs1n_cbn__p4 29.2978
Rw1763 xs1n_cbp xs1n_cbp__p1 9.54422
Rw1764 xs1n_cbp xs1n_cbp__p2 58.8
Rw1765 xs1n_cbp__p1 xs1n_cbp__p2 1320.09
Rw1766 xs1n_g xs1n_g__p1 0.6347
Rw1767 xs1n_g__p1 xs1n_g__p2 50.4222
Rw1768 xs1n_g__p1 xs1n_g__p3 350.24
Rw1769 xs1n_g__p1 xs1n_g__p4 405.356
Rw1770 xs1n_g__p1 xs1n_g__p5 481.735
Rw1771 xs1n_g__p2 xs1n_g__p3 112.116
Rw1772 xs1n_g__p2 xs1n_g__p4 129.759
Rw1773 xs1n_g__p2 xs1n_g__p5 154.209
Rw1774 xs1n_g__p3 xs1n_g__p4 30.5272
Rw1775 xs1n_g__p3 xs1n_g__p5 36.2793
Rw1776 xs1n_g__p4 xs1n_g__p5 33.2348
Rw1777 xs1n_n10 xs1n_n10__p1 10.7757
Rw1778 xs1n_x xs1n_x__p1 1.43436
Rw1779 xs1n_x xs1n_x__p2 61.0361
Rw1780 xs1n_x xs1n_x__p3 177.702
Rw1781 xs1n_x__p1 xs1n_x__p2 42.6192
Rw1782 xs1n_x__p1 xs1n_x__p3 124.083
Rw1783 xs1n_x__p2 xs1n_x__p3 61.9394
Rw1784 xs1p_cbn xs1p_cbn__p1 90.6795
Rw1785 xs1p_cbn xs1p_cbn__p2 1917.8
Rw1786 xs1p_cbn xs1p_cbn__p3 36.2644
Rw1787 xs1p_cbn xs1p_cbn__p4 107.009
Rw1788 xs1p_cbn__p1 xs1p_cbn__p2 9.94467
Rw1789 xs1p_cbn__p1 xs1p_cbn__p3 161.481
Rw1790 xs1p_cbn__p1 xs1p_cbn__p4 26.5667
Rw1791 xs1p_cbn__p2 xs1p_cbn__p3 3415.2
Rw1792 xs1p_cbn__p2 xs1p_cbn__p4 561.866
Rw1793 xs1p_cbn__p3 xs1p_cbn__p4 190.561
Rw1794 xs1p_cbp xs1p_cbp__p1 9.54302
Rw1795 xs1p_cbp xs1p_cbp__p2 59.8889
Rw1796 xs1p_cbp__p1 xs1p_cbp__p2 1344.53
Rw1797 xs1p_g xs1p_g__p1 0.6347
Rw1798 xs1p_g__p1 xs1p_g__p2 25.0282
Rw1799 xs1p_g__p1 xs1p_g__p3 227.075
Rw1800 xs1p_g__p1 xs1p_g__p4 204.371
Rw1801 xs1p_g__p1 xs1p_g__p5 130.835
Rw1802 xs1p_g__p2 xs1p_g__p3 181.724
Rw1803 xs1p_g__p2 xs1p_g__p4 163.555
Rw1804 xs1p_g__p2 xs1p_g__p5 104.705
Rw1805 xs1p_g__p3 xs1p_g__p4 24.22
Rw1806 xs1p_g__p3 xs1p_g__p5 104.731
Rw1807 xs1p_g__p4 xs1p_g__p5 94.2599
Rw1808 xs1p_n10 xs1p_n10__p1 46.209
Rw1809 xs1p_x xs1p_x__p1 1.00105
Rw1810 xs1p_x xs1p_x__p2 42.5398
Rw1811 xs1p_x xs1p_x__p3 126.923
Rw1812 xs1p_x__p1 xs1p_x__p2 60.1909
Rw1813 xs1p_x__p1 xs1p_x__p3 179.588
Rw1814 xs1p_x__p2 xs1p_x__p3 61.4978
Cp0 bn0 bn1 2.76e-16
Cp1 bn0 bn10 4.539e-17
Cp2 bn0 bn11 4.486e-17
Cp3 bn0 bn12 6.037e-17
Cp4 bn0 bn2 7.057e-15
Cp5 bn0 bn3 2.248e-16
Cp6 bn0 bn4 2.663e-16
Cp7 bn0 bn5 1.004e-15
Cp8 bn0 bn6 9.648e-16
Cp9 bn0 bn7 1.721e-15
Cp10 bn0 bn8 4.759e-17
Cp11 bn0 bn9 4.682e-17
Cp12 bn0 bp11 1.837e-16
Cp13 bn0 bp12 6.813e-16
Cp14 bn0 cn0 5.87e-16
Cp15 bn0 cn1 7.882e-17
Cp16 bn0 gnd 3.545e-15
Cp17 bn0 lsb_n 9.89e-17
Cp18 bn0 lsb_p 5.522e-17
Cp19 bn0 on 1.102e-19
Cp20 bn0 rstb 6.85e-17
Cp21 bn0 vdd 1.531e-16
Cp22 bn0 vrefl 7.359e-16
Cp23 bn0 xc4_din 1.294e-16
Cp24 bn0 xc4_dip 2.382e-16
Cp25 bn0 xc4_outnb 6.621e-17
Cp26 bn0 xc4_outpb 2.682e-17
Cp27 bn1 bn10 7.366e-17
Cp28 bn1 bn11 5.327e-16
Cp29 bn1 bn12 5.054e-16
Cp30 bn1 bn2 9.97e-16
Cp31 bn1 bn3 8.079e-16
Cp32 bn1 bn4 5.046e-16
Cp33 bn1 bn5 1.047e-15
Cp34 bn1 bn6 1.976e-15
Cp35 bn1 bn7 1.573e-15
Cp36 bn1 bn8 5.488e-17
Cp37 bn1 bn9 5.508e-17
Cp38 bn1 bp12 1.302e-17
Cp39 bn1 cn1 5.112e-16
Cp40 bn1 cn2 7.883e-17
Cp41 bn1 gnd 2.27e-15
Cp42 bn1 lsb_n 1.281e-16
Cp43 bn1 lsb_p 5.395e-17
Cp44 bn1 on 2.31e-18
Cp45 bn1 rstb 5.609e-17
Cp46 bn1 vdd 3.367e-16
Cp47 bn1 vrefl 6.283e-16
Cp48 bn1 xc4_din 1.051e-16
Cp49 bn1 xc4_dip 1.547e-15
Cp50 bn1 xc4_outnb 6.431e-17
Cp51 bn1 xc4_outpb 2.773e-17
Cp52 bn10 bn11 2.093e-14
Cp53 bn10 bn12 5.759e-15
Cp54 bn10 bn2 3.845e-17
Cp55 bn10 bn3 3.845e-17
Cp56 bn10 bn4 3.845e-17
Cp57 bn10 bn5 4.892e-16
Cp58 bn10 bn6 2.085e-15
Cp59 bn10 bn7 2.302e-15
Cp60 bn10 bn8 1.121e-15
Cp61 bn10 bn9 1.303e-14
Cp62 bn10 bp0 4.911e-17
Cp63 bn10 bp1 4.662e-17
Cp64 bn10 bp10 2.248e-15
Cp65 bn10 bp11 5.365e-17
Cp66 bn10 bp12 3.882e-17
Cp67 bn10 bp2 4.145e-17
Cp68 bn10 bp3 3.846e-17
Cp69 bn10 bp4 3.882e-17
Cp70 bn10 bp5 3.882e-17
Cp71 bn10 bp6 3.882e-17
Cp72 bn10 bp7 3.882e-17
Cp73 bn10 bp8 2.021e-16
Cp74 bn10 bp9 7.85e-17
Cp75 bn10 cn10 3.319e-16
Cp76 bn10 cn11 5.177e-17
Cp77 bn10 cn12 3.156e-18
Cp78 bn10 cn8 1.277e-16
Cp79 bn10 cn9 4.232e-16
Cp80 bn10 gnd 4.874e-15
Cp81 bn10 lsb_n 6.709e-16
Cp82 bn10 lsb_p 3.993e-16
Cp83 bn10 rstb 9.296e-17
Cp84 bn10 vdd 4.833e-17
Cp85 bn10 vref 1.571e-15
Cp86 bn10 xc4_din 1.098e-16
Cp87 bn10 xc4_dip 1.596e-16
Cp88 bn11 bn12 3.388e-14
Cp89 bn11 bn2 3.792e-17
Cp90 bn11 bn3 3.792e-17
Cp91 bn11 bn4 3.792e-17
Cp92 bn11 bn5 6.931e-17
Cp93 bn11 bn6 2.96e-15
Cp94 bn11 bn7 3.34e-15
Cp95 bn11 bn8 5.258e-16
Cp96 bn11 bn9 6.014e-16
Cp97 bn11 bp0 9.649e-17
Cp98 bn11 bp1 3.792e-17
Cp99 bn11 bp10 5.726e-16
Cp100 bn11 bp11 4.598e-15
Cp101 bn11 bp12 5.861e-17
Cp102 bn11 bp2 3.275e-17
Cp103 bn11 bp3 3.846e-17
Cp104 bn11 bp4 4.971e-17
Cp105 bn11 bp5 4.698e-16
Cp106 bn11 bp6 4.754e-16
Cp107 bn11 bp7 5.071e-17
Cp108 bn11 bp8 1.873e-16
Cp109 bn11 bp9 2.238e-16
Cp110 bn11 cn10 1.193e-16
Cp111 bn11 cn11 3.839e-16
Cp112 bn11 cn12 4.945e-18
Cp113 bn11 cn8 8.262e-19
Cp114 bn11 cn9 6.449e-17
Cp115 bn11 gnd 5.316e-15
Cp116 bn11 lsb_n 6.01e-16
Cp117 bn11 lsb_p 1.694e-16
Cp118 bn11 rstb 5.669e-16
Cp119 bn11 vdd 2.835e-17
Cp120 bn11 vref 1.273e-15
Cp121 bn11 xc4_din 1.175e-16
Cp122 bn11 xc4_dip 8.018e-17
Cp123 bn12 bn2 3.882e-17
Cp124 bn12 bn3 3.882e-17
Cp125 bn12 bn4 3.882e-17
Cp126 bn12 bn5 4.317e-17
Cp127 bn12 bn6 5.075e-15
Cp128 bn12 bn7 5.505e-15
Cp129 bn12 bn8 1.244e-15
Cp130 bn12 bn9 3.1e-15
Cp131 bn12 bp0 4.93e-16
Cp132 bn12 bp1 4.199e-16
Cp133 bn12 bp10 3.478e-16
Cp134 bn12 bp11 5.507e-16
Cp135 bn12 bp12 1.032e-14
Cp136 bn12 bp2 4.482e-17
Cp137 bn12 bp3 3.104e-16
Cp138 bn12 bp4 5.713e-16
Cp139 bn12 bp5 8.047e-17
Cp140 bn12 bp6 7.773e-17
Cp141 bn12 bp7 5.569e-16
Cp142 bn12 bp8 8.083e-16
Cp143 bn12 bp9 8.832e-16
Cp144 bn12 cn10 5.251e-17
Cp145 bn12 cn11 1.472e-16
Cp146 bn12 cn12 6.026e-16
Cp147 bn12 cp11 1.054e-19
Cp148 bn12 cp12 6.79e-18
Cp149 bn12 gnd 8.286e-15
Cp150 bn12 lsb_n 1.732e-14
Cp151 bn12 lsb_p 4.898e-16
Cp152 bn12 rstb 6.354e-17
Cp153 bn12 top_n 1.311e-17
Cp154 bn12 vdd 3.292e-17
Cp155 bn12 vref 1.436e-15
Cp156 bn12 xc4_din 1.392e-16
Cp157 bn12 xc4_dip 9.104e-17
Cp158 bn2 bn3 1.446e-14
Cp159 bn2 bn4 4.308e-16
Cp160 bn2 bn5 3.373e-15
Cp161 bn2 bn6 1.877e-15
Cp162 bn2 bn7 2.699e-15
Cp163 bn2 bn8 4.065e-17
Cp164 bn2 bn9 3.988e-17
Cp165 bn2 bp0 5.211e-16
Cp166 bn2 bp1 4.677e-16
Cp167 bn2 bp10 4.595e-17
Cp168 bn2 bp11 4.598e-17
Cp169 bn2 bp12 3.024e-17
Cp170 bn2 bp2 5.659e-17
Cp171 bn2 bp3 4.685e-17
Cp172 bn2 bp4 4.632e-17
Cp173 bn2 bp5 4.632e-17
Cp174 bn2 bp6 4.632e-17
Cp175 bn2 bp7 4.632e-17
Cp176 bn2 bp8 4.776e-17
Cp177 bn2 bp9 4.542e-17
Cp178 bn2 cn2 5.11e-16
Cp179 bn2 cn3 7.893e-17
Cp180 bn2 gnd 3.438e-15
Cp181 bn2 lsb_n 9.821e-17
Cp182 bn2 lsb_p 1.024e-16
Cp183 bn2 rstb 5.71e-17
Cp184 bn2 vdd 1.432e-16
Cp185 bn2 vrefl 6.62e-16
Cp186 bn2 xc4_din 1.086e-16
Cp187 bn2 xc4_dip 5.277e-16
Cp188 bn2 xc4_outnb 6.498e-17
Cp189 bn2 xc4_outpb 8.983e-17
Cp190 bn3 bn4 2.359e-14
Cp191 bn3 bn5 5.932e-15
Cp192 bn3 bn6 3.465e-15
Cp193 bn3 bn7 3.98e-15
Cp194 bn3 bn8 4.065e-17
Cp195 bn3 bn9 3.988e-17
Cp196 bn3 bp0 4.399e-17
Cp197 bn3 bp1 3.601e-17
Cp198 bn3 bp10 3.845e-17
Cp199 bn3 bp11 3.849e-17
Cp200 bn3 bp12 3.024e-17
Cp201 bn3 bp2 3.845e-17
Cp202 bn3 bp3 3.935e-17
Cp203 bn3 bp4 3.882e-17
Cp204 bn3 bp5 3.882e-17
Cp205 bn3 bp6 7.995e-17
Cp206 bn3 bp7 6.755e-16
Cp207 bn3 bp8 4.026e-17
Cp208 bn3 bp9 3.792e-17
Cp209 bn3 cn3 5.11e-16
Cp210 bn3 cn4 5.023e-16
Cp211 bn3 cn5 2.003e-19
Cp212 bn3 gnd 4.431e-15
Cp213 bn3 lsb_n 1.782e-16
Cp214 bn3 lsb_p 3.859e-16
Cp215 bn3 rstb 4.724e-17
Cp216 bn3 vdd 2.521e-16
Cp217 bn3 vrefl 6.027e-16
Cp218 bn3 xc4_din 1.079e-16
Cp219 bn3 xc4_dip 6.106e-16
Cp220 bn3 xc4_outnb 1.345e-16
Cp221 bn3 xc4_outpb 2.487e-18
Cp222 bn4 bn5 3.794e-14
Cp223 bn4 bn6 5.494e-15
Cp224 bn4 bn7 5.632e-15
Cp225 bn4 bn8 5.675e-16
Cp226 bn4 bn9 2.682e-16
Cp227 bn4 bp0 3.777e-17
Cp228 bn4 bp1 3.601e-17
Cp229 bn4 bp10 4.598e-17
Cp230 bn4 bp11 3.849e-17
Cp231 bn4 bp12 3.024e-17
Cp232 bn4 bp2 3.845e-17
Cp233 bn4 bp3 3.181e-16
Cp234 bn4 bp4 6.238e-16
Cp235 bn4 bp5 8.256e-17
Cp236 bn4 bp6 3.882e-17
Cp237 bn4 bp7 2.969e-17
Cp238 bn4 bp8 5.161e-16
Cp239 bn4 bp9 4.129e-16
Cp240 bn4 cn3 2.742e-19
Cp241 bn4 cn4 4.385e-17
Cp242 bn4 cn5 1.533e-16
Cp243 bn4 gnd 5.208e-15
Cp244 bn4 lsb_n 1.775e-16
Cp245 bn4 lsb_p 9.509e-17
Cp246 bn4 rstb 4.519e-17
Cp247 bn4 vdd 6.359e-16
Cp248 bn4 vrefl 1.649e-15
Cp249 bn4 xc4_din 1.195e-16
Cp250 bn4 xc4_dip 6.236e-16
Cp251 bn4 xc4_outnb 2.088e-18
Cp252 bn5 bn6 1.211e-14
Cp253 bn5 bn7 1.74e-14
Cp254 bn5 bn8 1.194e-16
Cp255 bn5 bn9 3.529e-16
Cp256 bn5 bp0 9.703e-17
Cp257 bn5 bp1 9.466e-17
Cp258 bn5 bp10 5.215e-16
Cp259 bn5 bp11 2.356e-16
Cp260 bn5 bp12 4.034e-17
Cp261 bn5 bp2 5.141e-16
Cp262 bn5 bp3 2.481e-16
Cp263 bn5 bp4 4.992e-17
Cp264 bn5 bp5 4.665e-16
Cp265 bn5 bp6 4.717e-16
Cp266 bn5 bp7 5.137e-17
Cp267 bn5 bp8 9.334e-17
Cp268 bn5 bp9 1.033e-16
Cp269 bn5 cn5 5.111e-16
Cp270 bn5 cn6 7.883e-17
Cp271 bn5 gnd 1.021e-14
Cp272 bn5 lsb_n 5.095e-16
Cp273 bn5 lsb_p 2.936e-16
Cp274 bn5 rstb 5.505e-17
Cp275 bn5 top_n 1.26e-19
Cp276 bn5 top_p 7.569e-18
Cp277 bn5 vdd 5.162e-16
Cp278 bn5 vrefl 6.277e-16
Cp279 bn5 xc4_din 1.159e-16
Cp280 bn5 xc4_dip 6.406e-16
Cp281 bn5 xc4_outnb 1.049e-18
Cp282 bn5 xs1n_cbp 2.091e-19
Cp283 bn5 xs1n_n10 2.244e-18
Cp284 bn6 bn7 1.162e-14
Cp285 bn6 bn8 7.431e-16
Cp286 bn6 bn9 1.991e-15
Cp287 bn6 bp0 6.733e-16
Cp288 bn6 bp1 5.426e-16
Cp289 bn6 bp10 6.568e-16
Cp290 bn6 bp11 5.943e-16
Cp291 bn6 bp12 8.081e-16
Cp292 bn6 bp2 6.364e-16
Cp293 bn6 bp3 6.091e-16
Cp294 bn6 bp4 9.209e-16
Cp295 bn6 bp5 5.852e-16
Cp296 bn6 bp6 5.901e-16
Cp297 bn6 bp7 8.532e-16
Cp298 bn6 bp8 6.868e-16
Cp299 bn6 bp9 5.326e-16
Cp300 bn6 cn6 5.111e-16
Cp301 bn6 cn7 7.893e-17
Cp302 bn6 cn8 1.344e-19
Cp303 bn6 gnd 2.864e-14
Cp304 bn6 lsb_n 1.724e-15
Cp305 bn6 lsb_p 6.785e-16
Cp306 bn6 rstb 5.609e-17
Cp307 bn6 top_n 5.775e-18
Cp308 bn6 top_p 7.569e-18
Cp309 bn6 vdd 1.345e-15
Cp310 bn6 vrefl 6.277e-16
Cp311 bn6 xc4_din 1.548e-16
Cp312 bn6 xc4_dip 3.701e-15
Cp313 bn6 xs1n_g 2.467e-19
Cp314 bn7 bn8 3.618e-15
Cp315 bn7 bn9 2.056e-15
Cp316 bn7 bp0 1.241e-15
Cp317 bn7 bp1 1.033e-15
Cp318 bn7 bp10 1.198e-15
Cp319 bn7 bp11 1.112e-15
Cp320 bn7 bp12 1.388e-15
Cp321 bn7 bp2 1.174e-15
Cp322 bn7 bp3 1.147e-15
Cp323 bn7 bp4 1.531e-15
Cp324 bn7 bp5 1.113e-15
Cp325 bn7 bp6 1.116e-15
Cp326 bn7 bp7 1.442e-15
Cp327 bn7 bp8 1.256e-15
Cp328 bn7 bp9 1.016e-15
Cp329 bn7 cn7 5.112e-16
Cp330 bn7 cn8 1.541e-17
Cp331 bn7 cn9 2.003e-19
Cp332 bn7 gnd 4.284e-14
Cp333 bn7 lsb_n 2.059e-15
Cp334 bn7 lsb_p 1.224e-15
Cp335 bn7 rstb 6.957e-17
Cp336 bn7 t0 3.223e-19
Cp337 bn7 t1b 5.677e-18
Cp338 bn7 top_n 6.005e-18
Cp339 bn7 top_p 1.514e-17
Cp340 bn7 vdd 2.463e-15
Cp341 bn7 vrefl 6.645e-16
Cp342 bn7 xc4_din 4.944e-15
Cp343 bn7 xc4_dip 8.89e-16
Cp344 bn8 bn9 4.44e-15
Cp345 bn8 bp12 6.613e-18
Cp346 bn8 cn10 3.075e-18
Cp347 bn8 cn7 2.742e-19
Cp348 bn8 cn8 2.232e-16
Cp349 bn8 cn9 1.338e-16
Cp350 bn8 gnd 5.754e-15
Cp351 bn8 lsb_n 5.49e-16
Cp352 bn8 lsb_p 2.011e-15
Cp353 bn8 rstb 6.179e-17
Cp354 bn8 top_n 2.126e-16
Cp355 bn8 top_p 3.132e-18
Cp356 bn8 vdd 1.468e-16
Cp357 bn8 vref 3.542e-16
Cp358 bn8 vrefl 1.917e-16
Cp359 bn8 xc4_din 8.33e-16
Cp360 bn8 xc4_dip 6.572e-16
Cp361 bn9 bp1 5.089e-17
Cp362 bn9 bp10 6.415e-17
Cp363 bn9 bp11 4.808e-17
Cp364 bn9 bp12 4.742e-17
Cp365 bn9 bp2 5.494e-16
Cp366 bn9 bp3 2.762e-16
Cp367 bn9 bp4 4.742e-17
Cp368 bn9 bp5 4.742e-17
Cp369 bn9 bp6 4.742e-17
Cp370 bn9 bp7 4.742e-17
Cp371 bn9 bp8 9.711e-17
Cp372 bn9 bp9 1.172e-15
Cp373 bn9 cn10 3.497e-18
Cp374 bn9 cn11 5.434e-19
Cp375 bn9 cn8 1.242e-16
Cp376 bn9 cn9 5.331e-16
Cp377 bn9 gnd 4.623e-15
Cp378 bn9 lsb_n 1.622e-16
Cp379 bn9 lsb_p 3.341e-16
Cp380 bn9 rstb 3.629e-16
Cp381 bn9 vdd 1.859e-16
Cp382 bn9 vref 4.511e-16
Cp383 bn9 vrefl 5.671e-18
Cp384 bn9 xc4_din 9.522e-16
Cp385 bn9 xc4_dip 1.259e-15
Cp386 bp0 bp1 1.683e-15
Cp387 bp0 bp10 4.444e-17
Cp388 bp0 bp11 9.649e-17
Cp389 bp0 bp12 5.005e-16
Cp390 bp0 bp2 1.212e-15
Cp391 bp0 bp3 1.05e-15
Cp392 bp0 bp4 9.815e-16
Cp393 bp0 bp5 1.116e-15
Cp394 bp0 bp6 1.791e-15
Cp395 bp0 bp7 8.897e-16
Cp396 bp0 bp8 5.138e-17
Cp397 bp0 cp0 2.595e-16
Cp398 bp0 cp1 1.093e-16
Cp399 bp0 cp2 8.8e-17
Cp400 bp0 cp3 1.155e-16
Cp401 bp0 cp4 4.601e-16
Cp402 bp0 cp5 3.214e-17
Cp403 bp0 gnd 5.355e-15
Cp404 bp0 lsb_n 4.735e-17
Cp405 bp0 vdd 1.92e-17
Cp406 bp0 vrefl 1.924e-15
Cp407 bp0 xc4_din 4.294e-16
Cp408 bp0 xc4_dip 6.156e-17
Cp409 bp1 bp10 4.195e-17
Cp410 bp1 bp11 3.792e-17
Cp411 bp1 bp12 4.274e-16
Cp412 bp1 bp2 8.674e-15
Cp413 bp1 bp3 3.291e-16
Cp414 bp1 bp4 1.241e-15
Cp415 bp1 bp5 1.352e-15
Cp416 bp1 bp6 1.206e-15
Cp417 bp1 bp7 2.272e-15
Cp418 bp1 bp8 4.889e-17
Cp419 bp1 bp9 5.089e-17
Cp420 bp1 cp0 5.834e-17
Cp421 bp1 cp1 1.356e-15
Cp422 bp1 cp2 1.301e-16
Cp423 bp1 cp3 1.184e-16
Cp424 bp1 cp4 6.054e-17
Cp425 bp1 cp5 2.108e-17
Cp426 bp1 gnd 4.154e-15
Cp427 bp1 lsb_n 4.486e-17
Cp428 bp1 vdd 2.613e-17
Cp429 bp1 vrefl 8.688e-16
Cp430 bp1 xc4_din 1.486e-16
Cp431 bp1 xc4_dip 7.088e-17
Cp432 bp10 bp11 2.034e-14
Cp433 bp10 bp12 5.978e-15
Cp434 bp10 bp2 3.679e-17
Cp435 bp10 bp3 3.846e-17
Cp436 bp10 bp4 3.882e-17
Cp437 bp10 bp5 3.882e-17
Cp438 bp10 bp6 1.262e-15
Cp439 bp10 bp7 1.281e-15
Cp440 bp10 bp8 1.195e-15
Cp441 bp10 bp9 1.374e-14
Cp442 bp10 cn12 1.1e-18
Cp443 bp10 cp10 1.899e-16
Cp444 bp10 cp11 6.791e-17
Cp445 bp10 cp12 2.639e-16
Cp446 bp10 cp6 3.807e-18
Cp447 bp10 cp7 1.115e-19
Cp448 bp10 cp8 4.34e-17
Cp449 bp10 cp9 1.339e-16
Cp450 bp10 gnd 4.618e-15
Cp451 bp10 lsb_n 6.515e-17
Cp452 bp10 lsb_p 6.763e-16
Cp453 bp10 rstb 1.632e-15
Cp454 bp10 vdd 1.292e-16
Cp455 bp10 vref 1.472e-15
Cp456 bp10 xc4_din 4.572e-16
Cp457 bp10 xc4_dip 1.214e-16
Cp458 bp11 bp12 3.389e-14
Cp459 bp11 bp2 3.275e-17
Cp460 bp11 bp3 3.846e-17
Cp461 bp11 bp4 4.971e-17
Cp462 bp11 bp5 4.698e-16
Cp463 bp11 bp6 2.927e-15
Cp464 bp11 bp7 2.409e-15
Cp465 bp11 bp8 5.197e-16
Cp466 bp11 bp9 5.622e-16
Cp467 bp11 cn11 9.678e-18
Cp468 bp11 cn12 4.273e-16
Cp469 bp11 cp10 3.585e-18
Cp470 bp11 cp11 2.314e-16
Cp471 bp11 cp12 1.841e-16
Cp472 bp11 gnd 5.699e-15
Cp473 bp11 lsb_n 7.72e-17
Cp474 bp11 lsb_p 7.969e-16
Cp475 bp11 rstb 6.749e-17
Cp476 bp11 vdd 1.893e-16
Cp477 bp11 vref 1.912e-15
Cp478 bp11 xc4_din 3.674e-16
Cp479 bp11 xc4_dip 9.266e-17
Cp480 bp12 bp2 5.232e-17
Cp481 bp12 bp3 3.179e-16
Cp482 bp12 bp4 5.788e-16
Cp483 bp12 bp5 8.797e-17
Cp484 bp12 bp6 5.779e-15
Cp485 bp12 bp7 5.302e-15
Cp486 bp12 bp8 1.229e-15
Cp487 bp12 bp9 3.169e-15
Cp488 bp12 cn11 9.589e-17
Cp489 bp12 cn12 3.729e-16
Cp490 bp12 cp10 1.977e-17
Cp491 bp12 cp11 3.921e-16
Cp492 bp12 cp12 8.048e-16
Cp493 bp12 gnd 7.813e-15
Cp494 bp12 lsb_n 1.038e-16
Cp495 bp12 lsb_p 1.776e-14
Cp496 bp12 rstb 6.95e-16
Cp497 bp12 top_p 1.311e-17
Cp498 bp12 vdd 5.356e-17
Cp499 bp12 vref 1.135e-15
Cp500 bp12 xc4_din 1.446e-16
Cp501 bp12 xc4_dip 8.229e-17
Cp502 bp2 bp3 1.449e-14
Cp503 bp2 bp4 4.489e-16
Cp504 bp2 bp5 3.429e-15
Cp505 bp2 bp6 1.845e-15
Cp506 bp2 bp7 2.839e-15
Cp507 bp2 bp8 4.942e-17
Cp508 bp2 bp9 5.494e-16
Cp509 bp2 cp0 6.301e-16
Cp510 bp2 cp1 7.823e-18
Cp511 bp2 cp2 4.475e-16
Cp512 bp2 cp3 1.362e-17
Cp513 bp2 cp4 9.854e-16
Cp514 bp2 cp6 4.24e-18
Cp515 bp2 gnd 6.151e-15
Cp516 bp2 lsb_n 4.539e-17
Cp517 bp2 t1 1.465e-16
Cp518 bp2 vdd 4.105e-17
Cp519 bp2 vrefl 1.387e-15
Cp520 bp2 xc4_din 1.965e-16
Cp521 bp2 xc4_dip 9.964e-16
Cp522 bp3 bp4 2.438e-14
Cp523 bp3 bp5 6.164e-15
Cp524 bp3 bp6 3.393e-15
Cp525 bp3 bp7 4.164e-15
Cp526 bp3 bp8 4.629e-17
Cp527 bp3 bp9 2.676e-16
Cp528 bp3 cp0 1.061e-15
Cp529 bp3 cp1 2.677e-16
Cp530 bp3 cp2 1.795e-15
Cp531 bp3 cp3 3.056e-16
Cp532 bp3 cp4 3.813e-16
Cp533 bp3 cp5 1.325e-18
Cp534 bp3 cp6 1.473e-18
Cp535 bp3 cp7 1.637e-16
Cp536 bp3 gnd 6.631e-15
Cp537 bp3 lsb_n 4.629e-17
Cp538 bp3 t1 2.618e-19
Cp539 bp3 vdd 8.854e-17
Cp540 bp3 vrefl 9.319e-16
Cp541 bp3 xc4_din 7.626e-16
Cp542 bp3 xc4_dip 1.169e-16
Cp543 bp4 bp5 4.088e-14
Cp544 bp4 bp6 5.822e-15
Cp545 bp4 bp7 5.67e-15
Cp546 bp4 bp8 5.125e-17
Cp547 bp4 bp9 3.967e-17
Cp548 bp4 cp0 1.086e-19
Cp549 bp4 cp1 8.375e-17
Cp550 bp4 cp2 4.254e-17
Cp551 bp4 cp3 1.101e-15
Cp552 bp4 cp4 1.355e-16
Cp553 bp4 cp5 2.004e-16
Cp554 bp4 cp6 4.046e-18
Cp555 bp4 cp7 1.927e-16
Cp556 bp4 gnd 6.488e-15
Cp557 bp4 lsb_n 4.576e-17
Cp558 bp4 lsb_p 2.435e-19
Cp559 bp4 rstb 9.302e-18
Cp560 bp4 vdd 1.156e-16
Cp561 bp4 vrefl 1.057e-15
Cp562 bp4 xc4_din 8.242e-16
Cp563 bp4 xc4_dip 1.091e-16
Cp564 bp5 bp6 1.377e-14
Cp565 bp5 bp7 1.795e-14
Cp566 bp5 bp8 4.65e-17
Cp567 bp5 bp9 3.924e-17
Cp568 bp5 cp0 1.086e-19
Cp569 bp5 cp1 1.007e-18
Cp570 bp5 cp2 6.213e-19
Cp571 bp5 cp3 4.306e-17
Cp572 bp5 cp4 1.458e-16
Cp573 bp5 cp5 9.434e-16
Cp574 bp5 cp6 1.553e-16
Cp575 bp5 cp7 1.736e-16
Cp576 bp5 gnd 1.186e-14
Cp577 bp5 lsb_n 4.576e-17
Cp578 bp5 lsb_p 7.123e-19
Cp579 bp5 rstb 1.701e-17
Cp580 bp5 t0 2.382e-18
Cp581 bp5 top_p 3.138e-19
Cp582 bp5 vdd 1.328e-16
Cp583 bp5 vrefl 1.082e-15
Cp584 bp5 xc4_din 8.625e-16
Cp585 bp5 xc4_dip 1.191e-16
Cp586 bp5 xs0p_x 1.022e-19
Cp587 bp5 xs1p_n10 1.9e-18
Cp588 bp6 bp7 1.382e-14
Cp589 bp6 bp8 7.72e-16
Cp590 bp6 bp9 8.446e-16
Cp591 bp6 cp2 4.648e-18
Cp592 bp6 cp3 1.328e-18
Cp593 bp6 cp4 7.507e-18
Cp594 bp6 cp5 1.42e-16
Cp595 bp6 cp6 1.57e-15
Cp596 bp6 cp7 1.089e-16
Cp597 bp6 cp8 3.475e-16
Cp598 bp6 cp9 6.071e-19
Cp599 bp6 gnd 3.145e-14
Cp600 bp6 lsb_n 4.586e-17
Cp601 bp6 lsb_p 3.681e-16
Cp602 bp6 rstb 1.39e-16
Cp603 bp6 top_p 1.027e-17
Cp604 bp6 vdd 1.129e-16
Cp605 bp6 vref 3.052e-17
Cp606 bp6 vrefl 1.023e-15
Cp607 bp6 xc4_din 4.678e-16
Cp608 bp6 xc4_dip 7.875e-17
Cp609 bp7 bp8 1.027e-15
Cp610 bp7 bp9 7.317e-16
Cp611 bp7 cp10 3.186e-18
Cp612 bp7 cp3 1.102e-19
Cp613 bp7 cp5 6.764e-17
Cp614 bp7 cp6 3.001e-16
Cp615 bp7 cp7 1.889e-16
Cp616 bp7 cp8 1.233e-16
Cp617 bp7 cp9 2.919e-16
Cp618 bp7 gnd 4.895e-14
Cp619 bp7 lsb_n 4.576e-17
Cp620 bp7 lsb_p 3.272e-15
Cp621 bp7 rstb 1.676e-16
Cp622 bp7 t0 5.596e-18
Cp623 bp7 top_p 4.329e-18
Cp624 bp7 vdd 1.217e-16
Cp625 bp7 vref 2.355e-17
Cp626 bp7 vrefl 9.977e-16
Cp627 bp7 xc4_din 4.812e-16
Cp628 bp7 xc4_dip 9.308e-16
Cp629 bp7 xs1p_cbp 2.091e-19
Cp630 bp7 xs1p_g 5.339e-19
Cp631 bp8 bp9 6.488e-15
Cp632 bp8 cp10 2.25e-16
Cp633 bp8 cp11 2.667e-19
Cp634 bp8 cp5 2.391e-18
Cp635 bp8 cp6 3.555e-16
Cp636 bp8 cp7 3.315e-17
Cp637 bp8 cp8 1.888e-16
Cp638 bp8 cp9 6.373e-17
Cp639 bp8 gnd 4.939e-15
Cp640 bp8 lsb_n 2.353e-15
Cp641 bp8 lsb_p 4.463e-16
Cp642 bp8 rstb 5.779e-17
Cp643 bp8 top_n 3.779e-18
Cp644 bp8 top_p 2.178e-16
Cp645 bp8 vdd 1.289e-16
Cp646 bp8 vref 5.844e-16
Cp647 bp8 vrefl 2.245e-17
Cp648 bp8 xc4_din 5.771e-16
Cp649 bp8 xc4_dip 1.217e-16
Cp650 bp9 cn12 2.912e-18
Cp651 bp9 cp10 4.056e-16
Cp652 bp9 cp11 1.197e-16
Cp653 bp9 cp12 5.435e-18
Cp654 bp9 cp3 2.912e-18
Cp655 bp9 cp5 2.667e-19
Cp656 bp9 cp6 6.572e-17
Cp657 bp9 cp7 2.652e-16
Cp658 bp9 cp8 6.377e-16
Cp659 bp9 cp9 1.482e-16
Cp660 bp9 gnd 4.003e-15
Cp661 bp9 lsb_n 5.491e-16
Cp662 bp9 lsb_p 2.667e-16
Cp663 bp9 rstb 5.376e-17
Cp664 bp9 vdd 1.032e-16
Cp665 bp9 vref 1.18e-15
Cp666 bp9 vrefl 8.617e-19
Cp667 bp9 xc4_din 4.38e-16
Cp668 bp9 xc4_dip 5.339e-16
Cp669 clkb clkn 5.869e-17
Cp670 clkb gnd 2.11e-14
Cp671 clkb on 1.23e-16
Cp672 clkb onn 3.631e-17
Cp673 clkb onp 1.54e-18
Cp674 clkb op 5.848e-17
Cp675 clkb t1 5.189e-17
Cp676 clkb t1b 6.116e-17
Cp677 clkb top_p 5.329e-17
Cp678 clkb vbp 1.055e-16
Cp679 clkb vdd 1.103e-14
Cp680 clkb vref 5.062e-16
Cp681 clkb vrefl 3.486e-16
Cp682 clkb xc4_din 2.921e-16
Cp683 clkb xc4_dip 5.05e-16
Cp684 clkb xc4_outnb 8.339e-18
Cp685 clkb xc4_outpb 1.103e-17
Cp686 clkb xc4_xs1_tail 1.245e-16
Cp687 clkb xc4_xs1_tail0 3.84e-16
Cp688 clkb xc5_din 1.073e-16
Cp689 clkb xc5_dip 5.012e-17
Cp690 clkb xc5_lt 5.373e-17
Cp691 clkb xc5_outnb 9.657e-18
Cp692 clkb xc5_outpb 1.593e-19
Cp693 clkb xc5_xs1_tail 7.813e-17
Cp694 clkn gnd 1.933e-14
Cp695 clkn onn 2.96e-19
Cp696 clkn onp 4.965e-19
Cp697 clkn top_n 4.691e-16
Cp698 clkn top_p 3.08e-16
Cp699 clkn vbn 7.469e-17
Cp700 clkn vbp 4.883e-19
Cp701 clkn vdd 6.745e-16
Cp702 clkn vrefl 1.432e-19
Cp703 clkn xc4_din 6.48e-18
Cp704 clkn xc4_dip 3.819e-17
Cp705 clkn xc4_xs1_tail 8.205e-18
Cp706 clkn xc5_din 2.437e-16
Cp707 clkn xc5_dip 2.303e-16
Cp708 clkn xc5_lt 4.936e-18
Cp709 clkn xc5_xs1_tail 7.919e-17
Cp710 clkn xc5_xs1_tail0 1.778e-16
Cp711 cn0 cn1 5.583e-17
Cp712 cn0 gnd 1.031e-15
Cp713 cn0 lsb_p 6.619e-17
Cp714 cn0 on 4.321e-19
Cp715 cn0 op 2.709e-18
Cp716 cn0 rstb 3.177e-17
Cp717 cn0 vdd 5.272e-18
Cp718 cn0 vrefl 4.948e-17
Cp719 cn0 xc4_din 6.928e-17
Cp720 cn0 xc4_dip 5.753e-19
Cp721 cn0 xc4_outnb 5.449e-17
Cp722 cn0 xc4_outpb 6.28e-17
Cp723 cn1 cn2 5.809e-17
Cp724 cn1 gnd 1.011e-15
Cp725 cn1 lsb_n 2.245e-19
Cp726 cn1 lsb_p 6.343e-17
Cp727 cn1 on 1.903e-18
Cp728 cn1 rstb 2.826e-17
Cp729 cn1 vdd 1.291e-18
Cp730 cn1 vrefl 7.005e-17
Cp731 cn1 xc4_dip 3.439e-18
Cp732 cn1 xc4_outnb 5.345e-17
Cp733 cn1 xc4_outpb 6.344e-17
Cp734 cn10 cn11 6.025e-16
Cp735 cn10 cn12 1.86e-17
Cp736 cn10 cn8 2.243e-17
Cp737 cn10 cn9 4.542e-17
Cp738 cn10 gnd 1.509e-15
Cp739 cn10 lsb_p 3.173e-18
Cp740 cn10 rstb 1.716e-16
Cp741 cn10 vdd 1.418e-18
Cp742 cn10 vref 2.838e-16
Cp743 cn10 xc4_din 2.291e-19
Cp744 cn10 xc4_dip 3.097e-19
Cp745 cn11 cn12 2.918e-16
Cp746 cn11 cn8 2.667e-19
Cp747 cn11 cn9 2.824e-18
Cp748 cn11 cp12 1.327e-17
Cp749 cn11 gnd 1.304e-15
Cp750 cn11 lsb_p 4.672e-18
Cp751 cn11 rstb 9.001e-16
Cp752 cn11 vdd 1.418e-18
Cp753 cn11 vref 5.988e-16
Cp754 cn11 xc4_dip 2.245e-19
Cp755 cn12 cp11 6.688e-18
Cp756 cn12 cp12 4.245e-16
Cp757 cn12 gnd 1.098e-15
Cp758 cn12 lsb_p 7.844e-18
Cp759 cn12 rstb 6.946e-17
Cp760 cn12 vdd 1.418e-18
Cp761 cn12 vref 7.609e-16
Cp762 cn12 xc4_din 2.291e-19
Cp763 cn12 xc4_dip 3.097e-19
Cp764 cn2 cn3 5.809e-17
Cp765 cn2 gnd 9.424e-16
Cp766 cn2 lsb_n 2.245e-19
Cp767 cn2 lsb_p 6.343e-17
Cp768 cn2 on 4.665e-19
Cp769 cn2 rstb 2.804e-17
Cp770 cn2 vdd 1.291e-18
Cp771 cn2 vrefl 6.968e-17
Cp772 cn2 xc4_dip 3.569e-18
Cp773 cn2 xc4_outnb 5.371e-17
Cp774 cn2 xc4_outpb 2.897e-16
Cp775 cn3 cn4 9.819e-17
Cp776 cn3 cn5 5.494e-18
Cp777 cn3 gnd 9.22e-16
Cp778 cn3 lsb_n 1.006e-19
Cp779 cn3 lsb_p 6.219e-17
Cp780 cn3 on 4.501e-18
Cp781 cn3 rstb 2.35e-17
Cp782 cn3 vdd 1.291e-18
Cp783 cn3 vrefl 7.481e-17
Cp784 cn3 xc4_dip 3.504e-18
Cp785 cn3 xc4_outnb 3.129e-16
Cp786 cn3 xc4_outpb 4.807e-18
Cp787 cn4 cn5 3.011e-17
Cp788 cn4 gnd 8.755e-16
Cp789 cn4 lsb_n 1.284e-18
Cp790 cn4 lsb_p 4.91e-17
Cp791 cn4 rstb 4.243e-17
Cp792 cn4 vdd 2.213e-18
Cp793 cn4 vrefl 1.21e-15
Cp794 cn4 xc4_din 7.729e-19
Cp795 cn4 xc4_dip 1.173e-17
Cp796 cn4 xc4_outnb 2.489e-16
Cp797 cn5 cn6 5.809e-17
Cp798 cn5 gnd 1.02e-15
Cp799 cn5 lsb_n 2.245e-19
Cp800 cn5 lsb_p 6.242e-17
Cp801 cn5 rstb 2.616e-17
Cp802 cn5 vdd 1.291e-18
Cp803 cn5 vrefl 8.264e-17
Cp804 cn5 xc4_dip 3.569e-18
Cp805 cn5 xc4_outnb 6.519e-19
Cp806 cn6 cn7 5.809e-17
Cp807 cn6 cn8 1.024e-19
Cp808 cn6 gnd 1.01e-15
Cp809 cn6 lsb_n 2.245e-19
Cp810 cn6 lsb_p 6.536e-17
Cp811 cn6 rstb 2.804e-17
Cp812 cn6 vdd 1.291e-18
Cp813 cn6 vrefl 6.976e-17
Cp814 cn6 xc4_dip 3.569e-18
Cp815 cn7 cn8 3.078e-17
Cp816 cn7 cn9 1.226e-19
Cp817 cn7 gnd 1.018e-15
Cp818 cn7 lsb_n 2.245e-19
Cp819 cn7 lsb_p 6.713e-17
Cp820 cn7 rstb 4.591e-17
Cp821 cn7 vdd 1.291e-18
Cp822 cn7 vrefl 6.963e-17
Cp823 cn7 xc4_dip 3.569e-18
Cp824 cn8 cn9 1.952e-16
Cp825 cn8 gnd 1.411e-15
Cp826 cn8 lsb_n 1.267e-19
Cp827 cn8 lsb_p 5.604e-17
Cp828 cn8 rstb 4.436e-16
Cp829 cn8 vdd 1.817e-18
Cp830 cn8 vref 1.255e-16
Cp831 cn8 vrefl 7.262e-18
Cp832 cn8 xc4_din 2.833e-19
Cp833 cn8 xc4_dip 1.437e-18
Cp834 cn9 gnd 1.105e-15
Cp835 cn9 lsb_p 9.986e-17
Cp836 cn9 rstb 5.493e-16
Cp837 cn9 vdd 1.97e-18
Cp838 cn9 vref 2.023e-16
Cp839 cn9 vrefl 4.221e-19
Cp840 cn9 xc4_din 3.376e-19
Cp841 cn9 xc4_dip 1.322e-18
Cp842 cp0 cp1 1.074e-16
Cp843 cp0 cp2 3.626e-18
Cp844 cp0 cp3 1.38e-18
Cp845 cp0 cp4 3.767e-16
Cp846 cp0 gnd 1.199e-15
Cp847 cp0 t1 6.332e-19
Cp848 cp0 vdd 1.291e-18
Cp849 cp0 vrefl 1.149e-16
Cp850 cp0 xc4_din 2.651e-18
Cp851 cp0 xc4_dip 3.097e-19
Cp852 cp1 cp2 2.774e-16
Cp853 cp1 cp3 8.226e-16
Cp854 cp1 cp4 9.511e-17
Cp855 cp1 cp5 2.731e-18
Cp856 cp1 gnd 1.199e-15
Cp857 cp1 t1 4.583e-19
Cp858 cp1 vdd 1.311e-18
Cp859 cp1 vrefl 7.419e-16
Cp860 cp1 xc4_din 5.798e-18
Cp861 cp1 xc4_dip 5.497e-19
Cp862 cp10 cp11 4.722e-16
Cp863 cp10 cp12 1.588e-16
Cp864 cp10 cp8 2.674e-16
Cp865 cp10 cp9 5.79e-16
Cp866 cp10 gnd 1.325e-15
Cp867 cp10 lsb_p 4.672e-18
Cp868 cp10 rstb 6.01e-17
Cp869 cp10 t1 1.086e-19
Cp870 cp10 vdd 1.955e-18
Cp871 cp10 vref 7.533e-16
Cp872 cp10 xc4_din 5.462e-19
Cp873 cp10 xc4_dip 3.43e-19
Cp874 cp11 cp12 2.405e-16
Cp875 cp11 cp9 1.153e-16
Cp876 cp11 gnd 1.359e-15
Cp877 cp11 lsb_p 1.317e-18
Cp878 cp11 rstb 5.388e-17
Cp879 cp11 t1 6.332e-19
Cp880 cp11 vdd 1.418e-18
Cp881 cp11 vref 6.69e-16
Cp882 cp11 xc4_din 5.462e-19
Cp883 cp12 gnd 1.401e-15
Cp884 cp12 lsb_p 5.497e-19
Cp885 cp12 rstb 5.389e-17
Cp886 cp12 t1 2.924e-18
Cp887 cp12 vdd 1.617e-18
Cp888 cp12 vref 7.86e-16
Cp889 cp2 cp3 1.214e-15
Cp890 cp2 cp4 1.183e-16
Cp891 cp2 cp6 1.767e-19
Cp892 cp2 gnd 1.035e-15
Cp893 cp2 t1 9.829e-19
Cp894 cp2 vdd 1.291e-18
Cp895 cp2 vrefl 5.449e-16
Cp896 cp2 xc4_din 5.752e-18
Cp897 cp2 xc4_dip 3.097e-19
Cp898 cp3 cp4 2.108e-16
Cp899 cp3 cp5 1.754e-17
Cp900 cp3 cp6 9.461e-19
Cp901 cp3 cp7 3.893e-16
Cp902 cp3 gnd 1.265e-15
Cp903 cp3 t1 3.512e-19
Cp904 cp3 vdd 1.291e-18
Cp905 cp3 vrefl 2.534e-16
Cp906 cp3 xc4_din 5.587e-18
Cp907 cp3 xc4_dip 2.245e-19
Cp908 cp4 cp5 5.797e-17
Cp909 cp4 cp6 2.842e-19
Cp910 cp4 cp7 1.106e-16
Cp911 cp4 gnd 1.509e-15
Cp912 cp4 rstb 3.21e-18
Cp913 cp4 t1 6.332e-19
Cp914 cp4 vdd 1.291e-18
Cp915 cp4 vrefl 2.27e-16
Cp916 cp4 xc4_din 3.255e-18
Cp917 cp5 cp6 1.203e-15
Cp918 cp5 cp7 2.287e-16
Cp919 cp5 gnd 1.391e-15
Cp920 cp5 lsb_p 1.799e-18
Cp921 cp5 rstb 1.676e-16
Cp922 cp5 vdd 2.113e-18
Cp923 cp5 vref 1.474e-19
Cp924 cp5 vrefl 1.363e-15
Cp925 cp5 xc4_din 3.699e-18
Cp926 cp5 xc4_dip 2.461e-19
Cp927 cp6 cp7 3.592e-16
Cp928 cp6 cp8 1.943e-17
Cp929 cp6 cp9 8.155e-18
Cp930 cp6 gnd 1.39e-15
Cp931 cp6 lsb_p 6.983e-19
Cp932 cp6 rstb 2.619e-16
Cp933 cp6 t1 6.332e-19
Cp934 cp6 vdd 5.137e-18
Cp935 cp6 vref 2.424e-18
Cp936 cp6 vrefl 1.633e-16
Cp937 cp6 xc4_din 3.438e-18
Cp938 cp6 xc4_dip 5.744e-19
Cp939 cp7 cp8 4.469e-16
Cp940 cp7 cp9 1.604e-16
Cp941 cp7 gnd 1.481e-15
Cp942 cp7 lsb_p 2.69e-19
Cp943 cp7 rstb 1.53e-17
Cp944 cp7 t1 6.332e-19
Cp945 cp7 vdd 1.291e-18
Cp946 cp7 vref 4.087e-18
Cp947 cp7 vrefl 1.088e-16
Cp948 cp7 xc4_din 3.255e-18
Cp949 cp8 cp9 4.446e-16
Cp950 cp8 gnd 1.066e-15
Cp951 cp8 lsb_p 7.31e-18
Cp952 cp8 rstb 8.871e-17
Cp953 cp8 t1 4.583e-19
Cp954 cp8 vdd 1.291e-18
Cp955 cp8 vref 3.934e-16
Cp956 cp8 vrefl 3.318e-19
Cp957 cp8 xc4_din 7.413e-19
Cp958 cp8 xc4_dip 5.497e-19
Cp959 cp9 gnd 1.353e-15
Cp960 cp9 lsb_p 7.31e-18
Cp961 cp9 rstb 6.405e-17
Cp962 cp9 t1 1.086e-19
Cp963 cp9 vdd 1.291e-18
Cp964 cp9 vref 4.277e-16
Cp965 cp9 xc4_din 7.299e-19
Cp966 cp9 xc4_dip 4.335e-19
Cp967 gnd in0n 1.477e-15
Cp968 gnd in0p 1.738e-15
Cp969 gnd in1n 1.734e-15
Cp970 gnd in1p 1.956e-15
Cp971 gnd lsb_n 1.087e-14
Cp972 gnd lsb_p 1.308e-14
Cp973 gnd nr 9.241e-16
Cp974 gnd on 7.625e-15
Cp975 gnd onn 1.075e-14
Cp976 gnd onp 9.075e-15
Cp977 gnd op 6.51e-15
Cp978 gnd rstb 5.156e-15
Cp979 gnd rstb_n 2.471e-15
Cp980 gnd t0 6.534e-15
Cp981 gnd t0b 1.169e-14
Cp982 gnd t1 2.051e-14
Cp983 gnd t1b 1.36e-14
Cp984 gnd top_n 1.703e-14
Cp985 gnd top_p 2.116e-14
Cp986 gnd trk0 2.158e-15
Cp987 gnd trk1 1.137e-15
Cp988 gnd vbn 1.368e-15
Cp989 gnd vbp 7.508e-15
Cp990 gnd vdd 8.173e-14
Cp991 gnd vref 2.148e-14
Cp992 gnd vrefl 2.387e-14
Cp993 gnd xc4_din 5.124e-14
Cp994 gnd xc4_dip 5.146e-14
Cp995 gnd xc4_lt 1.902e-15
Cp996 gnd xc4_outnb 2.33e-15
Cp997 gnd xc4_outpb 2.675e-15
Cp998 gnd xc4_xs1_tail 7.66e-15
Cp999 gnd xc4_xs1_tail0 2.029e-15
Cp1000 gnd xc5_din 2.359e-14
Cp1001 gnd xc5_dip 2.57e-14
Cp1002 gnd xc5_lt 7.116e-15
Cp1003 gnd xc5_outnb 2.161e-15
Cp1004 gnd xc5_outpb 1.906e-15
Cp1005 gnd xc5_xs1_tail 4.036e-15
Cp1006 gnd xc5_xs1_tail0 2.375e-15
Cp1007 gnd xs0n_cbn 4.051e-15
Cp1008 gnd xs0n_cbp 1.817e-15
Cp1009 gnd xs0n_g 4.78e-15
Cp1010 gnd xs0n_n10 1.165e-15
Cp1011 gnd xs0n_x 1.671e-15
Cp1012 gnd xs0p_cbn 6.326e-15
Cp1013 gnd xs0p_cbp 2.138e-15
Cp1014 gnd xs0p_g 4.536e-15
Cp1015 gnd xs0p_n10 1.353e-15
Cp1016 gnd xs0p_x 2.477e-15
Cp1017 gnd xs1n_cbn 5.643e-15
Cp1018 gnd xs1n_cbp 2.373e-15
Cp1019 gnd xs1n_g 5.426e-15
Cp1020 gnd xs1n_n10 1.523e-15
Cp1021 gnd xs1n_x 1.754e-15
Cp1022 gnd xs1p_cbn 5.312e-15
Cp1023 gnd xs1p_cbp 1.729e-15
Cp1024 gnd xs1p_g 3.834e-15
Cp1025 gnd xs1p_n10 1.184e-15
Cp1026 gnd xs1p_x 1.852e-15
Cp1027 in0n in0p 1.859e-16
Cp1028 in0n lsb_n 1.024e-19
Cp1029 in0n lsb_p 1.344e-19
Cp1030 in0n t0 1.918e-18
Cp1031 in0n t0b 1.39e-15
Cp1032 in0n top_n 9.124e-16
Cp1033 in0n top_p 1.605e-18
Cp1034 in0n vdd 1.109e-15
Cp1035 in0n xs0n_cbn 1.972e-15
Cp1036 in0n xs0n_cbp 3.402e-18
Cp1037 in0n xs0n_g 2.009e-16
Cp1038 in0n xs0n_n10 8.707e-17
Cp1039 in0n xs0n_x 4.197e-17
Cp1040 in0p t0 1.012e-16
Cp1041 in0p t0b 1.021e-15
Cp1042 in0p top_n 9.216e-17
Cp1043 in0p top_p 1.019e-15
Cp1044 in0p vdd 3.463e-16
Cp1045 in0p xs0n_cbn 1.409e-15
Cp1046 in0p xs0n_cbp 1.657e-16
Cp1047 in0p xs0n_g 5.902e-16
Cp1048 in0p xs0n_n10 4.326e-17
Cp1049 in0p xs0n_x 1.456e-15
Cp1050 in0p xs0p_cbn 2.744e-16
Cp1051 in0p xs0p_g 2.342e-16
Cp1052 in1n in1p 2.149e-16
Cp1053 in1n t1 5.303e-16
Cp1054 in1n t1b 2.368e-15
Cp1055 in1n top_n 1.207e-15
Cp1056 in1n top_p 1.079e-18
Cp1057 in1n vdd 1.475e-15
Cp1058 in1n xs1n_cbn 1.003e-15
Cp1059 in1n xs1n_cbp 8.311e-18
Cp1060 in1n xs1n_g 1.488e-15
Cp1061 in1n xs1n_n10 2.129e-18
Cp1062 in1n xs1n_x 1.343e-16
Cp1063 in1n xs1p_cbn 4.766e-18
Cp1064 in1n xs1p_g 3.31e-18
Cp1065 in1p t1 1.234e-15
Cp1066 in1p t1b 3.149e-16
Cp1067 in1p top_n 2.154e-15
Cp1068 in1p top_p 7.945e-16
Cp1069 in1p vdd 1.26e-15
Cp1070 in1p xs1n_cbn 2.813e-16
Cp1071 in1p xs1n_cbp 3.05e-17
Cp1072 in1p xs1n_g 5.762e-17
Cp1073 in1p xs1n_n10 8.925e-18
Cp1074 in1p xs1n_x 1.462e-15
Cp1075 in1p xs1p_cbn 3.085e-16
Cp1076 in1p xs1p_g 4.599e-16
Cp1077 in1p xs1p_x 1.47e-18
Cp1078 lsb_n lsb_p 3.101e-15
Cp1079 lsb_n on 2.535e-19
Cp1080 lsb_n rstb 4.161e-16
Cp1081 lsb_n t0 1.606e-16
Cp1082 lsb_n top_n 5.501e-16
Cp1083 lsb_n top_p 2.556e-17
Cp1084 lsb_n vdd 3.352e-16
Cp1085 lsb_n vref 1.895e-17
Cp1086 lsb_n vrefl 3.041e-16
Cp1087 lsb_n xc4_din 3.81e-15
Cp1088 lsb_n xc4_dip 4.541e-15
Cp1089 lsb_n xc4_lt 1.908e-18
Cp1090 lsb_n xs0n_cbn 6.394e-17
Cp1091 lsb_n xs0n_cbp 3.117e-18
Cp1092 lsb_n xs0n_g 2.345e-19
Cp1093 lsb_n xs0n_x 2.147e-17
Cp1094 lsb_n xs1p_g 1.34e-19
Cp1095 lsb_p on 2.112e-16
Cp1096 lsb_p onn 2.762e-19
Cp1097 lsb_p onp 6.046e-17
Cp1098 lsb_p op 6.057e-18
Cp1099 lsb_p rstb 7.947e-15
Cp1100 lsb_p t0 2.264e-15
Cp1101 lsb_p t0b 1.693e-18
Cp1102 lsb_p top_n 6.452e-17
Cp1103 lsb_p top_p 5.789e-16
Cp1104 lsb_p vdd 4.057e-15
Cp1105 lsb_p vref 2.399e-16
Cp1106 lsb_p vrefl 6.945e-16
Cp1107 lsb_p xc4_din 2.02e-15
Cp1108 lsb_p xc4_dip 4.352e-16
Cp1109 lsb_p xc4_lt 5.105e-17
Cp1110 lsb_p xc4_outnb 6.876e-16
Cp1111 lsb_p xc4_outpb 7.044e-18
Cp1112 lsb_p xc5_outnb 1.869e-18
Cp1113 lsb_p xc5_outpb 2.264e-17
Cp1114 lsb_p xs0n_cbn 1.276e-16
Cp1115 lsb_p xs0n_cbp 3.66e-18
Cp1116 lsb_p xs0n_g 4.502e-19
Cp1117 lsb_p xs0n_n10 4.893e-19
Cp1118 lsb_p xs0n_x 1.104e-16
Cp1119 lsb_p xs0p_cbn 8.584e-18
Cp1120 lsb_p xs0p_g 4.202e-18
Cp1121 lsb_p xs0p_x 1.802e-17
Cp1122 nr rstb 1.182e-17
Cp1123 nr rstb_n 6.318e-16
Cp1124 nr t0b 2.323e-16
Cp1125 nr t1 5.569e-17
Cp1126 nr t1b 2.391e-16
Cp1127 nr trk1 1.142e-19
Cp1128 nr vdd 2.449e-17
Cp1129 on onn 6.296e-18
Cp1130 on onp 8.024e-16
Cp1131 on op 1.932e-15
Cp1132 on rstb 1.895e-16
Cp1133 on t0 2.605e-18
Cp1134 on t1 4.092e-18
Cp1135 on t1b 8.692e-19
Cp1136 on vbp 9.659e-19
Cp1137 on vdd 2.513e-15
Cp1138 on vrefl 1.137e-16
Cp1139 on xc4_din 5.32e-16
Cp1140 on xc4_dip 7.007e-16
Cp1141 on xc4_lt 4.285e-16
Cp1142 on xc4_outnb 8.742e-16
Cp1143 on xc4_outpb 7.319e-16
Cp1144 on xc4_xs1_tail 1.024e-17
Cp1145 on xc4_xs1_tail0 1.157e-17
Cp1146 on xc5_lt 1.253e-17
Cp1147 on xc5_outnb 2.139e-16
Cp1148 on xc5_outpb 5.481e-16
Cp1149 onn onp 1.542e-14
Cp1150 onn op 1.064e-15
Cp1151 onn rstb 7.02e-17
Cp1152 onn rstb_n 1.619e-18
Cp1153 onn t0 4.085e-16
Cp1154 onn t0b 2.902e-16
Cp1155 onn t1 6.593e-17
Cp1156 onn t1b 1.849e-16
Cp1157 onn vbp 4.707e-17
Cp1158 onn vdd 4.852e-15
Cp1159 onn vref 4.419e-16
Cp1160 onn vrefl 3.014e-16
Cp1161 onn xc4_din 9.418e-19
Cp1162 onn xc4_dip 1.376e-17
Cp1163 onn xc4_xs1_tail 5.292e-17
Cp1164 onn xc4_xs1_tail0 6.814e-18
Cp1165 onn xc5_din 1.166e-16
Cp1166 onn xc5_dip 5.957e-18
Cp1167 onn xc5_lt 1.538e-14
Cp1168 onn xc5_outnb 7.62e-17
Cp1169 onn xc5_outpb 2.346e-16
Cp1170 onn xc5_xs1_tail 7.053e-18
Cp1171 onn xc5_xs1_tail0 1.767e-18
Cp1172 onp op 2.302e-15
Cp1173 onp rstb 8.123e-17
Cp1174 onp t0 1.023e-15
Cp1175 onp t0b 1.239e-16
Cp1176 onp t1 6.875e-17
Cp1177 onp t1b 1.449e-14
Cp1178 onp vbp 4.673e-17
Cp1179 onp vdd 1.246e-15
Cp1180 onp vref 4.419e-16
Cp1181 onp vrefl 3.014e-16
Cp1182 onp xc4_din 4.395e-19
Cp1183 onp xc4_dip 4.395e-19
Cp1184 onp xc4_lt 1.98e-17
Cp1185 onp xc4_outnb 7.746e-18
Cp1186 onp xc4_outpb 1.737e-18
Cp1187 onp xc4_xs1_tail 5.597e-17
Cp1188 onp xc4_xs1_tail0 1.333e-18
Cp1189 onp xc5_din 1.508e-17
Cp1190 onp xc5_dip 1.156e-16
Cp1191 onp xc5_lt 1.689e-15
Cp1192 onp xc5_outnb 2.69e-16
Cp1193 onp xc5_outpb 9.109e-16
Cp1194 onp xc5_xs1_tail 1.026e-17
Cp1195 onp xc5_xs1_tail0 3.389e-18
Cp1196 op rstb 3.247e-16
Cp1197 op t0 4.752e-17
Cp1198 op t0b 5.582e-19
Cp1199 op t1 6.093e-18
Cp1200 op t1b 1.433e-18
Cp1201 op vdd 3.343e-15
Cp1202 op xc4_din 4.666e-17
Cp1203 op xc4_dip 5.198e-16
Cp1204 op xc4_lt 6.701e-16
Cp1205 op xc4_outnb 2.258e-18
Cp1206 op xc4_outpb 4.739e-16
Cp1207 op xc4_xs1_tail 7.617e-18
Cp1208 op xc4_xs1_tail0 8.644e-19
Cp1209 op xc5_lt 4.388e-18
Cp1210 op xc5_outnb 2.63e-15
Cp1211 op xc5_outpb 2.314e-16
Cp1212 rstb rstb_n 2.029e-16
Cp1213 rstb t1 7.422e-17
Cp1214 rstb t1b 9.633e-17
Cp1215 rstb vdd 8.327e-16
Cp1216 rstb vref 2.255e-15
Cp1217 rstb vrefl 2.983e-15
Cp1218 rstb xc4_din 6.64e-17
Cp1219 rstb xc4_dip 2.069e-16
Cp1220 rstb xc4_lt 1.147e-17
Cp1221 rstb xc4_outnb 1.875e-18
Cp1222 rstb xc4_outpb 1.396e-17
Cp1223 rstb xc5_lt 6.15e-17
Cp1224 rstb xc5_outnb 5.053e-17
Cp1225 rstb xc5_outpb 6.097e-17
Cp1226 rstb_n t0b 1.639e-16
Cp1227 rstb_n t1 6.266e-17
Cp1228 rstb_n t1b 5.498e-16
Cp1229 rstb_n vdd 1.03e-15
Cp1230 t0 t0b 5.761e-16
Cp1231 t0 t1 8.863e-18
Cp1232 t0 t1b 8.669e-18
Cp1233 t0 top_n 8.324e-16
Cp1234 t0 top_p 4.745e-16
Cp1235 t0 trk0 2.258e-19
Cp1236 t0 trk1 1.315e-16
Cp1237 t0 vdd 8.168e-15
Cp1238 t0 xc4_lt 2.328e-18
Cp1239 t0 xc5_outpb 8.002e-17
Cp1240 t0 xs0n_cbn 1.145e-15
Cp1241 t0 xs0n_cbp 4.879e-18
Cp1242 t0 xs0n_g 2.101e-16
Cp1243 t0 xs0n_n10 7.613e-19
Cp1244 t0 xs0n_x 2.131e-16
Cp1245 t0 xs0p_cbn 3e-16
Cp1246 t0 xs0p_cbp 4.624e-18
Cp1247 t0 xs0p_g 8.374e-17
Cp1248 t0 xs0p_x 1.153e-16
Cp1249 t0b t1 5.507e-16
Cp1250 t0b t1b 7.66e-16
Cp1251 t0b top_n 1.091e-16
Cp1252 t0b top_p 1.28e-16
Cp1253 t0b trk0 2.445e-16
Cp1254 t0b trk1 8.183e-17
Cp1255 t0b vdd 2.213e-15
Cp1256 t0b xs0n_cbn 9.509e-16
Cp1257 t0b xs0n_cbp 5.402e-16
Cp1258 t0b xs0n_g 2.139e-16
Cp1259 t0b xs0n_n10 1.374e-16
Cp1260 t0b xs0n_x 8.698e-17
Cp1261 t0b xs0p_cbn 4.628e-16
Cp1262 t0b xs0p_cbp 2.112e-18
Cp1263 t0b xs0p_g 8.877e-17
Cp1264 t0b xs0p_n10 3.396e-17
Cp1265 t0b xs0p_x 1.257e-16
Cp1266 t1 t1b 2.052e-15
Cp1267 t1 top_n 2.173e-16
Cp1268 t1 top_p 6.185e-17
Cp1269 t1 trk1 2.742e-19
Cp1270 t1 vbp 5.912e-17
Cp1271 t1 vdd 1.564e-14
Cp1272 t1 vref 1.759e-15
Cp1273 t1 vrefl 4.007e-16
Cp1274 t1 xc4_din 6.791e-17
Cp1275 t1 xc4_dip 6.791e-17
Cp1276 t1 xc4_outpb 2.264e-19
Cp1277 t1 xc4_xs1_tail 5.494e-17
Cp1278 t1 xc4_xs1_tail0 4.956e-18
Cp1279 t1 xc5_dip 5.523e-18
Cp1280 t1 xc5_lt 3.044e-15
Cp1281 t1 xc5_outnb 2.264e-19
Cp1282 t1 xc5_outpb 1.372e-19
Cp1283 t1 xs1n_cbn 1.124e-15
Cp1284 t1 xs1n_cbp 4.779e-18
Cp1285 t1 xs1n_g 1.59e-15
Cp1286 t1 xs1n_n10 1.012e-18
Cp1287 t1 xs1n_x 2.076e-16
Cp1288 t1 xs1p_cbn 2.892e-16
Cp1289 t1 xs1p_cbp 4.816e-18
Cp1290 t1 xs1p_g 1.047e-16
Cp1291 t1 xs1p_n10 1.062e-19
Cp1292 t1 xs1p_x 1.101e-16
Cp1293 t1b top_n 3.211e-16
Cp1294 t1b top_p 1.317e-15
Cp1295 t1b trk1 1.496e-16
Cp1296 t1b vbn 1.178e-19
Cp1297 t1b vbp 5.329e-17
Cp1298 t1b vdd 3.856e-15
Cp1299 t1b vref 5.577e-16
Cp1300 t1b vrefl 3.714e-16
Cp1301 t1b xc4_din 2.473e-16
Cp1302 t1b xc4_dip 7.087e-17
Cp1303 t1b xc4_xs1_tail 5.94e-15
Cp1304 t1b xc4_xs1_tail0 9.605e-19
Cp1305 t1b xc5_din 6.363e-17
Cp1306 t1b xc5_dip 4.244e-15
Cp1307 t1b xc5_lt 4.147e-16
Cp1308 t1b xc5_xs1_tail 1.214e-18
Cp1309 t1b xc5_xs1_tail0 3.185e-18
Cp1310 t1b xs1n_cbn 1.406e-15
Cp1311 t1b xs1n_cbp 1.242e-17
Cp1312 t1b xs1n_g 6.746e-17
Cp1313 t1b xs1n_n10 3.726e-17
Cp1314 t1b xs1n_x 1.445e-15
Cp1315 t1b xs1p_cbn 6.678e-16
Cp1316 t1b xs1p_cbp 4.44e-17
Cp1317 t1b xs1p_g 7.513e-16
Cp1318 t1b xs1p_n10 4.782e-17
Cp1319 t1b xs1p_x 4.703e-16
Cp1320 top_n top_p 5.622e-15
Cp1321 top_n vdd 2.19e-15
Cp1322 top_n xc4_din 1.14e-15
Cp1323 top_n xc4_dip 5.962e-17
Cp1324 top_n xc4_xs1_tail 1.248e-15
Cp1325 top_n xc5_din 1.529e-15
Cp1326 top_n xc5_dip 9.126e-17
Cp1327 top_n xc5_lt 6.626e-17
Cp1328 top_n xc5_xs1_tail 9.994e-16
Cp1329 top_n xs0n_cbn 9.937e-16
Cp1330 top_n xs0n_cbp 8.507e-18
Cp1331 top_n xs0n_g 3.453e-16
Cp1332 top_n xs0n_n10 1.796e-18
Cp1333 top_n xs0n_x 1.404e-16
Cp1334 top_n xs0p_g 2.937e-18
Cp1335 top_n xs1n_cbn 1.085e-15
Cp1336 top_n xs1n_cbp 1.829e-16
Cp1337 top_n xs1n_g 2.624e-16
Cp1338 top_n xs1n_n10 4.801e-17
Cp1339 top_n xs1n_x 1.665e-16
Cp1340 top_n xs1p_cbn 3.88e-18
Cp1341 top_n xs1p_g 5.831e-17
Cp1342 top_p vdd 1.847e-15
Cp1343 top_p xc4_din 2.088e-16
Cp1344 top_p xc4_dip 1.14e-15
Cp1345 top_p xc4_xs1_tail 1.273e-15
Cp1346 top_p xc5_din 5.615e-16
Cp1347 top_p xc5_dip 6.45e-16
Cp1348 top_p xc5_lt 6.307e-17
Cp1349 top_p xc5_xs1_tail 1.158e-15
Cp1350 top_p xs0n_cbn 1.069e-16
Cp1351 top_p xs0n_cbp 1.124e-17
Cp1352 top_p xs0n_g 1.068e-15
Cp1353 top_p xs0n_n10 2.662e-18
Cp1354 top_p xs0n_x 2.05e-16
Cp1355 top_p xs0p_cbn 1.025e-16
Cp1356 top_p xs0p_g 7.132e-16
Cp1357 top_p xs0p_x 1.984e-18
Cp1358 top_p xs1n_cbn 3e-16
Cp1359 top_p xs1n_cbp 1.01e-17
Cp1360 top_p xs1n_g 2.612e-16
Cp1361 top_p xs1n_n10 4.825e-17
Cp1362 top_p xs1p_cbn 6.037e-18
Cp1363 top_p xs1p_g 9.266e-17
Cp1364 trk0 vdd 7.429e-17
Cp1365 trk1 vdd 3.129e-16
Cp1366 vbn vbp 6.554e-16
Cp1367 vbn vrefl 8.977e-18
Cp1368 vbn xc4_xs1_tail 4.133e-18
Cp1369 vbn xc5_din 1.317e-17
Cp1370 vbn xc5_dip 4.828e-17
Cp1371 vbn xc5_xs1_tail 1.148e-16
Cp1372 vbn xc5_xs1_tail0 3.221e-16
Cp1373 vbp vdd 6.588e-16
Cp1374 vbp vref 4.899e-16
Cp1375 vbp vrefl 8.126e-15
Cp1376 vbp xc4_dip 5.086e-17
Cp1377 vbp xc4_xs1_tail 1.637e-15
Cp1378 vbp xc4_xs1_tail0 1.03e-15
Cp1379 vbp xc5_din 2.095e-17
Cp1380 vbp xc5_dip 1.216e-16
Cp1381 vbp xc5_lt 5.454e-17
Cp1382 vbp xc5_outnb 1.781e-18
Cp1383 vbp xc5_xs1_tail0 2.468e-18
Cp1384 vdd vref 2.434e-15
Cp1385 vdd vrefl 2.328e-15
Cp1386 vdd xc4_din 1.551e-14
Cp1387 vdd xc4_dip 1.357e-14
Cp1388 vdd xc4_lt 9.167e-18
Cp1389 vdd xc4_outnb 3.406e-16
Cp1390 vdd xc4_outpb 4.225e-16
Cp1391 vdd xc4_xs1_tail 9.684e-16
Cp1392 vdd xc4_xs1_tail0 2.805e-15
Cp1393 vdd xc5_din 2.748e-15
Cp1394 vdd xc5_dip 2.296e-15
Cp1395 vdd xc5_lt 4.392e-15
Cp1396 vdd xc5_outnb 6.453e-16
Cp1397 vdd xc5_outpb 4.657e-16
Cp1398 vdd xc5_xs1_tail 2.875e-16
Cp1399 vdd xc5_xs1_tail0 2.925e-19
Cp1400 vdd xs0n_cbn 2.397e-15
Cp1401 vdd xs0n_cbp 5.276e-16
Cp1402 vdd xs0n_g 7.833e-16
Cp1403 vdd xs0n_n10 1.751e-16
Cp1404 vdd xs0n_x 9.861e-16
Cp1405 vdd xs0p_cbn 2.811e-15
Cp1406 vdd xs0p_cbp 7.317e-16
Cp1407 vdd xs0p_g 9.595e-16
Cp1408 vdd xs0p_n10 8.833e-17
Cp1409 vdd xs0p_x 9.978e-16
Cp1410 vdd xs1n_cbn 1.775e-15
Cp1411 vdd xs1n_cbp 5.751e-16
Cp1412 vdd xs1n_g 1.878e-15
Cp1413 vdd xs1n_n10 4.703e-17
Cp1414 vdd xs1n_x 1.03e-15
Cp1415 vdd xs1p_cbn 1.253e-15
Cp1416 vdd xs1p_cbp 4.04e-16
Cp1417 vdd xs1p_g 1.226e-15
Cp1418 vdd xs1p_n10 2.655e-16
Cp1419 vdd xs1p_x 4.537e-16
Cp1420 vref vrefl 1.201e-15
Cp1421 vref xc4_din 6.717e-17
Cp1422 vref xc4_dip 1.878e-15
Cp1423 vref xc4_xs1_tail 7.49e-16
Cp1424 vref xc5_din 5.329e-16
Cp1425 vref xc5_dip 1.619e-15
Cp1426 vref xc5_lt 5.777e-16
Cp1427 vrefl xc4_din 2.657e-16
Cp1428 vrefl xc4_dip 3.715e-15
Cp1429 vrefl xc4_outnb 3.337e-16
Cp1430 vrefl xc4_outpb 6.251e-18
Cp1431 vrefl xc4_xs1_tail 4.984e-16
Cp1432 vrefl xc5_din 1.678e-15
Cp1433 vrefl xc5_dip 7.255e-16
Cp1434 vrefl xc5_lt 3.867e-16
Cp1435 xc4_din xc4_dip 1.305e-14
Cp1436 xc4_din xc4_outnb 5.449e-17
Cp1437 xc4_din xc4_outpb 5.651e-17
Cp1438 xc4_din xc4_xs1_tail 7.635e-15
Cp1439 xc4_din xc5_din 5.158e-16
Cp1440 xc4_din xc5_dip 1.114e-16
Cp1441 xc4_din xc5_lt 9.767e-17
Cp1442 xc4_din xc5_xs1_tail 1.185e-17
Cp1443 xc4_dip xc4_outnb 6.196e-17
Cp1444 xc4_dip xc4_outpb 6.067e-17
Cp1445 xc4_dip xc4_xs1_tail 3.971e-15
Cp1446 xc4_dip xc4_xs1_tail0 3.203e-18
Cp1447 xc4_dip xc5_din 2.496e-15
Cp1448 xc4_dip xc5_dip 1.728e-16
Cp1449 xc4_dip xc5_lt 6.385e-17
Cp1450 xc4_dip xc5_xs1_tail 7.374e-16
Cp1451 xc4_lt xc4_outpb 7.066e-19
Cp1452 xc4_lt xc5_outnb 1.885e-17
Cp1453 xc4_lt xc5_outpb 3.328e-17
Cp1454 xc4_outnb xc4_outpb 4.518e-15
Cp1455 xc4_outnb xc5_outnb 2.373e-17
Cp1456 xc4_outnb xc5_outpb 2.508e-17
Cp1457 xc4_outpb xc5_lt 1.49e-19
Cp1458 xc4_outpb xc5_outnb 1.509e-16
Cp1459 xc4_outpb xc5_outpb 1.157e-15
Cp1460 xc4_xs1_tail xc4_xs1_tail0 8.297e-16
Cp1461 xc4_xs1_tail xc5_din 8.598e-16
Cp1462 xc4_xs1_tail xc5_dip 8.847e-16
Cp1463 xc4_xs1_tail xc5_lt 5.737e-17
Cp1464 xc4_xs1_tail xc5_xs1_tail 3.014e-16
Cp1465 xc4_xs1_tail xc5_xs1_tail0 2.353e-17
Cp1466 xc4_xs1_tail0 xc5_lt 2.383e-18
Cp1467 xc4_xs1_tail0 xc5_outnb 2.086e-17
Cp1468 xc4_xs1_tail0 xc5_outpb 1.36e-19
Cp1469 xc5_din xc5_dip 6.147e-15
Cp1470 xc5_din xc5_lt 6.443e-17
Cp1471 xc5_din xc5_xs1_tail 1.235e-15
Cp1472 xc5_din xc5_xs1_tail0 8.337e-17
Cp1473 xc5_dip xc5_lt 1.578e-15
Cp1474 xc5_dip xc5_xs1_tail 1.188e-15
Cp1475 xc5_dip xc5_xs1_tail0 7.261e-17
Cp1476 xc5_lt xc5_outnb 1.49e-19
Cp1477 xc5_lt xc5_outpb 9.541e-18
Cp1478 xc5_lt xc5_xs1_tail 3.762e-19
Cp1479 xc5_lt xc5_xs1_tail0 1.258e-18
Cp1480 xc5_outnb xc5_outpb 2.978e-15
Cp1481 xc5_xs1_tail xc5_xs1_tail0 2.314e-16
Cp1482 xs0n_cbn xs0n_cbp 3.563e-16
Cp1483 xs0n_cbn xs0n_g 6.205e-16
Cp1484 xs0n_cbn xs0n_n10 4.518e-16
Cp1485 xs0n_cbn xs0n_x 8.617e-16
Cp1486 xs0n_cbp xs0n_g 7.229e-16
Cp1487 xs0n_cbp xs0n_n10 3.831e-17
Cp1488 xs0n_cbp xs0n_x 1.037e-16
Cp1489 xs0n_cbp xs0p_g 2.295e-17
Cp1490 xs0n_g xs0n_n10 4.961e-16
Cp1491 xs0n_g xs0n_x 1.329e-15
Cp1492 xs0n_g xs0p_g 7.106e-18
Cp1493 xs0n_n10 xs0n_x 2.348e-17
Cp1494 xs0n_x xs0p_g 1.341e-17
Cp1495 xs0p_cbn xs0p_cbp 9.998e-16
Cp1496 xs0p_cbn xs0p_g 1.547e-15
Cp1497 xs0p_cbn xs0p_n10 6.098e-16
Cp1498 xs0p_cbn xs0p_x 1.097e-15
Cp1499 xs0p_cbp xs0p_g 6.461e-16
Cp1500 xs0p_cbp xs0p_n10 7.24e-17
Cp1501 xs0p_cbp xs0p_x 6.7e-16
Cp1502 xs0p_g xs0p_n10 5.16e-16
Cp1503 xs0p_g xs0p_x 1.545e-15
Cp1504 xs0p_n10 xs0p_x 2.417e-17
Cp1505 xs1n_cbn xs1n_cbp 3.679e-16
Cp1506 xs1n_cbn xs1n_g 1.218e-15
Cp1507 xs1n_cbn xs1n_n10 1.386e-16
Cp1508 xs1n_cbn xs1n_x 1.007e-15
Cp1509 xs1n_cbp xs1n_g 7.571e-16
Cp1510 xs1n_cbp xs1n_n10 1.43e-16
Cp1511 xs1n_cbp xs1n_x 9.054e-17
Cp1512 xs1n_cbp xs1p_g 1.064e-17
Cp1513 xs1n_g xs1n_n10 5.827e-16
Cp1514 xs1n_g xs1n_x 2.003e-16
Cp1515 xs1n_g xs1p_g 2.935e-17
Cp1516 xs1n_n10 xs1n_x 2.723e-17
Cp1517 xs1n_x xs1p_g 1.662e-17
Cp1518 xs1p_cbn xs1p_cbp 1.18e-15
Cp1519 xs1p_cbn xs1p_g 1.964e-15
Cp1520 xs1p_cbn xs1p_n10 6.628e-16
Cp1521 xs1p_cbn xs1p_x 1.271e-15
Cp1522 xs1p_cbp xs1p_g 5.906e-16
Cp1523 xs1p_cbp xs1p_n10 8.011e-17
Cp1524 xs1p_cbp xs1p_x 7.189e-16
Cp1525 xs1p_g xs1p_n10 5.182e-16
Cp1526 xs1p_g xs1p_x 1.825e-15
Cp1527 xs1p_n10 xs1p_x 1.858e-17
.ends
.subckt r1_adc_lay adc_hold is_smp clk adc_start adc_sel adc_valid_a adc_raw_a_0 adc_raw_a_1 adc_raw_a_2 adc_raw_a_3 adc_raw_a_4 adc_raw_a_5 adc_raw_a_6 adc_raw_a_7 adc_raw_a_8 adc_raw_a_9 adc_raw_a_10 adc_raw_a_11 adc_raw_a_12 adc_raw_a_13 adc_valid_b adc_raw_b_0 adc_raw_b_1 adc_raw_b_2 adc_raw_b_3 adc_raw_b_4 adc_raw_b_5 adc_raw_b_6 adc_raw_b_7 adc_raw_b_8 adc_raw_b_9 adc_raw_b_10 adc_raw_b_11 adc_raw_b_12 adc_raw_b_13 por_n ain_sin_p ain_sin_n ain_cos_p ain_cos_n vcm2 ibias ain_isa_p ain_isa_n ain_isb_p ain_isb_n vcm vdda vdd vss vref_in topap topan topbp topbn sar_clka sar_clkab sar_clkb sar_clkbb sar_clkna sar_clknab sar_clknb sar_clknbb sar_cna0 sar_cna1 sar_cna10 sar_cna11 sar_cna12 sar_cna2 sar_cna3 sar_cna4 sar_cna5 sar_cna6 sar_cna7 sar_cna8 sar_cna9 sar_cnb0 sar_cnb1 sar_cnb10 sar_cnb11 sar_cnb12 sar_cnb2 sar_cnb3 sar_cnb4 sar_cnb5 sar_cnb6 sar_cnb7 sar_cnb8 sar_cnb9 sar_cpa0 sar_cpa1 sar_cpa10 sar_cpa11 sar_cpa12 sar_cpa2 sar_cpa3 sar_cpa4 sar_cpa5 sar_cpa6 sar_cpa7 sar_cpa8 sar_cpa9 sar_cpb0 sar_cpb1 sar_cpb10 sar_cpb11 sar_cpb12 sar_cpb2 sar_cpb3 sar_cpb4 sar_cpb5 sar_cpb6 sar_cpb7 sar_cpb8 sar_cpb9 sar_oan sar_oann sar_oanp sar_oap sar_obn sar_obnn sar_obnp sar_obp sar_trka0 sar_trka1 sar_trkb0 sar_trkb1 sar_mclk
Xxckg_xpd0 xckg_d0__p1 clk vdd__p2 vdd sg13_lv_pmos w=1u l=0.5u ng=1 m=1
Xxckg_xnd0 xckg_d0 clk vss__p9 vss sg13_lv_nmos w=0.5u l=0.5u ng=1 m=1
Xxckg_cd0 xckg_d0__p2 vss__p16 cap_cmim w=2.53u l=2.53u m=1
Xxckg_xpd1 xckg_d1__p1 xckg_d0 vdd__p3 vdd sg13_lv_pmos w=1u l=0.5u ng=1 m=1
Xxckg_xnd1 xckg_d1 xckg_d0 vss__p10 vss sg13_lv_nmos w=0.5u l=0.5u ng=1 m=1
Xxckg_cd1 xckg_d1__p2 vss__p17 cap_cmim w=2.53u l=2.53u m=1
Xxckg_xpd2 xckg_d2__p1 xckg_d1 vdd__p4 vdd sg13_lv_pmos w=1u l=0.5u ng=1 m=1
Xxckg_xnd2 xckg_d2 xckg_d1 vss__p11 vss sg13_lv_nmos w=0.5u l=0.5u ng=1 m=1
Xxckg_cd2 xckg_d2__p2 vss__p18 cap_cmim w=2.53u l=2.53u m=1
Xxckg_xpd3 xckg_d3__p1 xckg_d2 vdd__p5 vdd sg13_lv_pmos w=1u l=0.5u ng=1 m=1
Xxckg_xnd3 xckg_d3 xckg_d2 vss__p12 vss sg13_lv_nmos w=0.5u l=0.5u ng=1 m=1
Xxckg_cd3 xckg_d3__p2 vss__p19 cap_cmim w=2.53u l=2.53u m=1
Xxckg_xpd4 xckg_x__p2 xckg_d3 vdd__p6 vdd sg13_lv_pmos w=1u l=0.5u ng=1 m=1
Xxckg_xnd4 xckg_x xckg_d3 vss__p13 vss sg13_lv_nmos w=0.5u l=0.5u ng=1 m=1
Xxckg_cd4 xckg_x__p4 vss__p20 cap_cmim w=2.53u l=2.53u m=1
Xxckg_xpa sar_mclk__p2 clk__p1 vdd__p7 vdd sg13_lv_pmos w=2u l=0.13u ng=1 m=1
Xxckg_xpb sar_mclk__p3 xckg_x__p3 vdd__p8 vdd sg13_lv_pmos w=2u l=0.13u ng=1 m=1
Xxckg_xna sar_mclk clk__p0 xckg_nn vss sg13_lv_nmos w=2u l=0.13u ng=1 m=1
Xxckg_xnb xckg_nn__p1 xckg_x__p1 vss__p14 vss sg13_lv_nmos w=2u l=0.13u ng=1 m=1
Xxckg_xpi mclkb__p1 sar_mclk__p4 vdd__p9 vdd sg13_lv_pmos w=2u l=0.13u ng=1 m=1
Xxckg_xni mclkb sar_mclk__p1 vss__p15 vss sg13_lv_nmos w=1u l=0.13u ng=1 m=1
Xxcbias_xmbd vbp__p1 vbp vdd__p1 vdd sg13_lv_pmos w=0.8u l=0.5u ng=1 m=1
Xxcbias_xrb_g0 vbp xcbias_xrb_s1 vss rppd w=1u l=40u m=1 b=0
Xxcbias_xrb_g1 xcbias_xrb_s1 xcbias_xrb_s2 vss rppd w=1u l=40u m=1 b=0
Xxcbias_xrb_g2 xcbias_xrb_s2 xcbias_xrb_s3 vss rppd w=1u l=40u m=1 b=0
Xxcbias_xrb_g3 xcbias_xrb_s3 vss__p7 vss rppd w=1u l=40u m=1 b=0
Xxcbiasn_xmbd vbn__p1 vbn vss__p8 vss sg13_lv_nmos w=0.2u l=0.5u ng=1 m=1
Xxcbiasn_xrb_g0 vdd__p0 xcbiasn_xrb_s1 vss rppd w=1u l=40u m=1 b=0
Xxcbiasn_xrb_g1 xcbiasn_xrb_s1 xcbiasn_xrb_s2 vss rppd w=1u l=40u m=1 b=0
Xxcbiasn_xrb_g2 xcbiasn_xrb_s2 xcbiasn_xrb_s3 vss rppd w=1u l=40u m=1 b=0
Xxcbiasn_xrb_g3 xcbiasn_xrb_s3 vbn vss rppd w=1u l=40u m=1 b=0
Xxref_xmb0 ibias__p0 ibias vss__p5 vss sg13_hv_nmos w=2u l=1u ng=1 m=1
Xxref_xmt xref_ntl ibias vss__p6 vss sg13_hv_nmos w=2u l=8u ng=1 m=1
Xxref_xm1 xref_na vref_in xref_ntl__p1 vss sg13_hv_nmos w=10u l=1u ng=2 m=1
Xxref_xm2 xref_ng vref xref_ntl__p2 vss sg13_hv_nmos w=10u l=1u ng=2 m=1
Xxref_xm3 xref_na__p1 xref_na vdda__p5 vdda sg13_hv_pmos w=4u l=1u ng=1 m=1
Xxref_xm4 xref_ng__p1 xref_na vdda__p6 vdda sg13_hv_pmos w=4u l=1u ng=1 m=1
Xxref_xcg_u0 vss xref_ng__p2 cap_cmim w=26.32u l=95u m=1
Xxref_xmsf_s0 vdda__p1 xref_ng vref vss sg13_hv_nmos w=80u l=0.45u ng=32 m=1
Xxref_xmsf_s1 vdda__p2 xref_ng vref__p5 vss sg13_hv_nmos w=80u l=0.45u ng=32 m=1
Xxref_xmsf_s2 vdda__p3 xref_ng vref__p6 vss sg13_hv_nmos w=80u l=0.45u ng=32 m=1
Xxref_xmsf_s3 vdda__p4 xref_ng vref__p7 vss sg13_hv_nmos w=80u l=0.45u ng=32 m=1
Xxref_xmib_s0 vref__p0 ibias vss__p0 vss sg13_hv_nmos w=80u l=1u ng=40 m=1
Xxref_xmib_s1 vref__p1 ibias vss__p1 vss sg13_hv_nmos w=80u l=1u ng=40 m=1
Xxref_xmib_s2 vref__p2 ibias vss__p2 vss sg13_hv_nmos w=80u l=1u ng=40 m=1
Xxref_xmib_s3 vref__p3 ibias vss__p3 vss sg13_hv_nmos w=80u l=1u ng=40 m=1
Xxref_xcd_u0 vss vref__p8 cap_cmim w=51.58u l=95u m=1
Xxref_xcd_u1 vss vref__p9 cap_cmim w=51.58u l=95u m=1
Xxref_xcd_u2 vss vref__p10 cap_cmim w=51.58u l=95u m=1
Xxref_xcd_u3 vss vref__p11 cap_cmim w=51.58u l=95u m=1
Xxref_xmsfl_s0 vdda__p0 xref_ng vrefl vss sg13_hv_nmos w=80u l=0.45u ng=32 m=1
Xxref_xmibl_s0 vrefl__p0 ibias vss__p4 vss sg13_hv_nmos w=80u l=1u ng=40 m=1
Xxref_xcdl_u0 vss vrefl__p2 cap_cmim w=51.58u l=95u m=1
Xxref_xcdl_u1 vss vrefl__p3 cap_cmim w=51.58u l=95u m=1
Xxfilt_xcf_u0 vss vref_in__p1 cap_cmim w=37.36u l=90u m=1
Xxfilt_xcf_u1 vss vref_in__p2 cap_cmim w=37.36u l=90u m=1
Xslice_a ain_sin_p__p1 ain_sin_n__p1 ain_isa_p__p1 ain_isa_n__p1 sar_trka0 sar_trka1 sar_cpa0 sar_cpa1 sar_cpa2 sar_cpa3 sar_cpa4 sar_cpa5 sar_cpa6 sar_cpa7 sar_cpa8 sar_cpa9 sar_cpa10 sar_cpa11 sar_cpa12 sar_cna0 sar_cna1 sar_cna2 sar_cna3 sar_cna4 sar_cna5 sar_cna6 sar_cna7 sar_cna8 sar_cna9 sar_cna10 sar_cna11 sar_cna12 sar_clka sar_clkab sar_clkna sar_clknab sar_oap sar_oan sar_oanp sar_oann vbp__p2 vbn__p2 vref__p12 vref__p13 vref__p14 vrefl__p4 vrefl__p5 topap topan vdd__p11 vdd__p12 vdd__p13 vdd__p14 xslice_a_gnd_nc0 vss__p22 xslice_a_gnd_nc2 vss__p23 xslice_a_gnd_nc4 vss__p24 xslice_a_gnd_nc6 vss__p25 r1_adc_slice_post
Xslice_b ain_cos_p__p1 ain_cos_n__p1 ain_isb_p__p1 ain_isb_n__p1 sar_trkb0 sar_trkb1 sar_cpb0 sar_cpb1 sar_cpb2 sar_cpb3 sar_cpb4 sar_cpb5 sar_cpb6 sar_cpb7 sar_cpb8 sar_cpb9 sar_cpb10 sar_cpb11 sar_cpb12 sar_cnb0 sar_cnb1 sar_cnb2 sar_cnb3 sar_cnb4 sar_cnb5 sar_cnb6 sar_cnb7 sar_cnb8 sar_cnb9 sar_cnb10 sar_cnb11 sar_cnb12 sar_clkb sar_clkbb sar_clknb sar_clknbb sar_obp sar_obn sar_obnp sar_obnn vbp__p3 vbn__p3 vref__p15 vref__p16 vref__p17 vrefl__p6 vrefl__p7 topbp topbn vdd__p15 vdd__p16 vdd__p17 vdd__p18 vss__p26 xslice_b_gnd_nc1 vss__p27 xslice_b_gnd_nc3 vss__p28 xslice_b_gnd_nc5 vss__p29 xslice_b_gnd_nc7 r1_adc_slice_post
Rt0 ain_cos_n ain_cos_n__p1 126.828
Rt1 ain_cos_p ain_cos_p__p1 128.647
Rt2 ain_isa_n ain_isa_n__p1 127.972
Rt3 ain_isa_p ain_isa_p__p1 129.791
Rt4 ain_isb_n ain_isb_n__p1 0.198
Rt5 ain_isb_p ain_isb_p__p1 0.198
Rt6 ain_sin_n ain_sin_n__p1 0.308
Rt7 ain_sin_p ain_sin_p__p1 0.308
Rt8 clk clk__p0 45.3911
Rt9 clk clk__p1 62.5679
Rt10 clk__p0 clk__p1 72.0627
Rt11 ibias ibias__p0 200.561
Rt12 mclkb mclkb__p1 43.3194
Rt13 sar_mclk sar_mclk__p1 56.5336
Rt14 sar_mclk sar_mclk__p3 125.793
Rt15 sar_mclk sar_mclk__p4 124.991
Rt16 sar_mclk__p1 sar_mclk__p3 116.67
Rt17 sar_mclk__p1 sar_mclk__p4 115.926
Rt18 sar_mclk__p2 sar_mclk__p3 0.6204
Rt19 sar_mclk__p3 sar_mclk__p4 23.2017
Rt20 vbn vbn__p1 68.8436
Rt21 vbn vbn__p2 240.016
Rt22 vbn vbn__p3 784.574
Rt23 vbn__p1 vbn__p2 217.489
Rt24 vbn__p1 vbn__p3 710.938
Rt25 vbn__p2 vbn__p3 168.032
Rt26 vbp vbp__p1 73.6975
Rt27 vbp vbp__p2 245.763
Rt28 vbp vbp__p3 1260.46
Rt29 vbp__p1 vbp__p2 195.517
Rt30 vbp__p1 vbp__p3 1002.76
Rt31 vbp__p2 vbp__p3 154.24
Rt32 vdd vdd__p0 34389.1
Rt33 vdd vdd__p1 40943
Rt34 vdd vdd__p11 82.2115
Rt35 vdd vdd__p12 11.0679
Rt36 vdd vdd__p13 29.2467
Rt37 vdd vdd__p14 436.353
Rt38 vdd vdd__p15 3346.14
Rt39 vdd vdd__p16 41638.1
Rt40 vdd vdd__p17 762947
Rt41 vdd__p0 vdd__p1 119.607
Rt42 vdd__p0 vdd__p11 99.6158
Rt43 vdd__p0 vdd__p12 288.609
Rt44 vdd__p0 vdd__p13 7715.85
Rt45 vdd__p0 vdd__p14 115118
Rt46 vdd__p0 vdd__p15 882776
Rt47 vdd__p1 vdd__p11 118.601
Rt48 vdd__p1 vdd__p12 343.612
Rt49 vdd__p1 vdd__p13 9186.33
Rt50 vdd__p1 vdd__p14 137057
Rt51 vdd__p11 vdd__p12 0.697261
Rt52 vdd__p11 vdd__p13 18.4457
Rt53 vdd__p11 vdd__p14 275.205
Rt54 vdd__p11 vdd__p15 2110.39
Rt55 vdd__p11 vdd__p16 26260.8
Rt56 vdd__p11 vdd__p17 481185
Rt57 vdd__p12 vdd__p13 2.4833
Rt58 vdd__p12 vdd__p14 37.0501
Rt59 vdd__p12 vdd__p15 284.116
Rt60 vdd__p12 vdd__p16 3535.43
Rt61 vdd__p12 vdd__p17 64780.7
Rt62 vdd__p12 vdd__p18 894412
Rt63 vdd__p13 vdd__p14 0.52562
Rt64 vdd__p13 vdd__p15 4.4303
Rt65 vdd__p13 vdd__p16 55.1288
Rt66 vdd__p13 vdd__p17 1010.14
Rt67 vdd__p13 vdd__p18 13946.8
Rt68 vdd__p14 vdd__p15 0.367865
Rt69 vdd__p14 vdd__p16 6.97049
Rt70 vdd__p14 vdd__p17 127.722
Rt71 vdd__p14 vdd__p18 1763.43
Rt72 vdd__p15 vdd__p16 0.802998
Rt73 vdd__p15 vdd__p17 14.9189
Rt74 vdd__p15 vdd__p18 205.982
Rt75 vdd__p16 vdd__p17 2.61773
Rt76 vdd__p16 vdd__p18 36.1423
Rt77 vdd__p16 vdd__p2 818965
Rt78 vdd__p16 vdd__p3 750476
Rt79 vdd__p16 vdd__p4 638837
Rt80 vdd__p16 vdd__p5 515222
Rt81 vdd__p16 vdd__p6 401045
Rt82 vdd__p16 vdd__p7 738625
Rt83 vdd__p16 vdd__p8 519274
Rt84 vdd__p16 vdd__p9 430036
Rt85 vdd__p17 vdd__p18 0.487483
Rt86 vdd__p17 vdd__p2 12054.5
Rt87 vdd__p17 vdd__p3 11046.4
Rt88 vdd__p17 vdd__p4 9403.17
Rt89 vdd__p17 vdd__p5 7583.66
Rt90 vdd__p17 vdd__p6 5903.07
Rt91 vdd__p17 vdd__p7 10872
Rt92 vdd__p17 vdd__p8 7643.31
Rt93 vdd__p17 vdd__p9 6329.78
Rt94 vdd__p18 vdd__p2 3600.08
Rt95 vdd__p18 vdd__p3 3299.01
Rt96 vdd__p18 vdd__p4 2808.25
Rt97 vdd__p18 vdd__p5 2264.86
Rt98 vdd__p18 vdd__p6 1762.95
Rt99 vdd__p18 vdd__p7 3246.91
Rt100 vdd__p18 vdd__p8 2282.67
Rt101 vdd__p18 vdd__p9 1890.39
Rt102 vdd__p2 vdd__p3 88.7111
Rt103 vdd__p2 vdd__p4 115.499
Rt104 vdd__p2 vdd__p5 146.381
Rt105 vdd__p2 vdd__p6 177.721
Rt106 vdd__p2 vdd__p7 385.4
Rt107 vdd__p2 vdd__p8 419.34
Rt108 vdd__p2 vdd__p9 441.535
Rt109 vdd__p3 vdd__p4 105.84
Rt110 vdd__p3 vdd__p5 134.139
Rt111 vdd__p3 vdd__p6 162.858
Rt112 vdd__p3 vdd__p7 353.17
Rt113 vdd__p3 vdd__p8 384.272
Rt114 vdd__p3 vdd__p9 404.61
Rt115 vdd__p4 vdd__p5 114.185
Rt116 vdd__p4 vdd__p6 138.632
Rt117 vdd__p4 vdd__p7 300.633
Rt118 vdd__p4 vdd__p8 327.108
Rt119 vdd__p4 vdd__p9 344.421
Rt120 vdd__p5 vdd__p6 111.806
Rt121 vdd__p5 vdd__p7 242.461
Rt122 vdd__p5 vdd__p8 263.813
Rt123 vdd__p5 vdd__p9 277.776
Rt124 vdd__p6 vdd__p7 188.73
Rt125 vdd__p6 vdd__p8 205.35
Rt126 vdd__p6 vdd__p9 216.219
Rt127 vdd__p7 vdd__p8 378.203
Rt128 vdd__p7 vdd__p9 398.221
Rt129 vdd__p8 vdd__p9 279.961
Rt130 vdda vdda__p1 41.3489
Rt131 vdda vdda__p2 278.578
Rt132 vdda vdda__p3 56.012
Rt133 vdda vdda__p5 261.48
Rt134 vdda vdda__p6 203.591
Rt135 vdda__p0 vdda__p3 62.8025
Rt136 vdda__p0 vdda__p4 67.5999
Rt137 vdda__p1 vdda__p2 1202.37
Rt138 vdda__p1 vdda__p3 241.754
Rt139 vdda__p1 vdda__p5 1128.58
Rt140 vdda__p1 vdda__p6 878.722
Rt141 vdda__p2 vdda__p3 256.165
Rt142 vdda__p2 vdda__p5 63.6193
Rt143 vdda__p2 vdda__p6 79.0683
Rt144 vdda__p3 vdda__p4 23.0314
Rt145 vdda__p3 vdda__p5 240.442
Rt146 vdda__p3 vdda__p6 187.211
Rt147 vdda__p5 vdda__p6 74.2153
Rt148 vref vref__p0 114.65
Rt149 vref vref__p1 6.10169
Rt150 vref vref__p10 186.142
Rt151 vref vref__p11 8271.36
Rt152 vref vref__p12 1487.93
Rt153 vref vref__p13 808.459
Rt154 vref vref__p14 372.871
Rt155 vref vref__p15 1459.54
Rt156 vref vref__p16 3157.02
Rt157 vref vref__p17 5801
Rt158 vref vref__p2 370.329
Rt159 vref vref__p3 10248.9
Rt160 vref vref__p5 428.96
Rt161 vref vref__p6 1135.72
Rt162 vref vref__p7 3138.93
Rt163 vref vref__p8 2223.31
Rt164 vref vref__p9 50.9452
Rt165 vref__p0 vref__p1 5.08178
Rt166 vref__p0 vref__p10 1372.92
Rt167 vref__p0 vref__p11 61005.8
Rt168 vref__p0 vref__p12 11330.2
Rt169 vref__p0 vref__p13 6156.32
Rt170 vref__p0 vref__p14 2839.43
Rt171 vref__p0 vref__p15 10764.9
Rt172 vref__p0 vref__p16 23284.7
Rt173 vref__p0 vref__p17 42785.5
Rt174 vref__p0 vref__p2 2151.06
Rt175 vref__p0 vref__p3 74645.3
Rt176 vref__p0 vref__p5 1782.68
Rt177 vref__p0 vref__p6 6979.82
Rt178 vref__p0 vref__p7 23027.9
Rt179 vref__p0 vref__p8 16928.7
Rt180 vref__p0 vref__p9 387.793
Rt181 vref__p1 vref__p10 27.2286
Rt182 vref__p1 vref__p11 1209.68
Rt183 vref__p1 vref__p12 366.189
Rt184 vref__p1 vref__p13 199.066
Rt185 vref__p1 vref__p14 91.8501
Rt186 vref__p1 vref__p15 213.441
Rt187 vref__p1 vref__p16 461.684
Rt188 vref__p1 vref__p17 848.354
Rt189 vref__p1 vref__p2 8.38761
Rt190 vref__p1 vref__p3 1193.26
Rt191 vref__p1 vref__p5 6.38445
Rt192 vref__p1 vref__p6 32.923
Rt193 vref__p1 vref__p7 414.228
Rt194 vref__p1 vref__p8 546.455
Rt195 vref__p1 vref__p9 12.4499
Rt196 vref__p10 vref__p11 1.96723
Rt197 vref__p10 vref__p12 390.352
Rt198 vref__p10 vref__p13 212.377
Rt199 vref__p10 vref__p14 98.0606
Rt200 vref__p10 vref__p15 1.88326
Rt201 vref__p10 vref__p16 2.58285
Rt202 vref__p10 vref__p17 2.96452
Rt203 vref__p10 vref__p2 13.5031
Rt204 vref__p10 vref__p3 151.839
Rt205 vref__p10 vref__p5 105.826
Rt206 vref__p10 vref__p6 71.6163
Rt207 vref__p10 vref__p7 45.7002
Rt208 vref__p10 vref__p8 581.257
Rt209 vref__p10 vref__p9 13.1189
Rt210 vref__p11 vref__p12 17345.9
Rt211 vref__p11 vref__p13 9437.27
Rt212 vref__p11 vref__p14 4357.47
Rt213 vref__p11 vref__p15 11.7242
Rt214 vref__p11 vref__p16 6.70636
Rt215 vref__p11 vref__p17 3.30899
Rt216 vref__p11 vref__p2 588.996
Rt217 vref__p11 vref__p3 6559.22
Rt218 vref__p11 vref__p5 4701.78
Rt219 vref__p11 vref__p6 3179.28
Rt220 vref__p11 vref__p7 1973.95
Rt221 vref__p11 vref__p8 25829
Rt222 vref__p11 vref__p9 582.958
Rt223 vref__p12 vref__p13 2.76051
Rt224 vref__p12 vref__p14 5.69068
Rt225 vref__p12 vref__p15 3060.82
Rt226 vref__p12 vref__p16 6620.62
Rt227 vref__p12 vref__p17 12165.3
Rt228 vref__p12 vref__p2 961.871
Rt229 vref__p12 vref__p3 21690.6
Rt230 vref__p12 vref__p5 2025.57
Rt231 vref__p12 vref__p6 2781.47
Rt232 vref__p12 vref__p7 6608.37
Rt233 vref__p12 vref__p8 3.41549
Rt234 vref__p12 vref__p9 2.8795
Rt235 vref__p13 vref__p14 2.76481
Rt236 vref__p13 vref__p15 1665.29
Rt237 vref__p13 vref__p16 3602.05
Rt238 vref__p13 vref__p17 6618.72
Rt239 vref__p13 vref__p2 523.306
Rt240 vref__p13 vref__p3 11801.1
Rt241 vref__p13 vref__p5 1101.86
Rt242 vref__p13 vref__p6 1513.26
Rt243 vref__p13 vref__p7 3595.37
Rt244 vref__p13 vref__p8 6.9687
Rt245 vref__p13 vref__p9 2.56608
Rt246 vref__p14 vref__p15 768.912
Rt247 vref__p14 vref__p16 1663.17
Rt248 vref__p14 vref__p17 3056.06
Rt249 vref__p14 vref__p2 241.621
Rt250 vref__p14 vref__p3 5448.89
Rt251 vref__p14 vref__p5 508.693
Rt252 vref__p14 vref__p6 698.702
Rt253 vref__p14 vref__p7 1660.09
Rt254 vref__p14 vref__p8 12.1708
Rt255 vref__p14 vref__p9 1.86726
Rt256 vref__p15 vref__p16 2.76621
Rt257 vref__p15 vref__p17 5.68373
Rt258 vref__p15 vref__p2 103.213
Rt259 vref__p15 vref__p3 1145.31
Rt260 vref__p15 vref__p5 829.619
Rt261 vref__p15 vref__p6 560.804
Rt262 vref__p15 vref__p7 344.658
Rt263 vref__p15 vref__p8 4557.75
Rt264 vref__p15 vref__p9 102.868
Rt265 vref__p16 vref__p17 2.75986
Rt266 vref__p16 vref__p2 223.556
Rt267 vref__p16 vref__p3 2482.45
Rt268 vref__p16 vref__p5 1794.5
Rt269 vref__p16 vref__p6 1213.12
Rt270 vref__p16 vref__p7 747.047
Rt271 vref__p16 vref__p8 9858.5
Rt272 vref__p16 vref__p9 222.505
Rt273 vref__p17 vref__p2 411.407
Rt274 vref__p17 vref__p3 4571.97
Rt275 vref__p17 vref__p5 3297.42
Rt276 vref__p17 vref__p6 2229.27
Rt277 vref__p17 vref__p7 1375.86
Rt278 vref__p17 vref__p8 18114.9
Rt279 vref__p17 vref__p9 408.851
Rt280 vref__p2 vref__p3 5.49374
Rt281 vref__p2 vref__p5 65.7993
Rt282 vref__p2 vref__p6 7.45703
Rt283 vref__p2 vref__p7 6.5906
Rt284 vref__p2 vref__p8 1432.38
Rt285 vref__p2 vref__p9 32.3382
Rt286 vref__p3 vref__p5 5279.01
Rt287 vref__p3 vref__p6 2064.28
Rt288 vref__p3 vref__p7 48.2546
Rt289 vref__p3 vref__p8 32298.7
Rt290 vref__p3 vref__p9 728.99
Rt291 vref__p5 vref__p6 244.984
Rt292 vref__p5 vref__p7 1709.1
Rt293 vref__p5 vref__p8 3017.46
Rt294 vref__p5 vref__p9 68.2281
Rt295 vref__p6 vref__p7 871.249
Rt296 vref__p6 vref__p8 4142.06
Rt297 vref__p6 vref__p9 93.5132
Rt298 vref__p7 vref__p8 9840.28
Rt299 vref__p7 vref__p9 222.096
Rt300 vref__p8 vref__p9 1.94076
Rt301 vref_in vref_in__p1 0.001
Rt302 vref_in vref_in__p2 0.001
Rt303 vrefl vrefl__p0 31.2586
Rt304 vrefl vrefl__p2 93.437
Rt305 vrefl vrefl__p3 7.18444
Rt306 vrefl vrefl__p4 7325.4
Rt307 vrefl vrefl__p5 4916.21
Rt308 vrefl vrefl__p6 359.98
Rt309 vrefl vrefl__p7 574.557
Rt310 vrefl__p0 vrefl__p2 18.0283
Rt311 vrefl__p0 vrefl__p3 12.5916
Rt312 vrefl__p0 vrefl__p4 63.5642
Rt313 vrefl__p0 vrefl__p5 72.9525
Rt314 vrefl__p0 vrefl__p6 631.93
Rt315 vrefl__p0 vrefl__p7 1009.16
Rt316 vrefl__p2 vrefl__p3 2.16812
Rt317 vrefl__p2 vrefl__p4 8.30061
Rt318 vrefl__p2 vrefl__p5 5.37046
Rt319 vrefl__p2 vrefl__p6 117.734
Rt320 vrefl__p2 vrefl__p7 192.433
Rt321 vrefl__p3 vrefl__p4 211.164
Rt322 vrefl__p3 vrefl__p5 128.531
Rt323 vrefl__p3 vrefl__p6 5.07096
Rt324 vrefl__p3 vrefl__p7 7.53987
Rt325 vrefl__p4 vrefl__p5 31.8717
Rt326 vrefl__p4 vrefl__p6 11315.9
Rt327 vrefl__p4 vrefl__p7 18493.5
Rt328 vrefl__p5 vrefl__p6 6889.67
Rt329 vrefl__p5 vrefl__p7 11261.9
Rt330 vrefl__p6 vrefl__p7 32.2289
Rt331 vss vss__p0 34.945
Rt332 vss vss__p1 372.7
Rt333 vss vss__p10 3790.86
Rt334 vss vss__p11 4337.67
Rt335 vss vss__p12 4581.33
Rt336 vss vss__p13 4426.67
Rt337 vss vss__p14 1679.54
Rt338 vss vss__p15 3863.88
Rt339 vss vss__p16 2714.4
Rt340 vss vss__p17 3470.72
Rt341 vss vss__p18 3221.91
Rt342 vss vss__p19 69396.7
Rt343 vss vss__p2 151.948
Rt344 vss vss__p20 339726
Rt345 vss vss__p22 2
Rt346 vss vss__p23 2
Rt347 vss vss__p24 2
Rt348 vss vss__p25 2
Rt349 vss vss__p26 2
Rt350 vss vss__p27 2
Rt351 vss vss__p28 2
Rt352 vss vss__p29 2
Rt353 vss vss__p3 88.9409
Rt354 vss vss__p4 1075.9
Rt355 vss vss__p5 1332.64
Rt356 vss vss__p6 1752.43
Rt357 vss vss__p7 37.7287
Rt358 vss vss__p8 41.2352
Rt359 vss vss__p9 3117.63
Rt360 vss__p0 vss__p1 169.257
Rt361 vss__p0 vss__p10 162600
Rt362 vss__p0 vss__p11 186054
Rt363 vss__p0 vss__p12 196505
Rt364 vss__p0 vss__p13 189872
Rt365 vss__p0 vss__p14 72040
Rt366 vss__p0 vss__p15 165732
Rt367 vss__p0 vss__p16 116428
Rt368 vss__p0 vss__p17 148868
Rt369 vss__p0 vss__p18 138196
Rt370 vss__p0 vss__p2 6646.98
Rt371 vss__p0 vss__p3 3890.73
Rt372 vss__p0 vss__p4 488.606
Rt373 vss__p0 vss__p5 605.202
Rt374 vss__p0 vss__p6 795.844
Rt375 vss__p0 vss__p7 445.234
Rt376 vss__p0 vss__p8 490.023
Rt377 vss__p0 vss__p9 133723
Rt378 vss__p1 vss__p14 768330
Rt379 vss__p1 vss__p2 70892.2
Rt380 vss__p1 vss__p3 41495.9
Rt381 vss__p1 vss__p4 340.811
Rt382 vss__p1 vss__p5 422.139
Rt383 vss__p1 vss__p6 555.115
Rt384 vss__p1 vss__p7 4748.57
Rt385 vss__p1 vss__p8 5226.25
Rt386 vss__p10 vss__p11 112.446
Rt387 vss__p10 vss__p12 142.098
Rt388 vss__p10 vss__p13 171.756
Rt389 vss__p10 vss__p14 353.419
Rt390 vss__p10 vss__p15 241.972
Rt391 vss__p10 vss__p16 658.005
Rt392 vss__p10 vss__p17 841.347
Rt393 vss__p10 vss__p18 781.032
Rt394 vss__p10 vss__p19 16822.6
Rt395 vss__p10 vss__p2 73319.5
Rt396 vss__p10 vss__p20 82353.9
Rt397 vss__p10 vss__p3 42916.7
Rt398 vss__p10 vss__p7 151636
Rt399 vss__p10 vss__p8 182397
Rt400 vss__p10 vss__p9 97.4244
Rt401 vss__p11 vss__p12 118.915
Rt402 vss__p11 vss__p13 144.572
Rt403 vss__p11 vss__p14 341.382
Rt404 vss__p11 vss__p15 207.376
Rt405 vss__p11 vss__p16 653.57
Rt406 vss__p11 vss__p17 835.677
Rt407 vss__p11 vss__p18 775.768
Rt408 vss__p11 vss__p19 16709.3
Rt409 vss__p11 vss__p2 83895.4
Rt410 vss__p11 vss__p20 81798.9
Rt411 vss__p11 vss__p3 49107.2
Rt412 vss__p11 vss__p7 173509
Rt413 vss__p11 vss__p8 208707
Rt414 vss__p11 vss__p9 126.229
Rt415 vss__p12 vss__p13 115.709
Rt416 vss__p12 vss__p14 303.402
Rt417 vss__p12 vss__p15 168.034
Rt418 vss__p12 vss__p16 595.316
Rt419 vss__p12 vss__p17 761.191
Rt420 vss__p12 vss__p18 706.622
Rt421 vss__p12 vss__p19 15219.9
Rt422 vss__p12 vss__p2 88608
Rt423 vss__p12 vss__p20 74507.9
Rt424 vss__p12 vss__p3 51865.6
Rt425 vss__p12 vss__p7 183255
Rt426 vss__p12 vss__p8 220430
Rt427 vss__p12 vss__p9 158.709
Rt428 vss__p13 vss__p14 252.325
Rt429 vss__p13 vss__p15 131.183
Rt430 vss__p13 vss__p16 504.38
Rt431 vss__p13 vss__p17 644.916
Rt432 vss__p13 vss__p18 598.683
Rt433 vss__p13 vss__p19 12895
Rt434 vss__p13 vss__p2 85616.8
Rt435 vss__p13 vss__p20 63126.6
Rt436 vss__p13 vss__p3 50114.8
Rt437 vss__p13 vss__p7 177069
Rt438 vss__p13 vss__p8 212989
Rt439 vss__p13 vss__p9 190.362
Rt440 vss__p14 vss__p15 195.469
Rt441 vss__p14 vss__p16 229.165
Rt442 vss__p14 vss__p17 293.018
Rt443 vss__p14 vss__p18 272.012
Rt444 vss__p14 vss__p19 5858.86
Rt445 vss__p14 vss__p2 32484.2
Rt446 vss__p14 vss__p20 28681.6
Rt447 vss__p14 vss__p3 19014.3
Rt448 vss__p14 vss__p7 67182.5
Rt449 vss__p14 vss__p8 80811
Rt450 vss__p14 vss__p9 335.047
Rt451 vss__p15 vss__p16 344.291
Rt452 vss__p15 vss__p17 440.222
Rt453 vss__p15 vss__p18 408.663
Rt454 vss__p15 vss__p19 8802.2
Rt455 vss__p15 vss__p2 74731.7
Rt456 vss__p15 vss__p20 43090.5
Rt457 vss__p15 vss__p3 43743.3
Rt458 vss__p15 vss__p7 154557
Rt459 vss__p15 vss__p8 185910
Rt460 vss__p15 vss__p9 262.034
Rt461 vss__p16 vss__p17 51.3118
Rt462 vss__p16 vss__p18 47.6333
Rt463 vss__p16 vss__p19 1025.97
Rt464 vss__p16 vss__p2 52499.6
Rt465 vss__p16 vss__p20 5022.57
Rt466 vss__p16 vss__p3 30730
Rt467 vss__p16 vss__p7 108577
Rt468 vss__p16 vss__p8 130603
Rt469 vss__p16 vss__p9 607.426
Rt470 vss__p17 vss__p18 39.2224
Rt471 vss__p17 vss__p19 844.81
Rt472 vss__p17 vss__p2 67127.7
Rt473 vss__p17 vss__p20 4135.7
Rt474 vss__p17 vss__p3 39292.4
Rt475 vss__p17 vss__p7 138831
Rt476 vss__p17 vss__p8 166994
Rt477 vss__p17 vss__p9 776.674
Rt478 vss__p18 vss__p19 0.666138
Rt479 vss__p18 vss__p2 62315.4
Rt480 vss__p18 vss__p20 3.26102
Rt481 vss__p18 vss__p3 36475.6
Rt482 vss__p18 vss__p7 128878
Rt483 vss__p18 vss__p8 155022
Rt484 vss__p18 vss__p9 720.996
Rt485 vss__p19 vss__p20 0.970954
Rt486 vss__p19 vss__p3 785647
Rt487 vss__p19 vss__p9 15529.5
Rt488 vss__p2 vss__p3 63.5752
Rt489 vss__p2 vss__p4 204650
Rt490 vss__p2 vss__p5 253485
Rt491 vss__p2 vss__p6 333334
Rt492 vss__p2 vss__p7 6625.71
Rt493 vss__p2 vss__p8 7693.25
Rt494 vss__p2 vss__p9 60298.5
Rt495 vss__p20 vss__p9 76023.5
Rt496 vss__p3 vss__p4 119789
Rt497 vss__p3 vss__p5 148375
Rt498 vss__p3 vss__p6 195113
Rt499 vss__p3 vss__p7 3878.28
Rt500 vss__p3 vss__p8 4503.15
Rt501 vss__p3 vss__p9 35295
Rt502 vss__p4 vss__p5 99.6258
Rt503 vss__p4 vss__p6 131.008
Rt504 vss__p4 vss__p7 13708
Rt505 vss__p4 vss__p8 15087
Rt506 vss__p5 vss__p6 57.9371
Rt507 vss__p5 vss__p7 16979.2
Rt508 vss__p5 vss__p8 18687.2
Rt509 vss__p6 vss__p7 22327.7
Rt510 vss__p6 vss__p8 24573.8
Rt511 vss__p7 vss__p8 217.108
Rt512 vss__p7 vss__p9 124707
Rt513 vss__p8 vss__p9 150005
Rt514 xckg_d0 xckg_d0__p1 206.411
Rt515 xckg_d0 xckg_d0__p2 50.6383
Rt516 xckg_d0__p1 xckg_d0__p2 40.5376
Rt517 xckg_d1 xckg_d1__p1 176.827
Rt518 xckg_d1 xckg_d1__p2 53.6164
Rt519 xckg_d1__p1 xckg_d1__p2 42.2433
Rt520 xckg_d2 xckg_d2__p1 98.5076
Rt521 xckg_d2 xckg_d2__p2 97.0379
Rt522 xckg_d2__p1 xckg_d2__p2 76.6587
Rt523 xckg_d3 xckg_d3__p1 99.3636
Rt524 xckg_d3 xckg_d3__p2 100.408
Rt525 xckg_d3__p1 xckg_d3__p2 78.0493
Rt526 xckg_nn xckg_nn__p1 46.1928
Rt527 xckg_x xckg_x__p1 68.4444
Rt528 xckg_x xckg_x__p2 147.088
Rt529 xckg_x xckg_x__p3 1240.78
Rt530 xckg_x xckg_x__p4 614.493
Rt531 xckg_x__p1 xckg_x__p2 97.458
Rt532 xckg_x__p1 xckg_x__p3 822.123
Rt533 xckg_x__p1 xckg_x__p4 407.153
Rt534 xckg_x__p2 xckg_x__p3 124.848
Rt535 xckg_x__p2 xckg_x__p4 61.8301
Rt536 xckg_x__p3 xckg_x__p4 33.2764
Rt537 xref_na xref_na__p1 77.984
Rt538 xref_ng xref_ng__p1 1225.95
Rt539 xref_ng xref_ng__p2 132.884
Rt540 xref_ng__p1 xref_ng__p2 31.5508
Rt541 xref_ntl xref_ntl__p1 60.2546
Rt542 xref_ntl__p1 xref_ntl__p2 19.318
Cq0 ain_cos_n ain_cos_p 2.707e-14
Cq1 ain_cos_n ain_isa_n 3.553e-17
Cq2 ain_cos_n ain_isa_p 4.484e-17
Cq3 ain_cos_n ibias 1.097e-16
Cq4 ain_cos_n vdd 1.545e-16
Cq5 ain_cos_n vss 3.47e-14
Cq6 ain_cos_n xckg_d0 9.755e-19
Cq7 ain_cos_n xckg_d1 9.755e-19
Cq8 ain_cos_n xckg_d2 9.755e-19
Cq9 ain_cos_n xckg_d3 1.006e-18
Cq10 ain_cos_n xckg_x 9.096e-19
Cq11 ain_cos_p ain_isa_n 3.556e-17
Cq12 ain_cos_p ain_isa_p 4.84e-17
Cq13 ain_cos_p ibias 2.317e-16
Cq14 ain_cos_p vdd 2.226e-17
Cq15 ain_cos_p vss 3.511e-14
Cq16 ain_isa_n ain_isa_p 2.783e-14
Cq17 ain_isa_n ain_isb_n 6.15e-17
Cq18 ain_isa_n ain_isb_p 6.417e-17
Cq19 ain_isa_n vdd 4.974e-16
Cq20 ain_isa_n vss 3.224e-14
Cq21 ain_isa_p ain_isb_n 7.645e-17
Cq22 ain_isa_p ain_isb_p 7.912e-17
Cq23 ain_isa_p vdd 1.655e-15
Cq24 ain_isa_p vss 3.144e-14
Cq25 ain_isb_n ain_isb_p 7.431e-17
Cq26 ain_isb_n vdd 1.258e-16
Cq27 ain_isb_n vss 8.117e-16
Cq28 ain_isb_p vdd 1.08e-16
Cq29 ain_isb_p vss 7.879e-16
Cq30 ain_sin_n ain_sin_p 8.625e-17
Cq31 ain_sin_n ibias 9.686e-17
Cq32 ain_sin_n vss 7.977e-16
Cq33 ain_sin_p ibias 9.686e-17
Cq34 ain_sin_p vss 7.924e-16
Cq35 clk mclkb 2.216e-18
Cq36 clk sar_mclk 1.431e-16
Cq37 clk vdd 4.256e-16
Cq38 clk vss 1.9e-14
Cq39 clk xckg_d0 2.205e-16
Cq40 clk xckg_d1 1.236e-16
Cq41 clk xckg_d2 1.227e-16
Cq42 clk xckg_d3 1.663e-16
Cq43 clk xckg_nn 2.534e-17
Cq44 clk xckg_x 1.452e-16
Cq45 ibias vbn 2.266e-15
Cq46 ibias vbp 6.102e-17
Cq47 ibias vdd 4.502e-15
Cq48 ibias vdda 2.216e-16
Cq49 ibias vref 4.11e-14
Cq50 ibias vref_in 9.847e-15
Cq51 ibias vrefl 1.687e-14
Cq52 ibias vss 1.681e-13
Cq53 ibias xref_ng 2.101e-15
Cq54 ibias xref_ntl 1.737e-16
Cq55 mclkb sar_mclk 2.613e-16
Cq56 mclkb vdd 3.868e-16
Cq57 mclkb vss 1.225e-15
Cq58 mclkb xckg_d0 5.591e-17
Cq59 mclkb xckg_d1 3.991e-15
Cq60 mclkb xckg_d2 3.955e-15
Cq61 mclkb xckg_d3 6.865e-17
Cq62 mclkb xckg_nn 1.864e-17
Cq63 mclkb xckg_x 9.569e-17
Cq64 sar_mclk vdd 1.618e-15
Cq65 sar_mclk vss 6.719e-15
Cq66 sar_mclk xckg_d0 4.707e-15
Cq67 sar_mclk xckg_d1 2.058e-16
Cq68 sar_mclk xckg_d2 7.519e-17
Cq69 sar_mclk xckg_d3 9.271e-17
Cq70 sar_mclk xckg_nn 4.141e-16
Cq71 sar_mclk xckg_x 1.044e-15
Cq72 vbn vbp 2.899e-14
Cq73 vbn vdd 2.028e-15
Cq74 vbn vdda 5.091e-17
Cq75 vbn vref 1.786e-14
Cq76 vbn vref_in 4.127e-15
Cq77 vbn vrefl 2.52e-14
Cq78 vbn vss 1.155e-14
Cq79 vbn xref_na 7.746e-19
Cq80 vbn xref_ng 1.886e-15
Cq81 vbp vdd 1.803e-15
Cq82 vbp vdda 8.761e-15
Cq83 vbp vref 1.878e-14
Cq84 vbp vref_in 4.205e-15
Cq85 vbp vrefl 1.08e-14
Cq86 vbp vss 1.857e-14
Cq87 vbp xref_na 9.789e-18
Cq88 vbp xref_ng 2.371e-15
Cq89 vdd vdda 5.954e-16
Cq90 vdd vref 1.718e-13
Cq91 vdd vref_in 4.225e-14
Cq92 vdd vrefl 5.877e-14
Cq93 vdd vss 1.539e-13
Cq94 vdd xckg_d0 5.77e-16
Cq95 vdd xckg_d1 4.281e-16
Cq96 vdd xckg_d2 3.088e-16
Cq97 vdd xckg_d3 4.114e-16
Cq98 vdd xckg_x 2.644e-15
Cq99 vdd xref_ng 1.363e-14
Cq100 vdda vref 4.398e-14
Cq101 vdda vref_in 3.223e-16
Cq102 vdda vrefl 2.519e-14
Cq103 vdda vss 3.507e-14
Cq104 vdda xref_na 1.249e-15
Cq105 vdda xref_ng 2.299e-14
Cq106 vdda xref_ntl 9.96e-18
Cq107 vref vref_in 4.541e-14
Cq108 vref vrefl 1.67e-13
Cq109 vref vss 3.743e-13
Cq110 vref xref_na 1.322e-16
Cq111 vref xref_ng 4.971e-14
Cq112 vref xref_ntl 1.685e-15
Cq113 vref_in vrefl 3.081e-14
Cq114 vref_in vss 9.166e-14
Cq115 vref_in xref_na 4.042e-16
Cq116 vref_in xref_ng 3.421e-15
Cq117 vref_in xref_ntl 1.606e-15
Cq118 vrefl vss 1.926e-13
Cq119 vrefl xref_na 1.039e-16
Cq120 vrefl xref_ng 3.178e-14
Cq121 vrefl xref_ntl 2.185e-15
Cq122 vss xckg_d0 4.927e-15
Cq123 vss xckg_d1 4.062e-15
Cq124 vss xckg_d2 4.793e-15
Cq125 vss xckg_d3 5.817e-15
Cq126 vss xckg_nn 1.117e-15
Cq127 vss xckg_x 9.571e-15
Cq128 vss xref_na 4.437e-15
Cq129 vss xref_ng 8.852e-14
Cq130 vss xref_ntl 3.71e-15
Cq131 xckg_d0 xckg_d1 8.434e-15
Cq132 xckg_d0 xckg_d2 2.37e-16
Cq133 xckg_d0 xckg_d3 1.818e-16
Cq134 xckg_d0 xckg_nn 2.011e-17
Cq135 xckg_d0 xckg_x 6.919e-16
Cq136 xckg_d1 xckg_d2 2.001e-15
Cq137 xckg_d1 xckg_d3 1.378e-16
Cq138 xckg_d1 xckg_nn 5.907e-16
Cq139 xckg_d1 xckg_x 4.219e-16
Cq140 xckg_d2 xckg_d3 8.547e-15
Cq141 xckg_d2 xckg_nn 5.574e-16
Cq142 xckg_d2 xckg_x 4.153e-16
Cq143 xckg_d3 xckg_nn 3.667e-17
Cq144 xckg_d3 xckg_x 5.111e-15
Cq145 xckg_nn xckg_x 1.118e-16
Cq146 xref_na xref_ng 2.554e-15
Cq147 xref_na xref_ntl 2.584e-16
Cq148 xref_ng xref_ntl 2.12e-15
.ends
.subckt r1_adc_lay_pr adc_hold is_smp clk adc_start adc_sel adc_valid_a adc_raw_a_0 adc_raw_a_1 adc_raw_a_2 adc_raw_a_3 adc_raw_a_4 adc_raw_a_5 adc_raw_a_6 adc_raw_a_7 adc_raw_a_8 adc_raw_a_9 adc_raw_a_10 adc_raw_a_11 adc_raw_a_12 adc_raw_a_13 adc_valid_b adc_raw_b_0 adc_raw_b_1 adc_raw_b_2 adc_raw_b_3 adc_raw_b_4 adc_raw_b_5 adc_raw_b_6 adc_raw_b_7 adc_raw_b_8 adc_raw_b_9 adc_raw_b_10 adc_raw_b_11 adc_raw_b_12 adc_raw_b_13 por_n ain_sin_p ain_sin_n ain_cos_p ain_cos_n vcm2 ibias ain_isa_p ain_isa_n ain_isb_p ain_isb_n vcm vdda vdd vss vref_in topap topan topbp topbn sar_clka sar_clkab sar_clkb sar_clkbb sar_clkna sar_clknab sar_clknb sar_clknbb sar_cna0 sar_cna1 sar_cna10 sar_cna11 sar_cna12 sar_cna2 sar_cna3 sar_cna4 sar_cna5 sar_cna6 sar_cna7 sar_cna8 sar_cna9 sar_cnb0 sar_cnb1 sar_cnb10 sar_cnb11 sar_cnb12 sar_cnb2 sar_cnb3 sar_cnb4 sar_cnb5 sar_cnb6 sar_cnb7 sar_cnb8 sar_cnb9 sar_cpa0 sar_cpa1 sar_cpa10 sar_cpa11 sar_cpa12 sar_cpa2 sar_cpa3 sar_cpa4 sar_cpa5 sar_cpa6 sar_cpa7 sar_cpa8 sar_cpa9 sar_cpb0 sar_cpb1 sar_cpb10 sar_cpb11 sar_cpb12 sar_cpb2 sar_cpb3 sar_cpb4 sar_cpb5 sar_cpb6 sar_cpb7 sar_cpb8 sar_cpb9 sar_oan sar_oann sar_oanp sar_oap sar_obn sar_obnn sar_obnp sar_obp sar_trka0 sar_trka1 sar_trkb0 sar_trkb1 sar_mclk vref vrefl
Xxckg_xpd0 xckg_d0__p1 clk vdd__p2 vdd sg13_lv_pmos w=1u l=0.5u ng=1 m=1
Xxckg_xnd0 xckg_d0 clk vss__p9 vss sg13_lv_nmos w=0.5u l=0.5u ng=1 m=1
Xxckg_cd0 xckg_d0__p2 vss__p16 cap_cmim w=2.53u l=2.53u m=1
Xxckg_xpd1 xckg_d1__p1 xckg_d0 vdd__p3 vdd sg13_lv_pmos w=1u l=0.5u ng=1 m=1
Xxckg_xnd1 xckg_d1 xckg_d0 vss__p10 vss sg13_lv_nmos w=0.5u l=0.5u ng=1 m=1
Xxckg_cd1 xckg_d1__p2 vss__p17 cap_cmim w=2.53u l=2.53u m=1
Xxckg_xpd2 xckg_d2__p1 xckg_d1 vdd__p4 vdd sg13_lv_pmos w=1u l=0.5u ng=1 m=1
Xxckg_xnd2 xckg_d2 xckg_d1 vss__p11 vss sg13_lv_nmos w=0.5u l=0.5u ng=1 m=1
Xxckg_cd2 xckg_d2__p2 vss__p18 cap_cmim w=2.53u l=2.53u m=1
Xxckg_xpd3 xckg_d3__p1 xckg_d2 vdd__p5 vdd sg13_lv_pmos w=1u l=0.5u ng=1 m=1
Xxckg_xnd3 xckg_d3 xckg_d2 vss__p12 vss sg13_lv_nmos w=0.5u l=0.5u ng=1 m=1
Xxckg_cd3 xckg_d3__p2 vss__p19 cap_cmim w=2.53u l=2.53u m=1
Xxckg_xpd4 xckg_x__p2 xckg_d3 vdd__p6 vdd sg13_lv_pmos w=1u l=0.5u ng=1 m=1
Xxckg_xnd4 xckg_x xckg_d3 vss__p13 vss sg13_lv_nmos w=0.5u l=0.5u ng=1 m=1
Xxckg_cd4 xckg_x__p4 vss__p20 cap_cmim w=2.53u l=2.53u m=1
Xxckg_xpa sar_mclk__p2 clk__p1 vdd__p7 vdd sg13_lv_pmos w=2u l=0.13u ng=1 m=1
Xxckg_xpb sar_mclk__p3 xckg_x__p3 vdd__p8 vdd sg13_lv_pmos w=2u l=0.13u ng=1 m=1
Xxckg_xna sar_mclk clk__p0 xckg_nn vss sg13_lv_nmos w=2u l=0.13u ng=1 m=1
Xxckg_xnb xckg_nn__p1 xckg_x__p1 vss__p14 vss sg13_lv_nmos w=2u l=0.13u ng=1 m=1
Xxckg_xpi mclkb__p1 sar_mclk__p4 vdd__p9 vdd sg13_lv_pmos w=2u l=0.13u ng=1 m=1
Xxckg_xni mclkb sar_mclk__p1 vss__p15 vss sg13_lv_nmos w=1u l=0.13u ng=1 m=1
Xxcbias_xmbd vbp__p1 vbp vdd__p1 vdd sg13_lv_pmos w=0.8u l=0.5u ng=1 m=1
Xxcbias_xrb_g0 vbp xcbias_xrb_s1 vss rppd w=1u l=40u m=1 b=0
Xxcbias_xrb_g1 xcbias_xrb_s1 xcbias_xrb_s2 vss rppd w=1u l=40u m=1 b=0
Xxcbias_xrb_g2 xcbias_xrb_s2 xcbias_xrb_s3 vss rppd w=1u l=40u m=1 b=0
Xxcbias_xrb_g3 xcbias_xrb_s3 vss__p7 vss rppd w=1u l=40u m=1 b=0
Xxcbiasn_xmbd vbn__p1 vbn vss__p8 vss sg13_lv_nmos w=0.2u l=0.5u ng=1 m=1
Xxcbiasn_xrb_g0 vdd__p0 xcbiasn_xrb_s1 vss rppd w=1u l=40u m=1 b=0
Xxcbiasn_xrb_g1 xcbiasn_xrb_s1 xcbiasn_xrb_s2 vss rppd w=1u l=40u m=1 b=0
Xxcbiasn_xrb_g2 xcbiasn_xrb_s2 xcbiasn_xrb_s3 vss rppd w=1u l=40u m=1 b=0
Xxcbiasn_xrb_g3 xcbiasn_xrb_s3 vbn vss rppd w=1u l=40u m=1 b=0
Xxref_xmb0 ibias__p0 ibias vss__p5 vss sg13_hv_nmos w=2u l=1u ng=1 m=1
Xxref_xmt xref_ntl ibias vss__p6 vss sg13_hv_nmos w=2u l=8u ng=1 m=1
Xxref_xm1 xref_na vref_in xref_ntl__p1 vss sg13_hv_nmos w=10u l=1u ng=2 m=1
Xxref_xm2 xref_ng vref xref_ntl__p2 vss sg13_hv_nmos w=10u l=1u ng=2 m=1
Xxref_xm3 xref_na__p1 xref_na vdda__p5 vdda sg13_hv_pmos w=4u l=1u ng=1 m=1
Xxref_xm4 xref_ng__p1 xref_na vdda__p6 vdda sg13_hv_pmos w=4u l=1u ng=1 m=1
Xxref_xcg_u0 vss xref_ng__p2 cap_cmim w=26.32u l=95u m=1
Xxref_xmsf_s0 vdda__p1 xref_ng vref vss sg13_hv_nmos w=80u l=0.45u ng=32 m=1
Xxref_xmsf_s1 vdda__p2 xref_ng vref__p5 vss sg13_hv_nmos w=80u l=0.45u ng=32 m=1
Xxref_xmsf_s2 vdda__p3 xref_ng vref__p6 vss sg13_hv_nmos w=80u l=0.45u ng=32 m=1
Xxref_xmsf_s3 vdda__p4 xref_ng vref__p7 vss sg13_hv_nmos w=80u l=0.45u ng=32 m=1
Xxref_xmib_s0 vref__p0 ibias vss__p0 vss sg13_hv_nmos w=80u l=1u ng=40 m=1
Xxref_xmib_s1 vref__p1 ibias vss__p1 vss sg13_hv_nmos w=80u l=1u ng=40 m=1
Xxref_xmib_s2 vref__p2 ibias vss__p2 vss sg13_hv_nmos w=80u l=1u ng=40 m=1
Xxref_xmib_s3 vref__p3 ibias vss__p3 vss sg13_hv_nmos w=80u l=1u ng=40 m=1
Xxref_xcd_u0 vss vref__p8 cap_cmim w=51.58u l=95u m=1
Xxref_xcd_u1 vss vref__p9 cap_cmim w=51.58u l=95u m=1
Xxref_xcd_u2 vss vref__p10 cap_cmim w=51.58u l=95u m=1
Xxref_xcd_u3 vss vref__p11 cap_cmim w=51.58u l=95u m=1
Xxref_xmsfl_s0 vdda__p0 xref_ng vrefl vss sg13_hv_nmos w=80u l=0.45u ng=32 m=1
Xxref_xmibl_s0 vrefl__p0 ibias vss__p4 vss sg13_hv_nmos w=80u l=1u ng=40 m=1
Xxref_xcdl_u0 vss vrefl__p2 cap_cmim w=51.58u l=95u m=1
Xxref_xcdl_u1 vss vrefl__p3 cap_cmim w=51.58u l=95u m=1
Xxfilt_xcf_u0 vss vref_in__p1 cap_cmim w=37.36u l=90u m=1
Xxfilt_xcf_u1 vss vref_in__p2 cap_cmim w=37.36u l=90u m=1
Xslice_a ain_sin_p__p1 ain_sin_n__p1 ain_isa_p__p1 ain_isa_n__p1 sar_trka0 sar_trka1 sar_cpa0 sar_cpa1 sar_cpa2 sar_cpa3 sar_cpa4 sar_cpa5 sar_cpa6 sar_cpa7 sar_cpa8 sar_cpa9 sar_cpa10 sar_cpa11 sar_cpa12 sar_cna0 sar_cna1 sar_cna2 sar_cna3 sar_cna4 sar_cna5 sar_cna6 sar_cna7 sar_cna8 sar_cna9 sar_cna10 sar_cna11 sar_cna12 sar_clka sar_clkab sar_clkna sar_clknab sar_oap sar_oan sar_oanp sar_oann vbp__p2 vbn__p2 sp_vref__p12_a sp_vref__p13_a sp_vref__p14_a sp_vrefl__p4_a sp_vrefl__p5_a topap topan vdd__p11 vdd__p12 vdd__p13 vdd__p14 xslice_a_gnd_nc0 vss__p22 xslice_a_gnd_nc2 vss__p23 xslice_a_gnd_nc4 vss__p24 xslice_a_gnd_nc6 vss__p25 r1_adc_slice_post
Vsp_vref__p12_a sp_vref__p12_a 0 DC 1.050007
Vsp_vref__p13_a sp_vref__p13_a 0 DC 1.050007
Vsp_vref__p14_a sp_vref__p14_a 0 DC 1.050007
Vsp_vrefl__p4_a sp_vrefl__p4_a 0 DC 1.058992
Vsp_vrefl__p5_a sp_vrefl__p5_a 0 DC 1.059011
Xslice_b ain_cos_p__p1 ain_cos_n__p1 ain_isb_p__p1 ain_isb_n__p1 sar_trkb0 sar_trkb1 sar_cpb0 sar_cpb1 sar_cpb2 sar_cpb3 sar_cpb4 sar_cpb5 sar_cpb6 sar_cpb7 sar_cpb8 sar_cpb9 sar_cpb10 sar_cpb11 sar_cpb12 sar_cnb0 sar_cnb1 sar_cnb2 sar_cnb3 sar_cnb4 sar_cnb5 sar_cnb6 sar_cnb7 sar_cnb8 sar_cnb9 sar_cnb10 sar_cnb11 sar_cnb12 sar_clkb sar_clkbb sar_clknb sar_clknbb sar_obp sar_obn sar_obnp sar_obnn vbp__p3 vbn__p3 sp_vref__p15_b sp_vref__p16_b sp_vref__p17_b sp_vrefl__p6_b sp_vrefl__p7_b topbp topbn vdd__p15 vdd__p16 vdd__p17 vdd__p18 vss__p26 xslice_b_gnd_nc1 vss__p27 xslice_b_gnd_nc3 vss__p28 xslice_b_gnd_nc5 vss__p29 xslice_b_gnd_nc7 r1_adc_slice_post
Vsp_vref__p15_b sp_vref__p15_b 0 DC 1.049984
Vsp_vref__p16_b sp_vref__p16_b 0 DC 1.049984
Vsp_vref__p17_b sp_vref__p17_b 0 DC 1.049984
Vsp_vrefl__p6_b sp_vrefl__p6_b 0 DC 1.059173
Vsp_vrefl__p7_b sp_vrefl__p7_b 0 DC 1.059173
Rt0 ain_cos_n ain_cos_n__p1 126.828
Rt1 ain_cos_p ain_cos_p__p1 128.647
Rt2 ain_isa_n ain_isa_n__p1 127.972
Rt3 ain_isa_p ain_isa_p__p1 129.791
Rt4 ain_isb_n ain_isb_n__p1 0.198
Rt5 ain_isb_p ain_isb_p__p1 0.198
Rt6 ain_sin_n ain_sin_n__p1 0.308
Rt7 ain_sin_p ain_sin_p__p1 0.308
Rt8 clk clk__p0 45.3911
Rt9 clk clk__p1 62.5679
Rt10 clk__p0 clk__p1 72.0627
Rt11 ibias ibias__p0 200.561
Rt12 mclkb mclkb__p1 43.3194
Rt13 sar_mclk sar_mclk__p1 56.5336
Rt14 sar_mclk sar_mclk__p3 125.793
Rt15 sar_mclk sar_mclk__p4 124.991
Rt16 sar_mclk__p1 sar_mclk__p3 116.67
Rt17 sar_mclk__p1 sar_mclk__p4 115.926
Rt18 sar_mclk__p2 sar_mclk__p3 0.6204
Rt19 sar_mclk__p3 sar_mclk__p4 23.2017
Rt20 vbn vbn__p1 68.8436
Rt21 vbn vbn__p2 240.016
Rt22 vbn vbn__p3 784.574
Rt23 vbn__p1 vbn__p2 217.489
Rt24 vbn__p1 vbn__p3 710.938
Rt25 vbn__p2 vbn__p3 168.032
Rt26 vbp vbp__p1 73.6975
Rt27 vbp vbp__p2 245.763
Rt28 vbp vbp__p3 1260.46
Rt29 vbp__p1 vbp__p2 195.517
Rt30 vbp__p1 vbp__p3 1002.76
Rt31 vbp__p2 vbp__p3 154.24
Rt32 vdd vdd__p0 34389.1
Rt33 vdd vdd__p1 40943
Rt34 vdd vdd__p11 82.2115
Rt35 vdd vdd__p12 11.0679
Rt36 vdd vdd__p13 29.2467
Rt37 vdd vdd__p14 436.353
Rt38 vdd vdd__p15 3346.14
Rt39 vdd vdd__p16 41638.1
Rt40 vdd vdd__p17 762947
Rt41 vdd__p0 vdd__p1 119.607
Rt42 vdd__p0 vdd__p11 99.6158
Rt43 vdd__p0 vdd__p12 288.609
Rt44 vdd__p0 vdd__p13 7715.85
Rt45 vdd__p0 vdd__p14 115118
Rt46 vdd__p0 vdd__p15 882776
Rt47 vdd__p1 vdd__p11 118.601
Rt48 vdd__p1 vdd__p12 343.612
Rt49 vdd__p1 vdd__p13 9186.33
Rt50 vdd__p1 vdd__p14 137057
Rt51 vdd__p11 vdd__p12 0.697261
Rt52 vdd__p11 vdd__p13 18.4457
Rt53 vdd__p11 vdd__p14 275.205
Rt54 vdd__p11 vdd__p15 2110.39
Rt55 vdd__p11 vdd__p16 26260.8
Rt56 vdd__p11 vdd__p17 481185
Rt57 vdd__p12 vdd__p13 2.4833
Rt58 vdd__p12 vdd__p14 37.0501
Rt59 vdd__p12 vdd__p15 284.116
Rt60 vdd__p12 vdd__p16 3535.43
Rt61 vdd__p12 vdd__p17 64780.7
Rt62 vdd__p12 vdd__p18 894412
Rt63 vdd__p13 vdd__p14 0.52562
Rt64 vdd__p13 vdd__p15 4.4303
Rt65 vdd__p13 vdd__p16 55.1288
Rt66 vdd__p13 vdd__p17 1010.14
Rt67 vdd__p13 vdd__p18 13946.8
Rt68 vdd__p14 vdd__p15 0.367865
Rt69 vdd__p14 vdd__p16 6.97049
Rt70 vdd__p14 vdd__p17 127.722
Rt71 vdd__p14 vdd__p18 1763.43
Rt72 vdd__p15 vdd__p16 0.802998
Rt73 vdd__p15 vdd__p17 14.9189
Rt74 vdd__p15 vdd__p18 205.982
Rt75 vdd__p16 vdd__p17 2.61773
Rt76 vdd__p16 vdd__p18 36.1423
Rt77 vdd__p16 vdd__p2 818965
Rt78 vdd__p16 vdd__p3 750476
Rt79 vdd__p16 vdd__p4 638837
Rt80 vdd__p16 vdd__p5 515222
Rt81 vdd__p16 vdd__p6 401045
Rt82 vdd__p16 vdd__p7 738625
Rt83 vdd__p16 vdd__p8 519274
Rt84 vdd__p16 vdd__p9 430036
Rt85 vdd__p17 vdd__p18 0.487483
Rt86 vdd__p17 vdd__p2 12054.5
Rt87 vdd__p17 vdd__p3 11046.4
Rt88 vdd__p17 vdd__p4 9403.17
Rt89 vdd__p17 vdd__p5 7583.66
Rt90 vdd__p17 vdd__p6 5903.07
Rt91 vdd__p17 vdd__p7 10872
Rt92 vdd__p17 vdd__p8 7643.31
Rt93 vdd__p17 vdd__p9 6329.78
Rt94 vdd__p18 vdd__p2 3600.08
Rt95 vdd__p18 vdd__p3 3299.01
Rt96 vdd__p18 vdd__p4 2808.25
Rt97 vdd__p18 vdd__p5 2264.86
Rt98 vdd__p18 vdd__p6 1762.95
Rt99 vdd__p18 vdd__p7 3246.91
Rt100 vdd__p18 vdd__p8 2282.67
Rt101 vdd__p18 vdd__p9 1890.39
Rt102 vdd__p2 vdd__p3 88.7111
Rt103 vdd__p2 vdd__p4 115.499
Rt104 vdd__p2 vdd__p5 146.381
Rt105 vdd__p2 vdd__p6 177.721
Rt106 vdd__p2 vdd__p7 385.4
Rt107 vdd__p2 vdd__p8 419.34
Rt108 vdd__p2 vdd__p9 441.535
Rt109 vdd__p3 vdd__p4 105.84
Rt110 vdd__p3 vdd__p5 134.139
Rt111 vdd__p3 vdd__p6 162.858
Rt112 vdd__p3 vdd__p7 353.17
Rt113 vdd__p3 vdd__p8 384.272
Rt114 vdd__p3 vdd__p9 404.61
Rt115 vdd__p4 vdd__p5 114.185
Rt116 vdd__p4 vdd__p6 138.632
Rt117 vdd__p4 vdd__p7 300.633
Rt118 vdd__p4 vdd__p8 327.108
Rt119 vdd__p4 vdd__p9 344.421
Rt120 vdd__p5 vdd__p6 111.806
Rt121 vdd__p5 vdd__p7 242.461
Rt122 vdd__p5 vdd__p8 263.813
Rt123 vdd__p5 vdd__p9 277.776
Rt124 vdd__p6 vdd__p7 188.73
Rt125 vdd__p6 vdd__p8 205.35
Rt126 vdd__p6 vdd__p9 216.219
Rt127 vdd__p7 vdd__p8 378.203
Rt128 vdd__p7 vdd__p9 398.221
Rt129 vdd__p8 vdd__p9 279.961
Rt130 vdda vdda__p1 41.3489
Rt131 vdda vdda__p2 278.578
Rt132 vdda vdda__p3 56.012
Rt133 vdda vdda__p5 261.48
Rt134 vdda vdda__p6 203.591
Rt135 vdda__p0 vdda__p3 62.8025
Rt136 vdda__p0 vdda__p4 67.5999
Rt137 vdda__p1 vdda__p2 1202.37
Rt138 vdda__p1 vdda__p3 241.754
Rt139 vdda__p1 vdda__p5 1128.58
Rt140 vdda__p1 vdda__p6 878.722
Rt141 vdda__p2 vdda__p3 256.165
Rt142 vdda__p2 vdda__p5 63.6193
Rt143 vdda__p2 vdda__p6 79.0683
Rt144 vdda__p3 vdda__p4 23.0314
Rt145 vdda__p3 vdda__p5 240.442
Rt146 vdda__p3 vdda__p6 187.211
Rt147 vdda__p5 vdda__p6 74.2153
Rt148 vref vref__p0 114.65
Rt149 vref vref__p1 6.10169
Rt150 vref vref__p10 186.142
Rt151 vref vref__p11 8271.36
Rt152 vref vref__p12 1487.93
Rt153 vref vref__p13 808.459
Rt154 vref vref__p14 372.871
Rt155 vref vref__p15 1459.54
Rt156 vref vref__p16 3157.02
Rt157 vref vref__p17 5801
Rt158 vref vref__p2 370.329
Rt159 vref vref__p3 10248.9
Rt160 vref vref__p5 428.96
Rt161 vref vref__p6 1135.72
Rt162 vref vref__p7 3138.93
Rt163 vref vref__p8 2223.31
Rt164 vref vref__p9 50.9452
Rt165 vref__p0 vref__p1 5.08178
Rt166 vref__p0 vref__p10 1372.92
Rt167 vref__p0 vref__p11 61005.8
Rt168 vref__p0 vref__p12 11330.2
Rt169 vref__p0 vref__p13 6156.32
Rt170 vref__p0 vref__p14 2839.43
Rt171 vref__p0 vref__p15 10764.9
Rt172 vref__p0 vref__p16 23284.7
Rt173 vref__p0 vref__p17 42785.5
Rt174 vref__p0 vref__p2 2151.06
Rt175 vref__p0 vref__p3 74645.3
Rt176 vref__p0 vref__p5 1782.68
Rt177 vref__p0 vref__p6 6979.82
Rt178 vref__p0 vref__p7 23027.9
Rt179 vref__p0 vref__p8 16928.7
Rt180 vref__p0 vref__p9 387.793
Rt181 vref__p1 vref__p10 27.2286
Rt182 vref__p1 vref__p11 1209.68
Rt183 vref__p1 vref__p12 366.189
Rt184 vref__p1 vref__p13 199.066
Rt185 vref__p1 vref__p14 91.8501
Rt186 vref__p1 vref__p15 213.441
Rt187 vref__p1 vref__p16 461.684
Rt188 vref__p1 vref__p17 848.354
Rt189 vref__p1 vref__p2 8.38761
Rt190 vref__p1 vref__p3 1193.26
Rt191 vref__p1 vref__p5 6.38445
Rt192 vref__p1 vref__p6 32.923
Rt193 vref__p1 vref__p7 414.228
Rt194 vref__p1 vref__p8 546.455
Rt195 vref__p1 vref__p9 12.4499
Rt196 vref__p10 vref__p11 1.96723
Rt197 vref__p10 vref__p12 390.352
Rt198 vref__p10 vref__p13 212.377
Rt199 vref__p10 vref__p14 98.0606
Rt200 vref__p10 vref__p15 1.88326
Rt201 vref__p10 vref__p16 2.58285
Rt202 vref__p10 vref__p17 2.96452
Rt203 vref__p10 vref__p2 13.5031
Rt204 vref__p10 vref__p3 151.839
Rt205 vref__p10 vref__p5 105.826
Rt206 vref__p10 vref__p6 71.6163
Rt207 vref__p10 vref__p7 45.7002
Rt208 vref__p10 vref__p8 581.257
Rt209 vref__p10 vref__p9 13.1189
Rt210 vref__p11 vref__p12 17345.9
Rt211 vref__p11 vref__p13 9437.27
Rt212 vref__p11 vref__p14 4357.47
Rt213 vref__p11 vref__p15 11.7242
Rt214 vref__p11 vref__p16 6.70636
Rt215 vref__p11 vref__p17 3.30899
Rt216 vref__p11 vref__p2 588.996
Rt217 vref__p11 vref__p3 6559.22
Rt218 vref__p11 vref__p5 4701.78
Rt219 vref__p11 vref__p6 3179.28
Rt220 vref__p11 vref__p7 1973.95
Rt221 vref__p11 vref__p8 25829
Rt222 vref__p11 vref__p9 582.958
Rt223 vref__p12 vref__p13 2.76051
Rt224 vref__p12 vref__p14 5.69068
Rt225 vref__p12 vref__p15 3060.82
Rt226 vref__p12 vref__p16 6620.62
Rt227 vref__p12 vref__p17 12165.3
Rt228 vref__p12 vref__p2 961.871
Rt229 vref__p12 vref__p3 21690.6
Rt230 vref__p12 vref__p5 2025.57
Rt231 vref__p12 vref__p6 2781.47
Rt232 vref__p12 vref__p7 6608.37
Rt233 vref__p12 vref__p8 3.41549
Rt234 vref__p12 vref__p9 2.8795
Rt235 vref__p13 vref__p14 2.76481
Rt236 vref__p13 vref__p15 1665.29
Rt237 vref__p13 vref__p16 3602.05
Rt238 vref__p13 vref__p17 6618.72
Rt239 vref__p13 vref__p2 523.306
Rt240 vref__p13 vref__p3 11801.1
Rt241 vref__p13 vref__p5 1101.86
Rt242 vref__p13 vref__p6 1513.26
Rt243 vref__p13 vref__p7 3595.37
Rt244 vref__p13 vref__p8 6.9687
Rt245 vref__p13 vref__p9 2.56608
Rt246 vref__p14 vref__p15 768.912
Rt247 vref__p14 vref__p16 1663.17
Rt248 vref__p14 vref__p17 3056.06
Rt249 vref__p14 vref__p2 241.621
Rt250 vref__p14 vref__p3 5448.89
Rt251 vref__p14 vref__p5 508.693
Rt252 vref__p14 vref__p6 698.702
Rt253 vref__p14 vref__p7 1660.09
Rt254 vref__p14 vref__p8 12.1708
Rt255 vref__p14 vref__p9 1.86726
Rt256 vref__p15 vref__p16 2.76621
Rt257 vref__p15 vref__p17 5.68373
Rt258 vref__p15 vref__p2 103.213
Rt259 vref__p15 vref__p3 1145.31
Rt260 vref__p15 vref__p5 829.619
Rt261 vref__p15 vref__p6 560.804
Rt262 vref__p15 vref__p7 344.658
Rt263 vref__p15 vref__p8 4557.75
Rt264 vref__p15 vref__p9 102.868
Rt265 vref__p16 vref__p17 2.75986
Rt266 vref__p16 vref__p2 223.556
Rt267 vref__p16 vref__p3 2482.45
Rt268 vref__p16 vref__p5 1794.5
Rt269 vref__p16 vref__p6 1213.12
Rt270 vref__p16 vref__p7 747.047
Rt271 vref__p16 vref__p8 9858.5
Rt272 vref__p16 vref__p9 222.505
Rt273 vref__p17 vref__p2 411.407
Rt274 vref__p17 vref__p3 4571.97
Rt275 vref__p17 vref__p5 3297.42
Rt276 vref__p17 vref__p6 2229.27
Rt277 vref__p17 vref__p7 1375.86
Rt278 vref__p17 vref__p8 18114.9
Rt279 vref__p17 vref__p9 408.851
Rt280 vref__p2 vref__p3 5.49374
Rt281 vref__p2 vref__p5 65.7993
Rt282 vref__p2 vref__p6 7.45703
Rt283 vref__p2 vref__p7 6.5906
Rt284 vref__p2 vref__p8 1432.38
Rt285 vref__p2 vref__p9 32.3382
Rt286 vref__p3 vref__p5 5279.01
Rt287 vref__p3 vref__p6 2064.28
Rt288 vref__p3 vref__p7 48.2546
Rt289 vref__p3 vref__p8 32298.7
Rt290 vref__p3 vref__p9 728.99
Rt291 vref__p5 vref__p6 244.984
Rt292 vref__p5 vref__p7 1709.1
Rt293 vref__p5 vref__p8 3017.46
Rt294 vref__p5 vref__p9 68.2281
Rt295 vref__p6 vref__p7 871.249
Rt296 vref__p6 vref__p8 4142.06
Rt297 vref__p6 vref__p9 93.5132
Rt298 vref__p7 vref__p8 9840.28
Rt299 vref__p7 vref__p9 222.096
Rt300 vref__p8 vref__p9 1.94076
Rt301 vref_in vref_in__p1 0.001
Rt302 vref_in vref_in__p2 0.001
Rt303 vrefl vrefl__p0 31.2586
Rt304 vrefl vrefl__p2 93.437
Rt305 vrefl vrefl__p3 7.18444
Rt306 vrefl vrefl__p4 7325.4
Rt307 vrefl vrefl__p5 4916.21
Rt308 vrefl vrefl__p6 359.98
Rt309 vrefl vrefl__p7 574.557
Rt310 vrefl__p0 vrefl__p2 18.0283
Rt311 vrefl__p0 vrefl__p3 12.5916
Rt312 vrefl__p0 vrefl__p4 63.5642
Rt313 vrefl__p0 vrefl__p5 72.9525
Rt314 vrefl__p0 vrefl__p6 631.93
Rt315 vrefl__p0 vrefl__p7 1009.16
Rt316 vrefl__p2 vrefl__p3 2.16812
Rt317 vrefl__p2 vrefl__p4 8.30061
Rt318 vrefl__p2 vrefl__p5 5.37046
Rt319 vrefl__p2 vrefl__p6 117.734
Rt320 vrefl__p2 vrefl__p7 192.433
Rt321 vrefl__p3 vrefl__p4 211.164
Rt322 vrefl__p3 vrefl__p5 128.531
Rt323 vrefl__p3 vrefl__p6 5.07096
Rt324 vrefl__p3 vrefl__p7 7.53987
Rt325 vrefl__p4 vrefl__p5 31.8717
Rt326 vrefl__p4 vrefl__p6 11315.9
Rt327 vrefl__p4 vrefl__p7 18493.5
Rt328 vrefl__p5 vrefl__p6 6889.67
Rt329 vrefl__p5 vrefl__p7 11261.9
Rt330 vrefl__p6 vrefl__p7 32.2289
Rt331 vss vss__p0 34.945
Rt332 vss vss__p1 372.7
Rt333 vss vss__p10 3790.86
Rt334 vss vss__p11 4337.67
Rt335 vss vss__p12 4581.33
Rt336 vss vss__p13 4426.67
Rt337 vss vss__p14 1679.54
Rt338 vss vss__p15 3863.88
Rt339 vss vss__p16 2714.4
Rt340 vss vss__p17 3470.72
Rt341 vss vss__p18 3221.91
Rt342 vss vss__p19 69396.7
Rt343 vss vss__p2 151.948
Rt344 vss vss__p20 339726
Rt345 vss vss__p22 2
Rt346 vss vss__p23 2
Rt347 vss vss__p24 2
Rt348 vss vss__p25 2
Rt349 vss vss__p26 2
Rt350 vss vss__p27 2
Rt351 vss vss__p28 2
Rt352 vss vss__p29 2
Rt353 vss vss__p3 88.9409
Rt354 vss vss__p4 1075.9
Rt355 vss vss__p5 1332.64
Rt356 vss vss__p6 1752.43
Rt357 vss vss__p7 37.7287
Rt358 vss vss__p8 41.2352
Rt359 vss vss__p9 3117.63
Rt360 vss__p0 vss__p1 169.257
Rt361 vss__p0 vss__p10 162600
Rt362 vss__p0 vss__p11 186054
Rt363 vss__p0 vss__p12 196505
Rt364 vss__p0 vss__p13 189872
Rt365 vss__p0 vss__p14 72040
Rt366 vss__p0 vss__p15 165732
Rt367 vss__p0 vss__p16 116428
Rt368 vss__p0 vss__p17 148868
Rt369 vss__p0 vss__p18 138196
Rt370 vss__p0 vss__p2 6646.98
Rt371 vss__p0 vss__p3 3890.73
Rt372 vss__p0 vss__p4 488.606
Rt373 vss__p0 vss__p5 605.202
Rt374 vss__p0 vss__p6 795.844
Rt375 vss__p0 vss__p7 445.234
Rt376 vss__p0 vss__p8 490.023
Rt377 vss__p0 vss__p9 133723
Rt378 vss__p1 vss__p14 768330
Rt379 vss__p1 vss__p2 70892.2
Rt380 vss__p1 vss__p3 41495.9
Rt381 vss__p1 vss__p4 340.811
Rt382 vss__p1 vss__p5 422.139
Rt383 vss__p1 vss__p6 555.115
Rt384 vss__p1 vss__p7 4748.57
Rt385 vss__p1 vss__p8 5226.25
Rt386 vss__p10 vss__p11 112.446
Rt387 vss__p10 vss__p12 142.098
Rt388 vss__p10 vss__p13 171.756
Rt389 vss__p10 vss__p14 353.419
Rt390 vss__p10 vss__p15 241.972
Rt391 vss__p10 vss__p16 658.005
Rt392 vss__p10 vss__p17 841.347
Rt393 vss__p10 vss__p18 781.032
Rt394 vss__p10 vss__p19 16822.6
Rt395 vss__p10 vss__p2 73319.5
Rt396 vss__p10 vss__p20 82353.9
Rt397 vss__p10 vss__p3 42916.7
Rt398 vss__p10 vss__p7 151636
Rt399 vss__p10 vss__p8 182397
Rt400 vss__p10 vss__p9 97.4244
Rt401 vss__p11 vss__p12 118.915
Rt402 vss__p11 vss__p13 144.572
Rt403 vss__p11 vss__p14 341.382
Rt404 vss__p11 vss__p15 207.376
Rt405 vss__p11 vss__p16 653.57
Rt406 vss__p11 vss__p17 835.677
Rt407 vss__p11 vss__p18 775.768
Rt408 vss__p11 vss__p19 16709.3
Rt409 vss__p11 vss__p2 83895.4
Rt410 vss__p11 vss__p20 81798.9
Rt411 vss__p11 vss__p3 49107.2
Rt412 vss__p11 vss__p7 173509
Rt413 vss__p11 vss__p8 208707
Rt414 vss__p11 vss__p9 126.229
Rt415 vss__p12 vss__p13 115.709
Rt416 vss__p12 vss__p14 303.402
Rt417 vss__p12 vss__p15 168.034
Rt418 vss__p12 vss__p16 595.316
Rt419 vss__p12 vss__p17 761.191
Rt420 vss__p12 vss__p18 706.622
Rt421 vss__p12 vss__p19 15219.9
Rt422 vss__p12 vss__p2 88608
Rt423 vss__p12 vss__p20 74507.9
Rt424 vss__p12 vss__p3 51865.6
Rt425 vss__p12 vss__p7 183255
Rt426 vss__p12 vss__p8 220430
Rt427 vss__p12 vss__p9 158.709
Rt428 vss__p13 vss__p14 252.325
Rt429 vss__p13 vss__p15 131.183
Rt430 vss__p13 vss__p16 504.38
Rt431 vss__p13 vss__p17 644.916
Rt432 vss__p13 vss__p18 598.683
Rt433 vss__p13 vss__p19 12895
Rt434 vss__p13 vss__p2 85616.8
Rt435 vss__p13 vss__p20 63126.6
Rt436 vss__p13 vss__p3 50114.8
Rt437 vss__p13 vss__p7 177069
Rt438 vss__p13 vss__p8 212989
Rt439 vss__p13 vss__p9 190.362
Rt440 vss__p14 vss__p15 195.469
Rt441 vss__p14 vss__p16 229.165
Rt442 vss__p14 vss__p17 293.018
Rt443 vss__p14 vss__p18 272.012
Rt444 vss__p14 vss__p19 5858.86
Rt445 vss__p14 vss__p2 32484.2
Rt446 vss__p14 vss__p20 28681.6
Rt447 vss__p14 vss__p3 19014.3
Rt448 vss__p14 vss__p7 67182.5
Rt449 vss__p14 vss__p8 80811
Rt450 vss__p14 vss__p9 335.047
Rt451 vss__p15 vss__p16 344.291
Rt452 vss__p15 vss__p17 440.222
Rt453 vss__p15 vss__p18 408.663
Rt454 vss__p15 vss__p19 8802.2
Rt455 vss__p15 vss__p2 74731.7
Rt456 vss__p15 vss__p20 43090.5
Rt457 vss__p15 vss__p3 43743.3
Rt458 vss__p15 vss__p7 154557
Rt459 vss__p15 vss__p8 185910
Rt460 vss__p15 vss__p9 262.034
Rt461 vss__p16 vss__p17 51.3118
Rt462 vss__p16 vss__p18 47.6333
Rt463 vss__p16 vss__p19 1025.97
Rt464 vss__p16 vss__p2 52499.6
Rt465 vss__p16 vss__p20 5022.57
Rt466 vss__p16 vss__p3 30730
Rt467 vss__p16 vss__p7 108577
Rt468 vss__p16 vss__p8 130603
Rt469 vss__p16 vss__p9 607.426
Rt470 vss__p17 vss__p18 39.2224
Rt471 vss__p17 vss__p19 844.81
Rt472 vss__p17 vss__p2 67127.7
Rt473 vss__p17 vss__p20 4135.7
Rt474 vss__p17 vss__p3 39292.4
Rt475 vss__p17 vss__p7 138831
Rt476 vss__p17 vss__p8 166994
Rt477 vss__p17 vss__p9 776.674
Rt478 vss__p18 vss__p19 0.666138
Rt479 vss__p18 vss__p2 62315.4
Rt480 vss__p18 vss__p20 3.26102
Rt481 vss__p18 vss__p3 36475.6
Rt482 vss__p18 vss__p7 128878
Rt483 vss__p18 vss__p8 155022
Rt484 vss__p18 vss__p9 720.996
Rt485 vss__p19 vss__p20 0.970954
Rt486 vss__p19 vss__p3 785647
Rt487 vss__p19 vss__p9 15529.5
Rt488 vss__p2 vss__p3 63.5752
Rt489 vss__p2 vss__p4 204650
Rt490 vss__p2 vss__p5 253485
Rt491 vss__p2 vss__p6 333334
Rt492 vss__p2 vss__p7 6625.71
Rt493 vss__p2 vss__p8 7693.25
Rt494 vss__p2 vss__p9 60298.5
Rt495 vss__p20 vss__p9 76023.5
Rt496 vss__p3 vss__p4 119789
Rt497 vss__p3 vss__p5 148375
Rt498 vss__p3 vss__p6 195113
Rt499 vss__p3 vss__p7 3878.28
Rt500 vss__p3 vss__p8 4503.15
Rt501 vss__p3 vss__p9 35295
Rt502 vss__p4 vss__p5 99.6258
Rt503 vss__p4 vss__p6 131.008
Rt504 vss__p4 vss__p7 13708
Rt505 vss__p4 vss__p8 15087
Rt506 vss__p5 vss__p6 57.9371
Rt507 vss__p5 vss__p7 16979.2
Rt508 vss__p5 vss__p8 18687.2
Rt509 vss__p6 vss__p7 22327.7
Rt510 vss__p6 vss__p8 24573.8
Rt511 vss__p7 vss__p8 217.108
Rt512 vss__p7 vss__p9 124707
Rt513 vss__p8 vss__p9 150005
Rt514 xckg_d0 xckg_d0__p1 206.411
Rt515 xckg_d0 xckg_d0__p2 50.6383
Rt516 xckg_d0__p1 xckg_d0__p2 40.5376
Rt517 xckg_d1 xckg_d1__p1 176.827
Rt518 xckg_d1 xckg_d1__p2 53.6164
Rt519 xckg_d1__p1 xckg_d1__p2 42.2433
Rt520 xckg_d2 xckg_d2__p1 98.5076
Rt521 xckg_d2 xckg_d2__p2 97.0379
Rt522 xckg_d2__p1 xckg_d2__p2 76.6587
Rt523 xckg_d3 xckg_d3__p1 99.3636
Rt524 xckg_d3 xckg_d3__p2 100.408
Rt525 xckg_d3__p1 xckg_d3__p2 78.0493
Rt526 xckg_nn xckg_nn__p1 46.1928
Rt527 xckg_x xckg_x__p1 68.4444
Rt528 xckg_x xckg_x__p2 147.088
Rt529 xckg_x xckg_x__p3 1240.78
Rt530 xckg_x xckg_x__p4 614.493
Rt531 xckg_x__p1 xckg_x__p2 97.458
Rt532 xckg_x__p1 xckg_x__p3 822.123
Rt533 xckg_x__p1 xckg_x__p4 407.153
Rt534 xckg_x__p2 xckg_x__p3 124.848
Rt535 xckg_x__p2 xckg_x__p4 61.8301
Rt536 xckg_x__p3 xckg_x__p4 33.2764
Rt537 xref_na xref_na__p1 77.984
Rt538 xref_ng xref_ng__p1 1225.95
Rt539 xref_ng xref_ng__p2 132.884
Rt540 xref_ng__p1 xref_ng__p2 31.5508
Rt541 xref_ntl xref_ntl__p1 60.2546
Rt542 xref_ntl__p1 xref_ntl__p2 19.318
Cq0 ain_cos_n ain_cos_p 2.707e-14
Cq1 ain_cos_n ain_isa_n 3.553e-17
Cq2 ain_cos_n ain_isa_p 4.484e-17
Cq3 ain_cos_n ibias 1.097e-16
Cq4 ain_cos_n vdd 1.545e-16
Cq5 ain_cos_n vss 3.47e-14
Cq6 ain_cos_n xckg_d0 9.755e-19
Cq7 ain_cos_n xckg_d1 9.755e-19
Cq8 ain_cos_n xckg_d2 9.755e-19
Cq9 ain_cos_n xckg_d3 1.006e-18
Cq10 ain_cos_n xckg_x 9.096e-19
Cq11 ain_cos_p ain_isa_n 3.556e-17
Cq12 ain_cos_p ain_isa_p 4.84e-17
Cq13 ain_cos_p ibias 2.317e-16
Cq14 ain_cos_p vdd 2.226e-17
Cq15 ain_cos_p vss 3.511e-14
Cq16 ain_isa_n ain_isa_p 2.783e-14
Cq17 ain_isa_n ain_isb_n 6.15e-17
Cq18 ain_isa_n ain_isb_p 6.417e-17
Cq19 ain_isa_n vdd 4.974e-16
Cq20 ain_isa_n vss 3.224e-14
Cq21 ain_isa_p ain_isb_n 7.645e-17
Cq22 ain_isa_p ain_isb_p 7.912e-17
Cq23 ain_isa_p vdd 1.655e-15
Cq24 ain_isa_p vss 3.144e-14
Cq25 ain_isb_n ain_isb_p 7.431e-17
Cq26 ain_isb_n vdd 1.258e-16
Cq27 ain_isb_n vss 8.117e-16
Cq28 ain_isb_p vdd 1.08e-16
Cq29 ain_isb_p vss 7.879e-16
Cq30 ain_sin_n ain_sin_p 8.625e-17
Cq31 ain_sin_n ibias 9.686e-17
Cq32 ain_sin_n vss 7.977e-16
Cq33 ain_sin_p ibias 9.686e-17
Cq34 ain_sin_p vss 7.924e-16
Cq35 clk mclkb 2.216e-18
Cq36 clk sar_mclk 1.431e-16
Cq37 clk vdd 4.256e-16
Cq38 clk vss 1.9e-14
Cq39 clk xckg_d0 2.205e-16
Cq40 clk xckg_d1 1.236e-16
Cq41 clk xckg_d2 1.227e-16
Cq42 clk xckg_d3 1.663e-16
Cq43 clk xckg_nn 2.534e-17
Cq44 clk xckg_x 1.452e-16
Cq45 ibias vbn 2.266e-15
Cq46 ibias vbp 6.102e-17
Cq47 ibias vdd 4.502e-15
Cq48 ibias vdda 2.216e-16
Cq49 ibias vref 4.11e-14
Cq50 ibias vref_in 9.847e-15
Cq51 ibias vrefl 1.687e-14
Cq52 ibias vss 1.681e-13
Cq53 ibias xref_ng 2.101e-15
Cq54 ibias xref_ntl 1.737e-16
Cq55 mclkb sar_mclk 2.613e-16
Cq56 mclkb vdd 3.868e-16
Cq57 mclkb vss 1.225e-15
Cq58 mclkb xckg_d0 5.591e-17
Cq59 mclkb xckg_d1 3.991e-15
Cq60 mclkb xckg_d2 3.955e-15
Cq61 mclkb xckg_d3 6.865e-17
Cq62 mclkb xckg_nn 1.864e-17
Cq63 mclkb xckg_x 9.569e-17
Cq64 sar_mclk vdd 1.618e-15
Cq65 sar_mclk vss 6.719e-15
Cq66 sar_mclk xckg_d0 4.707e-15
Cq67 sar_mclk xckg_d1 2.058e-16
Cq68 sar_mclk xckg_d2 7.519e-17
Cq69 sar_mclk xckg_d3 9.271e-17
Cq70 sar_mclk xckg_nn 4.141e-16
Cq71 sar_mclk xckg_x 1.044e-15
Cq72 vbn vbp 2.899e-14
Cq73 vbn vdd 2.028e-15
Cq74 vbn vdda 5.091e-17
Cq75 vbn vref 1.786e-14
Cq76 vbn vref_in 4.127e-15
Cq77 vbn vrefl 2.52e-14
Cq78 vbn vss 1.155e-14
Cq79 vbn xref_na 7.746e-19
Cq80 vbn xref_ng 1.886e-15
Cq81 vbp vdd 1.803e-15
Cq82 vbp vdda 8.761e-15
Cq83 vbp vref 1.878e-14
Cq84 vbp vref_in 4.205e-15
Cq85 vbp vrefl 1.08e-14
Cq86 vbp vss 1.857e-14
Cq87 vbp xref_na 9.789e-18
Cq88 vbp xref_ng 2.371e-15
Cq89 vdd vdda 5.954e-16
Cq90 vdd vref 1.718e-13
Cq91 vdd vref_in 4.225e-14
Cq92 vdd vrefl 5.877e-14
Cq93 vdd vss 1.539e-13
Cq94 vdd xckg_d0 5.77e-16
Cq95 vdd xckg_d1 4.281e-16
Cq96 vdd xckg_d2 3.088e-16
Cq97 vdd xckg_d3 4.114e-16
Cq98 vdd xckg_x 2.644e-15
Cq99 vdd xref_ng 1.363e-14
Cq100 vdda vref 4.398e-14
Cq101 vdda vref_in 3.223e-16
Cq102 vdda vrefl 2.519e-14
Cq103 vdda vss 3.507e-14
Cq104 vdda xref_na 1.249e-15
Cq105 vdda xref_ng 2.299e-14
Cq106 vdda xref_ntl 9.96e-18
Cq107 vref vref_in 4.541e-14
Cq108 vref vrefl 1.67e-13
Cq109 vref vss 3.743e-13
Cq110 vref xref_na 1.322e-16
Cq111 vref xref_ng 4.971e-14
Cq112 vref xref_ntl 1.685e-15
Cq113 vref_in vrefl 3.081e-14
Cq114 vref_in vss 9.166e-14
Cq115 vref_in xref_na 4.042e-16
Cq116 vref_in xref_ng 3.421e-15
Cq117 vref_in xref_ntl 1.606e-15
Cq118 vrefl vss 1.926e-13
Cq119 vrefl xref_na 1.039e-16
Cq120 vrefl xref_ng 3.178e-14
Cq121 vrefl xref_ntl 2.185e-15
Cq122 vss xckg_d0 4.927e-15
Cq123 vss xckg_d1 4.062e-15
Cq124 vss xckg_d2 4.793e-15
Cq125 vss xckg_d3 5.817e-15
Cq126 vss xckg_nn 1.117e-15
Cq127 vss xckg_x 9.571e-15
Cq128 vss xref_na 4.437e-15
Cq129 vss xref_ng 8.852e-14
Cq130 vss xref_ntl 3.71e-15
Cq131 xckg_d0 xckg_d1 8.434e-15
Cq132 xckg_d0 xckg_d2 2.37e-16
Cq133 xckg_d0 xckg_d3 1.818e-16
Cq134 xckg_d0 xckg_nn 2.011e-17
Cq135 xckg_d0 xckg_x 6.919e-16
Cq136 xckg_d1 xckg_d2 2.001e-15
Cq137 xckg_d1 xckg_d3 1.378e-16
Cq138 xckg_d1 xckg_nn 5.907e-16
Cq139 xckg_d1 xckg_x 4.219e-16
Cq140 xckg_d2 xckg_d3 8.547e-15
Cq141 xckg_d2 xckg_nn 5.574e-16
Cq142 xckg_d2 xckg_x 4.153e-16
Cq143 xckg_d3 xckg_nn 3.667e-17
Cq144 xckg_d3 xckg_x 5.111e-15
Cq145 xckg_nn xckg_x 1.118e-16
Cq146 xref_na xref_ng 2.554e-15
Cq147 xref_na xref_ntl 2.584e-16
Cq148 xref_ng xref_ntl 2.12e-15
.ends
