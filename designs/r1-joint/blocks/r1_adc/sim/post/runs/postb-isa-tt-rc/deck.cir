* tb_post_isa.cir: generated by sim/post/gen_post_decks.py from sim/r5/tb_adc5_isa.cir (include line -> NETLISTS substitution; core cell -> COREEXTRA CORECELL substitutions)
* tb_adc5_isa.cir -- R1 ADC revision 5 (T2 2026-10-21): D18 frame sequence with the input multiplexer, full core
* r1_adc5_core (complete bootstrapped switches on both inputs of each slice, transistor bottom-plate drivers r1_drv,
* transistor clkgen, r1_cmp5n for decision 0, r1_cmp4 for decisions 1-13), both slices in parallel (stagger 0),
* frames e c e e (encoder, stolen current frame, encoder, encoder; 22 ticks each). Copy of sim/r4/tb_adc4_isa.cir with
* the revision-5 core and reference ports; current CM 0.60 V (isense revision 2, INTERFACES.md).
*   frame 0 enc: SIN +0.40, COS -0.40   frame 1 cur: ISA +0.85, ISB -0.85
*   frame 2 enc: SIN -0.40, COS +0.40   frame 3 enc: SIN +0.72, COS -0.72
* Timing: TIMING (mux timing; the _pre33 variant gives one 33 ns start-up hold pulse on trk0, see gen_timing_pre5.py).
* Supply currents: average i(vdd) and i(vdda) over the four frames (0.6 us .. TSTOP).
.lib /foss/pdks/ihp-sg13g2/libs.tech/ngspice/models/cornerMOSlv.lib mos_tt
.lib /foss/pdks/ihp-sg13g2/libs.tech/ngspice/models/cornerCAP.lib cap_typ
.lib /foss/pdks/ihp-sg13g2/libs.tech/ngspice/models/cornerMOShv.lib mos_tt
.lib /foss/pdks/ihp-sg13g2/libs.tech/ngspice/models/cornerRES.lib res_typ
.include schematic/r1_adc_r5.spice
.include sim/post/r1_adc_post_rc_mb.spice
.include sim/post/r1_adc5_post.spice
.include sim/r5/r1_adc_timing_r5_mux_n0_cq_pre33.inc
.temp 27
.option reltol=1e-4 vntol=1e-6 abstol=1e-12 method=trap sparse seed=1 noopiter
Vdd vdd 0 1.2
Vdda vdda 0 3.3
Vbgi vbgw 0 DC 1.045 TRNOISE(0.0004646 4.73e-08 0 0)
Vbgf vbgi vbgw DC 0 TRNOISE(0 4.73e-08 1.15 1.285e-05)
Rbg vbgi vbg 190k
Ibref vdda nbr 5u
Vcme vcme 0 0.6
Vcmi vcmi 0 0.6
Vsin vsin 0 PWL(0 0.40 1.012u 0.40 1.022u -0.40 2.352u -0.40 2.362u 0.72 6u 0.72)
Visa visa 0 0.85
Esp sinp vcme vsin 0 0.5
Esn sinn vcme vsin 0 -0.5
Ecp cosp vcme vsin 0 -0.5
Ecn cosn vcme vsin 0 0.5
Eap isap vcmi visa 0 0.5
Ean isan vcmi visa 0 -0.5
Ebp isbp vcmi visa 0 -0.5
Ebn isbn vcmi visa 0 0.5
XADC sinp sinn cosp cosn isap isan isbp isbn trka0 trka1 trkb0 trkb1 clk30 wina winb lata latb
+ stba0 stba1 stba2 stba3 stba4 stba5 stba6 stba7 stba8 stba9 stba10 stba11 stba12 stba13
+ stbb0 stbb1 stbb2 stbb3 stbb4 stbb5 stbb6 stbb7 stbb8 stbb9 stbb10 stbb11 stbb12 stbb13
+ rawa rawb topap topan topbp topbn vdd vrefa vrefb vrefla vreflb 0 vbg nbr vdda r1_adc5_core_lay
.control
set num_threads=1
save v(rawa) v(rawb) v(topap) v(topan) v(topbp) v(topbn) v(trka0) v(trka1) v(trkb0) v(trkb1) v(lata) v(latb) v(clk30) v(vrefa) v(vrefla) i(vdd) i(vdda) v(vbg) v(vrefla)
tran 1n 3.31u 0 0.2n
meas tran idd avg i(vdd) from=0.6u to=3.31u
meas tran idda avg i(vdda) from=0.6u to=3.31u
write <G1_RESULTS_ROOT>/r1_adc/postb-isa-tt-rc/codes.raw
.endc
.end
