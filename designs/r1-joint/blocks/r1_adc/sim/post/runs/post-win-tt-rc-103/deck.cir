* tb_post_points.cir: generated by sim/post/gen_post_decks.py from sim/r5/tb_adc5_points.cir (include line -> NETLISTS substitution; instance in INSTANCES)
* tb_adc5_points.cir -- R1 ADC revision 5 (D18): both slices, one held differential input per frame and slice.
* Frame s: slice A samples vda (SIN path) at tsA = 0.6 us + s * 22 T, slice B samples vdb (COS path) at tsA.
* vda/vdb are PWL sources written by sim/r5/run_points5.py (value of frame s applied 550 ns before its edge).
* Inputs are linear E sources around the common mode CM (R2-7). Track is high from t = 0 (revision-5 timing).
* Reference: REFLINES (ideal source, or the buffer under test fed by the r1_bgr Thevenin + noise model, see
* run_points5.py); the core has per-slice ports vrefa vrefb (MSB array) and vrefla vreflb (LSB array).
* Substitutions: CORNER TEMP VDD CM CAPLIB TIMING OPTS TMAX TSTOP PWLA PWLB REFLINES INSTANCES SAVE RAW
.lib /foss/pdks/ihp-sg13g2/libs.tech/ngspice/models/cornerMOSlv.lib mos_tt
.lib /foss/pdks/ihp-sg13g2/libs.tech/ngspice/models/cornerCAP.lib cap_typ
.lib /foss/pdks/ihp-sg13g2/libs.tech/ngspice/models/cornerMOShv.lib mos_tt
.lib /foss/pdks/ihp-sg13g2/libs.tech/ngspice/models/cornerRES.lib res_typ
.include schematic/r1_adc_r5.spice
.include sim/post/r1_adc_post_rc_m.spice
.include sim/post/r1_adc5_post.spice
.include sim/r5/r1_adc_timing_r5_n0_cq.inc
.temp 27
.option reltol=1e-4 vntol=1e-6 abstol=1e-12 method=trap sparse seed=1 noopiter interp

Vdd vdd 0 1.2
Vdda vdda 0 3.3
Vbgi vbgi 0 DC 0.995000
Rbg vbgi vbg 190k
Ibref vdda nbr 5u
Vrefi vrefa 0 1.045
Vrefli vrefla 0 1.045
Vcm vcm 0 0.6
Vda vda 0 PWL(0 0.0000000 7.883333e-07 0.0000000 7.983333e-07 -0.4687106 1.521667e-06 -0.4687106 1.531667e-06 -0.4684774 2.255000e-06 -0.4684774 2.265000e-06 -0.4682441 2.988333e-06 -0.4682441
+ 2.998333e-06 -0.4680109 3.721667e-06 -0.4680109 3.731667e-06 -0.4677776 4.455000e-06 -0.4677776 4.465000e-06 -0.4675444 5.188333e-06 -0.4675444 5.198333e-06 -0.4673111 5.921667e-06 -0.4673111
+ 5.931667e-06 -0.4670779 6.655000e-06 -0.4670779 6.665000e-06 -0.4668447 7.388333e-06 -0.4668447 7.398333e-06 -0.4666114 8.121667e-06 -0.4666114 8.131667e-06 -0.4663782 8.855000e-06 -0.4663782
+ 8.865000e-06 -0.4661449 9.588333e-06 -0.4661449 9.598333e-06 -0.4659117 1.032167e-05 -0.4659117 1.033167e-05 -0.4656784 1.105500e-05 -0.4656784 1.106500e-05 -0.4654452 1.178833e-05 -0.4654452
+ 1.179833e-05 -0.4652120 1.252167e-05 -0.4652120 1.253167e-05 -0.4649787 1.325500e-05 -0.4649787 1.326500e-05 -0.4647455 1.398833e-05 -0.4647455 1.399833e-05 -0.4645122 1.472167e-05 -0.4645122
+ 1.473167e-05 -0.4642790 1.545500e-05 -0.4642790 1.546500e-05 -0.4640457 1.618833e-05 -0.4640457 1.619833e-05 -0.4638125 1.692167e-05 -0.4638125 1.693167e-05 -0.4635792 1.765500e-05 -0.4635792
+ 1.766500e-05 -0.4633460 1.838833e-05 -0.4633460 1.839833e-05 -0.4631128 1.912167e-05 -0.4631128 1.913167e-05 -0.0026739 1.985500e-05 -0.0026739 1.986500e-05 -0.0024407 2.058833e-05 -0.0024407
+ 2.059833e-05 -0.0022074 2.132167e-05 -0.0022074 2.133167e-05 -0.0019742 2.205500e-05 -0.0019742 2.206500e-05 -0.0017410 2.278833e-05 -0.0017410 2.279833e-05 -0.0015077 2.352167e-05 -0.0015077
+ 2.353167e-05 -0.0012745 2.425500e-05 -0.0012745 2.426500e-05 -0.0010412 2.498833e-05 -0.0010412 2.499833e-05 -0.0008080 2.572167e-05 -0.0008080 2.573167e-05 -0.0005747 2.645500e-05 -0.0005747
+ 2.646500e-05 -0.0003415 2.718833e-05 -0.0003415 2.719833e-05 -0.0001082 2.792167e-05 -0.0001082 2.793167e-05 0.0001250 2.865500e-05 0.0001250 2.866500e-05 0.0003582 2.938833e-05 0.0003582
+ 2.939833e-05 0.0005915 3.012167e-05 0.0005915 3.013167e-05 0.0008247 3.085500e-05 0.0008247 3.086500e-05 0.0010580 3.158833e-05 0.0010580 3.159833e-05 0.0012912 3.232167e-05 0.0012912
+ 3.233167e-05 0.0015245 3.305500e-05 0.0015245 3.306500e-05 0.0017577 3.378833e-05 0.0017577 3.379833e-05 0.0019910 3.452167e-05 0.0019910 3.453167e-05 0.0022242 3.525500e-05 0.0022242
+ 3.526500e-05 0.0024574 3.598833e-05 0.0024574 3.599833e-05 0.0026907 3.672167e-05 0.0026907 3.673167e-05 0.0029239 3.745500e-05 0.0029239 3.746500e-05 0.4631128 3.818833e-05 0.4631128
+ 3.819833e-05 0.4633460 3.892167e-05 0.4633460 3.893167e-05 0.4635792 3.965500e-05 0.4635792 3.966500e-05 0.4638125 4.038833e-05 0.4638125 4.039833e-05 0.4640457 4.112167e-05 0.4640457
+ 4.113167e-05 0.4642790 4.185500e-05 0.4642790 4.186500e-05 0.4645122 4.258833e-05 0.4645122 4.259833e-05 0.4647455 4.332167e-05 0.4647455 4.333167e-05 0.4649787 4.405500e-05 0.4649787
+ 4.406500e-05 0.4652120 4.478833e-05 0.4652120 4.479833e-05 0.4654452 4.552167e-05 0.4654452 4.553167e-05 0.4656784 4.625500e-05 0.4656784 4.626500e-05 0.4659117 4.698833e-05 0.4659117
+ 4.699833e-05 0.4661449 4.772167e-05 0.4661449 4.773167e-05 0.4663782 4.845500e-05 0.4663782 4.846500e-05 0.4666114 4.918833e-05 0.4666114 4.919833e-05 0.4668447 4.992167e-05 0.4668447
+ 4.993167e-05 0.4670779 5.065500e-05 0.4670779 5.066500e-05 0.4673111 5.138833e-05 0.4673111 5.139833e-05 0.4675444 5.212167e-05 0.4675444 5.213167e-05 0.4677776 5.285500e-05 0.4677776
+ 5.286500e-05 0.4680109 5.358833e-05 0.4680109 5.359833e-05 0.4682441 5.432167e-05 0.4682441 5.433167e-05 0.4684774 5.505500e-05 0.4684774 5.506500e-05 0.4687106)
Vdb vdb 0 PWL(0 0.0000000 7.883333e-07 0.0000000 7.983333e-07 -0.4688051 1.521667e-06 -0.4688051 1.531667e-06 -0.4685719 2.255000e-06 -0.4685719 2.265000e-06 -0.4683386 2.988333e-06 -0.4683386
+ 2.998333e-06 -0.4681054 3.721667e-06 -0.4681054 3.731667e-06 -0.4678721 4.455000e-06 -0.4678721 4.465000e-06 -0.4676389 5.188333e-06 -0.4676389 5.198333e-06 -0.4674056 5.921667e-06 -0.4674056
+ 5.931667e-06 -0.4671724 6.655000e-06 -0.4671724 6.665000e-06 -0.4669392 7.388333e-06 -0.4669392 7.398333e-06 -0.4667059 8.121667e-06 -0.4667059 8.131667e-06 -0.4664727 8.855000e-06 -0.4664727
+ 8.865000e-06 -0.4662394 9.588333e-06 -0.4662394 9.598333e-06 -0.4660062 1.032167e-05 -0.4660062 1.033167e-05 -0.4657729 1.105500e-05 -0.4657729 1.106500e-05 -0.4655397 1.178833e-05 -0.4655397
+ 1.179833e-05 -0.4653065 1.252167e-05 -0.4653065 1.253167e-05 -0.4650732 1.325500e-05 -0.4650732 1.326500e-05 -0.4648400 1.398833e-05 -0.4648400 1.399833e-05 -0.4646067 1.472167e-05 -0.4646067
+ 1.473167e-05 -0.4643735 1.545500e-05 -0.4643735 1.546500e-05 -0.4641402 1.618833e-05 -0.4641402 1.619833e-05 -0.4639070 1.692167e-05 -0.4639070 1.693167e-05 -0.4636737 1.765500e-05 -0.4636737
+ 1.766500e-05 -0.4634405 1.838833e-05 -0.4634405 1.839833e-05 -0.4632073 1.912167e-05 -0.4632073 1.913167e-05 -0.0026823 1.985500e-05 -0.0026823 1.986500e-05 -0.0024491 2.058833e-05 -0.0024491
+ 2.059833e-05 -0.0022158 2.132167e-05 -0.0022158 2.133167e-05 -0.0019826 2.205500e-05 -0.0019826 2.206500e-05 -0.0017493 2.278833e-05 -0.0017493 2.279833e-05 -0.0015161 2.352167e-05 -0.0015161
+ 2.353167e-05 -0.0012828 2.425500e-05 -0.0012828 2.426500e-05 -0.0010496 2.498833e-05 -0.0010496 2.499833e-05 -0.0008164 2.572167e-05 -0.0008164 2.573167e-05 -0.0005831 2.645500e-05 -0.0005831
+ 2.646500e-05 -0.0003499 2.718833e-05 -0.0003499 2.719833e-05 -0.0001166 2.792167e-05 -0.0001166 2.793167e-05 0.0001166 2.865500e-05 0.0001166 2.866500e-05 0.0003499 2.938833e-05 0.0003499
+ 2.939833e-05 0.0005831 3.012167e-05 0.0005831 3.013167e-05 0.0008164 3.085500e-05 0.0008164 3.086500e-05 0.0010496 3.158833e-05 0.0010496 3.159833e-05 0.0012828 3.232167e-05 0.0012828
+ 3.233167e-05 0.0015161 3.305500e-05 0.0015161 3.306500e-05 0.0017493 3.378833e-05 0.0017493 3.379833e-05 0.0019826 3.452167e-05 0.0019826 3.453167e-05 0.0022158 3.525500e-05 0.0022158
+ 3.526500e-05 0.0024491 3.598833e-05 0.0024491 3.599833e-05 0.0026823 3.672167e-05 0.0026823 3.673167e-05 0.0029155 3.745500e-05 0.0029155 3.746500e-05 0.4634405 3.818833e-05 0.4634405
+ 3.819833e-05 0.4636737 3.892167e-05 0.4636737 3.893167e-05 0.4639070 3.965500e-05 0.4639070 3.966500e-05 0.4641402 4.038833e-05 0.4641402 4.039833e-05 0.4643735 4.112167e-05 0.4643735
+ 4.113167e-05 0.4646067 4.185500e-05 0.4646067 4.186500e-05 0.4648400 4.258833e-05 0.4648400 4.259833e-05 0.4650732 4.332167e-05 0.4650732 4.333167e-05 0.4653065 4.405500e-05 0.4653065
+ 4.406500e-05 0.4655397 4.478833e-05 0.4655397 4.479833e-05 0.4657729 4.552167e-05 0.4657729 4.553167e-05 0.4660062 4.625500e-05 0.4660062 4.626500e-05 0.4662394 4.698833e-05 0.4662394
+ 4.699833e-05 0.4664727 4.772167e-05 0.4664727 4.773167e-05 0.4667059 4.845500e-05 0.4667059 4.846500e-05 0.4669392 4.918833e-05 0.4669392 4.919833e-05 0.4671724 4.992167e-05 0.4671724
+ 4.993167e-05 0.4674056 5.065500e-05 0.4674056 5.066500e-05 0.4676389 5.138833e-05 0.4676389 5.139833e-05 0.4678721 5.212167e-05 0.4678721 5.213167e-05 0.4681054 5.285500e-05 0.4681054
+ 5.286500e-05 0.4683386 5.358833e-05 0.4683386 5.359833e-05 0.4685719 5.432167e-05 0.4685719 5.433167e-05 0.4688051 5.505500e-05 0.4688051 5.506500e-05 0.4690384)
Esp sinp vcm vda 0 0.5
Esn sinn vcm vda 0 -0.5
Ecp cosp vcm vdb 0 0.5
Ecn cosn vcm vdb 0 -0.5
Vip isap 0 0.6
Vin isan 0 0.6

XADC sinp sinn cosp cosn isap isan isap isan trka0 trka1 trkb0 trkb1 clk30 wina winb lata latb
+ stba0 stba1 stba2 stba3 stba4 stba5 stba6 stba7 stba8 stba9 stba10 stba11 stba12 stba13
+ stbb0 stbb1 stbb2 stbb3 stbb4 stbb5 stbb6 stbb7 stbb8 stbb9 stbb10 stbb11 stbb12 stbb13
+ rawa rawb topap topan topbp topbn vdd vrefa vrefb vrefla vreflb 0 vbg nbr vdda r1_adc5_core_lay

.control
set num_threads=1
save v(rawa) v(rawb) i(vdda) v(vbg)
tran 1n 56.1267u 0 0.2n
write <G1_RESULTS_ROOT>/r1_adc/post-win-tt-rc-103/codes.raw
.endc
.end
