* a_r_sup_b.spice: diagnostic variant of r1_adc_post_rc_m.spice (--no-c --r-nets gnd,vdd,vss,vdda): 1523 C dropped, 901 R set to 0.05 Ohm, 0 R scaled
* merged by sim/post/merge_parallel.py from pex/r1_adc_post_rc.spice (sha256 dab1c57ab9ae0af4): 668 -> 285 device instances (identical parallel devices as m = count)
* r1_adc post-layout netlist, layout A (RC), written by pex/pex_build.py; see its docstring
* devices: LVS reference of layout/r1_adc_netlist.py; R: KLayout RNetExtractor Metal1-5/Via1-4; C: kpex 0.3.12 2.5D CC
* requires cornerMOSlv/hv.lib, cornerCAP.lib, cornerRES.lib
.subckt r1_adc_slice_post in0p in0n in1p in1n trk0 trk1 cp0 cp1 cp2 cp3 cp4 cp5 cp6 cp7 cp8 cp9 cp10 cp11 cp12 cn0 cn1 cn2 cn3 cn4 cn5 cn6 cn7 cn8 cn9 cn10 cn11 cn12 clk clkb clkn clknb op on onp onn vbp vbn vref vrefl vrefl__p19 top_p top_n vdd vdd__p36 vdd__p37 vdd__p38 gnd gnd__p59 gnd__p60 gnd__p61
Xxpt0a t0b__p7 trk0__p1 vdd__p12 vdd sg13_lv_pmos w=2u l=0.13u ng=1 m=1
Xxnt0a t0b__p4 trk0 gnd__p36 gnd sg13_lv_nmos w=1u l=0.13u ng=1 m=1
Xxpt0b t0__p5 t0b__p8 vdd__p13 vdd sg13_lv_pmos w=4u l=0.13u ng=1 m=1
Xxnt0b t0__p4 t0b__p5 gnd__p37 gnd sg13_lv_nmos w=2u l=0.13u ng=1 m=1
Xxpt1a t1b__p7 trk1__p1 vdd__p14 vdd sg13_lv_pmos w=2u l=0.13u ng=1 m=1
Xxnt1a t1b__p4 trk1 gnd__p38 gnd sg13_lv_nmos w=1u l=0.13u ng=1 m=1
Xxpt1b t1__p5 t1b__p8 vdd__p15 vdd sg13_lv_pmos w=4u l=0.13u ng=1 m=1
Xxnt1b t1__p4 t1b__p5 gnd__p39 gnd sg13_lv_nmos w=2u l=0.13u ng=1 m=1
Xxs0p_xms in0p__p0 xs0p_g top_p__p2 gnd sg13_lv_nmos w=6u l=0.13u ng=2 m=1
Xxs0p_cboot xs0p_cbp__p2 xs0p_cbn__p4 cap_cmim w=11.49u l=11.49u m=1
Xxs0p_xm1 xs0p_cbn__p1 t0b__p2 gnd__p30 gnd sg13_lv_nmos w=1u l=0.13u ng=1 m=1
Xxs0p_xm3 xs0p_cbp xs0p_g__p4 vdd__p4 xs0p_cbp sg13_lv_pmos w=1u l=0.13u ng=1 m=1
Xxs0p_xm8 xs0p_g__p5 xs0p_x__p2 xs0p_cbp__p1 xs0p_cbp sg13_lv_pmos w=2u l=0.13u ng=1 m=1
Xxs0p_xm4 xs0p_x__p3 t0__p3 vdd__p5 vdd sg13_lv_pmos w=0.5u l=0.13u ng=1 m=1
Xxs0p_xm5 xs0p_x t0__p2 xs0p_cbn__p2 gnd sg13_lv_nmos w=1u l=0.13u ng=1 m=1
Xxs0p_xm7 xs0p_x__p1 xs0p_g__p2 xs0p_cbn__p3 gnd sg13_lv_nmos w=0.5u l=0.13u ng=1 m=1
Xxs0p_xm9 xs0p_cbn xs0p_g__p1 in0p__p1 gnd sg13_lv_nmos w=2u l=0.13u ng=1 m=1
Xxs0p_xm10 xs0p_g__p3 vdd__p3 xs0p_n10 gnd sg13_lv_nmos w=2u l=0.13u ng=1 m=1
Xxs0p_xm11 xs0p_n10__p1 t0b__p3 gnd__p31 gnd sg13_lv_nmos w=2u l=0.13u ng=1 m=1
Xxs0n_xms in0n__p0 xs0n_g top_n__p2 gnd sg13_lv_nmos w=6u l=0.13u ng=2 m=1
Xxs0n_cboot xs0n_cbp__p2 xs0n_cbn__p4 cap_cmim w=11.49u l=11.49u m=1
Xxs0n_xm1 xs0n_cbn__p1 t0b gnd__p28 gnd sg13_lv_nmos w=1u l=0.13u ng=1 m=1
Xxs0n_xm3 xs0n_cbp xs0n_g__p4 vdd__p1 xs0n_cbp sg13_lv_pmos w=1u l=0.13u ng=1 m=1
Xxs0n_xm8 xs0n_g__p5 xs0n_x__p2 xs0n_cbp__p1 xs0n_cbp sg13_lv_pmos w=2u l=0.13u ng=1 m=1
Xxs0n_xm4 xs0n_x__p3 t0__p1 vdd__p2 vdd sg13_lv_pmos w=0.5u l=0.13u ng=1 m=1
Xxs0n_xm5 xs0n_x t0 xs0n_cbn__p2 gnd sg13_lv_nmos w=1u l=0.13u ng=1 m=1
Xxs0n_xm7 xs0n_x__p1 xs0n_g__p2 xs0n_cbn__p3 gnd sg13_lv_nmos w=0.5u l=0.13u ng=1 m=1
Xxs0n_xm9 xs0n_cbn xs0n_g__p1 in0n__p1 gnd sg13_lv_nmos w=2u l=0.13u ng=1 m=1
Xxs0n_xm10 xs0n_g__p3 vdd__p0 xs0n_n10 gnd sg13_lv_nmos w=2u l=0.13u ng=1 m=1
Xxs0n_xm11 xs0n_n10__p1 t0b__p1 gnd__p29 gnd sg13_lv_nmos w=2u l=0.13u ng=1 m=1
Xxs1p_xms in1p__p0 xs1p_g top_p__p3 gnd sg13_lv_nmos w=6u l=0.13u ng=2 m=1
Xxs1p_cboot xs1p_cbp__p2 xs1p_cbn__p4 cap_cmim w=11.49u l=11.49u m=1
Xxs1p_xm1 xs1p_cbn__p1 t1b__p2 gnd__p34 gnd sg13_lv_nmos w=1u l=0.13u ng=1 m=1
Xxs1p_xm3 xs1p_cbp xs1p_g__p4 vdd__p10 xs1p_cbp sg13_lv_pmos w=1u l=0.13u ng=1 m=1
Xxs1p_xm8 xs1p_g__p5 xs1p_x__p2 xs1p_cbp__p1 xs1p_cbp sg13_lv_pmos w=2u l=0.13u ng=1 m=1
Xxs1p_xm4 xs1p_x__p3 t1__p3 vdd__p11 vdd sg13_lv_pmos w=0.5u l=0.13u ng=1 m=1
Xxs1p_xm5 xs1p_x t1__p2 xs1p_cbn__p2 gnd sg13_lv_nmos w=1u l=0.13u ng=1 m=1
Xxs1p_xm7 xs1p_x__p1 xs1p_g__p2 xs1p_cbn__p3 gnd sg13_lv_nmos w=0.5u l=0.13u ng=1 m=1
Xxs1p_xm9 xs1p_cbn xs1p_g__p1 in1p__p1 gnd sg13_lv_nmos w=2u l=0.13u ng=1 m=1
Xxs1p_xm10 xs1p_g__p3 vdd__p9 xs1p_n10 gnd sg13_lv_nmos w=2u l=0.13u ng=1 m=1
Xxs1p_xm11 xs1p_n10__p1 t1b__p3 gnd__p35 gnd sg13_lv_nmos w=2u l=0.13u ng=1 m=1
Xxs1n_xms in1n__p0 xs1n_g top_n__p3 gnd sg13_lv_nmos w=6u l=0.13u ng=2 m=1
Xxs1n_cboot xs1n_cbp__p2 xs1n_cbn__p4 cap_cmim w=11.49u l=11.49u m=1
Xxs1n_xm1 xs1n_cbn__p1 t1b gnd__p32 gnd sg13_lv_nmos w=1u l=0.13u ng=1 m=1
Xxs1n_xm3 xs1n_cbp xs1n_g__p4 vdd__p7 xs1n_cbp sg13_lv_pmos w=1u l=0.13u ng=1 m=1
Xxs1n_xm8 xs1n_g__p5 xs1n_x__p2 xs1n_cbp__p1 xs1n_cbp sg13_lv_pmos w=2u l=0.13u ng=1 m=1
Xxs1n_xm4 xs1n_x__p3 t1__p1 vdd__p8 vdd sg13_lv_pmos w=0.5u l=0.13u ng=1 m=1
Xxs1n_xm5 xs1n_x t1 xs1n_cbn__p2 gnd sg13_lv_nmos w=1u l=0.13u ng=1 m=1
Xxs1n_xm7 xs1n_x__p1 xs1n_g__p2 xs1n_cbn__p3 gnd sg13_lv_nmos w=0.5u l=0.13u ng=1 m=1
Xxs1n_xm9 xs1n_cbn xs1n_g__p1 in1n__p1 gnd sg13_lv_nmos w=2u l=0.13u ng=1 m=1
Xxs1n_xm10 xs1n_g__p3 vdd__p6 xs1n_n10 gnd sg13_lv_nmos w=2u l=0.13u ng=1 m=1
Xxs1n_xm11 xs1n_n10__p1 t1b__p1 gnd__p33 gnd sg13_lv_nmos w=2u l=0.13u ng=1 m=1
Xxpr1 rstb_n__p2 t0b__p9 vdd__p16 vdd sg13_lv_pmos w=1u l=0.13u ng=1 m=1
Xxpr2 rstb_n__p3 t1b__p9 vdd__p17 vdd sg13_lv_pmos w=1u l=0.13u ng=1 m=1
Xxnr1 rstb_n t0b__p6 nr gnd sg13_lv_nmos w=1u l=0.13u ng=1 m=1
Xxnr2 nr__p1 t1b__p6 gnd__p40 gnd sg13_lv_nmos w=1u l=0.13u ng=1 m=1
Xxpr3 rstb__p3 rstb_n__p4 vdd__p18 vdd sg13_lv_pmos w=1u l=0.13u ng=1 m=1
Xxnr3 rstb__p2 rstb_n__p1 gnd__p41 gnd sg13_lv_nmos w=0.5u l=0.13u ng=1 m=1
Xxlrp lsb_p rstb__p1 vrefl__p9 vrefl sg13_lv_pmos w=1u l=0.13u ng=1 m=1
Xxlrn lsb_n rstb vrefl__p8 vrefl sg13_lv_pmos w=1u l=0.13u ng=1 m=1
Xxdp12_xmp bp12 cp12 vref__p5 vref sg13_lv_pmos w=2u l=0.13u ng=1 m=1
Xxdp12_xmn bp12__p1 cp12__p1 gnd__p13 gnd sg13_lv_nmos w=1u l=0.13u ng=1 m=1
Xxdp11_xmp bp11 cp11 vref__p6 vref sg13_lv_pmos w=2u l=0.13u ng=1 m=1
Xxdp11_xmn bp11__p1 cp11__p1 gnd__p14 gnd sg13_lv_nmos w=1u l=0.13u ng=1 m=1
Xxdp10_xmp bp10 cp10 vref__p7 vref sg13_lv_pmos w=2u l=0.13u ng=1 m=1
Xxdp10_xmn bp10__p1 cp10__p1 gnd__p15 gnd sg13_lv_nmos w=1u l=0.13u ng=1 m=1
Xxdp9_xmp bp9 cp9 vref__p8 vref sg13_lv_pmos w=1u l=0.13u ng=1 m=1
Xxdp9_xmn bp9__p1 cp9__p1 gnd__p16 gnd sg13_lv_nmos w=0.5u l=0.13u ng=1 m=1
Xxdp8_xmp bp8 cp8 vref__p9 vref sg13_lv_pmos w=1u l=0.13u ng=1 m=1
Xxdp8_xmn bp8__p1 cp8__p1 gnd__p17 gnd sg13_lv_nmos w=0.5u l=0.13u ng=1 m=1
Xxdp7_xmp bp7 cp7 vrefl__p10 vrefl sg13_lv_pmos w=1u l=0.13u ng=1 m=1
Xxdp7_xmn bp7__p1 cp7__p1 gnd__p18 gnd sg13_lv_nmos w=0.5u l=0.13u ng=1 m=1
Xxdp6_xmp bp6 cp6 vrefl__p11 vrefl sg13_lv_pmos w=1u l=0.13u ng=1 m=1
Xxdp6_xmn bp6__p1 cp6__p1 gnd__p19 gnd sg13_lv_nmos w=0.5u l=0.13u ng=1 m=1
Xxdp5_xmp bp5 cp5 vrefl__p12 vrefl sg13_lv_pmos w=1u l=0.13u ng=1 m=1
Xxdp5_xmn bp5__p1 cp5__p1 gnd__p20 gnd sg13_lv_nmos w=0.5u l=0.13u ng=1 m=1
Xxdp4_xmp bp4 cp4 vrefl__p13 vrefl sg13_lv_pmos w=1u l=0.13u ng=1 m=1
Xxdp4_xmn bp4__p1 cp4__p1 gnd__p21 gnd sg13_lv_nmos w=0.5u l=0.13u ng=1 m=1
Xxdp3_xmp bp3 cp3 vrefl__p14 vrefl sg13_lv_pmos w=1u l=0.13u ng=1 m=1
Xxdp3_xmn bp3__p1 cp3__p1 gnd__p22 gnd sg13_lv_nmos w=0.5u l=0.13u ng=1 m=1
Xxdp2_xmp bp2 cp2 vrefl__p15 vrefl sg13_lv_pmos w=1u l=0.13u ng=1 m=1
Xxdp2_xmn bp2__p1 cp2__p1 gnd__p23 gnd sg13_lv_nmos w=0.5u l=0.13u ng=1 m=1
Xxdp1_xmp bp1 cp1 vrefl__p16 vrefl sg13_lv_pmos w=1u l=0.13u ng=1 m=1
Xxdp1_xmn bp1__p1 cp1__p1 gnd__p24 gnd sg13_lv_nmos w=0.5u l=0.13u ng=1 m=1
Xxdp0_xmp bp0 cp0 vrefl__p17 vrefl sg13_lv_pmos w=1u l=0.13u ng=1 m=1
Xxdp0_xmn bp0__p1 cp0__p1 gnd__p25 gnd sg13_lv_nmos w=0.5u l=0.13u ng=1 m=1
Xxdn12_xmp bn12 cn12 vref__p4 vref sg13_lv_pmos w=2u l=0.13u ng=1 m=1
Xxdn12_xmn bn12__p1 cn12__p1 gnd__p12 gnd sg13_lv_nmos w=1u l=0.13u ng=1 m=1
Xxdn11_xmp bn11 cn11 vref__p3 vref sg13_lv_pmos w=2u l=0.13u ng=1 m=1
Xxdn11_xmn bn11__p1 cn11__p1 gnd__p11 gnd sg13_lv_nmos w=1u l=0.13u ng=1 m=1
Xxdn10_xmp bn10 cn10 vref__p2 vref sg13_lv_pmos w=2u l=0.13u ng=1 m=1
Xxdn10_xmn bn10__p1 cn10__p1 gnd__p10 gnd sg13_lv_nmos w=1u l=0.13u ng=1 m=1
Xxdn9_xmp bn9 cn9 vref__p1 vref sg13_lv_pmos w=1u l=0.13u ng=1 m=1
Xxdn9_xmn bn9__p1 cn9__p1 gnd__p9 gnd sg13_lv_nmos w=0.5u l=0.13u ng=1 m=1
Xxdn8_xmp bn8 cn8 vref__p0 vref sg13_lv_pmos w=1u l=0.13u ng=1 m=1
Xxdn8_xmn bn8__p1 cn8__p1 gnd__p8 gnd sg13_lv_nmos w=0.5u l=0.13u ng=1 m=1
Xxdn7_xmp bn7 cn7 vrefl__p7 vrefl sg13_lv_pmos w=1u l=0.13u ng=1 m=1
Xxdn7_xmn bn7__p1 cn7__p1 gnd__p7 gnd sg13_lv_nmos w=0.5u l=0.13u ng=1 m=1
Xxdn6_xmp bn6 cn6 vrefl__p6 vrefl sg13_lv_pmos w=1u l=0.13u ng=1 m=1
Xxdn6_xmn bn6__p1 cn6__p1 gnd__p6 gnd sg13_lv_nmos w=0.5u l=0.13u ng=1 m=1
Xxdn5_xmp bn5 cn5 vrefl__p5 vrefl sg13_lv_pmos w=1u l=0.13u ng=1 m=1
Xxdn5_xmn bn5__p1 cn5__p1 gnd__p5 gnd sg13_lv_nmos w=0.5u l=0.13u ng=1 m=1
Xxdn4_xmp bn4 cn4 vrefl__p4 vrefl sg13_lv_pmos w=1u l=0.13u ng=1 m=1
Xxdn4_xmn bn4__p1 cn4__p1 gnd__p4 gnd sg13_lv_nmos w=0.5u l=0.13u ng=1 m=1
Xxdn3_xmp bn3 cn3 vrefl__p3 vrefl sg13_lv_pmos w=1u l=0.13u ng=1 m=1
Xxdn3_xmn bn3__p1 cn3__p1 gnd__p3 gnd sg13_lv_nmos w=0.5u l=0.13u ng=1 m=1
Xxdn2_xmp bn2 cn2 vrefl__p2 vrefl sg13_lv_pmos w=1u l=0.13u ng=1 m=1
Xxdn2_xmn bn2__p1 cn2__p1 gnd__p2 gnd sg13_lv_nmos w=0.5u l=0.13u ng=1 m=1
Xxdn1_xmp bn1 cn1 vrefl__p1 vrefl sg13_lv_pmos w=1u l=0.13u ng=1 m=1
Xxdn1_xmn bn1__p1 cn1__p1 gnd__p1 gnd sg13_lv_nmos w=0.5u l=0.13u ng=1 m=1
Xxdn0_xmp bn0 cn0 vrefl__p0 vrefl sg13_lv_pmos w=1u l=0.13u ng=1 m=1
Xxdn0_xmn bn0__p1 cn0__p1 gnd__p0 gnd sg13_lv_nmos w=0.5u l=0.13u ng=1 m=1
Xxc4_xs1_xmt1 xc4_xs1_tail0 clkb__p2 vdd__p28 vdd sg13_lv_pmos w=16u l=0.13u ng=4 m=1
Xxc4_xs1_xmtc xc4_xs1_tail__p2 vbp xc4_xs1_tail0__p1 vdd sg13_lv_pmos w=16u l=0.5u ng=4 m=1
Xxc4_xs1_xm1 xc4_dip top_p__p4 xc4_xs1_tail vdd sg13_lv_pmos w=48u l=0.3u ng=12 m=1
Xxc4_xs1_xm2 xc4_din top_n__p4 xc4_xs1_tail__p1 vdd sg13_lv_pmos w=48u l=0.3u ng=12 m=1
Xxc4_xci1 vdd__p23 xc4_dip vdd__p22 vdd sg13_lv_pmos w=80u l=4u ng=8 m=1
Xxc4_xci2 vdd__p25 xc4_din vdd__p24 vdd sg13_lv_pmos w=80u l=4u ng=8 m=1
Xxc4_xmr1 xc4_dip__p1 clkb gnd__p49 gnd sg13_lv_nmos w=20u l=0.13u ng=2 m=1
Xxc4_xmr2 xc4_din__p1 clkb__p1 gnd__p50 gnd sg13_lv_nmos w=20u l=0.13u ng=2 m=1
Xxc4_xmt2 xc4_lt clk gnd__p55 gnd sg13_lv_nmos w=4u l=0.13u ng=1 m=1
Xxc4_xmn1 op on xc4_lt__p1 gnd sg13_lv_nmos w=2u l=0.13u ng=1 m=1
Xxc4_xmn2 on__p1 op__p1 xc4_lt__p2 gnd sg13_lv_nmos w=2u l=0.13u ng=1 m=1
Xxc4_xmp1 op__p4 on__p4 vdd__p31 vdd sg13_lv_pmos w=2u l=0.13u ng=1 m=1
Xxc4_xmp2 on__p5 op__p5 vdd__p32 vdd sg13_lv_pmos w=2u l=0.13u ng=1 m=1
Xxc4_xmh1 op__p3 xc4_dip__p2 vdd__p29 vdd sg13_lv_pmos w=8u l=0.13u ng=2 m=1
Xxc4_xmh2 on__p3 xc4_din__p2 vdd__p30 vdd sg13_lv_pmos w=8u l=0.13u ng=2 m=1
Xxc4_xbp1 xc4_outpb__p1 op__p6 vdd__p33 vdd sg13_lv_pmos w=1u l=0.13u ng=1 m=1
Xxc4_xbn1 xc4_outpb op__p2 gnd__p56 gnd sg13_lv_nmos w=0.5u l=0.13u ng=1 m=1
Xxc4_xbp2 xc4_outnb__p1 on__p6 vdd__p34 vdd sg13_lv_pmos w=1u l=0.13u ng=1 m=1
Xxc4_xbn2 xc4_outnb on__p2 gnd__p57 gnd sg13_lv_nmos w=0.5u l=0.13u ng=1 m=1
Xxc5_xs1_xmt1 xc5_xs1_tail0 clkn__p2 gnd__p46 gnd sg13_lv_nmos w=8u l=0.13u ng=2 m=1
Xxc5_xs1_xmtc xc5_xs1_tail__p2 vbn xc5_xs1_tail0__p1 gnd sg13_lv_nmos w=4u l=0.5u ng=1 m=1
Xxc5_xs1_xm1 xc5_dip__p1 top_p xc5_xs1_tail gnd sg13_lv_nmos w=16u l=0.5u ng=4 m=1
Xxc5_xs1_xm2 xc5_din__p1 top_n xc5_xs1_tail__p1 gnd sg13_lv_nmos w=16u l=0.5u ng=4 m=1
Xxc5_xci1 gnd__p43 xc5_dip gnd__p42 gnd sg13_lv_nmos w=30u l=4u ng=4 m=1
Xxc5_xci2 gnd__p45 xc5_din gnd__p44 gnd sg13_lv_nmos w=30u l=4u ng=4 m=1
Xxc5_xmr1 xc5_dip clkn vdd__p19 vdd sg13_lv_pmos w=16u l=0.13u ng=2 m=1
Xxc5_xmr2 xc5_din clkn__p1 vdd__p20 vdd sg13_lv_pmos w=16u l=0.13u ng=2 m=1
Xxc5_xmt2 xc5_lt clknb vdd__p21 vdd sg13_lv_pmos w=8u l=0.13u ng=1 m=1
Xxc5_xmp1 onp__p4 onn__p4 xc5_lt__p1 vdd sg13_lv_pmos w=4u l=0.13u ng=1 m=1
Xxc5_xmp2 onn__p5 onp__p5 xc5_lt__p2 vdd sg13_lv_pmos w=4u l=0.13u ng=1 m=1
Xxc5_xmn1 onp__p1 onn__p1 gnd__p51 gnd sg13_lv_nmos w=1u l=0.13u ng=1 m=1
Xxc5_xmn2 onn__p2 onp__p2 gnd__p52 gnd sg13_lv_nmos w=1u l=0.13u ng=1 m=1
Xxc5_xmh1 onp xc5_dip__p2 gnd__p47 gnd sg13_lv_nmos w=8u l=0.13u ng=1 m=1
Xxc5_xmh2 onn xc5_din__p2 gnd__p48 gnd sg13_lv_nmos w=8u l=0.13u ng=1 m=1
Xxc5_xbp1 xc5_outpb__p1 onp__p6 vdd__p26 vdd sg13_lv_pmos w=1u l=0.13u ng=1 m=1
Xxc5_xbn1 xc5_outpb onp__p3 gnd__p53 gnd sg13_lv_nmos w=0.5u l=0.13u ng=1 m=1
Xxc5_xbp2 xc5_outnb__p1 onn__p6 vdd__p27 vdd sg13_lv_pmos w=1u l=0.13u ng=1 m=1
Xxc5_xbn2 xc5_outnb onn__p3 gnd__p54 gnd sg13_lv_nmos w=0.5u l=0.13u ng=1 m=1
Xxdacp_xc12_u0 top_p__p1 bp12__p2 cap_cmim w=3.78u l=3.78u m=16
Xxdacp_xc11_u0 top_p__p1 bp11__p2 cap_cmim w=3.78u l=3.78u m=8
Xxdacp_xc10_u0 top_p__p1 bp10__p2 cap_cmim w=3.78u l=3.78u m=4
Xxdacp_xc9_u0 top_p__p1 bp9__p2 cap_cmim w=3.78u l=3.78u m=2
Xxdacp_xc8_u0 top_p__p1 bp8__p2 cap_cmim w=3.78u l=3.78u m=1
Xxdacp_xcb top_p__p1 lsb_p__p1 cap_cmim w=4.23u l=4.23u m=1
Xxdacp_xc7_u0 lsb_p__p1 bp7__p2 cap_cmim w=3.78u l=3.78u m=64
Xxdacp_xc6_u0 lsb_p__p1 bp6__p2 cap_cmim w=3.78u l=3.78u m=32
Xxdacp_xc5_u0 lsb_p__p1 bp5__p2 cap_cmim w=3.78u l=3.78u m=16
Xxdacp_xc4_u0 lsb_p__p1 bp4__p2 cap_cmim w=3.78u l=3.78u m=8
Xxdacp_xc3_u0 lsb_p__p1 bp3__p2 cap_cmim w=3.78u l=3.78u m=4
Xxdacp_xc2_u0 lsb_p__p1 bp2__p2 cap_cmim w=3.78u l=3.78u m=2
Xxdacp_xc1_u0 lsb_p__p1 bp1__p2 cap_cmim w=3.78u l=3.78u m=1
Xxdacp_xc0 lsb_p__p1 bp0__p2 cap_cmim w=2.67u l=2.67u m=1
Xxdacn_xc12_u0 top_n__p1 bn12__p2 cap_cmim w=3.78u l=3.78u m=16
Xxdacn_xc11_u0 top_n__p1 bn11__p2 cap_cmim w=3.78u l=3.78u m=8
Xxdacn_xc10_u0 top_n__p1 bn10__p2 cap_cmim w=3.78u l=3.78u m=4
Xxdacn_xc9_u0 top_n__p1 bn9__p2 cap_cmim w=3.78u l=3.78u m=2
Xxdacn_xc8_u0 top_n__p1 bn8__p2 cap_cmim w=3.78u l=3.78u m=1
Xxdacn_xcb top_n__p1 lsb_n__p1 cap_cmim w=4.23u l=4.23u m=1
Xxdacn_xc7_u0 lsb_n__p1 bn7__p2 cap_cmim w=3.78u l=3.78u m=64
Xxdacn_xc6_u0 lsb_n__p1 bn6__p2 cap_cmim w=3.78u l=3.78u m=32
Xxdacn_xc5_u0 lsb_n__p1 bn5__p2 cap_cmim w=3.78u l=3.78u m=16
Xxdacn_xc4_u0 lsb_n__p1 bn4__p2 cap_cmim w=3.78u l=3.78u m=8
Xxdacn_xc3_u0 lsb_n__p1 bn3__p2 cap_cmim w=3.78u l=3.78u m=4
Xxdacn_xc2_u0 lsb_n__p1 bn2__p2 cap_cmim w=3.78u l=3.78u m=2
Xxdacn_xc1_u0 lsb_n__p1 bn1__p2 cap_cmim w=3.78u l=3.78u m=1
Xxdacn_xc0 lsb_n__p1 bn0__p2 cap_cmim w=2.67u l=2.67u m=1
Xxdmy_u0 gnd__p27 gnd__p27 cap_cmim w=3.78u l=3.78u m=82
Cld_xc4_outpb xc4_outpb gnd 3f
Cld_xc4_outnb xc4_outnb gnd 3f
Cld_xc5_outpb xc5_outpb gnd 3f
Cld_xc5_outnb xc5_outnb gnd 3f
Rw0 bn0 bn0__p1 0.05
Rw1 bn0 bn0__p2 0.05
Rw2 bn0__p1 bn0__p2 0.05
Rw3 bn1 bn1__p1 0.05
Rw4 bn1 bn1__p2 0.05
Rw5 bn1__p1 bn1__p2 0.05
Rw6 bn10 bn10__p1 0.05
Rw7 bn10 bn10__p2 0.05
Rw8 bn10__p1 bn10__p2 0.05
Rw9 bn11 bn11__p2 0.05
Rw10 bn11__p1 bn11__p2 0.05
Rw11 bn12 bn12__p1 0.05
Rw12 bn12 bn12__p2 0.05
Rw13 bn12__p1 bn12__p2 0.05
Rw14 bn2 bn2__p1 0.05
Rw15 bn2 bn2__p2 0.05
Rw16 bn2__p1 bn2__p2 0.05
Rw17 bn3 bn3__p1 0.05
Rw18 bn3 bn3__p2 0.05
Rw19 bn3__p1 bn3__p2 0.05
Rw20 bn4 bn4__p1 0.05
Rw21 bn4 bn4__p2 0.05
Rw22 bn4__p1 bn4__p2 0.05
Rw23 bn5 bn5__p1 0.05
Rw24 bn5 bn5__p2 0.05
Rw25 bn5__p1 bn5__p2 0.05
Rw26 bn6 bn6__p1 0.05
Rw27 bn6 bn6__p2 0.05
Rw28 bn6__p1 bn6__p2 0.05
Rw29 bn7 bn7__p1 0.05
Rw30 bn7 bn7__p2 0.05
Rw31 bn7__p1 bn7__p2 0.05
Rw32 bn8 bn8__p2 0.05
Rw33 bn8__p1 bn8__p2 0.05
Rw34 bn9 bn9__p2 0.05
Rw35 bn9__p1 bn9__p2 0.05
Rw36 bp0 bp0__p1 0.05
Rw37 bp0 bp0__p2 0.05
Rw38 bp0__p1 bp0__p2 0.05
Rw39 bp1 bp1__p1 0.05
Rw40 bp1 bp1__p2 0.05
Rw41 bp1__p1 bp1__p2 0.05
Rw42 bp10 bp10__p1 0.05
Rw43 bp10 bp10__p2 0.05
Rw44 bp10__p1 bp10__p2 0.05
Rw45 bp11 bp11__p1 0.05
Rw46 bp11 bp11__p2 0.05
Rw47 bp11__p1 bp11__p2 0.05
Rw48 bp12 bp12__p2 0.05
Rw49 bp12__p1 bp12__p2 0.05
Rw50 bp2 bp2__p1 0.05
Rw51 bp2 bp2__p2 0.05
Rw52 bp2__p1 bp2__p2 0.05
Rw53 bp3 bp3__p2 0.05
Rw54 bp3__p1 bp3__p2 0.05
Rw55 bp4 bp4__p1 0.05
Rw56 bp4 bp4__p2 0.05
Rw57 bp4__p1 bp4__p2 0.05
Rw58 bp5 bp5__p1 0.05
Rw59 bp5 bp5__p2 0.05
Rw60 bp5__p1 bp5__p2 0.05
Rw61 bp6 bp6__p1 0.05
Rw62 bp6 bp6__p2 0.05
Rw63 bp6__p1 bp6__p2 0.05
Rw64 bp7 bp7__p2 0.05
Rw65 bp7__p1 bp7__p2 0.05
Rw66 bp8 bp8__p1 0.05
Rw67 bp8 bp8__p2 0.05
Rw68 bp8__p1 bp8__p2 0.05
Rw69 bp9 bp9__p1 0.05
Rw70 bp9 bp9__p2 0.05
Rw71 bp9__p1 bp9__p2 0.05
Rw72 clkb clkb__p1 0.05
Rw73 clkb clkb__p2 0.05
Rw74 clkn clkn__p1 0.05
Rw75 clkn clkn__p2 0.05
Rw76 clkn__p1 clkn__p2 0.05
Rw77 cn0 cn0__p1 0.05
Rw78 cn1 cn1__p1 0.05
Rw79 cn10 cn10__p1 0.05
Rw80 cn11 cn11__p1 0.05
Rw81 cn12 cn12__p1 0.05
Rw82 cn2 cn2__p1 0.05
Rw83 cn3 cn3__p1 0.05
Rw84 cn4 cn4__p1 0.05
Rw85 cn5 cn5__p1 0.05
Rw86 cn6 cn6__p1 0.05
Rw87 cn7 cn7__p1 0.05
Rw88 cn8 cn8__p1 0.05
Rw89 cn9 cn9__p1 0.05
Rw90 cp0 cp0__p1 0.05
Rw91 cp1 cp1__p1 0.05
Rw92 cp10 cp10__p1 0.05
Rw93 cp11 cp11__p1 0.05
Rw94 cp12 cp12__p1 0.05
Rw95 cp2 cp2__p1 0.05
Rw96 cp3 cp3__p1 0.05
Rw97 cp4 cp4__p1 0.05
Rw98 cp5 cp5__p1 0.05
Rw99 cp6 cp6__p1 0.05
Rw100 cp7 cp7__p1 0.05
Rw101 cp8 cp8__p1 0.05
Rw102 cp9 cp9__p1 0.05
Rw103 gnd__i56 gnd__i57 9
Rw104 gnd__i58 gnd__i59 9
Rw105 gnd__i61 gnd__i62 9
Rw106 gnd__i66 gnd__i67 9
Rw107 gnd__i69 gnd__i70 9
Rw108 gnd__i41 gnd__i18 23.6585
Rw109 gnd__i42 gnd__i41 6.05846
Rw110 gnd__i39 gnd__i42 1.32
Rw111 gnd__i40 gnd__i39 1.99692
Rw112 gnd__i16 gnd__i15 1.99692
Rw113 gnd__i17 gnd__i16 3.68923
Rw114 gnd__i28 gnd__i27 1.32
Rw115 gnd__i29 gnd__i28 1.32
Rw116 gnd__i30 gnd__i29 1.32
Rw117 gnd__i31 gnd__i30 1.32
Rw118 gnd__i32 gnd__i31 1.32
Rw119 gnd__i7 gnd__i32 1.32
Rw120 gnd__i8 gnd__i7 1.32
Rw121 gnd__i9 gnd__i8 1.32
Rw122 gnd__i10 gnd__i9 1.32
Rw123 gnd__i11 gnd__i10 1.32
Rw124 gnd__i12 gnd__i11 1.32
Rw125 gnd__i13 gnd__i12 0.643077
Rw126 gnd__i14 gnd__i13 0.643077
Rw127 gnd__i0 gnd__i14 1.32
Rw128 gnd__i35 gnd__i36 1.32
Rw129 gnd__i43 gnd__i44 1.32
Rw130 gnd__i45 gnd__i46 1.32
Rw131 gnd__i45 gnd__i44 1.32
Rw132 gnd__i37 gnd__i36 1.32
Rw133 gnd__i34 gnd__i35 1.32
Rw134 gnd__i47 gnd__i33 1.32
Rw135 gnd__i0 gnd__i43 1.32
Rw136 gnd__i34 gnd__i33 1.32
Rw137 gnd__i47 gnd__i46 1.32
Rw138 gnd__i22 gnd__i21 2.67385
Rw139 gnd__i22 gnd__i23 1.32
Rw140 gnd__i24 gnd__i23 4.02769
Rw141 gnd__i25 gnd__i24 1.32
Rw142 gnd__i48 gnd__i19 0.176
Rw143 gnd__i52 gnd__i73 0.526271
Rw144 gnd__i58 gnd__i53 0.134858
Rw145 gnd__i65 gnd__i63 0.0457844
Rw146 gnd__i64 gnd__p26 0.2464
Rw147 gnd__i72 gnd__p27 0.1408
Rw148 gnd__i56 gnd__i51 0.176
Rw149 gnd__i64 gnd__i63 9
Rw150 gnd__i61 gnd__i63 0.0423898
Rw151 gnd__i68 gnd__i54 9
Rw152 gnd__i66 gnd__i54 0.0653048
Rw153 gnd__i72 gnd__i71 9
Rw154 gnd__i69 gnd__i71 0.0361467
Rw155 gnd__i51 gnd__i57 9
Rw156 gnd__i60 gnd__i59 0.0586667
Rw157 gnd__i53 gnd__i59 9
Rw158 gnd__i63 gnd__i62 9
Rw159 gnd__i65 gnd__i62 9
Rw160 gnd__i64 gnd__i62 0.0352
Rw161 gnd__i68 gnd__i67 0.0432373
Rw162 gnd__i54 gnd__i67 9
Rw163 gnd__i71 gnd__i70 9
Rw164 gnd__i72 gnd__i70 0.0352
Rw165 gnd__i1 gnd__p32 9.10676
Rw166 gnd__i2 gnd__p33 9.07441
Rw167 gnd__i3 gnd__p34 9.10676
Rw168 gnd__i4 gnd__p28 9.06632
Rw169 gnd__i5 gnd__p30 9.06632
Rw170 gnd__i6 gnd__p29 9.07441
Rw171 gnd__i16 gnd__i20 9.88
Rw172 gnd__i19 gnd__p36 9.06632
Rw173 gnd__i20 gnd__p38 9.10676
Rw174 gnd__i26 gnd__i27 10.32
Rw175 gnd__i38 gnd__p48 9.07441
Rw176 gnd__i48 gnd__i73 11.8962
Rw177 gnd__i60 gnd__i53 9.06433
Rw178 gnd__i0 gnd__p14 18.9868
Rw179 gnd__p31 gnd__i54 18.2504
Rw180 gnd__p54 gnd__i22 18.7784
Rw181 gnd__p57 gnd__i25 18.7784
Rw182 gnd__i26 gnd__p0 9.77032
Rw183 gnd__p1 gnd__i27 18.8108
Rw184 gnd__p2 gnd__i28 18.8108
Rw185 gnd__p3 gnd__i29 18.8108
Rw186 gnd__p4 gnd__i30 18.8108
Rw187 gnd__p5 gnd__i31 18.8108
Rw188 gnd__p6 gnd__i32 18.8108
Rw189 gnd__i7 gnd__p7 18.8108
Rw190 gnd__i8 gnd__p8 18.8108
Rw191 gnd__i9 gnd__p9 18.8108
Rw192 gnd__p52 gnd__i53 18.252
Rw193 gnd__i10 gnd__p10 18.9868
Rw194 gnd__i11 gnd__p11 18.9868
Rw195 gnd__i12 gnd__p12 18.9868
Rw196 gnd__i14 gnd__p13 18.9868
Rw197 gnd__i18 gnd__p42 18.3537
Rw198 gnd__p42 gnd__i50 18.9332
Rw199 gnd__i48 gnd__p37 10.2308
Rw200 gnd__i20 gnd__p39 10.4068
Rw201 gnd__p43 gnd__i50 18.2259
Rw202 gnd__i21 gnd__i52 19.1575
Rw203 gnd__p15 gnd__i43 18.9868
Rw204 gnd__p50 gnd__i51 18.3928
Rw205 gnd__i41 gnd__p44 18.6437
Rw206 gnd__p47 gnd__i49 18.2553
Rw207 gnd__p16 gnd__i44 18.8108
Rw208 gnd__p17 gnd__i45 18.8108
Rw209 gnd__p18 gnd__i46 18.8108
Rw210 gnd__p19 gnd__i47 18.8108
Rw211 gnd__i33 gnd__p20 18.8108
Rw212 gnd__i34 gnd__p21 18.8108
Rw213 gnd__i35 gnd__p22 18.8108
Rw214 gnd__i36 gnd__p23 18.8108
Rw215 gnd__i37 gnd__p24 18.8108
Rw216 gnd__i15 gnd 18.297
Rw217 gnd__i39 gnd__p60 18.297
Rw218 gnd__i40 gnd__i49 18.8372
Rw219 gnd__i55 gnd__i38 18.176
Rw220 gnd__i21 gnd__i58 18.5321
Rw221 gnd__i55 gnd__i49 4.69062
Rw222 gnd__p27 gnd__p26 19.4416
Rw223 gnd__i2 gnd__i1 20.5995
Rw224 gnd__i3 gnd__p35 29.5795
Rw225 gnd__i6 gnd__i4 20.745
Rw226 gnd__i5 gnd__i66 29.461
Rw227 gnd__p25 gnd__i37 20.1308
Rw228 gnd__i15 gnd__i19 28.4861
Rw229 gnd__p40 gnd__i17 36.6934
Rw230 gnd__p44 gnd__p45 36.7157
Rw231 gnd__p56 gnd__i24 36.7784
Rw232 gnd__i52 gnd__p51 18.6469
Rw233 gnd__p55 gnd__i23 37.3026
Rw234 gnd__i56 gnd__i55 5.18891
Rw235 gnd__i50 gnd__i13 18.8817
Rw236 gnd__i60 gnd__p53 27.2504
Rw237 gnd__i69 gnd__i68 5.91
Rw238 gnd__i38 gnd__p49 10.4618
Rw239 gnd__p41 gnd__i17 38.4692
Rw240 gnd__p46 gnd__i42 36.8641
Rw241 gnd__i73 gnd__i61 43.007
Rw242 gnd__i65 gnd__i4 30.6571
Rw243 gnd__p59 gnd__i18 38.2905
Rw244 gnd__i26 gnd__i25 47.2623
Rw245 gnd__i1 gnd__i57 74.1862
Rw246 gnd__i5 gnd__i6 80.1772
Rw247 gnd__i3 gnd__i2 80.4342
Rw248 gnd__p61 gnd__i40 36.7352
Rw249 in0n in0n__p0 0.05
Rw250 in0n in0n__p1 0.05
Rw251 in0n__p0 in0n__p1 0.05
Rw252 in0p in0p__p0 0.05
Rw253 in0p in0p__p1 0.05
Rw254 in0p__p0 in0p__p1 0.05
Rw255 in1n in1n__p0 0.05
Rw256 in1n in1n__p1 0.05
Rw257 in1n__p0 in1n__p1 0.05
Rw258 in1p in1p__p0 0.05
Rw259 in1p in1p__p1 0.05
Rw260 in1p__p0 in1p__p1 0.05
Rw261 lsb_n lsb_n__p1 0.05
Rw262 lsb_n__p1 lsb_n__p2 0.05
Rw263 lsb_p lsb_p__p1 0.05
Rw264 lsb_p lsb_p__p2 0.05
Rw265 lsb_p__p1 lsb_p__p2 0.05
Rw266 nr nr__p1 0.05
Rw267 on on__p1 0.05
Rw268 on on__p2 0.05
Rw269 on on__p3 0.05
Rw270 on on__p4 0.05
Rw271 on on__p5 0.05
Rw272 on on__p6 0.05
Rw273 on__p1 on__p2 0.05
Rw274 on__p1 on__p3 0.05
Rw275 on__p1 on__p4 0.05
Rw276 on__p1 on__p5 0.05
Rw277 on__p1 on__p6 0.05
Rw278 on__p2 on__p3 0.05
Rw279 on__p2 on__p4 0.05
Rw280 on__p2 on__p5 0.05
Rw281 on__p2 on__p6 0.05
Rw282 on__p3 on__p4 0.05
Rw283 on__p3 on__p5 0.05
Rw284 on__p3 on__p6 0.05
Rw285 on__p4 on__p5 0.05
Rw286 on__p4 on__p6 0.05
Rw287 on__p5 on__p6 0.05
Rw288 onn onn__p1 0.05
Rw289 onn onn__p2 0.05
Rw290 onn onn__p3 0.05
Rw291 onn onn__p4 0.05
Rw292 onn onn__p5 0.05
Rw293 onn onn__p6 0.05
Rw294 onn__p1 onn__p2 0.05
Rw295 onn__p1 onn__p3 0.05
Rw296 onn__p1 onn__p4 0.05
Rw297 onn__p1 onn__p5 0.05
Rw298 onn__p1 onn__p6 0.05
Rw299 onn__p2 onn__p3 0.05
Rw300 onn__p2 onn__p4 0.05
Rw301 onn__p2 onn__p5 0.05
Rw302 onn__p2 onn__p6 0.05
Rw303 onn__p3 onn__p4 0.05
Rw304 onn__p3 onn__p5 0.05
Rw305 onn__p3 onn__p6 0.05
Rw306 onn__p4 onn__p5 0.05
Rw307 onn__p4 onn__p6 0.05
Rw308 onn__p5 onn__p6 0.05
Rw309 onp onp__p5 0.05
Rw310 onp onp__p6 0.05
Rw311 onp__p1 onp__p2 0.05
Rw312 onp__p2 onp__p3 0.05
Rw313 onp__p3 onp__p4 0.05
Rw314 onp__p3 onp__p5 0.05
Rw315 onp__p4 onp__p5 0.05
Rw316 onp__p5 onp__p6 0.05
Rw317 op op__p1 0.05
Rw318 op__p1 op__p2 0.05
Rw319 op__p2 op__p3 0.05
Rw320 op__p2 op__p4 0.05
Rw321 op__p2 op__p5 0.05
Rw322 op__p3 op__p4 0.05
Rw323 op__p3 op__p5 0.05
Rw324 op__p4 op__p5 0.05
Rw325 op__p5 op__p6 0.05
Rw326 rstb rstb__p1 0.05
Rw327 rstb rstb__p2 0.05
Rw328 rstb rstb__p3 0.05
Rw329 rstb__p1 rstb__p2 0.05
Rw330 rstb__p1 rstb__p3 0.05
Rw331 rstb__p2 rstb__p3 0.05
Rw332 rstb_n rstb_n__p1 0.05
Rw333 rstb_n rstb_n__p3 0.05
Rw334 rstb_n rstb_n__p4 0.05
Rw335 rstb_n__p1 rstb_n__p3 0.05
Rw336 rstb_n__p1 rstb_n__p4 0.05
Rw337 rstb_n__p2 rstb_n__p3 0.05
Rw338 rstb_n__p3 rstb_n__p4 0.05
Rw339 t0 t0__p1 0.05
Rw340 t0 t0__p2 0.05
Rw341 t0 t0__p3 0.05
Rw342 t0 t0__p4 0.05
Rw343 t0 t0__p5 0.05
Rw344 t0__p1 t0__p2 0.05
Rw345 t0__p1 t0__p3 0.05
Rw346 t0__p1 t0__p4 0.05
Rw347 t0__p1 t0__p5 0.05
Rw348 t0__p2 t0__p3 0.05
Rw349 t0__p2 t0__p4 0.05
Rw350 t0__p2 t0__p5 0.05
Rw351 t0__p3 t0__p4 0.05
Rw352 t0__p3 t0__p5 0.05
Rw353 t0__p4 t0__p5 0.05
Rw354 t0b t0b__p1 0.05
Rw355 t0b t0b__p2 0.05
Rw356 t0b t0b__p3 0.05
Rw357 t0b t0b__p4 0.05
Rw358 t0b t0b__p5 0.05
Rw359 t0b t0b__p6 0.05
Rw360 t0b t0b__p7 0.05
Rw361 t0b t0b__p8 0.05
Rw362 t0b t0b__p9 0.05
Rw363 t0b__p1 t0b__p2 0.05
Rw364 t0b__p1 t0b__p3 0.05
Rw365 t0b__p1 t0b__p4 0.05
Rw366 t0b__p1 t0b__p5 0.05
Rw367 t0b__p1 t0b__p6 0.05
Rw368 t0b__p1 t0b__p7 0.05
Rw369 t0b__p1 t0b__p8 0.05
Rw370 t0b__p1 t0b__p9 0.05
Rw371 t0b__p2 t0b__p3 0.05
Rw372 t0b__p2 t0b__p4 0.05
Rw373 t0b__p2 t0b__p5 0.05
Rw374 t0b__p2 t0b__p6 0.05
Rw375 t0b__p2 t0b__p7 0.05
Rw376 t0b__p2 t0b__p8 0.05
Rw377 t0b__p2 t0b__p9 0.05
Rw378 t0b__p3 t0b__p4 0.05
Rw379 t0b__p3 t0b__p5 0.05
Rw380 t0b__p3 t0b__p6 0.05
Rw381 t0b__p3 t0b__p7 0.05
Rw382 t0b__p3 t0b__p8 0.05
Rw383 t0b__p3 t0b__p9 0.05
Rw384 t0b__p4 t0b__p5 0.05
Rw385 t0b__p4 t0b__p6 0.05
Rw386 t0b__p4 t0b__p7 0.05
Rw387 t0b__p4 t0b__p8 0.05
Rw388 t0b__p4 t0b__p9 0.05
Rw389 t0b__p5 t0b__p6 0.05
Rw390 t0b__p5 t0b__p7 0.05
Rw391 t0b__p5 t0b__p8 0.05
Rw392 t0b__p5 t0b__p9 0.05
Rw393 t0b__p6 t0b__p7 0.05
Rw394 t0b__p6 t0b__p8 0.05
Rw395 t0b__p6 t0b__p9 0.05
Rw396 t0b__p7 t0b__p8 0.05
Rw397 t0b__p7 t0b__p9 0.05
Rw398 t0b__p8 t0b__p9 0.05
Rw399 t1 t1__p1 0.05
Rw400 t1 t1__p2 0.05
Rw401 t1 t1__p3 0.05
Rw402 t1 t1__p4 0.05
Rw403 t1 t1__p5 0.05
Rw404 t1__p1 t1__p2 0.05
Rw405 t1__p1 t1__p3 0.05
Rw406 t1__p1 t1__p4 0.05
Rw407 t1__p1 t1__p5 0.05
Rw408 t1__p2 t1__p3 0.05
Rw409 t1__p2 t1__p4 0.05
Rw410 t1__p2 t1__p5 0.05
Rw411 t1__p3 t1__p4 0.05
Rw412 t1__p3 t1__p5 0.05
Rw413 t1__p4 t1__p5 0.05
Rw414 t1b t1b__p1 0.05
Rw415 t1b t1b__p2 0.05
Rw416 t1b t1b__p3 0.05
Rw417 t1b t1b__p4 0.05
Rw418 t1b t1b__p5 0.05
Rw419 t1b t1b__p6 0.05
Rw420 t1b t1b__p7 0.05
Rw421 t1b t1b__p8 0.05
Rw422 t1b t1b__p9 0.05
Rw423 t1b__p1 t1b__p2 0.05
Rw424 t1b__p1 t1b__p3 0.05
Rw425 t1b__p1 t1b__p4 0.05
Rw426 t1b__p1 t1b__p5 0.05
Rw427 t1b__p1 t1b__p6 0.05
Rw428 t1b__p1 t1b__p7 0.05
Rw429 t1b__p1 t1b__p8 0.05
Rw430 t1b__p1 t1b__p9 0.05
Rw431 t1b__p2 t1b__p3 0.05
Rw432 t1b__p2 t1b__p4 0.05
Rw433 t1b__p2 t1b__p5 0.05
Rw434 t1b__p2 t1b__p6 0.05
Rw435 t1b__p2 t1b__p7 0.05
Rw436 t1b__p2 t1b__p8 0.05
Rw437 t1b__p2 t1b__p9 0.05
Rw438 t1b__p3 t1b__p4 0.05
Rw439 t1b__p3 t1b__p5 0.05
Rw440 t1b__p3 t1b__p6 0.05
Rw441 t1b__p3 t1b__p7 0.05
Rw442 t1b__p3 t1b__p8 0.05
Rw443 t1b__p3 t1b__p9 0.05
Rw444 t1b__p4 t1b__p5 0.05
Rw445 t1b__p4 t1b__p6 0.05
Rw446 t1b__p4 t1b__p7 0.05
Rw447 t1b__p4 t1b__p8 0.05
Rw448 t1b__p4 t1b__p9 0.05
Rw449 t1b__p5 t1b__p6 0.05
Rw450 t1b__p5 t1b__p7 0.05
Rw451 t1b__p5 t1b__p8 0.05
Rw452 t1b__p5 t1b__p9 0.05
Rw453 t1b__p6 t1b__p7 0.05
Rw454 t1b__p6 t1b__p8 0.05
Rw455 t1b__p6 t1b__p9 0.05
Rw456 t1b__p7 t1b__p8 0.05
Rw457 t1b__p7 t1b__p9 0.05
Rw458 t1b__p8 t1b__p9 0.05
Rw459 top_n top_n__p1 0.05
Rw460 top_n top_n__p2 0.05
Rw461 top_n__p1 top_n__p3 0.05
Rw462 top_n__p1 top_n__p4 0.05
Rw463 top_n__p3 top_n__p4 0.05
Rw464 top_p top_p__p1 0.05
Rw465 top_p top_p__p2 0.05
Rw466 top_p__p1 top_p__p3 0.05
Rw467 top_p__p1 top_p__p4 0.05
Rw468 top_p__p3 top_p__p4 0.05
Rw469 trk0 trk0__p1 0.05
Rw470 trk1 trk1__p1 0.05
Rw471 vdd vdd__p0 1128.17
Rw472 vdd vdd__p1 6542.79
Rw473 vdd vdd__p12 579.864
Rw474 vdd vdd__p13 587.318
Rw475 vdd vdd__p14 488.524
Rw476 vdd vdd__p15 423.646
Rw477 vdd vdd__p16 530.358
Rw478 vdd vdd__p17 149.629
Rw479 vdd vdd__p18 523.887
Rw480 vdd vdd__p2 1479.67
Rw481 vdd vdd__p22 158311
Rw482 vdd vdd__p24 413711
Rw483 vdd vdd__p26 2783.8
Rw484 vdd vdd__p27 3153.48
Rw485 vdd vdd__p28 3665.91
Rw486 vdd vdd__p29 16793.6
Rw487 vdd vdd__p3 7274.07
Rw488 vdd vdd__p30 15673.8
Rw489 vdd vdd__p31 16142.5
Rw490 vdd vdd__p32 7837.98
Rw491 vdd vdd__p33 8698.5
Rw492 vdd vdd__p34 15889.1
Rw493 vdd vdd__p36 5717.06
Rw494 vdd vdd__p4 38407.9
Rw495 vdd vdd__p5 7551.45
Rw496 vdd__p0 vdd__p1 488.136
Rw497 vdd__p0 vdd__p12 559.684
Rw498 vdd__p0 vdd__p13 566.879
Rw499 vdd__p0 vdd__p14 195.668
Rw500 vdd__p0 vdd__p15 423.921
Rw501 vdd__p0 vdd__p16 559.199
Rw502 vdd__p0 vdd__p17 515.704
Rw503 vdd__p0 vdd__p18 572.84
Rw504 vdd__p0 vdd__p2 110.394
Rw505 vdd__p0 vdd__p22 173104
Rw506 vdd__p0 vdd__p24 452370
Rw507 vdd__p0 vdd__p26 3043.92
Rw508 vdd__p0 vdd__p27 3448.15
Rw509 vdd__p0 vdd__p28 4008.46
Rw510 vdd__p0 vdd__p29 18362.8
Rw511 vdd__p0 vdd__p3 542.694
Rw512 vdd__p0 vdd__p30 17138.4
Rw513 vdd__p0 vdd__p31 17650.9
Rw514 vdd__p0 vdd__p32 8570.38
Rw515 vdd__p0 vdd__p33 9511.31
Rw516 vdd__p0 vdd__p34 17373.8
Rw517 vdd__p0 vdd__p36 6251.28
Rw518 vdd__p0 vdd__p4 2865.49
Rw519 vdd__p0 vdd__p5 563.388
Rw520 vdd__p1 vdd__p12 3245.88
Rw521 vdd__p1 vdd__p13 3287.61
Rw522 vdd__p1 vdd__p14 1134.77
Rw523 vdd__p1 vdd__p15 2458.52
Rw524 vdd__p1 vdd__p16 3243.07
Rw525 vdd__p1 vdd__p17 2990.81
Rw526 vdd__p1 vdd__p18 3322.17
Rw527 vdd__p1 vdd__p2 87.741
Rw528 vdd__p1 vdd__p26 17653.2
Rw529 vdd__p1 vdd__p27 19997.5
Rw530 vdd__p1 vdd__p28 23247
Rw531 vdd__p1 vdd__p29 106495
Rw532 vdd__p1 vdd__p3 431.334
Rw533 vdd__p1 vdd__p30 99393.7
Rw534 vdd__p1 vdd__p31 102366
Rw535 vdd__p1 vdd__p32 49703.8
Rw536 vdd__p1 vdd__p33 55160.7
Rw537 vdd__p1 vdd__p34 100759
Rw538 vdd__p1 vdd__p36 36254.2
Rw539 vdd__p1 vdd__p4 2277.49
Rw540 vdd__p1 vdd__p5 447.782
Rw541 vdd__p10 vdd__p11 198.01
Rw542 vdd__p10 vdd__p19 2703.76
Rw543 vdd__p10 vdd__p20 2272.22
Rw544 vdd__p10 vdd__p21 2204.75
Rw545 vdd__p10 vdd__p37 14886.3
Rw546 vdd__p10 vdd__p38 7412.43
Rw547 vdd__p10 vdd__p6 848.157
Rw548 vdd__p10 vdd__p7 237.718
Rw549 vdd__p10 vdd__p8 165.889
Rw550 vdd__p10 vdd__p9 71.7262
Rw551 vdd__p11 vdd__p19 3178.78
Rw552 vdd__p11 vdd__p20 2671.43
Rw553 vdd__p11 vdd__p21 2592.1
Rw554 vdd__p11 vdd__p37 17501.7
Rw555 vdd__p11 vdd__p38 8714.73
Rw556 vdd__p11 vdd__p6 997.172
Rw557 vdd__p11 vdd__p7 279.483
Rw558 vdd__p11 vdd__p8 195.035
Rw559 vdd__p11 vdd__p9 153.835
Rw560 vdd__p12 vdd__p13 239.958
Rw561 vdd__p12 vdd__p14 242.16
Rw562 vdd__p12 vdd__p15 220.492
Rw563 vdd__p12 vdd__p16 284.828
Rw564 vdd__p12 vdd__p17 265.065
Rw565 vdd__p12 vdd__p18 294.432
Rw566 vdd__p12 vdd__p2 734.066
Rw567 vdd__p12 vdd__p22 88973.1
Rw568 vdd__p12 vdd__p24 232512
Rw569 vdd__p12 vdd__p26 1564.53
Rw570 vdd__p12 vdd__p27 1772.3
Rw571 vdd__p12 vdd__p28 2060.29
Rw572 vdd__p12 vdd__p29 9438.25
Rw573 vdd__p12 vdd__p3 3608.66
Rw574 vdd__p12 vdd__p30 8808.9
Rw575 vdd__p12 vdd__p31 9072.33
Rw576 vdd__p12 vdd__p32 4405.06
Rw577 vdd__p12 vdd__p33 4888.69
Rw578 vdd__p12 vdd__p34 8929.88
Rw579 vdd__p12 vdd__p36 3213.07
Rw580 vdd__p12 vdd__p37 640470
Rw581 vdd__p12 vdd__p4 19054.2
Rw582 vdd__p12 vdd__p5 3746.27
Rw583 vdd__p13 vdd__p14 245.274
Rw584 vdd__p13 vdd__p15 223.327
Rw585 vdd__p13 vdd__p16 288.49
Rw586 vdd__p13 vdd__p17 268.472
Rw587 vdd__p13 vdd__p18 298.217
Rw588 vdd__p13 vdd__p2 743.503
Rw589 vdd__p13 vdd__p22 90116.9
Rw590 vdd__p13 vdd__p24 235501
Rw591 vdd__p13 vdd__p26 1584.65
Rw592 vdd__p13 vdd__p27 1795.09
Rw593 vdd__p13 vdd__p28 2086.78
Rw594 vdd__p13 vdd__p29 9559.58
Rw595 vdd__p13 vdd__p3 3655.06
Rw596 vdd__p13 vdd__p30 8922.15
Rw597 vdd__p13 vdd__p31 9188.96
Rw598 vdd__p13 vdd__p32 4461.69
Rw599 vdd__p13 vdd__p33 4951.54
Rw600 vdd__p13 vdd__p34 9044.68
Rw601 vdd__p13 vdd__p36 3254.38
Rw602 vdd__p13 vdd__p37 648703
Rw603 vdd__p13 vdd__p4 19299.1
Rw604 vdd__p13 vdd__p5 3794.43
Rw605 vdd__p14 vdd__p15 183.605
Rw606 vdd__p14 vdd__p16 242.108
Rw607 vdd__p14 vdd__p17 223.312
Rw608 vdd__p14 vdd__p18 248.053
Rw609 vdd__p14 vdd__p2 256.632
Rw610 vdd__p14 vdd__p22 74958.1
Rw611 vdd__p14 vdd__p24 195887
Rw612 vdd__p14 vdd__p26 1318.09
Rw613 vdd__p14 vdd__p27 1493.13
Rw614 vdd__p14 vdd__p28 1735.76
Rw615 vdd__p14 vdd__p29 7951.54
Rw616 vdd__p14 vdd__p3 1261.6
Rw617 vdd__p14 vdd__p30 7421.33
Rw618 vdd__p14 vdd__p31 7643.26
Rw619 vdd__p14 vdd__p32 3711.18
Rw620 vdd__p14 vdd__p33 4118.63
Rw621 vdd__p14 vdd__p34 7523.26
Rw622 vdd__p14 vdd__p36 2706.95
Rw623 vdd__p14 vdd__p37 539583
Rw624 vdd__p14 vdd__p4 6661.41
Rw625 vdd__p14 vdd__p5 1309.71
Rw626 vdd__p15 vdd__p16 209.959
Rw627 vdd__p15 vdd__p17 193.655
Rw628 vdd__p15 vdd__p18 215.111
Rw629 vdd__p15 vdd__p2 556.003
Rw630 vdd__p15 vdd__p22 65003.3
Rw631 vdd__p15 vdd__p24 169872
Rw632 vdd__p15 vdd__p26 1143.04
Rw633 vdd__p15 vdd__p27 1294.84
Rw634 vdd__p15 vdd__p28 1505.24
Rw635 vdd__p15 vdd__p29 6895.54
Rw636 vdd__p15 vdd__p3 2733.31
Rw637 vdd__p15 vdd__p30 6435.75
Rw638 vdd__p15 vdd__p31 6628.2
Rw639 vdd__p15 vdd__p32 3218.32
Rw640 vdd__p15 vdd__p33 3571.65
Rw641 vdd__p15 vdd__p34 6524.13
Rw642 vdd__p15 vdd__p36 2347.46
Rw643 vdd__p15 vdd__p37 467924
Rw644 vdd__p15 vdd__p4 14432.2
Rw645 vdd__p15 vdd__p5 2837.53
Rw646 vdd__p16 vdd__p17 242.435
Rw647 vdd__p16 vdd__p18 269.295
Rw648 vdd__p16 vdd__p2 733.43
Rw649 vdd__p16 vdd__p22 81377
Rw650 vdd__p16 vdd__p24 212661
Rw651 vdd__p16 vdd__p26 1430.96
Rw652 vdd__p16 vdd__p27 1620.99
Rw653 vdd__p16 vdd__p28 1884.4
Rw654 vdd__p16 vdd__p29 8632.46
Rw655 vdd__p16 vdd__p3 3605.54
Rw656 vdd__p16 vdd__p30 8056.84
Rw657 vdd__p16 vdd__p31 8297.78
Rw658 vdd__p16 vdd__p32 4028.98
Rw659 vdd__p16 vdd__p33 4471.32
Rw660 vdd__p16 vdd__p34 8167.5
Rw661 vdd__p16 vdd__p36 2938.76
Rw662 vdd__p16 vdd__p37 585789
Rw663 vdd__p16 vdd__p4 19037.7
Rw664 vdd__p16 vdd__p5 3743.03
Rw665 vdd__p17 vdd__p18 239.477
Rw666 vdd__p17 vdd__p2 676.382
Rw667 vdd__p17 vdd__p22 72366.4
Rw668 vdd__p17 vdd__p24 189114
Rw669 vdd__p17 vdd__p26 1272.52
Rw670 vdd__p17 vdd__p27 1441.51
Rw671 vdd__p17 vdd__p28 1675.74
Rw672 vdd__p17 vdd__p29 7676.61
Rw673 vdd__p17 vdd__p3 3325.09
Rw674 vdd__p17 vdd__p30 7164.74
Rw675 vdd__p17 vdd__p31 7379
Rw676 vdd__p17 vdd__p32 3582.87
Rw677 vdd__p17 vdd__p33 3976.22
Rw678 vdd__p17 vdd__p34 7263.14
Rw679 vdd__p17 vdd__p36 2613.36
Rw680 vdd__p17 vdd__p37 520927
Rw681 vdd__p17 vdd__p4 17556.9
Rw682 vdd__p17 vdd__p5 3451.89
Rw683 vdd__p18 vdd__p2 751.32
Rw684 vdd__p18 vdd__p22 74930.6
Rw685 vdd__p18 vdd__p24 195815
Rw686 vdd__p18 vdd__p26 1317.61
Rw687 vdd__p18 vdd__p27 1492.58
Rw688 vdd__p18 vdd__p28 1735.12
Rw689 vdd__p18 vdd__p29 7948.63
Rw690 vdd__p18 vdd__p3 3693.49
Rw691 vdd__p18 vdd__p30 7418.61
Rw692 vdd__p18 vdd__p31 7640.46
Rw693 vdd__p18 vdd__p32 3709.82
Rw694 vdd__p18 vdd__p33 4117.12
Rw695 vdd__p18 vdd__p34 7520.5
Rw696 vdd__p18 vdd__p36 2705.96
Rw697 vdd__p18 vdd__p37 539385
Rw698 vdd__p18 vdd__p4 19502
Rw699 vdd__p18 vdd__p5 3834.33
Rw700 vdd__p19 vdd__p20 110.662
Rw701 vdd__p19 vdd__p21 111.26
Rw702 vdd__p19 vdd__p22 343264
Rw703 vdd__p19 vdd__p24 128178
Rw704 vdd__p19 vdd__p37 319.309
Rw705 vdd__p19 vdd__p38 158.995
Rw706 vdd__p19 vdd__p6 238.054
Rw707 vdd__p19 vdd__p7 1977.51
Rw708 vdd__p19 vdd__p8 282.044
Rw709 vdd__p19 vdd__p9 2100.55
Rw710 vdd__p2 vdd__p22 227038
Rw711 vdd__p2 vdd__p24 593315
Rw712 vdd__p2 vdd__p26 3992.32
Rw713 vdd__p2 vdd__p27 4522.5
Rw714 vdd__p2 vdd__p28 5257.38
Rw715 vdd__p2 vdd__p29 24084.2
Rw716 vdd__p2 vdd__p3 93.6757
Rw717 vdd__p2 vdd__p30 22478.2
Rw718 vdd__p2 vdd__p31 23150.4
Rw719 vdd__p2 vdd__p32 11240.7
Rw720 vdd__p2 vdd__p33 12474.8
Rw721 vdd__p2 vdd__p34 22786.9
Rw722 vdd__p2 vdd__p36 8199
Rw723 vdd__p2 vdd__p4 494.619
Rw724 vdd__p2 vdd__p5 97.2478
Rw725 vdd__p20 vdd__p21 93.5025
Rw726 vdd__p20 vdd__p22 654994
Rw727 vdd__p20 vdd__p24 244581
Rw728 vdd__p20 vdd__p37 609.284
Rw729 vdd__p20 vdd__p38 303.384
Rw730 vdd__p20 vdd__p6 200.06
Rw731 vdd__p20 vdd__p7 1661.89
Rw732 vdd__p20 vdd__p8 237.029
Rw733 vdd__p20 vdd__p9 1765.29
Rw734 vdd__p21 vdd__p22 658533
Rw735 vdd__p21 vdd__p24 245903
Rw736 vdd__p21 vdd__p37 612.576
Rw737 vdd__p21 vdd__p38 305.023
Rw738 vdd__p21 vdd__p6 194.119
Rw739 vdd__p21 vdd__p7 1612.54
Rw740 vdd__p21 vdd__p8 229.99
Rw741 vdd__p21 vdd__p9 1712.87
Rw742 vdd__p22 vdd__p23 21.6962
Rw743 vdd__p22 vdd__p24 91.8193
Rw744 vdd__p22 vdd__p25 144132
Rw745 vdd__p22 vdd__p26 12383.9
Rw746 vdd__p22 vdd__p27 11313.5
Rw747 vdd__p22 vdd__p28 9951.71
Rw748 vdd__p22 vdd__p29 343.466
Rw749 vdd__p22 vdd__p30 288.306
Rw750 vdd__p22 vdd__p31 330.15
Rw751 vdd__p22 vdd__p32 7784.47
Rw752 vdd__p22 vdd__p33 8639.11
Rw753 vdd__p22 vdd__p34 15780.6
Rw754 vdd__p22 vdd__p36 5678.03
Rw755 vdd__p22 vdd__p37 252.922
Rw756 vdd__p22 vdd__p38 100653
Rw757 vdd__p24 vdd__p25 21.921
Rw758 vdd__p24 vdd__p26 32362.6
Rw759 vdd__p24 vdd__p27 29565.5
Rw760 vdd__p24 vdd__p28 26006.6
Rw761 vdd__p24 vdd__p29 897.575
Rw762 vdd__p24 vdd__p30 753.425
Rw763 vdd__p24 vdd__p31 862.776
Rw764 vdd__p24 vdd__p32 20343
Rw765 vdd__p24 vdd__p33 22576.5
Rw766 vdd__p24 vdd__p34 41239.1
Rw767 vdd__p24 vdd__p36 14838.3
Rw768 vdd__p24 vdd__p37 94.4436
Rw769 vdd__p24 vdd__p38 37584.9
Rw770 vdd__p24 vdd__p6 526137
Rw771 vdd__p24 vdd__p8 623362
Rw772 vdd__p25 vdd__p37 148252
Rw773 vdd__p26 vdd__p27 246.681
Rw774 vdd__p26 vdd__p28 286.766
Rw775 vdd__p26 vdd__p29 1313.68
Rw776 vdd__p26 vdd__p3 19626.2
Rw777 vdd__p26 vdd__p30 1226.08
Rw778 vdd__p26 vdd__p31 1262.75
Rw779 vdd__p26 vdd__p32 613.127
Rw780 vdd__p26 vdd__p33 680.441
Rw781 vdd__p26 vdd__p34 1242.92
Rw782 vdd__p26 vdd__p36 447.218
Rw783 vdd__p26 vdd__p37 89144.9
Rw784 vdd__p26 vdd__p4 103629
Rw785 vdd__p26 vdd__p5 20374.6
Rw786 vdd__p27 vdd__p28 261.981
Rw787 vdd__p27 vdd__p29 1200.14
Rw788 vdd__p27 vdd__p3 22232.6
Rw789 vdd__p27 vdd__p30 1120.11
Rw790 vdd__p27 vdd__p31 1153.61
Rw791 vdd__p27 vdd__p32 560.134
Rw792 vdd__p27 vdd__p33 621.63
Rw793 vdd__p27 vdd__p34 1135.5
Rw794 vdd__p27 vdd__p36 408.564
Rw795 vdd__p27 vdd__p37 81440.1
Rw796 vdd__p27 vdd__p4 117391
Rw797 vdd__p27 vdd__p5 23080.4
Rw798 vdd__p28 vdd__p29 1055.68
Rw799 vdd__p28 vdd__p3 25845.3
Rw800 vdd__p28 vdd__p30 985.282
Rw801 vdd__p28 vdd__p31 1014.75
Rw802 vdd__p28 vdd__p32 492.71
Rw803 vdd__p28 vdd__p33 546.803
Rw804 vdd__p28 vdd__p34 998.814
Rw805 vdd__p28 vdd__p36 359.385
Rw806 vdd__p28 vdd__p37 71637
Rw807 vdd__p28 vdd__p4 136466
Rw808 vdd__p28 vdd__p5 26830.8
Rw809 vdd__p29 vdd__p3 118398
Rw810 vdd__p29 vdd__p30 34.0053
Rw811 vdd__p29 vdd__p31 35.0223
Rw812 vdd__p29 vdd__p32 825.775
Rw813 vdd__p29 vdd__p33 916.435
Rw814 vdd__p29 vdd__p34 1674
Rw815 vdd__p29 vdd__p36 602.324
Rw816 vdd__p29 vdd__p37 2472.43
Rw817 vdd__p29 vdd__p38 983930
Rw818 vdd__p29 vdd__p4 625153
Rw819 vdd__p29 vdd__p5 122912
Rw820 vdd__p3 vdd__p30 110503
Rw821 vdd__p3 vdd__p31 113807
Rw822 vdd__p3 vdd__p32 55259.1
Rw823 vdd__p3 vdd__p33 61325.9
Rw824 vdd__p3 vdd__p34 112020
Rw825 vdd__p3 vdd__p36 40306.2
Rw826 vdd__p3 vdd__p4 372.752
Rw827 vdd__p3 vdd__p5 73.2874
Rw828 vdd__p30 vdd__p31 32.687
Rw829 vdd__p30 vdd__p32 770.712
Rw830 vdd__p30 vdd__p33 855.327
Rw831 vdd__p30 vdd__p34 1562.38
Rw832 vdd__p30 vdd__p36 562.161
Rw833 vdd__p30 vdd__p37 2075.36
Rw834 vdd__p30 vdd__p38 825911
Rw835 vdd__p30 vdd__p4 583468
Rw836 vdd__p30 vdd__p5 114717
Rw837 vdd__p31 vdd__p32 793.76
Rw838 vdd__p31 vdd__p33 880.905
Rw839 vdd__p31 vdd__p34 1609.1
Rw840 vdd__p31 vdd__p36 578.972
Rw841 vdd__p31 vdd__p37 2376.57
Rw842 vdd__p31 vdd__p38 945783
Rw843 vdd__p31 vdd__p4 600916
Rw844 vdd__p31 vdd__p5 118147
Rw845 vdd__p32 vdd__p33 267.069
Rw846 vdd__p32 vdd__p34 487.84
Rw847 vdd__p32 vdd__p36 175.53
Rw848 vdd__p32 vdd__p37 56036.2
Rw849 vdd__p32 vdd__p4 291774
Rw850 vdd__p32 vdd__p5 57366.2
Rw851 vdd__p33 vdd__p34 428.838
Rw852 vdd__p33 vdd__p36 154.301
Rw853 vdd__p33 vdd__p37 62188.3
Rw854 vdd__p33 vdd__p4 323808
Rw855 vdd__p33 vdd__p5 63664.4
Rw856 vdd__p34 vdd__p36 52.9087
Rw857 vdd__p34 vdd__p37 113596
Rw858 vdd__p34 vdd__p4 591481
Rw859 vdd__p34 vdd__p5 116292
Rw860 vdd__p36 vdd__p37 40873.1
Rw861 vdd__p36 vdd__p4 212822
Rw862 vdd__p36 vdd__p5 41843.2
Rw863 vdd__p37 vdd__p38 93.6289
Rw864 vdd__p37 vdd__p6 1310.68
Rw865 vdd__p37 vdd__p7 10887.8
Rw866 vdd__p37 vdd__p8 1552.88
Rw867 vdd__p37 vdd__p9 11565.2
Rw868 vdd__p38 vdd__p6 652.633
Rw869 vdd__p38 vdd__p7 5421.41
Rw870 vdd__p38 vdd__p8 773.233
Rw871 vdd__p38 vdd__p9 5758.72
Rw872 vdd__p4 vdd__p5 76.5135
Rw873 vdd__p6 vdd__p7 620.338
Rw874 vdd__p6 vdd__p8 88.4762
Rw875 vdd__p6 vdd__p9 658.934
Rw876 vdd__p7 vdd__p8 121.331
Rw877 vdd__p7 vdd__p9 184.683
Rw878 vdd__p8 vdd__p9 128.88
Rw879 vref vref__p0 0.05
Rw880 vref vref__p1 0.05
Rw881 vref vref__p2 0.05
Rw882 vref vref__p3 0.05
Rw883 vref vref__p4 0.05
Rw884 vref vref__p5 0.05
Rw885 vref vref__p6 0.05
Rw886 vref vref__p7 0.05
Rw887 vref vref__p8 0.05
Rw888 vref vref__p9 0.05
Rw889 vref__p0 vref__p1 0.05
Rw890 vref__p0 vref__p2 0.05
Rw891 vref__p0 vref__p3 0.05
Rw892 vref__p0 vref__p4 0.05
Rw893 vref__p0 vref__p5 0.05
Rw894 vref__p0 vref__p6 0.05
Rw895 vref__p0 vref__p7 0.05
Rw896 vref__p0 vref__p8 0.05
Rw897 vref__p0 vref__p9 0.05
Rw898 vref__p1 vref__p2 0.05
Rw899 vref__p1 vref__p3 0.05
Rw900 vref__p1 vref__p4 0.05
Rw901 vref__p1 vref__p5 0.05
Rw902 vref__p1 vref__p6 0.05
Rw903 vref__p1 vref__p7 0.05
Rw904 vref__p1 vref__p8 0.05
Rw905 vref__p1 vref__p9 0.05
Rw906 vref__p2 vref__p3 0.05
Rw907 vref__p2 vref__p4 0.05
Rw908 vref__p2 vref__p5 0.05
Rw909 vref__p2 vref__p6 0.05
Rw910 vref__p2 vref__p7 0.05
Rw911 vref__p2 vref__p8 0.05
Rw912 vref__p2 vref__p9 0.05
Rw913 vref__p3 vref__p4 0.05
Rw914 vref__p3 vref__p5 0.05
Rw915 vref__p3 vref__p6 0.05
Rw916 vref__p3 vref__p7 0.05
Rw917 vref__p3 vref__p8 0.05
Rw918 vref__p3 vref__p9 0.05
Rw919 vref__p4 vref__p5 0.05
Rw920 vref__p4 vref__p6 0.05
Rw921 vref__p4 vref__p7 0.05
Rw922 vref__p4 vref__p8 0.05
Rw923 vref__p4 vref__p9 0.05
Rw924 vref__p5 vref__p6 0.05
Rw925 vref__p5 vref__p7 0.05
Rw926 vref__p5 vref__p8 0.05
Rw927 vref__p5 vref__p9 0.05
Rw928 vref__p6 vref__p7 0.05
Rw929 vref__p6 vref__p8 0.05
Rw930 vref__p6 vref__p9 0.05
Rw931 vref__p7 vref__p8 0.05
Rw932 vref__p7 vref__p9 0.05
Rw933 vref__p8 vref__p9 0.05
Rw934 vrefl vrefl__p0 0.05
Rw935 vrefl vrefl__p1 0.05
Rw936 vrefl vrefl__p10 0.05
Rw937 vrefl vrefl__p11 0.05
Rw938 vrefl vrefl__p12 0.05
Rw939 vrefl vrefl__p13 0.05
Rw940 vrefl vrefl__p14 0.05
Rw941 vrefl vrefl__p15 0.05
Rw942 vrefl vrefl__p16 0.05
Rw943 vrefl vrefl__p17 0.05
Rw944 vrefl vrefl__p19 0.05
Rw945 vrefl vrefl__p2 0.05
Rw946 vrefl vrefl__p3 0.05
Rw947 vrefl vrefl__p4 0.05
Rw948 vrefl vrefl__p5 0.05
Rw949 vrefl vrefl__p6 0.05
Rw950 vrefl vrefl__p7 0.05
Rw951 vrefl vrefl__p8 0.05
Rw952 vrefl vrefl__p9 0.05
Rw953 vrefl__p0 vrefl__p1 0.05
Rw954 vrefl__p0 vrefl__p10 0.05
Rw955 vrefl__p0 vrefl__p11 0.05
Rw956 vrefl__p0 vrefl__p12 0.05
Rw957 vrefl__p0 vrefl__p13 0.05
Rw958 vrefl__p0 vrefl__p14 0.05
Rw959 vrefl__p0 vrefl__p15 0.05
Rw960 vrefl__p0 vrefl__p16 0.05
Rw961 vrefl__p0 vrefl__p17 0.05
Rw962 vrefl__p0 vrefl__p19 0.05
Rw963 vrefl__p0 vrefl__p2 0.05
Rw964 vrefl__p0 vrefl__p3 0.05
Rw965 vrefl__p0 vrefl__p4 0.05
Rw966 vrefl__p0 vrefl__p5 0.05
Rw967 vrefl__p0 vrefl__p6 0.05
Rw968 vrefl__p0 vrefl__p7 0.05
Rw969 vrefl__p0 vrefl__p8 0.05
Rw970 vrefl__p0 vrefl__p9 0.05
Rw971 vrefl__p1 vrefl__p10 0.05
Rw972 vrefl__p1 vrefl__p11 0.05
Rw973 vrefl__p1 vrefl__p12 0.05
Rw974 vrefl__p1 vrefl__p13 0.05
Rw975 vrefl__p1 vrefl__p14 0.05
Rw976 vrefl__p1 vrefl__p15 0.05
Rw977 vrefl__p1 vrefl__p16 0.05
Rw978 vrefl__p1 vrefl__p17 0.05
Rw979 vrefl__p1 vrefl__p19 0.05
Rw980 vrefl__p1 vrefl__p2 0.05
Rw981 vrefl__p1 vrefl__p3 0.05
Rw982 vrefl__p1 vrefl__p4 0.05
Rw983 vrefl__p1 vrefl__p5 0.05
Rw984 vrefl__p1 vrefl__p6 0.05
Rw985 vrefl__p1 vrefl__p7 0.05
Rw986 vrefl__p1 vrefl__p8 0.05
Rw987 vrefl__p1 vrefl__p9 0.05
Rw988 vrefl__p10 vrefl__p11 0.05
Rw989 vrefl__p10 vrefl__p12 0.05
Rw990 vrefl__p10 vrefl__p13 0.05
Rw991 vrefl__p10 vrefl__p14 0.05
Rw992 vrefl__p10 vrefl__p15 0.05
Rw993 vrefl__p10 vrefl__p16 0.05
Rw994 vrefl__p10 vrefl__p17 0.05
Rw995 vrefl__p10 vrefl__p19 0.05
Rw996 vrefl__p10 vrefl__p2 0.05
Rw997 vrefl__p10 vrefl__p3 0.05
Rw998 vrefl__p10 vrefl__p4 0.05
Rw999 vrefl__p10 vrefl__p5 0.05
Rw1000 vrefl__p10 vrefl__p6 0.05
Rw1001 vrefl__p10 vrefl__p7 0.05
Rw1002 vrefl__p10 vrefl__p8 0.05
Rw1003 vrefl__p10 vrefl__p9 0.05
Rw1004 vrefl__p11 vrefl__p12 0.05
Rw1005 vrefl__p11 vrefl__p13 0.05
Rw1006 vrefl__p11 vrefl__p14 0.05
Rw1007 vrefl__p11 vrefl__p15 0.05
Rw1008 vrefl__p11 vrefl__p16 0.05
Rw1009 vrefl__p11 vrefl__p17 0.05
Rw1010 vrefl__p11 vrefl__p19 0.05
Rw1011 vrefl__p11 vrefl__p2 0.05
Rw1012 vrefl__p11 vrefl__p3 0.05
Rw1013 vrefl__p11 vrefl__p4 0.05
Rw1014 vrefl__p11 vrefl__p5 0.05
Rw1015 vrefl__p11 vrefl__p6 0.05
Rw1016 vrefl__p11 vrefl__p7 0.05
Rw1017 vrefl__p11 vrefl__p8 0.05
Rw1018 vrefl__p11 vrefl__p9 0.05
Rw1019 vrefl__p12 vrefl__p13 0.05
Rw1020 vrefl__p12 vrefl__p14 0.05
Rw1021 vrefl__p12 vrefl__p15 0.05
Rw1022 vrefl__p12 vrefl__p16 0.05
Rw1023 vrefl__p12 vrefl__p17 0.05
Rw1024 vrefl__p12 vrefl__p19 0.05
Rw1025 vrefl__p12 vrefl__p2 0.05
Rw1026 vrefl__p12 vrefl__p3 0.05
Rw1027 vrefl__p12 vrefl__p4 0.05
Rw1028 vrefl__p12 vrefl__p5 0.05
Rw1029 vrefl__p12 vrefl__p6 0.05
Rw1030 vrefl__p12 vrefl__p7 0.05
Rw1031 vrefl__p12 vrefl__p8 0.05
Rw1032 vrefl__p12 vrefl__p9 0.05
Rw1033 vrefl__p13 vrefl__p14 0.05
Rw1034 vrefl__p13 vrefl__p15 0.05
Rw1035 vrefl__p13 vrefl__p16 0.05
Rw1036 vrefl__p13 vrefl__p17 0.05
Rw1037 vrefl__p13 vrefl__p19 0.05
Rw1038 vrefl__p13 vrefl__p2 0.05
Rw1039 vrefl__p13 vrefl__p3 0.05
Rw1040 vrefl__p13 vrefl__p4 0.05
Rw1041 vrefl__p13 vrefl__p5 0.05
Rw1042 vrefl__p13 vrefl__p6 0.05
Rw1043 vrefl__p13 vrefl__p7 0.05
Rw1044 vrefl__p13 vrefl__p8 0.05
Rw1045 vrefl__p13 vrefl__p9 0.05
Rw1046 vrefl__p14 vrefl__p15 0.05
Rw1047 vrefl__p14 vrefl__p16 0.05
Rw1048 vrefl__p14 vrefl__p17 0.05
Rw1049 vrefl__p14 vrefl__p19 0.05
Rw1050 vrefl__p14 vrefl__p2 0.05
Rw1051 vrefl__p14 vrefl__p3 0.05
Rw1052 vrefl__p14 vrefl__p4 0.05
Rw1053 vrefl__p14 vrefl__p5 0.05
Rw1054 vrefl__p14 vrefl__p6 0.05
Rw1055 vrefl__p14 vrefl__p7 0.05
Rw1056 vrefl__p14 vrefl__p8 0.05
Rw1057 vrefl__p14 vrefl__p9 0.05
Rw1058 vrefl__p15 vrefl__p16 0.05
Rw1059 vrefl__p15 vrefl__p17 0.05
Rw1060 vrefl__p15 vrefl__p19 0.05
Rw1061 vrefl__p15 vrefl__p2 0.05
Rw1062 vrefl__p15 vrefl__p3 0.05
Rw1063 vrefl__p15 vrefl__p4 0.05
Rw1064 vrefl__p15 vrefl__p5 0.05
Rw1065 vrefl__p15 vrefl__p6 0.05
Rw1066 vrefl__p15 vrefl__p7 0.05
Rw1067 vrefl__p15 vrefl__p8 0.05
Rw1068 vrefl__p15 vrefl__p9 0.05
Rw1069 vrefl__p16 vrefl__p17 0.05
Rw1070 vrefl__p16 vrefl__p19 0.05
Rw1071 vrefl__p16 vrefl__p2 0.05
Rw1072 vrefl__p16 vrefl__p3 0.05
Rw1073 vrefl__p16 vrefl__p4 0.05
Rw1074 vrefl__p16 vrefl__p5 0.05
Rw1075 vrefl__p16 vrefl__p6 0.05
Rw1076 vrefl__p16 vrefl__p7 0.05
Rw1077 vrefl__p16 vrefl__p8 0.05
Rw1078 vrefl__p16 vrefl__p9 0.05
Rw1079 vrefl__p17 vrefl__p19 0.05
Rw1080 vrefl__p17 vrefl__p2 0.05
Rw1081 vrefl__p17 vrefl__p3 0.05
Rw1082 vrefl__p17 vrefl__p4 0.05
Rw1083 vrefl__p17 vrefl__p5 0.05
Rw1084 vrefl__p17 vrefl__p6 0.05
Rw1085 vrefl__p17 vrefl__p7 0.05
Rw1086 vrefl__p17 vrefl__p8 0.05
Rw1087 vrefl__p17 vrefl__p9 0.05
Rw1088 vrefl__p19 vrefl__p2 0.05
Rw1089 vrefl__p19 vrefl__p3 0.05
Rw1090 vrefl__p19 vrefl__p4 0.05
Rw1091 vrefl__p19 vrefl__p5 0.05
Rw1092 vrefl__p19 vrefl__p6 0.05
Rw1093 vrefl__p19 vrefl__p7 0.05
Rw1094 vrefl__p19 vrefl__p8 0.05
Rw1095 vrefl__p19 vrefl__p9 0.05
Rw1096 vrefl__p2 vrefl__p3 0.05
Rw1097 vrefl__p2 vrefl__p4 0.05
Rw1098 vrefl__p2 vrefl__p5 0.05
Rw1099 vrefl__p2 vrefl__p6 0.05
Rw1100 vrefl__p2 vrefl__p7 0.05
Rw1101 vrefl__p2 vrefl__p8 0.05
Rw1102 vrefl__p2 vrefl__p9 0.05
Rw1103 vrefl__p3 vrefl__p4 0.05
Rw1104 vrefl__p3 vrefl__p5 0.05
Rw1105 vrefl__p3 vrefl__p6 0.05
Rw1106 vrefl__p3 vrefl__p7 0.05
Rw1107 vrefl__p3 vrefl__p8 0.05
Rw1108 vrefl__p3 vrefl__p9 0.05
Rw1109 vrefl__p4 vrefl__p5 0.05
Rw1110 vrefl__p4 vrefl__p6 0.05
Rw1111 vrefl__p4 vrefl__p7 0.05
Rw1112 vrefl__p4 vrefl__p8 0.05
Rw1113 vrefl__p4 vrefl__p9 0.05
Rw1114 vrefl__p5 vrefl__p6 0.05
Rw1115 vrefl__p5 vrefl__p7 0.05
Rw1116 vrefl__p5 vrefl__p8 0.05
Rw1117 vrefl__p5 vrefl__p9 0.05
Rw1118 vrefl__p6 vrefl__p7 0.05
Rw1119 vrefl__p6 vrefl__p8 0.05
Rw1120 vrefl__p6 vrefl__p9 0.05
Rw1121 vrefl__p7 vrefl__p8 0.05
Rw1122 vrefl__p7 vrefl__p9 0.05
Rw1123 vrefl__p8 vrefl__p9 0.05
Rw1124 xc4_din xc4_din__p1 0.05
Rw1125 xc4_din xc4_din__p2 0.05
Rw1126 xc4_din__p1 xc4_din__p2 0.05
Rw1127 xc4_dip xc4_dip__p1 0.05
Rw1128 xc4_dip xc4_dip__p2 0.05
Rw1129 xc4_dip__p1 xc4_dip__p2 0.05
Rw1130 xc4_lt xc4_lt__p1 0.05
Rw1131 xc4_lt xc4_lt__p2 0.05
Rw1132 xc4_lt__p1 xc4_lt__p2 0.05
Rw1133 xc4_outnb xc4_outnb__p1 0.05
Rw1134 xc4_outpb xc4_outpb__p1 0.05
Rw1135 xc4_xs1_tail xc4_xs1_tail__p1 0.05
Rw1136 xc4_xs1_tail xc4_xs1_tail__p2 0.05
Rw1137 xc4_xs1_tail__p1 xc4_xs1_tail__p2 0.05
Rw1138 xc4_xs1_tail0 xc4_xs1_tail0__p1 0.05
Rw1139 xc5_din xc5_din__p1 0.05
Rw1140 xc5_din xc5_din__p2 0.05
Rw1141 xc5_din__p1 xc5_din__p2 0.05
Rw1142 xc5_dip xc5_dip__p1 0.05
Rw1143 xc5_dip xc5_dip__p2 0.05
Rw1144 xc5_dip__p1 xc5_dip__p2 0.05
Rw1145 xc5_lt xc5_lt__p1 0.05
Rw1146 xc5_lt xc5_lt__p2 0.05
Rw1147 xc5_lt__p1 xc5_lt__p2 0.05
Rw1148 xc5_outnb xc5_outnb__p1 0.05
Rw1149 xc5_outpb xc5_outpb__p1 0.05
Rw1150 xc5_xs1_tail xc5_xs1_tail__p1 0.05
Rw1151 xc5_xs1_tail__p1 xc5_xs1_tail__p2 0.05
Rw1152 xc5_xs1_tail0 xc5_xs1_tail0__p1 0.05
Rw1153 xs0n_cbn xs0n_cbn__p1 0.05
Rw1154 xs0n_cbn xs0n_cbn__p2 0.05
Rw1155 xs0n_cbn xs0n_cbn__p3 0.05
Rw1156 xs0n_cbn xs0n_cbn__p4 0.05
Rw1157 xs0n_cbn__p1 xs0n_cbn__p2 0.05
Rw1158 xs0n_cbn__p1 xs0n_cbn__p3 0.05
Rw1159 xs0n_cbn__p1 xs0n_cbn__p4 0.05
Rw1160 xs0n_cbn__p2 xs0n_cbn__p3 0.05
Rw1161 xs0n_cbn__p2 xs0n_cbn__p4 0.05
Rw1162 xs0n_cbn__p3 xs0n_cbn__p4 0.05
Rw1163 xs0n_cbp xs0n_cbp__p1 0.05
Rw1164 xs0n_cbp xs0n_cbp__p2 0.05
Rw1165 xs0n_cbp__p1 xs0n_cbp__p2 0.05
Rw1166 xs0n_g xs0n_g__p1 0.05
Rw1167 xs0n_g__p1 xs0n_g__p2 0.05
Rw1168 xs0n_g__p1 xs0n_g__p3 0.05
Rw1169 xs0n_g__p1 xs0n_g__p4 0.05
Rw1170 xs0n_g__p1 xs0n_g__p5 0.05
Rw1171 xs0n_g__p2 xs0n_g__p3 0.05
Rw1172 xs0n_g__p2 xs0n_g__p4 0.05
Rw1173 xs0n_g__p2 xs0n_g__p5 0.05
Rw1174 xs0n_g__p3 xs0n_g__p4 0.05
Rw1175 xs0n_g__p3 xs0n_g__p5 0.05
Rw1176 xs0n_g__p4 xs0n_g__p5 0.05
Rw1177 xs0n_n10 xs0n_n10__p1 0.05
Rw1178 xs0n_x xs0n_x__p1 0.05
Rw1179 xs0n_x xs0n_x__p2 0.05
Rw1180 xs0n_x xs0n_x__p3 0.05
Rw1181 xs0n_x__p1 xs0n_x__p2 0.05
Rw1182 xs0n_x__p1 xs0n_x__p3 0.05
Rw1183 xs0n_x__p2 xs0n_x__p3 0.05
Rw1184 xs0p_cbn xs0p_cbn__p1 0.05
Rw1185 xs0p_cbn xs0p_cbn__p2 0.05
Rw1186 xs0p_cbn xs0p_cbn__p3 0.05
Rw1187 xs0p_cbn xs0p_cbn__p4 0.05
Rw1188 xs0p_cbn__p1 xs0p_cbn__p2 0.05
Rw1189 xs0p_cbn__p1 xs0p_cbn__p3 0.05
Rw1190 xs0p_cbn__p1 xs0p_cbn__p4 0.05
Rw1191 xs0p_cbn__p2 xs0p_cbn__p3 0.05
Rw1192 xs0p_cbn__p2 xs0p_cbn__p4 0.05
Rw1193 xs0p_cbn__p3 xs0p_cbn__p4 0.05
Rw1194 xs0p_cbp xs0p_cbp__p1 0.05
Rw1195 xs0p_cbp xs0p_cbp__p2 0.05
Rw1196 xs0p_cbp__p1 xs0p_cbp__p2 0.05
Rw1197 xs0p_g xs0p_g__p1 0.05
Rw1198 xs0p_g__p1 xs0p_g__p2 0.05
Rw1199 xs0p_g__p1 xs0p_g__p3 0.05
Rw1200 xs0p_g__p1 xs0p_g__p4 0.05
Rw1201 xs0p_g__p1 xs0p_g__p5 0.05
Rw1202 xs0p_g__p2 xs0p_g__p3 0.05
Rw1203 xs0p_g__p2 xs0p_g__p4 0.05
Rw1204 xs0p_g__p2 xs0p_g__p5 0.05
Rw1205 xs0p_g__p3 xs0p_g__p4 0.05
Rw1206 xs0p_g__p3 xs0p_g__p5 0.05
Rw1207 xs0p_g__p4 xs0p_g__p5 0.05
Rw1208 xs0p_n10 xs0p_n10__p1 0.05
Rw1209 xs0p_x xs0p_x__p1 0.05
Rw1210 xs0p_x xs0p_x__p2 0.05
Rw1211 xs0p_x xs0p_x__p3 0.05
Rw1212 xs0p_x__p1 xs0p_x__p2 0.05
Rw1213 xs0p_x__p1 xs0p_x__p3 0.05
Rw1214 xs0p_x__p2 xs0p_x__p3 0.05
Rw1215 xs1n_cbn xs1n_cbn__p1 0.05
Rw1216 xs1n_cbn xs1n_cbn__p2 0.05
Rw1217 xs1n_cbn xs1n_cbn__p3 0.05
Rw1218 xs1n_cbn xs1n_cbn__p4 0.05
Rw1219 xs1n_cbn__p1 xs1n_cbn__p2 0.05
Rw1220 xs1n_cbn__p1 xs1n_cbn__p3 0.05
Rw1221 xs1n_cbn__p1 xs1n_cbn__p4 0.05
Rw1222 xs1n_cbn__p2 xs1n_cbn__p3 0.05
Rw1223 xs1n_cbn__p2 xs1n_cbn__p4 0.05
Rw1224 xs1n_cbn__p3 xs1n_cbn__p4 0.05
Rw1225 xs1n_cbp xs1n_cbp__p1 0.05
Rw1226 xs1n_cbp xs1n_cbp__p2 0.05
Rw1227 xs1n_cbp__p1 xs1n_cbp__p2 0.05
Rw1228 xs1n_g xs1n_g__p1 0.05
Rw1229 xs1n_g__p1 xs1n_g__p2 0.05
Rw1230 xs1n_g__p1 xs1n_g__p3 0.05
Rw1231 xs1n_g__p1 xs1n_g__p4 0.05
Rw1232 xs1n_g__p1 xs1n_g__p5 0.05
Rw1233 xs1n_g__p2 xs1n_g__p3 0.05
Rw1234 xs1n_g__p2 xs1n_g__p4 0.05
Rw1235 xs1n_g__p2 xs1n_g__p5 0.05
Rw1236 xs1n_g__p3 xs1n_g__p4 0.05
Rw1237 xs1n_g__p3 xs1n_g__p5 0.05
Rw1238 xs1n_g__p4 xs1n_g__p5 0.05
Rw1239 xs1n_n10 xs1n_n10__p1 0.05
Rw1240 xs1n_x xs1n_x__p1 0.05
Rw1241 xs1n_x xs1n_x__p2 0.05
Rw1242 xs1n_x xs1n_x__p3 0.05
Rw1243 xs1n_x__p1 xs1n_x__p2 0.05
Rw1244 xs1n_x__p1 xs1n_x__p3 0.05
Rw1245 xs1n_x__p2 xs1n_x__p3 0.05
Rw1246 xs1p_cbn xs1p_cbn__p1 0.05
Rw1247 xs1p_cbn xs1p_cbn__p2 0.05
Rw1248 xs1p_cbn xs1p_cbn__p3 0.05
Rw1249 xs1p_cbn xs1p_cbn__p4 0.05
Rw1250 xs1p_cbn__p1 xs1p_cbn__p2 0.05
Rw1251 xs1p_cbn__p1 xs1p_cbn__p3 0.05
Rw1252 xs1p_cbn__p1 xs1p_cbn__p4 0.05
Rw1253 xs1p_cbn__p2 xs1p_cbn__p3 0.05
Rw1254 xs1p_cbn__p2 xs1p_cbn__p4 0.05
Rw1255 xs1p_cbn__p3 xs1p_cbn__p4 0.05
Rw1256 xs1p_cbp xs1p_cbp__p1 0.05
Rw1257 xs1p_cbp xs1p_cbp__p2 0.05
Rw1258 xs1p_cbp__p1 xs1p_cbp__p2 0.05
Rw1259 xs1p_g xs1p_g__p1 0.05
Rw1260 xs1p_g__p1 xs1p_g__p2 0.05
Rw1261 xs1p_g__p1 xs1p_g__p3 0.05
Rw1262 xs1p_g__p1 xs1p_g__p4 0.05
Rw1263 xs1p_g__p1 xs1p_g__p5 0.05
Rw1264 xs1p_g__p2 xs1p_g__p3 0.05
Rw1265 xs1p_g__p2 xs1p_g__p4 0.05
Rw1266 xs1p_g__p2 xs1p_g__p5 0.05
Rw1267 xs1p_g__p3 xs1p_g__p4 0.05
Rw1268 xs1p_g__p3 xs1p_g__p5 0.05
Rw1269 xs1p_g__p4 xs1p_g__p5 0.05
Rw1270 xs1p_n10 xs1p_n10__p1 0.05
Rw1271 xs1p_x xs1p_x__p1 0.05
Rw1272 xs1p_x xs1p_x__p2 0.05
Rw1273 xs1p_x xs1p_x__p3 0.05
Rw1274 xs1p_x__p1 xs1p_x__p2 0.05
Rw1275 xs1p_x__p1 xs1p_x__p3 0.05
Rw1276 xs1p_x__p2 xs1p_x__p3 0.05
.ends
.subckt r1_adc_lay adc_hold is_smp clk adc_start adc_sel adc_valid_a adc_raw_a_0 adc_raw_a_1 adc_raw_a_2 adc_raw_a_3 adc_raw_a_4 adc_raw_a_5 adc_raw_a_6 adc_raw_a_7 adc_raw_a_8 adc_raw_a_9 adc_raw_a_10 adc_raw_a_11 adc_raw_a_12 adc_raw_a_13 adc_valid_b adc_raw_b_0 adc_raw_b_1 adc_raw_b_2 adc_raw_b_3 adc_raw_b_4 adc_raw_b_5 adc_raw_b_6 adc_raw_b_7 adc_raw_b_8 adc_raw_b_9 adc_raw_b_10 adc_raw_b_11 adc_raw_b_12 adc_raw_b_13 por_n ain_sin_p ain_sin_n ain_cos_p ain_cos_n vcm2 ibias ain_isa_p ain_isa_n ain_isb_p ain_isb_n vcm vdda vdd vss vref_in topap topan topbp topbn sar_clka sar_clkab sar_clkb sar_clkbb sar_clkna sar_clknab sar_clknb sar_clknbb sar_cna0 sar_cna1 sar_cna10 sar_cna11 sar_cna12 sar_cna2 sar_cna3 sar_cna4 sar_cna5 sar_cna6 sar_cna7 sar_cna8 sar_cna9 sar_cnb0 sar_cnb1 sar_cnb10 sar_cnb11 sar_cnb12 sar_cnb2 sar_cnb3 sar_cnb4 sar_cnb5 sar_cnb6 sar_cnb7 sar_cnb8 sar_cnb9 sar_cpa0 sar_cpa1 sar_cpa10 sar_cpa11 sar_cpa12 sar_cpa2 sar_cpa3 sar_cpa4 sar_cpa5 sar_cpa6 sar_cpa7 sar_cpa8 sar_cpa9 sar_cpb0 sar_cpb1 sar_cpb10 sar_cpb11 sar_cpb12 sar_cpb2 sar_cpb3 sar_cpb4 sar_cpb5 sar_cpb6 sar_cpb7 sar_cpb8 sar_cpb9 sar_oan sar_oann sar_oanp sar_oap sar_obn sar_obnn sar_obnp sar_obp sar_trka0 sar_trka1 sar_trkb0 sar_trkb1 sar_mclk
Xxckg_xpd0 xckg_d0__p1 clk vdd__p2 vdd sg13_lv_pmos w=1u l=0.5u ng=1 m=1
Xxckg_xnd0 xckg_d0 clk vss__p9 vss sg13_lv_nmos w=0.5u l=0.5u ng=1 m=1
Xxckg_cd0 xckg_d0__p2 vss__p16 cap_cmim w=2.53u l=2.53u m=1
Xxckg_xpd1 xckg_d1__p1 xckg_d0 vdd__p3 vdd sg13_lv_pmos w=1u l=0.5u ng=1 m=1
Xxckg_xnd1 xckg_d1 xckg_d0 vss__p10 vss sg13_lv_nmos w=0.5u l=0.5u ng=1 m=1
Xxckg_cd1 xckg_d1__p2 vss__p17 cap_cmim w=2.53u l=2.53u m=1
Xxckg_xpd2 xckg_d2__p1 xckg_d1 vdd__p4 vdd sg13_lv_pmos w=1u l=0.5u ng=1 m=1
Xxckg_xnd2 xckg_d2 xckg_d1 vss__p11 vss sg13_lv_nmos w=0.5u l=0.5u ng=1 m=1
Xxckg_cd2 xckg_d2__p2 vss__p18 cap_cmim w=2.53u l=2.53u m=1
Xxckg_xpd3 xckg_d3__p1 xckg_d2 vdd__p5 vdd sg13_lv_pmos w=1u l=0.5u ng=1 m=1
Xxckg_xnd3 xckg_d3 xckg_d2 vss__p12 vss sg13_lv_nmos w=0.5u l=0.5u ng=1 m=1
Xxckg_cd3 xckg_d3__p2 vss__p19 cap_cmim w=2.53u l=2.53u m=1
Xxckg_xpd4 xckg_x__p2 xckg_d3 vdd__p6 vdd sg13_lv_pmos w=1u l=0.5u ng=1 m=1
Xxckg_xnd4 xckg_x xckg_d3 vss__p13 vss sg13_lv_nmos w=0.5u l=0.5u ng=1 m=1
Xxckg_cd4 xckg_x__p4 vss__p20 cap_cmim w=2.53u l=2.53u m=1
Xxckg_xpa sar_mclk__p2 clk__p1 vdd__p7 vdd sg13_lv_pmos w=2u l=0.13u ng=1 m=1
Xxckg_xpb sar_mclk__p3 xckg_x__p3 vdd__p8 vdd sg13_lv_pmos w=2u l=0.13u ng=1 m=1
Xxckg_xna sar_mclk clk__p0 xckg_nn vss sg13_lv_nmos w=2u l=0.13u ng=1 m=1
Xxckg_xnb xckg_nn__p1 xckg_x__p1 vss__p14 vss sg13_lv_nmos w=2u l=0.13u ng=1 m=1
Xxckg_xpi mclkb__p1 sar_mclk__p4 vdd__p9 vdd sg13_lv_pmos w=2u l=0.13u ng=1 m=1
Xxckg_xni mclkb sar_mclk__p1 vss__p15 vss sg13_lv_nmos w=1u l=0.13u ng=1 m=1
Xxcbias_xmbd vbp__p1 vbp vdd__p1 vdd sg13_lv_pmos w=0.8u l=0.5u ng=1 m=1
Xxcbias_xrb_g0 vbp xcbias_xrb_s1 vss rppd w=1u l=40u m=1 b=0
Xxcbias_xrb_g1 xcbias_xrb_s1 xcbias_xrb_s2 vss rppd w=1u l=40u m=1 b=0
Xxcbias_xrb_g2 xcbias_xrb_s2 xcbias_xrb_s3 vss rppd w=1u l=40u m=1 b=0
Xxcbias_xrb_g3 xcbias_xrb_s3 vss__p7 vss rppd w=1u l=40u m=1 b=0
Xxcbiasn_xmbd vbn__p1 vbn vss__p8 vss sg13_lv_nmos w=0.2u l=0.5u ng=1 m=1
Xxcbiasn_xrb_g0 vdd__p0 xcbiasn_xrb_s1 vss rppd w=1u l=40u m=1 b=0
Xxcbiasn_xrb_g1 xcbiasn_xrb_s1 xcbiasn_xrb_s2 vss rppd w=1u l=40u m=1 b=0
Xxcbiasn_xrb_g2 xcbiasn_xrb_s2 xcbiasn_xrb_s3 vss rppd w=1u l=40u m=1 b=0
Xxcbiasn_xrb_g3 xcbiasn_xrb_s3 vbn vss rppd w=1u l=40u m=1 b=0
Xxref_xmb0 ibias__p0 ibias vss__p5 vss sg13_hv_nmos w=2u l=1u ng=1 m=1
Xxref_xmt xref_ntl ibias vss__p6 vss sg13_hv_nmos w=2u l=8u ng=1 m=1
Xxref_xm1 xref_na vref_in xref_ntl__p1 vss sg13_hv_nmos w=10u l=1u ng=2 m=1
Xxref_xm2 xref_ng vref xref_ntl__p2 vss sg13_hv_nmos w=10u l=1u ng=2 m=1
Xxref_xm3 xref_na__p1 xref_na vdda__p5 vdda sg13_hv_pmos w=4u l=1u ng=1 m=1
Xxref_xm4 xref_ng__p1 xref_na vdda__p6 vdda sg13_hv_pmos w=4u l=1u ng=1 m=1
Xxref_xcg_u0 vss xref_ng cap_cmim w=26.32u l=95u m=1
Xxref_xmsf_s0 vdda__p1 xref_ng vref vss sg13_hv_nmos w=80u l=0.45u ng=32 m=1
Xxref_xmsf_s1 vdda__p2 xref_ng vref__p5 vss sg13_hv_nmos w=80u l=0.45u ng=32 m=1
Xxref_xmsf_s2 vdda__p3 xref_ng vref__p6 vss sg13_hv_nmos w=80u l=0.45u ng=32 m=1
Xxref_xmsf_s3 vdda__p4 xref_ng vref__p7 vss sg13_hv_nmos w=80u l=0.45u ng=32 m=1
Xxref_xmib_s0 vref__p0 ibias vss__p0 vss sg13_hv_nmos w=80u l=1u ng=40 m=1
Xxref_xmib_s1 vref__p1 ibias vss__p1 vss sg13_hv_nmos w=80u l=1u ng=40 m=1
Xxref_xmib_s2 vref__p2 ibias vss__p2 vss sg13_hv_nmos w=80u l=1u ng=40 m=1
Xxref_xmib_s3 vref__p3 ibias vss__p3 vss sg13_hv_nmos w=80u l=1u ng=40 m=1
Xxref_xcd_u0 vss vref cap_cmim w=51.58u l=95u m=4
Xxref_xmsfl_s0 vdda__p0 xref_ng vrefl vss sg13_hv_nmos w=80u l=0.45u ng=32 m=1
Xxref_xmibl_s0 vrefl__p0 ibias vss__p4 vss sg13_hv_nmos w=80u l=1u ng=40 m=1
Xxref_xcdl_u0 vss vrefl cap_cmim w=51.58u l=95u m=2
Xxfilt_xcf_u0 vss vref_in cap_cmim w=37.36u l=90u m=2
Xslice_a ain_sin_p__p1 ain_sin_n__p1 ain_isa_p__p1 ain_isa_n__p1 sar_trka0 sar_trka1 sar_cpa0 sar_cpa1 sar_cpa2 sar_cpa3 sar_cpa4 sar_cpa5 sar_cpa6 sar_cpa7 sar_cpa8 sar_cpa9 sar_cpa10 sar_cpa11 sar_cpa12 sar_cna0 sar_cna1 sar_cna2 sar_cna3 sar_cna4 sar_cna5 sar_cna6 sar_cna7 sar_cna8 sar_cna9 sar_cna10 sar_cna11 sar_cna12 sar_clka sar_clkab sar_clkna sar_clknab sar_oap sar_oan sar_oanp sar_oann vbp__p2 vbn__p2 vref__p8 vrefl__p2 vrefl__p3 topap topan vdd__p11 vdd__p12 vdd__p13 vdd__p14 vss__p22 vss__p23 vss__p24 vss__p25 r1_adc_slice_post
Xslice_b ain_cos_p__p1 ain_cos_n__p1 ain_isb_p__p1 ain_isb_n__p1 sar_trkb0 sar_trkb1 sar_cpb0 sar_cpb1 sar_cpb2 sar_cpb3 sar_cpb4 sar_cpb5 sar_cpb6 sar_cpb7 sar_cpb8 sar_cpb9 sar_cpb10 sar_cpb11 sar_cpb12 sar_cnb0 sar_cnb1 sar_cnb2 sar_cnb3 sar_cnb4 sar_cnb5 sar_cnb6 sar_cnb7 sar_cnb8 sar_cnb9 sar_cnb10 sar_cnb11 sar_cnb12 sar_clkb sar_clkbb sar_clknb sar_clknbb sar_obp sar_obn sar_obnp sar_obnn vbp__p3 vbn__p3 vref__p9 vrefl__p4 vrefl__p5 topbp topbn vdd__p15 vdd__p16 vdd__p17 vdd__p18 vss__p26 vss__p27 vss__p28 vss__p29 r1_adc_slice_post
Rt0 ain_cos_n ain_cos_n__p1 0.05
Rt1 ain_cos_p ain_cos_p__p1 0.05
Rt2 ain_isa_n ain_isa_n__p1 0.05
Rt3 ain_isa_p ain_isa_p__p1 0.05
Rt4 ain_isb_n ain_isb_n__p1 0.05
Rt5 ain_isb_p ain_isb_p__p1 0.05
Rt6 ain_sin_n ain_sin_n__p1 0.05
Rt7 ain_sin_p ain_sin_p__p1 0.05
Rt8 clk clk__p0 0.05
Rt9 clk clk__p1 0.05
Rt10 clk__p0 clk__p1 0.05
Rt11 ibias ibias__p0 0.05
Rt12 mclkb mclkb__p1 0.05
Rt13 sar_mclk sar_mclk__p1 0.05
Rt14 sar_mclk sar_mclk__p3 0.05
Rt15 sar_mclk sar_mclk__p4 0.05
Rt16 sar_mclk__p1 sar_mclk__p3 0.05
Rt17 sar_mclk__p1 sar_mclk__p4 0.05
Rt18 sar_mclk__p2 sar_mclk__p3 0.05
Rt19 sar_mclk__p3 sar_mclk__p4 0.05
Rt20 vbn vbn__p1 0.05
Rt21 vbn vbn__p2 0.05
Rt22 vbn vbn__p3 0.05
Rt23 vbn__p1 vbn__p2 0.05
Rt24 vbn__p1 vbn__p3 0.05
Rt25 vbn__p2 vbn__p3 0.05
Rt26 vbp vbp__p1 0.05
Rt27 vbp vbp__p2 0.05
Rt28 vbp vbp__p3 0.05
Rt29 vbp__p1 vbp__p2 0.05
Rt30 vbp__p1 vbp__p3 0.05
Rt31 vbp__p2 vbp__p3 0.05
Rt32 vdd vdd__p0 51.7969
Rt33 vdd vdd__p1 129.356
Rt34 vdd vdd__p11 227.932
Rt35 vdd vdd__p12 340.649
Rt36 vdd vdd__p13 1516.8
Rt37 vdd vdd__p14 3969.78
Rt38 vdd vdd__p15 7290.2
Rt39 vdd vdd__p16 18493.6
Rt40 vdd vdd__p17 198850
Rt41 vdd vdd__p18 378541
Rt42 vdd vdd__p2 9366.97
Rt43 vdd vdd__p3 12380.2
Rt44 vdd vdd__p4 16093
Rt45 vdd vdd__p5 20342.3
Rt46 vdd vdd__p6 24598.2
Rt47 vdd vdd__p7 53237.1
Rt48 vdd vdd__p8 57510.5
Rt49 vdd vdd__p9 60223.6
Rt50 vdd__p0 vdd__p1 185.206
Rt51 vdd__p0 vdd__p11 326.344
Rt52 vdd__p0 vdd__p12 487.728
Rt53 vdd__p0 vdd__p13 2171.69
Rt54 vdd__p0 vdd__p14 5683.77
Rt55 vdd__p0 vdd__p15 10437.8
Rt56 vdd__p0 vdd__p16 26478.5
Rt57 vdd__p0 vdd__p17 284706
Rt58 vdd__p0 vdd__p18 541980
Rt59 vdd__p0 vdd__p2 13411.3
Rt60 vdd__p0 vdd__p3 17725.5
Rt61 vdd__p0 vdd__p4 23041.3
Rt62 vdd__p0 vdd__p5 29125.3
Rt63 vdd__p0 vdd__p6 35218.7
Rt64 vdd__p0 vdd__p7 76222.8
Rt65 vdd__p0 vdd__p8 82341.3
Rt66 vdd__p0 vdd__p9 86225.7
Rt67 vdd__p1 vdd__p11 271.988
Rt68 vdd__p1 vdd__p12 406.492
Rt69 vdd__p1 vdd__p13 1809.98
Rt70 vdd__p1 vdd__p14 4737.09
Rt71 vdd__p1 vdd__p15 8699.31
Rt72 vdd__p1 vdd__p16 22068.2
Rt73 vdd__p1 vdd__p17 237286
Rt74 vdd__p1 vdd__p18 451709
Rt75 vdd__p1 vdd__p2 11177.5
Rt76 vdd__p1 vdd__p3 14773.1
Rt77 vdd__p1 vdd__p4 19203.5
Rt78 vdd__p1 vdd__p5 24274.2
Rt79 vdd__p1 vdd__p6 29352.7
Rt80 vdd__p1 vdd__p7 63527.2
Rt81 vdd__p1 vdd__p8 68626.7
Rt82 vdd__p1 vdd__p9 71864.1
Rt83 vdd__p11 vdd__p12 48.8126
Rt84 vdd__p11 vdd__p13 217.347
Rt85 vdd__p11 vdd__p14 568.842
Rt86 vdd__p11 vdd__p15 1044.64
Rt87 vdd__p11 vdd__p16 2650.01
Rt88 vdd__p11 vdd__p17 28493.9
Rt89 vdd__p11 vdd__p18 54242.4
Rt90 vdd__p11 vdd__p2 640.666
Rt91 vdd__p11 vdd__p3 846.759
Rt92 vdd__p11 vdd__p4 1100.7
Rt93 vdd__p11 vdd__p5 1391.34
Rt94 vdd__p11 vdd__p6 1682.42
Rt95 vdd__p11 vdd__p7 3641.22
Rt96 vdd__p11 vdd__p8 3933.51
Rt97 vdd__p11 vdd__p9 4119.07
Rt98 vdd__p12 vdd__p13 77.2099
Rt99 vdd__p12 vdd__p14 202.075
Rt100 vdd__p12 vdd__p15 371.095
Rt101 vdd__p12 vdd__p16 941.386
Rt102 vdd__p12 vdd__p17 10122.1
Rt103 vdd__p12 vdd__p18 19269
Rt104 vdd__p12 vdd__p2 2005.98
Rt105 vdd__p12 vdd__p3 2651.28
Rt106 vdd__p12 vdd__p4 3446.38
Rt107 vdd__p12 vdd__p5 4356.4
Rt108 vdd__p12 vdd__p6 5267.82
Rt109 vdd__p12 vdd__p7 11401
Rt110 vdd__p12 vdd__p8 12316.2
Rt111 vdd__p12 vdd__p9 12897.2
Rt112 vdd__p13 vdd__p14 49.1805
Rt113 vdd__p13 vdd__p15 90.3164
Rt114 vdd__p13 vdd__p16 229.113
Rt115 vdd__p13 vdd__p17 2463.51
Rt116 vdd__p13 vdd__p18 4689.65
Rt117 vdd__p13 vdd__p2 8931.97
Rt118 vdd__p13 vdd__p3 11805.3
Rt119 vdd__p13 vdd__p4 15345.6
Rt120 vdd__p13 vdd__p5 19397.6
Rt121 vdd__p13 vdd__p6 23455.9
Rt122 vdd__p13 vdd__p7 50764.8
Rt123 vdd__p13 vdd__p8 54839.8
Rt124 vdd__p13 vdd__p9 57426.8
Rt125 vdd__p14 vdd__p15 40.3724
Rt126 vdd__p14 vdd__p16 102.416
Rt127 vdd__p14 vdd__p17 1101.21
Rt128 vdd__p14 vdd__p18 2096.32
Rt129 vdd__p14 vdd__p2 23376.8
Rt130 vdd__p14 vdd__p3 30896.9
Rt131 vdd__p14 vdd__p4 40162.7
Rt132 vdd__p14 vdd__p5 50767.6
Rt133 vdd__p14 vdd__p6 61388.9
Rt134 vdd__p14 vdd__p7 132862
Rt135 vdd__p14 vdd__p8 143527
Rt136 vdd__p14 vdd__p9 150298
Rt137 vdd__p15 vdd__p16 53.0715
Rt138 vdd__p15 vdd__p17 570.644
Rt139 vdd__p15 vdd__p18 1086.31
Rt140 vdd__p15 vdd__p2 42929.8
Rt141 vdd__p15 vdd__p3 56739.8
Rt142 vdd__p15 vdd__p4 73755.8
Rt143 vdd__p15 vdd__p5 93230.9
Rt144 vdd__p15 vdd__p6 112736
Rt145 vdd__p15 vdd__p7 243991
Rt146 vdd__p15 vdd__p8 263577
Rt147 vdd__p15 vdd__p9 276011
Rt148 vdd__p16 vdd__p17 164.448
Rt149 vdd__p16 vdd__p18 313.051
Rt150 vdd__p16 vdd__p2 108904
Rt151 vdd__p16 vdd__p3 143936
Rt152 vdd__p16 vdd__p4 187102
Rt153 vdd__p16 vdd__p5 236506
Rt154 vdd__p16 vdd__p6 285987
Rt155 vdd__p16 vdd__p7 618953
Rt156 vdd__p16 vdd__p8 668637
Rt157 vdd__p16 vdd__p9 700179
Rt158 vdd__p17 vdd__p18 29.0526
Rt159 vdd__p2 vdd__p3 92.6957
Rt160 vdd__p2 vdd__p4 120.495
Rt161 vdd__p2 vdd__p5 152.311
Rt162 vdd__p2 vdd__p6 184.177
Rt163 vdd__p2 vdd__p7 398.608
Rt164 vdd__p2 vdd__p8 430.605
Rt165 vdd__p2 vdd__p9 450.919
Rt166 vdd__p3 vdd__p4 108.814
Rt167 vdd__p3 vdd__p5 137.546
Rt168 vdd__p3 vdd__p6 166.322
Rt169 vdd__p3 vdd__p7 359.966
Rt170 vdd__p3 vdd__p8 388.861
Rt171 vdd__p3 vdd__p9 407.206
Rt172 vdd__p4 vdd__p5 115.772
Rt173 vdd__p4 vdd__p6 139.993
Rt174 vdd__p4 vdd__p7 302.983
Rt175 vdd__p4 vdd__p8 327.304
Rt176 vdd__p4 vdd__p9 342.744
Rt177 vdd__p5 vdd__p6 112.042
Rt178 vdd__p5 vdd__p7 242.489
Rt179 vdd__p5 vdd__p8 261.954
Rt180 vdd__p5 vdd__p9 274.312
Rt181 vdd__p6 vdd__p7 187.851
Rt182 vdd__p6 vdd__p8 202.93
Rt183 vdd__p6 vdd__p9 212.503
Rt184 vdd__p7 vdd__p8 373.265
Rt185 vdd__p7 vdd__p9 390.874
Rt186 vdd__p8 vdd__p9 274.094
Rt187 vdda vdda__p1 30.7341
Rt188 vdda__p0 vdda__p3 66.7792
Rt189 vdda__p0 vdda__p4 64.5261
Rt190 vdda__p1 vdda__p2 19.5742
Rt191 vdda__p2 vdda__p3 93.9618
Rt192 vdda__p2 vdda__p5 66.6691
Rt193 vdda__p2 vdda__p6 85.2968
Rt194 vdda__p3 vdda__p4 23.0035
Rt195 vdda__p3 vdda__p5 88.1947
Rt196 vdda__p3 vdda__p6 68.6694
Rt197 vdda__p5 vdda__p6 80.0616
Rt198 vref vref__p1 0.05
Rt199 vref vref__p5 0.05
Rt200 vref vref__p8 0.05
Rt201 vref vref__p9 0.05
Rt202 vref__p0 vref__p1 0.05
Rt203 vref__p1 vref__p5 0.05
Rt204 vref__p1 vref__p8 0.05
Rt205 vref__p1 vref__p9 0.05
Rt206 vref__p2 vref__p3 0.05
Rt207 vref__p2 vref__p6 0.05
Rt208 vref__p5 vref__p6 0.05
Rt209 vref__p5 vref__p8 0.05
Rt210 vref__p5 vref__p9 0.05
Rt211 vref__p6 vref__p7 0.05
Rt212 vref__p8 vref__p9 0.05
Rt213 vrefl vrefl__p0 0.05
Rt214 vrefl vrefl__p2 0.05
Rt215 vrefl vrefl__p3 0.05
Rt216 vrefl vrefl__p4 0.05
Rt217 vrefl vrefl__p5 0.05
Rt218 vrefl__p0 vrefl__p2 0.05
Rt219 vrefl__p0 vrefl__p3 0.05
Rt220 vrefl__p0 vrefl__p4 0.05
Rt221 vrefl__p0 vrefl__p5 0.05
Rt222 vrefl__p2 vrefl__p3 0.05
Rt223 vrefl__p2 vrefl__p4 0.05
Rt224 vrefl__p2 vrefl__p5 0.05
Rt225 vrefl__p3 vrefl__p4 0.05
Rt226 vrefl__p3 vrefl__p5 0.05
Rt227 vrefl__p4 vrefl__p5 0.05
Rt228 vss vss__p0 64.0123
Rt229 vss vss__p1 683.259
Rt230 vss vss__p10 0.001
Rt231 vss vss__p2 371.2
Rt232 vss vss__p22 97.4665
Rt233 vss vss__p23 273.377
Rt234 vss vss__p24 471242
Rt235 vss vss__p25 358523
Rt236 vss vss__p26 51921.8
Rt237 vss vss__p27 86075
Rt238 vss vss__p28 244.041
Rt239 vss vss__p29 100.595
Rt240 vss vss__p3 217.277
Rt241 vss vss__p4 1870.56
Rt242 vss vss__p5 2480.51
Rt243 vss vss__p6 3517.19
Rt244 vss vss__p7 118.25
Rt245 vss vss__p8 119.221
Rt246 vss__p0 vss__p1 161.851
Rt247 vss__p0 vss__p2 2839.25
Rt248 vss__p0 vss__p22 263.99
Rt249 vss__p0 vss__p23 740.446
Rt250 vss__p0 vss__p24 111628
Rt251 vss__p0 vss__p25 84927.1
Rt252 vss__p0 vss__p26 12299.3
Rt253 vss__p0 vss__p27 20389.5
Rt254 vss__p0 vss__p28 1815.36
Rt255 vss__p0 vss__p29 748.299
Rt256 vss__p0 vss__p3 1661.92
Rt257 vss__p0 vss__p4 443.099
Rt258 vss__p0 vss__p5 587.584
Rt259 vss__p0 vss__p6 833.152
Rt260 vss__p0 vss__p7 320.451
Rt261 vss__p0 vss__p8 322.646
Rt262 vss__p1 vss__p2 30305.8
Rt263 vss__p1 vss__p22 2817.79
Rt264 vss__p1 vss__p23 7903.42
Rt265 vss__p1 vss__p24 84165.5
Rt266 vss__p1 vss__p25 64033.5
Rt267 vss__p1 vss__p26 9273.42
Rt268 vss__p1 vss__p27 15373.3
Rt269 vss__p1 vss__p28 19376.9
Rt270 vss__p1 vss__p29 7987.25
Rt271 vss__p1 vss__p3 17739.1
Rt272 vss__p1 vss__p4 334.089
Rt273 vss__p1 vss__p5 443.028
Rt274 vss__p1 vss__p6 628.182
Rt275 vss__p1 vss__p7 3420.45
Rt276 vss__p1 vss__p8 3443.88
Rt277 vss__p10 vss__p11 113.514
Rt278 vss__p10 vss__p12 143.98
Rt279 vss__p10 vss__p13 175.022
Rt280 vss__p10 vss__p14 393.007
Rt281 vss__p10 vss__p15 251.471
Rt282 vss__p10 vss__p16 619.655
Rt283 vss__p10 vss__p17 663.526
Rt284 vss__p10 vss__p18 489.378
Rt285 vss__p10 vss__p19 10540.7
Rt286 vss__p10 vss__p20 51601.3
Rt287 vss__p10 vss__p9 98.2846
Rt288 vss__p11 vss__p12 120.167
Rt289 vss__p11 vss__p13 146.721
Rt290 vss__p11 vss__p14 381.007
Rt291 vss__p11 vss__p15 213.501
Rt292 vss__p11 vss__p16 622.078
Rt293 vss__p11 vss__p17 666.121
Rt294 vss__p11 vss__p18 491.292
Rt295 vss__p11 vss__p19 10581.9
Rt296 vss__p11 vss__p20 51803
Rt297 vss__p11 vss__p9 127.728
Rt298 vss__p12 vss__p13 117.108
Rt299 vss__p12 vss__p14 339.683
Rt300 vss__p12 vss__p15 171.879
Rt301 vss__p12 vss__p16 572.183
Rt302 vss__p12 vss__p17 612.694
Rt303 vss__p12 vss__p18 451.887
Rt304 vss__p12 vss__p19 9733.2
Rt305 vss__p12 vss__p20 47648.1
Rt306 vss__p12 vss__p9 161.388
Rt307 vss__p13 vss__p14 283.157
Rt308 vss__p13 vss__p15 133.639
Rt309 vss__p13 vss__p16 488.476
Rt310 vss__p13 vss__p17 523.06
Rt311 vss__p13 vss__p18 385.779
Rt312 vss__p13 vss__p19 8309.28
Rt313 vss__p13 vss__p20 40677.4
Rt314 vss__p13 vss__p9 195.03
Rt315 vss__p14 vss__p15 225.414
Rt316 vss__p14 vss__p16 211.446
Rt317 vss__p14 vss__p17 226.416
Rt318 vss__p14 vss__p18 166.991
Rt319 vss__p14 vss__p19 3596.83
Rt320 vss__p14 vss__p20 17608
Rt321 vss__p14 vss__p9 371.254
Rt322 vss__p15 vss__p16 338.846
Rt323 vss__p15 vss__p17 362.836
Rt324 vss__p15 vss__p18 267.607
Rt325 vss__p15 vss__p19 5763.98
Rt326 vss__p15 vss__p20 28217.1
Rt327 vss__p15 vss__p9 275.605
Rt328 vss__p16 vss__p17 48.9479
Rt329 vss__p16 vss__p18 36.1012
Rt330 vss__p16 vss__p19 777.582
Rt331 vss__p16 vss__p20 3806.59
Rt332 vss__p16 vss__p9 566.446
Rt333 vss__p17 vss__p18 34.3505
Rt334 vss__p17 vss__p19 739.876
Rt335 vss__p17 vss__p20 3622
Rt336 vss__p17 vss__p9 606.55
Rt337 vss__p18 vss__p19 0.666482
Rt338 vss__p18 vss__p20 3.26271
Rt339 vss__p18 vss__p9 447.356
Rt340 vss__p19 vss__p20 0.970961
Rt341 vss__p19 vss__p9 9635.59
Rt342 vss__p2 vss__p22 4002.37
Rt343 vss__p2 vss__p23 11226
Rt344 vss__p2 vss__p28 1236.98
Rt345 vss__p2 vss__p29 509.888
Rt346 vss__p2 vss__p3 62.1518
Rt347 vss__p2 vss__p4 82968.3
Rt348 vss__p2 vss__p5 110022
Rt349 vss__p2 vss__p6 156004
Rt350 vss__p2 vss__p7 4737.78
Rt351 vss__p2 vss__p8 4990.17
Rt352 vss__p20 vss__p9 47170.3
Rt353 vss__p22 vss__p23 13.1644
Rt354 vss__p22 vss__p26 214128
Rt355 vss__p22 vss__p27 354978
Rt356 vss__p22 vss__p28 2291.22
Rt357 vss__p22 vss__p29 944.448
Rt358 vss__p22 vss__p3 2342.74
Rt359 vss__p22 vss__p4 7714.29
Rt360 vss__p22 vss__p5 10229.7
Rt361 vss__p22 vss__p6 14505
Rt362 vss__p22 vss__p7 105.519
Rt363 vss__p22 vss__p8 133.386
Rt364 vss__p23 vss__p26 600593
Rt365 vss__p23 vss__p27 995651
Rt366 vss__p23 vss__p28 6426.46
Rt367 vss__p23 vss__p29 2649.01
Rt368 vss__p23 vss__p3 6570.98
Rt369 vss__p23 vss__p4 21637.2
Rt370 vss__p23 vss__p5 28692.7
Rt371 vss__p23 vss__p6 40684.2
Rt372 vss__p23 vss__p7 295.961
Rt373 vss__p23 vss__p8 374.125
Rt374 vss__p24 vss__p25 97.1468
Rt375 vss__p24 vss__p26 129.246
Rt376 vss__p24 vss__p27 1768.45
Rt377 vss__p24 vss__p4 19241.6
Rt378 vss__p24 vss__p5 8459.44
Rt379 vss__p24 vss__p6 1790.84
Rt380 vss__p25 vss__p26 98.3311
Rt381 vss__p25 vss__p27 1345.45
Rt382 vss__p25 vss__p4 14639.1
Rt383 vss__p25 vss__p5 6435.98
Rt384 vss__p25 vss__p6 1362.48
Rt385 vss__p26 vss__p27 194.85
Rt386 vss__p26 vss__p29 606963
Rt387 vss__p26 vss__p4 2120.05
Rt388 vss__p26 vss__p5 932.068
Rt389 vss__p26 vss__p6 197.317
Rt390 vss__p26 vss__p7 259925
Rt391 vss__p26 vss__p8 261706
Rt392 vss__p27 vss__p4 3514.58
Rt393 vss__p27 vss__p5 1545.17
Rt394 vss__p27 vss__p6 327.108
Rt395 vss__p27 vss__p7 430899
Rt396 vss__p27 vss__p8 433851
Rt397 vss__p28 vss__p29 11.3118
Rt398 vss__p28 vss__p3 724.052
Rt399 vss__p28 vss__p4 53048.4
Rt400 vss__p28 vss__p5 70346.2
Rt401 vss__p28 vss__p6 99746
Rt402 vss__p28 vss__p7 2611
Rt403 vss__p28 vss__p8 2945.87
Rt404 vss__p29 vss__p3 298.457
Rt405 vss__p29 vss__p4 21866.7
Rt406 vss__p29 vss__p5 28997
Rt407 vss__p29 vss__p6 41115.7
Rt408 vss__p29 vss__p7 1076.26
Rt409 vss__p29 vss__p8 1214.3
Rt410 vss__p3 vss__p4 48564.5
Rt411 vss__p3 vss__p5 64400.3
Rt412 vss__p3 vss__p6 91315
Rt413 vss__p3 vss__p7 2773.2
Rt414 vss__p3 vss__p8 2920.94
Rt415 vss__p4 vss__p5 101.283
Rt416 vss__p4 vss__p6 143.612
Rt417 vss__p4 vss__p7 9364.19
Rt418 vss__p4 vss__p8 9428.33
Rt419 vss__p5 vss__p6 63.1383
Rt420 vss__p5 vss__p7 12417.6
Rt421 vss__p5 vss__p8 12502.7
Rt422 vss__p6 vss__p7 17607.3
Rt423 vss__p6 vss__p8 17727.9
Rt424 vss__p7 vss__p8 171.407
Rt425 xckg_d0 xckg_d0__p1 0.05
Rt426 xckg_d0 xckg_d0__p2 0.05
Rt427 xckg_d0__p1 xckg_d0__p2 0.05
Rt428 xckg_d1 xckg_d1__p1 0.05
Rt429 xckg_d1 xckg_d1__p2 0.05
Rt430 xckg_d1__p1 xckg_d1__p2 0.05
Rt431 xckg_d2 xckg_d2__p1 0.05
Rt432 xckg_d2 xckg_d2__p2 0.05
Rt433 xckg_d2__p1 xckg_d2__p2 0.05
Rt434 xckg_d3 xckg_d3__p1 0.05
Rt435 xckg_d3 xckg_d3__p2 0.05
Rt436 xckg_d3__p1 xckg_d3__p2 0.05
Rt437 xckg_nn xckg_nn__p1 0.05
Rt438 xckg_x xckg_x__p1 0.05
Rt439 xckg_x xckg_x__p2 0.05
Rt440 xckg_x xckg_x__p3 0.05
Rt441 xckg_x xckg_x__p4 0.05
Rt442 xckg_x__p1 xckg_x__p2 0.05
Rt443 xckg_x__p1 xckg_x__p3 0.05
Rt444 xckg_x__p1 xckg_x__p4 0.05
Rt445 xckg_x__p2 xckg_x__p3 0.05
Rt446 xckg_x__p2 xckg_x__p4 0.05
Rt447 xckg_x__p3 xckg_x__p4 0.05
Rt448 xref_na xref_na__p1 0.05
Rt449 xref_ng xref_ng__p1 0.05
Rt450 xref_ntl xref_ntl__p1 0.05
Rt451 xref_ntl__p1 xref_ntl__p2 0.05
Cq0 ain_cos_n ain_cos_p 2.709e-14
Cq1 ain_cos_n ain_isa_n 3.644e-17
Cq2 ain_cos_n ain_isa_p 4.64e-17
Cq3 ain_cos_n ibias 5.314e-17
Cq4 ain_cos_n vdd 5.829e-16
Cq5 ain_cos_n vss 2.705e-14
Cq6 ain_cos_n xckg_d0 9.755e-19
Cq7 ain_cos_n xckg_d1 9.755e-19
Cq8 ain_cos_n xckg_d2 9.755e-19
Cq9 ain_cos_n xckg_d3 1.006e-18
Cq10 ain_cos_n xckg_x 5.633e-18
Cq11 ain_cos_p ain_isa_n 4.287e-17
Cq12 ain_cos_p ain_isa_p 7.229e-16
Cq13 ain_cos_p ibias 3.52e-15
Cq14 ain_cos_p vdd 2.509e-15
Cq15 ain_cos_p vss 1.273e-14
Cq16 ain_isa_n ain_isa_p 2.783e-14
Cq17 ain_isa_n ain_isb_n 6.15e-17
Cq18 ain_isa_n ain_isb_p 6.417e-17
Cq19 ain_isa_n vss 2.894e-14
Cq20 ain_isa_p ain_isb_n 7.645e-17
Cq21 ain_isa_p ain_isb_p 7.912e-17
Cq22 ain_isa_p vss 2.868e-14
Cq23 ain_isb_n ain_isb_p 7.431e-17
Cq24 ain_isb_n vss 9.265e-16
Cq25 ain_isb_p vss 8.611e-16
Cq26 ain_sin_n ain_sin_p 8.625e-17
Cq27 ain_sin_n ibias 9.414e-17
Cq28 ain_sin_n vdd 2.257e-16
Cq29 ain_sin_n vss 7.685e-16
Cq30 ain_sin_p ibias 9.681e-17
Cq31 ain_sin_p vdd 1.633e-16
Cq32 ain_sin_p vss 7.651e-16
Cq33 clk mclkb 2.216e-18
Cq34 clk sar_mclk 1.431e-16
Cq35 clk vdd 4.347e-16
Cq36 clk vss 1.85e-14
Cq37 clk xckg_d0 2.205e-16
Cq38 clk xckg_d1 1.236e-16
Cq39 clk xckg_d2 1.227e-16
Cq40 clk xckg_d3 1.663e-16
Cq41 clk xckg_nn 2.534e-17
Cq42 clk xckg_x 1.452e-16
Cq43 ibias vbn 3.378e-16
Cq44 ibias vbp 1.24e-16
Cq45 ibias vdd 6.258e-15
Cq46 ibias vdda 2.57e-16
Cq47 ibias vref 3.367e-14
Cq48 ibias vref_in 1.257e-14
Cq49 ibias vrefl 1.528e-14
Cq50 ibias vss 1.669e-13
Cq51 ibias xref_ng 2.502e-15
Cq52 ibias xref_ntl 1.763e-16
Cq53 mclkb sar_mclk 2.613e-16
Cq54 mclkb vdd 3.849e-16
Cq55 mclkb vss 1.23e-15
Cq56 mclkb xckg_d0 5.604e-17
Cq57 mclkb xckg_d1 3.991e-15
Cq58 mclkb xckg_d2 3.955e-15
Cq59 mclkb xckg_d3 6.865e-17
Cq60 mclkb xckg_nn 1.864e-17
Cq61 mclkb xckg_x 9.575e-17
Cq62 sar_mclk vdd 1.621e-15
Cq63 sar_mclk vss 6.739e-15
Cq64 sar_mclk xckg_d0 4.707e-15
Cq65 sar_mclk xckg_d1 2.058e-16
Cq66 sar_mclk xckg_d2 7.519e-17
Cq67 sar_mclk xckg_d3 9.271e-17
Cq68 sar_mclk xckg_nn 4.141e-16
Cq69 sar_mclk xckg_x 1.044e-15
Cq70 vbn vbp 4.048e-14
Cq71 vbn vdd 2.668e-14
Cq72 vbn vdda 4.597e-16
Cq73 vbn vref 1.548e-14
Cq74 vbn vref_in 2.405e-15
Cq75 vbn vrefl 8.131e-15
Cq76 vbn vss 1.116e-14
Cq77 vbn xref_ng 1.543e-15
Cq78 vbp vdd 1.669e-15
Cq79 vbp vdda 1.395e-15
Cq80 vbp vref 2.767e-14
Cq81 vbp vref_in 4.117e-15
Cq82 vbp vrefl 7.984e-15
Cq83 vbp vss 1.325e-14
Cq84 vbp xref_ng 1.886e-15
Cq85 vdd vdda 3.895e-16
Cq86 vdd vref 3.92e-14
Cq87 vdd vref_in 2.491e-14
Cq88 vdd vrefl 1.224e-14
Cq89 vdd vss 6.927e-14
Cq90 vdd xckg_d0 5.466e-16
Cq91 vdd xckg_d1 3.974e-16
Cq92 vdd xckg_d2 2.624e-16
Cq93 vdd xckg_d3 3.649e-16
Cq94 vdd xckg_x 1.1e-15
Cq95 vdd xref_ng 3.009e-15
Cq96 vdda vref 4e-14
Cq97 vdda vref_in 3.048e-16
Cq98 vdda vrefl 1.272e-14
Cq99 vdda vss 3.096e-14
Cq100 vdda xref_na 7.939e-16
Cq101 vdda xref_ng 1.455e-14
Cq102 vdda xref_ntl 1.132e-17
Cq103 vref vref_in 4.546e-14
Cq104 vref vrefl 1.197e-13
Cq105 vref vss 3.586e-13
Cq106 vref xref_na 1.908e-16
Cq107 vref xref_ng 3.832e-14
Cq108 vref xref_ntl 9.852e-16
Cq109 vref_in vrefl 3.069e-14
Cq110 vref_in vss 1.048e-13
Cq111 vref_in xref_na 4.222e-16
Cq112 vref_in xref_ng 3.86e-15
Cq113 vref_in xref_ntl 1.282e-15
Cq114 vrefl vss 1.991e-13
Cq115 vrefl xref_na 8.519e-18
Cq116 vrefl xref_ng 2.644e-14
Cq117 vrefl xref_ntl 5.775e-16
Cq118 vss xckg_d0 4.966e-15
Cq119 vss xckg_d1 4.102e-15
Cq120 vss xckg_d2 4.83e-15
Cq121 vss xckg_d3 5.854e-15
Cq122 vss xckg_nn 1.117e-15
Cq123 vss xckg_x 1.086e-14
Cq124 vss xref_na 4.919e-15
Cq125 vss xref_ng 9.404e-14
Cq126 vss xref_ntl 4.054e-15
Cq127 xckg_d0 xckg_d1 8.434e-15
Cq128 xckg_d0 xckg_d2 2.37e-16
Cq129 xckg_d0 xckg_d3 1.818e-16
Cq130 xckg_d0 xckg_nn 2.011e-17
Cq131 xckg_d0 xckg_x 6.919e-16
Cq132 xckg_d1 xckg_d2 2.001e-15
Cq133 xckg_d1 xckg_d3 1.378e-16
Cq134 xckg_d1 xckg_nn 5.907e-16
Cq135 xckg_d1 xckg_x 4.219e-16
Cq136 xckg_d2 xckg_d3 8.547e-15
Cq137 xckg_d2 xckg_nn 5.574e-16
Cq138 xckg_d2 xckg_x 4.153e-16
Cq139 xckg_d3 xckg_nn 3.667e-17
Cq140 xckg_d3 xckg_x 5.111e-15
Cq141 xckg_nn xckg_x 1.118e-16
Cq142 xref_na xref_ng 2.502e-15
Cq143 xref_na xref_ntl 3.114e-16
Cq144 xref_ng xref_ntl 2.861e-15
.ends
.subckt r1_adc_lay_pr adc_hold is_smp clk adc_start adc_sel adc_valid_a adc_raw_a_0 adc_raw_a_1 adc_raw_a_2 adc_raw_a_3 adc_raw_a_4 adc_raw_a_5 adc_raw_a_6 adc_raw_a_7 adc_raw_a_8 adc_raw_a_9 adc_raw_a_10 adc_raw_a_11 adc_raw_a_12 adc_raw_a_13 adc_valid_b adc_raw_b_0 adc_raw_b_1 adc_raw_b_2 adc_raw_b_3 adc_raw_b_4 adc_raw_b_5 adc_raw_b_6 adc_raw_b_7 adc_raw_b_8 adc_raw_b_9 adc_raw_b_10 adc_raw_b_11 adc_raw_b_12 adc_raw_b_13 por_n ain_sin_p ain_sin_n ain_cos_p ain_cos_n vcm2 ibias ain_isa_p ain_isa_n ain_isb_p ain_isb_n vcm vdda vdd vss vref_in topap topan topbp topbn sar_clka sar_clkab sar_clkb sar_clkbb sar_clkna sar_clknab sar_clknb sar_clknbb sar_cna0 sar_cna1 sar_cna10 sar_cna11 sar_cna12 sar_cna2 sar_cna3 sar_cna4 sar_cna5 sar_cna6 sar_cna7 sar_cna8 sar_cna9 sar_cnb0 sar_cnb1 sar_cnb10 sar_cnb11 sar_cnb12 sar_cnb2 sar_cnb3 sar_cnb4 sar_cnb5 sar_cnb6 sar_cnb7 sar_cnb8 sar_cnb9 sar_cpa0 sar_cpa1 sar_cpa10 sar_cpa11 sar_cpa12 sar_cpa2 sar_cpa3 sar_cpa4 sar_cpa5 sar_cpa6 sar_cpa7 sar_cpa8 sar_cpa9 sar_cpb0 sar_cpb1 sar_cpb10 sar_cpb11 sar_cpb12 sar_cpb2 sar_cpb3 sar_cpb4 sar_cpb5 sar_cpb6 sar_cpb7 sar_cpb8 sar_cpb9 sar_oan sar_oann sar_oanp sar_oap sar_obn sar_obnn sar_obnp sar_obp sar_trka0 sar_trka1 sar_trkb0 sar_trkb1 sar_mclk vref vrefl
Xxckg_xpd0 xckg_d0__p1 clk vdd__p2 vdd sg13_lv_pmos w=1u l=0.5u ng=1 m=1
Xxckg_xnd0 xckg_d0 clk vss__p9 vss sg13_lv_nmos w=0.5u l=0.5u ng=1 m=1
Xxckg_cd0 xckg_d0__p2 vss__p16 cap_cmim w=2.53u l=2.53u m=1
Xxckg_xpd1 xckg_d1__p1 xckg_d0 vdd__p3 vdd sg13_lv_pmos w=1u l=0.5u ng=1 m=1
Xxckg_xnd1 xckg_d1 xckg_d0 vss__p10 vss sg13_lv_nmos w=0.5u l=0.5u ng=1 m=1
Xxckg_cd1 xckg_d1__p2 vss__p17 cap_cmim w=2.53u l=2.53u m=1
Xxckg_xpd2 xckg_d2__p1 xckg_d1 vdd__p4 vdd sg13_lv_pmos w=1u l=0.5u ng=1 m=1
Xxckg_xnd2 xckg_d2 xckg_d1 vss__p11 vss sg13_lv_nmos w=0.5u l=0.5u ng=1 m=1
Xxckg_cd2 xckg_d2__p2 vss__p18 cap_cmim w=2.53u l=2.53u m=1
Xxckg_xpd3 xckg_d3__p1 xckg_d2 vdd__p5 vdd sg13_lv_pmos w=1u l=0.5u ng=1 m=1
Xxckg_xnd3 xckg_d3 xckg_d2 vss__p12 vss sg13_lv_nmos w=0.5u l=0.5u ng=1 m=1
Xxckg_cd3 xckg_d3__p2 vss__p19 cap_cmim w=2.53u l=2.53u m=1
Xxckg_xpd4 xckg_x__p2 xckg_d3 vdd__p6 vdd sg13_lv_pmos w=1u l=0.5u ng=1 m=1
Xxckg_xnd4 xckg_x xckg_d3 vss__p13 vss sg13_lv_nmos w=0.5u l=0.5u ng=1 m=1
Xxckg_cd4 xckg_x__p4 vss__p20 cap_cmim w=2.53u l=2.53u m=1
Xxckg_xpa sar_mclk__p2 clk__p1 vdd__p7 vdd sg13_lv_pmos w=2u l=0.13u ng=1 m=1
Xxckg_xpb sar_mclk__p3 xckg_x__p3 vdd__p8 vdd sg13_lv_pmos w=2u l=0.13u ng=1 m=1
Xxckg_xna sar_mclk clk__p0 xckg_nn vss sg13_lv_nmos w=2u l=0.13u ng=1 m=1
Xxckg_xnb xckg_nn__p1 xckg_x__p1 vss__p14 vss sg13_lv_nmos w=2u l=0.13u ng=1 m=1
Xxckg_xpi mclkb__p1 sar_mclk__p4 vdd__p9 vdd sg13_lv_pmos w=2u l=0.13u ng=1 m=1
Xxckg_xni mclkb sar_mclk__p1 vss__p15 vss sg13_lv_nmos w=1u l=0.13u ng=1 m=1
Xxcbias_xmbd vbp__p1 vbp vdd__p1 vdd sg13_lv_pmos w=0.8u l=0.5u ng=1 m=1
Xxcbias_xrb_g0 vbp xcbias_xrb_s1 vss rppd w=1u l=40u m=1 b=0
Xxcbias_xrb_g1 xcbias_xrb_s1 xcbias_xrb_s2 vss rppd w=1u l=40u m=1 b=0
Xxcbias_xrb_g2 xcbias_xrb_s2 xcbias_xrb_s3 vss rppd w=1u l=40u m=1 b=0
Xxcbias_xrb_g3 xcbias_xrb_s3 vss__p7 vss rppd w=1u l=40u m=1 b=0
Xxcbiasn_xmbd vbn__p1 vbn vss__p8 vss sg13_lv_nmos w=0.2u l=0.5u ng=1 m=1
Xxcbiasn_xrb_g0 vdd__p0 xcbiasn_xrb_s1 vss rppd w=1u l=40u m=1 b=0
Xxcbiasn_xrb_g1 xcbiasn_xrb_s1 xcbiasn_xrb_s2 vss rppd w=1u l=40u m=1 b=0
Xxcbiasn_xrb_g2 xcbiasn_xrb_s2 xcbiasn_xrb_s3 vss rppd w=1u l=40u m=1 b=0
Xxcbiasn_xrb_g3 xcbiasn_xrb_s3 vbn vss rppd w=1u l=40u m=1 b=0
Xxref_xmb0 ibias__p0 ibias vss__p5 vss sg13_hv_nmos w=2u l=1u ng=1 m=1
Xxref_xmt xref_ntl ibias vss__p6 vss sg13_hv_nmos w=2u l=8u ng=1 m=1
Xxref_xm1 xref_na vref_in xref_ntl__p1 vss sg13_hv_nmos w=10u l=1u ng=2 m=1
Xxref_xm2 xref_ng vref xref_ntl__p2 vss sg13_hv_nmos w=10u l=1u ng=2 m=1
Xxref_xm3 xref_na__p1 xref_na vdda__p5 vdda sg13_hv_pmos w=4u l=1u ng=1 m=1
Xxref_xm4 xref_ng__p1 xref_na vdda__p6 vdda sg13_hv_pmos w=4u l=1u ng=1 m=1
Xxref_xcg_u0 vss xref_ng cap_cmim w=26.32u l=95u m=1
Xxref_xmsf_s0 vdda__p1 xref_ng vref vss sg13_hv_nmos w=80u l=0.45u ng=32 m=1
Xxref_xmsf_s1 vdda__p2 xref_ng vref__p5 vss sg13_hv_nmos w=80u l=0.45u ng=32 m=1
Xxref_xmsf_s2 vdda__p3 xref_ng vref__p6 vss sg13_hv_nmos w=80u l=0.45u ng=32 m=1
Xxref_xmsf_s3 vdda__p4 xref_ng vref__p7 vss sg13_hv_nmos w=80u l=0.45u ng=32 m=1
Xxref_xmib_s0 vref__p0 ibias vss__p0 vss sg13_hv_nmos w=80u l=1u ng=40 m=1
Xxref_xmib_s1 vref__p1 ibias vss__p1 vss sg13_hv_nmos w=80u l=1u ng=40 m=1
Xxref_xmib_s2 vref__p2 ibias vss__p2 vss sg13_hv_nmos w=80u l=1u ng=40 m=1
Xxref_xmib_s3 vref__p3 ibias vss__p3 vss sg13_hv_nmos w=80u l=1u ng=40 m=1
Xxref_xcd_u0 vss vref cap_cmim w=51.58u l=95u m=4
Xxref_xmsfl_s0 vdda__p0 xref_ng vrefl vss sg13_hv_nmos w=80u l=0.45u ng=32 m=1
Xxref_xmibl_s0 vrefl__p0 ibias vss__p4 vss sg13_hv_nmos w=80u l=1u ng=40 m=1
Xxref_xcdl_u0 vss vrefl cap_cmim w=51.58u l=95u m=2
Xxfilt_xcf_u0 vss vref_in cap_cmim w=37.36u l=90u m=2
Xslice_a ain_sin_p__p1 ain_sin_n__p1 ain_isa_p__p1 ain_isa_n__p1 sar_trka0 sar_trka1 sar_cpa0 sar_cpa1 sar_cpa2 sar_cpa3 sar_cpa4 sar_cpa5 sar_cpa6 sar_cpa7 sar_cpa8 sar_cpa9 sar_cpa10 sar_cpa11 sar_cpa12 sar_cna0 sar_cna1 sar_cna2 sar_cna3 sar_cna4 sar_cna5 sar_cna6 sar_cna7 sar_cna8 sar_cna9 sar_cna10 sar_cna11 sar_cna12 sar_clka sar_clkab sar_clkna sar_clknab sar_oap sar_oan sar_oanp sar_oann vbp__p2 vbn__p2 vref__p8 vrefl__p2 vrefl__p3 topap topan vdd__p11 vdd__p12 vdd__p13 vdd__p14 vss__p22 vss__p23 vss__p24 vss__p25 r1_adc_slice_post
Xslice_b ain_cos_p__p1 ain_cos_n__p1 ain_isb_p__p1 ain_isb_n__p1 sar_trkb0 sar_trkb1 sar_cpb0 sar_cpb1 sar_cpb2 sar_cpb3 sar_cpb4 sar_cpb5 sar_cpb6 sar_cpb7 sar_cpb8 sar_cpb9 sar_cpb10 sar_cpb11 sar_cpb12 sar_cnb0 sar_cnb1 sar_cnb2 sar_cnb3 sar_cnb4 sar_cnb5 sar_cnb6 sar_cnb7 sar_cnb8 sar_cnb9 sar_cnb10 sar_cnb11 sar_cnb12 sar_clkb sar_clkbb sar_clknb sar_clknbb sar_obp sar_obn sar_obnp sar_obnn vbp__p3 vbn__p3 vref__p9 vrefl__p4 vrefl__p5 topbp topbn vdd__p15 vdd__p16 vdd__p17 vdd__p18 vss__p26 vss__p27 vss__p28 vss__p29 r1_adc_slice_post
Rt0 ain_cos_n ain_cos_n__p1 0.05
Rt1 ain_cos_p ain_cos_p__p1 0.05
Rt2 ain_isa_n ain_isa_n__p1 0.05
Rt3 ain_isa_p ain_isa_p__p1 0.05
Rt4 ain_isb_n ain_isb_n__p1 0.05
Rt5 ain_isb_p ain_isb_p__p1 0.05
Rt6 ain_sin_n ain_sin_n__p1 0.05
Rt7 ain_sin_p ain_sin_p__p1 0.05
Rt8 clk clk__p0 0.05
Rt9 clk clk__p1 0.05
Rt10 clk__p0 clk__p1 0.05
Rt11 ibias ibias__p0 0.05
Rt12 mclkb mclkb__p1 0.05
Rt13 sar_mclk sar_mclk__p1 0.05
Rt14 sar_mclk sar_mclk__p3 0.05
Rt15 sar_mclk sar_mclk__p4 0.05
Rt16 sar_mclk__p1 sar_mclk__p3 0.05
Rt17 sar_mclk__p1 sar_mclk__p4 0.05
Rt18 sar_mclk__p2 sar_mclk__p3 0.05
Rt19 sar_mclk__p3 sar_mclk__p4 0.05
Rt20 vbn vbn__p1 0.05
Rt21 vbn vbn__p2 0.05
Rt22 vbn vbn__p3 0.05
Rt23 vbn__p1 vbn__p2 0.05
Rt24 vbn__p1 vbn__p3 0.05
Rt25 vbn__p2 vbn__p3 0.05
Rt26 vbp vbp__p1 0.05
Rt27 vbp vbp__p2 0.05
Rt28 vbp vbp__p3 0.05
Rt29 vbp__p1 vbp__p2 0.05
Rt30 vbp__p1 vbp__p3 0.05
Rt31 vbp__p2 vbp__p3 0.05
Rt32 vdd vdd__p0 51.7969
Rt33 vdd vdd__p1 129.356
Rt34 vdd vdd__p11 227.932
Rt35 vdd vdd__p12 340.649
Rt36 vdd vdd__p13 1516.8
Rt37 vdd vdd__p14 3969.78
Rt38 vdd vdd__p15 7290.2
Rt39 vdd vdd__p16 18493.6
Rt40 vdd vdd__p17 198850
Rt41 vdd vdd__p18 378541
Rt42 vdd vdd__p2 9366.97
Rt43 vdd vdd__p3 12380.2
Rt44 vdd vdd__p4 16093
Rt45 vdd vdd__p5 20342.3
Rt46 vdd vdd__p6 24598.2
Rt47 vdd vdd__p7 53237.1
Rt48 vdd vdd__p8 57510.5
Rt49 vdd vdd__p9 60223.6
Rt50 vdd__p0 vdd__p1 185.206
Rt51 vdd__p0 vdd__p11 326.344
Rt52 vdd__p0 vdd__p12 487.728
Rt53 vdd__p0 vdd__p13 2171.69
Rt54 vdd__p0 vdd__p14 5683.77
Rt55 vdd__p0 vdd__p15 10437.8
Rt56 vdd__p0 vdd__p16 26478.5
Rt57 vdd__p0 vdd__p17 284706
Rt58 vdd__p0 vdd__p18 541980
Rt59 vdd__p0 vdd__p2 13411.3
Rt60 vdd__p0 vdd__p3 17725.5
Rt61 vdd__p0 vdd__p4 23041.3
Rt62 vdd__p0 vdd__p5 29125.3
Rt63 vdd__p0 vdd__p6 35218.7
Rt64 vdd__p0 vdd__p7 76222.8
Rt65 vdd__p0 vdd__p8 82341.3
Rt66 vdd__p0 vdd__p9 86225.7
Rt67 vdd__p1 vdd__p11 271.988
Rt68 vdd__p1 vdd__p12 406.492
Rt69 vdd__p1 vdd__p13 1809.98
Rt70 vdd__p1 vdd__p14 4737.09
Rt71 vdd__p1 vdd__p15 8699.31
Rt72 vdd__p1 vdd__p16 22068.2
Rt73 vdd__p1 vdd__p17 237286
Rt74 vdd__p1 vdd__p18 451709
Rt75 vdd__p1 vdd__p2 11177.5
Rt76 vdd__p1 vdd__p3 14773.1
Rt77 vdd__p1 vdd__p4 19203.5
Rt78 vdd__p1 vdd__p5 24274.2
Rt79 vdd__p1 vdd__p6 29352.7
Rt80 vdd__p1 vdd__p7 63527.2
Rt81 vdd__p1 vdd__p8 68626.7
Rt82 vdd__p1 vdd__p9 71864.1
Rt83 vdd__p11 vdd__p12 48.8126
Rt84 vdd__p11 vdd__p13 217.347
Rt85 vdd__p11 vdd__p14 568.842
Rt86 vdd__p11 vdd__p15 1044.64
Rt87 vdd__p11 vdd__p16 2650.01
Rt88 vdd__p11 vdd__p17 28493.9
Rt89 vdd__p11 vdd__p18 54242.4
Rt90 vdd__p11 vdd__p2 640.666
Rt91 vdd__p11 vdd__p3 846.759
Rt92 vdd__p11 vdd__p4 1100.7
Rt93 vdd__p11 vdd__p5 1391.34
Rt94 vdd__p11 vdd__p6 1682.42
Rt95 vdd__p11 vdd__p7 3641.22
Rt96 vdd__p11 vdd__p8 3933.51
Rt97 vdd__p11 vdd__p9 4119.07
Rt98 vdd__p12 vdd__p13 77.2099
Rt99 vdd__p12 vdd__p14 202.075
Rt100 vdd__p12 vdd__p15 371.095
Rt101 vdd__p12 vdd__p16 941.386
Rt102 vdd__p12 vdd__p17 10122.1
Rt103 vdd__p12 vdd__p18 19269
Rt104 vdd__p12 vdd__p2 2005.98
Rt105 vdd__p12 vdd__p3 2651.28
Rt106 vdd__p12 vdd__p4 3446.38
Rt107 vdd__p12 vdd__p5 4356.4
Rt108 vdd__p12 vdd__p6 5267.82
Rt109 vdd__p12 vdd__p7 11401
Rt110 vdd__p12 vdd__p8 12316.2
Rt111 vdd__p12 vdd__p9 12897.2
Rt112 vdd__p13 vdd__p14 49.1805
Rt113 vdd__p13 vdd__p15 90.3164
Rt114 vdd__p13 vdd__p16 229.113
Rt115 vdd__p13 vdd__p17 2463.51
Rt116 vdd__p13 vdd__p18 4689.65
Rt117 vdd__p13 vdd__p2 8931.97
Rt118 vdd__p13 vdd__p3 11805.3
Rt119 vdd__p13 vdd__p4 15345.6
Rt120 vdd__p13 vdd__p5 19397.6
Rt121 vdd__p13 vdd__p6 23455.9
Rt122 vdd__p13 vdd__p7 50764.8
Rt123 vdd__p13 vdd__p8 54839.8
Rt124 vdd__p13 vdd__p9 57426.8
Rt125 vdd__p14 vdd__p15 40.3724
Rt126 vdd__p14 vdd__p16 102.416
Rt127 vdd__p14 vdd__p17 1101.21
Rt128 vdd__p14 vdd__p18 2096.32
Rt129 vdd__p14 vdd__p2 23376.8
Rt130 vdd__p14 vdd__p3 30896.9
Rt131 vdd__p14 vdd__p4 40162.7
Rt132 vdd__p14 vdd__p5 50767.6
Rt133 vdd__p14 vdd__p6 61388.9
Rt134 vdd__p14 vdd__p7 132862
Rt135 vdd__p14 vdd__p8 143527
Rt136 vdd__p14 vdd__p9 150298
Rt137 vdd__p15 vdd__p16 53.0715
Rt138 vdd__p15 vdd__p17 570.644
Rt139 vdd__p15 vdd__p18 1086.31
Rt140 vdd__p15 vdd__p2 42929.8
Rt141 vdd__p15 vdd__p3 56739.8
Rt142 vdd__p15 vdd__p4 73755.8
Rt143 vdd__p15 vdd__p5 93230.9
Rt144 vdd__p15 vdd__p6 112736
Rt145 vdd__p15 vdd__p7 243991
Rt146 vdd__p15 vdd__p8 263577
Rt147 vdd__p15 vdd__p9 276011
Rt148 vdd__p16 vdd__p17 164.448
Rt149 vdd__p16 vdd__p18 313.051
Rt150 vdd__p16 vdd__p2 108904
Rt151 vdd__p16 vdd__p3 143936
Rt152 vdd__p16 vdd__p4 187102
Rt153 vdd__p16 vdd__p5 236506
Rt154 vdd__p16 vdd__p6 285987
Rt155 vdd__p16 vdd__p7 618953
Rt156 vdd__p16 vdd__p8 668637
Rt157 vdd__p16 vdd__p9 700179
Rt158 vdd__p17 vdd__p18 29.0526
Rt159 vdd__p2 vdd__p3 92.6957
Rt160 vdd__p2 vdd__p4 120.495
Rt161 vdd__p2 vdd__p5 152.311
Rt162 vdd__p2 vdd__p6 184.177
Rt163 vdd__p2 vdd__p7 398.608
Rt164 vdd__p2 vdd__p8 430.605
Rt165 vdd__p2 vdd__p9 450.919
Rt166 vdd__p3 vdd__p4 108.814
Rt167 vdd__p3 vdd__p5 137.546
Rt168 vdd__p3 vdd__p6 166.322
Rt169 vdd__p3 vdd__p7 359.966
Rt170 vdd__p3 vdd__p8 388.861
Rt171 vdd__p3 vdd__p9 407.206
Rt172 vdd__p4 vdd__p5 115.772
Rt173 vdd__p4 vdd__p6 139.993
Rt174 vdd__p4 vdd__p7 302.983
Rt175 vdd__p4 vdd__p8 327.304
Rt176 vdd__p4 vdd__p9 342.744
Rt177 vdd__p5 vdd__p6 112.042
Rt178 vdd__p5 vdd__p7 242.489
Rt179 vdd__p5 vdd__p8 261.954
Rt180 vdd__p5 vdd__p9 274.312
Rt181 vdd__p6 vdd__p7 187.851
Rt182 vdd__p6 vdd__p8 202.93
Rt183 vdd__p6 vdd__p9 212.503
Rt184 vdd__p7 vdd__p8 373.265
Rt185 vdd__p7 vdd__p9 390.874
Rt186 vdd__p8 vdd__p9 274.094
Rt187 vdda vdda__p1 30.7341
Rt188 vdda__p0 vdda__p3 66.7792
Rt189 vdda__p0 vdda__p4 64.5261
Rt190 vdda__p1 vdda__p2 19.5742
Rt191 vdda__p2 vdda__p3 93.9618
Rt192 vdda__p2 vdda__p5 66.6691
Rt193 vdda__p2 vdda__p6 85.2968
Rt194 vdda__p3 vdda__p4 23.0035
Rt195 vdda__p3 vdda__p5 88.1947
Rt196 vdda__p3 vdda__p6 68.6694
Rt197 vdda__p5 vdda__p6 80.0616
Rt198 vref vref__p1 0.05
Rt199 vref vref__p5 0.05
Rt200 vref vref__p8 0.05
Rt201 vref vref__p9 0.05
Rt202 vref__p0 vref__p1 0.05
Rt203 vref__p1 vref__p5 0.05
Rt204 vref__p1 vref__p8 0.05
Rt205 vref__p1 vref__p9 0.05
Rt206 vref__p2 vref__p3 0.05
Rt207 vref__p2 vref__p6 0.05
Rt208 vref__p5 vref__p6 0.05
Rt209 vref__p5 vref__p8 0.05
Rt210 vref__p5 vref__p9 0.05
Rt211 vref__p6 vref__p7 0.05
Rt212 vref__p8 vref__p9 0.05
Rt213 vrefl vrefl__p0 0.05
Rt214 vrefl vrefl__p2 0.05
Rt215 vrefl vrefl__p3 0.05
Rt216 vrefl vrefl__p4 0.05
Rt217 vrefl vrefl__p5 0.05
Rt218 vrefl__p0 vrefl__p2 0.05
Rt219 vrefl__p0 vrefl__p3 0.05
Rt220 vrefl__p0 vrefl__p4 0.05
Rt221 vrefl__p0 vrefl__p5 0.05
Rt222 vrefl__p2 vrefl__p3 0.05
Rt223 vrefl__p2 vrefl__p4 0.05
Rt224 vrefl__p2 vrefl__p5 0.05
Rt225 vrefl__p3 vrefl__p4 0.05
Rt226 vrefl__p3 vrefl__p5 0.05
Rt227 vrefl__p4 vrefl__p5 0.05
Rt228 vss vss__p0 64.0123
Rt229 vss vss__p1 683.259
Rt230 vss vss__p10 0.001
Rt231 vss vss__p2 371.2
Rt232 vss vss__p22 97.4665
Rt233 vss vss__p23 273.377
Rt234 vss vss__p24 471242
Rt235 vss vss__p25 358523
Rt236 vss vss__p26 51921.8
Rt237 vss vss__p27 86075
Rt238 vss vss__p28 244.041
Rt239 vss vss__p29 100.595
Rt240 vss vss__p3 217.277
Rt241 vss vss__p4 1870.56
Rt242 vss vss__p5 2480.51
Rt243 vss vss__p6 3517.19
Rt244 vss vss__p7 118.25
Rt245 vss vss__p8 119.221
Rt246 vss__p0 vss__p1 161.851
Rt247 vss__p0 vss__p2 2839.25
Rt248 vss__p0 vss__p22 263.99
Rt249 vss__p0 vss__p23 740.446
Rt250 vss__p0 vss__p24 111628
Rt251 vss__p0 vss__p25 84927.1
Rt252 vss__p0 vss__p26 12299.3
Rt253 vss__p0 vss__p27 20389.5
Rt254 vss__p0 vss__p28 1815.36
Rt255 vss__p0 vss__p29 748.299
Rt256 vss__p0 vss__p3 1661.92
Rt257 vss__p0 vss__p4 443.099
Rt258 vss__p0 vss__p5 587.584
Rt259 vss__p0 vss__p6 833.152
Rt260 vss__p0 vss__p7 320.451
Rt261 vss__p0 vss__p8 322.646
Rt262 vss__p1 vss__p2 30305.8
Rt263 vss__p1 vss__p22 2817.79
Rt264 vss__p1 vss__p23 7903.42
Rt265 vss__p1 vss__p24 84165.5
Rt266 vss__p1 vss__p25 64033.5
Rt267 vss__p1 vss__p26 9273.42
Rt268 vss__p1 vss__p27 15373.3
Rt269 vss__p1 vss__p28 19376.9
Rt270 vss__p1 vss__p29 7987.25
Rt271 vss__p1 vss__p3 17739.1
Rt272 vss__p1 vss__p4 334.089
Rt273 vss__p1 vss__p5 443.028
Rt274 vss__p1 vss__p6 628.182
Rt275 vss__p1 vss__p7 3420.45
Rt276 vss__p1 vss__p8 3443.88
Rt277 vss__p10 vss__p11 113.514
Rt278 vss__p10 vss__p12 143.98
Rt279 vss__p10 vss__p13 175.022
Rt280 vss__p10 vss__p14 393.007
Rt281 vss__p10 vss__p15 251.471
Rt282 vss__p10 vss__p16 619.655
Rt283 vss__p10 vss__p17 663.526
Rt284 vss__p10 vss__p18 489.378
Rt285 vss__p10 vss__p19 10540.7
Rt286 vss__p10 vss__p20 51601.3
Rt287 vss__p10 vss__p9 98.2846
Rt288 vss__p11 vss__p12 120.167
Rt289 vss__p11 vss__p13 146.721
Rt290 vss__p11 vss__p14 381.007
Rt291 vss__p11 vss__p15 213.501
Rt292 vss__p11 vss__p16 622.078
Rt293 vss__p11 vss__p17 666.121
Rt294 vss__p11 vss__p18 491.292
Rt295 vss__p11 vss__p19 10581.9
Rt296 vss__p11 vss__p20 51803
Rt297 vss__p11 vss__p9 127.728
Rt298 vss__p12 vss__p13 117.108
Rt299 vss__p12 vss__p14 339.683
Rt300 vss__p12 vss__p15 171.879
Rt301 vss__p12 vss__p16 572.183
Rt302 vss__p12 vss__p17 612.694
Rt303 vss__p12 vss__p18 451.887
Rt304 vss__p12 vss__p19 9733.2
Rt305 vss__p12 vss__p20 47648.1
Rt306 vss__p12 vss__p9 161.388
Rt307 vss__p13 vss__p14 283.157
Rt308 vss__p13 vss__p15 133.639
Rt309 vss__p13 vss__p16 488.476
Rt310 vss__p13 vss__p17 523.06
Rt311 vss__p13 vss__p18 385.779
Rt312 vss__p13 vss__p19 8309.28
Rt313 vss__p13 vss__p20 40677.4
Rt314 vss__p13 vss__p9 195.03
Rt315 vss__p14 vss__p15 225.414
Rt316 vss__p14 vss__p16 211.446
Rt317 vss__p14 vss__p17 226.416
Rt318 vss__p14 vss__p18 166.991
Rt319 vss__p14 vss__p19 3596.83
Rt320 vss__p14 vss__p20 17608
Rt321 vss__p14 vss__p9 371.254
Rt322 vss__p15 vss__p16 338.846
Rt323 vss__p15 vss__p17 362.836
Rt324 vss__p15 vss__p18 267.607
Rt325 vss__p15 vss__p19 5763.98
Rt326 vss__p15 vss__p20 28217.1
Rt327 vss__p15 vss__p9 275.605
Rt328 vss__p16 vss__p17 48.9479
Rt329 vss__p16 vss__p18 36.1012
Rt330 vss__p16 vss__p19 777.582
Rt331 vss__p16 vss__p20 3806.59
Rt332 vss__p16 vss__p9 566.446
Rt333 vss__p17 vss__p18 34.3505
Rt334 vss__p17 vss__p19 739.876
Rt335 vss__p17 vss__p20 3622
Rt336 vss__p17 vss__p9 606.55
Rt337 vss__p18 vss__p19 0.666482
Rt338 vss__p18 vss__p20 3.26271
Rt339 vss__p18 vss__p9 447.356
Rt340 vss__p19 vss__p20 0.970961
Rt341 vss__p19 vss__p9 9635.59
Rt342 vss__p2 vss__p22 4002.37
Rt343 vss__p2 vss__p23 11226
Rt344 vss__p2 vss__p28 1236.98
Rt345 vss__p2 vss__p29 509.888
Rt346 vss__p2 vss__p3 62.1518
Rt347 vss__p2 vss__p4 82968.3
Rt348 vss__p2 vss__p5 110022
Rt349 vss__p2 vss__p6 156004
Rt350 vss__p2 vss__p7 4737.78
Rt351 vss__p2 vss__p8 4990.17
Rt352 vss__p20 vss__p9 47170.3
Rt353 vss__p22 vss__p23 13.1644
Rt354 vss__p22 vss__p26 214128
Rt355 vss__p22 vss__p27 354978
Rt356 vss__p22 vss__p28 2291.22
Rt357 vss__p22 vss__p29 944.448
Rt358 vss__p22 vss__p3 2342.74
Rt359 vss__p22 vss__p4 7714.29
Rt360 vss__p22 vss__p5 10229.7
Rt361 vss__p22 vss__p6 14505
Rt362 vss__p22 vss__p7 105.519
Rt363 vss__p22 vss__p8 133.386
Rt364 vss__p23 vss__p26 600593
Rt365 vss__p23 vss__p27 995651
Rt366 vss__p23 vss__p28 6426.46
Rt367 vss__p23 vss__p29 2649.01
Rt368 vss__p23 vss__p3 6570.98
Rt369 vss__p23 vss__p4 21637.2
Rt370 vss__p23 vss__p5 28692.7
Rt371 vss__p23 vss__p6 40684.2
Rt372 vss__p23 vss__p7 295.961
Rt373 vss__p23 vss__p8 374.125
Rt374 vss__p24 vss__p25 97.1468
Rt375 vss__p24 vss__p26 129.246
Rt376 vss__p24 vss__p27 1768.45
Rt377 vss__p24 vss__p4 19241.6
Rt378 vss__p24 vss__p5 8459.44
Rt379 vss__p24 vss__p6 1790.84
Rt380 vss__p25 vss__p26 98.3311
Rt381 vss__p25 vss__p27 1345.45
Rt382 vss__p25 vss__p4 14639.1
Rt383 vss__p25 vss__p5 6435.98
Rt384 vss__p25 vss__p6 1362.48
Rt385 vss__p26 vss__p27 194.85
Rt386 vss__p26 vss__p29 606963
Rt387 vss__p26 vss__p4 2120.05
Rt388 vss__p26 vss__p5 932.068
Rt389 vss__p26 vss__p6 197.317
Rt390 vss__p26 vss__p7 259925
Rt391 vss__p26 vss__p8 261706
Rt392 vss__p27 vss__p4 3514.58
Rt393 vss__p27 vss__p5 1545.17
Rt394 vss__p27 vss__p6 327.108
Rt395 vss__p27 vss__p7 430899
Rt396 vss__p27 vss__p8 433851
Rt397 vss__p28 vss__p29 11.3118
Rt398 vss__p28 vss__p3 724.052
Rt399 vss__p28 vss__p4 53048.4
Rt400 vss__p28 vss__p5 70346.2
Rt401 vss__p28 vss__p6 99746
Rt402 vss__p28 vss__p7 2611
Rt403 vss__p28 vss__p8 2945.87
Rt404 vss__p29 vss__p3 298.457
Rt405 vss__p29 vss__p4 21866.7
Rt406 vss__p29 vss__p5 28997
Rt407 vss__p29 vss__p6 41115.7
Rt408 vss__p29 vss__p7 1076.26
Rt409 vss__p29 vss__p8 1214.3
Rt410 vss__p3 vss__p4 48564.5
Rt411 vss__p3 vss__p5 64400.3
Rt412 vss__p3 vss__p6 91315
Rt413 vss__p3 vss__p7 2773.2
Rt414 vss__p3 vss__p8 2920.94
Rt415 vss__p4 vss__p5 101.283
Rt416 vss__p4 vss__p6 143.612
Rt417 vss__p4 vss__p7 9364.19
Rt418 vss__p4 vss__p8 9428.33
Rt419 vss__p5 vss__p6 63.1383
Rt420 vss__p5 vss__p7 12417.6
Rt421 vss__p5 vss__p8 12502.7
Rt422 vss__p6 vss__p7 17607.3
Rt423 vss__p6 vss__p8 17727.9
Rt424 vss__p7 vss__p8 171.407
Rt425 xckg_d0 xckg_d0__p1 0.05
Rt426 xckg_d0 xckg_d0__p2 0.05
Rt427 xckg_d0__p1 xckg_d0__p2 0.05
Rt428 xckg_d1 xckg_d1__p1 0.05
Rt429 xckg_d1 xckg_d1__p2 0.05
Rt430 xckg_d1__p1 xckg_d1__p2 0.05
Rt431 xckg_d2 xckg_d2__p1 0.05
Rt432 xckg_d2 xckg_d2__p2 0.05
Rt433 xckg_d2__p1 xckg_d2__p2 0.05
Rt434 xckg_d3 xckg_d3__p1 0.05
Rt435 xckg_d3 xckg_d3__p2 0.05
Rt436 xckg_d3__p1 xckg_d3__p2 0.05
Rt437 xckg_nn xckg_nn__p1 0.05
Rt438 xckg_x xckg_x__p1 0.05
Rt439 xckg_x xckg_x__p2 0.05
Rt440 xckg_x xckg_x__p3 0.05
Rt441 xckg_x xckg_x__p4 0.05
Rt442 xckg_x__p1 xckg_x__p2 0.05
Rt443 xckg_x__p1 xckg_x__p3 0.05
Rt444 xckg_x__p1 xckg_x__p4 0.05
Rt445 xckg_x__p2 xckg_x__p3 0.05
Rt446 xckg_x__p2 xckg_x__p4 0.05
Rt447 xckg_x__p3 xckg_x__p4 0.05
Rt448 xref_na xref_na__p1 0.05
Rt449 xref_ng xref_ng__p1 0.05
Rt450 xref_ntl xref_ntl__p1 0.05
Rt451 xref_ntl__p1 xref_ntl__p2 0.05
Cq0 ain_cos_n ain_cos_p 2.709e-14
Cq1 ain_cos_n ain_isa_n 3.644e-17
Cq2 ain_cos_n ain_isa_p 4.64e-17
Cq3 ain_cos_n ibias 5.314e-17
Cq4 ain_cos_n vdd 5.829e-16
Cq5 ain_cos_n vss 2.705e-14
Cq6 ain_cos_n xckg_d0 9.755e-19
Cq7 ain_cos_n xckg_d1 9.755e-19
Cq8 ain_cos_n xckg_d2 9.755e-19
Cq9 ain_cos_n xckg_d3 1.006e-18
Cq10 ain_cos_n xckg_x 5.633e-18
Cq11 ain_cos_p ain_isa_n 4.287e-17
Cq12 ain_cos_p ain_isa_p 7.229e-16
Cq13 ain_cos_p ibias 3.52e-15
Cq14 ain_cos_p vdd 2.509e-15
Cq15 ain_cos_p vss 1.273e-14
Cq16 ain_isa_n ain_isa_p 2.783e-14
Cq17 ain_isa_n ain_isb_n 6.15e-17
Cq18 ain_isa_n ain_isb_p 6.417e-17
Cq19 ain_isa_n vss 2.894e-14
Cq20 ain_isa_p ain_isb_n 7.645e-17
Cq21 ain_isa_p ain_isb_p 7.912e-17
Cq22 ain_isa_p vss 2.868e-14
Cq23 ain_isb_n ain_isb_p 7.431e-17
Cq24 ain_isb_n vss 9.265e-16
Cq25 ain_isb_p vss 8.611e-16
Cq26 ain_sin_n ain_sin_p 8.625e-17
Cq27 ain_sin_n ibias 9.414e-17
Cq28 ain_sin_n vdd 2.257e-16
Cq29 ain_sin_n vss 7.685e-16
Cq30 ain_sin_p ibias 9.681e-17
Cq31 ain_sin_p vdd 1.633e-16
Cq32 ain_sin_p vss 7.651e-16
Cq33 clk mclkb 2.216e-18
Cq34 clk sar_mclk 1.431e-16
Cq35 clk vdd 4.347e-16
Cq36 clk vss 1.85e-14
Cq37 clk xckg_d0 2.205e-16
Cq38 clk xckg_d1 1.236e-16
Cq39 clk xckg_d2 1.227e-16
Cq40 clk xckg_d3 1.663e-16
Cq41 clk xckg_nn 2.534e-17
Cq42 clk xckg_x 1.452e-16
Cq43 ibias vbn 3.378e-16
Cq44 ibias vbp 1.24e-16
Cq45 ibias vdd 6.258e-15
Cq46 ibias vdda 2.57e-16
Cq47 ibias vref 3.367e-14
Cq48 ibias vref_in 1.257e-14
Cq49 ibias vrefl 1.528e-14
Cq50 ibias vss 1.669e-13
Cq51 ibias xref_ng 2.502e-15
Cq52 ibias xref_ntl 1.763e-16
Cq53 mclkb sar_mclk 2.613e-16
Cq54 mclkb vdd 3.849e-16
Cq55 mclkb vss 1.23e-15
Cq56 mclkb xckg_d0 5.604e-17
Cq57 mclkb xckg_d1 3.991e-15
Cq58 mclkb xckg_d2 3.955e-15
Cq59 mclkb xckg_d3 6.865e-17
Cq60 mclkb xckg_nn 1.864e-17
Cq61 mclkb xckg_x 9.575e-17
Cq62 sar_mclk vdd 1.621e-15
Cq63 sar_mclk vss 6.739e-15
Cq64 sar_mclk xckg_d0 4.707e-15
Cq65 sar_mclk xckg_d1 2.058e-16
Cq66 sar_mclk xckg_d2 7.519e-17
Cq67 sar_mclk xckg_d3 9.271e-17
Cq68 sar_mclk xckg_nn 4.141e-16
Cq69 sar_mclk xckg_x 1.044e-15
Cq70 vbn vbp 4.048e-14
Cq71 vbn vdd 2.668e-14
Cq72 vbn vdda 4.597e-16
Cq73 vbn vref 1.548e-14
Cq74 vbn vref_in 2.405e-15
Cq75 vbn vrefl 8.131e-15
Cq76 vbn vss 1.116e-14
Cq77 vbn xref_ng 1.543e-15
Cq78 vbp vdd 1.669e-15
Cq79 vbp vdda 1.395e-15
Cq80 vbp vref 2.767e-14
Cq81 vbp vref_in 4.117e-15
Cq82 vbp vrefl 7.984e-15
Cq83 vbp vss 1.325e-14
Cq84 vbp xref_ng 1.886e-15
Cq85 vdd vdda 3.895e-16
Cq86 vdd vref 3.92e-14
Cq87 vdd vref_in 2.491e-14
Cq88 vdd vrefl 1.224e-14
Cq89 vdd vss 6.927e-14
Cq90 vdd xckg_d0 5.466e-16
Cq91 vdd xckg_d1 3.974e-16
Cq92 vdd xckg_d2 2.624e-16
Cq93 vdd xckg_d3 3.649e-16
Cq94 vdd xckg_x 1.1e-15
Cq95 vdd xref_ng 3.009e-15
Cq96 vdda vref 4e-14
Cq97 vdda vref_in 3.048e-16
Cq98 vdda vrefl 1.272e-14
Cq99 vdda vss 3.096e-14
Cq100 vdda xref_na 7.939e-16
Cq101 vdda xref_ng 1.455e-14
Cq102 vdda xref_ntl 1.132e-17
Cq103 vref vref_in 4.546e-14
Cq104 vref vrefl 1.197e-13
Cq105 vref vss 3.586e-13
Cq106 vref xref_na 1.908e-16
Cq107 vref xref_ng 3.832e-14
Cq108 vref xref_ntl 9.852e-16
Cq109 vref_in vrefl 3.069e-14
Cq110 vref_in vss 1.048e-13
Cq111 vref_in xref_na 4.222e-16
Cq112 vref_in xref_ng 3.86e-15
Cq113 vref_in xref_ntl 1.282e-15
Cq114 vrefl vss 1.991e-13
Cq115 vrefl xref_na 8.519e-18
Cq116 vrefl xref_ng 2.644e-14
Cq117 vrefl xref_ntl 5.775e-16
Cq118 vss xckg_d0 4.966e-15
Cq119 vss xckg_d1 4.102e-15
Cq120 vss xckg_d2 4.83e-15
Cq121 vss xckg_d3 5.854e-15
Cq122 vss xckg_nn 1.117e-15
Cq123 vss xckg_x 1.086e-14
Cq124 vss xref_na 4.919e-15
Cq125 vss xref_ng 9.404e-14
Cq126 vss xref_ntl 4.054e-15
Cq127 xckg_d0 xckg_d1 8.434e-15
Cq128 xckg_d0 xckg_d2 2.37e-16
Cq129 xckg_d0 xckg_d3 1.818e-16
Cq130 xckg_d0 xckg_nn 2.011e-17
Cq131 xckg_d0 xckg_x 6.919e-16
Cq132 xckg_d1 xckg_d2 2.001e-15
Cq133 xckg_d1 xckg_d3 1.378e-16
Cq134 xckg_d1 xckg_nn 5.907e-16
Cq135 xckg_d1 xckg_x 4.219e-16
Cq136 xckg_d2 xckg_d3 8.547e-15
Cq137 xckg_d2 xckg_nn 5.574e-16
Cq138 xckg_d2 xckg_x 4.153e-16
Cq139 xckg_d3 xckg_nn 3.667e-17
Cq140 xckg_d3 xckg_x 5.111e-15
Cq141 xckg_nn xckg_x 1.118e-16
Cq142 xref_na xref_ng 2.502e-15
Cq143 xref_na xref_ntl 3.114e-16
Cq144 xref_ng xref_ntl 2.861e-15
.ends
