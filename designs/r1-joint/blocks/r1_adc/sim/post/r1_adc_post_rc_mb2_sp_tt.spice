* r1_adc_post_rc_mb2_sp_tt.spice: r1_adc_post_rc_mb2.spice with ideal slice references from op run postb2-op-tt-rc (sim/post/make_sp_netlist.py)
* merged by sim/post/merge_parallel.py from ../../pex/r1_adc_post_rc_b2.spice (sha256 f940a0099b3d832a): 668 -> 295 device instances (identical parallel devices as m = count)
* r1_adc post-layout netlist, layout B (RC), written by pex/pex_build.py; see its docstring
* devices: LVS reference of layout/r1_adc_netlist.py; R: KLayout RNetExtractor Metal1-5/Via1-4; C: kpex 0.3.12 2.5D CC
* requires cornerMOSlv/hv.lib, cornerCAP.lib, cornerRES.lib
.subckt r1_adc_slice_post in0p in0n in1p in1n trk0 trk1 cp0 cp1 cp2 cp3 cp4 cp5 cp6 cp7 cp8 cp9 cp10 cp11 cp12 cn0 cn1 cn2 cn3 cn4 cn5 cn6 cn7 cn8 cn9 cn10 cn11 cn12 clk clkb clkn clknb op on onp onn vbp vbn vref vref__p11 vref__p12 vrefl vrefl__p19 top_p top_n vdd vdd__p36 vdd__p37 vdd__p38 gnd gnd__p59 gnd__p60 gnd__p61 gnd__p62 gnd__p63 gnd__p64 gnd__p65
Xxpt0a t0b__p7 trk0__p1 vdd__p12 vdd sg13_lv_pmos w=2u l=0.13u ng=1 m=1
Xxnt0a t0b__p4 trk0 gnd__p36 gnd sg13_lv_nmos w=1u l=0.13u ng=1 m=1
Xxpt0b t0__p5 t0b__p8 vdd__p13 vdd sg13_lv_pmos w=4u l=0.13u ng=1 m=1
Xxnt0b t0__p4 t0b__p5 gnd__p37 gnd sg13_lv_nmos w=2u l=0.13u ng=1 m=1
Xxpt1a t1b__p7 trk1__p1 vdd__p14 vdd sg13_lv_pmos w=2u l=0.13u ng=1 m=1
Xxnt1a t1b__p4 trk1 gnd__p38 gnd sg13_lv_nmos w=1u l=0.13u ng=1 m=1
Xxpt1b t1__p5 t1b__p8 vdd__p15 vdd sg13_lv_pmos w=4u l=0.13u ng=1 m=1
Xxnt1b t1__p4 t1b__p5 gnd__p39 gnd sg13_lv_nmos w=2u l=0.13u ng=1 m=1
Xxs0p_xms in0p__p0 xs0p_g top_p__p2 gnd sg13_lv_nmos w=6u l=0.13u ng=2 m=1
Xxs0p_cboot xs0p_cbp__p2 xs0p_cbn__p4 cap_cmim w=11.49u l=11.49u m=1
Xxs0p_xm1 xs0p_cbn__p1 t0b__p2 gnd__p30 gnd sg13_lv_nmos w=1u l=0.13u ng=1 m=1
Xxs0p_xm3 xs0p_cbp xs0p_g__p4 vdd__p4 xs0p_cbp sg13_lv_pmos w=1u l=0.13u ng=1 m=1
Xxs0p_xm8 xs0p_g__p5 xs0p_x__p2 xs0p_cbp__p1 xs0p_cbp sg13_lv_pmos w=2u l=0.13u ng=1 m=1
Xxs0p_xm4 xs0p_x__p3 t0__p3 vdd__p5 vdd sg13_lv_pmos w=0.5u l=0.13u ng=1 m=1
Xxs0p_xm5 xs0p_x t0__p2 xs0p_cbn__p2 gnd sg13_lv_nmos w=1u l=0.13u ng=1 m=1
Xxs0p_xm7 xs0p_x__p1 xs0p_g__p2 xs0p_cbn__p3 gnd sg13_lv_nmos w=0.5u l=0.13u ng=1 m=1
Xxs0p_xm9 xs0p_cbn xs0p_g__p1 in0p__p1 gnd sg13_lv_nmos w=2u l=0.13u ng=1 m=1
Xxs0p_xm10 xs0p_g__p3 vdd__p3 xs0p_n10 gnd sg13_lv_nmos w=2u l=0.13u ng=1 m=1
Xxs0p_xm11 xs0p_n10__p1 t0b__p3 gnd__p31 gnd sg13_lv_nmos w=2u l=0.13u ng=1 m=1
Xxs0n_xms in0n__p0 xs0n_g top_n__p2 gnd sg13_lv_nmos w=6u l=0.13u ng=2 m=1
Xxs0n_cboot xs0n_cbp__p2 xs0n_cbn__p4 cap_cmim w=11.49u l=11.49u m=1
Xxs0n_xm1 xs0n_cbn__p1 t0b gnd__p28 gnd sg13_lv_nmos w=1u l=0.13u ng=1 m=1
Xxs0n_xm3 xs0n_cbp xs0n_g__p4 vdd__p1 xs0n_cbp sg13_lv_pmos w=1u l=0.13u ng=1 m=1
Xxs0n_xm8 xs0n_g__p5 xs0n_x__p2 xs0n_cbp__p1 xs0n_cbp sg13_lv_pmos w=2u l=0.13u ng=1 m=1
Xxs0n_xm4 xs0n_x__p3 t0__p1 vdd__p2 vdd sg13_lv_pmos w=0.5u l=0.13u ng=1 m=1
Xxs0n_xm5 xs0n_x t0 xs0n_cbn__p2 gnd sg13_lv_nmos w=1u l=0.13u ng=1 m=1
Xxs0n_xm7 xs0n_x__p1 xs0n_g__p2 xs0n_cbn__p3 gnd sg13_lv_nmos w=0.5u l=0.13u ng=1 m=1
Xxs0n_xm9 xs0n_cbn xs0n_g__p1 in0n__p1 gnd sg13_lv_nmos w=2u l=0.13u ng=1 m=1
Xxs0n_xm10 xs0n_g__p3 vdd__p0 xs0n_n10 gnd sg13_lv_nmos w=2u l=0.13u ng=1 m=1
Xxs0n_xm11 xs0n_n10__p1 t0b__p1 gnd__p29 gnd sg13_lv_nmos w=2u l=0.13u ng=1 m=1
Xxs1p_xms in1p__p0 xs1p_g top_p__p3 gnd sg13_lv_nmos w=6u l=0.13u ng=2 m=1
Xxs1p_cboot xs1p_cbp__p2 xs1p_cbn__p4 cap_cmim w=11.49u l=11.49u m=1
Xxs1p_xm1 xs1p_cbn__p1 t1b__p2 gnd__p34 gnd sg13_lv_nmos w=1u l=0.13u ng=1 m=1
Xxs1p_xm3 xs1p_cbp xs1p_g__p4 vdd__p10 xs1p_cbp sg13_lv_pmos w=1u l=0.13u ng=1 m=1
Xxs1p_xm8 xs1p_g__p5 xs1p_x__p2 xs1p_cbp__p1 xs1p_cbp sg13_lv_pmos w=2u l=0.13u ng=1 m=1
Xxs1p_xm4 xs1p_x__p3 t1__p3 vdd__p11 vdd sg13_lv_pmos w=0.5u l=0.13u ng=1 m=1
Xxs1p_xm5 xs1p_x t1__p2 xs1p_cbn__p2 gnd sg13_lv_nmos w=1u l=0.13u ng=1 m=1
Xxs1p_xm7 xs1p_x__p1 xs1p_g__p2 xs1p_cbn__p3 gnd sg13_lv_nmos w=0.5u l=0.13u ng=1 m=1
Xxs1p_xm9 xs1p_cbn xs1p_g__p1 in1p__p1 gnd sg13_lv_nmos w=2u l=0.13u ng=1 m=1
Xxs1p_xm10 xs1p_g__p3 vdd__p9 xs1p_n10 gnd sg13_lv_nmos w=2u l=0.13u ng=1 m=1
Xxs1p_xm11 xs1p_n10__p1 t1b__p3 gnd__p35 gnd sg13_lv_nmos w=2u l=0.13u ng=1 m=1
Xxs1n_xms in1n__p0 xs1n_g top_n__p3 gnd sg13_lv_nmos w=6u l=0.13u ng=2 m=1
Xxs1n_cboot xs1n_cbp__p2 xs1n_cbn__p4 cap_cmim w=11.49u l=11.49u m=1
Xxs1n_xm1 xs1n_cbn__p1 t1b gnd__p32 gnd sg13_lv_nmos w=1u l=0.13u ng=1 m=1
Xxs1n_xm3 xs1n_cbp xs1n_g__p4 vdd__p7 xs1n_cbp sg13_lv_pmos w=1u l=0.13u ng=1 m=1
Xxs1n_xm8 xs1n_g__p5 xs1n_x__p2 xs1n_cbp__p1 xs1n_cbp sg13_lv_pmos w=2u l=0.13u ng=1 m=1
Xxs1n_xm4 xs1n_x__p3 t1__p1 vdd__p8 vdd sg13_lv_pmos w=0.5u l=0.13u ng=1 m=1
Xxs1n_xm5 xs1n_x t1 xs1n_cbn__p2 gnd sg13_lv_nmos w=1u l=0.13u ng=1 m=1
Xxs1n_xm7 xs1n_x__p1 xs1n_g__p2 xs1n_cbn__p3 gnd sg13_lv_nmos w=0.5u l=0.13u ng=1 m=1
Xxs1n_xm9 xs1n_cbn xs1n_g__p1 in1n__p1 gnd sg13_lv_nmos w=2u l=0.13u ng=1 m=1
Xxs1n_xm10 xs1n_g__p3 vdd__p6 xs1n_n10 gnd sg13_lv_nmos w=2u l=0.13u ng=1 m=1
Xxs1n_xm11 xs1n_n10__p1 t1b__p1 gnd__p33 gnd sg13_lv_nmos w=2u l=0.13u ng=1 m=1
Xxpr1 rstb_n__p2 t0b__p9 vdd__p16 vdd sg13_lv_pmos w=1u l=0.13u ng=1 m=1
Xxpr2 rstb_n__p3 t1b__p9 vdd__p17 vdd sg13_lv_pmos w=1u l=0.13u ng=1 m=1
Xxnr1 rstb_n t0b__p6 nr gnd sg13_lv_nmos w=1u l=0.13u ng=1 m=1
Xxnr2 nr__p1 t1b__p6 gnd__p40 gnd sg13_lv_nmos w=1u l=0.13u ng=1 m=1
Xxpr3 rstb__p3 rstb_n__p4 vdd__p18 vdd sg13_lv_pmos w=1u l=0.13u ng=1 m=1
Xxnr3 rstb__p2 rstb_n__p1 gnd__p41 gnd sg13_lv_nmos w=0.5u l=0.13u ng=1 m=1
Xxlrp lsb_p rstb__p1 vrefl__p9 vrefl sg13_lv_pmos w=1u l=0.13u ng=1 m=1
Xxlrn lsb_n rstb vrefl__p8 vrefl sg13_lv_pmos w=1u l=0.13u ng=1 m=1
Xxdp12_xmp bp12 cp12 vref__p5 vref sg13_lv_pmos w=2u l=0.13u ng=1 m=1
Xxdp12_xmn bp12__p1 cp12__p1 gnd__p13 gnd sg13_lv_nmos w=1u l=0.13u ng=1 m=1
Xxdp11_xmp bp11 cp11 vref__p6 vref sg13_lv_pmos w=2u l=0.13u ng=1 m=1
Xxdp11_xmn bp11__p1 cp11__p1 gnd__p14 gnd sg13_lv_nmos w=1u l=0.13u ng=1 m=1
Xxdp10_xmp bp10 cp10 vref__p7 vref sg13_lv_pmos w=2u l=0.13u ng=1 m=1
Xxdp10_xmn bp10__p1 cp10__p1 gnd__p15 gnd sg13_lv_nmos w=1u l=0.13u ng=1 m=1
Xxdp9_xmp bp9 cp9 vref__p8 vref sg13_lv_pmos w=1u l=0.13u ng=1 m=1
Xxdp9_xmn bp9__p1 cp9__p1 gnd__p16 gnd sg13_lv_nmos w=0.5u l=0.13u ng=1 m=1
Xxdp8_xmp bp8 cp8 vref__p9 vref sg13_lv_pmos w=1u l=0.13u ng=1 m=1
Xxdp8_xmn bp8__p1 cp8__p1 gnd__p17 gnd sg13_lv_nmos w=0.5u l=0.13u ng=1 m=1
Xxdp7_xmp bp7 cp7 vrefl__p10 vrefl sg13_lv_pmos w=1u l=0.13u ng=1 m=1
Xxdp7_xmn bp7__p1 cp7__p1 gnd__p18 gnd sg13_lv_nmos w=0.5u l=0.13u ng=1 m=1
Xxdp6_xmp bp6 cp6 vrefl__p11 vrefl sg13_lv_pmos w=1u l=0.13u ng=1 m=1
Xxdp6_xmn bp6__p1 cp6__p1 gnd__p19 gnd sg13_lv_nmos w=0.5u l=0.13u ng=1 m=1
Xxdp5_xmp bp5 cp5 vrefl__p12 vrefl sg13_lv_pmos w=1u l=0.13u ng=1 m=1
Xxdp5_xmn bp5__p1 cp5__p1 gnd__p20 gnd sg13_lv_nmos w=0.5u l=0.13u ng=1 m=1
Xxdp4_xmp bp4 cp4 vrefl__p13 vrefl sg13_lv_pmos w=1u l=0.13u ng=1 m=1
Xxdp4_xmn bp4__p1 cp4__p1 gnd__p21 gnd sg13_lv_nmos w=0.5u l=0.13u ng=1 m=1
Xxdp3_xmp bp3 cp3 vrefl__p14 vrefl sg13_lv_pmos w=1u l=0.13u ng=1 m=1
Xxdp3_xmn bp3__p1 cp3__p1 gnd__p22 gnd sg13_lv_nmos w=0.5u l=0.13u ng=1 m=1
Xxdp2_xmp bp2 cp2 vrefl__p15 vrefl sg13_lv_pmos w=1u l=0.13u ng=1 m=1
Xxdp2_xmn bp2__p1 cp2__p1 gnd__p23 gnd sg13_lv_nmos w=0.5u l=0.13u ng=1 m=1
Xxdp1_xmp bp1 cp1 vrefl__p16 vrefl sg13_lv_pmos w=1u l=0.13u ng=1 m=1
Xxdp1_xmn bp1__p1 cp1__p1 gnd__p24 gnd sg13_lv_nmos w=0.5u l=0.13u ng=1 m=1
Xxdp0_xmp bp0 cp0 vrefl__p17 vrefl sg13_lv_pmos w=1u l=0.13u ng=1 m=1
Xxdp0_xmn bp0__p1 cp0__p1 gnd__p25 gnd sg13_lv_nmos w=0.5u l=0.13u ng=1 m=1
Xxdn12_xmp bn12 cn12 vref__p4 vref sg13_lv_pmos w=2u l=0.13u ng=1 m=1
Xxdn12_xmn bn12__p1 cn12__p1 gnd__p12 gnd sg13_lv_nmos w=1u l=0.13u ng=1 m=1
Xxdn11_xmp bn11 cn11 vref__p3 vref sg13_lv_pmos w=2u l=0.13u ng=1 m=1
Xxdn11_xmn bn11__p1 cn11__p1 gnd__p11 gnd sg13_lv_nmos w=1u l=0.13u ng=1 m=1
Xxdn10_xmp bn10 cn10 vref__p2 vref sg13_lv_pmos w=2u l=0.13u ng=1 m=1
Xxdn10_xmn bn10__p1 cn10__p1 gnd__p10 gnd sg13_lv_nmos w=1u l=0.13u ng=1 m=1
Xxdn9_xmp bn9 cn9 vref__p1 vref sg13_lv_pmos w=1u l=0.13u ng=1 m=1
Xxdn9_xmn bn9__p1 cn9__p1 gnd__p9 gnd sg13_lv_nmos w=0.5u l=0.13u ng=1 m=1
Xxdn8_xmp bn8 cn8 vref__p0 vref sg13_lv_pmos w=1u l=0.13u ng=1 m=1
Xxdn8_xmn bn8__p1 cn8__p1 gnd__p8 gnd sg13_lv_nmos w=0.5u l=0.13u ng=1 m=1
Xxdn7_xmp bn7 cn7 vrefl__p7 vrefl sg13_lv_pmos w=1u l=0.13u ng=1 m=1
Xxdn7_xmn bn7__p1 cn7__p1 gnd__p7 gnd sg13_lv_nmos w=0.5u l=0.13u ng=1 m=1
Xxdn6_xmp bn6 cn6 vrefl__p6 vrefl sg13_lv_pmos w=1u l=0.13u ng=1 m=1
Xxdn6_xmn bn6__p1 cn6__p1 gnd__p6 gnd sg13_lv_nmos w=0.5u l=0.13u ng=1 m=1
Xxdn5_xmp bn5 cn5 vrefl__p5 vrefl sg13_lv_pmos w=1u l=0.13u ng=1 m=1
Xxdn5_xmn bn5__p1 cn5__p1 gnd__p5 gnd sg13_lv_nmos w=0.5u l=0.13u ng=1 m=1
Xxdn4_xmp bn4 cn4 vrefl__p4 vrefl sg13_lv_pmos w=1u l=0.13u ng=1 m=1
Xxdn4_xmn bn4__p1 cn4__p1 gnd__p4 gnd sg13_lv_nmos w=0.5u l=0.13u ng=1 m=1
Xxdn3_xmp bn3 cn3 vrefl__p3 vrefl sg13_lv_pmos w=1u l=0.13u ng=1 m=1
Xxdn3_xmn bn3__p1 cn3__p1 gnd__p3 gnd sg13_lv_nmos w=0.5u l=0.13u ng=1 m=1
Xxdn2_xmp bn2 cn2 vrefl__p2 vrefl sg13_lv_pmos w=1u l=0.13u ng=1 m=1
Xxdn2_xmn bn2__p1 cn2__p1 gnd__p2 gnd sg13_lv_nmos w=0.5u l=0.13u ng=1 m=1
Xxdn1_xmp bn1 cn1 vrefl__p1 vrefl sg13_lv_pmos w=1u l=0.13u ng=1 m=1
Xxdn1_xmn bn1__p1 cn1__p1 gnd__p1 gnd sg13_lv_nmos w=0.5u l=0.13u ng=1 m=1
Xxdn0_xmp bn0 cn0 vrefl__p0 vrefl sg13_lv_pmos w=1u l=0.13u ng=1 m=1
Xxdn0_xmn bn0__p1 cn0__p1 gnd__p0 gnd sg13_lv_nmos w=0.5u l=0.13u ng=1 m=1
Xxc4_xs1_xmt1 xc4_xs1_tail0 clkb__p2 vdd__p28 vdd sg13_lv_pmos w=16u l=0.13u ng=4 m=1
Xxc4_xs1_xmtc xc4_xs1_tail__p2 vbp xc4_xs1_tail0__p1 vdd sg13_lv_pmos w=16u l=0.5u ng=4 m=1
Xxc4_xs1_xm1 xc4_dip top_p__p4 xc4_xs1_tail vdd sg13_lv_pmos w=48u l=0.3u ng=12 m=1
Xxc4_xs1_xm2 xc4_din top_n__p4 xc4_xs1_tail__p1 vdd sg13_lv_pmos w=48u l=0.3u ng=12 m=1
Xxc4_xci1 vdd__p23 xc4_dip vdd__p22 vdd sg13_lv_pmos w=80u l=4u ng=8 m=1
Xxc4_xci2 vdd__p25 xc4_din vdd__p24 vdd sg13_lv_pmos w=80u l=4u ng=8 m=1
Xxc4_xmr1 xc4_dip__p1 clkb gnd__p49 gnd sg13_lv_nmos w=20u l=0.13u ng=2 m=1
Xxc4_xmr2 xc4_din__p1 clkb__p1 gnd__p50 gnd sg13_lv_nmos w=20u l=0.13u ng=2 m=1
Xxc4_xmt2 xc4_lt clk gnd__p55 gnd sg13_lv_nmos w=4u l=0.13u ng=1 m=1
Xxc4_xmn1 op on xc4_lt__p1 gnd sg13_lv_nmos w=2u l=0.13u ng=1 m=1
Xxc4_xmn2 on__p1 op__p1 xc4_lt__p2 gnd sg13_lv_nmos w=2u l=0.13u ng=1 m=1
Xxc4_xmp1 op__p4 on__p4 vdd__p31 vdd sg13_lv_pmos w=2u l=0.13u ng=1 m=1
Xxc4_xmp2 on__p5 op__p5 vdd__p32 vdd sg13_lv_pmos w=2u l=0.13u ng=1 m=1
Xxc4_xmh1 op__p3 xc4_dip__p2 vdd__p29 vdd sg13_lv_pmos w=8u l=0.13u ng=2 m=1
Xxc4_xmh2 on__p3 xc4_din__p2 vdd__p30 vdd sg13_lv_pmos w=8u l=0.13u ng=2 m=1
Xxc4_xbp1 xc4_outpb__p1 op__p6 vdd__p33 vdd sg13_lv_pmos w=1u l=0.13u ng=1 m=1
Xxc4_xbn1 xc4_outpb op__p2 gnd__p56 gnd sg13_lv_nmos w=0.5u l=0.13u ng=1 m=1
Xxc4_xbp2 xc4_outnb__p1 on__p6 vdd__p34 vdd sg13_lv_pmos w=1u l=0.13u ng=1 m=1
Xxc4_xbn2 xc4_outnb on__p2 gnd__p57 gnd sg13_lv_nmos w=0.5u l=0.13u ng=1 m=1
Xxc5_xs1_xmt1 xc5_xs1_tail0 clkn__p2 gnd__p46 gnd sg13_lv_nmos w=8u l=0.13u ng=2 m=1
Xxc5_xs1_xmtc xc5_xs1_tail vbn xc5_xs1_tail0__p1 gnd sg13_lv_nmos w=4u l=0.5u ng=1 m=1
Xxc5_xs1_xm1 xc5_dip__p2 top_p xc5_xs1_tail__p1 gnd sg13_lv_nmos w=16u l=0.5u ng=4 m=1
Xxc5_xs1_xm2 xc5_din__p2 top_n xc5_xs1_tail__p2 gnd sg13_lv_nmos w=16u l=0.5u ng=4 m=1
Xxc5_xci1 gnd__p43 xc5_dip gnd__p42 gnd sg13_lv_nmos w=30u l=4u ng=4 m=1
Xxc5_xci2 gnd__p45 xc5_din gnd__p44 gnd sg13_lv_nmos w=30u l=4u ng=4 m=1
Xxc5_xmr1 xc5_dip clkn vdd__p19 vdd sg13_lv_pmos w=16u l=0.13u ng=2 m=1
Xxc5_xmr2 xc5_din clkn__p1 vdd__p20 vdd sg13_lv_pmos w=16u l=0.13u ng=2 m=1
Xxc5_xmt2 xc5_lt clknb vdd__p21 vdd sg13_lv_pmos w=8u l=0.13u ng=1 m=1
Xxc5_xmp1 onp__p4 onn__p4 xc5_lt__p1 vdd sg13_lv_pmos w=4u l=0.13u ng=1 m=1
Xxc5_xmp2 onn__p5 onp__p5 xc5_lt__p2 vdd sg13_lv_pmos w=4u l=0.13u ng=1 m=1
Xxc5_xmn1 onp__p1 onn__p1 gnd__p51 gnd sg13_lv_nmos w=1u l=0.13u ng=1 m=1
Xxc5_xmn2 onn__p2 onp__p2 gnd__p52 gnd sg13_lv_nmos w=1u l=0.13u ng=1 m=1
Xxc5_xmh1 onp xc5_dip__p1 gnd__p47 gnd sg13_lv_nmos w=8u l=0.13u ng=1 m=1
Xxc5_xmh2 onn xc5_din__p1 gnd__p48 gnd sg13_lv_nmos w=8u l=0.13u ng=1 m=1
Xxc5_xbp1 xc5_outpb__p1 onp__p6 vdd__p26 vdd sg13_lv_pmos w=1u l=0.13u ng=1 m=1
Xxc5_xbn1 xc5_outpb onp__p3 gnd__p53 gnd sg13_lv_nmos w=0.5u l=0.13u ng=1 m=1
Xxc5_xbp2 xc5_outnb__p1 onn__p6 vdd__p27 vdd sg13_lv_pmos w=1u l=0.13u ng=1 m=1
Xxc5_xbn2 xc5_outnb onn__p3 gnd__p54 gnd sg13_lv_nmos w=0.5u l=0.13u ng=1 m=1
Xxdacp_xc12_u0 top_p__p1 bp12__p2 cap_cmim w=3.78u l=3.78u m=16
Xxdacp_xc11_u0 top_p__p1 bp11__p2 cap_cmim w=3.78u l=3.78u m=8
Xxdacp_xc10_u0 top_p__p1 bp10__p2 cap_cmim w=3.78u l=3.78u m=4
Xxdacp_xc9_u0 top_p__p1 bp9__p2 cap_cmim w=3.78u l=3.78u m=2
Xxdacp_xc8_u0 top_p__p1 bp8__p2 cap_cmim w=3.78u l=3.78u m=1
Xxdacp_xcb top_p__p1 lsb_p__p1 cap_cmim w=4.23u l=4.23u m=1
Xxdacp_xc7_u0 lsb_p__p1 bp7__p2 cap_cmim w=3.78u l=3.78u m=64
Xxdacp_xc6_u0 lsb_p__p1 bp6__p2 cap_cmim w=3.78u l=3.78u m=32
Xxdacp_xc5_u0 lsb_p__p1 bp5__p2 cap_cmim w=3.78u l=3.78u m=16
Xxdacp_xc4_u0 lsb_p__p1 bp4__p2 cap_cmim w=3.78u l=3.78u m=8
Xxdacp_xc3_u0 lsb_p__p1 bp3__p2 cap_cmim w=3.78u l=3.78u m=4
Xxdacp_xc2_u0 lsb_p__p1 bp2__p2 cap_cmim w=3.78u l=3.78u m=2
Xxdacp_xc1_u0 lsb_p__p1 bp1__p2 cap_cmim w=3.78u l=3.78u m=1
Xxdacp_xc0 lsb_p__p1 bp0__p2 cap_cmim w=2.67u l=2.67u m=1
Xxdacn_xc12_u0 top_n__p1 bn12__p2 cap_cmim w=3.78u l=3.78u m=16
Xxdacn_xc11_u0 top_n__p1 bn11__p2 cap_cmim w=3.78u l=3.78u m=8
Xxdacn_xc10_u0 top_n__p1 bn10__p2 cap_cmim w=3.78u l=3.78u m=4
Xxdacn_xc9_u0 top_n__p1 bn9__p2 cap_cmim w=3.78u l=3.78u m=2
Xxdacn_xc8_u0 top_n__p1 bn8__p2 cap_cmim w=3.78u l=3.78u m=1
Xxdacn_xcb top_n__p1 lsb_n__p1 cap_cmim w=4.23u l=4.23u m=1
Xxdacn_xc7_u0 lsb_n__p1 bn7__p2 cap_cmim w=3.78u l=3.78u m=64
Xxdacn_xc6_u0 lsb_n__p1 bn6__p2 cap_cmim w=3.78u l=3.78u m=32
Xxdacn_xc5_u0 lsb_n__p1 bn5__p2 cap_cmim w=3.78u l=3.78u m=16
Xxdacn_xc4_u0 lsb_n__p1 bn4__p2 cap_cmim w=3.78u l=3.78u m=8
Xxdacn_xc3_u0 lsb_n__p1 bn3__p2 cap_cmim w=3.78u l=3.78u m=4
Xxdacn_xc2_u0 lsb_n__p1 bn2__p2 cap_cmim w=3.78u l=3.78u m=2
Xxdacn_xc1_u0 lsb_n__p1 bn1__p2 cap_cmim w=3.78u l=3.78u m=1
Xxdacn_xc0 lsb_n__p1 bn0__p2 cap_cmim w=2.67u l=2.67u m=1
Xxdmy_u0 gnd__p27 gnd__p27 cap_cmim w=3.78u l=3.78u m=82
Cld_xc4_outpb xc4_outpb gnd 3f
Cld_xc4_outnb xc4_outnb gnd 3f
Cld_xc5_outpb xc5_outpb gnd 3f
Cld_xc5_outnb xc5_outnb gnd 3f
Rw0 bn0 bn0__p1 30.5072
Rw1 bn0 bn0__p2 26.3744
Rw2 bn0__p1 bn0__p2 32.1711
Rw3 bn1 bn1__p1 31.7277
Rw4 bn1 bn1__p2 26.1343
Rw5 bn1__p1 bn1__p2 32.3351
Rw6 bn10 bn10__p1 21.7134
Rw7 bn10 bn10__p2 18.5632
Rw8 bn11 bn11__p2 18.369
Rw9 bn11__p1 bn11__p2 21.7992
Rw10 bn12 bn12__p2 18.369
Rw11 bn12__p1 bn12__p2 21.747
Rw12 bn2 bn2__p1 30.7888
Rw13 bn2 bn2__p2 26.7387
Rw14 bn2__p1 bn2__p2 31.8477
Rw15 bn3 bn3__p1 30.9128
Rw16 bn3 bn3__p2 26.3943
Rw17 bn3__p1 bn3__p2 31.4474
Rw18 bn4 bn4__p1 31.7277
Rw19 bn4 bn4__p2 26.1343
Rw20 bn4__p1 bn4__p2 32.3351
Rw21 bn5 bn5__p1 31.7277
Rw22 bn5 bn5__p2 26.1343
Rw23 bn5__p1 bn5__p2 32.3351
Rw24 bn6 bn6__p1 31.7277
Rw25 bn6 bn6__p2 26.1343
Rw26 bn6__p1 bn6__p2 32.3351
Rw27 bn7 bn7__p1 30.7888
Rw28 bn7 bn7__p2 26.7387
Rw29 bn7__p1 bn7__p2 31.8477
Rw30 bn8 bn8__p2 18.5632
Rw31 bn8__p1 bn8__p2 21.7312
Rw32 bn9 bn9__p2 18.545
Rw33 bn9__p1 bn9__p2 21.957
Rw34 bp0 bp0__p1 41.3322
Rw35 bp0 bp0__p2 18.7942
Rw36 bp1 bp1__p1 73.6661
Rw37 bp1 bp1__p2 21.2087
Rw38 bp1__p1 bp1__p2 75.0764
Rw39 bp10 bp10__p1 69.8254
Rw40 bp10 bp10__p2 21.3841
Rw41 bp10__p1 bp10__p2 70.8928
Rw42 bp11 bp11__p2 18.369
Rw43 bp11__p1 bp11__p2 39.849
Rw44 bp12 bp12__p1 71.1094
Rw45 bp12 bp12__p2 21.1158
Rw46 bp12__p1 bp12__p2 71.1094
Rw47 bp2 bp2__p1 72.6526
Rw48 bp2 bp2__p2 21.46
Rw49 bp2__p1 bp2__p2 75.1514
Rw50 bp3 bp3__p1 73.63
Rw51 bp3 bp3__p2 21.2102
Rw52 bp3__p1 bp3__p2 75.0396
Rw53 bp4 bp4__p2 18.545
Rw54 bp4__p1 bp4__p2 23.6612
Rw55 bp5 bp5__p1 73.7647
Rw56 bp5 bp5__p2 21.2046
Rw57 bp5__p1 bp5__p2 75.1769
Rw58 bp6 bp6__p2 18.545
Rw59 bp6__p1 bp6__p2 41.473
Rw60 bp7 bp7__p2 18.545
Rw61 bp7__p1 bp7__p2 41.5592
Rw62 bp8 bp8__p1 70.4918
Rw63 bp8 bp8__p2 21.3457
Rw64 bp8__p1 bp8__p2 71.8413
Rw65 bp9 bp9__p1 70.4918
Rw66 bp9 bp9__p2 21.3457
Rw67 bp9__p1 bp9__p2 71.8413
Rw68 clkb clkb__p1 0.72754
Rw69 clkb clkb__p2 65.656
Rw70 clkn clkn__p1 0.756667
Rw71 clkn clkn__p2 57.1313
Rw72 clkn__p1 clkn__p2 348.939
Rw73 cn0 cn0__p1 19.6116
Rw74 cn1 cn1__p1 19.6179
Rw75 cn10 cn10__p1 39.168
Rw76 cn11 cn11__p1 39.4861
Rw77 cn12 cn12__p1 39.168
Rw78 cn2 cn2__p1 19.6179
Rw79 cn3 cn3__p1 19.6179
Rw80 cn4 cn4__p1 20.3219
Rw81 cn5 cn5__p1 19.6179
Rw82 cn6 cn6__p1 19.6179
Rw83 cn7 cn7__p1 19.6179
Rw84 cn8 cn8__p1 39.1405
Rw85 cn9 cn9__p1 39.168
Rw86 cp0 cp0__p1 40.752
Rw87 cp1 cp1__p1 40.752
Rw88 cp10 cp10__p1 39.4861
Rw89 cp11 cp11__p1 39.168
Rw90 cp12 cp12__p1 39.5541
Rw91 cp2 cp2__p1 40.752
Rw92 cp3 cp3__p1 41.1379
Rw93 cp4 cp4__p1 40.7859
Rw94 cp5 cp5__p1 40.7521
Rw95 cp6 cp6__p1 40.7521
Rw96 cp7 cp7__p1 40.7521
Rw97 cp8 cp8__p1 39.8381
Rw98 cp9 cp9__p1 39.168
Rw99 gnd__i23 gnd__i24 9
Rw100 gnd__i27 gnd__i28 9
Rw101 gnd__i29 gnd__i30 9
Rw102 gnd__i34 gnd__i35 9
Rw103 gnd__i37 gnd__i38 9
Rw104 gnd__i63 gnd__i64 9
Rw105 gnd__i68 gnd__i69 9
Rw106 gnd__i71 gnd__i72 9
Rw107 gnd__i4 gnd__i3 10.7969
Rw108 gnd__i1 gnd__i0 1.32
Rw109 gnd__i2 gnd__i1 4.02769
Rw110 gnd__i10 gnd__i9 0.981538
Rw111 gnd__i10 gnd__i11 3.01231
Rw112 gnd__i8 gnd__i9 1.32
Rw113 gnd__i7 gnd__i6 1.32
Rw114 gnd__i8 gnd__i7 1.32
Rw115 gnd__i40 gnd__i21 0.176
Rw116 gnd__i67 gnd__i65 0.0465127
Rw117 gnd__i33 gnd__i35 0.0704
Rw118 gnd__i35 gnd__i30 0.0352
Rw119 gnd__i36 gnd__i38 0.0352
Rw120 gnd__i38 gnd__i31 0.0352
Rw121 gnd gnd__i43 0.17985
Rw122 gnd__i43 gnd__p59 0.539
Rw123 gnd__p59 gnd__p60 0.7876
Rw124 gnd__p60 gnd__p61 0.71885
Rw125 gnd__p61 gnd__i41 0.17655
Rw126 gnd__i41 gnd__i77 0.022
Rw127 gnd__i77 gnd__p62 0.58905
Rw128 gnd__p62 gnd__i44 0.09295
Rw129 gnd__i44 gnd__p63 0.6259
Rw130 gnd__p63 gnd__i42 0.3861
Rw131 gnd__i42 gnd__p64 0.4015
Rw132 gnd__p64 gnd__p65 0.71885
Rw133 gnd__i45 gnd__i78 0.66
Rw134 gnd__i78 gnd__i46 0.22
Rw135 gnd__i46 gnd__i47 0.352
Rw136 gnd__i47 gnd__i48 0.352
Rw137 gnd__i48 gnd__i49 0.176
Rw138 gnd__i49 gnd__i50 0.528
Rw139 gnd__i50 gnd__i51 0.176
Rw140 gnd__i78 gnd__i77 0.132
Rw141 gnd__i54 gnd__i55 0.704
Rw142 gnd__i57 gnd__i58 0.704
Rw143 gnd__i58 gnd__i59 0.704
Rw144 gnd__i59 gnd__i60 0.704
Rw145 gnd__i60 gnd__i61 0.704
Rw146 gnd__i62 gnd__i61 0.947988
Rw147 gnd__i66 gnd__p26 0.2464
Rw148 gnd__i74 gnd__p27 0.1408
Rw149 gnd__i39 gnd__i21 9
Rw150 gnd__i20 gnd__i37 0.0586667
Rw151 gnd__i31 gnd__i20 9
Rw152 gnd__i36 gnd__i34 9
Rw153 gnd__i29 gnd__i34 0.0401107
Rw154 gnd__i33 gnd__i32 9
Rw155 gnd__i27 gnd__i32 0.0352
Rw156 gnd__i66 gnd__i65 9
Rw157 gnd__i63 gnd__i65 0.0432458
Rw158 gnd__i60 gnd__i25 9
Rw159 gnd__i70 gnd__i26 9
Rw160 gnd__i68 gnd__i26 0.0653048
Rw161 gnd__i74 gnd__i73 9
Rw162 gnd__i71 gnd__i73 0.0361467
Rw163 gnd__i32 gnd__i28 9
Rw164 gnd__i33 gnd__i28 0.0352
Rw165 gnd__i36 gnd__i30 0.0352
Rw166 gnd__i34 gnd__i30 9
Rw167 gnd__i37 gnd__i31 9
Rw168 gnd__i40 gnd__i39 9
Rw169 gnd__i65 gnd__i64 9
Rw170 gnd__i67 gnd__i64 9
Rw171 gnd__i66 gnd__i64 0.0352
Rw172 gnd__i70 gnd__i69 0.0432373
Rw173 gnd__i26 gnd__i69 9
Rw174 gnd__i73 gnd__i72 9
Rw175 gnd__i74 gnd__i72 0.0352
Rw176 gnd__i1 gnd__i5 9.88
Rw177 gnd__i5 gnd__p38 9.10676
Rw178 gnd__i6 gnd__i13 9.88
Rw179 gnd__i12 gnd__p5 9.10676
Rw180 gnd__i13 gnd__p52 9.07603
Rw181 gnd__i14 gnd__p28 9.06632
Rw182 gnd__i16 gnd__p29 9.07441
Rw183 gnd__i17 gnd__p30 9.06632
Rw184 gnd__i18 gnd__p34 9.10676
Rw185 gnd__i42 gnd__i40 10.408
Rw186 gnd__i45 gnd__i25 9.88
Rw187 gnd__i46 gnd__i22 9.528
Rw188 gnd__i47 gnd__i24 9.528
Rw189 gnd__i50 gnd__i53 9.528
Rw190 gnd__i51 gnd__i75 9.528
Rw191 gnd__i53 gnd__i52 9.704
Rw192 gnd__i56 gnd__i55 9.704
Rw193 gnd__i3 gnd__p44 18.4814
Rw194 gnd__p36 gnd__i19 18.4183
Rw195 gnd__i5 gnd__p39 10.4068
Rw196 gnd__p49 gnd__i20 18.3378
Rw197 gnd__p50 gnd__i21 18.3928
Rw198 gnd__i8 gnd__p54 18.7784
Rw199 gnd__i12 gnd__p4 10.5828
Rw200 gnd__p9 gnd__i25 18.2828
Rw201 gnd__i23 gnd__p17 10.4068
Rw202 gnd__p13 gnd__i22 19.5488
Rw203 gnd__i23 gnd__p15 10.5488
Rw204 gnd__i15 gnd__p32 9.66876
Rw205 gnd__p31 gnd__i26 18.2504
Rw206 gnd__i12 gnd__i57 18.88
Rw207 gnd__i45 gnd__i56 10.76
Rw208 gnd__p27 gnd__p26 19.4416
Rw209 gnd__p42 gnd__i3 31.6436
Rw210 gnd__p57 gnd__i11 20.0984
Rw211 gnd__p51 gnd__i6 20.2026
Rw212 gnd__i14 gnd__i67 30.658
Rw213 gnd__i16 gnd__i14 20.728
Rw214 gnd__i17 gnd__i68 29.461
Rw215 gnd__i19 gnd__i0 20.515
Rw216 gnd__p40 gnd__i2 36.9498
Rw217 gnd__p37 gnd__i0 37.1371
Rw218 gnd__i41 gnd__p43 27.9299
Rw219 gnd__i27 gnd__p47 18.3354
Rw220 gnd__i29 gnd__p48 18.4218
Rw221 gnd__p53 gnd__i7 36.7784
Rw222 gnd__p56 gnd__i11 36.7784
Rw223 gnd__p0 gnd__i54 28.1223
Rw224 gnd__i54 gnd__p1 27.4588
Rw225 gnd__i55 gnd__p2 27.4588
Rw226 gnd__i56 gnd__p3 18.4588
Rw227 gnd__i57 gnd__p6 27.2828
Rw228 gnd__i58 gnd__p7 27.2828
Rw229 gnd__i59 gnd__p8 27.2828
Rw230 gnd__i24 gnd__p16 18.6348
Rw231 gnd__i48 gnd__p18 28.1628
Rw232 gnd__i49 gnd__p19 28.1628
Rw233 gnd__p20 gnd__i52 28.3388
Rw234 gnd__i52 gnd__p21 27.6348
Rw235 gnd__i53 gnd__p22 18.6348
Rw236 gnd__i75 gnd__p23 18.6348
Rw237 gnd__i75 gnd__p24 19.3628
Rw238 gnd__p25 gnd__i51 28.5148
Rw239 gnd__i61 gnd__p10 27.4588
Rw240 gnd__i62 gnd__p11 27.2828
Rw241 gnd__i62 gnd__p12 27.9868
Rw242 gnd__i22 gnd__p14 18.8108
Rw243 gnd__p55 gnd__i9 36.8193
Rw244 gnd__i63 gnd__i13 10.0237
Rw245 gnd__i76 gnd__i15 28.3415
Rw246 gnd__i76 gnd__p33 18.2747
Rw247 gnd__i39 gnd__i31 0.176
Rw248 gnd gnd__i19 8.37032
Rw249 gnd__i43 gnd__i10 27.3872
Rw250 gnd__i71 gnd__i70 5.91
Rw251 gnd__p41 gnd__i2 38.1308
Rw252 gnd__p46 gnd__i4 36.8356
Rw253 gnd__p35 gnd__i18 47.6482
Rw254 gnd__i44 gnd__p45 27.8807
Rw255 gnd__p65 gnd__i15 95.5579
Rw256 gnd__i17 gnd__i16 80.1262
Rw257 gnd__i76 gnd__i18 63.3238
Rw258 gnd__i20 gnd__i4 19.9044
Rw259 in0n in0n__p0 30.3747
Rw260 in0n in0n__p1 1228.71
Rw261 in0n__p0 in0n__p1 9.97289
Rw262 in0p in0p__p0 56.0447
Rw263 in0p in0p__p1 897.293
Rw264 in0p__p0 in0p__p1 9.95162
Rw265 in1n in1n__p0 55.5315
Rw266 in1n in1n__p1 2549.47
Rw267 in1n__p0 in1n__p1 9.94528
Rw268 in1p in1p__p0 32.6056
Rw269 in1p in1p__p1 495.158
Rw270 in1p__p0 in1p__p1 10.1323
Rw271 lsb_n lsb_n__p1 18.545
Rw272 lsb_n__p1 lsb_n__p2 39.892
Rw273 lsb_p lsb_p__p1 18.545
Rw274 lsb_p__p1 lsb_p__p2 110.714
Rw275 nr nr__p1 46.253
Rw276 on on__p1 68.914
Rw277 on on__p2 73.3807
Rw278 on on__p3 102.24
Rw279 on__p1 on__p2 73.3807
Rw280 on__p1 on__p3 102.24
Rw281 on__p2 on__p3 86.3655
Rw282 on__p3 on__p4 21.9687
Rw283 on__p3 on__p5 1.76413
Rw284 on__p4 on__p5 196.469
Rw285 on__p5 on__p6 20.1749
Rw286 onn onn__p1 3668.03
Rw287 onn onn__p2 3634.18
Rw288 onn onn__p3 850.826
Rw289 onn onn__p4 510.002
Rw290 onn onn__p5 481.338
Rw291 onn onn__p6 92.4263
Rw292 onn__p1 onn__p2 59.6272
Rw293 onn__p1 onn__p3 75.3094
Rw294 onn__p1 onn__p4 486.951
Rw295 onn__p1 onn__p5 548.426
Rw296 onn__p1 onn__p6 619.209
Rw297 onn__p2 onn__p3 74.6144
Rw298 onn__p2 onn__p4 482.458
Rw299 onn__p2 onn__p5 543.366
Rw300 onn__p2 onn__p6 613.495
Rw301 onn__p3 onn__p4 112.952
Rw302 onn__p3 onn__p5 127.211
Rw303 onn__p3 onn__p6 143.63
Rw304 onn__p4 onn__p5 76.2531
Rw305 onn__p4 onn__p6 86.0947
Rw306 onn__p5 onn__p6 81.2558
Rw307 onp onp__p1 224.361
Rw308 onp onp__p3 206.398
Rw309 onp onp__p4 223.808
Rw310 onp onp__p5 256.275
Rw311 onp__p1 onp__p3 60.9263
Rw312 onp__p1 onp__p4 132.446
Rw313 onp__p1 onp__p5 151.659
Rw314 onp__p2 onp__p3 0.7029
Rw315 onp__p3 onp__p4 121.842
Rw316 onp__p3 onp__p5 139.517
Rw317 onp__p4 onp__p5 24.3717
Rw318 onp__p5 onp__p6 0.704
Rw319 op op__p1 19.4601
Rw320 op__p1 op__p2 0.704
Rw321 op__p2 op__p3 57.3638
Rw322 op__p2 op__p4 275.291
Rw323 op__p2 op__p5 318.32
Rw324 op__p3 op__p4 76.8366
Rw325 op__p3 op__p5 88.8468
Rw326 op__p4 op__p5 23.4047
Rw327 op__p5 op__p6 0.704
Rw328 rstb rstb__p1 46.9438
Rw329 rstb rstb__p2 113.179
Rw330 rstb rstb__p3 93.5227
Rw331 rstb__p1 rstb__p2 33186
Rw332 rstb__p1 rstb__p3 27422.4
Rw333 rstb__p2 rstb__p3 22.591
Rw334 rstb_n rstb_n__p1 88.824
Rw335 rstb_n rstb_n__p3 101.63
Rw336 rstb_n rstb_n__p4 96.0304
Rw337 rstb_n__p1 rstb_n__p3 37.1031
Rw338 rstb_n__p1 rstb_n__p4 35.059
Rw339 rstb_n__p2 rstb_n__p3 0.6534
Rw340 rstb_n__p3 rstb_n__p4 30.359
Rw341 t0 t0__p1 75.6109
Rw342 t0 t0__p2 342.012
Rw343 t0 t0__p3 148.019
Rw344 t0 t0__p4 391.687
Rw345 t0 t0__p5 318.63
Rw346 t0__p1 t0__p2 93.531
Rw347 t0__p1 t0__p3 40.4792
Rw348 t0__p1 t0__p4 188.995
Rw349 t0__p1 t0__p5 153.744
Rw350 t0__p2 t0__p3 78.2282
Rw351 t0__p2 t0__p4 854.883
Rw352 t0__p2 t0__p5 695.431
Rw353 t0__p3 t0__p4 369.985
Rw354 t0__p3 t0__p5 300.975
Rw355 t0__p4 t0__p5 23.6755
Rw356 t0b t0b__p1 35.0173
Rw357 t0b t0b__p2 80.151
Rw358 t0b t0b__p3 91.917
Rw359 t0b t0b__p7 54.8425
Rw360 t0b__p1 t0b__p2 63.8068
Rw361 t0b__p1 t0b__p3 73.1736
Rw362 t0b__p1 t0b__p7 66.6206
Rw363 t0b__p2 t0b__p3 29.7746
Rw364 t0b__p2 t0b__p7 152.488
Rw365 t0b__p3 t0b__p7 174.873
Rw366 t0b__p4 t0b__p5 36.6424
Rw367 t0b__p4 t0b__p6 265.156
Rw368 t0b__p4 t0b__p7 49.4116
Rw369 t0b__p4 t0b__p8 44.1235
Rw370 t0b__p4 t0b__p9 221.176
Rw371 t0b__p5 t0b__p6 289.099
Rw372 t0b__p5 t0b__p7 53.8734
Rw373 t0b__p5 t0b__p8 48.1077
Rw374 t0b__p5 t0b__p9 241.148
Rw375 t0b__p6 t0b__p7 232.691
Rw376 t0b__p6 t0b__p8 207.788
Rw377 t0b__p6 t0b__p9 24.6537
Rw378 t0b__p7 t0b__p8 38.7211
Rw379 t0b__p7 t0b__p9 194.096
Rw380 t0b__p8 t0b__p9 173.323
Rw381 t1 t1__p1 67.2933
Rw382 t1 t1__p2 309.568
Rw383 t1 t1__p3 132.904
Rw384 t1 t1__p4 992.265
Rw385 t1 t1__p5 835.599
Rw386 t1__p1 t1__p2 88.7548
Rw387 t1__p1 t1__p3 38.1043
Rw388 t1__p1 t1__p4 478.027
Rw389 t1__p1 t1__p5 402.553
Rw390 t1__p2 t1__p3 74.2198
Rw391 t1__p2 t1__p4 2199.06
Rw392 t1__p2 t1__p5 1851.86
Rw393 t1__p3 t1__p4 944.101
Rw394 t1__p3 t1__p5 795.04
Rw395 t1__p4 t1__p5 21.6477
Rw396 t1b t1b__p1 22.2717
Rw397 t1b t1b__p2 207.755
Rw398 t1b t1b__p3 218.438
Rw399 t1b t1b__p5 759.438
Rw400 t1b t1b__p6 253.71
Rw401 t1b t1b__p7 1125.06
Rw402 t1b t1b__p8 964.188
Rw403 t1b t1b__p9 192.304
Rw404 t1b__p1 t1b__p2 176.575
Rw405 t1b__p1 t1b__p3 185.655
Rw406 t1b__p2 t1b__p3 48.2268
Rw407 t1b__p4 t1b__p5 1.26262
Rw408 t1b__p5 t1b__p6 70.0358
Rw409 t1b__p5 t1b__p7 506.324
Rw410 t1b__p5 t1b__p8 433.926
Rw411 t1b__p5 t1b__p9 90.8017
Rw412 t1b__p6 t1b__p7 169.151
Rw413 t1b__p6 t1b__p8 144.964
Rw414 t1b__p6 t1b__p9 30.3347
Rw415 t1b__p7 t1b__p8 24.0048
Rw416 t1b__p7 t1b__p9 134.517
Rw417 t1b__p8 t1b__p9 115.283
Rw418 top_n top_n__p1 0.001
Rw419 top_n top_n__p2 0.001
Rw420 top_n__p1 top_n__p3 86.378
Rw421 top_n__p1 top_n__p4 92.5143
Rw422 top_n__p3 top_n__p4 49.7283
Rw423 top_p top_p__p1 0.001
Rw424 top_p top_p__p2 0.001
Rw425 top_p__p1 top_p__p3 31.2837
Rw426 top_p__p1 top_p__p4 82.8984
Rw427 top_p__p3 top_p__p4 163.124
Rw428 trk0 trk0__p1 20.4429
Rw429 trk1 trk1__p1 19.7939
Rw430 vdd vdd__p0 59.855
Rw431 vdd vdd__p1 781.085
Rw432 vdd vdd__p10 42399.2
Rw433 vdd vdd__p11 27661.7
Rw434 vdd vdd__p12 61.6814
Rw435 vdd vdd__p13 59.9808
Rw436 vdd vdd__p14 59.9861
Rw437 vdd vdd__p15 27.7246
Rw438 vdd vdd__p16 62.6941
Rw439 vdd vdd__p17 65.5951
Rw440 vdd vdd__p18 69.3768
Rw441 vdd vdd__p19 2166.24
Rw442 vdd vdd__p2 153.275
Rw443 vdd vdd__p20 1940.14
Rw444 vdd vdd__p21 1865.27
Rw445 vdd vdd__p22 1387.17
Rw446 vdd vdd__p24 3451.87
Rw447 vdd vdd__p26 85.414
Rw448 vdd vdd__p27 89.4898
Rw449 vdd vdd__p28 96.9868
Rw450 vdd vdd__p29 121.008
Rw451 vdd vdd__p3 627.181
Rw452 vdd vdd__p30 142.67
Rw453 vdd vdd__p31 140.65
Rw454 vdd vdd__p32 151.392
Rw455 vdd vdd__p33 161.302
Rw456 vdd vdd__p34 173.882
Rw457 vdd vdd__p36 9.8729
Rw458 vdd vdd__p37 39.2742
Rw459 vdd vdd__p38 71.1672
Rw460 vdd vdd__p4 6612.6
Rw461 vdd vdd__p5 1300.11
Rw462 vdd vdd__p6 1975.67
Rw463 vdd vdd__p7 22447.1
Rw464 vdd vdd__p8 4931.03
Rw465 vdd vdd__p9 32660.1
Rw466 vdd__p0 vdd__p1 1099.5
Rw467 vdd__p0 vdd__p11 953094
Rw468 vdd__p0 vdd__p12 2125.26
Rw469 vdd__p0 vdd__p13 2066.66
Rw470 vdd__p0 vdd__p14 2066.84
Rw471 vdd__p0 vdd__p15 1176.42
Rw472 vdd__p0 vdd__p16 2160.15
Rw473 vdd__p0 vdd__p17 2260.1
Rw474 vdd__p0 vdd__p18 2390.4
Rw475 vdd__p0 vdd__p19 74638.6
Rw476 vdd__p0 vdd__p2 215.76
Rw477 vdd__p0 vdd__p20 66848.4
Rw478 vdd__p0 vdd__p21 64268.5
Rw479 vdd__p0 vdd__p22 47795.4
Rw480 vdd__p0 vdd__p24 118936
Rw481 vdd__p0 vdd__p26 2942.97
Rw482 vdd__p0 vdd__p27 3083.4
Rw483 vdd__p0 vdd__p28 3341.72
Rw484 vdd__p0 vdd__p29 4169.38
Rw485 vdd__p0 vdd__p3 882.857
Rw486 vdd__p0 vdd__p30 4915.75
Rw487 vdd__p0 vdd__p31 4846.15
Rw488 vdd__p0 vdd__p32 5216.27
Rw489 vdd__p0 vdd__p33 5557.74
Rw490 vdd__p0 vdd__p34 5991.15
Rw491 vdd__p0 vdd__p36 340.174
Rw492 vdd__p0 vdd__p37 1353.21
Rw493 vdd__p0 vdd__p38 2452.09
Rw494 vdd__p0 vdd__p4 9308.29
Rw495 vdd__p0 vdd__p5 1830.12
Rw496 vdd__p0 vdd__p6 68072.5
Rw497 vdd__p0 vdd__p7 773423
Rw498 vdd__p0 vdd__p8 169900
Rw499 vdd__p1 vdd__p12 27733.8
Rw500 vdd__p1 vdd__p13 26969.1
Rw501 vdd__p1 vdd__p14 26971.5
Rw502 vdd__p1 vdd__p15 15351.9
Rw503 vdd__p1 vdd__p16 28189.1
Rw504 vdd__p1 vdd__p17 29493.5
Rw505 vdd__p1 vdd__p18 31193.9
Rw506 vdd__p1 vdd__p19 974005
Rw507 vdd__p1 vdd__p2 84.6179
Rw508 vdd__p1 vdd__p20 872346
Rw509 vdd__p1 vdd__p21 838679
Rw510 vdd__p1 vdd__p22 623712
Rw511 vdd__p1 vdd__p26 38404.7
Rw512 vdd__p1 vdd__p27 40237.3
Rw513 vdd__p1 vdd__p28 43608.1
Rw514 vdd__p1 vdd__p29 54408.9
Rw515 vdd__p1 vdd__p3 346.244
Rw516 vdd__p1 vdd__p30 64148.7
Rw517 vdd__p1 vdd__p31 63240.4
Rw518 vdd__p1 vdd__p32 68070.3
Rw519 vdd__p1 vdd__p33 72526.4
Rw520 vdd__p1 vdd__p34 78182.3
Rw521 vdd__p1 vdd__p36 4439.15
Rw522 vdd__p1 vdd__p37 17658.9
Rw523 vdd__p1 vdd__p38 31998.9
Rw524 vdd__p1 vdd__p4 3650.58
Rw525 vdd__p1 vdd__p5 717.747
Rw526 vdd__p1 vdd__p6 888320
Rw527 vdd__p10 vdd__p11 103.693
Rw528 vdd__p10 vdd__p12 768905
Rw529 vdd__p10 vdd__p13 747705
Rw530 vdd__p10 vdd__p14 747771
Rw531 vdd__p10 vdd__p15 833337
Rw532 vdd__p10 vdd__p16 693225
Rw533 vdd__p10 vdd__p17 663707
Rw534 vdd__p10 vdd__p18 606977
Rw535 vdd__p10 vdd__p19 57810.1
Rw536 vdd__p10 vdd__p20 51776.4
Rw537 vdd__p10 vdd__p21 45943.9
Rw538 vdd__p10 vdd__p26 475489
Rw539 vdd__p10 vdd__p27 457746
Rw540 vdd__p10 vdd__p28 430659
Rw541 vdd__p10 vdd__p29 359050
Rw542 vdd__p10 vdd__p30 375560
Rw543 vdd__p10 vdd__p31 327587
Rw544 vdd__p10 vdd__p32 311081
Rw545 vdd__p10 vdd__p33 291478
Rw546 vdd__p10 vdd__p34 275387
Rw547 vdd__p10 vdd__p36 15636.3
Rw548 vdd__p10 vdd__p37 3387.19
Rw549 vdd__p10 vdd__p38 1752.94
Rw550 vdd__p10 vdd__p6 1693.17
Rw551 vdd__p10 vdd__p7 699.385
Rw552 vdd__p10 vdd__p8 148.124
Rw553 vdd__p10 vdd__p9 77.1175
Rw554 vdd__p11 vdd__p12 501642
Rw555 vdd__p11 vdd__p13 487811
Rw556 vdd__p11 vdd__p14 487854
Rw557 vdd__p11 vdd__p15 543678
Rw558 vdd__p11 vdd__p16 452268
Rw559 vdd__p11 vdd__p17 433010
Rw560 vdd__p11 vdd__p18 395998
Rw561 vdd__p11 vdd__p19 37716
Rw562 vdd__p11 vdd__p20 33779.5
Rw563 vdd__p11 vdd__p21 29974.3
Rw564 vdd__p11 vdd__p26 310214
Rw565 vdd__p11 vdd__p27 298639
Rw566 vdd__p11 vdd__p28 280967
Rw567 vdd__p11 vdd__p29 234248
Rw568 vdd__p11 vdd__p30 245019
Rw569 vdd__p11 vdd__p31 213721
Rw570 vdd__p11 vdd__p32 202953
Rw571 vdd__p11 vdd__p33 190164
Rw572 vdd__p11 vdd__p34 179666
Rw573 vdd__p11 vdd__p36 10201.3
Rw574 vdd__p11 vdd__p37 2209.84
Rw575 vdd__p11 vdd__p38 1143.64
Rw576 vdd__p11 vdd__p6 1104.64
Rw577 vdd__p11 vdd__p7 456.286
Rw578 vdd__p11 vdd__p8 96.6377
Rw579 vdd__p11 vdd__p9 79.8743
Rw580 vdd__p12 vdd__p13 872.71
Rw581 vdd__p12 vdd__p14 969.436
Rw582 vdd__p12 vdd__p15 1212.32
Rw583 vdd__p12 vdd__p16 1136.95
Rw584 vdd__p12 vdd__p17 1189.56
Rw585 vdd__p12 vdd__p18 1258.14
Rw586 vdd__p12 vdd__p19 39284.5
Rw587 vdd__p12 vdd__p2 5442.31
Rw588 vdd__p12 vdd__p20 35184.3
Rw589 vdd__p12 vdd__p21 33826.4
Rw590 vdd__p12 vdd__p22 25156.2
Rw591 vdd__p12 vdd__p24 62599.4
Rw592 vdd__p12 vdd__p26 1548.97
Rw593 vdd__p12 vdd__p27 1622.89
Rw594 vdd__p12 vdd__p28 1758.85
Rw595 vdd__p12 vdd__p29 2194.47
Rw596 vdd__p12 vdd__p3 22269.1
Rw597 vdd__p12 vdd__p30 2587.31
Rw598 vdd__p12 vdd__p31 2550.67
Rw599 vdd__p12 vdd__p32 2745.48
Rw600 vdd__p12 vdd__p33 2925.2
Rw601 vdd__p12 vdd__p34 3153.33
Rw602 vdd__p12 vdd__p36 179.044
Rw603 vdd__p12 vdd__p37 712.234
Rw604 vdd__p12 vdd__p38 1290.61
Rw605 vdd__p12 vdd__p4 234792
Rw606 vdd__p12 vdd__p5 46162.8
Rw607 vdd__p12 vdd__p6 35828.6
Rw608 vdd__p12 vdd__p7 407076
Rw609 vdd__p12 vdd__p8 89423.8
Rw610 vdd__p12 vdd__p9 592287
Rw611 vdd__p13 vdd__p14 942.707
Rw612 vdd__p13 vdd__p15 1178.9
Rw613 vdd__p13 vdd__p16 1105.6
Rw614 vdd__p13 vdd__p17 1156.76
Rw615 vdd__p13 vdd__p18 1223.45
Rw616 vdd__p13 vdd__p19 38201.4
Rw617 vdd__p13 vdd__p2 5292.26
Rw618 vdd__p13 vdd__p20 34214.2
Rw619 vdd__p13 vdd__p21 32893.8
Rw620 vdd__p13 vdd__p22 24462.6
Rw621 vdd__p13 vdd__p24 60873.4
Rw622 vdd__p13 vdd__p26 1506.27
Rw623 vdd__p13 vdd__p27 1578.14
Rw624 vdd__p13 vdd__p28 1710.35
Rw625 vdd__p13 vdd__p29 2133.97
Rw626 vdd__p13 vdd__p3 21655.1
Rw627 vdd__p13 vdd__p30 2515.97
Rw628 vdd__p13 vdd__p31 2480.35
Rw629 vdd__p13 vdd__p32 2669.78
Rw630 vdd__p13 vdd__p33 2844.55
Rw631 vdd__p13 vdd__p34 3066.38
Rw632 vdd__p13 vdd__p36 174.107
Rw633 vdd__p13 vdd__p37 692.597
Rw634 vdd__p13 vdd__p38 1255.03
Rw635 vdd__p13 vdd__p4 228318
Rw636 vdd__p13 vdd__p5 44890
Rw637 vdd__p13 vdd__p6 34840.8
Rw638 vdd__p13 vdd__p7 395852
Rw639 vdd__p13 vdd__p8 86958.2
Rw640 vdd__p13 vdd__p9 575957
Rw641 vdd__p14 vdd__p15 1179
Rw642 vdd__p14 vdd__p16 1105.7
Rw643 vdd__p14 vdd__p17 1156.87
Rw644 vdd__p14 vdd__p18 1223.56
Rw645 vdd__p14 vdd__p19 38204.8
Rw646 vdd__p14 vdd__p2 5292.73
Rw647 vdd__p14 vdd__p20 34217.3
Rw648 vdd__p14 vdd__p21 32896.7
Rw649 vdd__p14 vdd__p22 24464.7
Rw650 vdd__p14 vdd__p24 60878.8
Rw651 vdd__p14 vdd__p26 1506.4
Rw652 vdd__p14 vdd__p27 1578.28
Rw653 vdd__p14 vdd__p28 1710.5
Rw654 vdd__p14 vdd__p29 2134.16
Rw655 vdd__p14 vdd__p3 21657.1
Rw656 vdd__p14 vdd__p30 2516.2
Rw657 vdd__p14 vdd__p31 2480.57
Rw658 vdd__p14 vdd__p32 2670.02
Rw659 vdd__p14 vdd__p33 2844.8
Rw660 vdd__p14 vdd__p34 3066.65
Rw661 vdd__p14 vdd__p36 174.123
Rw662 vdd__p14 vdd__p37 692.658
Rw663 vdd__p14 vdd__p38 1255.14
Rw664 vdd__p14 vdd__p4 228338
Rw665 vdd__p14 vdd__p5 44894
Rw666 vdd__p14 vdd__p6 34843.8
Rw667 vdd__p14 vdd__p7 395887
Rw668 vdd__p14 vdd__p8 86965.9
Rw669 vdd__p14 vdd__p9 576008
Rw670 vdd__p15 vdd__p16 1232.22
Rw671 vdd__p15 vdd__p17 1289.24
Rw672 vdd__p15 vdd__p18 1363.57
Rw673 vdd__p15 vdd__p19 42576.5
Rw674 vdd__p15 vdd__p2 3012.56
Rw675 vdd__p15 vdd__p20 38132.7
Rw676 vdd__p15 vdd__p21 36661
Rw677 vdd__p15 vdd__p22 27264.2
Rw678 vdd__p15 vdd__p24 67845.1
Rw679 vdd__p15 vdd__p26 1678.77
Rw680 vdd__p15 vdd__p27 1758.88
Rw681 vdd__p15 vdd__p28 1906.23
Rw682 vdd__p15 vdd__p29 2378.36
Rw683 vdd__p15 vdd__p3 12327
Rw684 vdd__p15 vdd__p30 2804.12
Rw685 vdd__p15 vdd__p31 2764.41
Rw686 vdd__p15 vdd__p32 2975.54
Rw687 vdd__p15 vdd__p33 3170.33
Rw688 vdd__p15 vdd__p34 3417.57
Rw689 vdd__p15 vdd__p36 194.047
Rw690 vdd__p15 vdd__p37 771.918
Rw691 vdd__p15 vdd__p38 1398.76
Rw692 vdd__p15 vdd__p4 129968
Rw693 vdd__p15 vdd__p5 25553.2
Rw694 vdd__p15 vdd__p6 38831
Rw695 vdd__p15 vdd__p7 441188
Rw696 vdd__p15 vdd__p8 96917.3
Rw697 vdd__p15 vdd__p9 641919
Rw698 vdd__p16 vdd__p17 1072.48
Rw699 vdd__p16 vdd__p18 1134.31
Rw700 vdd__p16 vdd__p19 35417.9
Rw701 vdd__p16 vdd__p2 5531.66
Rw702 vdd__p16 vdd__p20 31721.3
Rw703 vdd__p16 vdd__p21 30497.1
Rw704 vdd__p16 vdd__p22 22680.2
Rw705 vdd__p16 vdd__p24 56438
Rw706 vdd__p16 vdd__p26 1396.52
Rw707 vdd__p16 vdd__p27 1463.16
Rw708 vdd__p16 vdd__p28 1585.73
Rw709 vdd__p16 vdd__p29 1978.48
Rw710 vdd__p16 vdd__p3 22634.7
Rw711 vdd__p16 vdd__p30 2332.65
Rw712 vdd__p16 vdd__p31 2299.62
Rw713 vdd__p16 vdd__p32 2475.26
Rw714 vdd__p16 vdd__p33 2637.29
Rw715 vdd__p16 vdd__p34 2842.96
Rw716 vdd__p16 vdd__p36 161.422
Rw717 vdd__p16 vdd__p37 642.132
Rw718 vdd__p16 vdd__p38 1163.58
Rw719 vdd__p16 vdd__p4 238646
Rw720 vdd__p16 vdd__p5 46920.7
Rw721 vdd__p16 vdd__p6 32302.2
Rw722 vdd__p16 vdd__p7 367009
Rw723 vdd__p16 vdd__p8 80622.2
Rw724 vdd__p16 vdd__p9 533991
Rw725 vdd__p17 vdd__p18 1086.01
Rw726 vdd__p17 vdd__p19 33909.8
Rw727 vdd__p17 vdd__p2 5787.63
Rw728 vdd__p17 vdd__p20 30370.6
Rw729 vdd__p17 vdd__p21 29198.5
Rw730 vdd__p17 vdd__p22 21714.4
Rw731 vdd__p17 vdd__p24 54034.8
Rw732 vdd__p17 vdd__p26 1337.05
Rw733 vdd__p17 vdd__p27 1400.85
Rw734 vdd__p17 vdd__p28 1518.21
Rw735 vdd__p17 vdd__p29 1894.24
Rw736 vdd__p17 vdd__p3 23682.1
Rw737 vdd__p17 vdd__p30 2233.33
Rw738 vdd__p17 vdd__p31 2201.7
Rw739 vdd__p17 vdd__p32 2369.86
Rw740 vdd__p17 vdd__p33 2524.99
Rw741 vdd__p17 vdd__p34 2721.9
Rw742 vdd__p17 vdd__p36 154.548
Rw743 vdd__p17 vdd__p37 614.79
Rw744 vdd__p17 vdd__p38 1114.04
Rw745 vdd__p17 vdd__p4 249689
Rw746 vdd__p17 vdd__p5 49091.8
Rw747 vdd__p17 vdd__p6 30926.7
Rw748 vdd__p17 vdd__p7 351382
Rw749 vdd__p17 vdd__p8 77189.2
Rw750 vdd__p17 vdd__p9 511253
Rw751 vdd__p18 vdd__p19 31011.4
Rw752 vdd__p18 vdd__p2 6121.3
Rw753 vdd__p18 vdd__p20 27774.7
Rw754 vdd__p18 vdd__p21 26702.7
Rw755 vdd__p18 vdd__p22 19858.4
Rw756 vdd__p18 vdd__p24 49416.2
Rw757 vdd__p18 vdd__p26 1222.77
Rw758 vdd__p18 vdd__p27 1281.12
Rw759 vdd__p18 vdd__p28 1388.44
Rw760 vdd__p18 vdd__p29 1732.33
Rw761 vdd__p18 vdd__p3 25047.4
Rw762 vdd__p18 vdd__p30 2042.43
Rw763 vdd__p18 vdd__p31 2013.51
Rw764 vdd__p18 vdd__p32 2167.29
Rw765 vdd__p18 vdd__p33 2309.17
Rw766 vdd__p18 vdd__p34 2489.25
Rw767 vdd__p18 vdd__p36 141.338
Rw768 vdd__p18 vdd__p37 562.241
Rw769 vdd__p18 vdd__p38 1018.81
Rw770 vdd__p18 vdd__p4 264084
Rw771 vdd__p18 vdd__p5 51922.1
Rw772 vdd__p18 vdd__p6 28283.3
Rw773 vdd__p18 vdd__p7 321348
Rw774 vdd__p18 vdd__p8 70591.5
Rw775 vdd__p18 vdd__p9 467554
Rw776 vdd__p19 vdd__p2 191133
Rw777 vdd__p19 vdd__p20 25.2411
Rw778 vdd__p19 vdd__p21 2543.24
Rw779 vdd__p19 vdd__p22 186562
Rw780 vdd__p19 vdd__p24 464247
Rw781 vdd__p19 vdd__p26 24293.5
Rw782 vdd__p19 vdd__p27 23387
Rw783 vdd__p19 vdd__p28 22003
Rw784 vdd__p19 vdd__p29 18344.4
Rw785 vdd__p19 vdd__p3 782088
Rw786 vdd__p19 vdd__p30 19187.9
Rw787 vdd__p19 vdd__p31 16736.9
Rw788 vdd__p19 vdd__p32 15893.6
Rw789 vdd__p19 vdd__p33 14892.1
Rw790 vdd__p19 vdd__p34 14070
Rw791 vdd__p19 vdd__p36 798.884
Rw792 vdd__p19 vdd__p37 173.057
Rw793 vdd__p19 vdd__p38 97.0347
Rw794 vdd__p19 vdd__p6 2693.78
Rw795 vdd__p19 vdd__p7 30606
Rw796 vdd__p19 vdd__p8 6723.33
Rw797 vdd__p19 vdd__p9 44531.1
Rw798 vdd__p2 vdd__p20 171184
Rw799 vdd__p2 vdd__p21 164577
Rw800 vdd__p2 vdd__p22 122393
Rw801 vdd__p2 vdd__p24 304568
Rw802 vdd__p2 vdd__p26 7536.3
Rw803 vdd__p2 vdd__p27 7895.92
Rw804 vdd__p2 vdd__p28 8557.4
Rw805 vdd__p2 vdd__p29 10676.9
Rw806 vdd__p2 vdd__p3 67.9448
Rw807 vdd__p2 vdd__p30 12588.2
Rw808 vdd__p2 vdd__p31 12409.9
Rw809 vdd__p2 vdd__p32 13357.7
Rw810 vdd__p2 vdd__p33 14232.1
Rw811 vdd__p2 vdd__p34 15342
Rw812 vdd__p2 vdd__p36 871.111
Rw813 vdd__p2 vdd__p37 3465.27
Rw814 vdd__p2 vdd__p38 6279.27
Rw815 vdd__p2 vdd__p4 716.368
Rw816 vdd__p2 vdd__p5 140.846
Rw817 vdd__p2 vdd__p6 174319
Rw818 vdd__p2 vdd__p8 435078
Rw819 vdd__p20 vdd__p21 2277.8
Rw820 vdd__p20 vdd__p22 167090
Rw821 vdd__p20 vdd__p24 415793
Rw822 vdd__p20 vdd__p26 21757.9
Rw823 vdd__p20 vdd__p27 20946
Rw824 vdd__p20 vdd__p28 19706.5
Rw825 vdd__p20 vdd__p29 16429.8
Rw826 vdd__p20 vdd__p3 700459
Rw827 vdd__p20 vdd__p30 17185.2
Rw828 vdd__p20 vdd__p31 14990.1
Rw829 vdd__p20 vdd__p32 14234.8
Rw830 vdd__p20 vdd__p33 13337.8
Rw831 vdd__p20 vdd__p34 12601.4
Rw832 vdd__p20 vdd__p36 715.502
Rw833 vdd__p20 vdd__p37 154.994
Rw834 vdd__p20 vdd__p38 86.9069
Rw835 vdd__p20 vdd__p6 2412.62
Rw836 vdd__p20 vdd__p7 27411.6
Rw837 vdd__p20 vdd__p8 6021.6
Rw838 vdd__p20 vdd__p9 39883.3
Rw839 vdd__p21 vdd__p22 160642
Rw840 vdd__p21 vdd__p24 399746
Rw841 vdd__p21 vdd__p26 20918.2
Rw842 vdd__p21 vdd__p27 20137.6
Rw843 vdd__p21 vdd__p28 18946
Rw844 vdd__p21 vdd__p29 15795.7
Rw845 vdd__p21 vdd__p3 673426
Rw846 vdd__p21 vdd__p30 16522
Rw847 vdd__p21 vdd__p31 14411.5
Rw848 vdd__p21 vdd__p32 13685.4
Rw849 vdd__p21 vdd__p33 12823
Rw850 vdd__p21 vdd__p34 12115.1
Rw851 vdd__p21 vdd__p36 687.888
Rw852 vdd__p21 vdd__p37 149.013
Rw853 vdd__p21 vdd__p38 23.996
Rw854 vdd__p21 vdd__p6 2140.85
Rw855 vdd__p21 vdd__p7 24323.8
Rw856 vdd__p21 vdd__p8 5343.29
Rw857 vdd__p21 vdd__p9 35390.6
Rw858 vdd__p22 vdd__p23 21.6623
Rw859 vdd__p22 vdd__p24 78.0251
Rw860 vdd__p22 vdd__p26 15556.5
Rw861 vdd__p22 vdd__p27 14976
Rw862 vdd__p22 vdd__p28 14089.8
Rw863 vdd__p22 vdd__p29 11747
Rw864 vdd__p22 vdd__p3 500816
Rw865 vdd__p22 vdd__p30 144.59
Rw866 vdd__p22 vdd__p31 12113.1
Rw867 vdd__p22 vdd__p32 13038.3
Rw868 vdd__p22 vdd__p33 13891.8
Rw869 vdd__p22 vdd__p34 14975.1
Rw870 vdd__p22 vdd__p36 850.28
Rw871 vdd__p22 vdd__p37 3382.4
Rw872 vdd__p22 vdd__p38 6129.11
Rw873 vdd__p22 vdd__p6 170150
Rw874 vdd__p22 vdd__p8 424673
Rw875 vdd__p24 vdd__p25 21.8792
Rw876 vdd__p24 vdd__p26 38711.3
Rw877 vdd__p24 vdd__p27 37266.8
Rw878 vdd__p24 vdd__p28 35061.5
Rw879 vdd__p24 vdd__p29 29231.6
Rw880 vdd__p24 vdd__p30 359.803
Rw881 vdd__p24 vdd__p31 30142.7
Rw882 vdd__p24 vdd__p32 32444.9
Rw883 vdd__p24 vdd__p33 34568.8
Rw884 vdd__p24 vdd__p34 37264.6
Rw885 vdd__p24 vdd__p36 2115.86
Rw886 vdd__p24 vdd__p37 8416.87
Rw887 vdd__p24 vdd__p38 15251.9
Rw888 vdd__p24 vdd__p6 423407
Rw889 vdd__p26 vdd__p27 1003.59
Rw890 vdd__p26 vdd__p28 1087.67
Rw891 vdd__p26 vdd__p29 1357.06
Rw892 vdd__p26 vdd__p3 30837.4
Rw893 vdd__p26 vdd__p30 1599.99
Rw894 vdd__p26 vdd__p31 1577.33
Rw895 vdd__p26 vdd__p32 1697.8
Rw896 vdd__p26 vdd__p33 1808.94
Rw897 vdd__p26 vdd__p34 1950.01
Rw898 vdd__p26 vdd__p36 110.72
Rw899 vdd__p26 vdd__p37 440.444
Rw900 vdd__p26 vdd__p38 798.11
Rw901 vdd__p26 vdd__p4 325130
Rw902 vdd__p26 vdd__p5 63924.4
Rw903 vdd__p26 vdd__p6 22156.3
Rw904 vdd__p26 vdd__p7 251735
Rw905 vdd__p26 vdd__p8 55299.4
Rw906 vdd__p26 vdd__p9 366269
Rw907 vdd__p27 vdd__p28 1047.08
Rw908 vdd__p27 vdd__p29 1306.42
Rw909 vdd__p27 vdd__p3 32308.9
Rw910 vdd__p27 vdd__p30 1540.28
Rw911 vdd__p27 vdd__p31 1518.47
Rw912 vdd__p27 vdd__p32 1634.44
Rw913 vdd__p27 vdd__p33 1741.44
Rw914 vdd__p27 vdd__p34 1877.24
Rw915 vdd__p27 vdd__p36 106.589
Rw916 vdd__p27 vdd__p37 424.009
Rw917 vdd__p27 vdd__p38 768.329
Rw918 vdd__p27 vdd__p4 340645
Rw919 vdd__p27 vdd__p5 66974.8
Rw920 vdd__p27 vdd__p6 21329.6
Rw921 vdd__p27 vdd__p7 242341
Rw922 vdd__p27 vdd__p8 53235.9
Rw923 vdd__p27 vdd__p9 352601
Rw924 vdd__p28 vdd__p29 1229.11
Rw925 vdd__p28 vdd__p3 35015.6
Rw926 vdd__p28 vdd__p30 1449.14
Rw927 vdd__p28 vdd__p31 1428.62
Rw928 vdd__p28 vdd__p32 1537.73
Rw929 vdd__p28 vdd__p33 1638.39
Rw930 vdd__p28 vdd__p34 1766.16
Rw931 vdd__p28 vdd__p36 100.281
Rw932 vdd__p28 vdd__p37 398.918
Rw933 vdd__p28 vdd__p38 722.863
Rw934 vdd__p28 vdd__p4 369183
Rw935 vdd__p28 vdd__p5 72585.6
Rw936 vdd__p28 vdd__p6 20067.4
Rw937 vdd__p28 vdd__p7 228001
Rw938 vdd__p28 vdd__p8 50085.7
Rw939 vdd__p28 vdd__p9 331736
Rw940 vdd__p29 vdd__p3 43688.2
Rw941 vdd__p29 vdd__p30 1208.18
Rw942 vdd__p29 vdd__p31 1191.07
Rw943 vdd__p29 vdd__p32 1282.04
Rw944 vdd__p29 vdd__p33 1365.96
Rw945 vdd__p29 vdd__p34 1472.49
Rw946 vdd__p29 vdd__p36 83.607
Rw947 vdd__p29 vdd__p37 332.587
Rw948 vdd__p29 vdd__p38 602.668
Rw949 vdd__p29 vdd__p4 460621
Rw950 vdd__p29 vdd__p5 90563.4
Rw951 vdd__p29 vdd__p6 16730.6
Rw952 vdd__p29 vdd__p7 190089
Rw953 vdd__p29 vdd__p8 41757.6
Rw954 vdd__p29 vdd__p9 276576
Rw955 vdd__p3 vdd__p30 51508.9
Rw956 vdd__p3 vdd__p31 50779.5
Rw957 vdd__p3 vdd__p32 54657.8
Rw958 vdd__p3 vdd__p33 58235.8
Rw959 vdd__p3 vdd__p34 62777.3
Rw960 vdd__p3 vdd__p36 3564.46
Rw961 vdd__p3 vdd__p37 14179.4
Rw962 vdd__p3 vdd__p38 25693.8
Rw963 vdd__p3 vdd__p4 620.375
Rw964 vdd__p3 vdd__p5 121.973
Rw965 vdd__p3 vdd__p6 713286
Rw966 vdd__p30 vdd__p31 1245.84
Rw967 vdd__p30 vdd__p32 1340.99
Rw968 vdd__p30 vdd__p33 1428.77
Rw969 vdd__p30 vdd__p34 1540.19
Rw970 vdd__p30 vdd__p36 87.4512
Rw971 vdd__p30 vdd__p37 347.88
Rw972 vdd__p30 vdd__p38 630.379
Rw973 vdd__p30 vdd__p4 543077
Rw974 vdd__p30 vdd__p5 106775
Rw975 vdd__p30 vdd__p6 17499.9
Rw976 vdd__p30 vdd__p7 198830
Rw977 vdd__p30 vdd__p8 43677.6
Rw978 vdd__p30 vdd__p9 289293
Rw979 vdd__p31 vdd__p32 1169.69
Rw980 vdd__p31 vdd__p33 1246.27
Rw981 vdd__p31 vdd__p34 1343.45
Rw982 vdd__p31 vdd__p36 76.2806
Rw983 vdd__p31 vdd__p37 303.443
Rw984 vdd__p31 vdd__p38 549.857
Rw985 vdd__p31 vdd__p4 535387
Rw986 vdd__p31 vdd__p5 105263
Rw987 vdd__p31 vdd__p6 15264.6
Rw988 vdd__p31 vdd__p7 173432
Rw989 vdd__p31 vdd__p8 38098.4
Rw990 vdd__p31 vdd__p9 252340
Rw991 vdd__p32 vdd__p33 1183.47
Rw992 vdd__p32 vdd__p34 1275.76
Rw993 vdd__p32 vdd__p36 72.4371
Rw994 vdd__p32 vdd__p37 288.154
Rw995 vdd__p32 vdd__p38 522.152
Rw996 vdd__p32 vdd__p4 576277
Rw997 vdd__p32 vdd__p5 113303
Rw998 vdd__p32 vdd__p6 14495.4
Rw999 vdd__p32 vdd__p7 164694
Rw1000 vdd__p32 vdd__p8 36178.8
Rw1001 vdd__p32 vdd__p9 239626
Rw1002 vdd__p33 vdd__p34 1195.37
Rw1003 vdd__p33 vdd__p36 67.8724
Rw1004 vdd__p33 vdd__p37 269.995
Rw1005 vdd__p33 vdd__p38 489.248
Rw1006 vdd__p33 vdd__p4 614002
Rw1007 vdd__p33 vdd__p5 120720
Rw1008 vdd__p33 vdd__p6 13582
Rw1009 vdd__p33 vdd__p7 154315
Rw1010 vdd__p33 vdd__p8 33899
Rw1011 vdd__p33 vdd__p9 224526
Rw1012 vdd__p34 vdd__p36 31.294
Rw1013 vdd__p34 vdd__p37 255.09
Rw1014 vdd__p34 vdd__p38 462.239
Rw1015 vdd__p34 vdd__p4 661884
Rw1016 vdd__p34 vdd__p5 130134
Rw1017 vdd__p34 vdd__p6 12832.2
Rw1018 vdd__p34 vdd__p7 145796
Rw1019 vdd__p34 vdd__p8 32027.6
Rw1020 vdd__p34 vdd__p9 212130
Rw1021 vdd__p36 vdd__p37 14.4839
Rw1022 vdd__p36 vdd__p38 26.2456
Rw1023 vdd__p36 vdd__p4 37581.4
Rw1024 vdd__p36 vdd__p5 7388.94
Rw1025 vdd__p36 vdd__p6 728.604
Rw1026 vdd__p36 vdd__p7 8278.22
Rw1027 vdd__p36 vdd__p8 1818.51
Rw1028 vdd__p36 vdd__p9 12044.6
Rw1029 vdd__p37 vdd__p38 5.68541
Rw1030 vdd__p37 vdd__p4 149498
Rw1031 vdd__p37 vdd__p5 29393.1
Rw1032 vdd__p37 vdd__p6 157.833
Rw1033 vdd__p37 vdd__p7 1793.25
Rw1034 vdd__p37 vdd__p8 393.93
Rw1035 vdd__p37 vdd__p9 2609.15
Rw1036 vdd__p38 vdd__p4 270900
Rw1037 vdd__p38 vdd__p5 53262.1
Rw1038 vdd__p38 vdd__p6 81.6817
Rw1039 vdd__p38 vdd__p7 928.047
Rw1040 vdd__p38 vdd__p8 203.867
Rw1041 vdd__p38 vdd__p9 1350.29
Rw1042 vdd__p4 vdd__p5 66.2743
Rw1043 vdd__p6 vdd__p7 896.401
Rw1044 vdd__p6 vdd__p8 196.915
Rw1045 vdd__p6 vdd__p9 1304.24
Rw1046 vdd__p7 vdd__p8 81.3385
Rw1047 vdd__p7 vdd__p9 538.736
Rw1048 vdd__p8 vdd__p9 114.1
Rw1049 vref vref__p0 1563.29
Rw1050 vref vref__p1 789.41
Rw1051 vref vref__p11 10.112
Rw1052 vref vref__p12 12.0124
Rw1053 vref vref__p2 36.8195
Rw1054 vref vref__p3 36.5831
Rw1055 vref vref__p4 104.331
Rw1056 vref vref__p5 103.661
Rw1057 vref vref__p6 123.308
Rw1058 vref vref__p7 122.516
Rw1059 vref vref__p8 547.167
Rw1060 vref vref__p9 588.453
Rw1061 vref__p0 vref__p1 105.39
Rw1062 vref__p0 vref__p11 1350.35
Rw1063 vref__p0 vref__p12 410.249
Rw1064 vref__p0 vref__p2 16129.3
Rw1065 vref__p0 vref__p3 16025.8
Rw1066 vref__p0 vref__p4 13932.3
Rw1067 vref__p0 vref__p5 13842.9
Rw1068 vref__p0 vref__p6 4947.73
Rw1069 vref__p0 vref__p7 4915.96
Rw1070 vref__p0 vref__p8 256.181
Rw1071 vref__p0 vref__p9 275.511
Rw1072 vref__p1 vref__p11 681.883
Rw1073 vref__p1 vref__p12 207.162
Rw1074 vref__p1 vref__p2 8144.78
Rw1075 vref__p1 vref__p3 8092.49
Rw1076 vref__p1 vref__p4 7035.36
Rw1077 vref__p1 vref__p5 6990.19
Rw1078 vref__p1 vref__p6 2498.44
Rw1079 vref__p1 vref__p7 2482.4
Rw1080 vref__p1 vref__p8 129.363
Rw1081 vref__p1 vref__p9 139.124
Rw1082 vref__p11 vref__p12 10.3762
Rw1083 vref__p11 vref__p2 104.331
Rw1084 vref__p11 vref__p3 103.661
Rw1085 vref__p11 vref__p4 38.7348
Rw1086 vref__p11 vref__p5 38.4861
Rw1087 vref__p11 vref__p6 106.512
Rw1088 vref__p11 vref__p7 105.828
Rw1089 vref__p11 vref__p8 472.636
Rw1090 vref__p11 vref__p9 508.298
Rw1091 vref__p12 vref__p2 123.939
Rw1092 vref__p12 vref__p3 123.143
Rw1093 vref__p12 vref__p4 107.057
Rw1094 vref__p12 vref__p5 106.369
Rw1095 vref__p12 vref__p6 38.0187
Rw1096 vref__p12 vref__p7 37.7746
Rw1097 vref__p12 vref__p8 143.591
Rw1098 vref__p12 vref__p9 154.426
Rw1099 vref__p2 vref__p3 364.683
Rw1100 vref__p2 vref__p4 1076.44
Rw1101 vref__p2 vref__p5 1069.53
Rw1102 vref__p2 vref__p6 1272.23
Rw1103 vref__p2 vref__p7 1264.06
Rw1104 vref__p2 vref__p8 5645.42
Rw1105 vref__p2 vref__p9 6071.39
Rw1106 vref__p3 vref__p4 1069.53
Rw1107 vref__p3 vref__p5 1062.66
Rw1108 vref__p3 vref__p6 1264.06
Rw1109 vref__p3 vref__p7 1255.95
Rw1110 vref__p3 vref__p8 5609.17
Rw1111 vref__p3 vref__p9 6032.41
Rw1112 vref__p4 vref__p5 382.979
Rw1113 vref__p4 vref__p6 1098.94
Rw1114 vref__p4 vref__p7 1091.88
Rw1115 vref__p4 vref__p8 4876.45
Rw1116 vref__p4 vref__p9 5244.39
Rw1117 vref__p5 vref__p6 1091.88
Rw1118 vref__p5 vref__p7 1084.87
Rw1119 vref__p5 vref__p8 4845.14
Rw1120 vref__p5 vref__p9 5210.72
Rw1121 vref__p6 vref__p7 374.297
Rw1122 vref__p6 vref__p8 1731.75
Rw1123 vref__p6 vref__p9 1862.42
Rw1124 vref__p7 vref__p8 1720.63
Rw1125 vref__p7 vref__p9 1850.46
Rw1126 vref__p8 vref__p9 75.1286
Rw1127 vrefl vrefl__p0 254.176
Rw1128 vrefl vrefl__p1 238.128
Rw1129 vrefl vrefl__p10 8143.57
Rw1130 vrefl vrefl__p11 10451.8
Rw1131 vrefl vrefl__p12 160082
Rw1132 vrefl vrefl__p13 15488.8
Rw1133 vrefl vrefl__p14 35256.4
Rw1134 vrefl vrefl__p15 21879.9
Rw1135 vrefl vrefl__p16 24792.1
Rw1136 vrefl vrefl__p17 26496.8
Rw1137 vrefl vrefl__p19 13996.9
Rw1138 vrefl vrefl__p2 209.868
Rw1139 vrefl vrefl__p3 176.628
Rw1140 vrefl vrefl__p4 21.4538
Rw1141 vrefl vrefl__p5 161.59
Rw1142 vrefl vrefl__p6 194.286
Rw1143 vrefl vrefl__p7 224.042
Rw1144 vrefl vrefl__p8 244.49
Rw1145 vrefl vrefl__p9 1304.55
Rw1146 vrefl__p0 vrefl__p1 103.473
Rw1147 vrefl__p0 vrefl__p10 13384
Rw1148 vrefl__p0 vrefl__p11 17177.6
Rw1149 vrefl__p0 vrefl__p12 263095
Rw1150 vrefl__p0 vrefl__p13 25456
Rw1151 vrefl__p0 vrefl__p14 57944.2
Rw1152 vrefl__p0 vrefl__p15 35959.8
Rw1153 vrefl__p0 vrefl__p16 40746
Rw1154 vrefl__p0 vrefl__p17 43547.7
Rw1155 vrefl__p0 vrefl__p19 23004
Rw1156 vrefl__p0 vrefl__p2 132.709
Rw1157 vrefl__p0 vrefl__p3 168.632
Rw1158 vrefl__p0 vrefl__p4 2901.51
Rw1159 vrefl__p0 vrefl__p5 265.575
Rw1160 vrefl__p0 vrefl__p6 319.31
Rw1161 vrefl__p0 vrefl__p7 368.215
Rw1162 vrefl__p0 vrefl__p8 401.822
Rw1163 vrefl__p0 vrefl__p9 2144.04
Rw1164 vrefl__p1 vrefl__p10 12539
Rw1165 vrefl__p1 vrefl__p11 16093.1
Rw1166 vrefl__p1 vrefl__p12 246484
Rw1167 vrefl__p1 vrefl__p13 23848.8
Rw1168 vrefl__p1 vrefl__p14 54285.7
Rw1169 vrefl__p1 vrefl__p15 33689.4
Rw1170 vrefl__p1 vrefl__p16 38173.4
Rw1171 vrefl__p1 vrefl__p17 40798.3
Rw1172 vrefl__p1 vrefl__p19 21551.6
Rw1173 vrefl__p1 vrefl__p2 124.33
Rw1174 vrefl__p1 vrefl__p3 157.985
Rw1175 vrefl__p1 vrefl__p4 2718.32
Rw1176 vrefl__p1 vrefl__p5 248.807
Rw1177 vrefl__p1 vrefl__p6 299.15
Rw1178 vrefl__p1 vrefl__p7 344.967
Rw1179 vrefl__p1 vrefl__p8 376.452
Rw1180 vrefl__p1 vrefl__p9 2008.67
Rw1181 vrefl__p10 vrefl__p11 126.341
Rw1182 vrefl__p10 vrefl__p12 1935.06
Rw1183 vrefl__p10 vrefl__p13 187.228
Rw1184 vrefl__p10 vrefl__p14 426.178
Rw1185 vrefl__p10 vrefl__p15 264.483
Rw1186 vrefl__p10 vrefl__p16 299.686
Rw1187 vrefl__p10 vrefl__p17 320.293
Rw1188 vrefl__p10 vrefl__p19 169.194
Rw1189 vrefl__p10 vrefl__p2 11050.9
Rw1190 vrefl__p10 vrefl__p3 9300.59
Rw1191 vrefl__p10 vrefl__p4 92961.7
Rw1192 vrefl__p10 vrefl__p5 6118.67
Rw1193 vrefl__p10 vrefl__p6 4794.18
Rw1194 vrefl__p10 vrefl__p7 3728.01
Rw1195 vrefl__p10 vrefl__p8 2885.65
Rw1196 vrefl__p10 vrefl__p9 114.062
Rw1197 vrefl__p11 vrefl__p12 1698.02
Rw1198 vrefl__p11 vrefl__p13 164.293
Rw1199 vrefl__p11 vrefl__p14 373.971
Rw1200 vrefl__p11 vrefl__p15 232.084
Rw1201 vrefl__p11 vrefl__p16 262.974
Rw1202 vrefl__p11 vrefl__p17 281.057
Rw1203 vrefl__p11 vrefl__p19 148.468
Rw1204 vrefl__p11 vrefl__p2 14183.2
Rw1205 vrefl__p11 vrefl__p3 11936.8
Rw1206 vrefl__p11 vrefl__p4 119311
Rw1207 vrefl__p11 vrefl__p5 7852.95
Rw1208 vrefl__p11 vrefl__p6 6153.04
Rw1209 vrefl__p11 vrefl__p7 4784.68
Rw1210 vrefl__p11 vrefl__p8 3703.56
Rw1211 vrefl__p11 vrefl__p9 146.392
Rw1212 vrefl__p12 vrefl__p13 1851.68
Rw1213 vrefl__p12 vrefl__p14 4214.88
Rw1214 vrefl__p12 vrefl__p15 2615.73
Rw1215 vrefl__p12 vrefl__p16 2963.88
Rw1216 vrefl__p12 vrefl__p17 3167.68
Rw1217 vrefl__p12 vrefl__p19 21.4766
Rw1218 vrefl__p12 vrefl__p2 217233
Rw1219 vrefl__p12 vrefl__p3 182826
Rw1220 vrefl__p12 vrefl__p5 120277
Rw1221 vrefl__p12 vrefl__p6 94241.2
Rw1222 vrefl__p12 vrefl__p7 73283
Rw1223 vrefl__p12 vrefl__p8 56724.5
Rw1224 vrefl__p12 vrefl__p9 2242.16
Rw1225 vrefl__p13 vrefl__p14 268.346
Rw1226 vrefl__p13 vrefl__p15 166.534
Rw1227 vrefl__p13 vrefl__p16 188.699
Rw1228 vrefl__p13 vrefl__p17 201.674
Rw1229 vrefl__p13 vrefl__p19 161.903
Rw1230 vrefl__p13 vrefl__p2 21018.5
Rw1231 vrefl__p13 vrefl__p3 17689.4
Rw1232 vrefl__p13 vrefl__p4 176810
Rw1233 vrefl__p13 vrefl__p5 11637.5
Rw1234 vrefl__p13 vrefl__p6 9118.38
Rw1235 vrefl__p13 vrefl__p7 7090.55
Rw1236 vrefl__p13 vrefl__p8 5488.42
Rw1237 vrefl__p13 vrefl__p9 216.942
Rw1238 vrefl__p14 vrefl__p15 252.382
Rw1239 vrefl__p14 vrefl__p16 285.974
Rw1240 vrefl__p14 vrefl__p17 305.638
Rw1241 vrefl__p14 vrefl__p19 368.532
Rw1242 vrefl__p14 vrefl__p2 47843.4
Rw1243 vrefl__p14 vrefl__p3 40265.5
Rw1244 vrefl__p14 vrefl__p4 402464
Rw1245 vrefl__p14 vrefl__p5 26489.9
Rw1246 vrefl__p14 vrefl__p6 20755.7
Rw1247 vrefl__p14 vrefl__p7 16139.9
Rw1248 vrefl__p14 vrefl__p8 12493
Rw1249 vrefl__p14 vrefl__p9 493.814
Rw1250 vrefl__p15 vrefl__p16 120.488
Rw1251 vrefl__p15 vrefl__p17 128.773
Rw1252 vrefl__p15 vrefl__p19 228.708
Rw1253 vrefl__p15 vrefl__p2 29691.3
Rw1254 vrefl__p15 vrefl__p3 24988.5
Rw1255 vrefl__p15 vrefl__p4 249766
Rw1256 vrefl__p15 vrefl__p5 16439.4
Rw1257 vrefl__p15 vrefl__p6 12880.8
Rw1258 vrefl__p15 vrefl__p7 10016.3
Rw1259 vrefl__p15 vrefl__p8 7753.08
Rw1260 vrefl__p15 vrefl__p9 306.457
Rw1261 vrefl__p16 vrefl__p17 101.924
Rw1262 vrefl__p16 vrefl__p19 259.149
Rw1263 vrefl__p16 vrefl__p2 33643.2
Rw1264 vrefl__p16 vrefl__p3 28314.5
Rw1265 vrefl__p16 vrefl__p4 283010
Rw1266 vrefl__p16 vrefl__p5 18627.5
Rw1267 vrefl__p16 vrefl__p6 14595.3
Rw1268 vrefl__p16 vrefl__p7 11349.4
Rw1269 vrefl__p16 vrefl__p8 8785.01
Rw1270 vrefl__p16 vrefl__p9 347.247
Rw1271 vrefl__p17 vrefl__p19 276.969
Rw1272 vrefl__p17 vrefl__p2 35956.5
Rw1273 vrefl__p17 vrefl__p3 30261.4
Rw1274 vrefl__p17 vrefl__p4 302470
Rw1275 vrefl__p17 vrefl__p5 19908.4
Rw1276 vrefl__p17 vrefl__p6 15598.9
Rw1277 vrefl__p17 vrefl__p7 12129.9
Rw1278 vrefl__p17 vrefl__p8 9389.08
Rw1279 vrefl__p17 vrefl__p9 371.124
Rw1280 vrefl__p19 vrefl__p2 18994
Rw1281 vrefl__p19 vrefl__p3 15985.5
Rw1282 vrefl__p19 vrefl__p4 159779
Rw1283 vrefl__p19 vrefl__p5 10516.6
Rw1284 vrefl__p19 vrefl__p6 8240.07
Rw1285 vrefl__p19 vrefl__p7 6407.57
Rw1286 vrefl__p19 vrefl__p8 4959.76
Rw1287 vrefl__p19 vrefl__p9 196.045
Rw1288 vrefl__p2 vrefl__p3 139.236
Rw1289 vrefl__p2 vrefl__p4 2395.72
Rw1290 vrefl__p2 vrefl__p5 219.28
Rw1291 vrefl__p2 vrefl__p6 263.648
Rw1292 vrefl__p2 vrefl__p7 304.028
Rw1293 vrefl__p2 vrefl__p8 331.777
Rw1294 vrefl__p2 vrefl__p9 1770.29
Rw1295 vrefl__p3 vrefl__p4 2016.27
Rw1296 vrefl__p3 vrefl__p5 184.548
Rw1297 vrefl__p3 vrefl__p6 221.89
Rw1298 vrefl__p3 vrefl__p7 255.874
Rw1299 vrefl__p3 vrefl__p8 279.227
Rw1300 vrefl__p3 vrefl__p9 1489.9
Rw1301 vrefl__p4 vrefl__p5 1844.61
Rw1302 vrefl__p4 vrefl__p6 2217.84
Rw1303 vrefl__p4 vrefl__p7 2557.52
Rw1304 vrefl__p4 vrefl__p8 2790.94
Rw1305 vrefl__p4 vrefl__p9 14891.9
Rw1306 vrefl__p5 vrefl__p6 145.977
Rw1307 vrefl__p5 vrefl__p7 168.334
Rw1308 vrefl__p5 vrefl__p8 183.698
Rw1309 vrefl__p5 vrefl__p9 980.174
Rw1310 vrefl__p6 vrefl__p7 131.895
Rw1311 vrefl__p6 vrefl__p8 143.933
Rw1312 vrefl__p6 vrefl__p9 767.998
Rw1313 vrefl__p7 vrefl__p8 111.924
Rw1314 vrefl__p7 vrefl__p9 597.204
Rw1315 vrefl__p8 vrefl__p9 462.264
Rw1316 xc4_din xc4_din__p1 51.0551
Rw1317 xc4_din xc4_din__p2 344.407
Rw1318 xc4_din__p1 xc4_din__p2 85.587
Rw1319 xc4_dip xc4_dip__p1 48.2375
Rw1320 xc4_dip xc4_dip__p2 414.166
Rw1321 xc4_dip__p1 xc4_dip__p2 109.461
Rw1322 xc4_lt xc4_lt__p1 10.8365
Rw1323 xc4_lt xc4_lt__p2 12.6193
Rw1324 xc4_lt__p1 xc4_lt__p2 120.796
Rw1325 xc4_outnb xc4_outnb__p1 47.7242
Rw1326 xc4_outpb xc4_outpb__p1 47.3382
Rw1327 xc4_xs1_tail xc4_xs1_tail__p1 71.5986
Rw1328 xc4_xs1_tail xc4_xs1_tail__p2 142.261
Rw1329 xc4_xs1_tail__p1 xc4_xs1_tail__p2 154.206
Rw1330 xc4_xs1_tail0 xc4_xs1_tail0__p1 29.2884
Rw1331 xc5_din xc5_din__p1 130.063
Rw1332 xc5_din xc5_din__p2 74.042
Rw1333 xc5_din__p1 xc5_din__p2 66.6396
Rw1334 xc5_dip xc5_dip__p1 129.665
Rw1335 xc5_dip xc5_dip__p2 75.5526
Rw1336 xc5_dip__p1 xc5_dip__p2 65.1387
Rw1337 xc5_lt xc5_lt__p1 165.919
Rw1338 xc5_lt xc5_lt__p2 166.056
Rw1339 xc5_lt__p1 xc5_lt__p2 20.8871
Rw1340 xc5_outnb xc5_outnb__p1 44.1702
Rw1341 xc5_outpb xc5_outpb__p1 44.1702
Rw1342 xc5_xs1_tail xc5_xs1_tail__p1 59.2156
Rw1343 xc5_xs1_tail__p1 xc5_xs1_tail__p2 19.0185
Rw1344 xc5_xs1_tail0 xc5_xs1_tail0__p1 29.0295
Rw1345 xs0n_cbn xs0n_cbn__p1 1089.56
Rw1346 xs0n_cbn xs0n_cbn__p2 16589.4
Rw1347 xs0n_cbn xs0n_cbn__p3 784.446
Rw1348 xs0n_cbn xs0n_cbn__p4 21.0451
Rw1349 xs0n_cbn__p1 xs0n_cbn__p2 9.96169
Rw1350 xs0n_cbn__p1 xs0n_cbn__p3 1561.64
Rw1351 xs0n_cbn__p1 xs0n_cbn__p4 21.0507
Rw1352 xs0n_cbn__p2 xs0n_cbn__p3 23777.3
Rw1353 xs0n_cbn__p2 xs0n_cbn__p4 320.514
Rw1354 xs0n_cbn__p3 xs0n_cbn__p4 30.1636
Rw1355 xs0n_cbp xs0n_cbp__p1 9.57598
Rw1356 xs0n_cbp xs0n_cbp__p2 59.1671
Rw1357 xs0n_cbp__p1 xs0n_cbp__p2 1243.71
Rw1358 xs0n_g xs0n_g__p1 0.67694
Rw1359 xs0n_g__p1 xs0n_g__p2 25.2118
Rw1360 xs0n_g__p1 xs0n_g__p3 209.923
Rw1361 xs0n_g__p1 xs0n_g__p4 198.15
Rw1362 xs0n_g__p1 xs0n_g__p5 133.079
Rw1363 xs0n_g__p2 xs0n_g__p3 167.588
Rw1364 xs0n_g__p2 xs0n_g__p4 158.189
Rw1365 xs0n_g__p2 xs0n_g__p5 106.241
Rw1366 xs0n_g__p3 xs0n_g__p4 23.6529
Rw1367 xs0n_g__p3 xs0n_g__p5 102.437
Rw1368 xs0n_g__p4 xs0n_g__p5 96.6917
Rw1369 xs0n_n10 xs0n_n10__p1 46.1685
Rw1370 xs0n_x xs0n_x__p1 1.00108
Rw1371 xs0n_x xs0n_x__p2 42.4395
Rw1372 xs0n_x xs0n_x__p3 126.624
Rw1373 xs0n_x__p1 xs0n_x__p2 60.0491
Rw1374 xs0n_x__p1 xs0n_x__p3 179.165
Rw1375 xs0n_x__p2 xs0n_x__p3 61.5879
Rw1376 xs0p_cbn xs0p_cbn__p1 90.3104
Rw1377 xs0p_cbn xs0p_cbn__p2 2073.02
Rw1378 xs0p_cbn xs0p_cbn__p3 36.3159
Rw1379 xs0p_cbn xs0p_cbn__p4 107.321
Rw1380 xs0p_cbn__p1 xs0p_cbn__p2 9.87285
Rw1381 xs0p_cbn__p1 xs0p_cbn__p3 160.393
Rw1382 xs0p_cbn__p1 xs0p_cbn__p4 26.4214
Rw1383 xs0p_cbn__p2 xs0p_cbn__p3 3681.73
Rw1384 xs0p_cbn__p2 xs0p_cbn__p4 606.486
Rw1385 xs0p_cbn__p3 xs0p_cbn__p4 190.604
Rw1386 xs0p_cbp xs0p_cbp__p1 9.5749
Rw1387 xs0p_cbp xs0p_cbp__p2 60.089
Rw1388 xs0p_cbp__p1 xs0p_cbp__p2 1263.09
Rw1389 xs0p_g xs0p_g__p1 0.67694
Rw1390 xs0p_g__p1 xs0p_g__p2 25.2118
Rw1391 xs0p_g__p1 xs0p_g__p3 209.923
Rw1392 xs0p_g__p1 xs0p_g__p4 198.15
Rw1393 xs0p_g__p1 xs0p_g__p5 133.079
Rw1394 xs0p_g__p2 xs0p_g__p3 167.588
Rw1395 xs0p_g__p2 xs0p_g__p4 158.189
Rw1396 xs0p_g__p2 xs0p_g__p5 106.241
Rw1397 xs0p_g__p3 xs0p_g__p4 23.6529
Rw1398 xs0p_g__p3 xs0p_g__p5 102.437
Rw1399 xs0p_g__p4 xs0p_g__p5 96.6917
Rw1400 xs0p_n10 xs0p_n10__p1 46.1685
Rw1401 xs0p_x xs0p_x__p1 1.00105
Rw1402 xs0p_x xs0p_x__p2 42.5398
Rw1403 xs0p_x xs0p_x__p3 126.923
Rw1404 xs0p_x__p1 xs0p_x__p2 60.1909
Rw1405 xs0p_x__p1 xs0p_x__p3 179.588
Rw1406 xs0p_x__p2 xs0p_x__p3 61.4978
Rw1407 xs1n_cbn xs1n_cbn__p1 31.9914
Rw1408 xs1n_cbn xs1n_cbn__p2 1328.66
Rw1409 xs1n_cbn xs1n_cbn__p3 4662.46
Rw1410 xs1n_cbn xs1n_cbn__p4 31.3431
Rw1411 xs1n_cbn__p1 xs1n_cbn__p2 9.86002
Rw1412 xs1n_cbn__p1 xs1n_cbn__p3 4007.11
Rw1413 xs1n_cbn__p1 xs1n_cbn__p4 26.9375
Rw1414 xs1n_cbn__p2 xs1n_cbn__p3 166422
Rw1415 xs1n_cbn__p2 xs1n_cbn__p4 1118.76
Rw1416 xs1n_cbn__p3 xs1n_cbn__p4 29.2978
Rw1417 xs1n_cbp xs1n_cbp__p1 9.54422
Rw1418 xs1n_cbp xs1n_cbp__p2 58.8
Rw1419 xs1n_cbp__p1 xs1n_cbp__p2 1320.09
Rw1420 xs1n_g xs1n_g__p1 0.6347
Rw1421 xs1n_g__p1 xs1n_g__p2 50.4222
Rw1422 xs1n_g__p1 xs1n_g__p3 350.24
Rw1423 xs1n_g__p1 xs1n_g__p4 405.356
Rw1424 xs1n_g__p1 xs1n_g__p5 481.735
Rw1425 xs1n_g__p2 xs1n_g__p3 112.116
Rw1426 xs1n_g__p2 xs1n_g__p4 129.759
Rw1427 xs1n_g__p2 xs1n_g__p5 154.209
Rw1428 xs1n_g__p3 xs1n_g__p4 30.5272
Rw1429 xs1n_g__p3 xs1n_g__p5 36.2793
Rw1430 xs1n_g__p4 xs1n_g__p5 33.2348
Rw1431 xs1n_n10 xs1n_n10__p1 10.7757
Rw1432 xs1n_x xs1n_x__p1 1.43436
Rw1433 xs1n_x xs1n_x__p2 61.0361
Rw1434 xs1n_x xs1n_x__p3 177.702
Rw1435 xs1n_x__p1 xs1n_x__p2 42.6192
Rw1436 xs1n_x__p1 xs1n_x__p3 124.083
Rw1437 xs1n_x__p2 xs1n_x__p3 61.9394
Rw1438 xs1p_cbn xs1p_cbn__p1 90.6795
Rw1439 xs1p_cbn xs1p_cbn__p2 1917.8
Rw1440 xs1p_cbn xs1p_cbn__p3 36.2644
Rw1441 xs1p_cbn xs1p_cbn__p4 107.009
Rw1442 xs1p_cbn__p1 xs1p_cbn__p2 9.94467
Rw1443 xs1p_cbn__p1 xs1p_cbn__p3 161.481
Rw1444 xs1p_cbn__p1 xs1p_cbn__p4 26.5667
Rw1445 xs1p_cbn__p2 xs1p_cbn__p3 3415.2
Rw1446 xs1p_cbn__p2 xs1p_cbn__p4 561.866
Rw1447 xs1p_cbn__p3 xs1p_cbn__p4 190.561
Rw1448 xs1p_cbp xs1p_cbp__p1 9.54302
Rw1449 xs1p_cbp xs1p_cbp__p2 59.8889
Rw1450 xs1p_cbp__p1 xs1p_cbp__p2 1344.53
Rw1451 xs1p_g xs1p_g__p1 0.6347
Rw1452 xs1p_g__p1 xs1p_g__p2 25.0282
Rw1453 xs1p_g__p1 xs1p_g__p3 227.075
Rw1454 xs1p_g__p1 xs1p_g__p4 204.371
Rw1455 xs1p_g__p1 xs1p_g__p5 130.835
Rw1456 xs1p_g__p2 xs1p_g__p3 181.724
Rw1457 xs1p_g__p2 xs1p_g__p4 163.555
Rw1458 xs1p_g__p2 xs1p_g__p5 104.705
Rw1459 xs1p_g__p3 xs1p_g__p4 24.22
Rw1460 xs1p_g__p3 xs1p_g__p5 104.731
Rw1461 xs1p_g__p4 xs1p_g__p5 94.2599
Rw1462 xs1p_n10 xs1p_n10__p1 46.209
Rw1463 xs1p_x xs1p_x__p1 1.00105
Rw1464 xs1p_x xs1p_x__p2 42.5398
Rw1465 xs1p_x xs1p_x__p3 126.923
Rw1466 xs1p_x__p1 xs1p_x__p2 60.1909
Rw1467 xs1p_x__p1 xs1p_x__p3 179.588
Rw1468 xs1p_x__p2 xs1p_x__p3 61.4978
Cp0 bn0 bn1 2.632e-16
Cp1 bn0 bn10 4.539e-17
Cp2 bn0 bn11 4.486e-17
Cp3 bn0 bn12 6.037e-17
Cp4 bn0 bn2 7.057e-15
Cp5 bn0 bn3 2.248e-16
Cp6 bn0 bn4 2.663e-16
Cp7 bn0 bn5 1.004e-15
Cp8 bn0 bn6 9.648e-16
Cp9 bn0 bn7 1.721e-15
Cp10 bn0 bn8 4.759e-17
Cp11 bn0 bn9 4.682e-17
Cp12 bn0 bp11 1.837e-16
Cp13 bn0 bp12 6.813e-16
Cp14 bn0 cn0 5.872e-16
Cp15 bn0 cn1 7.702e-17
Cp16 bn0 cn2 2.003e-19
Cp17 bn0 gnd 3.555e-15
Cp18 bn0 lsb_n 1.472e-16
Cp19 bn0 lsb_p 6.004e-17
Cp20 bn0 on 5.532e-19
Cp21 bn0 onp 1.625e-17
Cp22 bn0 op 2.31e-18
Cp23 bn0 rstb 7.712e-17
Cp24 bn0 vdd 1.525e-16
Cp25 bn0 vrefl 6.398e-16
Cp26 bn0 xc4_din 5.426e-17
Cp27 bn0 xc4_dip 3.417e-16
Cp28 bn0 xc4_outnb 6.863e-17
Cp29 bn0 xc4_outpb 6.983e-19
Cp30 bn1 bn10 7.366e-17
Cp31 bn1 bn11 5.327e-16
Cp32 bn1 bn12 5.054e-16
Cp33 bn1 bn2 1.009e-15
Cp34 bn1 bn3 8.083e-16
Cp35 bn1 bn4 5.046e-16
Cp36 bn1 bn5 1.047e-15
Cp37 bn1 bn6 1.98e-15
Cp38 bn1 bn7 1.573e-15
Cp39 bn1 bn8 5.488e-17
Cp40 bn1 bn9 5.508e-17
Cp41 bn1 bp12 1.302e-17
Cp42 bn1 cn1 2.505e-16
Cp43 bn1 cn2 1.52e-16
Cp44 bn1 gnd 2.383e-15
Cp45 bn1 lsb_n 1.641e-16
Cp46 bn1 lsb_p 6.444e-17
Cp47 bn1 on 1.137e-18
Cp48 bn1 onp 2.523e-17
Cp49 bn1 rstb 6.776e-17
Cp50 bn1 vdd 3.414e-16
Cp51 bn1 vrefl 6.215e-16
Cp52 bn1 xc4_din 9.675e-17
Cp53 bn1 xc4_dip 1.564e-15
Cp54 bn1 xc4_outnb 7.002e-17
Cp55 bn1 xc4_outpb 1.411e-18
Cp56 bn10 bn11 2.101e-14
Cp57 bn10 bn12 5.769e-15
Cp58 bn10 bn2 3.845e-17
Cp59 bn10 bn3 3.845e-17
Cp60 bn10 bn4 3.845e-17
Cp61 bn10 bn5 4.892e-16
Cp62 bn10 bn6 2.086e-15
Cp63 bn10 bn7 2.302e-15
Cp64 bn10 bn8 1.201e-15
Cp65 bn10 bn9 1.323e-14
Cp66 bn10 bp0 4.911e-17
Cp67 bn10 bp1 4.662e-17
Cp68 bn10 bp10 2.248e-15
Cp69 bn10 bp11 5.365e-17
Cp70 bn10 bp12 3.882e-17
Cp71 bn10 bp2 4.145e-17
Cp72 bn10 bp3 3.846e-17
Cp73 bn10 bp4 3.882e-17
Cp74 bn10 bp5 3.882e-17
Cp75 bn10 bp6 3.882e-17
Cp76 bn10 bp7 3.882e-17
Cp77 bn10 bp8 2.021e-16
Cp78 bn10 bp9 7.85e-17
Cp79 bn10 cn10 8.432e-17
Cp80 bn10 cn11 1.224e-18
Cp81 bn10 cn8 1.924e-17
Cp82 bn10 cn9 1.31e-16
Cp83 bn10 gnd 5.289e-15
Cp84 bn10 lsb_n 6.709e-16
Cp85 bn10 lsb_p 3.655e-16
Cp86 bn10 onp 3.178e-18
Cp87 bn10 rstb 7.419e-17
Cp88 bn10 vdd 9.049e-17
Cp89 bn10 vref 1.122e-15
Cp90 bn10 vrefl 5.527e-17
Cp91 bn10 xc4_din 1.53e-16
Cp92 bn10 xc4_dip 1.431e-16
Cp93 bn11 bn12 3.381e-14
Cp94 bn11 bn2 3.792e-17
Cp95 bn11 bn3 3.792e-17
Cp96 bn11 bn4 3.792e-17
Cp97 bn11 bn5 6.931e-17
Cp98 bn11 bn6 2.969e-15
Cp99 bn11 bn7 3.341e-15
Cp100 bn11 bn8 5.258e-16
Cp101 bn11 bn9 7.8e-16
Cp102 bn11 bp0 9.649e-17
Cp103 bn11 bp1 3.792e-17
Cp104 bn11 bp10 5.726e-16
Cp105 bn11 bp11 4.598e-15
Cp106 bn11 bp12 5.17e-17
Cp107 bn11 bp2 3.275e-17
Cp108 bn11 bp3 3.846e-17
Cp109 bn11 bp4 4.971e-17
Cp110 bn11 bp5 4.698e-16
Cp111 bn11 bp6 4.754e-16
Cp112 bn11 bp7 5.071e-17
Cp113 bn11 bp8 1.873e-16
Cp114 bn11 bp9 2.238e-16
Cp115 bn11 cn10 4.854e-16
Cp116 bn11 cn11 1.638e-16
Cp117 bn11 cn12 5.376e-19
Cp118 bn11 cn9 1.422e-17
Cp119 bn11 gnd 5.732e-15
Cp120 bn11 lsb_n 6.01e-16
Cp121 bn11 lsb_p 3.889e-16
Cp122 bn11 onp 1.634e-18
Cp123 bn11 rstb 3.611e-17
Cp124 bn11 vdd 5.249e-17
Cp125 bn11 vref 7.54e-16
Cp126 bn11 vrefl 7.831e-17
Cp127 bn11 xc4_din 6.785e-16
Cp128 bn11 xc4_dip 7.984e-17
Cp129 bn12 bn2 3.882e-17
Cp130 bn12 bn3 3.882e-17
Cp131 bn12 bn4 3.882e-17
Cp132 bn12 bn5 4.317e-17
Cp133 bn12 bn6 5.082e-15
Cp134 bn12 bn7 5.501e-15
Cp135 bn12 bn8 1.244e-15
Cp136 bn12 bn9 3.1e-15
Cp137 bn12 bp0 4.93e-16
Cp138 bn12 bp1 4.199e-16
Cp139 bn12 bp10 3.49e-16
Cp140 bn12 bp11 5.593e-16
Cp141 bn12 bp12 1.034e-14
Cp142 bn12 bp2 4.482e-17
Cp143 bn12 bp3 3.104e-16
Cp144 bn12 bp4 5.713e-16
Cp145 bn12 bp5 8.047e-17
Cp146 bn12 bp6 7.773e-17
Cp147 bn12 bp7 5.569e-16
Cp148 bn12 bp8 8.083e-16
Cp149 bn12 bp9 8.832e-16
Cp150 bn12 cn10 9.143e-17
Cp151 bn12 cn11 4.825e-16
Cp152 bn12 cn12 4.622e-16
Cp153 bn12 cp12 8.781e-18
Cp154 bn12 gnd 8.421e-15
Cp155 bn12 lsb_n 1.732e-14
Cp156 bn12 lsb_p 3.728e-16
Cp157 bn12 onp 3.965e-18
Cp158 bn12 rstb 3.759e-17
Cp159 bn12 top_n 1.311e-17
Cp160 bn12 vdd 4.324e-17
Cp161 bn12 vref 1.249e-15
Cp162 bn12 vrefl 1.192e-16
Cp163 bn12 xc4_din 2.078e-16
Cp164 bn12 xc4_dip 5.425e-17
Cp165 bn2 bn3 1.449e-14
Cp166 bn2 bn4 4.308e-16
Cp167 bn2 bn5 3.373e-15
Cp168 bn2 bn6 1.877e-15
Cp169 bn2 bn7 2.699e-15
Cp170 bn2 bn8 4.065e-17
Cp171 bn2 bn9 3.988e-17
Cp172 bn2 bp0 5.211e-16
Cp173 bn2 bp1 4.677e-16
Cp174 bn2 bp10 4.595e-17
Cp175 bn2 bp11 4.598e-17
Cp176 bn2 bp12 3.024e-17
Cp177 bn2 bp2 5.659e-17
Cp178 bn2 bp3 4.685e-17
Cp179 bn2 bp4 4.632e-17
Cp180 bn2 bp5 4.632e-17
Cp181 bn2 bp6 4.632e-17
Cp182 bn2 bp7 4.632e-17
Cp183 bn2 bp8 4.776e-17
Cp184 bn2 bp9 4.542e-17
Cp185 bn2 cn2 2.503e-16
Cp186 bn2 cn3 1.52e-16
Cp187 bn2 gnd 3.46e-15
Cp188 bn2 lsb_n 1.429e-16
Cp189 bn2 lsb_p 1.125e-16
Cp190 bn2 onp 2.523e-17
Cp191 bn2 rstb 6.614e-17
Cp192 bn2 vdd 1.423e-16
Cp193 bn2 vrefl 6.116e-16
Cp194 bn2 xc4_din 5.849e-17
Cp195 bn2 xc4_dip 5.04e-16
Cp196 bn2 xc4_outnb 7.321e-17
Cp197 bn2 xc4_outpb 1.596e-18
Cp198 bn3 bn4 2.359e-14
Cp199 bn3 bn5 5.932e-15
Cp200 bn3 bn6 3.465e-15
Cp201 bn3 bn7 3.98e-15
Cp202 bn3 bn8 4.065e-17
Cp203 bn3 bn9 3.988e-17
Cp204 bn3 bp0 4.399e-17
Cp205 bn3 bp1 3.601e-17
Cp206 bn3 bp10 3.845e-17
Cp207 bn3 bp11 3.849e-17
Cp208 bn3 bp12 3.024e-17
Cp209 bn3 bp2 3.845e-17
Cp210 bn3 bp3 3.935e-17
Cp211 bn3 bp4 3.882e-17
Cp212 bn3 bp5 3.882e-17
Cp213 bn3 bp6 7.995e-17
Cp214 bn3 bp7 6.755e-16
Cp215 bn3 bp8 4.026e-17
Cp216 bn3 bp9 3.792e-17
Cp217 bn3 cn2 3.974e-19
Cp218 bn3 cn3 5.114e-16
Cp219 bn3 cn4 5.026e-16
Cp220 bn3 gnd 4.432e-15
Cp221 bn3 lsb_n 2.092e-16
Cp222 bn3 lsb_p 3.915e-16
Cp223 bn3 onp 1.292e-17
Cp224 bn3 rstb 5.586e-17
Cp225 bn3 vdd 2.521e-16
Cp226 bn3 vrefl 5.81e-16
Cp227 bn3 xc4_din 7.648e-17
Cp228 bn3 xc4_dip 6.106e-16
Cp229 bn3 xc4_outnb 1.311e-16
Cp230 bn4 bn5 3.794e-14
Cp231 bn4 bn6 5.494e-15
Cp232 bn4 bn7 5.632e-15
Cp233 bn4 bn8 5.675e-16
Cp234 bn4 bn9 2.682e-16
Cp235 bn4 bp0 3.777e-17
Cp236 bn4 bp1 3.601e-17
Cp237 bn4 bp10 4.598e-17
Cp238 bn4 bp11 3.849e-17
Cp239 bn4 bp12 3.024e-17
Cp240 bn4 bp2 3.845e-17
Cp241 bn4 bp3 3.181e-16
Cp242 bn4 bp4 6.238e-16
Cp243 bn4 bp5 8.256e-17
Cp244 bn4 bp6 3.882e-17
Cp245 bn4 bp7 2.969e-17
Cp246 bn4 bp8 5.161e-16
Cp247 bn4 bp9 4.129e-16
Cp248 bn4 cn3 2.742e-19
Cp249 bn4 cn4 4.424e-17
Cp250 bn4 cn5 1.495e-16
Cp251 bn4 gnd 5.226e-15
Cp252 bn4 lsb_n 1.971e-16
Cp253 bn4 lsb_p 1.036e-16
Cp254 bn4 onp 6.847e-18
Cp255 bn4 rstb 5.59e-17
Cp256 bn4 vdd 6.359e-16
Cp257 bn4 vrefl 1.603e-15
Cp258 bn4 xc4_din 9.987e-17
Cp259 bn4 xc4_dip 6.246e-16
Cp260 bn4 xc4_outnb 2.156e-18
Cp261 bn5 bn6 1.213e-14
Cp262 bn5 bn7 1.74e-14
Cp263 bn5 bn8 1.194e-16
Cp264 bn5 bn9 3.529e-16
Cp265 bn5 bp0 9.703e-17
Cp266 bn5 bp1 9.466e-17
Cp267 bn5 bp10 5.215e-16
Cp268 bn5 bp11 2.356e-16
Cp269 bn5 bp12 4.034e-17
Cp270 bn5 bp2 5.141e-16
Cp271 bn5 bp3 2.481e-16
Cp272 bn5 bp4 4.992e-17
Cp273 bn5 bp5 4.665e-16
Cp274 bn5 bp6 4.717e-16
Cp275 bn5 bp7 5.137e-17
Cp276 bn5 bp8 9.334e-17
Cp277 bn5 bp9 1.033e-16
Cp278 bn5 cn5 2.504e-16
Cp279 bn5 cn6 1.522e-16
Cp280 bn5 gnd 1.032e-14
Cp281 bn5 lsb_n 5.513e-16
Cp282 bn5 lsb_p 3.089e-16
Cp283 bn5 onp 3.623e-18
Cp284 bn5 rstb 6.715e-17
Cp285 bn5 top_n 1.26e-19
Cp286 bn5 top_p 7.569e-18
Cp287 bn5 vdd 5.21e-16
Cp288 bn5 vrefl 6.179e-16
Cp289 bn5 xc4_din 1.013e-16
Cp290 bn5 xc4_dip 6.583e-16
Cp291 bn5 xc4_outnb 9.225e-19
Cp292 bn5 xs1n_cbp 2.091e-19
Cp293 bn5 xs1n_n10 2.244e-18
Cp294 bn6 bn7 1.163e-14
Cp295 bn6 bn8 7.423e-16
Cp296 bn6 bn9 1.994e-15
Cp297 bn6 bp0 6.733e-16
Cp298 bn6 bp1 5.426e-16
Cp299 bn6 bp10 6.568e-16
Cp300 bn6 bp11 5.943e-16
Cp301 bn6 bp12 8.081e-16
Cp302 bn6 bp2 6.364e-16
Cp303 bn6 bp3 6.091e-16
Cp304 bn6 bp4 9.209e-16
Cp305 bn6 bp5 5.852e-16
Cp306 bn6 bp6 5.901e-16
Cp307 bn6 bp7 8.532e-16
Cp308 bn6 bp8 6.868e-16
Cp309 bn6 bp9 5.326e-16
Cp310 bn6 cn6 2.505e-16
Cp311 bn6 cn7 1.523e-16
Cp312 bn6 cn8 1.024e-19
Cp313 bn6 gnd 2.876e-14
Cp314 bn6 lsb_n 1.803e-15
Cp315 bn6 lsb_p 6.762e-16
Cp316 bn6 onp 3.623e-18
Cp317 bn6 rstb 6.715e-17
Cp318 bn6 top_n 5.775e-18
Cp319 bn6 top_p 7.569e-18
Cp320 bn6 vdd 1.355e-15
Cp321 bn6 vrefl 6.176e-16
Cp322 bn6 xc4_din 9.78e-17
Cp323 bn6 xc4_dip 3.713e-15
Cp324 bn6 xs1n_g 2.467e-19
Cp325 bn7 bn8 3.597e-15
Cp326 bn7 bn9 2.051e-15
Cp327 bn7 bp0 1.241e-15
Cp328 bn7 bp1 1.033e-15
Cp329 bn7 bp10 1.198e-15
Cp330 bn7 bp11 1.116e-15
Cp331 bn7 bp12 1.393e-15
Cp332 bn7 bp2 1.174e-15
Cp333 bn7 bp3 1.142e-15
Cp334 bn7 bp4 1.533e-15
Cp335 bn7 bp5 1.108e-15
Cp336 bn7 bp6 1.12e-15
Cp337 bn7 bp7 1.45e-15
Cp338 bn7 bp8 1.256e-15
Cp339 bn7 bp9 1.016e-15
Cp340 bn7 cn7 2.505e-16
Cp341 bn7 cn8 6.101e-17
Cp342 bn7 gnd 4.292e-14
Cp343 bn7 lsb_n 2.155e-15
Cp344 bn7 lsb_p 1.23e-15
Cp345 bn7 onp 3.623e-18
Cp346 bn7 rstb 7.887e-17
Cp347 bn7 t0 3.223e-19
Cp348 bn7 t1b 5.677e-18
Cp349 bn7 top_n 6.005e-18
Cp350 bn7 top_p 1.514e-17
Cp351 bn7 vdd 2.461e-15
Cp352 bn7 vrefl 6.209e-16
Cp353 bn7 xc4_din 4.852e-15
Cp354 bn7 xc4_dip 8.65e-16
Cp355 bn8 bn9 5.234e-15
Cp356 bn8 bp12 6.613e-18
Cp357 bn8 cn7 6.18e-19
Cp358 bn8 cn8 7.077e-16
Cp359 bn8 cn9 1.777e-17
Cp360 bn8 gnd 5.821e-15
Cp361 bn8 lsb_n 3.437e-16
Cp362 bn8 lsb_p 1.097e-15
Cp363 bn8 onp 1.034e-18
Cp364 bn8 rstb 9.064e-17
Cp365 bn8 top_n 2.126e-16
Cp366 bn8 top_p 3.132e-18
Cp367 bn8 vdd 1.493e-16
Cp368 bn8 vref 3.089e-16
Cp369 bn8 vrefl 2.441e-16
Cp370 bn8 xc4_din 1.703e-16
Cp371 bn8 xc4_dip 6.616e-16
Cp372 bn9 bp1 5.089e-17
Cp373 bn9 bp10 6.415e-17
Cp374 bn9 bp11 4.808e-17
Cp375 bn9 bp12 4.742e-17
Cp376 bn9 bp2 5.494e-16
Cp377 bn9 bp3 2.762e-16
Cp378 bn9 bp4 4.742e-17
Cp379 bn9 bp5 4.742e-17
Cp380 bn9 bp6 4.742e-17
Cp381 bn9 bp7 4.742e-17
Cp382 bn9 bp8 9.711e-17
Cp383 bn9 bp9 1.172e-15
Cp384 bn9 cn10 3.335e-18
Cp385 bn9 cn11 4.295e-19
Cp386 bn9 cn7 1.2e-19
Cp387 bn9 cn8 5.647e-17
Cp388 bn9 cn9 5.89e-16
Cp389 bn9 gnd 4.745e-15
Cp390 bn9 lsb_n 1.581e-16
Cp391 bn9 lsb_p 1.091e-16
Cp392 bn9 onp 7.507e-19
Cp393 bn9 rstb 7.074e-17
Cp394 bn9 vdd 2.099e-16
Cp395 bn9 vref 5.373e-16
Cp396 bn9 vrefl 8.711e-17
Cp397 bn9 xc4_din 7.791e-16
Cp398 bn9 xc4_dip 3.74e-16
Cp399 bp0 bp1 1.19e-15
Cp400 bp0 bp10 4.444e-17
Cp401 bp0 bp11 9.649e-17
Cp402 bp0 bp12 5.005e-16
Cp403 bp0 bp2 1.374e-15
Cp404 bp0 bp3 1.807e-15
Cp405 bp0 bp4 5.152e-16
Cp406 bp0 bp5 7.4e-16
Cp407 bp0 bp6 1.791e-15
Cp408 bp0 bp7 8.897e-16
Cp409 bp0 bp8 5.138e-17
Cp410 bp0 cp0 2.746e-16
Cp411 bp0 cp1 9.713e-17
Cp412 bp0 cp2 7.798e-17
Cp413 bp0 cp3 9.015e-17
Cp414 bp0 cp4 1.549e-17
Cp415 bp0 cp6 2.003e-19
Cp416 bp0 gnd 5.685e-15
Cp417 bp0 lsb_n 4.735e-17
Cp418 bp0 onp 7.507e-19
Cp419 bp0 vdd 1.787e-17
Cp420 bp0 vrefl 6.224e-16
Cp421 bp0 xc4_din 4.378e-16
Cp422 bp0 xc4_dip 1.706e-16
Cp423 bp1 bp10 4.195e-17
Cp424 bp1 bp11 3.792e-17
Cp425 bp1 bp12 4.274e-16
Cp426 bp1 bp2 8.644e-15
Cp427 bp1 bp3 1.287e-15
Cp428 bp1 bp4 2.977e-16
Cp429 bp1 bp5 1.349e-15
Cp430 bp1 bp6 1.21e-15
Cp431 bp1 bp7 2.272e-15
Cp432 bp1 bp8 4.889e-17
Cp433 bp1 bp9 5.089e-17
Cp434 bp1 cp0 1.909e-15
Cp435 bp1 cp1 4.414e-16
Cp436 bp1 cp2 6.607e-17
Cp437 bp1 cp3 5.605e-17
Cp438 bp1 cp4 9.684e-19
Cp439 bp1 cp5 1.117e-17
Cp440 bp1 cp6 1.885e-18
Cp441 bp1 gnd 4.062e-15
Cp442 bp1 lsb_n 4.486e-17
Cp443 bp1 onp 3.386e-19
Cp444 bp1 vdd 2.767e-17
Cp445 bp1 vrefl 1.033e-15
Cp446 bp1 xc4_din 1.636e-16
Cp447 bp1 xc4_dip 7.788e-17
Cp448 bp10 bp11 2.034e-14
Cp449 bp10 bp12 6.1e-15
Cp450 bp10 bp2 3.679e-17
Cp451 bp10 bp3 3.846e-17
Cp452 bp10 bp4 3.882e-17
Cp453 bp10 bp5 3.882e-17
Cp454 bp10 bp6 1.262e-15
Cp455 bp10 bp7 1.223e-15
Cp456 bp10 bp8 1.429e-15
Cp457 bp10 bp9 1.426e-14
Cp458 bp10 cn11 1.344e-19
Cp459 bp10 cn12 2.667e-19
Cp460 bp10 cp10 5.676e-16
Cp461 bp10 cp11 6.123e-17
Cp462 bp10 cp12 1.253e-16
Cp463 bp10 cp8 1.344e-19
Cp464 bp10 cp9 3.877e-16
Cp465 bp10 gnd 4.481e-15
Cp466 bp10 lsb_n 6.515e-17
Cp467 bp10 lsb_p 5.755e-16
Cp468 bp10 onp 3.354e-19
Cp469 bp10 rstb 3.625e-17
Cp470 bp10 vdd 1.271e-16
Cp471 bp10 vref 1.079e-15
Cp472 bp10 vrefl 8.027e-16
Cp473 bp10 xc4_din 4.588e-16
Cp474 bp10 xc4_dip 7.11e-17
Cp475 bp11 bp12 3.412e-14
Cp476 bp11 bp2 3.275e-17
Cp477 bp11 bp3 3.846e-17
Cp478 bp11 bp4 4.971e-17
Cp479 bp11 bp5 4.698e-16
Cp480 bp11 bp6 2.927e-15
Cp481 bp11 bp7 2.409e-15
Cp482 bp11 bp8 5.197e-16
Cp483 bp11 bp9 5.585e-16
Cp484 bp11 cn11 2.184e-18
Cp485 bp11 cn12 4.681e-16
Cp486 bp11 cp10 3.367e-18
Cp487 bp11 cp11 7.574e-17
Cp488 bp11 cp12 9.58e-17
Cp489 bp11 gnd 5.873e-15
Cp490 bp11 lsb_n 7.72e-17
Cp491 bp11 lsb_p 6.335e-16
Cp492 bp11 onp 3.793e-18
Cp493 bp11 rstb 4.721e-17
Cp494 bp11 vdd 2.137e-16
Cp495 bp11 vref 1.683e-15
Cp496 bp11 vrefl 9.182e-17
Cp497 bp11 xc4_din 6.571e-16
Cp498 bp11 xc4_dip 5.14e-17
Cp499 bp12 bp2 5.232e-17
Cp500 bp12 bp3 3.179e-16
Cp501 bp12 bp4 5.788e-16
Cp502 bp12 bp5 8.797e-17
Cp503 bp12 bp6 5.779e-15
Cp504 bp12 bp7 5.302e-15
Cp505 bp12 bp8 1.224e-15
Cp506 bp12 bp9 3.187e-15
Cp507 bp12 cn10 1.344e-19
Cp508 bp12 cn11 1.155e-16
Cp509 bp12 cn12 1.034e-16
Cp510 bp12 cp10 3.526e-17
Cp511 bp12 cp11 4.784e-16
Cp512 bp12 cp12 1.373e-15
Cp513 bp12 gnd 7.936e-15
Cp514 bp12 lsb_n 1.038e-16
Cp515 bp12 lsb_p 1.766e-14
Cp516 bp12 onp 1.634e-18
Cp517 bp12 rstb 3.496e-17
Cp518 bp12 top_p 1.311e-17
Cp519 bp12 vdd 6.029e-17
Cp520 bp12 vref 9.889e-16
Cp521 bp12 vrefl 2.819e-16
Cp522 bp12 xc4_din 1.047e-16
Cp523 bp12 xc4_dip 6.262e-17
Cp524 bp2 bp3 1.516e-14
Cp525 bp2 bp4 4.479e-16
Cp526 bp2 bp5 4.264e-15
Cp527 bp2 bp6 2.072e-15
Cp528 bp2 bp7 2.839e-15
Cp529 bp2 bp8 4.942e-17
Cp530 bp2 bp9 5.494e-16
Cp531 bp2 cp0 1.252e-18
Cp532 bp2 cp1 1.33e-16
Cp533 bp2 cp2 1.987e-16
Cp534 bp2 cp3 6.424e-17
Cp535 bp2 cp4 8.439e-17
Cp536 bp2 cp5 3.778e-18
Cp537 bp2 cp6 2.958e-16
Cp538 bp2 cp7 8.328e-18
Cp539 bp2 gnd 4.665e-15
Cp540 bp2 lsb_n 4.539e-17
Cp541 bp2 onp 2.878e-18
Cp542 bp2 vdd 3.919e-17
Cp543 bp2 vrefl 1.396e-15
Cp544 bp2 xc4_din 1.695e-16
Cp545 bp2 xc4_dip 8.051e-17
Cp546 bp3 bp4 2.42e-14
Cp547 bp3 bp5 6.307e-15
Cp548 bp3 bp6 3.832e-15
Cp549 bp3 bp7 4.161e-15
Cp550 bp3 bp8 4.629e-17
Cp551 bp3 bp9 2.676e-16
Cp552 bp3 cp0 3.02e-18
Cp553 bp3 cp1 8.679e-19
Cp554 bp3 cp2 4.374e-16
Cp555 bp3 cp3 1.675e-16
Cp556 bp3 cp4 2.605e-18
Cp557 bp3 cp5 2.35e-18
Cp558 bp3 cp6 1.028e-16
Cp559 bp3 cp7 2.226e-16
Cp560 bp3 gnd 5.993e-15
Cp561 bp3 lsb_n 4.629e-17
Cp562 bp3 onp 2.396e-18
Cp563 bp3 t1 1.038e-19
Cp564 bp3 vdd 7.308e-17
Cp565 bp3 vrefl 9.381e-16
Cp566 bp3 xc4_din 4.193e-16
Cp567 bp3 xc4_dip 8.461e-17
Cp568 bp4 bp5 3.893e-14
Cp569 bp4 bp6 6.406e-15
Cp570 bp4 bp7 6.093e-15
Cp571 bp4 bp8 4.576e-17
Cp572 bp4 bp9 3.882e-17
Cp573 bp4 cp3 1.175e-17
Cp574 bp4 cp4 2.054e-16
Cp575 bp4 cp5 4.919e-17
Cp576 bp4 cp6 5.111e-17
Cp577 bp4 cp7 1.29e-16
Cp578 bp4 gnd 6.804e-15
Cp579 bp4 lsb_n 4.576e-17
Cp580 bp4 lsb_p 7.713e-17
Cp581 bp4 onp 4.716e-18
Cp582 bp4 rstb 6.182e-17
Cp583 bp4 t1 3.747e-19
Cp584 bp4 vdd 1.417e-16
Cp585 bp4 vrefl 7.519e-16
Cp586 bp4 xc4_din 1.803e-15
Cp587 bp4 xc4_dip 1.019e-16
Cp588 bp5 bp6 1.266e-14
Cp589 bp5 bp7 1.818e-14
Cp590 bp5 bp8 4.576e-17
Cp591 bp5 bp9 3.882e-17
Cp592 bp5 cp0 1.438e-19
Cp593 bp5 cp3 4.593e-19
Cp594 bp5 cp4 3.057e-16
Cp595 bp5 cp5 2.154e-15
Cp596 bp5 cp6 5.936e-17
Cp597 bp5 cp7 6.705e-17
Cp598 bp5 cp8 4.677e-18
Cp599 bp5 gnd 1.152e-14
Cp600 bp5 lsb_n 4.576e-17
Cp601 bp5 lsb_p 9.171e-19
Cp602 bp5 onp 6.999e-19
Cp603 bp5 rstb 8.786e-17
Cp604 bp5 t0 2.382e-18
Cp605 bp5 top_p 3.138e-19
Cp606 bp5 vdd 1.148e-16
Cp607 bp5 vref 1.84e-18
Cp608 bp5 vrefl 1.533e-15
Cp609 bp5 xc4_din 4.655e-16
Cp610 bp5 xc4_dip 8.634e-17
Cp611 bp5 xs0p_x 1.022e-19
Cp612 bp5 xs1p_n10 1.9e-18
Cp613 bp6 bp7 1.386e-14
Cp614 bp6 bp8 7.798e-16
Cp615 bp6 bp9 6.872e-16
Cp616 bp6 cp10 3.789e-19
Cp617 bp6 cp2 3.469e-18
Cp618 bp6 cp4 1.112e-16
Cp619 bp6 cp5 9.447e-17
Cp620 bp6 cp6 5.973e-16
Cp621 bp6 cp7 1.886e-16
Cp622 bp6 cp8 1.263e-16
Cp623 bp6 cp9 1.266e-18
Cp624 bp6 gnd 3.151e-14
Cp625 bp6 lsb_n 4.586e-17
Cp626 bp6 lsb_p 3.713e-16
Cp627 bp6 onp 5.475e-19
Cp628 bp6 rstb 2.133e-18
Cp629 bp6 top_p 1.027e-17
Cp630 bp6 vdd 1.417e-16
Cp631 bp6 vref 5.433e-18
Cp632 bp6 vrefl 1.279e-15
Cp633 bp6 xc4_din 5.081e-16
Cp634 bp6 xc4_dip 8.046e-17
Cp635 bp7 bp8 8.496e-16
Cp636 bp7 bp9 8.002e-16
Cp637 bp7 cp10 2.553e-18
Cp638 bp7 cp4 7.826e-18
Cp639 bp7 cp5 6.068e-17
Cp640 bp7 cp6 3.514e-16
Cp641 bp7 cp7 2.074e-16
Cp642 bp7 cp8 1.368e-16
Cp643 bp7 cp9 7.834e-17
Cp644 bp7 gnd 4.906e-14
Cp645 bp7 lsb_n 4.576e-17
Cp646 bp7 lsb_p 4.131e-15
Cp647 bp7 onp 7.672e-18
Cp648 bp7 rstb 9.59e-17
Cp649 bp7 t0 5.596e-18
Cp650 bp7 t1 1.806e-19
Cp651 bp7 top_p 4.329e-18
Cp652 bp7 vdd 1.407e-16
Cp653 bp7 vref 7.974e-17
Cp654 bp7 vrefl 4.143e-16
Cp655 bp7 xc4_din 1.37e-15
Cp656 bp7 xc4_dip 7.421e-17
Cp657 bp7 xs1p_cbp 2.091e-19
Cp658 bp7 xs1p_g 5.339e-19
Cp659 bp8 bp9 4.763e-15
Cp660 bp8 cp10 2.992e-16
Cp661 bp8 cp12 5.406e-19
Cp662 bp8 cp6 3.132e-19
Cp663 bp8 cp8 4.658e-16
Cp664 bp8 cp9 6.55e-17
Cp665 bp8 gnd 4.868e-15
Cp666 bp8 lsb_n 2.353e-15
Cp667 bp8 lsb_p 7.26e-16
Cp668 bp8 onp 4.121e-19
Cp669 bp8 rstb 4.908e-17
Cp670 bp8 top_n 3.779e-18
Cp671 bp8 top_p 2.178e-16
Cp672 bp8 vdd 1.286e-16
Cp673 bp8 vref 7.274e-16
Cp674 bp8 vrefl 1.193e-15
Cp675 bp8 xc4_din 5.367e-16
Cp676 bp8 xc4_dip 7.066e-17
Cp677 bp9 cp10 2.472e-16
Cp678 bp9 cp11 1.19e-16
Cp679 bp9 cp12 4.796e-18
Cp680 bp9 cp7 2.03e-17
Cp681 bp9 cp8 7.059e-17
Cp682 bp9 cp9 3.054e-16
Cp683 bp9 gnd 4.019e-15
Cp684 bp9 lsb_n 5.491e-16
Cp685 bp9 lsb_p 4.541e-16
Cp686 bp9 onp 9.943e-18
Cp687 bp9 rstb 5.216e-17
Cp688 bp9 vdd 1.039e-16
Cp689 bp9 vref 8.212e-16
Cp690 bp9 vrefl 5.841e-17
Cp691 bp9 xc4_din 4.484e-16
Cp692 bp9 xc4_dip 7.898e-17
Cp693 clkb clkn 4.749e-17
Cp694 clkb gnd 2.129e-14
Cp695 clkb on 1.229e-16
Cp696 clkb onn 3.375e-17
Cp697 clkb onp 6.031e-17
Cp698 clkb op 5.945e-17
Cp699 clkb t1 5.189e-17
Cp700 clkb t1b 5.804e-17
Cp701 clkb top_p 5.329e-17
Cp702 clkb vbp 1.055e-16
Cp703 clkb vdd 1.1e-14
Cp704 clkb vref 5.062e-16
Cp705 clkb vrefl 3.518e-16
Cp706 clkb xc4_din 2.92e-16
Cp707 clkb xc4_dip 4.512e-16
Cp708 clkb xc4_outnb 1.662e-17
Cp709 clkb xc4_outpb 1.119e-17
Cp710 clkb xc4_xs1_tail 1.245e-16
Cp711 clkb xc4_xs1_tail0 3.84e-16
Cp712 clkb xc5_din 1.076e-16
Cp713 clkb xc5_dip 5.043e-17
Cp714 clkb xc5_lt 4.817e-17
Cp715 clkb xc5_outnb 9.657e-18
Cp716 clkb xc5_outpb 1.593e-19
Cp717 clkb xc5_xs1_tail 7.844e-17
Cp718 clkn gnd 1.942e-14
Cp719 clkn onn 2.96e-19
Cp720 clkn onp 4.965e-19
Cp721 clkn top_n 4.691e-16
Cp722 clkn top_p 3.08e-16
Cp723 clkn vbn 7.469e-17
Cp724 clkn vbp 4.883e-19
Cp725 clkn vdd 6.745e-16
Cp726 clkn vrefl 1.432e-19
Cp727 clkn xc4_din 6.48e-18
Cp728 clkn xc4_dip 2.315e-18
Cp729 clkn xc4_xs1_tail 8.205e-18
Cp730 clkn xc5_din 2.437e-16
Cp731 clkn xc5_dip 2.303e-16
Cp732 clkn xc5_lt 5.977e-18
Cp733 clkn xc5_xs1_tail 7.919e-17
Cp734 clkn xc5_xs1_tail0 1.778e-16
Cp735 cn0 cn1 4.899e-17
Cp736 cn0 gnd 8.907e-16
Cp737 cn0 lsb_p 5.698e-17
Cp738 cn0 on 3.502e-18
Cp739 cn0 onp 5.463e-17
Cp740 cn0 op 2.678e-18
Cp741 cn0 rstb 3.231e-17
Cp742 cn0 vdd 3.859e-18
Cp743 cn0 vrefl 2.489e-16
Cp744 cn0 xc4_din 1.741e-18
Cp745 cn0 xc4_dip 1.912e-16
Cp746 cn0 xc4_outnb 5.701e-17
Cp747 cn0 xc4_outpb 2.399e-18
Cp748 cn1 cn2 3.997e-17
Cp749 cn1 gnd 9.54e-16
Cp750 cn1 lsb_p 6.476e-17
Cp751 cn1 on 4.556e-18
Cp752 cn1 onp 5.422e-17
Cp753 cn1 rstb 3.22e-17
Cp754 cn1 vdd 1.291e-18
Cp755 cn1 vrefl 2.567e-16
Cp756 cn1 xc4_din 2.245e-19
Cp757 cn1 xc4_dip 3.439e-18
Cp758 cn1 xc4_outnb 6.482e-17
Cp759 cn1 xc4_outpb 2.5e-18
Cp760 cn10 cn11 2.417e-16
Cp761 cn10 cn12 1.15e-16
Cp762 cn10 cn8 2.495e-19
Cp763 cn10 cn9 6.482e-17
Cp764 cn10 cp12 3.277e-19
Cp765 cn10 gnd 1.771e-15
Cp766 cn10 lsb_p 5.547e-17
Cp767 cn10 onp 8.095e-16
Cp768 cn10 rstb 4.675e-17
Cp769 cn10 vdd 1.418e-18
Cp770 cn10 vref 3.596e-16
Cp771 cn10 vrefl 1.098e-16
Cp772 cn10 xc4_dip 4.329e-19
Cp773 cn11 cn12 2.35e-16
Cp774 cn11 cn9 9.934e-18
Cp775 cn11 cp12 2.1e-16
Cp776 cn11 gnd 1.371e-15
Cp777 cn11 lsb_p 8.349e-17
Cp778 cn11 onp 8.431e-17
Cp779 cn11 rstb 4.302e-17
Cp780 cn11 vdd 1.66e-18
Cp781 cn11 vref 5.07e-16
Cp782 cn11 vrefl 2.644e-16
Cp783 cn11 xc4_din 3.861e-19
Cp784 cn11 xc4_dip 8.925e-19
Cp785 cn12 cp10 1.933e-19
Cp786 cn12 cp11 1.146e-16
Cp787 cn12 cp12 4.077e-16
Cp788 cn12 gnd 1.121e-15
Cp789 cn12 lsb_p 5.317e-17
Cp790 cn12 onp 7.988e-16
Cp791 cn12 rstb 3.564e-17
Cp792 cn12 vdd 1.418e-18
Cp793 cn12 vref 5.639e-16
Cp794 cn12 vrefl 8.731e-17
Cp795 cn12 xc4_din 4.335e-19
Cp796 cn12 xc4_dip 4.329e-19
Cp797 cn2 cn3 3.997e-17
Cp798 cn2 gnd 9.314e-16
Cp799 cn2 lsb_p 6.261e-17
Cp800 cn2 on 4.161e-18
Cp801 cn2 onp 5.414e-17
Cp802 cn2 rstb 3.211e-17
Cp803 cn2 vdd 1.291e-18
Cp804 cn2 vrefl 2.542e-16
Cp805 cn2 xc4_din 2.245e-19
Cp806 cn2 xc4_dip 3.569e-18
Cp807 cn2 xc4_outnb 6.369e-17
Cp808 cn2 xc4_outpb 2.533e-18
Cp809 cn3 cn4 9.824e-17
Cp810 cn3 gnd 8.193e-16
Cp811 cn3 lsb_p 5.695e-17
Cp812 cn3 onp 5.229e-17
Cp813 cn3 rstb 2.86e-17
Cp814 cn3 vdd 1.291e-18
Cp815 cn3 vrefl 2.358e-16
Cp816 cn3 xc4_din 1.006e-19
Cp817 cn3 xc4_dip 3.504e-18
Cp818 cn3 xc4_outnb 3.051e-16
Cp819 cn4 cn5 2.356e-17
Cp820 cn4 gnd 8.721e-16
Cp821 cn4 lsb_n 7.729e-19
Cp822 cn4 lsb_p 5.691e-17
Cp823 cn4 onp 7.094e-17
Cp824 cn4 rstb 5.05e-17
Cp825 cn4 vdd 2.213e-18
Cp826 cn4 vrefl 1.222e-15
Cp827 cn4 xc4_din 1.284e-18
Cp828 cn4 xc4_dip 1.173e-17
Cp829 cn4 xc4_outnb 2.488e-16
Cp830 cn5 cn6 5.105e-17
Cp831 cn5 gnd 8.606e-16
Cp832 cn5 lsb_p 6.732e-17
Cp833 cn5 onp 6.84e-17
Cp834 cn5 rstb 3.156e-17
Cp835 cn5 vdd 1.291e-18
Cp836 cn5 vrefl 2.96e-16
Cp837 cn5 xc4_din 2.245e-19
Cp838 cn5 xc4_dip 3.569e-18
Cp839 cn5 xc4_outnb 6.519e-19
Cp840 cn6 cn7 5.105e-17
Cp841 cn6 gnd 8.396e-16
Cp842 cn6 lsb_p 6.732e-17
Cp843 cn6 onp 7.107e-17
Cp844 cn6 rstb 3.211e-17
Cp845 cn6 vdd 1.291e-18
Cp846 cn6 vrefl 2.543e-16
Cp847 cn6 xc4_din 2.245e-19
Cp848 cn6 xc4_dip 3.569e-18
Cp849 cn7 cn8 3.268e-17
Cp850 cn7 gnd 8.474e-16
Cp851 cn7 lsb_p 6.732e-17
Cp852 cn7 onp 7.207e-17
Cp853 cn7 rstb 4.171e-17
Cp854 cn7 vdd 1.291e-18
Cp855 cn7 vrefl 2.544e-16
Cp856 cn7 xc4_din 2.245e-19
Cp857 cn7 xc4_dip 3.569e-18
Cp858 cn8 cn9 3.872e-16
Cp859 cn8 gnd 1.102e-15
Cp860 cn8 lsb_p 1.29e-16
Cp861 cn8 onp 7.095e-17
Cp862 cn8 rstb 3.611e-16
Cp863 cn8 vdd 1.69e-18
Cp864 cn8 vref 2.877e-16
Cp865 cn8 vrefl 5.627e-16
Cp866 cn8 xc4_din 4.041e-19
Cp867 cn8 xc4_dip 3.347e-17
Cp868 cn9 gnd 1.139e-15
Cp869 cn9 lsb_p 1.089e-16
Cp870 cn9 onp 7.252e-17
Cp871 cn9 rstb 4.318e-16
Cp872 cn9 vdd 2.444e-18
Cp873 cn9 vref 8.527e-16
Cp874 cn9 vrefl 6.025e-17
Cp875 cn9 xc4_din 6.328e-19
Cp876 cn9 xc4_dip 4.953e-18
Cp877 cp0 cp1 1.292e-15
Cp878 cp0 cp2 1.094e-16
Cp879 cp0 cp3 1.165e-16
Cp880 cp0 cp4 5.987e-18
Cp881 cp0 cp6 1.024e-19
Cp882 cp0 gnd 1.127e-15
Cp883 cp0 onp 1.664e-16
Cp884 cp0 t1 8.088e-19
Cp885 cp0 vdd 1.428e-18
Cp886 cp0 vrefl 1.802e-16
Cp887 cp0 xc4_din 2.931e-18
Cp888 cp0 xc4_dip 1.413e-17
Cp889 cp1 cp2 1.31e-15
Cp890 cp1 cp3 5.766e-17
Cp891 cp1 cp4 1.749e-19
Cp892 cp1 cp5 1.336e-19
Cp893 cp1 cp6 7.065e-18
Cp894 cp1 gnd 1.194e-15
Cp895 cp1 onp 1.742e-16
Cp896 cp1 t1 4.583e-19
Cp897 cp1 vdd 1.447e-18
Cp898 cp1 vrefl 5.71e-16
Cp899 cp1 xc4_din 6.307e-18
Cp900 cp1 xc4_dip 1.082e-18
Cp901 cp10 cp11 4.89e-16
Cp902 cp10 cp12 1.599e-16
Cp903 cp10 cp6 3.807e-18
Cp904 cp10 cp8 2.81e-18
Cp905 cp10 cp9 6.564e-16
Cp906 cp10 gnd 1.179e-15
Cp907 cp10 lsb_p 5.179e-17
Cp908 cp10 onp 6.592e-17
Cp909 cp10 rstb 4.302e-17
Cp910 cp10 t1 1.086e-19
Cp911 cp10 vdd 1.955e-18
Cp912 cp10 vref 7.642e-16
Cp913 cp10 vrefl 4.372e-17
Cp914 cp10 xc4_din 3.865e-18
Cp915 cp10 xc4_dip 1.15e-18
Cp916 cp11 cp12 2.115e-16
Cp917 cp11 cp9 1.137e-16
Cp918 cp11 gnd 1.098e-15
Cp919 cp11 lsb_p 5.359e-17
Cp920 cp11 onp 7.94e-16
Cp921 cp11 rstb 4.327e-17
Cp922 cp11 t1 6.332e-19
Cp923 cp11 vdd 1.418e-18
Cp924 cp11 vref 6.493e-16
Cp925 cp11 vrefl 1.001e-16
Cp926 cp11 xc4_din 7.475e-19
Cp927 cp11 xc4_dip 2.814e-19
Cp928 cp12 gnd 1.211e-15
Cp929 cp12 lsb_p 5.238e-17
Cp930 cp12 onp 5.866e-17
Cp931 cp12 rstb 4.302e-17
Cp932 cp12 t1 2.924e-18
Cp933 cp12 vdd 1.617e-18
Cp934 cp12 vref 7.164e-16
Cp935 cp12 vrefl 1.07e-16
Cp936 cp12 xc4_din 1.616e-19
Cp937 cp12 xc4_dip 5.786e-19
Cp938 cp2 cp3 1.202e-16
Cp939 cp2 cp4 4.699e-19
Cp940 cp2 cp6 1.533e-16
Cp941 cp2 cp7 1.06e-17
Cp942 cp2 gnd 1.282e-15
Cp943 cp2 onp 1.68e-15
Cp944 cp2 t1 5.246e-19
Cp945 cp2 vdd 1.447e-18
Cp946 cp2 vrefl 3.738e-16
Cp947 cp2 xc4_din 6.508e-18
Cp948 cp2 xc4_dip 1.082e-18
Cp949 cp3 cp4 3.536e-17
Cp950 cp3 cp6 1.5e-18
Cp951 cp3 cp7 6.388e-18
Cp952 cp3 gnd 1.933e-15
Cp953 cp3 onp 1.798e-15
Cp954 cp3 t1 1.177e-17
Cp955 cp3 vdd 1.311e-18
Cp956 cp3 vrefl 5.073e-16
Cp957 cp3 xc4_din 5.999e-18
Cp958 cp3 xc4_dip 7.684e-19
Cp959 cp4 cp5 1.7e-15
Cp960 cp4 cp6 7.529e-17
Cp961 cp4 cp7 7.71e-17
Cp962 cp4 cp8 4.602e-19
Cp963 cp4 gnd 1.019e-15
Cp964 cp4 lsb_p 1.799e-18
Cp965 cp4 onp 5.416e-17
Cp966 cp4 rstb 3.411e-16
Cp967 cp4 t1 3.512e-19
Cp968 cp4 vdd 3.01e-18
Cp969 cp4 vref 1.474e-19
Cp970 cp4 vrefl 1.743e-15
Cp971 cp4 xc4_din 6.198e-18
Cp972 cp4 xc4_dip 1.082e-18
Cp973 cp5 cp6 1.467e-16
Cp974 cp5 cp7 9.873e-17
Cp975 cp5 cp8 1.839e-17
Cp976 cp5 gnd 1.085e-15
Cp977 cp5 lsb_p 6.983e-19
Cp978 cp5 onp 6.41e-17
Cp979 cp5 rstb 2.775e-16
Cp980 cp5 vdd 1.798e-18
Cp981 cp5 vref 1.219e-18
Cp982 cp5 vrefl 4.651e-16
Cp983 cp5 xc4_din 3.504e-18
Cp984 cp5 xc4_dip 4.86e-19
Cp985 cp6 cp7 1.476e-15
Cp986 cp6 cp8 2.679e-16
Cp987 cp6 cp9 8.706e-18
Cp988 cp6 gnd 1.066e-15
Cp989 cp6 lsb_p 1.174e-19
Cp990 cp6 onp 1.393e-16
Cp991 cp6 rstb 3.977e-19
Cp992 cp6 t1 6.332e-19
Cp993 cp6 vdd 4.185e-18
Cp994 cp6 vref 5.933e-18
Cp995 cp6 vrefl 8.341e-16
Cp996 cp6 xc4_din 1.05e-18
Cp997 cp6 xc4_dip 1.623e-19
Cp998 cp7 cp8 5.916e-17
Cp999 cp7 cp9 1.14e-16
Cp1000 cp7 gnd 1.232e-15
Cp1001 cp7 onp 1.784e-15
Cp1002 cp7 rstb 9.143e-18
Cp1003 cp7 t1 6.332e-19
Cp1004 cp7 vdd 1.291e-18
Cp1005 cp7 vref 2.835e-18
Cp1006 cp7 vrefl 2.606e-16
Cp1007 cp7 xc4_din 3.479e-18
Cp1008 cp7 xc4_dip 3.139e-19
Cp1009 cp8 cp9 3.194e-17
Cp1010 cp8 gnd 1.668e-15
Cp1011 cp8 lsb_p 4.595e-17
Cp1012 cp8 onp 1.014e-15
Cp1013 cp8 rstb 6.411e-17
Cp1014 cp8 t1 6.471e-19
Cp1015 cp8 vdd 1.491e-18
Cp1016 cp8 vref 3.449e-16
Cp1017 cp8 vrefl 5.31e-17
Cp1018 cp8 xc4_din 3.255e-18
Cp1019 cp8 xc4_dip 2.539e-19
Cp1020 cp9 gnd 1.13e-15
Cp1021 cp9 lsb_p 5.867e-17
Cp1022 cp9 onp 7.938e-16
Cp1023 cp9 rstb 4.543e-17
Cp1024 cp9 t1 1.086e-19
Cp1025 cp9 vdd 1.762e-18
Cp1026 cp9 vref 4.332e-16
Cp1027 cp9 vrefl 4.518e-17
Cp1028 cp9 xc4_din 6.09e-18
Cp1029 cp9 xc4_dip 1.049e-18
Cp1030 gnd in0n 1.477e-15
Cp1031 gnd in0p 1.738e-15
Cp1032 gnd in1n 1.734e-15
Cp1033 gnd in1p 1.956e-15
Cp1034 gnd lsb_n 1.197e-14
Cp1035 gnd lsb_p 1.174e-14
Cp1036 gnd nr 9.241e-16
Cp1037 gnd on 5.226e-15
Cp1038 gnd onn 1.124e-14
Cp1039 gnd onp 1.633e-14
Cp1040 gnd op 4.912e-15
Cp1041 gnd rstb 5.687e-15
Cp1042 gnd rstb_n 2.471e-15
Cp1043 gnd t0 6.533e-15
Cp1044 gnd t0b 1.143e-14
Cp1045 gnd t1 2.082e-14
Cp1046 gnd t1b 1.352e-14
Cp1047 gnd top_n 1.703e-14
Cp1048 gnd top_p 2.116e-14
Cp1049 gnd trk0 2.158e-15
Cp1050 gnd trk1 1.137e-15
Cp1051 gnd vbn 1.368e-15
Cp1052 gnd vbp 8.44e-15
Cp1053 gnd vdd 8.214e-14
Cp1054 gnd vref 2.135e-14
Cp1055 gnd vrefl 2.299e-14
Cp1056 gnd xc4_din 4.976e-14
Cp1057 gnd xc4_dip 5.103e-14
Cp1058 gnd xc4_lt 1.902e-15
Cp1059 gnd xc4_outnb 2.329e-15
Cp1060 gnd xc4_outpb 4.034e-15
Cp1061 gnd xc4_xs1_tail 7.661e-15
Cp1062 gnd xc4_xs1_tail0 2.029e-15
Cp1063 gnd xc5_din 2.38e-14
Cp1064 gnd xc5_dip 2.562e-14
Cp1065 gnd xc5_lt 7.516e-15
Cp1066 gnd xc5_outnb 2.144e-15
Cp1067 gnd xc5_outpb 1.861e-15
Cp1068 gnd xc5_xs1_tail 4.094e-15
Cp1069 gnd xc5_xs1_tail0 2.375e-15
Cp1070 gnd xs0n_cbn 4.051e-15
Cp1071 gnd xs0n_cbp 1.817e-15
Cp1072 gnd xs0n_g 4.78e-15
Cp1073 gnd xs0n_n10 1.165e-15
Cp1074 gnd xs0n_x 1.671e-15
Cp1075 gnd xs0p_cbn 6.326e-15
Cp1076 gnd xs0p_cbp 2.138e-15
Cp1077 gnd xs0p_g 4.536e-15
Cp1078 gnd xs0p_n10 1.353e-15
Cp1079 gnd xs0p_x 2.477e-15
Cp1080 gnd xs1n_cbn 5.643e-15
Cp1081 gnd xs1n_cbp 2.373e-15
Cp1082 gnd xs1n_g 5.426e-15
Cp1083 gnd xs1n_n10 1.523e-15
Cp1084 gnd xs1n_x 1.754e-15
Cp1085 gnd xs1p_cbn 5.312e-15
Cp1086 gnd xs1p_cbp 1.729e-15
Cp1087 gnd xs1p_g 3.834e-15
Cp1088 gnd xs1p_n10 1.184e-15
Cp1089 gnd xs1p_x 1.852e-15
Cp1090 in0n in0p 1.859e-16
Cp1091 in0n lsb_n 1.024e-19
Cp1092 in0n lsb_p 1.344e-19
Cp1093 in0n t0 1.918e-18
Cp1094 in0n t0b 1.39e-15
Cp1095 in0n top_n 9.124e-16
Cp1096 in0n top_p 1.605e-18
Cp1097 in0n vdd 1.109e-15
Cp1098 in0n xs0n_cbn 1.972e-15
Cp1099 in0n xs0n_cbp 3.402e-18
Cp1100 in0n xs0n_g 2.009e-16
Cp1101 in0n xs0n_n10 8.707e-17
Cp1102 in0n xs0n_x 4.197e-17
Cp1103 in0p t0 1.012e-16
Cp1104 in0p t0b 1.021e-15
Cp1105 in0p top_n 9.216e-17
Cp1106 in0p top_p 1.019e-15
Cp1107 in0p vdd 3.463e-16
Cp1108 in0p xs0n_cbn 1.409e-15
Cp1109 in0p xs0n_cbp 1.657e-16
Cp1110 in0p xs0n_g 5.902e-16
Cp1111 in0p xs0n_n10 4.326e-17
Cp1112 in0p xs0n_x 1.456e-15
Cp1113 in0p xs0p_cbn 2.744e-16
Cp1114 in0p xs0p_g 2.342e-16
Cp1115 in1n in1p 2.149e-16
Cp1116 in1n t1 5.303e-16
Cp1117 in1n t1b 2.368e-15
Cp1118 in1n top_n 1.207e-15
Cp1119 in1n top_p 1.079e-18
Cp1120 in1n vdd 1.475e-15
Cp1121 in1n xs1n_cbn 1.003e-15
Cp1122 in1n xs1n_cbp 8.311e-18
Cp1123 in1n xs1n_g 1.488e-15
Cp1124 in1n xs1n_n10 2.129e-18
Cp1125 in1n xs1n_x 1.343e-16
Cp1126 in1n xs1p_cbn 4.766e-18
Cp1127 in1n xs1p_g 3.31e-18
Cp1128 in1p t1 1.234e-15
Cp1129 in1p t1b 3.149e-16
Cp1130 in1p top_n 2.154e-15
Cp1131 in1p top_p 7.945e-16
Cp1132 in1p vdd 1.26e-15
Cp1133 in1p xs1n_cbn 2.813e-16
Cp1134 in1p xs1n_cbp 3.05e-17
Cp1135 in1p xs1n_g 5.762e-17
Cp1136 in1p xs1n_n10 8.925e-18
Cp1137 in1p xs1n_x 1.462e-15
Cp1138 in1p xs1p_cbn 3.085e-16
Cp1139 in1p xs1p_g 4.599e-16
Cp1140 in1p xs1p_x 1.47e-18
Cp1141 lsb_n lsb_p 2.962e-15
Cp1142 lsb_n on 2.076e-19
Cp1143 lsb_n rstb 4.042e-16
Cp1144 lsb_n t0 1.606e-16
Cp1145 lsb_n top_n 5.501e-16
Cp1146 lsb_n top_p 2.556e-17
Cp1147 lsb_n vdd 9.262e-16
Cp1148 lsb_n vref 1.216e-17
Cp1149 lsb_n vrefl 2.75e-16
Cp1150 lsb_n xc4_din 3.618e-15
Cp1151 lsb_n xc4_dip 7.512e-16
Cp1152 lsb_n xc4_lt 1.875e-18
Cp1153 lsb_n xs0n_cbn 6.394e-17
Cp1154 lsb_n xs0n_cbp 3.117e-18
Cp1155 lsb_n xs0n_g 2.345e-19
Cp1156 lsb_n xs0n_x 2.147e-17
Cp1157 lsb_n xs1p_g 1.34e-19
Cp1158 lsb_p on 1.589e-17
Cp1159 lsb_p onn 1.371e-18
Cp1160 lsb_p onp 5.362e-17
Cp1161 lsb_p op 2.335e-17
Cp1162 lsb_p rstb 4.692e-15
Cp1163 lsb_p t0 2.264e-15
Cp1164 lsb_p t0b 1.693e-18
Cp1165 lsb_p top_n 6.452e-17
Cp1166 lsb_p top_p 5.789e-16
Cp1167 lsb_p vdd 3.627e-15
Cp1168 lsb_p vref 2.837e-15
Cp1169 lsb_p vrefl 1.845e-15
Cp1170 lsb_p xc4_din 1.032e-15
Cp1171 lsb_p xc4_dip 1.4e-16
Cp1172 lsb_p xc4_lt 1.033e-16
Cp1173 lsb_p xc4_outnb 1.633e-15
Cp1174 lsb_p xc4_outpb 3.417e-18
Cp1175 lsb_p xc5_outnb 4.03e-16
Cp1176 lsb_p xc5_outpb 2.86e-17
Cp1177 lsb_p xs0n_cbn 1.276e-16
Cp1178 lsb_p xs0n_cbp 3.66e-18
Cp1179 lsb_p xs0n_g 4.502e-19
Cp1180 lsb_p xs0n_n10 4.893e-19
Cp1181 lsb_p xs0n_x 1.104e-16
Cp1182 lsb_p xs0p_cbn 8.584e-18
Cp1183 lsb_p xs0p_g 4.202e-18
Cp1184 lsb_p xs0p_x 1.802e-17
Cp1185 nr rstb 1.182e-17
Cp1186 nr rstb_n 6.318e-16
Cp1187 nr t0b 2.323e-16
Cp1188 nr t1 5.569e-17
Cp1189 nr t1b 2.391e-16
Cp1190 nr trk1 1.142e-19
Cp1191 nr vdd 2.449e-17
Cp1192 on onn 8.114e-18
Cp1193 on onp 3.508e-16
Cp1194 on op 5.074e-15
Cp1195 on rstb 5.446e-16
Cp1196 on t1 4.475e-18
Cp1197 on t1b 8.692e-19
Cp1198 on vdd 2.847e-15
Cp1199 on vrefl 2.149e-17
Cp1200 on xc4_din 1.031e-15
Cp1201 on xc4_dip 7.102e-16
Cp1202 on xc4_lt 3.482e-16
Cp1203 on xc4_outnb 5.739e-17
Cp1204 on xc4_outpb 4.03e-15
Cp1205 on xc4_xs1_tail 1.736e-18
Cp1206 on xc4_xs1_tail0 1.21e-18
Cp1207 on xc5_lt 3.356e-18
Cp1208 on xc5_outnb 1.279e-16
Cp1209 on xc5_outpb 1.062e-16
Cp1210 onn onp 1.068e-15
Cp1211 onn op 2.319e-18
Cp1212 onn rstb 7.305e-17
Cp1213 onn rstb_n 1.619e-18
Cp1214 onn t0 5.881e-16
Cp1215 onn t0b 1.635e-15
Cp1216 onn t1 7.138e-17
Cp1217 onn t1b 1.449e-14
Cp1218 onn trk0 2.377e-18
Cp1219 onn vbp 4.673e-17
Cp1220 onn vdd 5.019e-15
Cp1221 onn vref 4.419e-16
Cp1222 onn vrefl 3.014e-16
Cp1223 onn xc4_din 1.008e-18
Cp1224 onn xc4_dip 2.497e-18
Cp1225 onn xc4_outpb 9.539e-19
Cp1226 onn xc4_xs1_tail 5.342e-17
Cp1227 onn xc4_xs1_tail0 6.395e-18
Cp1228 onn xc5_din 1.26e-16
Cp1229 onn xc5_dip 6.498e-18
Cp1230 onn xc5_lt 1.532e-14
Cp1231 onn xc5_outnb 6.513e-17
Cp1232 onn xc5_outpb 5.364e-17
Cp1233 onn xc5_xs1_tail 7.318e-18
Cp1234 onn xc5_xs1_tail0 2.363e-18
Cp1235 onp op 4.163e-15
Cp1236 onp rstb 7.939e-17
Cp1237 onp t0 2.253e-16
Cp1238 onp t0b 1.348e-16
Cp1239 onp t1 1.682e-16
Cp1240 onp t1b 1.781e-17
Cp1241 onp vdd 1.245e-15
Cp1242 onp vref 5.464e-16
Cp1243 onp vrefl 4.44e-16
Cp1244 onp xc4_din 5.701e-17
Cp1245 onp xc4_dip 1.258e-16
Cp1246 onp xc4_lt 1.839e-17
Cp1247 onp xc4_outnb 8.825e-16
Cp1248 onp xc4_outpb 1.961e-16
Cp1249 onp xc4_xs1_tail 1.142e-17
Cp1250 onp xc4_xs1_tail0 6.943e-19
Cp1251 onp xc5_din 9.826e-18
Cp1252 onp xc5_dip 1.02e-16
Cp1253 onp xc5_lt 1.475e-15
Cp1254 onp xc5_outnb 1.977e-16
Cp1255 onp xc5_outpb 3.336e-15
Cp1256 onp xc5_xs1_tail 9.628e-18
Cp1257 onp xc5_xs1_tail0 1.138e-18
Cp1258 op rstb 1.774e-16
Cp1259 op t1 6.093e-18
Cp1260 op t1b 1.433e-18
Cp1261 op vdd 3.198e-15
Cp1262 op xc4_din 5.372e-17
Cp1263 op xc4_dip 1.051e-15
Cp1264 op xc4_lt 6.731e-16
Cp1265 op xc4_outnb 2.587e-18
Cp1266 op xc4_outpb 3.007e-16
Cp1267 op xc4_xs1_tail 7.617e-18
Cp1268 op xc4_xs1_tail0 8.644e-19
Cp1269 op xc5_lt 2.709e-18
Cp1270 op xc5_outnb 1.552e-16
Cp1271 op xc5_outpb 1.275e-16
Cp1272 rstb rstb_n 2.029e-16
Cp1273 rstb t1 7.422e-17
Cp1274 rstb t1b 9.633e-17
Cp1275 rstb vdd 8.733e-16
Cp1276 rstb vref 9.084e-16
Cp1277 rstb vrefl 7.377e-15
Cp1278 rstb xc4_din 8.533e-17
Cp1279 rstb xc4_dip 1.39e-16
Cp1280 rstb xc4_lt 8.046e-18
Cp1281 rstb xc4_outnb 6.262e-18
Cp1282 rstb xc4_outpb 4.126e-17
Cp1283 rstb xc5_lt 6.637e-17
Cp1284 rstb xc5_outnb 5.335e-17
Cp1285 rstb xc5_outpb 4.364e-17
Cp1286 rstb_n t0b 1.639e-16
Cp1287 rstb_n t1 6.266e-17
Cp1288 rstb_n t1b 5.498e-16
Cp1289 rstb_n vdd 1.03e-15
Cp1290 t0 t0b 5.261e-16
Cp1291 t0 t1 8.863e-18
Cp1292 t0 t1b 8.669e-18
Cp1293 t0 top_n 8.324e-16
Cp1294 t0 top_p 4.745e-16
Cp1295 t0 trk0 2.258e-19
Cp1296 t0 trk1 1.315e-16
Cp1297 t0 vdd 8.3e-15
Cp1298 t0 xc4_lt 2.343e-18
Cp1299 t0 xc5_outpb 1.123e-16
Cp1300 t0 xs0n_cbn 1.145e-15
Cp1301 t0 xs0n_cbp 4.879e-18
Cp1302 t0 xs0n_g 2.101e-16
Cp1303 t0 xs0n_n10 7.613e-19
Cp1304 t0 xs0n_x 2.131e-16
Cp1305 t0 xs0p_cbn 3e-16
Cp1306 t0 xs0p_cbp 4.624e-18
Cp1307 t0 xs0p_g 8.374e-17
Cp1308 t0 xs0p_x 1.153e-16
Cp1309 t0b t1 5.507e-16
Cp1310 t0b t1b 7.66e-16
Cp1311 t0b top_n 1.091e-16
Cp1312 t0b top_p 1.28e-16
Cp1313 t0b trk0 2.445e-16
Cp1314 t0b trk1 8.183e-17
Cp1315 t0b vdd 2.109e-15
Cp1316 t0b xs0n_cbn 9.509e-16
Cp1317 t0b xs0n_cbp 5.402e-16
Cp1318 t0b xs0n_g 2.139e-16
Cp1319 t0b xs0n_n10 1.374e-16
Cp1320 t0b xs0n_x 8.698e-17
Cp1321 t0b xs0p_cbn 4.628e-16
Cp1322 t0b xs0p_cbp 2.112e-18
Cp1323 t0b xs0p_g 8.877e-17
Cp1324 t0b xs0p_n10 3.396e-17
Cp1325 t0b xs0p_x 1.257e-16
Cp1326 t1 t1b 2.052e-15
Cp1327 t1 top_n 2.173e-16
Cp1328 t1 top_p 6.185e-17
Cp1329 t1 trk1 2.742e-19
Cp1330 t1 vbp 6.179e-17
Cp1331 t1 vdd 1.564e-14
Cp1332 t1 vref 1.773e-15
Cp1333 t1 vrefl 4.14e-16
Cp1334 t1 xc4_din 6.791e-17
Cp1335 t1 xc4_dip 6.773e-17
Cp1336 t1 xc4_outnb 2.264e-19
Cp1337 t1 xc4_xs1_tail 5.76e-17
Cp1338 t1 xc4_xs1_tail0 4.956e-18
Cp1339 t1 xc5_dip 5.523e-18
Cp1340 t1 xc5_lt 1.858e-15
Cp1341 t1 xc5_outnb 2.264e-19
Cp1342 t1 xc5_outpb 1.372e-19
Cp1343 t1 xs1n_cbn 1.124e-15
Cp1344 t1 xs1n_cbp 4.779e-18
Cp1345 t1 xs1n_g 1.59e-15
Cp1346 t1 xs1n_n10 1.012e-18
Cp1347 t1 xs1n_x 2.076e-16
Cp1348 t1 xs1p_cbn 2.892e-16
Cp1349 t1 xs1p_cbp 4.816e-18
Cp1350 t1 xs1p_g 1.047e-16
Cp1351 t1 xs1p_n10 1.062e-19
Cp1352 t1 xs1p_x 1.101e-16
Cp1353 t1b top_n 3.211e-16
Cp1354 t1b top_p 1.317e-15
Cp1355 t1b trk1 1.496e-16
Cp1356 t1b vbn 1.178e-19
Cp1357 t1b vbp 5.329e-17
Cp1358 t1b vdd 3.855e-15
Cp1359 t1b vref 5.577e-16
Cp1360 t1b vrefl 3.714e-16
Cp1361 t1b xc4_din 2.429e-16
Cp1362 t1b xc4_dip 6.727e-17
Cp1363 t1b xc4_xs1_tail 5.94e-15
Cp1364 t1b xc4_xs1_tail0 9.605e-19
Cp1365 t1b xc5_din 6.363e-17
Cp1366 t1b xc5_dip 4.237e-15
Cp1367 t1b xc5_lt 8.039e-16
Cp1368 t1b xc5_xs1_tail 1.214e-18
Cp1369 t1b xc5_xs1_tail0 3.185e-18
Cp1370 t1b xs1n_cbn 1.406e-15
Cp1371 t1b xs1n_cbp 1.242e-17
Cp1372 t1b xs1n_g 6.746e-17
Cp1373 t1b xs1n_n10 3.726e-17
Cp1374 t1b xs1n_x 1.445e-15
Cp1375 t1b xs1p_cbn 6.678e-16
Cp1376 t1b xs1p_cbp 4.44e-17
Cp1377 t1b xs1p_g 7.513e-16
Cp1378 t1b xs1p_n10 4.782e-17
Cp1379 t1b xs1p_x 4.703e-16
Cp1380 top_n top_p 5.622e-15
Cp1381 top_n vdd 2.191e-15
Cp1382 top_n xc4_din 1.14e-15
Cp1383 top_n xc4_dip 5.962e-17
Cp1384 top_n xc4_xs1_tail 1.248e-15
Cp1385 top_n xc5_din 1.529e-15
Cp1386 top_n xc5_dip 8.425e-17
Cp1387 top_n xc5_lt 6.037e-17
Cp1388 top_n xc5_xs1_tail 9.994e-16
Cp1389 top_n xs0n_cbn 9.937e-16
Cp1390 top_n xs0n_cbp 8.507e-18
Cp1391 top_n xs0n_g 3.453e-16
Cp1392 top_n xs0n_n10 1.796e-18
Cp1393 top_n xs0n_x 1.404e-16
Cp1394 top_n xs0p_g 2.937e-18
Cp1395 top_n xs1n_cbn 1.085e-15
Cp1396 top_n xs1n_cbp 1.829e-16
Cp1397 top_n xs1n_g 2.624e-16
Cp1398 top_n xs1n_n10 4.801e-17
Cp1399 top_n xs1n_x 1.665e-16
Cp1400 top_n xs1p_cbn 3.88e-18
Cp1401 top_n xs1p_g 5.831e-17
Cp1402 top_p vdd 1.848e-15
Cp1403 top_p xc4_din 2.088e-16
Cp1404 top_p xc4_dip 1.14e-15
Cp1405 top_p xc4_xs1_tail 1.273e-15
Cp1406 top_p xc5_din 5.615e-16
Cp1407 top_p xc5_dip 6.38e-16
Cp1408 top_p xc5_lt 5.718e-17
Cp1409 top_p xc5_xs1_tail 1.158e-15
Cp1410 top_p xs0n_cbn 1.069e-16
Cp1411 top_p xs0n_cbp 1.124e-17
Cp1412 top_p xs0n_g 1.068e-15
Cp1413 top_p xs0n_n10 2.662e-18
Cp1414 top_p xs0n_x 2.05e-16
Cp1415 top_p xs0p_cbn 1.025e-16
Cp1416 top_p xs0p_g 7.132e-16
Cp1417 top_p xs0p_x 1.984e-18
Cp1418 top_p xs1n_cbn 3e-16
Cp1419 top_p xs1n_cbp 1.01e-17
Cp1420 top_p xs1n_g 2.612e-16
Cp1421 top_p xs1n_n10 4.825e-17
Cp1422 top_p xs1p_cbn 6.037e-18
Cp1423 top_p xs1p_g 9.266e-17
Cp1424 trk0 vdd 7.362e-17
Cp1425 trk1 vdd 3.129e-16
Cp1426 vbn vbp 6.554e-16
Cp1427 vbn vrefl 8.977e-18
Cp1428 vbn xc4_xs1_tail 4.133e-18
Cp1429 vbn xc5_din 1.317e-17
Cp1430 vbn xc5_dip 4.828e-17
Cp1431 vbn xc5_xs1_tail 1.148e-16
Cp1432 vbn xc5_xs1_tail0 3.221e-16
Cp1433 vbp vdd 6.588e-16
Cp1434 vbp vref 6.655e-16
Cp1435 vbp vrefl 4.531e-16
Cp1436 vbp xc4_dip 5.068e-17
Cp1437 vbp xc4_xs1_tail 1.637e-15
Cp1438 vbp xc4_xs1_tail0 1.03e-15
Cp1439 vbp xc5_din 5.145e-16
Cp1440 vbp xc5_dip 3.871e-16
Cp1441 vbp xc5_lt 5.674e-17
Cp1442 vbp xc5_outnb 1.781e-18
Cp1443 vbp xc5_xs1_tail0 2.468e-18
Cp1444 vdd vref 2.449e-15
Cp1445 vdd vrefl 2.334e-15
Cp1446 vdd xc4_din 1.49e-14
Cp1447 vdd xc4_dip 1.317e-14
Cp1448 vdd xc4_lt 2.462e-18
Cp1449 vdd xc4_outnb 3.729e-16
Cp1450 vdd xc4_outpb 3.097e-16
Cp1451 vdd xc4_xs1_tail 9.684e-16
Cp1452 vdd xc4_xs1_tail0 2.805e-15
Cp1453 vdd xc5_din 2.746e-15
Cp1454 vdd xc5_dip 2.263e-15
Cp1455 vdd xc5_lt 3.764e-15
Cp1456 vdd xc5_outnb 4.903e-16
Cp1457 vdd xc5_outpb 6.227e-16
Cp1458 vdd xc5_xs1_tail 2.875e-16
Cp1459 vdd xc5_xs1_tail0 2.925e-19
Cp1460 vdd xs0n_cbn 2.397e-15
Cp1461 vdd xs0n_cbp 5.276e-16
Cp1462 vdd xs0n_g 7.833e-16
Cp1463 vdd xs0n_n10 1.751e-16
Cp1464 vdd xs0n_x 9.861e-16
Cp1465 vdd xs0p_cbn 2.811e-15
Cp1466 vdd xs0p_cbp 7.317e-16
Cp1467 vdd xs0p_g 9.595e-16
Cp1468 vdd xs0p_n10 8.833e-17
Cp1469 vdd xs0p_x 9.978e-16
Cp1470 vdd xs1n_cbn 1.775e-15
Cp1471 vdd xs1n_cbp 5.751e-16
Cp1472 vdd xs1n_g 1.878e-15
Cp1473 vdd xs1n_n10 4.703e-17
Cp1474 vdd xs1n_x 1.03e-15
Cp1475 vdd xs1p_cbn 1.253e-15
Cp1476 vdd xs1p_cbp 4.04e-16
Cp1477 vdd xs1p_g 1.226e-15
Cp1478 vdd xs1p_n10 2.655e-16
Cp1479 vdd xs1p_x 4.537e-16
Cp1480 vref vrefl 1.266e-15
Cp1481 vref xc4_din 1.428e-16
Cp1482 vref xc4_dip 3.358e-15
Cp1483 vref xc4_xs1_tail 7.49e-16
Cp1484 vref xc5_din 5.725e-16
Cp1485 vref xc5_dip 1.619e-15
Cp1486 vref xc5_lt 6.021e-16
Cp1487 vrefl xc4_din 2.224e-16
Cp1488 vrefl xc4_dip 5.368e-15
Cp1489 vrefl xc4_outnb 3.251e-16
Cp1490 vrefl xc4_outpb 1.337e-18
Cp1491 vrefl xc4_xs1_tail 4.984e-16
Cp1492 vrefl xc5_din 4.371e-16
Cp1493 vrefl xc5_dip 2.097e-16
Cp1494 vrefl xc5_lt 4.056e-16
Cp1495 xc4_din xc4_dip 1.758e-14
Cp1496 xc4_din xc4_outnb 5.701e-17
Cp1497 xc4_din xc4_outpb 4.564e-17
Cp1498 xc4_din xc4_xs1_tail 7.635e-15
Cp1499 xc4_din xc5_din 5.158e-16
Cp1500 xc4_din xc5_dip 1.114e-16
Cp1501 xc4_din xc5_lt 9.893e-17
Cp1502 xc4_din xc5_xs1_tail 1.185e-17
Cp1503 xc4_dip xc4_outnb 6.3e-17
Cp1504 xc4_dip xc4_outpb 2.419e-16
Cp1505 xc4_dip xc4_xs1_tail 3.967e-15
Cp1506 xc4_dip xc4_xs1_tail0 3.176e-18
Cp1507 xc4_dip xc5_din 2.442e-15
Cp1508 xc4_dip xc5_dip 1.255e-16
Cp1509 xc4_dip xc5_lt 6.32e-17
Cp1510 xc4_dip xc5_xs1_tail 6.523e-16
Cp1511 xc4_lt xc4_outpb 3.852e-19
Cp1512 xc4_lt xc5_outnb 5.522e-17
Cp1513 xc4_lt xc5_outpb 2.073e-17
Cp1514 xc4_outnb xc4_outpb 1.27e-16
Cp1515 xc4_outnb xc5_outnb 1.209e-15
Cp1516 xc4_outnb xc5_outpb 2.485e-17
Cp1517 xc4_outpb xc4_xs1_tail 2.568e-18
Cp1518 xc4_outpb xc4_xs1_tail0 1.751e-18
Cp1519 xc4_outpb xc5_lt 6.419e-19
Cp1520 xc4_outpb xc5_outnb 1.386e-16
Cp1521 xc4_outpb xc5_outpb 1.343e-16
Cp1522 xc4_xs1_tail xc4_xs1_tail0 8.297e-16
Cp1523 xc4_xs1_tail xc5_din 8.598e-16
Cp1524 xc4_xs1_tail xc5_dip 8.847e-16
Cp1525 xc4_xs1_tail xc5_lt 6.132e-17
Cp1526 xc4_xs1_tail xc5_xs1_tail 3.014e-16
Cp1527 xc4_xs1_tail xc5_xs1_tail0 2.353e-17
Cp1528 xc4_xs1_tail0 xc5_lt 1.752e-18
Cp1529 xc4_xs1_tail0 xc5_outnb 2.086e-17
Cp1530 xc4_xs1_tail0 xc5_outpb 1.36e-19
Cp1531 xc5_din xc5_dip 6.147e-15
Cp1532 xc5_din xc5_lt 7.892e-17
Cp1533 xc5_din xc5_xs1_tail 1.235e-15
Cp1534 xc5_din xc5_xs1_tail0 8.337e-17
Cp1535 xc5_dip xc5_lt 4.681e-15
Cp1536 xc5_dip xc5_xs1_tail 1.189e-15
Cp1537 xc5_dip xc5_xs1_tail0 7.261e-17
Cp1538 xc5_lt xc5_outpb 9.421e-18
Cp1539 xc5_lt xc5_xs1_tail 5.865e-19
Cp1540 xc5_lt xc5_xs1_tail0 1.655e-18
Cp1541 xc5_outnb xc5_outpb 2.911e-15
Cp1542 xc5_xs1_tail xc5_xs1_tail0 2.314e-16
Cp1543 xs0n_cbn xs0n_cbp 3.563e-16
Cp1544 xs0n_cbn xs0n_g 6.205e-16
Cp1545 xs0n_cbn xs0n_n10 4.518e-16
Cp1546 xs0n_cbn xs0n_x 8.617e-16
Cp1547 xs0n_cbp xs0n_g 7.229e-16
Cp1548 xs0n_cbp xs0n_n10 3.831e-17
Cp1549 xs0n_cbp xs0n_x 1.037e-16
Cp1550 xs0n_cbp xs0p_g 2.295e-17
Cp1551 xs0n_g xs0n_n10 4.961e-16
Cp1552 xs0n_g xs0n_x 1.329e-15
Cp1553 xs0n_g xs0p_g 7.106e-18
Cp1554 xs0n_n10 xs0n_x 2.348e-17
Cp1555 xs0n_x xs0p_g 1.341e-17
Cp1556 xs0p_cbn xs0p_cbp 9.998e-16
Cp1557 xs0p_cbn xs0p_g 1.547e-15
Cp1558 xs0p_cbn xs0p_n10 6.098e-16
Cp1559 xs0p_cbn xs0p_x 1.097e-15
Cp1560 xs0p_cbp xs0p_g 6.461e-16
Cp1561 xs0p_cbp xs0p_n10 7.24e-17
Cp1562 xs0p_cbp xs0p_x 6.7e-16
Cp1563 xs0p_g xs0p_n10 5.16e-16
Cp1564 xs0p_g xs0p_x 1.545e-15
Cp1565 xs0p_n10 xs0p_x 2.417e-17
Cp1566 xs1n_cbn xs1n_cbp 3.679e-16
Cp1567 xs1n_cbn xs1n_g 1.218e-15
Cp1568 xs1n_cbn xs1n_n10 1.386e-16
Cp1569 xs1n_cbn xs1n_x 1.007e-15
Cp1570 xs1n_cbp xs1n_g 7.571e-16
Cp1571 xs1n_cbp xs1n_n10 1.43e-16
Cp1572 xs1n_cbp xs1n_x 9.054e-17
Cp1573 xs1n_cbp xs1p_g 1.064e-17
Cp1574 xs1n_g xs1n_n10 5.827e-16
Cp1575 xs1n_g xs1n_x 2.003e-16
Cp1576 xs1n_g xs1p_g 2.935e-17
Cp1577 xs1n_n10 xs1n_x 2.723e-17
Cp1578 xs1n_x xs1p_g 1.662e-17
Cp1579 xs1p_cbn xs1p_cbp 1.18e-15
Cp1580 xs1p_cbn xs1p_g 1.964e-15
Cp1581 xs1p_cbn xs1p_n10 6.628e-16
Cp1582 xs1p_cbn xs1p_x 1.271e-15
Cp1583 xs1p_cbp xs1p_g 5.906e-16
Cp1584 xs1p_cbp xs1p_n10 8.011e-17
Cp1585 xs1p_cbp xs1p_x 7.189e-16
Cp1586 xs1p_g xs1p_n10 5.182e-16
Cp1587 xs1p_g xs1p_x 1.825e-15
Cp1588 xs1p_n10 xs1p_x 1.858e-17
.ends
.subckt r1_adc_lay adc_hold is_smp clk adc_start adc_sel adc_valid_a adc_raw_a_0 adc_raw_a_1 adc_raw_a_2 adc_raw_a_3 adc_raw_a_4 adc_raw_a_5 adc_raw_a_6 adc_raw_a_7 adc_raw_a_8 adc_raw_a_9 adc_raw_a_10 adc_raw_a_11 adc_raw_a_12 adc_raw_a_13 adc_valid_b adc_raw_b_0 adc_raw_b_1 adc_raw_b_2 adc_raw_b_3 adc_raw_b_4 adc_raw_b_5 adc_raw_b_6 adc_raw_b_7 adc_raw_b_8 adc_raw_b_9 adc_raw_b_10 adc_raw_b_11 adc_raw_b_12 adc_raw_b_13 por_n ain_sin_p ain_sin_n ain_cos_p ain_cos_n vcm2 ibias ain_isa_p ain_isa_n ain_isb_p ain_isb_n vcm vdda vdd vss vref_in topap topan topbp topbn sar_clka sar_clkab sar_clkb sar_clkbb sar_clkna sar_clknab sar_clknb sar_clknbb sar_cna0 sar_cna1 sar_cna10 sar_cna11 sar_cna12 sar_cna2 sar_cna3 sar_cna4 sar_cna5 sar_cna6 sar_cna7 sar_cna8 sar_cna9 sar_cnb0 sar_cnb1 sar_cnb10 sar_cnb11 sar_cnb12 sar_cnb2 sar_cnb3 sar_cnb4 sar_cnb5 sar_cnb6 sar_cnb7 sar_cnb8 sar_cnb9 sar_cpa0 sar_cpa1 sar_cpa10 sar_cpa11 sar_cpa12 sar_cpa2 sar_cpa3 sar_cpa4 sar_cpa5 sar_cpa6 sar_cpa7 sar_cpa8 sar_cpa9 sar_cpb0 sar_cpb1 sar_cpb10 sar_cpb11 sar_cpb12 sar_cpb2 sar_cpb3 sar_cpb4 sar_cpb5 sar_cpb6 sar_cpb7 sar_cpb8 sar_cpb9 sar_oan sar_oann sar_oanp sar_oap sar_obn sar_obnn sar_obnp sar_obp sar_trka0 sar_trka1 sar_trkb0 sar_trkb1 sar_mclk
Xxckg_xpd0 xckg_d0__p1 clk vdd__p2 vdd sg13_lv_pmos w=1u l=0.5u ng=1 m=1
Xxckg_xnd0 xckg_d0 clk vss__p9 vss sg13_lv_nmos w=0.5u l=0.5u ng=1 m=1
Xxckg_cd0 xckg_d0__p2 vss__p16 cap_cmim w=2.53u l=2.53u m=1
Xxckg_xpd1 xckg_d1__p1 xckg_d0 vdd__p3 vdd sg13_lv_pmos w=1u l=0.5u ng=1 m=1
Xxckg_xnd1 xckg_d1 xckg_d0 vss__p10 vss sg13_lv_nmos w=0.5u l=0.5u ng=1 m=1
Xxckg_cd1 xckg_d1__p2 vss__p17 cap_cmim w=2.53u l=2.53u m=1
Xxckg_xpd2 xckg_d2__p1 xckg_d1 vdd__p4 vdd sg13_lv_pmos w=1u l=0.5u ng=1 m=1
Xxckg_xnd2 xckg_d2 xckg_d1 vss__p11 vss sg13_lv_nmos w=0.5u l=0.5u ng=1 m=1
Xxckg_cd2 xckg_d2__p2 vss__p18 cap_cmim w=2.53u l=2.53u m=1
Xxckg_xpd3 xckg_d3__p1 xckg_d2 vdd__p5 vdd sg13_lv_pmos w=1u l=0.5u ng=1 m=1
Xxckg_xnd3 xckg_d3 xckg_d2 vss__p12 vss sg13_lv_nmos w=0.5u l=0.5u ng=1 m=1
Xxckg_cd3 xckg_d3__p2 vss__p19 cap_cmim w=2.53u l=2.53u m=1
Xxckg_xpd4 xckg_x__p2 xckg_d3 vdd__p6 vdd sg13_lv_pmos w=1u l=0.5u ng=1 m=1
Xxckg_xnd4 xckg_x xckg_d3 vss__p13 vss sg13_lv_nmos w=0.5u l=0.5u ng=1 m=1
Xxckg_cd4 xckg_x__p4 vss__p20 cap_cmim w=2.53u l=2.53u m=1
Xxckg_xpa sar_mclk__p2 clk__p1 vdd__p7 vdd sg13_lv_pmos w=2u l=0.13u ng=1 m=1
Xxckg_xpb sar_mclk__p3 xckg_x__p3 vdd__p8 vdd sg13_lv_pmos w=2u l=0.13u ng=1 m=1
Xxckg_xna sar_mclk clk__p0 xckg_nn vss sg13_lv_nmos w=2u l=0.13u ng=1 m=1
Xxckg_xnb xckg_nn__p1 xckg_x__p1 vss__p14 vss sg13_lv_nmos w=2u l=0.13u ng=1 m=1
Xxckg_xpi mclkb__p1 sar_mclk__p4 vdd__p9 vdd sg13_lv_pmos w=2u l=0.13u ng=1 m=1
Xxckg_xni mclkb sar_mclk__p1 vss__p15 vss sg13_lv_nmos w=1u l=0.13u ng=1 m=1
Xxcbias_xmbd vbp__p1 vbp vdd__p1 vdd sg13_lv_pmos w=0.8u l=0.5u ng=1 m=1
Xxcbias_xrb_g0 vbp xcbias_xrb_s1 vss rppd w=1u l=40u m=1 b=0
Xxcbias_xrb_g1 xcbias_xrb_s1 xcbias_xrb_s2 vss rppd w=1u l=40u m=1 b=0
Xxcbias_xrb_g2 xcbias_xrb_s2 xcbias_xrb_s3 vss rppd w=1u l=40u m=1 b=0
Xxcbias_xrb_g3 xcbias_xrb_s3 vss__p7 vss rppd w=1u l=40u m=1 b=0
Xxcbiasn_xmbd vbn__p1 vbn vss__p8 vss sg13_lv_nmos w=0.2u l=0.5u ng=1 m=1
Xxcbiasn_xrb_g0 vdd__p0 xcbiasn_xrb_s1 vss rppd w=1u l=40u m=1 b=0
Xxcbiasn_xrb_g1 xcbiasn_xrb_s1 xcbiasn_xrb_s2 vss rppd w=1u l=40u m=1 b=0
Xxcbiasn_xrb_g2 xcbiasn_xrb_s2 xcbiasn_xrb_s3 vss rppd w=1u l=40u m=1 b=0
Xxcbiasn_xrb_g3 xcbiasn_xrb_s3 vbn vss rppd w=1u l=40u m=1 b=0
Xxref_xmb0 ibias__p0 ibias vss__p5 vss sg13_hv_nmos w=2u l=1u ng=1 m=1
Xxref_xmt xref_ntl ibias vss__p6 vss sg13_hv_nmos w=2u l=8u ng=1 m=1
Xxref_xm1 xref_na vref_in xref_ntl__p1 vss sg13_hv_nmos w=10u l=1u ng=2 m=1
Xxref_xm2 xref_ng vref xref_ntl__p2 vss sg13_hv_nmos w=10u l=1u ng=2 m=1
Xxref_xm3 xref_na__p1 xref_na vdda__p5 vdda sg13_hv_pmos w=4u l=1u ng=1 m=1
Xxref_xm4 xref_ng__p1 xref_na vdda__p6 vdda sg13_hv_pmos w=4u l=1u ng=1 m=1
Xxref_xcg_u0 vss xref_ng__p2 cap_cmim w=26.32u l=95u m=1
Xxref_xmsf_s0 vdda__p1 xref_ng vref vss sg13_hv_nmos w=80u l=0.45u ng=32 m=1
Xxref_xmsf_s1 vdda__p2 xref_ng vref__p5 vss sg13_hv_nmos w=80u l=0.45u ng=32 m=1
Xxref_xmsf_s2 vdda__p3 xref_ng vref__p6 vss sg13_hv_nmos w=80u l=0.45u ng=32 m=1
Xxref_xmsf_s3 vdda__p4 xref_ng vref__p7 vss sg13_hv_nmos w=80u l=0.45u ng=32 m=1
Xxref_xmib_s0 vref__p0 ibias vss__p0 vss sg13_hv_nmos w=80u l=1u ng=40 m=1
Xxref_xmib_s1 vref__p1 ibias vss__p1 vss sg13_hv_nmos w=80u l=1u ng=40 m=1
Xxref_xmib_s2 vref__p2 ibias vss__p2 vss sg13_hv_nmos w=80u l=1u ng=40 m=1
Xxref_xmib_s3 vref__p3 ibias vss__p3 vss sg13_hv_nmos w=80u l=1u ng=40 m=1
Xxref_xcd_u0 vss vref__p8 cap_cmim w=51.58u l=95u m=1
Xxref_xcd_u1 vss vref__p9 cap_cmim w=51.58u l=95u m=1
Xxref_xcd_u2 vss vref__p10 cap_cmim w=51.58u l=95u m=1
Xxref_xcd_u3 vss vref__p11 cap_cmim w=51.58u l=95u m=1
Xxref_xmsfl_s0 vdda__p0 xref_ng vrefl vss sg13_hv_nmos w=80u l=0.45u ng=32 m=1
Xxref_xmibl_s0 vrefl__p0 ibias vss__p4 vss sg13_hv_nmos w=80u l=1u ng=40 m=1
Xxref_xcdl_u0 vss vrefl__p2 cap_cmim w=51.58u l=95u m=1
Xxref_xcdl_u1 vss vrefl__p3 cap_cmim w=51.58u l=95u m=1
Xxfilt_xcf_u0 vss vref_in__p1 cap_cmim w=37.36u l=90u m=1
Xxfilt_xcf_u1 vss vref_in__p2 cap_cmim w=37.36u l=90u m=1
Xslice_a ain_sin_p__p1 ain_sin_n__p1 ain_isa_p__p1 ain_isa_n__p1 sar_trka0 sar_trka1 sar_cpa0 sar_cpa1 sar_cpa2 sar_cpa3 sar_cpa4 sar_cpa5 sar_cpa6 sar_cpa7 sar_cpa8 sar_cpa9 sar_cpa10 sar_cpa11 sar_cpa12 sar_cna0 sar_cna1 sar_cna2 sar_cna3 sar_cna4 sar_cna5 sar_cna6 sar_cna7 sar_cna8 sar_cna9 sar_cna10 sar_cna11 sar_cna12 sar_clka sar_clkab sar_clkna sar_clknab sar_oap sar_oan sar_oanp sar_oann vbp__p2 vbn__p2 vref__p12 vref__p13 vref__p14 vrefl__p4 vrefl__p5 topap topan vdd__p11 vdd__p12 vdd__p13 vdd__p14 xslice_a_gnd_nc0 vss__p22 xslice_a_gnd_nc2 vss__p23 xslice_a_gnd_nc4 vss__p24 xslice_a_gnd_nc6 vss__p25 r1_adc_slice_post
Xslice_b ain_cos_p__p1 ain_cos_n__p1 ain_isb_p__p1 ain_isb_n__p1 sar_trkb0 sar_trkb1 sar_cpb0 sar_cpb1 sar_cpb2 sar_cpb3 sar_cpb4 sar_cpb5 sar_cpb6 sar_cpb7 sar_cpb8 sar_cpb9 sar_cpb10 sar_cpb11 sar_cpb12 sar_cnb0 sar_cnb1 sar_cnb2 sar_cnb3 sar_cnb4 sar_cnb5 sar_cnb6 sar_cnb7 sar_cnb8 sar_cnb9 sar_cnb10 sar_cnb11 sar_cnb12 sar_clkb sar_clkbb sar_clknb sar_clknbb sar_obp sar_obn sar_obnp sar_obnn vbp__p3 vbn__p3 vref__p15 vref__p16 vref__p17 vrefl__p6 vrefl__p7 topbp topbn vdd__p15 vdd__p16 vdd__p17 vdd__p18 vss__p26 xslice_b_gnd_nc1 vss__p27 xslice_b_gnd_nc3 vss__p28 xslice_b_gnd_nc5 vss__p29 xslice_b_gnd_nc7 r1_adc_slice_post
Rt0 ain_cos_n ain_cos_n__p1 126.828
Rt1 ain_cos_p ain_cos_p__p1 128.647
Rt2 ain_isa_n ain_isa_n__p1 127.972
Rt3 ain_isa_p ain_isa_p__p1 129.791
Rt4 ain_isb_n ain_isb_n__p1 0.198
Rt5 ain_isb_p ain_isb_p__p1 0.198
Rt6 ain_sin_n ain_sin_n__p1 0.308
Rt7 ain_sin_p ain_sin_p__p1 0.308
Rt8 clk clk__p0 45.3911
Rt9 clk clk__p1 62.5679
Rt10 clk__p0 clk__p1 72.0627
Rt11 ibias ibias__p0 200.561
Rt12 mclkb mclkb__p1 43.3194
Rt13 sar_mclk sar_mclk__p1 56.5336
Rt14 sar_mclk sar_mclk__p3 125.793
Rt15 sar_mclk sar_mclk__p4 124.991
Rt16 sar_mclk__p1 sar_mclk__p3 116.67
Rt17 sar_mclk__p1 sar_mclk__p4 115.926
Rt18 sar_mclk__p2 sar_mclk__p3 0.6204
Rt19 sar_mclk__p3 sar_mclk__p4 23.2017
Rt20 vbn vbn__p1 68.8436
Rt21 vbn vbn__p2 240.016
Rt22 vbn vbn__p3 784.574
Rt23 vbn__p1 vbn__p2 217.489
Rt24 vbn__p1 vbn__p3 710.938
Rt25 vbn__p2 vbn__p3 168.032
Rt26 vbp vbp__p1 73.6975
Rt27 vbp vbp__p2 245.763
Rt28 vbp vbp__p3 1260.46
Rt29 vbp__p1 vbp__p2 195.517
Rt30 vbp__p1 vbp__p3 1002.76
Rt31 vbp__p2 vbp__p3 154.24
Rt32 vdd vdd__p0 34389.1
Rt33 vdd vdd__p1 40943
Rt34 vdd vdd__p11 82.2115
Rt35 vdd vdd__p12 11.0679
Rt36 vdd vdd__p13 29.2468
Rt37 vdd vdd__p14 436.411
Rt38 vdd vdd__p15 3347.45
Rt39 vdd vdd__p16 41646.7
Rt40 vdd vdd__p17 763098
Rt41 vdd__p0 vdd__p1 119.607
Rt42 vdd__p0 vdd__p11 99.6158
Rt43 vdd__p0 vdd__p12 288.609
Rt44 vdd__p0 vdd__p13 7715.85
Rt45 vdd__p0 vdd__p14 115134
Rt46 vdd__p0 vdd__p15 883122
Rt47 vdd__p1 vdd__p11 118.601
Rt48 vdd__p1 vdd__p12 343.612
Rt49 vdd__p1 vdd__p13 9186.33
Rt50 vdd__p1 vdd__p14 137076
Rt51 vdd__p11 vdd__p12 0.697261
Rt52 vdd__p11 vdd__p13 18.4457
Rt53 vdd__p11 vdd__p14 275.241
Rt54 vdd__p11 vdd__p15 2111.21
Rt55 vdd__p11 vdd__p16 26266.2
Rt56 vdd__p11 vdd__p17 481280
Rt57 vdd__p12 vdd__p13 2.4833
Rt58 vdd__p12 vdd__p14 37.055
Rt59 vdd__p12 vdd__p15 284.227
Rt60 vdd__p12 vdd__p16 3536.16
Rt61 vdd__p12 vdd__p17 64793.5
Rt62 vdd__p12 vdd__p18 894245
Rt63 vdd__p13 vdd__p14 0.525684
Rt64 vdd__p13 vdd__p15 4.43203
Rt65 vdd__p13 vdd__p16 55.1402
Rt66 vdd__p13 vdd__p17 1010.34
Rt67 vdd__p13 vdd__p18 13944.2
Rt68 vdd__p13 vdd__p2 35117.4
Rt69 vdd__p13 vdd__p3 32180.6
Rt70 vdd__p13 vdd__p4 27393.5
Rt71 vdd__p13 vdd__p5 22092.9
Rt72 vdd__p13 vdd__p6 17196.9
Rt73 vdd__p13 vdd__p7 31672.4
Rt74 vdd__p13 vdd__p8 22266.6
Rt75 vdd__p13 vdd__p9 18440
Rt76 vdd__p14 vdd__p15 0.368199
Rt77 vdd__p14 vdd__p16 6.97557
Rt78 vdd__p14 vdd__p17 127.814
Rt79 vdd__p14 vdd__p18 1764.03
Rt80 vdd__p14 vdd__p2 1256.58
Rt81 vdd__p14 vdd__p3 1151.5
Rt82 vdd__p14 vdd__p4 980.203
Rt83 vdd__p14 vdd__p5 790.534
Rt84 vdd__p14 vdd__p6 615.346
Rt85 vdd__p14 vdd__p7 1133.31
Rt86 vdd__p14 vdd__p8 796.752
Rt87 vdd__p14 vdd__p9 659.828
Rt88 vdd__p15 vdd__p16 0.803024
Rt89 vdd__p15 vdd__p17 14.9193
Rt90 vdd__p15 vdd__p18 205.908
Rt91 vdd__p15 vdd__p2 3270.69
Rt92 vdd__p15 vdd__p3 2997.17
Rt93 vdd__p15 vdd__p4 2551.32
Rt94 vdd__p15 vdd__p5 2057.64
Rt95 vdd__p15 vdd__p6 1601.65
Rt96 vdd__p15 vdd__p7 2949.84
Rt97 vdd__p15 vdd__p8 2073.82
Rt98 vdd__p15 vdd__p9 1717.43
Rt99 vdd__p16 vdd__p17 2.61771
Rt100 vdd__p16 vdd__p18 36.1282
Rt101 vdd__p16 vdd__p2 77135.5
Rt102 vdd__p16 vdd__p3 70684.8
Rt103 vdd__p16 vdd__p4 60169.8
Rt104 vdd__p16 vdd__p5 48527
Rt105 vdd__p16 vdd__p6 37773.1
Rt106 vdd__p16 vdd__p7 69568.5
Rt107 vdd__p16 vdd__p8 48908.7
Rt108 vdd__p16 vdd__p9 40503.6
Rt109 vdd__p17 vdd__p18 0.487307
Rt110 vdd__p17 vdd__p5 889168
Rt111 vdd__p17 vdd__p6 692122
Rt112 vdd__p17 vdd__p8 896161
Rt113 vdd__p17 vdd__p9 742154
Rt114 vdd__p2 vdd__p3 89.2941
Rt115 vdd__p2 vdd__p4 116.664
Rt116 vdd__p2 vdd__p5 148.715
Rt117 vdd__p2 vdd__p6 182.18
Rt118 vdd__p2 vdd__p7 396.838
Rt119 vdd__p2 vdd__p8 438.92
Rt120 vdd__p2 vdd__p9 468.083
Rt121 vdd__p3 vdd__p4 106.908
Rt122 vdd__p3 vdd__p5 136.278
Rt123 vdd__p3 vdd__p6 166.945
Rt124 vdd__p3 vdd__p7 363.651
Rt125 vdd__p3 vdd__p8 402.214
Rt126 vdd__p3 vdd__p9 428.938
Rt127 vdd__p4 vdd__p5 116.005
Rt128 vdd__p4 vdd__p6 142.11
Rt129 vdd__p4 vdd__p7 309.555
Rt130 vdd__p4 vdd__p8 342.381
Rt131 vdd__p4 vdd__p9 365.13
Rt132 vdd__p5 vdd__p6 114.612
Rt133 vdd__p5 vdd__p7 249.657
Rt134 vdd__p5 vdd__p8 276.131
Rt135 vdd__p5 vdd__p9 294.478
Rt136 vdd__p6 vdd__p7 194.331
Rt137 vdd__p6 vdd__p8 214.938
Rt138 vdd__p6 vdd__p9 229.219
Rt139 vdd__p7 vdd__p8 395.862
Rt140 vdd__p7 vdd__p9 422.164
Rt141 vdd__p8 vdd__p9 296.794
Rt142 vdda vdda__p1 41.3489
Rt143 vdda vdda__p2 278.578
Rt144 vdda vdda__p3 56.012
Rt145 vdda vdda__p5 261.48
Rt146 vdda vdda__p6 203.591
Rt147 vdda__p0 vdda__p3 62.8025
Rt148 vdda__p0 vdda__p4 67.5999
Rt149 vdda__p1 vdda__p2 1202.37
Rt150 vdda__p1 vdda__p3 241.754
Rt151 vdda__p1 vdda__p5 1128.58
Rt152 vdda__p1 vdda__p6 878.722
Rt153 vdda__p2 vdda__p3 256.165
Rt154 vdda__p2 vdda__p5 63.6193
Rt155 vdda__p2 vdda__p6 79.0683
Rt156 vdda__p3 vdda__p4 23.0314
Rt157 vdda__p3 vdda__p5 240.442
Rt158 vdda__p3 vdda__p6 187.211
Rt159 vdda__p5 vdda__p6 74.2153
Rt160 vref vref__p0 114.65
Rt161 vref vref__p1 6.10169
Rt162 vref vref__p10 186.142
Rt163 vref vref__p11 8271.36
Rt164 vref vref__p12 1487.93
Rt165 vref vref__p13 808.459
Rt166 vref vref__p14 372.871
Rt167 vref vref__p15 1459.54
Rt168 vref vref__p16 3157.02
Rt169 vref vref__p17 5801
Rt170 vref vref__p2 370.329
Rt171 vref vref__p3 10248.9
Rt172 vref vref__p5 428.96
Rt173 vref vref__p6 1135.72
Rt174 vref vref__p7 3138.93
Rt175 vref vref__p8 2223.31
Rt176 vref vref__p9 50.9452
Rt177 vref__p0 vref__p1 5.08178
Rt178 vref__p0 vref__p10 1372.92
Rt179 vref__p0 vref__p11 61005.8
Rt180 vref__p0 vref__p12 11330.2
Rt181 vref__p0 vref__p13 6156.32
Rt182 vref__p0 vref__p14 2839.43
Rt183 vref__p0 vref__p15 10764.9
Rt184 vref__p0 vref__p16 23284.7
Rt185 vref__p0 vref__p17 42785.5
Rt186 vref__p0 vref__p2 2151.06
Rt187 vref__p0 vref__p3 74645.3
Rt188 vref__p0 vref__p5 1782.68
Rt189 vref__p0 vref__p6 6979.82
Rt190 vref__p0 vref__p7 23027.9
Rt191 vref__p0 vref__p8 16928.7
Rt192 vref__p0 vref__p9 387.793
Rt193 vref__p1 vref__p10 27.2286
Rt194 vref__p1 vref__p11 1209.68
Rt195 vref__p1 vref__p12 366.189
Rt196 vref__p1 vref__p13 199.066
Rt197 vref__p1 vref__p14 91.8501
Rt198 vref__p1 vref__p15 213.441
Rt199 vref__p1 vref__p16 461.684
Rt200 vref__p1 vref__p17 848.354
Rt201 vref__p1 vref__p2 8.38761
Rt202 vref__p1 vref__p3 1193.26
Rt203 vref__p1 vref__p5 6.38445
Rt204 vref__p1 vref__p6 32.923
Rt205 vref__p1 vref__p7 414.228
Rt206 vref__p1 vref__p8 546.455
Rt207 vref__p1 vref__p9 12.4499
Rt208 vref__p10 vref__p11 1.96723
Rt209 vref__p10 vref__p12 390.352
Rt210 vref__p10 vref__p13 212.377
Rt211 vref__p10 vref__p14 98.0606
Rt212 vref__p10 vref__p15 1.88326
Rt213 vref__p10 vref__p16 2.58285
Rt214 vref__p10 vref__p17 2.96452
Rt215 vref__p10 vref__p2 13.5031
Rt216 vref__p10 vref__p3 151.839
Rt217 vref__p10 vref__p5 105.826
Rt218 vref__p10 vref__p6 71.6163
Rt219 vref__p10 vref__p7 45.7002
Rt220 vref__p10 vref__p8 581.257
Rt221 vref__p10 vref__p9 13.1189
Rt222 vref__p11 vref__p12 17345.9
Rt223 vref__p11 vref__p13 9437.27
Rt224 vref__p11 vref__p14 4357.47
Rt225 vref__p11 vref__p15 11.7242
Rt226 vref__p11 vref__p16 6.70636
Rt227 vref__p11 vref__p17 3.30899
Rt228 vref__p11 vref__p2 588.996
Rt229 vref__p11 vref__p3 6559.22
Rt230 vref__p11 vref__p5 4701.78
Rt231 vref__p11 vref__p6 3179.28
Rt232 vref__p11 vref__p7 1973.95
Rt233 vref__p11 vref__p8 25829
Rt234 vref__p11 vref__p9 582.958
Rt235 vref__p12 vref__p13 2.76051
Rt236 vref__p12 vref__p14 5.69068
Rt237 vref__p12 vref__p15 3060.82
Rt238 vref__p12 vref__p16 6620.62
Rt239 vref__p12 vref__p17 12165.3
Rt240 vref__p12 vref__p2 961.871
Rt241 vref__p12 vref__p3 21690.6
Rt242 vref__p12 vref__p5 2025.57
Rt243 vref__p12 vref__p6 2781.47
Rt244 vref__p12 vref__p7 6608.37
Rt245 vref__p12 vref__p8 3.41549
Rt246 vref__p12 vref__p9 2.8795
Rt247 vref__p13 vref__p14 2.76481
Rt248 vref__p13 vref__p15 1665.29
Rt249 vref__p13 vref__p16 3602.05
Rt250 vref__p13 vref__p17 6618.72
Rt251 vref__p13 vref__p2 523.306
Rt252 vref__p13 vref__p3 11801.1
Rt253 vref__p13 vref__p5 1101.86
Rt254 vref__p13 vref__p6 1513.26
Rt255 vref__p13 vref__p7 3595.37
Rt256 vref__p13 vref__p8 6.9687
Rt257 vref__p13 vref__p9 2.56608
Rt258 vref__p14 vref__p15 768.912
Rt259 vref__p14 vref__p16 1663.17
Rt260 vref__p14 vref__p17 3056.06
Rt261 vref__p14 vref__p2 241.621
Rt262 vref__p14 vref__p3 5448.89
Rt263 vref__p14 vref__p5 508.693
Rt264 vref__p14 vref__p6 698.702
Rt265 vref__p14 vref__p7 1660.09
Rt266 vref__p14 vref__p8 12.1708
Rt267 vref__p14 vref__p9 1.86726
Rt268 vref__p15 vref__p16 2.76621
Rt269 vref__p15 vref__p17 5.68373
Rt270 vref__p15 vref__p2 103.213
Rt271 vref__p15 vref__p3 1145.31
Rt272 vref__p15 vref__p5 829.619
Rt273 vref__p15 vref__p6 560.804
Rt274 vref__p15 vref__p7 344.658
Rt275 vref__p15 vref__p8 4557.75
Rt276 vref__p15 vref__p9 102.868
Rt277 vref__p16 vref__p17 2.75986
Rt278 vref__p16 vref__p2 223.556
Rt279 vref__p16 vref__p3 2482.45
Rt280 vref__p16 vref__p5 1794.5
Rt281 vref__p16 vref__p6 1213.12
Rt282 vref__p16 vref__p7 747.047
Rt283 vref__p16 vref__p8 9858.5
Rt284 vref__p16 vref__p9 222.505
Rt285 vref__p17 vref__p2 411.407
Rt286 vref__p17 vref__p3 4571.97
Rt287 vref__p17 vref__p5 3297.42
Rt288 vref__p17 vref__p6 2229.27
Rt289 vref__p17 vref__p7 1375.86
Rt290 vref__p17 vref__p8 18114.9
Rt291 vref__p17 vref__p9 408.851
Rt292 vref__p2 vref__p3 5.49374
Rt293 vref__p2 vref__p5 65.7993
Rt294 vref__p2 vref__p6 7.45703
Rt295 vref__p2 vref__p7 6.5906
Rt296 vref__p2 vref__p8 1432.38
Rt297 vref__p2 vref__p9 32.3382
Rt298 vref__p3 vref__p5 5279.01
Rt299 vref__p3 vref__p6 2064.28
Rt300 vref__p3 vref__p7 48.2546
Rt301 vref__p3 vref__p8 32298.7
Rt302 vref__p3 vref__p9 728.99
Rt303 vref__p5 vref__p6 244.984
Rt304 vref__p5 vref__p7 1709.1
Rt305 vref__p5 vref__p8 3017.46
Rt306 vref__p5 vref__p9 68.2281
Rt307 vref__p6 vref__p7 871.249
Rt308 vref__p6 vref__p8 4142.06
Rt309 vref__p6 vref__p9 93.5132
Rt310 vref__p7 vref__p8 9840.28
Rt311 vref__p7 vref__p9 222.096
Rt312 vref__p8 vref__p9 1.94076
Rt313 vref_in vref_in__p1 0.001
Rt314 vref_in vref_in__p2 0.001
Rt315 vrefl vrefl__p0 31.2142
Rt316 vrefl vrefl__p2 90.457
Rt317 vrefl vrefl__p3 7.02586
Rt318 vrefl vrefl__p4 23111.2
Rt319 vrefl vrefl__p5 21086.8
Rt320 vrefl vrefl__p6 1580.13
Rt321 vrefl vrefl__p7 1812.07
Rt322 vrefl__p0 vrefl__p2 13.4619
Rt323 vrefl__p0 vrefl__p3 12.1983
Rt324 vrefl__p0 vrefl__p4 214.433
Rt325 vrefl__p0 vrefl__p5 298.857
Rt326 vrefl__p0 vrefl__p6 2749.51
Rt327 vrefl__p0 vrefl__p7 3154.95
Rt328 vrefl__p2 vrefl__p3 2.08764
Rt329 vrefl__p2 vrefl__p4 26.3196
Rt330 vrefl__p2 vrefl__p5 23.3537
Rt331 vrefl__p2 vrefl__p6 508.685
Rt332 vrefl__p2 vrefl__p7 594.319
Rt333 vrefl__p3 vrefl__p4 650.27
Rt334 vrefl__p3 vrefl__p5 550.114
Rt335 vrefl__p3 vrefl__p6 22.135
Rt336 vrefl__p3 vrefl__p7 24.0092
Rt337 vrefl__p4 vrefl__p5 561.468
Rt338 vrefl__p4 vrefl__p6 156447
Rt339 vrefl__p4 vrefl__p7 182772
Rt340 vrefl__p5 vrefl__p6 132380
Rt341 vrefl__p5 vrefl__p7 154674
Rt342 vrefl__p6 vrefl__p7 569.288
Rt343 vss vss__p0 35.217
Rt344 vss vss__p1 375.601
Rt345 vss vss__p10 2622.08
Rt346 vss vss__p11 3078.51
Rt347 vss vss__p12 3357.22
Rt348 vss vss__p13 3355.35
Rt349 vss vss__p14 1170.33
Rt350 vss vss__p15 3199.3
Rt351 vss vss__p16 1556.9
Rt352 vss vss__p17 1667.13
Rt353 vss vss__p18 1229.58
Rt354 vss vss__p19 26483.9
Rt355 vss vss__p2 149.37
Rt356 vss vss__p20 129650
Rt357 vss vss__p22 2
Rt358 vss vss__p23 2
Rt359 vss vss__p24 2
Rt360 vss vss__p25 2
Rt361 vss vss__p26 2
Rt362 vss vss__p27 2
Rt363 vss vss__p28 2
Rt364 vss vss__p29 2
Rt365 vss vss__p3 87.4318
Rt366 vss vss__p4 1084.27
Rt367 vss vss__p5 1343.02
Rt368 vss vss__p6 1766.07
Rt369 vss vss__p7 38.6999
Rt370 vss vss__p8 42.1829
Rt371 vss vss__p9 2117.8
Rt372 vss__p0 vss__p1 169.316
Rt373 vss__p0 vss__p10 31184.1
Rt374 vss__p0 vss__p11 36612.3
Rt375 vss__p0 vss__p12 39927.1
Rt376 vss__p0 vss__p13 39904.8
Rt377 vss__p0 vss__p14 13918.6
Rt378 vss__p0 vss__p15 38048.9
Rt379 vss__p0 vss__p16 18516.1
Rt380 vss__p0 vss__p17 19827
Rt381 vss__p0 vss__p18 14623.3
Rt382 vss__p0 vss__p19 314970
Rt383 vss__p0 vss__p2 6580.14
Rt384 vss__p0 vss__p3 3851.61
Rt385 vss__p0 vss__p4 488.778
Rt386 vss__p0 vss__p5 605.415
Rt387 vss__p0 vss__p6 796.124
Rt388 vss__p0 vss__p7 457.414
Rt389 vss__p0 vss__p8 502.088
Rt390 vss__p0 vss__p9 25186.8
Rt391 vss__p1 vss__p10 332589
Rt392 vss__p1 vss__p11 390483
Rt393 vss__p1 vss__p12 425836
Rt394 vss__p1 vss__p13 425598
Rt395 vss__p1 vss__p14 148446
Rt396 vss__p1 vss__p15 405804
Rt397 vss__p1 vss__p16 197480
Rt398 vss__p1 vss__p17 211462
Rt399 vss__p1 vss__p18 155962
Rt400 vss__p1 vss__p2 70179.4
Rt401 vss__p1 vss__p3 41078.7
Rt402 vss__p1 vss__p4 340.819
Rt403 vss__p1 vss__p5 422.149
Rt404 vss__p1 vss__p6 555.127
Rt405 vss__p1 vss__p7 4878.47
Rt406 vss__p1 vss__p8 5354.93
Rt407 vss__p1 vss__p9 268625
Rt408 vss__p10 vss__p11 113.995
Rt409 vss__p10 vss__p12 144.689
Rt410 vss__p10 vss__p13 176.071
Rt411 vss__p10 vss__p14 408.694
Rt412 vss__p10 vss__p15 253.751
Rt413 vss__p10 vss__p16 649.189
Rt414 vss__p10 vss__p17 695.151
Rt415 vss__p10 vss__p18 512.703
Rt416 vss__p10 vss__p19 11043.1
Rt417 vss__p10 vss__p2 474595
Rt418 vss__p10 vss__p20 54060.7
Rt419 vss__p10 vss__p3 277799
Rt420 vss__p10 vss__p4 960109
Rt421 vss__p10 vss__p7 12001.6
Rt422 vss__p10 vss__p8 14632.1
Rt423 vss__p10 vss__p9 98.8087
Rt424 vss__p11 vss__p12 120.587
Rt425 vss__p11 vss__p13 147.348
Rt426 vss__p11 vss__p14 393.479
Rt427 vss__p11 vss__p15 214.897
Rt428 vss__p11 vss__p16 647.256
Rt429 vss__p11 vss__p17 693.082
Rt430 vss__p11 vss__p18 511.177
Rt431 vss__p11 vss__p19 11010.2
Rt432 vss__p11 vss__p2 557208
Rt433 vss__p11 vss__p20 53899.7
Rt434 vss__p11 vss__p3 326155
Rt435 vss__p11 vss__p7 14090.7
Rt436 vss__p11 vss__p8 17179.1
Rt437 vss__p11 vss__p9 128.482
Rt438 vss__p12 vss__p13 117.474
Rt439 vss__p12 vss__p14 348.719
Rt440 vss__p12 vss__p15 172.707
Rt441 vss__p12 vss__p16 591.593
Rt442 vss__p12 vss__p17 633.478
Rt443 vss__p12 vss__p18 467.216
Rt444 vss__p12 vss__p19 10063.4
Rt445 vss__p12 vss__p2 607656
Rt446 vss__p12 vss__p20 49264.4
Rt447 vss__p12 vss__p3 355684
Rt448 vss__p12 vss__p7 15366.5
Rt449 vss__p12 vss__p8 18734.4
Rt450 vss__p12 vss__p9 162.494
Rt451 vss__p13 vss__p14 289.411
Rt452 vss__p13 vss__p15 134.139
Rt453 vss__p13 vss__p16 502.56
Rt454 vss__p13 vss__p17 538.142
Rt455 vss__p13 vss__p18 396.902
Rt456 vss__p13 vss__p19 8548.87
Rt457 vss__p13 vss__p2 607316
Rt458 vss__p13 vss__p20 41850.3
Rt459 vss__p13 vss__p3 355485
Rt460 vss__p13 vss__p7 15357.9
Rt461 vss__p13 vss__p8 18724
Rt462 vss__p13 vss__p9 196.648
Rt463 vss__p14 vss__p15 229.556
Rt464 vss__p14 vss__p16 219.065
Rt465 vss__p14 vss__p17 234.575
Rt466 vss__p14 vss__p18 173.009
Rt467 vss__p14 vss__p19 3726.44
Rt468 vss__p14 vss__p2 211828
Rt469 vss__p14 vss__p20 18242.5
Rt470 vss__p14 vss__p3 123991
Rt471 vss__p14 vss__p4 428530
Rt472 vss__p14 vss__p5 530790
Rt473 vss__p14 vss__p6 697992
Rt474 vss__p14 vss__p7 5356.74
Rt475 vss__p14 vss__p8 6530.81
Rt476 vss__p14 vss__p9 388.704
Rt477 vss__p15 vss__p16 345.898
Rt478 vss__p15 vss__p17 370.388
Rt479 vss__p15 vss__p18 273.176
Rt480 vss__p15 vss__p19 5883.95
Rt481 vss__p15 vss__p2 579071
Rt482 vss__p15 vss__p20 28804.4
Rt483 vss__p15 vss__p3 338952
Rt484 vss__p15 vss__p7 14643.6
Rt485 vss__p15 vss__p8 17853.2
Rt486 vss__p15 vss__p9 279.007
Rt487 vss__p16 vss__p17 49.2262
Rt488 vss__p16 vss__p18 36.3064
Rt489 vss__p16 vss__p19 782.002
Rt490 vss__p16 vss__p2 281799
Rt491 vss__p16 vss__p20 3828.23
Rt492 vss__p16 vss__p3 164948
Rt493 vss__p16 vss__p4 570080
Rt494 vss__p16 vss__p5 706119
Rt495 vss__p16 vss__p6 928550
Rt496 vss__p16 vss__p7 7126.16
Rt497 vss__p16 vss__p8 8688.05
Rt498 vss__p16 vss__p9 597.195
Rt499 vss__p17 vss__p18 34.5239
Rt500 vss__p17 vss__p19 743.61
Rt501 vss__p17 vss__p2 301750
Rt502 vss__p17 vss__p20 3640.29
Rt503 vss__p17 vss__p3 176626
Rt504 vss__p17 vss__p4 610442
Rt505 vss__p17 vss__p5 756112
Rt506 vss__p17 vss__p6 994291
Rt507 vss__p17 vss__p7 7630.69
Rt508 vss__p17 vss__p8 9303.16
Rt509 vss__p17 vss__p9 639.476
Rt510 vss__p18 vss__p19 0.666486
Rt511 vss__p18 vss__p2 222553
Rt512 vss__p18 vss__p20 3.26273
Rt513 vss__p18 vss__p3 130269
Rt514 vss__p18 vss__p4 450226
Rt515 vss__p18 vss__p5 557664
Rt516 vss__p18 vss__p6 733331
Rt517 vss__p18 vss__p7 5627.95
Rt518 vss__p18 vss__p8 6861.47
Rt519 vss__p18 vss__p9 471.64
Rt520 vss__p19 vss__p20 0.970962
Rt521 vss__p19 vss__p7 121220
Rt522 vss__p19 vss__p8 147789
Rt523 vss__p19 vss__p9 10158.7
Rt524 vss__p2 vss__p3 63.5288
Rt525 vss__p2 vss__p4 202592
Rt526 vss__p2 vss__p5 250937
Rt527 vss__p2 vss__p6 329983
Rt528 vss__p2 vss__p7 6657.77
Rt529 vss__p2 vss__p8 7726.5
Rt530 vss__p2 vss__p9 383321
Rt531 vss__p20 vss__p7 593425
Rt532 vss__p20 vss__p8 723490
Rt533 vss__p20 vss__p9 49730.9
Rt534 vss__p3 vss__p4 118585
Rt535 vss__p3 vss__p5 146883
Rt536 vss__p3 vss__p6 193152
Rt537 vss__p3 vss__p7 3897.05
Rt538 vss__p3 vss__p8 4522.62
Rt539 vss__p3 vss__p9 224372
Rt540 vss__p4 vss__p5 99.626
Rt541 vss__p4 vss__p6 131.009
Rt542 vss__p4 vss__p7 14083
Rt543 vss__p4 vss__p8 15458.5
Rt544 vss__p4 vss__p9 775460
Rt545 vss__p5 vss__p6 57.9372
Rt546 vss__p5 vss__p7 17443.7
Rt547 vss__p5 vss__p8 19147.3
Rt548 vss__p5 vss__p9 960509
Rt549 vss__p6 vss__p7 22938.5
Rt550 vss__p6 vss__p8 25178.8
Rt551 vss__p7 vss__p8 223.379
Rt552 vss__p7 vss__p9 9693.46
Rt553 vss__p8 vss__p9 11818
Rt554 xckg_d0 xckg_d0__p1 206.411
Rt555 xckg_d0 xckg_d0__p2 50.6383
Rt556 xckg_d0__p1 xckg_d0__p2 40.5376
Rt557 xckg_d1 xckg_d1__p1 176.827
Rt558 xckg_d1 xckg_d1__p2 53.6164
Rt559 xckg_d1__p1 xckg_d1__p2 42.2433
Rt560 xckg_d2 xckg_d2__p1 98.5076
Rt561 xckg_d2 xckg_d2__p2 97.0379
Rt562 xckg_d2__p1 xckg_d2__p2 76.6587
Rt563 xckg_d3 xckg_d3__p1 99.3636
Rt564 xckg_d3 xckg_d3__p2 100.408
Rt565 xckg_d3__p1 xckg_d3__p2 78.0493
Rt566 xckg_nn xckg_nn__p1 46.1928
Rt567 xckg_x xckg_x__p1 68.4444
Rt568 xckg_x xckg_x__p2 147.088
Rt569 xckg_x xckg_x__p3 1240.78
Rt570 xckg_x xckg_x__p4 614.493
Rt571 xckg_x__p1 xckg_x__p2 97.458
Rt572 xckg_x__p1 xckg_x__p3 822.123
Rt573 xckg_x__p1 xckg_x__p4 407.153
Rt574 xckg_x__p2 xckg_x__p3 124.848
Rt575 xckg_x__p2 xckg_x__p4 61.8301
Rt576 xckg_x__p3 xckg_x__p4 33.2764
Rt577 xref_na xref_na__p1 77.984
Rt578 xref_ng xref_ng__p1 1225.95
Rt579 xref_ng xref_ng__p2 132.884
Rt580 xref_ng__p1 xref_ng__p2 31.5508
Rt581 xref_ntl xref_ntl__p1 60.2546
Rt582 xref_ntl__p1 xref_ntl__p2 19.318
Cq0 ain_cos_n ain_cos_p 2.707e-14
Cq1 ain_cos_n ain_isa_n 3.593e-17
Cq2 ain_cos_n ain_isa_p 4.589e-17
Cq3 ain_cos_n ibias 1.098e-16
Cq4 ain_cos_n vdd 7.405e-16
Cq5 ain_cos_n vss 3.272e-14
Cq6 ain_cos_n xckg_d0 9.755e-19
Cq7 ain_cos_n xckg_d1 9.755e-19
Cq8 ain_cos_n xckg_d2 9.755e-19
Cq9 ain_cos_n xckg_d3 1.006e-18
Cq10 ain_cos_n xckg_x 5.633e-18
Cq11 ain_cos_p ain_isa_n 3.579e-17
Cq12 ain_cos_p ain_isa_p 4.832e-17
Cq13 ain_cos_p ibias 6.162e-17
Cq14 ain_cos_p vdd 1.923e-15
Cq15 ain_cos_p vss 3.653e-14
Cq16 ain_isa_n ain_isa_p 2.783e-14
Cq17 ain_isa_n ain_isb_n 6.95e-17
Cq18 ain_isa_n ain_isb_p 6.95e-17
Cq19 ain_isa_n vdd 1.357e-15
Cq20 ain_isa_n vss 3.109e-14
Cq21 ain_isa_p ain_isb_n 8.473e-17
Cq22 ain_isa_p ain_isb_p 8.473e-17
Cq23 ain_isa_p vdd 1.764e-15
Cq24 ain_isa_p vss 3.146e-14
Cq25 ain_isb_n ain_isb_p 7.431e-17
Cq26 ain_isb_n vss 7.586e-16
Cq27 ain_isb_p vss 7.532e-16
Cq28 ain_sin_n ain_sin_p 8.625e-17
Cq29 ain_sin_n ibias 7.283e-17
Cq30 ain_sin_n vss 1.026e-15
Cq31 ain_sin_p ibias 7.607e-17
Cq32 ain_sin_p vss 9.168e-16
Cq33 clk mclkb 2.216e-18
Cq34 clk sar_mclk 1.431e-16
Cq35 clk vdd 4.256e-16
Cq36 clk vss 1.851e-14
Cq37 clk xckg_d0 2.205e-16
Cq38 clk xckg_d1 1.236e-16
Cq39 clk xckg_d2 1.227e-16
Cq40 clk xckg_d3 1.663e-16
Cq41 clk xckg_nn 2.534e-17
Cq42 clk xckg_x 1.452e-16
Cq43 ibias vbn 2.266e-15
Cq44 ibias vbp 6.102e-17
Cq45 ibias vdd 4.481e-15
Cq46 ibias vdda 2.216e-16
Cq47 ibias vref 4.109e-14
Cq48 ibias vref_in 9.277e-15
Cq49 ibias vrefl 1.686e-14
Cq50 ibias vss 1.742e-13
Cq51 ibias xref_ng 2.101e-15
Cq52 ibias xref_ntl 1.737e-16
Cq53 mclkb sar_mclk 2.613e-16
Cq54 mclkb vdd 3.878e-16
Cq55 mclkb vss 1.226e-15
Cq56 mclkb xckg_d0 5.591e-17
Cq57 mclkb xckg_d1 3.991e-15
Cq58 mclkb xckg_d2 3.955e-15
Cq59 mclkb xckg_d3 6.865e-17
Cq60 mclkb xckg_nn 1.864e-17
Cq61 mclkb xckg_x 9.569e-17
Cq62 sar_mclk vdd 1.621e-15
Cq63 sar_mclk vss 6.739e-15
Cq64 sar_mclk xckg_d0 4.707e-15
Cq65 sar_mclk xckg_d1 2.058e-16
Cq66 sar_mclk xckg_d2 7.519e-17
Cq67 sar_mclk xckg_d3 9.271e-17
Cq68 sar_mclk xckg_nn 4.141e-16
Cq69 sar_mclk xckg_x 1.044e-15
Cq70 vbn vbp 2.899e-14
Cq71 vbn vdd 2.028e-15
Cq72 vbn vdda 5.091e-17
Cq73 vbn vref 1.786e-14
Cq74 vbn vref_in 4.127e-15
Cq75 vbn vrefl 2.512e-14
Cq76 vbn vss 1.155e-14
Cq77 vbn xref_na 7.746e-19
Cq78 vbn xref_ng 1.886e-15
Cq79 vbp vdd 1.803e-15
Cq80 vbp vdda 8.761e-15
Cq81 vbp vref 1.878e-14
Cq82 vbp vref_in 4.205e-15
Cq83 vbp vrefl 1.08e-14
Cq84 vbp vss 1.857e-14
Cq85 vbp xref_na 9.789e-18
Cq86 vbp xref_ng 2.371e-15
Cq87 vdd vdda 5.954e-16
Cq88 vdd vref 1.719e-13
Cq89 vdd vref_in 4.013e-14
Cq90 vdd vrefl 5.736e-14
Cq91 vdd vss 9.509e-14
Cq92 vdd xckg_d0 5.453e-16
Cq93 vdd xckg_d1 3.963e-16
Cq94 vdd xckg_d2 2.615e-16
Cq95 vdd xckg_d3 3.642e-16
Cq96 vdd xckg_x 1.101e-15
Cq97 vdd xref_ng 1.71e-14
Cq98 vdda vref 4.398e-14
Cq99 vdda vref_in 3.223e-16
Cq100 vdda vrefl 2.519e-14
Cq101 vdda vss 3.507e-14
Cq102 vdda xref_na 1.249e-15
Cq103 vdda xref_ng 2.299e-14
Cq104 vdda xref_ntl 9.96e-18
Cq105 vref vref_in 4.54e-14
Cq106 vref vrefl 1.648e-13
Cq107 vref vss 3.746e-13
Cq108 vref xref_na 1.322e-16
Cq109 vref xref_ng 4.971e-14
Cq110 vref xref_ntl 1.685e-15
Cq111 vref_in vrefl 3.08e-14
Cq112 vref_in vss 9.461e-14
Cq113 vref_in xref_na 4.042e-16
Cq114 vref_in xref_ng 3.421e-15
Cq115 vref_in xref_ntl 1.606e-15
Cq116 vrefl vss 1.912e-13
Cq117 vrefl xref_na 1.039e-16
Cq118 vrefl xref_ng 3.178e-14
Cq119 vrefl xref_ntl 2.185e-15
Cq120 vss xckg_d0 4.966e-15
Cq121 vss xckg_d1 4.102e-15
Cq122 vss xckg_d2 4.829e-15
Cq123 vss xckg_d3 5.853e-15
Cq124 vss xckg_nn 1.117e-15
Cq125 vss xckg_x 1.086e-14
Cq126 vss xref_na 4.437e-15
Cq127 vss xref_ng 8.811e-14
Cq128 vss xref_ntl 3.71e-15
Cq129 xckg_d0 xckg_d1 8.434e-15
Cq130 xckg_d0 xckg_d2 2.37e-16
Cq131 xckg_d0 xckg_d3 1.818e-16
Cq132 xckg_d0 xckg_nn 2.011e-17
Cq133 xckg_d0 xckg_x 6.919e-16
Cq134 xckg_d1 xckg_d2 2.001e-15
Cq135 xckg_d1 xckg_d3 1.378e-16
Cq136 xckg_d1 xckg_nn 5.907e-16
Cq137 xckg_d1 xckg_x 4.219e-16
Cq138 xckg_d2 xckg_d3 8.547e-15
Cq139 xckg_d2 xckg_nn 5.574e-16
Cq140 xckg_d2 xckg_x 4.153e-16
Cq141 xckg_d3 xckg_nn 3.667e-17
Cq142 xckg_d3 xckg_x 5.111e-15
Cq143 xckg_nn xckg_x 1.118e-16
Cq144 xref_na xref_ng 2.554e-15
Cq145 xref_na xref_ntl 2.584e-16
Cq146 xref_ng xref_ntl 2.12e-15
.ends
.subckt r1_adc_lay_pr adc_hold is_smp clk adc_start adc_sel adc_valid_a adc_raw_a_0 adc_raw_a_1 adc_raw_a_2 adc_raw_a_3 adc_raw_a_4 adc_raw_a_5 adc_raw_a_6 adc_raw_a_7 adc_raw_a_8 adc_raw_a_9 adc_raw_a_10 adc_raw_a_11 adc_raw_a_12 adc_raw_a_13 adc_valid_b adc_raw_b_0 adc_raw_b_1 adc_raw_b_2 adc_raw_b_3 adc_raw_b_4 adc_raw_b_5 adc_raw_b_6 adc_raw_b_7 adc_raw_b_8 adc_raw_b_9 adc_raw_b_10 adc_raw_b_11 adc_raw_b_12 adc_raw_b_13 por_n ain_sin_p ain_sin_n ain_cos_p ain_cos_n vcm2 ibias ain_isa_p ain_isa_n ain_isb_p ain_isb_n vcm vdda vdd vss vref_in topap topan topbp topbn sar_clka sar_clkab sar_clkb sar_clkbb sar_clkna sar_clknab sar_clknb sar_clknbb sar_cna0 sar_cna1 sar_cna10 sar_cna11 sar_cna12 sar_cna2 sar_cna3 sar_cna4 sar_cna5 sar_cna6 sar_cna7 sar_cna8 sar_cna9 sar_cnb0 sar_cnb1 sar_cnb10 sar_cnb11 sar_cnb12 sar_cnb2 sar_cnb3 sar_cnb4 sar_cnb5 sar_cnb6 sar_cnb7 sar_cnb8 sar_cnb9 sar_cpa0 sar_cpa1 sar_cpa10 sar_cpa11 sar_cpa12 sar_cpa2 sar_cpa3 sar_cpa4 sar_cpa5 sar_cpa6 sar_cpa7 sar_cpa8 sar_cpa9 sar_cpb0 sar_cpb1 sar_cpb10 sar_cpb11 sar_cpb12 sar_cpb2 sar_cpb3 sar_cpb4 sar_cpb5 sar_cpb6 sar_cpb7 sar_cpb8 sar_cpb9 sar_oan sar_oann sar_oanp sar_oap sar_obn sar_obnn sar_obnp sar_obp sar_trka0 sar_trka1 sar_trkb0 sar_trkb1 sar_mclk vref vrefl
Xxckg_xpd0 xckg_d0__p1 clk vdd__p2 vdd sg13_lv_pmos w=1u l=0.5u ng=1 m=1
Xxckg_xnd0 xckg_d0 clk vss__p9 vss sg13_lv_nmos w=0.5u l=0.5u ng=1 m=1
Xxckg_cd0 xckg_d0__p2 vss__p16 cap_cmim w=2.53u l=2.53u m=1
Xxckg_xpd1 xckg_d1__p1 xckg_d0 vdd__p3 vdd sg13_lv_pmos w=1u l=0.5u ng=1 m=1
Xxckg_xnd1 xckg_d1 xckg_d0 vss__p10 vss sg13_lv_nmos w=0.5u l=0.5u ng=1 m=1
Xxckg_cd1 xckg_d1__p2 vss__p17 cap_cmim w=2.53u l=2.53u m=1
Xxckg_xpd2 xckg_d2__p1 xckg_d1 vdd__p4 vdd sg13_lv_pmos w=1u l=0.5u ng=1 m=1
Xxckg_xnd2 xckg_d2 xckg_d1 vss__p11 vss sg13_lv_nmos w=0.5u l=0.5u ng=1 m=1
Xxckg_cd2 xckg_d2__p2 vss__p18 cap_cmim w=2.53u l=2.53u m=1
Xxckg_xpd3 xckg_d3__p1 xckg_d2 vdd__p5 vdd sg13_lv_pmos w=1u l=0.5u ng=1 m=1
Xxckg_xnd3 xckg_d3 xckg_d2 vss__p12 vss sg13_lv_nmos w=0.5u l=0.5u ng=1 m=1
Xxckg_cd3 xckg_d3__p2 vss__p19 cap_cmim w=2.53u l=2.53u m=1
Xxckg_xpd4 xckg_x__p2 xckg_d3 vdd__p6 vdd sg13_lv_pmos w=1u l=0.5u ng=1 m=1
Xxckg_xnd4 xckg_x xckg_d3 vss__p13 vss sg13_lv_nmos w=0.5u l=0.5u ng=1 m=1
Xxckg_cd4 xckg_x__p4 vss__p20 cap_cmim w=2.53u l=2.53u m=1
Xxckg_xpa sar_mclk__p2 clk__p1 vdd__p7 vdd sg13_lv_pmos w=2u l=0.13u ng=1 m=1
Xxckg_xpb sar_mclk__p3 xckg_x__p3 vdd__p8 vdd sg13_lv_pmos w=2u l=0.13u ng=1 m=1
Xxckg_xna sar_mclk clk__p0 xckg_nn vss sg13_lv_nmos w=2u l=0.13u ng=1 m=1
Xxckg_xnb xckg_nn__p1 xckg_x__p1 vss__p14 vss sg13_lv_nmos w=2u l=0.13u ng=1 m=1
Xxckg_xpi mclkb__p1 sar_mclk__p4 vdd__p9 vdd sg13_lv_pmos w=2u l=0.13u ng=1 m=1
Xxckg_xni mclkb sar_mclk__p1 vss__p15 vss sg13_lv_nmos w=1u l=0.13u ng=1 m=1
Xxcbias_xmbd vbp__p1 vbp vdd__p1 vdd sg13_lv_pmos w=0.8u l=0.5u ng=1 m=1
Xxcbias_xrb_g0 vbp xcbias_xrb_s1 vss rppd w=1u l=40u m=1 b=0
Xxcbias_xrb_g1 xcbias_xrb_s1 xcbias_xrb_s2 vss rppd w=1u l=40u m=1 b=0
Xxcbias_xrb_g2 xcbias_xrb_s2 xcbias_xrb_s3 vss rppd w=1u l=40u m=1 b=0
Xxcbias_xrb_g3 xcbias_xrb_s3 vss__p7 vss rppd w=1u l=40u m=1 b=0
Xxcbiasn_xmbd vbn__p1 vbn vss__p8 vss sg13_lv_nmos w=0.2u l=0.5u ng=1 m=1
Xxcbiasn_xrb_g0 vdd__p0 xcbiasn_xrb_s1 vss rppd w=1u l=40u m=1 b=0
Xxcbiasn_xrb_g1 xcbiasn_xrb_s1 xcbiasn_xrb_s2 vss rppd w=1u l=40u m=1 b=0
Xxcbiasn_xrb_g2 xcbiasn_xrb_s2 xcbiasn_xrb_s3 vss rppd w=1u l=40u m=1 b=0
Xxcbiasn_xrb_g3 xcbiasn_xrb_s3 vbn vss rppd w=1u l=40u m=1 b=0
Xxref_xmb0 ibias__p0 ibias vss__p5 vss sg13_hv_nmos w=2u l=1u ng=1 m=1
Xxref_xmt xref_ntl ibias vss__p6 vss sg13_hv_nmos w=2u l=8u ng=1 m=1
Xxref_xm1 xref_na vref_in xref_ntl__p1 vss sg13_hv_nmos w=10u l=1u ng=2 m=1
Xxref_xm2 xref_ng vref xref_ntl__p2 vss sg13_hv_nmos w=10u l=1u ng=2 m=1
Xxref_xm3 xref_na__p1 xref_na vdda__p5 vdda sg13_hv_pmos w=4u l=1u ng=1 m=1
Xxref_xm4 xref_ng__p1 xref_na vdda__p6 vdda sg13_hv_pmos w=4u l=1u ng=1 m=1
Xxref_xcg_u0 vss xref_ng__p2 cap_cmim w=26.32u l=95u m=1
Xxref_xmsf_s0 vdda__p1 xref_ng vref vss sg13_hv_nmos w=80u l=0.45u ng=32 m=1
Xxref_xmsf_s1 vdda__p2 xref_ng vref__p5 vss sg13_hv_nmos w=80u l=0.45u ng=32 m=1
Xxref_xmsf_s2 vdda__p3 xref_ng vref__p6 vss sg13_hv_nmos w=80u l=0.45u ng=32 m=1
Xxref_xmsf_s3 vdda__p4 xref_ng vref__p7 vss sg13_hv_nmos w=80u l=0.45u ng=32 m=1
Xxref_xmib_s0 vref__p0 ibias vss__p0 vss sg13_hv_nmos w=80u l=1u ng=40 m=1
Xxref_xmib_s1 vref__p1 ibias vss__p1 vss sg13_hv_nmos w=80u l=1u ng=40 m=1
Xxref_xmib_s2 vref__p2 ibias vss__p2 vss sg13_hv_nmos w=80u l=1u ng=40 m=1
Xxref_xmib_s3 vref__p3 ibias vss__p3 vss sg13_hv_nmos w=80u l=1u ng=40 m=1
Xxref_xcd_u0 vss vref__p8 cap_cmim w=51.58u l=95u m=1
Xxref_xcd_u1 vss vref__p9 cap_cmim w=51.58u l=95u m=1
Xxref_xcd_u2 vss vref__p10 cap_cmim w=51.58u l=95u m=1
Xxref_xcd_u3 vss vref__p11 cap_cmim w=51.58u l=95u m=1
Xxref_xmsfl_s0 vdda__p0 xref_ng vrefl vss sg13_hv_nmos w=80u l=0.45u ng=32 m=1
Xxref_xmibl_s0 vrefl__p0 ibias vss__p4 vss sg13_hv_nmos w=80u l=1u ng=40 m=1
Xxref_xcdl_u0 vss vrefl__p2 cap_cmim w=51.58u l=95u m=1
Xxref_xcdl_u1 vss vrefl__p3 cap_cmim w=51.58u l=95u m=1
Xxfilt_xcf_u0 vss vref_in__p1 cap_cmim w=37.36u l=90u m=1
Xxfilt_xcf_u1 vss vref_in__p2 cap_cmim w=37.36u l=90u m=1
Xslice_a ain_sin_p__p1 ain_sin_n__p1 ain_isa_p__p1 ain_isa_n__p1 sar_trka0 sar_trka1 sar_cpa0 sar_cpa1 sar_cpa2 sar_cpa3 sar_cpa4 sar_cpa5 sar_cpa6 sar_cpa7 sar_cpa8 sar_cpa9 sar_cpa10 sar_cpa11 sar_cpa12 sar_cna0 sar_cna1 sar_cna2 sar_cna3 sar_cna4 sar_cna5 sar_cna6 sar_cna7 sar_cna8 sar_cna9 sar_cna10 sar_cna11 sar_cna12 sar_clka sar_clkab sar_clkna sar_clknab sar_oap sar_oan sar_oanp sar_oann vbp__p2 vbn__p2 sp_vref__p12_a sp_vref__p13_a sp_vref__p14_a sp_vrefl__p4_a sp_vrefl__p5_a topap topan vdd__p11 vdd__p12 vdd__p13 vdd__p14 xslice_a_gnd_nc0 vss__p22 xslice_a_gnd_nc2 vss__p23 xslice_a_gnd_nc4 vss__p24 xslice_a_gnd_nc6 vss__p25 r1_adc_slice_post
Vsp_vref__p12_a sp_vref__p12_a 0 DC 1.049760
Vsp_vref__p13_a sp_vref__p13_a 0 DC 1.049760
Vsp_vref__p14_a sp_vref__p14_a 0 DC 1.049760
Vsp_vrefl__p4_a sp_vrefl__p4_a 0 DC 1.058137
Vsp_vrefl__p5_a sp_vrefl__p5_a 0 DC 1.058156
Xslice_b ain_cos_p__p1 ain_cos_n__p1 ain_isb_p__p1 ain_isb_n__p1 sar_trkb0 sar_trkb1 sar_cpb0 sar_cpb1 sar_cpb2 sar_cpb3 sar_cpb4 sar_cpb5 sar_cpb6 sar_cpb7 sar_cpb8 sar_cpb9 sar_cpb10 sar_cpb11 sar_cpb12 sar_cnb0 sar_cnb1 sar_cnb2 sar_cnb3 sar_cnb4 sar_cnb5 sar_cnb6 sar_cnb7 sar_cnb8 sar_cnb9 sar_cnb10 sar_cnb11 sar_cnb12 sar_clkb sar_clkbb sar_clknb sar_clknbb sar_obp sar_obn sar_obnp sar_obnn vbp__p3 vbn__p3 sp_vref__p15_b sp_vref__p16_b sp_vref__p17_b sp_vrefl__p6_b sp_vrefl__p7_b topbp topbn vdd__p15 vdd__p16 vdd__p17 vdd__p18 vss__p26 xslice_b_gnd_nc1 vss__p27 xslice_b_gnd_nc3 vss__p28 xslice_b_gnd_nc5 vss__p29 xslice_b_gnd_nc7 r1_adc_slice_post
Vsp_vref__p15_b sp_vref__p15_b 0 DC 1.049737
Vsp_vref__p16_b sp_vref__p16_b 0 DC 1.049737
Vsp_vref__p17_b sp_vref__p17_b 0 DC 1.049737
Vsp_vrefl__p6_b sp_vrefl__p6_b 0 DC 1.058317
Vsp_vrefl__p7_b sp_vrefl__p7_b 0 DC 1.058317
Rt0 ain_cos_n ain_cos_n__p1 126.828
Rt1 ain_cos_p ain_cos_p__p1 128.647
Rt2 ain_isa_n ain_isa_n__p1 127.972
Rt3 ain_isa_p ain_isa_p__p1 129.791
Rt4 ain_isb_n ain_isb_n__p1 0.198
Rt5 ain_isb_p ain_isb_p__p1 0.198
Rt6 ain_sin_n ain_sin_n__p1 0.308
Rt7 ain_sin_p ain_sin_p__p1 0.308
Rt8 clk clk__p0 45.3911
Rt9 clk clk__p1 62.5679
Rt10 clk__p0 clk__p1 72.0627
Rt11 ibias ibias__p0 200.561
Rt12 mclkb mclkb__p1 43.3194
Rt13 sar_mclk sar_mclk__p1 56.5336
Rt14 sar_mclk sar_mclk__p3 125.793
Rt15 sar_mclk sar_mclk__p4 124.991
Rt16 sar_mclk__p1 sar_mclk__p3 116.67
Rt17 sar_mclk__p1 sar_mclk__p4 115.926
Rt18 sar_mclk__p2 sar_mclk__p3 0.6204
Rt19 sar_mclk__p3 sar_mclk__p4 23.2017
Rt20 vbn vbn__p1 68.8436
Rt21 vbn vbn__p2 240.016
Rt22 vbn vbn__p3 784.574
Rt23 vbn__p1 vbn__p2 217.489
Rt24 vbn__p1 vbn__p3 710.938
Rt25 vbn__p2 vbn__p3 168.032
Rt26 vbp vbp__p1 73.6975
Rt27 vbp vbp__p2 245.763
Rt28 vbp vbp__p3 1260.46
Rt29 vbp__p1 vbp__p2 195.517
Rt30 vbp__p1 vbp__p3 1002.76
Rt31 vbp__p2 vbp__p3 154.24
Rt32 vdd vdd__p0 34389.1
Rt33 vdd vdd__p1 40943
Rt34 vdd vdd__p11 82.2115
Rt35 vdd vdd__p12 11.0679
Rt36 vdd vdd__p13 29.2468
Rt37 vdd vdd__p14 436.411
Rt38 vdd vdd__p15 3347.45
Rt39 vdd vdd__p16 41646.7
Rt40 vdd vdd__p17 763098
Rt41 vdd__p0 vdd__p1 119.607
Rt42 vdd__p0 vdd__p11 99.6158
Rt43 vdd__p0 vdd__p12 288.609
Rt44 vdd__p0 vdd__p13 7715.85
Rt45 vdd__p0 vdd__p14 115134
Rt46 vdd__p0 vdd__p15 883122
Rt47 vdd__p1 vdd__p11 118.601
Rt48 vdd__p1 vdd__p12 343.612
Rt49 vdd__p1 vdd__p13 9186.33
Rt50 vdd__p1 vdd__p14 137076
Rt51 vdd__p11 vdd__p12 0.697261
Rt52 vdd__p11 vdd__p13 18.4457
Rt53 vdd__p11 vdd__p14 275.241
Rt54 vdd__p11 vdd__p15 2111.21
Rt55 vdd__p11 vdd__p16 26266.2
Rt56 vdd__p11 vdd__p17 481280
Rt57 vdd__p12 vdd__p13 2.4833
Rt58 vdd__p12 vdd__p14 37.055
Rt59 vdd__p12 vdd__p15 284.227
Rt60 vdd__p12 vdd__p16 3536.16
Rt61 vdd__p12 vdd__p17 64793.5
Rt62 vdd__p12 vdd__p18 894245
Rt63 vdd__p13 vdd__p14 0.525684
Rt64 vdd__p13 vdd__p15 4.43203
Rt65 vdd__p13 vdd__p16 55.1402
Rt66 vdd__p13 vdd__p17 1010.34
Rt67 vdd__p13 vdd__p18 13944.2
Rt68 vdd__p13 vdd__p2 35117.4
Rt69 vdd__p13 vdd__p3 32180.6
Rt70 vdd__p13 vdd__p4 27393.5
Rt71 vdd__p13 vdd__p5 22092.9
Rt72 vdd__p13 vdd__p6 17196.9
Rt73 vdd__p13 vdd__p7 31672.4
Rt74 vdd__p13 vdd__p8 22266.6
Rt75 vdd__p13 vdd__p9 18440
Rt76 vdd__p14 vdd__p15 0.368199
Rt77 vdd__p14 vdd__p16 6.97557
Rt78 vdd__p14 vdd__p17 127.814
Rt79 vdd__p14 vdd__p18 1764.03
Rt80 vdd__p14 vdd__p2 1256.58
Rt81 vdd__p14 vdd__p3 1151.5
Rt82 vdd__p14 vdd__p4 980.203
Rt83 vdd__p14 vdd__p5 790.534
Rt84 vdd__p14 vdd__p6 615.346
Rt85 vdd__p14 vdd__p7 1133.31
Rt86 vdd__p14 vdd__p8 796.752
Rt87 vdd__p14 vdd__p9 659.828
Rt88 vdd__p15 vdd__p16 0.803024
Rt89 vdd__p15 vdd__p17 14.9193
Rt90 vdd__p15 vdd__p18 205.908
Rt91 vdd__p15 vdd__p2 3270.69
Rt92 vdd__p15 vdd__p3 2997.17
Rt93 vdd__p15 vdd__p4 2551.32
Rt94 vdd__p15 vdd__p5 2057.64
Rt95 vdd__p15 vdd__p6 1601.65
Rt96 vdd__p15 vdd__p7 2949.84
Rt97 vdd__p15 vdd__p8 2073.82
Rt98 vdd__p15 vdd__p9 1717.43
Rt99 vdd__p16 vdd__p17 2.61771
Rt100 vdd__p16 vdd__p18 36.1282
Rt101 vdd__p16 vdd__p2 77135.5
Rt102 vdd__p16 vdd__p3 70684.8
Rt103 vdd__p16 vdd__p4 60169.8
Rt104 vdd__p16 vdd__p5 48527
Rt105 vdd__p16 vdd__p6 37773.1
Rt106 vdd__p16 vdd__p7 69568.5
Rt107 vdd__p16 vdd__p8 48908.7
Rt108 vdd__p16 vdd__p9 40503.6
Rt109 vdd__p17 vdd__p18 0.487307
Rt110 vdd__p17 vdd__p5 889168
Rt111 vdd__p17 vdd__p6 692122
Rt112 vdd__p17 vdd__p8 896161
Rt113 vdd__p17 vdd__p9 742154
Rt114 vdd__p2 vdd__p3 89.2941
Rt115 vdd__p2 vdd__p4 116.664
Rt116 vdd__p2 vdd__p5 148.715
Rt117 vdd__p2 vdd__p6 182.18
Rt118 vdd__p2 vdd__p7 396.838
Rt119 vdd__p2 vdd__p8 438.92
Rt120 vdd__p2 vdd__p9 468.083
Rt121 vdd__p3 vdd__p4 106.908
Rt122 vdd__p3 vdd__p5 136.278
Rt123 vdd__p3 vdd__p6 166.945
Rt124 vdd__p3 vdd__p7 363.651
Rt125 vdd__p3 vdd__p8 402.214
Rt126 vdd__p3 vdd__p9 428.938
Rt127 vdd__p4 vdd__p5 116.005
Rt128 vdd__p4 vdd__p6 142.11
Rt129 vdd__p4 vdd__p7 309.555
Rt130 vdd__p4 vdd__p8 342.381
Rt131 vdd__p4 vdd__p9 365.13
Rt132 vdd__p5 vdd__p6 114.612
Rt133 vdd__p5 vdd__p7 249.657
Rt134 vdd__p5 vdd__p8 276.131
Rt135 vdd__p5 vdd__p9 294.478
Rt136 vdd__p6 vdd__p7 194.331
Rt137 vdd__p6 vdd__p8 214.938
Rt138 vdd__p6 vdd__p9 229.219
Rt139 vdd__p7 vdd__p8 395.862
Rt140 vdd__p7 vdd__p9 422.164
Rt141 vdd__p8 vdd__p9 296.794
Rt142 vdda vdda__p1 41.3489
Rt143 vdda vdda__p2 278.578
Rt144 vdda vdda__p3 56.012
Rt145 vdda vdda__p5 261.48
Rt146 vdda vdda__p6 203.591
Rt147 vdda__p0 vdda__p3 62.8025
Rt148 vdda__p0 vdda__p4 67.5999
Rt149 vdda__p1 vdda__p2 1202.37
Rt150 vdda__p1 vdda__p3 241.754
Rt151 vdda__p1 vdda__p5 1128.58
Rt152 vdda__p1 vdda__p6 878.722
Rt153 vdda__p2 vdda__p3 256.165
Rt154 vdda__p2 vdda__p5 63.6193
Rt155 vdda__p2 vdda__p6 79.0683
Rt156 vdda__p3 vdda__p4 23.0314
Rt157 vdda__p3 vdda__p5 240.442
Rt158 vdda__p3 vdda__p6 187.211
Rt159 vdda__p5 vdda__p6 74.2153
Rt160 vref vref__p0 114.65
Rt161 vref vref__p1 6.10169
Rt162 vref vref__p10 186.142
Rt163 vref vref__p11 8271.36
Rt164 vref vref__p12 1487.93
Rt165 vref vref__p13 808.459
Rt166 vref vref__p14 372.871
Rt167 vref vref__p15 1459.54
Rt168 vref vref__p16 3157.02
Rt169 vref vref__p17 5801
Rt170 vref vref__p2 370.329
Rt171 vref vref__p3 10248.9
Rt172 vref vref__p5 428.96
Rt173 vref vref__p6 1135.72
Rt174 vref vref__p7 3138.93
Rt175 vref vref__p8 2223.31
Rt176 vref vref__p9 50.9452
Rt177 vref__p0 vref__p1 5.08178
Rt178 vref__p0 vref__p10 1372.92
Rt179 vref__p0 vref__p11 61005.8
Rt180 vref__p0 vref__p12 11330.2
Rt181 vref__p0 vref__p13 6156.32
Rt182 vref__p0 vref__p14 2839.43
Rt183 vref__p0 vref__p15 10764.9
Rt184 vref__p0 vref__p16 23284.7
Rt185 vref__p0 vref__p17 42785.5
Rt186 vref__p0 vref__p2 2151.06
Rt187 vref__p0 vref__p3 74645.3
Rt188 vref__p0 vref__p5 1782.68
Rt189 vref__p0 vref__p6 6979.82
Rt190 vref__p0 vref__p7 23027.9
Rt191 vref__p0 vref__p8 16928.7
Rt192 vref__p0 vref__p9 387.793
Rt193 vref__p1 vref__p10 27.2286
Rt194 vref__p1 vref__p11 1209.68
Rt195 vref__p1 vref__p12 366.189
Rt196 vref__p1 vref__p13 199.066
Rt197 vref__p1 vref__p14 91.8501
Rt198 vref__p1 vref__p15 213.441
Rt199 vref__p1 vref__p16 461.684
Rt200 vref__p1 vref__p17 848.354
Rt201 vref__p1 vref__p2 8.38761
Rt202 vref__p1 vref__p3 1193.26
Rt203 vref__p1 vref__p5 6.38445
Rt204 vref__p1 vref__p6 32.923
Rt205 vref__p1 vref__p7 414.228
Rt206 vref__p1 vref__p8 546.455
Rt207 vref__p1 vref__p9 12.4499
Rt208 vref__p10 vref__p11 1.96723
Rt209 vref__p10 vref__p12 390.352
Rt210 vref__p10 vref__p13 212.377
Rt211 vref__p10 vref__p14 98.0606
Rt212 vref__p10 vref__p15 1.88326
Rt213 vref__p10 vref__p16 2.58285
Rt214 vref__p10 vref__p17 2.96452
Rt215 vref__p10 vref__p2 13.5031
Rt216 vref__p10 vref__p3 151.839
Rt217 vref__p10 vref__p5 105.826
Rt218 vref__p10 vref__p6 71.6163
Rt219 vref__p10 vref__p7 45.7002
Rt220 vref__p10 vref__p8 581.257
Rt221 vref__p10 vref__p9 13.1189
Rt222 vref__p11 vref__p12 17345.9
Rt223 vref__p11 vref__p13 9437.27
Rt224 vref__p11 vref__p14 4357.47
Rt225 vref__p11 vref__p15 11.7242
Rt226 vref__p11 vref__p16 6.70636
Rt227 vref__p11 vref__p17 3.30899
Rt228 vref__p11 vref__p2 588.996
Rt229 vref__p11 vref__p3 6559.22
Rt230 vref__p11 vref__p5 4701.78
Rt231 vref__p11 vref__p6 3179.28
Rt232 vref__p11 vref__p7 1973.95
Rt233 vref__p11 vref__p8 25829
Rt234 vref__p11 vref__p9 582.958
Rt235 vref__p12 vref__p13 2.76051
Rt236 vref__p12 vref__p14 5.69068
Rt237 vref__p12 vref__p15 3060.82
Rt238 vref__p12 vref__p16 6620.62
Rt239 vref__p12 vref__p17 12165.3
Rt240 vref__p12 vref__p2 961.871
Rt241 vref__p12 vref__p3 21690.6
Rt242 vref__p12 vref__p5 2025.57
Rt243 vref__p12 vref__p6 2781.47
Rt244 vref__p12 vref__p7 6608.37
Rt245 vref__p12 vref__p8 3.41549
Rt246 vref__p12 vref__p9 2.8795
Rt247 vref__p13 vref__p14 2.76481
Rt248 vref__p13 vref__p15 1665.29
Rt249 vref__p13 vref__p16 3602.05
Rt250 vref__p13 vref__p17 6618.72
Rt251 vref__p13 vref__p2 523.306
Rt252 vref__p13 vref__p3 11801.1
Rt253 vref__p13 vref__p5 1101.86
Rt254 vref__p13 vref__p6 1513.26
Rt255 vref__p13 vref__p7 3595.37
Rt256 vref__p13 vref__p8 6.9687
Rt257 vref__p13 vref__p9 2.56608
Rt258 vref__p14 vref__p15 768.912
Rt259 vref__p14 vref__p16 1663.17
Rt260 vref__p14 vref__p17 3056.06
Rt261 vref__p14 vref__p2 241.621
Rt262 vref__p14 vref__p3 5448.89
Rt263 vref__p14 vref__p5 508.693
Rt264 vref__p14 vref__p6 698.702
Rt265 vref__p14 vref__p7 1660.09
Rt266 vref__p14 vref__p8 12.1708
Rt267 vref__p14 vref__p9 1.86726
Rt268 vref__p15 vref__p16 2.76621
Rt269 vref__p15 vref__p17 5.68373
Rt270 vref__p15 vref__p2 103.213
Rt271 vref__p15 vref__p3 1145.31
Rt272 vref__p15 vref__p5 829.619
Rt273 vref__p15 vref__p6 560.804
Rt274 vref__p15 vref__p7 344.658
Rt275 vref__p15 vref__p8 4557.75
Rt276 vref__p15 vref__p9 102.868
Rt277 vref__p16 vref__p17 2.75986
Rt278 vref__p16 vref__p2 223.556
Rt279 vref__p16 vref__p3 2482.45
Rt280 vref__p16 vref__p5 1794.5
Rt281 vref__p16 vref__p6 1213.12
Rt282 vref__p16 vref__p7 747.047
Rt283 vref__p16 vref__p8 9858.5
Rt284 vref__p16 vref__p9 222.505
Rt285 vref__p17 vref__p2 411.407
Rt286 vref__p17 vref__p3 4571.97
Rt287 vref__p17 vref__p5 3297.42
Rt288 vref__p17 vref__p6 2229.27
Rt289 vref__p17 vref__p7 1375.86
Rt290 vref__p17 vref__p8 18114.9
Rt291 vref__p17 vref__p9 408.851
Rt292 vref__p2 vref__p3 5.49374
Rt293 vref__p2 vref__p5 65.7993
Rt294 vref__p2 vref__p6 7.45703
Rt295 vref__p2 vref__p7 6.5906
Rt296 vref__p2 vref__p8 1432.38
Rt297 vref__p2 vref__p9 32.3382
Rt298 vref__p3 vref__p5 5279.01
Rt299 vref__p3 vref__p6 2064.28
Rt300 vref__p3 vref__p7 48.2546
Rt301 vref__p3 vref__p8 32298.7
Rt302 vref__p3 vref__p9 728.99
Rt303 vref__p5 vref__p6 244.984
Rt304 vref__p5 vref__p7 1709.1
Rt305 vref__p5 vref__p8 3017.46
Rt306 vref__p5 vref__p9 68.2281
Rt307 vref__p6 vref__p7 871.249
Rt308 vref__p6 vref__p8 4142.06
Rt309 vref__p6 vref__p9 93.5132
Rt310 vref__p7 vref__p8 9840.28
Rt311 vref__p7 vref__p9 222.096
Rt312 vref__p8 vref__p9 1.94076
Rt313 vref_in vref_in__p1 0.001
Rt314 vref_in vref_in__p2 0.001
Rt315 vrefl vrefl__p0 31.2142
Rt316 vrefl vrefl__p2 90.457
Rt317 vrefl vrefl__p3 7.02586
Rt318 vrefl vrefl__p4 23111.2
Rt319 vrefl vrefl__p5 21086.8
Rt320 vrefl vrefl__p6 1580.13
Rt321 vrefl vrefl__p7 1812.07
Rt322 vrefl__p0 vrefl__p2 13.4619
Rt323 vrefl__p0 vrefl__p3 12.1983
Rt324 vrefl__p0 vrefl__p4 214.433
Rt325 vrefl__p0 vrefl__p5 298.857
Rt326 vrefl__p0 vrefl__p6 2749.51
Rt327 vrefl__p0 vrefl__p7 3154.95
Rt328 vrefl__p2 vrefl__p3 2.08764
Rt329 vrefl__p2 vrefl__p4 26.3196
Rt330 vrefl__p2 vrefl__p5 23.3537
Rt331 vrefl__p2 vrefl__p6 508.685
Rt332 vrefl__p2 vrefl__p7 594.319
Rt333 vrefl__p3 vrefl__p4 650.27
Rt334 vrefl__p3 vrefl__p5 550.114
Rt335 vrefl__p3 vrefl__p6 22.135
Rt336 vrefl__p3 vrefl__p7 24.0092
Rt337 vrefl__p4 vrefl__p5 561.468
Rt338 vrefl__p4 vrefl__p6 156447
Rt339 vrefl__p4 vrefl__p7 182772
Rt340 vrefl__p5 vrefl__p6 132380
Rt341 vrefl__p5 vrefl__p7 154674
Rt342 vrefl__p6 vrefl__p7 569.288
Rt343 vss vss__p0 35.217
Rt344 vss vss__p1 375.601
Rt345 vss vss__p10 2622.08
Rt346 vss vss__p11 3078.51
Rt347 vss vss__p12 3357.22
Rt348 vss vss__p13 3355.35
Rt349 vss vss__p14 1170.33
Rt350 vss vss__p15 3199.3
Rt351 vss vss__p16 1556.9
Rt352 vss vss__p17 1667.13
Rt353 vss vss__p18 1229.58
Rt354 vss vss__p19 26483.9
Rt355 vss vss__p2 149.37
Rt356 vss vss__p20 129650
Rt357 vss vss__p22 2
Rt358 vss vss__p23 2
Rt359 vss vss__p24 2
Rt360 vss vss__p25 2
Rt361 vss vss__p26 2
Rt362 vss vss__p27 2
Rt363 vss vss__p28 2
Rt364 vss vss__p29 2
Rt365 vss vss__p3 87.4318
Rt366 vss vss__p4 1084.27
Rt367 vss vss__p5 1343.02
Rt368 vss vss__p6 1766.07
Rt369 vss vss__p7 38.6999
Rt370 vss vss__p8 42.1829
Rt371 vss vss__p9 2117.8
Rt372 vss__p0 vss__p1 169.316
Rt373 vss__p0 vss__p10 31184.1
Rt374 vss__p0 vss__p11 36612.3
Rt375 vss__p0 vss__p12 39927.1
Rt376 vss__p0 vss__p13 39904.8
Rt377 vss__p0 vss__p14 13918.6
Rt378 vss__p0 vss__p15 38048.9
Rt379 vss__p0 vss__p16 18516.1
Rt380 vss__p0 vss__p17 19827
Rt381 vss__p0 vss__p18 14623.3
Rt382 vss__p0 vss__p19 314970
Rt383 vss__p0 vss__p2 6580.14
Rt384 vss__p0 vss__p3 3851.61
Rt385 vss__p0 vss__p4 488.778
Rt386 vss__p0 vss__p5 605.415
Rt387 vss__p0 vss__p6 796.124
Rt388 vss__p0 vss__p7 457.414
Rt389 vss__p0 vss__p8 502.088
Rt390 vss__p0 vss__p9 25186.8
Rt391 vss__p1 vss__p10 332589
Rt392 vss__p1 vss__p11 390483
Rt393 vss__p1 vss__p12 425836
Rt394 vss__p1 vss__p13 425598
Rt395 vss__p1 vss__p14 148446
Rt396 vss__p1 vss__p15 405804
Rt397 vss__p1 vss__p16 197480
Rt398 vss__p1 vss__p17 211462
Rt399 vss__p1 vss__p18 155962
Rt400 vss__p1 vss__p2 70179.4
Rt401 vss__p1 vss__p3 41078.7
Rt402 vss__p1 vss__p4 340.819
Rt403 vss__p1 vss__p5 422.149
Rt404 vss__p1 vss__p6 555.127
Rt405 vss__p1 vss__p7 4878.47
Rt406 vss__p1 vss__p8 5354.93
Rt407 vss__p1 vss__p9 268625
Rt408 vss__p10 vss__p11 113.995
Rt409 vss__p10 vss__p12 144.689
Rt410 vss__p10 vss__p13 176.071
Rt411 vss__p10 vss__p14 408.694
Rt412 vss__p10 vss__p15 253.751
Rt413 vss__p10 vss__p16 649.189
Rt414 vss__p10 vss__p17 695.151
Rt415 vss__p10 vss__p18 512.703
Rt416 vss__p10 vss__p19 11043.1
Rt417 vss__p10 vss__p2 474595
Rt418 vss__p10 vss__p20 54060.7
Rt419 vss__p10 vss__p3 277799
Rt420 vss__p10 vss__p4 960109
Rt421 vss__p10 vss__p7 12001.6
Rt422 vss__p10 vss__p8 14632.1
Rt423 vss__p10 vss__p9 98.8087
Rt424 vss__p11 vss__p12 120.587
Rt425 vss__p11 vss__p13 147.348
Rt426 vss__p11 vss__p14 393.479
Rt427 vss__p11 vss__p15 214.897
Rt428 vss__p11 vss__p16 647.256
Rt429 vss__p11 vss__p17 693.082
Rt430 vss__p11 vss__p18 511.177
Rt431 vss__p11 vss__p19 11010.2
Rt432 vss__p11 vss__p2 557208
Rt433 vss__p11 vss__p20 53899.7
Rt434 vss__p11 vss__p3 326155
Rt435 vss__p11 vss__p7 14090.7
Rt436 vss__p11 vss__p8 17179.1
Rt437 vss__p11 vss__p9 128.482
Rt438 vss__p12 vss__p13 117.474
Rt439 vss__p12 vss__p14 348.719
Rt440 vss__p12 vss__p15 172.707
Rt441 vss__p12 vss__p16 591.593
Rt442 vss__p12 vss__p17 633.478
Rt443 vss__p12 vss__p18 467.216
Rt444 vss__p12 vss__p19 10063.4
Rt445 vss__p12 vss__p2 607656
Rt446 vss__p12 vss__p20 49264.4
Rt447 vss__p12 vss__p3 355684
Rt448 vss__p12 vss__p7 15366.5
Rt449 vss__p12 vss__p8 18734.4
Rt450 vss__p12 vss__p9 162.494
Rt451 vss__p13 vss__p14 289.411
Rt452 vss__p13 vss__p15 134.139
Rt453 vss__p13 vss__p16 502.56
Rt454 vss__p13 vss__p17 538.142
Rt455 vss__p13 vss__p18 396.902
Rt456 vss__p13 vss__p19 8548.87
Rt457 vss__p13 vss__p2 607316
Rt458 vss__p13 vss__p20 41850.3
Rt459 vss__p13 vss__p3 355485
Rt460 vss__p13 vss__p7 15357.9
Rt461 vss__p13 vss__p8 18724
Rt462 vss__p13 vss__p9 196.648
Rt463 vss__p14 vss__p15 229.556
Rt464 vss__p14 vss__p16 219.065
Rt465 vss__p14 vss__p17 234.575
Rt466 vss__p14 vss__p18 173.009
Rt467 vss__p14 vss__p19 3726.44
Rt468 vss__p14 vss__p2 211828
Rt469 vss__p14 vss__p20 18242.5
Rt470 vss__p14 vss__p3 123991
Rt471 vss__p14 vss__p4 428530
Rt472 vss__p14 vss__p5 530790
Rt473 vss__p14 vss__p6 697992
Rt474 vss__p14 vss__p7 5356.74
Rt475 vss__p14 vss__p8 6530.81
Rt476 vss__p14 vss__p9 388.704
Rt477 vss__p15 vss__p16 345.898
Rt478 vss__p15 vss__p17 370.388
Rt479 vss__p15 vss__p18 273.176
Rt480 vss__p15 vss__p19 5883.95
Rt481 vss__p15 vss__p2 579071
Rt482 vss__p15 vss__p20 28804.4
Rt483 vss__p15 vss__p3 338952
Rt484 vss__p15 vss__p7 14643.6
Rt485 vss__p15 vss__p8 17853.2
Rt486 vss__p15 vss__p9 279.007
Rt487 vss__p16 vss__p17 49.2262
Rt488 vss__p16 vss__p18 36.3064
Rt489 vss__p16 vss__p19 782.002
Rt490 vss__p16 vss__p2 281799
Rt491 vss__p16 vss__p20 3828.23
Rt492 vss__p16 vss__p3 164948
Rt493 vss__p16 vss__p4 570080
Rt494 vss__p16 vss__p5 706119
Rt495 vss__p16 vss__p6 928550
Rt496 vss__p16 vss__p7 7126.16
Rt497 vss__p16 vss__p8 8688.05
Rt498 vss__p16 vss__p9 597.195
Rt499 vss__p17 vss__p18 34.5239
Rt500 vss__p17 vss__p19 743.61
Rt501 vss__p17 vss__p2 301750
Rt502 vss__p17 vss__p20 3640.29
Rt503 vss__p17 vss__p3 176626
Rt504 vss__p17 vss__p4 610442
Rt505 vss__p17 vss__p5 756112
Rt506 vss__p17 vss__p6 994291
Rt507 vss__p17 vss__p7 7630.69
Rt508 vss__p17 vss__p8 9303.16
Rt509 vss__p17 vss__p9 639.476
Rt510 vss__p18 vss__p19 0.666486
Rt511 vss__p18 vss__p2 222553
Rt512 vss__p18 vss__p20 3.26273
Rt513 vss__p18 vss__p3 130269
Rt514 vss__p18 vss__p4 450226
Rt515 vss__p18 vss__p5 557664
Rt516 vss__p18 vss__p6 733331
Rt517 vss__p18 vss__p7 5627.95
Rt518 vss__p18 vss__p8 6861.47
Rt519 vss__p18 vss__p9 471.64
Rt520 vss__p19 vss__p20 0.970962
Rt521 vss__p19 vss__p7 121220
Rt522 vss__p19 vss__p8 147789
Rt523 vss__p19 vss__p9 10158.7
Rt524 vss__p2 vss__p3 63.5288
Rt525 vss__p2 vss__p4 202592
Rt526 vss__p2 vss__p5 250937
Rt527 vss__p2 vss__p6 329983
Rt528 vss__p2 vss__p7 6657.77
Rt529 vss__p2 vss__p8 7726.5
Rt530 vss__p2 vss__p9 383321
Rt531 vss__p20 vss__p7 593425
Rt532 vss__p20 vss__p8 723490
Rt533 vss__p20 vss__p9 49730.9
Rt534 vss__p3 vss__p4 118585
Rt535 vss__p3 vss__p5 146883
Rt536 vss__p3 vss__p6 193152
Rt537 vss__p3 vss__p7 3897.05
Rt538 vss__p3 vss__p8 4522.62
Rt539 vss__p3 vss__p9 224372
Rt540 vss__p4 vss__p5 99.626
Rt541 vss__p4 vss__p6 131.009
Rt542 vss__p4 vss__p7 14083
Rt543 vss__p4 vss__p8 15458.5
Rt544 vss__p4 vss__p9 775460
Rt545 vss__p5 vss__p6 57.9372
Rt546 vss__p5 vss__p7 17443.7
Rt547 vss__p5 vss__p8 19147.3
Rt548 vss__p5 vss__p9 960509
Rt549 vss__p6 vss__p7 22938.5
Rt550 vss__p6 vss__p8 25178.8
Rt551 vss__p7 vss__p8 223.379
Rt552 vss__p7 vss__p9 9693.46
Rt553 vss__p8 vss__p9 11818
Rt554 xckg_d0 xckg_d0__p1 206.411
Rt555 xckg_d0 xckg_d0__p2 50.6383
Rt556 xckg_d0__p1 xckg_d0__p2 40.5376
Rt557 xckg_d1 xckg_d1__p1 176.827
Rt558 xckg_d1 xckg_d1__p2 53.6164
Rt559 xckg_d1__p1 xckg_d1__p2 42.2433
Rt560 xckg_d2 xckg_d2__p1 98.5076
Rt561 xckg_d2 xckg_d2__p2 97.0379
Rt562 xckg_d2__p1 xckg_d2__p2 76.6587
Rt563 xckg_d3 xckg_d3__p1 99.3636
Rt564 xckg_d3 xckg_d3__p2 100.408
Rt565 xckg_d3__p1 xckg_d3__p2 78.0493
Rt566 xckg_nn xckg_nn__p1 46.1928
Rt567 xckg_x xckg_x__p1 68.4444
Rt568 xckg_x xckg_x__p2 147.088
Rt569 xckg_x xckg_x__p3 1240.78
Rt570 xckg_x xckg_x__p4 614.493
Rt571 xckg_x__p1 xckg_x__p2 97.458
Rt572 xckg_x__p1 xckg_x__p3 822.123
Rt573 xckg_x__p1 xckg_x__p4 407.153
Rt574 xckg_x__p2 xckg_x__p3 124.848
Rt575 xckg_x__p2 xckg_x__p4 61.8301
Rt576 xckg_x__p3 xckg_x__p4 33.2764
Rt577 xref_na xref_na__p1 77.984
Rt578 xref_ng xref_ng__p1 1225.95
Rt579 xref_ng xref_ng__p2 132.884
Rt580 xref_ng__p1 xref_ng__p2 31.5508
Rt581 xref_ntl xref_ntl__p1 60.2546
Rt582 xref_ntl__p1 xref_ntl__p2 19.318
Cq0 ain_cos_n ain_cos_p 2.707e-14
Cq1 ain_cos_n ain_isa_n 3.593e-17
Cq2 ain_cos_n ain_isa_p 4.589e-17
Cq3 ain_cos_n ibias 1.098e-16
Cq4 ain_cos_n vdd 7.405e-16
Cq5 ain_cos_n vss 3.272e-14
Cq6 ain_cos_n xckg_d0 9.755e-19
Cq7 ain_cos_n xckg_d1 9.755e-19
Cq8 ain_cos_n xckg_d2 9.755e-19
Cq9 ain_cos_n xckg_d3 1.006e-18
Cq10 ain_cos_n xckg_x 5.633e-18
Cq11 ain_cos_p ain_isa_n 3.579e-17
Cq12 ain_cos_p ain_isa_p 4.832e-17
Cq13 ain_cos_p ibias 6.162e-17
Cq14 ain_cos_p vdd 1.923e-15
Cq15 ain_cos_p vss 3.653e-14
Cq16 ain_isa_n ain_isa_p 2.783e-14
Cq17 ain_isa_n ain_isb_n 6.95e-17
Cq18 ain_isa_n ain_isb_p 6.95e-17
Cq19 ain_isa_n vdd 1.357e-15
Cq20 ain_isa_n vss 3.109e-14
Cq21 ain_isa_p ain_isb_n 8.473e-17
Cq22 ain_isa_p ain_isb_p 8.473e-17
Cq23 ain_isa_p vdd 1.764e-15
Cq24 ain_isa_p vss 3.146e-14
Cq25 ain_isb_n ain_isb_p 7.431e-17
Cq26 ain_isb_n vss 7.586e-16
Cq27 ain_isb_p vss 7.532e-16
Cq28 ain_sin_n ain_sin_p 8.625e-17
Cq29 ain_sin_n ibias 7.283e-17
Cq30 ain_sin_n vss 1.026e-15
Cq31 ain_sin_p ibias 7.607e-17
Cq32 ain_sin_p vss 9.168e-16
Cq33 clk mclkb 2.216e-18
Cq34 clk sar_mclk 1.431e-16
Cq35 clk vdd 4.256e-16
Cq36 clk vss 1.851e-14
Cq37 clk xckg_d0 2.205e-16
Cq38 clk xckg_d1 1.236e-16
Cq39 clk xckg_d2 1.227e-16
Cq40 clk xckg_d3 1.663e-16
Cq41 clk xckg_nn 2.534e-17
Cq42 clk xckg_x 1.452e-16
Cq43 ibias vbn 2.266e-15
Cq44 ibias vbp 6.102e-17
Cq45 ibias vdd 4.481e-15
Cq46 ibias vdda 2.216e-16
Cq47 ibias vref 4.109e-14
Cq48 ibias vref_in 9.277e-15
Cq49 ibias vrefl 1.686e-14
Cq50 ibias vss 1.742e-13
Cq51 ibias xref_ng 2.101e-15
Cq52 ibias xref_ntl 1.737e-16
Cq53 mclkb sar_mclk 2.613e-16
Cq54 mclkb vdd 3.878e-16
Cq55 mclkb vss 1.226e-15
Cq56 mclkb xckg_d0 5.591e-17
Cq57 mclkb xckg_d1 3.991e-15
Cq58 mclkb xckg_d2 3.955e-15
Cq59 mclkb xckg_d3 6.865e-17
Cq60 mclkb xckg_nn 1.864e-17
Cq61 mclkb xckg_x 9.569e-17
Cq62 sar_mclk vdd 1.621e-15
Cq63 sar_mclk vss 6.739e-15
Cq64 sar_mclk xckg_d0 4.707e-15
Cq65 sar_mclk xckg_d1 2.058e-16
Cq66 sar_mclk xckg_d2 7.519e-17
Cq67 sar_mclk xckg_d3 9.271e-17
Cq68 sar_mclk xckg_nn 4.141e-16
Cq69 sar_mclk xckg_x 1.044e-15
Cq70 vbn vbp 2.899e-14
Cq71 vbn vdd 2.028e-15
Cq72 vbn vdda 5.091e-17
Cq73 vbn vref 1.786e-14
Cq74 vbn vref_in 4.127e-15
Cq75 vbn vrefl 2.512e-14
Cq76 vbn vss 1.155e-14
Cq77 vbn xref_na 7.746e-19
Cq78 vbn xref_ng 1.886e-15
Cq79 vbp vdd 1.803e-15
Cq80 vbp vdda 8.761e-15
Cq81 vbp vref 1.878e-14
Cq82 vbp vref_in 4.205e-15
Cq83 vbp vrefl 1.08e-14
Cq84 vbp vss 1.857e-14
Cq85 vbp xref_na 9.789e-18
Cq86 vbp xref_ng 2.371e-15
Cq87 vdd vdda 5.954e-16
Cq88 vdd vref 1.719e-13
Cq89 vdd vref_in 4.013e-14
Cq90 vdd vrefl 5.736e-14
Cq91 vdd vss 9.509e-14
Cq92 vdd xckg_d0 5.453e-16
Cq93 vdd xckg_d1 3.963e-16
Cq94 vdd xckg_d2 2.615e-16
Cq95 vdd xckg_d3 3.642e-16
Cq96 vdd xckg_x 1.101e-15
Cq97 vdd xref_ng 1.71e-14
Cq98 vdda vref 4.398e-14
Cq99 vdda vref_in 3.223e-16
Cq100 vdda vrefl 2.519e-14
Cq101 vdda vss 3.507e-14
Cq102 vdda xref_na 1.249e-15
Cq103 vdda xref_ng 2.299e-14
Cq104 vdda xref_ntl 9.96e-18
Cq105 vref vref_in 4.54e-14
Cq106 vref vrefl 1.648e-13
Cq107 vref vss 3.746e-13
Cq108 vref xref_na 1.322e-16
Cq109 vref xref_ng 4.971e-14
Cq110 vref xref_ntl 1.685e-15
Cq111 vref_in vrefl 3.08e-14
Cq112 vref_in vss 9.461e-14
Cq113 vref_in xref_na 4.042e-16
Cq114 vref_in xref_ng 3.421e-15
Cq115 vref_in xref_ntl 1.606e-15
Cq116 vrefl vss 1.912e-13
Cq117 vrefl xref_na 1.039e-16
Cq118 vrefl xref_ng 3.178e-14
Cq119 vrefl xref_ntl 2.185e-15
Cq120 vss xckg_d0 4.966e-15
Cq121 vss xckg_d1 4.102e-15
Cq122 vss xckg_d2 4.829e-15
Cq123 vss xckg_d3 5.853e-15
Cq124 vss xckg_nn 1.117e-15
Cq125 vss xckg_x 1.086e-14
Cq126 vss xref_na 4.437e-15
Cq127 vss xref_ng 8.811e-14
Cq128 vss xref_ntl 3.71e-15
Cq129 xckg_d0 xckg_d1 8.434e-15
Cq130 xckg_d0 xckg_d2 2.37e-16
Cq131 xckg_d0 xckg_d3 1.818e-16
Cq132 xckg_d0 xckg_nn 2.011e-17
Cq133 xckg_d0 xckg_x 6.919e-16
Cq134 xckg_d1 xckg_d2 2.001e-15
Cq135 xckg_d1 xckg_d3 1.378e-16
Cq136 xckg_d1 xckg_nn 5.907e-16
Cq137 xckg_d1 xckg_x 4.219e-16
Cq138 xckg_d2 xckg_d3 8.547e-15
Cq139 xckg_d2 xckg_nn 5.574e-16
Cq140 xckg_d2 xckg_x 4.153e-16
Cq141 xckg_d3 xckg_nn 3.667e-17
Cq142 xckg_d3 xckg_x 5.111e-15
Cq143 xckg_nn xckg_x 1.118e-16
Cq144 xref_na xref_ng 2.554e-15
Cq145 xref_na xref_ntl 2.584e-16
Cq146 xref_ng xref_ntl 2.12e-15
.ends
