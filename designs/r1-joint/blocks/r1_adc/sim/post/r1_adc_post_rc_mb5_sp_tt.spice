* r1_adc_post_rc_mb5_sp_tt.spice: r1_adc_post_rc_mb5.spice with ideal slice references from op run postb5-op-tt-rc (sim/post/make_sp_netlist.py)
* merged by sim/post/merge_parallel.py from <G1_RESULTS_ROOT>/r1_adc/pex-b5/build/r1_adc_post_rc.spice (sha256 f53e48465d35499e): 726 -> 353 device instances (identical parallel devices as m = count)
* r1_adc post-layout netlist, layout B (RC), written by pex/pex_build.py; see its docstring
* devices: LVS reference of layout/r1_adc_netlist.py; R: KLayout RNetExtractor Metal1-5/Via1-4; C: kpex 0.3.12 2.5D CC
* requires cornerMOSlv/hv.lib, cornerCAP.lib, cornerRES.lib
.subckt r1_adc_slice_post in0p in0n in1p in1n trk0 trk1 cp0 cp1 cp2 cp3 cp4 cp5 cp6 cp7 cp8 cp9 cp10 cp11 cp12 cn0 cn1 cn2 cn3 cn4 cn5 cn6 cn7 cn8 cn9 cn10 cn11 cn12 clk clkb clkn clknb op on onp onn vbp vbn vref vref__p11 vref__p12 vrefl vrefl__p19 top_p top_n vdd vdd__p36 vdd__p37 vdd__p38 gnd gnd__p59 gnd__p60 gnd__p61 gnd__p62 gnd__p63 gnd__p64 gnd__p65
Xxpt0a t0b__p7 trk0__p1 vdd__p12 vdd sg13_lv_pmos w=2u l=0.13u ng=1 m=1
Xxnt0a t0b__p4 trk0__p0 gnd__p36 gnd sg13_lv_nmos w=1u l=0.13u ng=1 m=1
Xxpt0b t0__p5 t0b__p8 vdd__p13 vdd sg13_lv_pmos w=4u l=0.13u ng=1 m=1
Xxnt0b t0__p4 t0b__p5 gnd__p37 gnd sg13_lv_nmos w=2u l=0.13u ng=1 m=1
Xxpt1a t1b__p7 trk1__p1 vdd__p14 vdd sg13_lv_pmos w=2u l=0.13u ng=1 m=1
Xxnt1a t1b__p4 trk1__p0 gnd__p38 gnd sg13_lv_nmos w=1u l=0.13u ng=1 m=1
Xxpt1b t1__p5 t1b__p8 vdd__p15 vdd sg13_lv_pmos w=4u l=0.13u ng=1 m=1
Xxnt1b t1__p4 t1b__p5 gnd__p39 gnd sg13_lv_nmos w=2u l=0.13u ng=1 m=1
Xxs0p_xms in0p__p0 xs0p_g top_p__p2 gnd sg13_lv_nmos w=6u l=0.13u ng=2 m=1
Xxs0p_cboot xs0p_cbp__p2 xs0p_cbn__p4 cap_cmim w=11.49u l=11.49u m=1
Xxs0p_xm1 xs0p_cbn__p1 t0b__p2 gnd__p30 gnd sg13_lv_nmos w=1u l=0.13u ng=1 m=1
Xxs0p_xm3 xs0p_cbp xs0p_g__p4 vdd__p4 xs0p_cbp sg13_lv_pmos w=1u l=0.13u ng=1 m=1
Xxs0p_xm8 xs0p_g__p5 xs0p_x__p2 xs0p_cbp__p1 xs0p_cbp sg13_lv_pmos w=2u l=0.13u ng=1 m=1
Xxs0p_xm4 xs0p_x__p3 t0__p3 vdd__p5 vdd sg13_lv_pmos w=0.5u l=0.13u ng=1 m=1
Xxs0p_xm5 xs0p_x t0__p2 xs0p_cbn__p2 gnd sg13_lv_nmos w=1u l=0.13u ng=1 m=1
Xxs0p_xm7 xs0p_x__p1 xs0p_g__p2 xs0p_cbn__p3 gnd sg13_lv_nmos w=0.5u l=0.13u ng=1 m=1
Xxs0p_xm9 xs0p_cbn xs0p_g__p1 in0p__p1 gnd sg13_lv_nmos w=2u l=0.13u ng=1 m=1
Xxs0p_xm10 xs0p_g__p3 vdd__p3 xs0p_n10 gnd sg13_lv_nmos w=2u l=0.13u ng=1 m=1
Xxs0p_xm11 xs0p_n10__p1 t0b__p3 gnd__p31 gnd sg13_lv_nmos w=2u l=0.13u ng=1 m=1
Xxs0n_xms in0n__p0 xs0n_g top_n__p2 gnd sg13_lv_nmos w=6u l=0.13u ng=2 m=1
Xxs0n_cboot xs0n_cbp__p2 xs0n_cbn__p4 cap_cmim w=11.49u l=11.49u m=1
Xxs0n_xm1 xs0n_cbn__p1 t0b gnd__p28 gnd sg13_lv_nmos w=1u l=0.13u ng=1 m=1
Xxs0n_xm3 xs0n_cbp xs0n_g__p4 vdd__p1 xs0n_cbp sg13_lv_pmos w=1u l=0.13u ng=1 m=1
Xxs0n_xm8 xs0n_g__p5 xs0n_x__p2 xs0n_cbp__p1 xs0n_cbp sg13_lv_pmos w=2u l=0.13u ng=1 m=1
Xxs0n_xm4 xs0n_x__p3 t0__p1 vdd__p2 vdd sg13_lv_pmos w=0.5u l=0.13u ng=1 m=1
Xxs0n_xm5 xs0n_x t0 xs0n_cbn__p2 gnd sg13_lv_nmos w=1u l=0.13u ng=1 m=1
Xxs0n_xm7 xs0n_x__p1 xs0n_g__p2 xs0n_cbn__p3 gnd sg13_lv_nmos w=0.5u l=0.13u ng=1 m=1
Xxs0n_xm9 xs0n_cbn xs0n_g__p1 in0n__p1 gnd sg13_lv_nmos w=2u l=0.13u ng=1 m=1
Xxs0n_xm10 xs0n_g__p3 vdd__p0 xs0n_n10 gnd sg13_lv_nmos w=2u l=0.13u ng=1 m=1
Xxs0n_xm11 xs0n_n10__p1 t0b__p1 gnd__p29 gnd sg13_lv_nmos w=2u l=0.13u ng=1 m=1
Xxs1p_xms in1p__p0 xs1p_g top_p__p3 gnd sg13_lv_nmos w=6u l=0.13u ng=2 m=1
Xxs1p_cboot xs1p_cbp__p2 xs1p_cbn__p4 cap_cmim w=11.49u l=11.49u m=1
Xxs1p_xm1 xs1p_cbn__p1 t1b__p2 gnd__p34 gnd sg13_lv_nmos w=1u l=0.13u ng=1 m=1
Xxs1p_xm3 xs1p_cbp xs1p_g__p4 vdd__p10 xs1p_cbp sg13_lv_pmos w=1u l=0.13u ng=1 m=1
Xxs1p_xm8 xs1p_g__p5 xs1p_x__p2 xs1p_cbp__p1 xs1p_cbp sg13_lv_pmos w=2u l=0.13u ng=1 m=1
Xxs1p_xm4 xs1p_x__p3 t1__p3 vdd__p11 vdd sg13_lv_pmos w=0.5u l=0.13u ng=1 m=1
Xxs1p_xm5 xs1p_x t1__p2 xs1p_cbn__p2 gnd sg13_lv_nmos w=1u l=0.13u ng=1 m=1
Xxs1p_xm7 xs1p_x__p1 xs1p_g__p2 xs1p_cbn__p3 gnd sg13_lv_nmos w=0.5u l=0.13u ng=1 m=1
Xxs1p_xm9 xs1p_cbn xs1p_g__p1 in1p__p1 gnd sg13_lv_nmos w=2u l=0.13u ng=1 m=1
Xxs1p_xm10 xs1p_g__p3 vdd__p9 xs1p_n10 gnd sg13_lv_nmos w=2u l=0.13u ng=1 m=1
Xxs1p_xm11 xs1p_n10__p1 t1b__p3 gnd__p35 gnd sg13_lv_nmos w=2u l=0.13u ng=1 m=1
Xxs1n_xms in1n__p0 xs1n_g top_n__p3 gnd sg13_lv_nmos w=6u l=0.13u ng=2 m=1
Xxs1n_cboot xs1n_cbp__p2 xs1n_cbn__p4 cap_cmim w=11.49u l=11.49u m=1
Xxs1n_xm1 xs1n_cbn__p1 t1b gnd__p32 gnd sg13_lv_nmos w=1u l=0.13u ng=1 m=1
Xxs1n_xm3 xs1n_cbp xs1n_g__p4 vdd__p7 xs1n_cbp sg13_lv_pmos w=1u l=0.13u ng=1 m=1
Xxs1n_xm8 xs1n_g__p5 xs1n_x__p2 xs1n_cbp__p1 xs1n_cbp sg13_lv_pmos w=2u l=0.13u ng=1 m=1
Xxs1n_xm4 xs1n_x__p3 t1__p1 vdd__p8 vdd sg13_lv_pmos w=0.5u l=0.13u ng=1 m=1
Xxs1n_xm5 xs1n_x t1 xs1n_cbn__p2 gnd sg13_lv_nmos w=1u l=0.13u ng=1 m=1
Xxs1n_xm7 xs1n_x__p1 xs1n_g__p2 xs1n_cbn__p3 gnd sg13_lv_nmos w=0.5u l=0.13u ng=1 m=1
Xxs1n_xm9 xs1n_cbn xs1n_g__p1 in1n__p1 gnd sg13_lv_nmos w=2u l=0.13u ng=1 m=1
Xxs1n_xm10 xs1n_g__p3 vdd__p6 xs1n_n10 gnd sg13_lv_nmos w=2u l=0.13u ng=1 m=1
Xxs1n_xm11 xs1n_n10__p1 t1b__p1 gnd__p33 gnd sg13_lv_nmos w=2u l=0.13u ng=1 m=1
Xxpr1 rstb_n__p2 t0b__p9 vdd__p16 vdd sg13_lv_pmos w=1u l=0.13u ng=1 m=1
Xxpr2 rstb_n__p3 t1b__p9 vdd__p17 vdd sg13_lv_pmos w=1u l=0.13u ng=1 m=1
Xxnr1 rstb_n t0b__p6 nr gnd sg13_lv_nmos w=1u l=0.13u ng=1 m=1
Xxnr2 nr__p1 t1b__p6 gnd__p40 gnd sg13_lv_nmos w=1u l=0.13u ng=1 m=1
Xxpr3 rstb__p3 rstb_n__p4 vdd__p18 vdd sg13_lv_pmos w=1u l=0.13u ng=1 m=1
Xxnr3 rstb__p2 rstb_n__p1 gnd__p41 gnd sg13_lv_nmos w=0.5u l=0.13u ng=1 m=1
Xxlrp lsb_p rstb__p1 vrefl__p9 vrefl sg13_lv_pmos w=1u l=0.13u ng=1 m=1
Xxlrn lsb_n rstb vrefl__p8 vrefl sg13_lv_pmos w=1u l=0.13u ng=1 m=1
Xxdp12_xmp bp12 cp12__p0 vref__p5 vref sg13_lv_pmos w=2u l=0.13u ng=1 m=1
Xxdp12_xmn bp12__p1 cp12__p1 gnd__p13 gnd sg13_lv_nmos w=1u l=0.13u ng=1 m=1
Xxdp11_xmp bp11 cp11__p0 vref__p6 vref sg13_lv_pmos w=2u l=0.13u ng=1 m=1
Xxdp11_xmn bp11__p1 cp11__p1 gnd__p14 gnd sg13_lv_nmos w=1u l=0.13u ng=1 m=1
Xxdp10_xmp bp10 cp10__p0 vref__p7 vref sg13_lv_pmos w=2u l=0.13u ng=1 m=1
Xxdp10_xmn bp10__p1 cp10__p1 gnd__p15 gnd sg13_lv_nmos w=1u l=0.13u ng=1 m=1
Xxdp9_xmp bp9 cp9__p0 vref__p8 vref sg13_lv_pmos w=1u l=0.13u ng=1 m=1
Xxdp9_xmn bp9__p1 cp9__p1 gnd__p16 gnd sg13_lv_nmos w=0.5u l=0.13u ng=1 m=1
Xxdp8_xmp bp8 cp8__p0 vref__p9 vref sg13_lv_pmos w=1u l=0.13u ng=1 m=1
Xxdp8_xmn bp8__p1 cp8__p1 gnd__p17 gnd sg13_lv_nmos w=0.5u l=0.13u ng=1 m=1
Xxdp7_xmp bp7 cp7__p0 vrefl__p10 vrefl sg13_lv_pmos w=1u l=0.13u ng=1 m=1
Xxdp7_xmn bp7__p1 cp7__p1 gnd__p18 gnd sg13_lv_nmos w=0.5u l=0.13u ng=1 m=1
Xxdp6_xmp bp6 cp6__p0 vrefl__p11 vrefl sg13_lv_pmos w=1u l=0.13u ng=1 m=1
Xxdp6_xmn bp6__p1 cp6__p1 gnd__p19 gnd sg13_lv_nmos w=0.5u l=0.13u ng=1 m=1
Xxdp5_xmp bp5 cp5__p0 vrefl__p12 vrefl sg13_lv_pmos w=1u l=0.13u ng=1 m=1
Xxdp5_xmn bp5__p1 cp5__p1 gnd__p20 gnd sg13_lv_nmos w=0.5u l=0.13u ng=1 m=1
Xxdp4_xmp bp4 cp4__p0 vrefl__p13 vrefl sg13_lv_pmos w=1u l=0.13u ng=1 m=1
Xxdp4_xmn bp4__p1 cp4__p1 gnd__p21 gnd sg13_lv_nmos w=0.5u l=0.13u ng=1 m=1
Xxdp3_xmp bp3 cp3__p0 vrefl__p14 vrefl sg13_lv_pmos w=1u l=0.13u ng=1 m=1
Xxdp3_xmn bp3__p1 cp3__p1 gnd__p22 gnd sg13_lv_nmos w=0.5u l=0.13u ng=1 m=1
Xxdp2_xmp bp2 cp2__p0 vrefl__p15 vrefl sg13_lv_pmos w=1u l=0.13u ng=1 m=1
Xxdp2_xmn bp2__p1 cp2__p1 gnd__p23 gnd sg13_lv_nmos w=0.5u l=0.13u ng=1 m=1
Xxdp1_xmp bp1 cp1__p0 vrefl__p16 vrefl sg13_lv_pmos w=1u l=0.13u ng=1 m=1
Xxdp1_xmn bp1__p1 cp1__p1 gnd__p24 gnd sg13_lv_nmos w=0.5u l=0.13u ng=1 m=1
Xxdp0_xmp bp0 cp0__p0 vrefl__p17 vrefl sg13_lv_pmos w=1u l=0.13u ng=1 m=1
Xxdp0_xmn bp0__p1 cp0__p1 gnd__p25 gnd sg13_lv_nmos w=0.5u l=0.13u ng=1 m=1
Xxdn12_xmp bn12 cn12__p0 vref__p4 vref sg13_lv_pmos w=2u l=0.13u ng=1 m=1
Xxdn12_xmn bn12__p1 cn12__p1 gnd__p12 gnd sg13_lv_nmos w=1u l=0.13u ng=1 m=1
Xxdn11_xmp bn11 cn11__p0 vref__p3 vref sg13_lv_pmos w=2u l=0.13u ng=1 m=1
Xxdn11_xmn bn11__p1 cn11__p1 gnd__p11 gnd sg13_lv_nmos w=1u l=0.13u ng=1 m=1
Xxdn10_xmp bn10 cn10__p0 vref__p2 vref sg13_lv_pmos w=2u l=0.13u ng=1 m=1
Xxdn10_xmn bn10__p1 cn10__p1 gnd__p10 gnd sg13_lv_nmos w=1u l=0.13u ng=1 m=1
Xxdn9_xmp bn9 cn9__p0 vref__p1 vref sg13_lv_pmos w=1u l=0.13u ng=1 m=1
Xxdn9_xmn bn9__p1 cn9__p1 gnd__p9 gnd sg13_lv_nmos w=0.5u l=0.13u ng=1 m=1
Xxdn8_xmp bn8 cn8__p0 vref__p0 vref sg13_lv_pmos w=1u l=0.13u ng=1 m=1
Xxdn8_xmn bn8__p1 cn8__p1 gnd__p8 gnd sg13_lv_nmos w=0.5u l=0.13u ng=1 m=1
Xxdn7_xmp bn7 cn7__p0 vrefl__p7 vrefl sg13_lv_pmos w=1u l=0.13u ng=1 m=1
Xxdn7_xmn bn7__p1 cn7__p1 gnd__p7 gnd sg13_lv_nmos w=0.5u l=0.13u ng=1 m=1
Xxdn6_xmp bn6 cn6__p0 vrefl__p6 vrefl sg13_lv_pmos w=1u l=0.13u ng=1 m=1
Xxdn6_xmn bn6__p1 cn6__p1 gnd__p6 gnd sg13_lv_nmos w=0.5u l=0.13u ng=1 m=1
Xxdn5_xmp bn5 cn5__p0 vrefl__p5 vrefl sg13_lv_pmos w=1u l=0.13u ng=1 m=1
Xxdn5_xmn bn5__p1 cn5__p1 gnd__p5 gnd sg13_lv_nmos w=0.5u l=0.13u ng=1 m=1
Xxdn4_xmp bn4 cn4__p0 vrefl__p4 vrefl sg13_lv_pmos w=1u l=0.13u ng=1 m=1
Xxdn4_xmn bn4__p1 cn4__p1 gnd__p4 gnd sg13_lv_nmos w=0.5u l=0.13u ng=1 m=1
Xxdn3_xmp bn3 cn3__p0 vrefl__p3 vrefl sg13_lv_pmos w=1u l=0.13u ng=1 m=1
Xxdn3_xmn bn3__p1 cn3__p1 gnd__p3 gnd sg13_lv_nmos w=0.5u l=0.13u ng=1 m=1
Xxdn2_xmp bn2 cn2__p0 vrefl__p2 vrefl sg13_lv_pmos w=1u l=0.13u ng=1 m=1
Xxdn2_xmn bn2__p1 cn2__p1 gnd__p2 gnd sg13_lv_nmos w=0.5u l=0.13u ng=1 m=1
Xxdn1_xmp bn1 cn1__p0 vrefl__p1 vrefl sg13_lv_pmos w=1u l=0.13u ng=1 m=1
Xxdn1_xmn bn1__p1 cn1__p1 gnd__p1 gnd sg13_lv_nmos w=0.5u l=0.13u ng=1 m=1
Xxdn0_xmp bn0 cn0__p0 vrefl__p0 vrefl sg13_lv_pmos w=1u l=0.13u ng=1 m=1
Xxdn0_xmn bn0__p1 cn0__p1 gnd__p0 gnd sg13_lv_nmos w=0.5u l=0.13u ng=1 m=1
Xxc4_xs1_xmt1 xc4_xs1_tail0 clkb__p2 vdd__p28 vdd sg13_lv_pmos w=16u l=0.13u ng=4 m=1
Xxc4_xs1_xmtc xc4_xs1_tail__p2 vbp xc4_xs1_tail0__p1 vdd sg13_lv_pmos w=16u l=0.5u ng=4 m=1
Xxc4_xs1_xm1 xc4_dip top_p__p4 xc4_xs1_tail vdd sg13_lv_pmos w=48u l=0.3u ng=12 m=1
Xxc4_xs1_xm2 xc4_din top_n__p4 xc4_xs1_tail__p1 vdd sg13_lv_pmos w=48u l=0.3u ng=12 m=1
Xxc4_xci1 vdd__p23 xc4_dip vdd__p22 vdd sg13_lv_pmos w=80u l=4u ng=8 m=1
Xxc4_xci2 vdd__p25 xc4_din vdd__p24 vdd sg13_lv_pmos w=80u l=4u ng=8 m=1
Xxc4_xmr1 xc4_dip__p1 clkb__p0 gnd__p49 gnd sg13_lv_nmos w=20u l=0.13u ng=2 m=1
Xxc4_xmr2 xc4_din__p1 clkb__p1 gnd__p50 gnd sg13_lv_nmos w=20u l=0.13u ng=2 m=1
Xxc4_xmt2 xc4_lt clk__p0 gnd__p55 gnd sg13_lv_nmos w=4u l=0.13u ng=1 m=1
Xxc4_xmn1 op__p0 on__p0 xc4_lt__p1 gnd sg13_lv_nmos w=2u l=0.13u ng=1 m=1
Xxc4_xmn2 on__p1 op__p1 xc4_lt__p2 gnd sg13_lv_nmos w=2u l=0.13u ng=1 m=1
Xxc4_xmp1 op__p4 on__p4 vdd__p31 vdd sg13_lv_pmos w=2u l=0.13u ng=1 m=1
Xxc4_xmp2 on__p5 op__p5 vdd__p32 vdd sg13_lv_pmos w=2u l=0.13u ng=1 m=1
Xxc4_xmh1 op__p3 xc4_dip__p2 vdd__p29 vdd sg13_lv_pmos w=8u l=0.13u ng=2 m=1
Xxc4_xmh2 on__p3 xc4_din__p2 vdd__p30 vdd sg13_lv_pmos w=8u l=0.13u ng=2 m=1
Xxc4_xbp1 xc4_outpb__p1 op__p6 vdd__p33 vdd sg13_lv_pmos w=1u l=0.13u ng=1 m=1
Xxc4_xbn1 xc4_outpb op__p2 gnd__p56 gnd sg13_lv_nmos w=0.5u l=0.13u ng=1 m=1
Xxc4_xbp2 xc4_outnb__p1 on__p6 vdd__p34 vdd sg13_lv_pmos w=1u l=0.13u ng=1 m=1
Xxc4_xbn2 xc4_outnb on__p2 gnd__p57 gnd sg13_lv_nmos w=0.5u l=0.13u ng=1 m=1
Xxc5_xs1_xmt1 xc5_xs1_tail0 clkn__p2 gnd__p46 gnd sg13_lv_nmos w=8u l=0.13u ng=2 m=1
Xxc5_xs1_xmtc xc5_xs1_tail vbn xc5_xs1_tail0__p1 gnd sg13_lv_nmos w=4u l=0.5u ng=1 m=1
Xxc5_xs1_xm1 xc5_dip__p2 top_p xc5_xs1_tail__p1 gnd sg13_lv_nmos w=16u l=0.5u ng=4 m=1
Xxc5_xs1_xm2 xc5_din__p2 top_n xc5_xs1_tail__p2 gnd sg13_lv_nmos w=16u l=0.5u ng=4 m=1
Xxc5_xci1 gnd__p43 xc5_dip gnd__p42 gnd sg13_lv_nmos w=30u l=4u ng=4 m=1
Xxc5_xci2 gnd__p45 xc5_din gnd__p44 gnd sg13_lv_nmos w=30u l=4u ng=4 m=1
Xxc5_xmr1 xc5_dip clkn__p0 vdd__p19 vdd sg13_lv_pmos w=16u l=0.13u ng=2 m=1
Xxc5_xmr2 xc5_din clkn__p1 vdd__p20 vdd sg13_lv_pmos w=16u l=0.13u ng=2 m=1
Xxc5_xmt2 xc5_lt clknb__p0 vdd__p21 vdd sg13_lv_pmos w=8u l=0.13u ng=1 m=1
Xxc5_xmp1 onp__p4 onn__p4 xc5_lt__p1 vdd sg13_lv_pmos w=4u l=0.13u ng=1 m=1
Xxc5_xmp2 onn__p5 onp__p5 xc5_lt__p2 vdd sg13_lv_pmos w=4u l=0.13u ng=1 m=1
Xxc5_xmn1 onp__p1 onn__p1 gnd__p51 gnd sg13_lv_nmos w=1u l=0.13u ng=1 m=1
Xxc5_xmn2 onn__p2 onp__p2 gnd__p52 gnd sg13_lv_nmos w=1u l=0.13u ng=1 m=1
Xxc5_xmh1 onp__p0 xc5_dip__p1 gnd__p47 gnd sg13_lv_nmos w=8u l=0.13u ng=1 m=1
Xxc5_xmh2 onn__p0 xc5_din__p1 gnd__p48 gnd sg13_lv_nmos w=8u l=0.13u ng=1 m=1
Xxc5_xbp1 xc5_outpb__p1 onp__p6 vdd__p26 vdd sg13_lv_pmos w=1u l=0.13u ng=1 m=1
Xxc5_xbn1 xc5_outpb onp__p3 gnd__p53 gnd sg13_lv_nmos w=0.5u l=0.13u ng=1 m=1
Xxc5_xbp2 xc5_outnb__p1 onn__p6 vdd__p27 vdd sg13_lv_pmos w=1u l=0.13u ng=1 m=1
Xxc5_xbn2 xc5_outnb onn__p3 gnd__p54 gnd sg13_lv_nmos w=0.5u l=0.13u ng=1 m=1
Xxdacp_xc12_u0 top_p__p1 bp12__p2 cap_cmim w=3.78u l=3.78u m=16
Xxdacp_xc11_u0 top_p__p1 bp11__p2 cap_cmim w=3.78u l=3.78u m=8
Xxdacp_xc10_u0 top_p__p1 bp10__p2 cap_cmim w=3.78u l=3.78u m=4
Xxdacp_xc9_u0 top_p__p1 bp9__p2 cap_cmim w=3.78u l=3.78u m=2
Xxdacp_xc8_u0 top_p__p1 bp8__p2 cap_cmim w=3.78u l=3.78u m=1
Xxdacp_xcb top_p__p1 lsb_p__p1 cap_cmim w=4.23u l=4.23u m=1
Xxdacp_xc7_u0 lsb_p__p1 bp7__p2 cap_cmim w=3.78u l=3.78u m=64
Xxdacp_xc6_u0 lsb_p__p1 bp6__p2 cap_cmim w=3.78u l=3.78u m=32
Xxdacp_xc5_u0 lsb_p__p1 bp5__p2 cap_cmim w=3.78u l=3.78u m=16
Xxdacp_xc4_u0 lsb_p__p1 bp4__p2 cap_cmim w=3.78u l=3.78u m=8
Xxdacp_xc3_u0 lsb_p__p1 bp3__p2 cap_cmim w=3.78u l=3.78u m=4
Xxdacp_xc2_u0 lsb_p__p1 bp2__p2 cap_cmim w=3.78u l=3.78u m=2
Xxdacp_xc1_u0 lsb_p__p1 bp1__p2 cap_cmim w=3.78u l=3.78u m=1
Xxdacp_xc0 lsb_p__p1 bp0__p2 cap_cmim w=2.67u l=2.67u m=1
Xxdacn_xc12_u0 top_n__p1 bn12__p2 cap_cmim w=3.78u l=3.78u m=16
Xxdacn_xc11_u0 top_n__p1 bn11__p2 cap_cmim w=3.78u l=3.78u m=8
Xxdacn_xc10_u0 top_n__p1 bn10__p2 cap_cmim w=3.78u l=3.78u m=4
Xxdacn_xc9_u0 top_n__p1 bn9__p2 cap_cmim w=3.78u l=3.78u m=2
Xxdacn_xc8_u0 top_n__p1 bn8__p2 cap_cmim w=3.78u l=3.78u m=1
Xxdacn_xcb top_n__p1 lsb_n__p1 cap_cmim w=4.23u l=4.23u m=1
Xxdacn_xc7_u0 lsb_n__p1 bn7__p2 cap_cmim w=3.78u l=3.78u m=64
Xxdacn_xc6_u0 lsb_n__p1 bn6__p2 cap_cmim w=3.78u l=3.78u m=32
Xxdacn_xc5_u0 lsb_n__p1 bn5__p2 cap_cmim w=3.78u l=3.78u m=16
Xxdacn_xc4_u0 lsb_n__p1 bn4__p2 cap_cmim w=3.78u l=3.78u m=8
Xxdacn_xc3_u0 lsb_n__p1 bn3__p2 cap_cmim w=3.78u l=3.78u m=4
Xxdacn_xc2_u0 lsb_n__p1 bn2__p2 cap_cmim w=3.78u l=3.78u m=2
Xxdacn_xc1_u0 lsb_n__p1 bn1__p2 cap_cmim w=3.78u l=3.78u m=1
Xxdacn_xc0 lsb_n__p1 bn0__p2 cap_cmim w=2.67u l=2.67u m=1
Xxdmy_u0 gnd__p27 gnd__p27 cap_cmim w=3.78u l=3.78u m=82
Cld_xc4_outpb xc4_outpb gnd 3f
Cld_xc4_outnb xc4_outnb gnd 3f
Cld_xc5_outpb xc5_outpb gnd 3f
Cld_xc5_outnb xc5_outnb gnd 3f
Rw0 bn0 bn0__p1 30.5072
Rw1 bn0 bn0__p2 26.3744
Rw2 bn0__p1 bn0__p2 32.1711
Rw3 bn1 bn1__p1 30.9128
Rw4 bn1 bn1__p2 26.3943
Rw5 bn1__p1 bn1__p2 31.4474
Rw6 bn10 bn10__p1 39.3432
Rw7 bn10 bn10__p2 18.5632
Rw8 bn11 bn11__p1 70.36
Rw9 bn11 bn11__p2 21.1297
Rw10 bn11__p1 bn11__p2 70.2299
Rw11 bn12 bn12__p1 70.5049
Rw12 bn12 bn12__p2 21.1428
Rw13 bn12__p1 bn12__p2 70.5049
Rw14 bn2 bn2__p1 19.8494
Rw15 bn2 bn2__p2 18.7725
Rw16 bn2__p1 bn2__p2 10547.3
Rw17 bn3 bn3__p1 31.7277
Rw18 bn3 bn3__p2 26.1343
Rw19 bn3__p1 bn3__p2 32.3351
Rw20 bn4 bn4__p1 31.7277
Rw21 bn4 bn4__p2 26.1343
Rw22 bn4__p1 bn4__p2 32.3351
Rw23 bn5 bn5__p1 30.9128
Rw24 bn5 bn5__p2 26.3943
Rw25 bn5__p1 bn5__p2 31.4474
Rw26 bn6 bn6__p1 30.9128
Rw27 bn6 bn6__p2 26.3943
Rw28 bn6__p1 bn6__p2 31.4474
Rw29 bn7 bn7__p1 19.8494
Rw30 bn7 bn7__p2 18.7725
Rw31 bn7__p1 bn7__p2 10547.3
Rw32 bn8 bn8__p2 18.5632
Rw33 bn8__p1 bn8__p2 21.7312
Rw34 bn9 bn9__p1 69.7478
Rw35 bn9 bn9__p2 21.3604
Rw36 bn9__p1 bn9__p2 70.9542
Rw37 bp0 bp0__p1 73.63
Rw38 bp0 bp0__p2 21.2102
Rw39 bp0__p1 bp0__p2 75.0396
Rw40 bp1 bp1__p1 72.925
Rw41 bp1 bp1__p2 21.22
Rw42 bp1__p1 bp1__p2 74.1863
Rw43 bp10 bp10__p1 69.9965
Rw44 bp10 bp10__p2 21.3762
Rw45 bp10__p1 bp10__p2 71.0665
Rw46 bp11 bp11__p1 71.7074
Rw47 bp11 bp11__p2 21.0897
Rw48 bp11__p1 bp11__p2 71.7074
Rw49 bp12 bp12__p1 70.3916
Rw50 bp12 bp12__p2 21.1283
Rw51 bp12__p1 bp12__p2 70.2615
Rw52 bp2 bp2__p1 41.0573
Rw53 bp2 bp2__p2 18.7553
Rw54 bp2__p1 bp2__p2 21816.3
Rw55 bp3 bp3__p2 18.9152
Rw56 bp3__p1 bp3__p2 23.9792
Rw57 bp4 bp4__p1 73.383
Rw58 bp4 bp4__p2 21.2009
Rw59 bp4__p1 bp4__p2 74.6523
Rw60 bp5 bp5__p1 72.925
Rw61 bp5 bp5__p2 21.22
Rw62 bp5__p1 bp5__p2 74.1863
Rw63 bp6 bp6__p1 108.594
Rw64 bp6 bp6__p2 20.2787
Rw65 bp6__p1 bp6__p2 110.674
Rw66 bp7 bp7__p2 18.545
Rw67 bp7__p1 bp7__p2 41.541
Rw68 bp8 bp8__p1 70.5278
Rw69 bp8 bp8__p2 21.3441
Rw70 bp8__p1 bp8__p2 71.8781
Rw71 bp9 bp9__p1 69.7478
Rw72 bp9 bp9__p2 21.3604
Rw73 bp9__p1 bp9__p2 70.9542
Rw74 clk clk__p0 27.4239
Rw75 clkb clkb__p0 213.908
Rw76 clkb clkb__p2 84.0974
Rw77 clkb__p0 clkb__p1 0.72754
Rw78 clkb__p0 clkb__p2 84.3101
Rw79 clkn clkn__p0 310.297
Rw80 clkn clkn__p1 1895.19
Rw81 clkn clkn__p2 61.1134
Rw82 clkn__p0 clkn__p1 0.756716
Rw83 clkn__p0 clkn__p2 67.1965
Rw84 clkn__p1 clkn__p2 410.413
Rw85 clknb clknb__p0 33.078
Rw86 cn0 cn0__p0 119.277
Rw87 cn0 cn0__p1 125.794
Rw88 cn0__p0 cn0__p1 21.3175
Rw89 cn1 cn1__p0 113.211
Rw90 cn1 cn1__p1 128.382
Rw91 cn1__p0 cn1__p1 21.3517
Rw92 cn10 cn10__p0 47.8805
Rw93 cn10 cn10__p1 8917.65
Rw94 cn10__p0 cn10__p1 39.4941
Rw95 cn11 cn11__p0 174.29
Rw96 cn11 cn11__p1 206.251
Rw97 cn11__p0 cn11__p1 43.8732
Rw98 cn12 cn12__p0 111.59
Rw99 cn12 cn12__p1 356.14
Rw100 cn12__p0 cn12__p1 42.8693
Rw101 cn2 cn2__p0 85.617
Rw102 cn2 cn2__p1 266.479
Rw103 cn2__p0 cn2__p1 43.088
Rw104 cn3 cn3__p0 91.4068
Rw105 cn3 cn3__p1 265.781
Rw106 cn3__p0 cn3__p1 43.3698
Rw107 cn4 cn4__p0 92.8188
Rw108 cn4 cn4__p1 270.814
Rw109 cn4__p0 cn4__p1 43.2342
Rw110 cn5 cn5__p0 122.421
Rw111 cn5 cn5__p1 138.826
Rw112 cn5__p0 cn5__p1 21.2107
Rw113 cn6 cn6__p0 124.801
Rw114 cn6 cn6__p1 136.523
Rw115 cn6__p0 cn6__p1 21.2102
Rw116 cn7 cn7__p0 119.301
Rw117 cn7 cn7__p1 135.288
Rw118 cn7__p0 cn7__p1 21.2559
Rw119 cn8 cn8__p0 46.7307
Rw120 cn8 cn8__p1 5314.82
Rw121 cn8__p0 cn8__p1 39.4627
Rw122 cn9 cn9__p0 45.866
Rw123 cn9__p0 cn9__p1 39.2019
Rw124 cp0 cp0__p0 81.2006
Rw125 cp0 cp0__p1 259.208
Rw126 cp0__p0 cp0__p1 46.2941
Rw127 cp1 cp1__p0 114.46
Rw128 cp1 cp1__p1 121.333
Rw129 cp1__p0 cp1__p1 49.7821
Rw130 cp10 cp10__p0 48.858
Rw131 cp10 cp10__p1 4993.67
Rw132 cp10__p0 cp10__p1 21.7666
Rw133 cp11 cp11__p0 87.0417
Rw134 cp11 cp11__p1 269.796
Rw135 cp11__p0 cp11__p1 44.1261
Rw136 cp12 cp12__p0 149.483
Rw137 cp12 cp12__p1 189.669
Rw138 cp12__p0 cp12__p1 23.1332
Rw139 cp2 cp2__p0 82.7894
Rw140 cp2 cp2__p1 277.319
Rw141 cp2__p0 cp2__p1 45.9522
Rw142 cp3 cp3__p0 105.689
Rw143 cp3 cp3__p1 362.826
Rw144 cp3__p0 cp3__p1 44.6344
Rw145 cp4 cp4__p0 90.4239
Rw146 cp4 cp4__p1 282.53
Rw147 cp4__p0 cp4__p1 45.8369
Rw148 cp5 cp5__p0 52.2018
Rw149 cp5 cp5__p1 281.804
Rw150 cp5__p0 cp5__p1 71.3926
Rw151 cp6 cp6__p0 114.9
Rw152 cp6 cp6__p1 368.389
Rw153 cp6__p0 cp6__p1 44.667
Rw154 cp7 cp7__p0 56.827
Rw155 cp7 cp7__p1 345.623
Rw156 cp7__p0 cp7__p1 77.6698
Rw157 cp8 cp8__p0 199.362
Rw158 cp8 cp8__p1 199.018
Rw159 cp8__p0 cp8__p1 43.4388
Rw160 cp9 cp9__p0 47.9701
Rw161 cp9 cp9__p1 110867
Rw162 cp9__p0 cp9__p1 39.1818
Rw163 gnd__i8 gnd__i9 9
Rw164 gnd__i11 gnd__i12 9
Rw165 gnd__i14 gnd__i15 9
Rw166 gnd__i17 gnd__i18 9
Rw167 gnd__i23 gnd__i24 9
Rw168 gnd__i26 gnd__i27 9
Rw169 gnd__i29 gnd__i30 9
Rw170 gnd__i37 gnd__i38 9
Rw171 gnd__i40 gnd__i41 9
Rw172 gnd__i43 gnd__i44 9
Rw173 gnd__i46 gnd__i47 9
Rw174 gnd__i68 gnd__i69 9
Rw175 gnd__i71 gnd__i72 9
Rw176 gnd__i74 gnd__i75 9
Rw177 gnd__i77 gnd__i78 9
Rw178 gnd__i80 gnd__i81 9
Rw179 gnd__i88 gnd__i89 9
Rw180 gnd__i91 gnd__i92 9
Rw181 gnd__i133 gnd__i134 9
Rw182 gnd__i146 gnd__i147 9
Rw183 gnd__i149 gnd__i150 9
Rw184 gnd__i152 gnd__i153 9
Rw185 gnd__i156 gnd__i157 9
Rw186 gnd__i158 gnd__i159 9
Rw187 gnd__i161 gnd__i162 9
Rw188 gnd__i164 gnd__i165 9
Rw189 gnd__i168 gnd__i169 9
Rw190 gnd__i171 gnd__i172 9
Rw191 gnd__i174 gnd__i175 9
Rw192 gnd__i177 gnd__i178 9
Rw193 gnd__i180 gnd__i181 9
Rw194 gnd__i183 gnd__i184 9
Rw195 gnd__i186 gnd__i187 9
Rw196 gnd__i189 gnd__i190 9
Rw197 gnd__i192 gnd__i193 9
Rw198 gnd__i205 gnd__i206 9
Rw199 gnd__i224 gnd__i225 9
Rw200 gnd__i228 gnd__i229 9
Rw201 gnd__i231 gnd__i232 9
Rw202 gnd__i234 gnd__i235 9
Rw203 gnd__i237 gnd__i238 9
Rw204 gnd__i240 gnd__i241 9
Rw205 gnd__i243 gnd__i244 9
Rw206 gnd__i246 gnd__i247 9
Rw207 gnd__i249 gnd__i250 9
Rw208 gnd__i97 gnd__i66 10.7969
Rw209 gnd__i54 gnd__i53 1.32
Rw210 gnd__i55 gnd__i54 4.02769
Rw211 gnd__i58 gnd__i57 1.32
Rw212 gnd__i59 gnd__i58 2.33538
Rw213 gnd__i60 gnd__i59 3.01231
Rw214 gnd__i267 gnd__i91 0.12692
Rw215 gnd__i91 gnd__p23 0.0306538
Rw216 gnd__i267 gnd__i95 0.0444966
Rw217 gnd__i95 gnd__p23 0.0159287
Rw218 gnd__i268 gnd__i23 0.12692
Rw219 gnd__i23 gnd__p1 0.0306538
Rw220 gnd__i268 gnd__i62 0.0444966
Rw221 gnd__i62 gnd__p1 0.0159287
Rw222 gnd__i269 gnd__i26 0.12692
Rw223 gnd__i26 gnd__p2 0.0306538
Rw224 gnd__i269 gnd__i63 0.0444966
Rw225 gnd__i63 gnd__p2 0.0159287
Rw226 gnd__i270 gnd__i29 0.12692
Rw227 gnd__i29 gnd__p3 0.0306538
Rw228 gnd__i270 gnd__i64 0.0444966
Rw229 gnd__i64 gnd__p3 0.0159287
Rw230 gnd__i271 gnd__i32 0.12692
Rw231 gnd__i32 gnd__p6 0.0306538
Rw232 gnd__i271 gnd__i8 0.0444966
Rw233 gnd__i8 gnd__p6 0.0159287
Rw234 gnd__i272 gnd__i33 0.12692
Rw235 gnd__i33 gnd__p7 0.0306538
Rw236 gnd__i272 gnd__i11 0.0444966
Rw237 gnd__i11 gnd__p7 0.0159287
Rw238 gnd__i273 gnd__i34 0.12692
Rw239 gnd__i34 gnd__p8 0.0306538
Rw240 gnd__i273 gnd__i14 0.0444966
Rw241 gnd__i14 gnd__p8 0.0159287
Rw242 gnd__i274 gnd__i35 0.12692
Rw243 gnd__i35 gnd__p9 0.0306538
Rw244 gnd__i274 gnd__i17 0.0444966
Rw245 gnd__i17 gnd__p9 0.0159287
Rw246 gnd__i275 gnd__i88 0.12692
Rw247 gnd__i88 gnd__p22 0.0306538
Rw248 gnd__i275 gnd__i94 0.0444966
Rw249 gnd__i94 gnd__p22 0.0159287
Rw250 gnd__i276 gnd__i87 0.12692
Rw251 gnd__i87 gnd__p21 0.0306538
Rw252 gnd__i276 gnd__i80 0.0444966
Rw253 gnd__i80 gnd__p21 0.0159287
Rw254 gnd__i277 gnd__i86 0.12692
Rw255 gnd__i86 gnd__p20 0.0306538
Rw256 gnd__i277 gnd__i77 0.0444966
Rw257 gnd__i77 gnd__p20 0.0159287
Rw258 gnd__i278 gnd__i85 0.12692
Rw259 gnd__i85 gnd__p19 0.0306538
Rw260 gnd__i278 gnd__i74 0.0444966
Rw261 gnd__i74 gnd__p19 0.0159287
Rw262 gnd__i279 gnd__i84 0.12692
Rw263 gnd__i84 gnd__p18 0.0306538
Rw264 gnd__i279 gnd__i71 0.0444966
Rw265 gnd__i71 gnd__p18 0.0159287
Rw266 gnd__i280 gnd__i83 0.12692
Rw267 gnd__i83 gnd__p16 0.0306538
Rw268 gnd__i280 gnd__i68 0.0444966
Rw269 gnd__i68 gnd__p16 0.0159287
Rw270 gnd__i281 gnd__i49 0.12692
Rw271 gnd__i49 gnd__p10 0.0306538
Rw272 gnd__i281 gnd__i37 0.0444966
Rw273 gnd__i37 gnd__p10 0.0159287
Rw274 gnd__i282 gnd__i50 0.12692
Rw275 gnd__i50 gnd__p11 0.0306538
Rw276 gnd__i282 gnd__i40 0.0444966
Rw277 gnd__i40 gnd__p11 0.0159287
Rw278 gnd__i283 gnd__i51 0.12692
Rw279 gnd__i51 gnd__p12 0.0306538
Rw280 gnd__i283 gnd__i43 0.0444966
Rw281 gnd__i43 gnd__p12 0.0159287
Rw282 gnd__i284 gnd__i52 0.12692
Rw283 gnd__i52 gnd__p14 0.0306538
Rw284 gnd__i284 gnd__i46 0.0444966
Rw285 gnd__i46 gnd__p14 0.0159287
Rw286 gnd__i285 gnd__i133 0.737994
Rw287 gnd__i48 gnd__i121 1.10699
Rw288 gnd__i286 gnd__i224 0.0171741
Rw289 gnd__i226 gnd__i286 0.196985
Rw290 gnd__i208 gnd__i205 0.0586667
Rw291 gnd__i120 gnd__i116 0.118249
Rw292 gnd__i116 gnd__i287 0.82826
Rw293 gnd__i287 gnd__i204 0.236952
Rw294 gnd__i228 gnd__i135 0.185778
Rw295 gnd__i136 gnd__i231 0.185778
Rw296 gnd__i143 gnd__i131 0.0564431
Rw297 gnd__i144 gnd__i143 0.0874829
Rw298 gnd__i145 gnd__i149 0.0586667
Rw299 gnd gnd__i211 0.17985
Rw300 gnd__i211 gnd__p59 0.539
Rw301 gnd__i209 gnd__p60 0.6446
Rw302 gnd__p60 gnd__i210 0.6974
Rw303 gnd__i210 gnd__p61 0.02145
Rw304 gnd__p61 gnd__i288 0.19855
Rw305 gnd__i288 gnd__p62 0.58905
Rw306 gnd__p62 gnd__i252 0.09295
Rw307 gnd__i252 gnd__p63 0.6259
Rw308 gnd__p63 gnd__i250 0.2761
Rw309 gnd__i250 gnd__i251 0.022
Rw310 gnd__p64 gnd__p65 0.71885
Rw311 gnd__i289 gnd__i190 0.1925
Rw312 gnd__i289 gnd__i288 0.132
Rw313 gnd__i206 gnd__i207 0.0644678
Rw314 gnd__i207 gnd__i290 0.0683188
Rw315 gnd__i290 gnd__p26 0.193814
Rw316 gnd__i291 gnd__i150 0.201661
Rw317 gnd__i150 gnd__i151 0.0471629
Rw318 gnd__i155 gnd__p27 0.3872
Rw319 gnd__i93 gnd__p25 9
Rw320 gnd__i31 gnd__p5 9
Rw321 gnd__i96 gnd__i93 0.11
Rw322 gnd__i132 gnd__i96 9
Rw323 gnd__i105 gnd__i20 9
Rw324 gnd__i123 gnd__i20 9
Rw325 gnd__i21 gnd__i20 0.0488889
Rw326 gnd__i106 gnd__i22 9
Rw327 gnd__i124 gnd__i22 9
Rw328 gnd__i24 gnd__i22 0.0488889
Rw329 gnd__i62 gnd__i24 9
Rw330 gnd__i107 gnd__i25 9
Rw331 gnd__i27 gnd__i25 0.0488889
Rw332 gnd__i63 gnd__i27 9
Rw333 gnd__i98 gnd__i27 9
Rw334 gnd__i99 gnd__i28 9
Rw335 gnd__i108 gnd__i28 9
Rw336 gnd__i30 gnd__i28 0.0488889
Rw337 gnd__i64 gnd__i30 9
Rw338 gnd__i131 gnd__i90 9
Rw339 gnd__i143 gnd__i90 9
Rw340 gnd__i92 gnd__i90 0.0488889
Rw341 gnd__i95 gnd__i92 9
Rw342 gnd__i144 gnd__i92 9
Rw343 gnd__i101 gnd__i7 9
Rw344 gnd__i109 gnd__i7 9
Rw345 gnd__i9 gnd__i7 0.0488889
Rw346 gnd__i32 gnd__i9 9
Rw347 gnd__i102 gnd__i10 9
Rw348 gnd__i110 gnd__i10 9
Rw349 gnd__i12 gnd__i10 0.0488889
Rw350 gnd__i33 gnd__i12 9
Rw351 gnd__i103 gnd__i13 9
Rw352 gnd__i111 gnd__i13 9
Rw353 gnd__i15 gnd__i13 0.0488889
Rw354 gnd__i34 gnd__i15 9
Rw355 gnd__i104 gnd__i16 9
Rw356 gnd__i112 gnd__i16 9
Rw357 gnd__i18 gnd__i16 0.0488889
Rw358 gnd__i35 gnd__i18 9
Rw359 gnd__i130 gnd__i82 9
Rw360 gnd__i142 gnd__i82 9
Rw361 gnd__i89 gnd__i82 0.0488889
Rw362 gnd__i94 gnd__i89 9
Rw363 gnd__i129 gnd__i79 9
Rw364 gnd__i141 gnd__i79 9
Rw365 gnd__i81 gnd__i79 0.0488889
Rw366 gnd__i87 gnd__i81 9
Rw367 gnd__i128 gnd__i76 9
Rw368 gnd__i140 gnd__i76 9
Rw369 gnd__i78 gnd__i76 0.0488889
Rw370 gnd__i86 gnd__i78 9
Rw371 gnd__i127 gnd__i73 9
Rw372 gnd__i139 gnd__i73 9
Rw373 gnd__i75 gnd__i73 0.0488889
Rw374 gnd__i85 gnd__i75 9
Rw375 gnd__i126 gnd__i70 9
Rw376 gnd__i138 gnd__i70 9
Rw377 gnd__i72 gnd__i70 0.0488889
Rw378 gnd__i84 gnd__i72 9
Rw379 gnd__i137 gnd__i67 9
Rw380 gnd__i69 gnd__i67 0.0488889
Rw381 gnd__i83 gnd__i69 9
Rw382 gnd__i125 gnd__i69 9
Rw383 gnd__i65 gnd__i31 0.11
Rw384 gnd__i100 gnd__i65 9
Rw385 gnd__i113 gnd__i36 9
Rw386 gnd__i117 gnd__i36 9
Rw387 gnd__i38 gnd__i36 0.0488889
Rw388 gnd__i49 gnd__i38 9
Rw389 gnd__i114 gnd__i39 9
Rw390 gnd__i118 gnd__i39 9
Rw391 gnd__i41 gnd__i39 0.0488889
Rw392 gnd__i50 gnd__i41 9
Rw393 gnd__i115 gnd__i42 9
Rw394 gnd__i119 gnd__i42 9
Rw395 gnd__i44 gnd__i42 0.0488889
Rw396 gnd__i51 gnd__i44 9
Rw397 gnd__i47 gnd__i45 0.0488889
Rw398 gnd__i52 gnd__i47 9
Rw399 gnd__i116 gnd__i47 9
Rw400 gnd__i120 gnd__i47 9
Rw401 gnd__i226 gnd__i134 0.185635
Rw402 gnd__i251 gnd__i249 9
Rw403 gnd__i134 gnd__i249 0.521654
Rw404 gnd__i207 gnd__i205 9
Rw405 gnd__i123 gnd__i105 0.0488889
Rw406 gnd__i21 gnd__i105 9
Rw407 gnd__i192 gnd__i123 0.371556
Rw408 gnd__i21 gnd__i123 9
Rw409 gnd__i156 gnd__i192 0.0488889
Rw410 gnd__i212 gnd__i156 0.0488889
Rw411 gnd__i124 gnd__i106 0.0488889
Rw412 gnd__i24 gnd__i106 9
Rw413 gnd__i194 gnd__i124 0.371556
Rw414 gnd__i24 gnd__i124 9
Rw415 gnd__i158 gnd__i194 0.0488889
Rw416 gnd__i160 gnd__i158 9
Rw417 gnd__i213 gnd__i158 0.0488889
Rw418 gnd__i98 gnd__i107 0.0488889
Rw419 gnd__i27 gnd__i107 9
Rw420 gnd__i195 gnd__i98 0.371556
Rw421 gnd__i25 gnd__i98 9
Rw422 gnd__i161 gnd__i195 0.0488889
Rw423 gnd__i163 gnd__i161 9
Rw424 gnd__i214 gnd__i161 0.0488889
Rw425 gnd__i99 gnd__i108 0.0488889
Rw426 gnd__i30 gnd__i108 9
Rw427 gnd__i196 gnd__i99 0.371556
Rw428 gnd__i30 gnd__i99 9
Rw429 gnd__i164 gnd__i196 0.0488889
Rw430 gnd__i166 gnd__i164 9
Rw431 gnd__i215 gnd__i164 0.0488889
Rw432 gnd__i101 gnd__i109 0.0488889
Rw433 gnd__i9 gnd__i109 9
Rw434 gnd__i197 gnd__i101 0.371556
Rw435 gnd__i9 gnd__i101 9
Rw436 gnd__i168 gnd__i197 0.0488889
Rw437 gnd__i170 gnd__i168 9
Rw438 gnd__i216 gnd__i168 0.0488889
Rw439 gnd__i102 gnd__i110 0.0488889
Rw440 gnd__i12 gnd__i110 9
Rw441 gnd__i198 gnd__i102 0.371556
Rw442 gnd__i12 gnd__i102 9
Rw443 gnd__i171 gnd__i198 0.0488889
Rw444 gnd__i173 gnd__i171 9
Rw445 gnd__i217 gnd__i171 0.0488889
Rw446 gnd__i103 gnd__i111 0.0488889
Rw447 gnd__i15 gnd__i111 9
Rw448 gnd__i199 gnd__i103 0.371556
Rw449 gnd__i15 gnd__i103 9
Rw450 gnd__i174 gnd__i199 0.0488889
Rw451 gnd__i176 gnd__i174 9
Rw452 gnd__i218 gnd__i174 0.0488889
Rw453 gnd__i104 gnd__i112 0.0488889
Rw454 gnd__i18 gnd__i112 9
Rw455 gnd__i200 gnd__i104 0.371556
Rw456 gnd__i18 gnd__i104 9
Rw457 gnd__i177 gnd__i200 0.0488889
Rw458 gnd__i179 gnd__i177 9
Rw459 gnd__i219 gnd__i177 0.0488889
Rw460 gnd__i113 gnd__i117 0.0488889
Rw461 gnd__i38 gnd__i117 9
Rw462 gnd__i201 gnd__i113 0.449778
Rw463 gnd__i38 gnd__i113 9
Rw464 gnd__i180 gnd__i201 0.0488889
Rw465 gnd__i182 gnd__i180 9
Rw466 gnd__i220 gnd__i180 0.0488889
Rw467 gnd__i114 gnd__i118 0.0488889
Rw468 gnd__i41 gnd__i118 9
Rw469 gnd__i202 gnd__i114 0.449778
Rw470 gnd__i41 gnd__i114 9
Rw471 gnd__i183 gnd__i202 0.0488889
Rw472 gnd__i185 gnd__i183 9
Rw473 gnd__i221 gnd__i183 0.0488889
Rw474 gnd__i115 gnd__i119 0.0488889
Rw475 gnd__i44 gnd__i119 9
Rw476 gnd__i203 gnd__i115 0.449778
Rw477 gnd__i44 gnd__i115 9
Rw478 gnd__i186 gnd__i203 0.0488889
Rw479 gnd__i188 gnd__i186 9
Rw480 gnd__i222 gnd__i186 0.0488889
Rw481 gnd__i189 gnd__i204 0.052291
Rw482 gnd__i191 gnd__i189 9
Rw483 gnd__i223 gnd__i189 0.0504461
Rw484 gnd__i125 gnd__i137 0.0488889
Rw485 gnd__i69 gnd__i137 9
Rw486 gnd__i135 gnd__i125 0.185778
Rw487 gnd__i67 gnd__i125 9
Rw488 gnd__i230 gnd__i228 9
Rw489 gnd__i254 gnd__i228 0.0488889
Rw490 gnd__i253 gnd__i254 0.0488889
Rw491 gnd__i126 gnd__i138 0.0488889
Rw492 gnd__i72 gnd__i138 9
Rw493 gnd__i136 gnd__i126 0.185778
Rw494 gnd__i72 gnd__i126 9
Rw495 gnd__i233 gnd__i231 9
Rw496 gnd__i255 gnd__i231 0.0488889
Rw497 gnd__i261 gnd__i255 0.0488889
Rw498 gnd__i127 gnd__i139 0.0488889
Rw499 gnd__i75 gnd__i139 9
Rw500 gnd__i234 gnd__i127 0.371556
Rw501 gnd__i75 gnd__i127 9
Rw502 gnd__i236 gnd__i234 9
Rw503 gnd__i256 gnd__i234 0.0488889
Rw504 gnd__i262 gnd__i256 0.0488889
Rw505 gnd__i128 gnd__i140 0.0488889
Rw506 gnd__i78 gnd__i140 9
Rw507 gnd__i237 gnd__i128 0.371556
Rw508 gnd__i78 gnd__i128 9
Rw509 gnd__i239 gnd__i237 9
Rw510 gnd__i257 gnd__i237 0.0488889
Rw511 gnd__i263 gnd__i257 0.0488889
Rw512 gnd__i129 gnd__i141 0.0488889
Rw513 gnd__i81 gnd__i141 9
Rw514 gnd__i240 gnd__i129 0.371556
Rw515 gnd__i81 gnd__i129 9
Rw516 gnd__i242 gnd__i240 9
Rw517 gnd__i258 gnd__i240 0.0488889
Rw518 gnd__i264 gnd__i258 0.0488889
Rw519 gnd__i130 gnd__i142 0.0488889
Rw520 gnd__i89 gnd__i142 9
Rw521 gnd__i243 gnd__i130 0.371556
Rw522 gnd__i89 gnd__i130 9
Rw523 gnd__i245 gnd__i243 9
Rw524 gnd__i259 gnd__i243 0.0488889
Rw525 gnd__i265 gnd__i259 0.0488889
Rw526 gnd__i246 gnd__i131 0.371556
Rw527 gnd__i92 gnd__i131 9
Rw528 gnd__i248 gnd__i246 9
Rw529 gnd__i260 gnd__i246 0.0488889
Rw530 gnd__i266 gnd__i260 0.0488889
Rw531 gnd__i146 gnd__i148 0.0586667
Rw532 gnd__i151 gnd__i149 9
Rw533 gnd__i155 gnd__i154 9
Rw534 gnd__i152 gnd__i154 0.0352
Rw535 gnd__i226 gnd__i225 9
Rw536 gnd__i227 gnd__i225 0.0352
Rw537 gnd__i134 gnd__i225 9
Rw538 gnd__i212 gnd__i193 9
Rw539 gnd__i157 gnd__i193 0.0275
Rw540 gnd__i156 gnd__i193 9
Rw541 gnd__i192 gnd__i157 9
Rw542 gnd__i159 gnd__i157 0.1485
Rw543 gnd__i212 gnd__i157 9
Rw544 gnd__i194 gnd__i159 9
Rw545 gnd__i213 gnd__i159 9
Rw546 gnd__i160 gnd__i159 0.0275
Rw547 gnd__i194 gnd__i160 9
Rw548 gnd__i162 gnd__i160 0.1485
Rw549 gnd__i213 gnd__i160 9
Rw550 gnd__i195 gnd__i162 9
Rw551 gnd__i214 gnd__i162 9
Rw552 gnd__i163 gnd__i162 0.0275
Rw553 gnd__i195 gnd__i163 9
Rw554 gnd__i165 gnd__i163 0.1485
Rw555 gnd__i214 gnd__i163 9
Rw556 gnd__i196 gnd__i165 9
Rw557 gnd__i215 gnd__i165 9
Rw558 gnd__i166 gnd__i165 0.0275
Rw559 gnd__i196 gnd__i166 9
Rw560 gnd__i167 gnd__i166 0.352
Rw561 gnd__i215 gnd__i166 9
Rw562 gnd__i169 gnd__i167 0.1485
Rw563 gnd__i197 gnd__i169 9
Rw564 gnd__i216 gnd__i169 9
Rw565 gnd__i170 gnd__i169 0.0275
Rw566 gnd__i197 gnd__i170 9
Rw567 gnd__i172 gnd__i170 0.1485
Rw568 gnd__i216 gnd__i170 9
Rw569 gnd__i198 gnd__i172 9
Rw570 gnd__i217 gnd__i172 9
Rw571 gnd__i173 gnd__i172 0.0275
Rw572 gnd__i198 gnd__i173 9
Rw573 gnd__i175 gnd__i173 0.1485
Rw574 gnd__i217 gnd__i173 9
Rw575 gnd__i199 gnd__i175 9
Rw576 gnd__i218 gnd__i175 9
Rw577 gnd__i176 gnd__i175 0.0275
Rw578 gnd__i199 gnd__i176 9
Rw579 gnd__i178 gnd__i176 0.1485
Rw580 gnd__i218 gnd__i176 9
Rw581 gnd__i200 gnd__i178 9
Rw582 gnd__i219 gnd__i178 9
Rw583 gnd__i179 gnd__i178 0.0275
Rw584 gnd__i200 gnd__i179 9
Rw585 gnd__i181 gnd__i179 0.1485
Rw586 gnd__i219 gnd__i179 9
Rw587 gnd__i201 gnd__i181 9
Rw588 gnd__i220 gnd__i181 9
Rw589 gnd__i182 gnd__i181 0.0275
Rw590 gnd__i201 gnd__i182 9
Rw591 gnd__i184 gnd__i182 0.1485
Rw592 gnd__i220 gnd__i182 9
Rw593 gnd__i202 gnd__i184 9
Rw594 gnd__i221 gnd__i184 9
Rw595 gnd__i185 gnd__i184 0.0275
Rw596 gnd__i202 gnd__i185 9
Rw597 gnd__i187 gnd__i185 0.1485
Rw598 gnd__i221 gnd__i185 9
Rw599 gnd__i203 gnd__i187 9
Rw600 gnd__i222 gnd__i187 9
Rw601 gnd__i188 gnd__i187 0.0275
Rw602 gnd__i203 gnd__i188 9
Rw603 gnd__i289 gnd__i188 0.132
Rw604 gnd__i222 gnd__i188 9
Rw605 gnd__i204 gnd__i190 9
Rw606 gnd__i223 gnd__i190 9
Rw607 gnd__i191 gnd__i190 0.0275
Rw608 gnd__i204 gnd__i191 9
Rw609 gnd__i229 gnd__i191 0.3245
Rw610 gnd__i223 gnd__i191 9
Rw611 gnd__i253 gnd__i229 9
Rw612 gnd__i254 gnd__i229 9
Rw613 gnd__i230 gnd__i229 0.0275
Rw614 gnd__i253 gnd__i230 9
Rw615 gnd__i232 gnd__i230 0.3245
Rw616 gnd__i254 gnd__i230 9
Rw617 gnd__i255 gnd__i232 9
Rw618 gnd__i261 gnd__i232 9
Rw619 gnd__i233 gnd__i232 0.0275
Rw620 gnd__i255 gnd__i233 9
Rw621 gnd__i235 gnd__i233 0.1485
Rw622 gnd__i261 gnd__i233 9
Rw623 gnd__i256 gnd__i235 9
Rw624 gnd__i262 gnd__i235 9
Rw625 gnd__i236 gnd__i235 0.0275
Rw626 gnd__i256 gnd__i236 9
Rw627 gnd__i238 gnd__i236 0.1485
Rw628 gnd__i262 gnd__i236 9
Rw629 gnd__i257 gnd__i238 9
Rw630 gnd__i263 gnd__i238 9
Rw631 gnd__i239 gnd__i238 0.0275
Rw632 gnd__i257 gnd__i239 9
Rw633 gnd__i241 gnd__i239 0.1485
Rw634 gnd__i263 gnd__i239 9
Rw635 gnd__i258 gnd__i241 9
Rw636 gnd__i264 gnd__i241 9
Rw637 gnd__i242 gnd__i241 0.0275
Rw638 gnd__i258 gnd__i242 9
Rw639 gnd__i244 gnd__i242 0.1485
Rw640 gnd__i264 gnd__i242 9
Rw641 gnd__i259 gnd__i244 9
Rw642 gnd__i265 gnd__i244 9
Rw643 gnd__i245 gnd__i244 0.0275
Rw644 gnd__i259 gnd__i245 9
Rw645 gnd__i247 gnd__i245 0.1485
Rw646 gnd__i265 gnd__i245 9
Rw647 gnd__i260 gnd__i247 9
Rw648 gnd__i266 gnd__i247 9
Rw649 gnd__i248 gnd__i247 0.0275
Rw650 gnd__i260 gnd__i248 9
Rw651 gnd__i266 gnd__i248 9
Rw652 gnd__i148 gnd__i147 9
Rw653 gnd__i291 gnd__i147 0.0656616
Rw654 gnd__i154 gnd__i153 9
Rw655 gnd__i155 gnd__i153 0.0352
Rw656 gnd__i1 gnd__p33 9.07441
Rw657 gnd__i2 gnd__p34 9.10676
Rw658 gnd__i3 gnd__p28 9.06632
Rw659 gnd__i4 gnd__p30 9.06632
Rw660 gnd__i5 gnd__p29 9.07441
Rw661 gnd__i6 gnd__p31 9.07441
Rw662 gnd__i7 gnd__i271 4.53823
Rw663 gnd__i10 gnd__i272 4.53823
Rw664 gnd__i13 gnd__i273 4.53823
Rw665 gnd__i16 gnd__i274 4.53823
Rw666 gnd__i19 gnd__p54 9.07441
Rw667 gnd__i20 gnd__p0 4.56519
Rw668 gnd__i21 gnd__p0 4.50634
Rw669 gnd__i22 gnd__i268 4.53823
Rw670 gnd__i25 gnd__i269 4.53823
Rw671 gnd__i28 gnd__i270 4.53823
Rw672 gnd__i36 gnd__i281 4.53823
Rw673 gnd__i39 gnd__i282 4.53823
Rw674 gnd__i42 gnd__i283 4.53823
Rw675 gnd__i45 gnd__i284 4.53823
Rw676 gnd__i48 gnd__p51 9.13103
Rw677 gnd__i54 gnd__i56 9.88
Rw678 gnd__i56 gnd__p38 9.10676
Rw679 gnd__i58 gnd__i19 9.704
Rw680 gnd__i61 gnd__i60 10.32
Rw681 gnd__i65 gnd__p5 9.18301
Rw682 gnd__i67 gnd__i280 4.53823
Rw683 gnd__i70 gnd__i279 4.53823
Rw684 gnd__i73 gnd__i278 4.53823
Rw685 gnd__i76 gnd__i277 4.53823
Rw686 gnd__i79 gnd__i276 4.53823
Rw687 gnd__i82 gnd__i275 4.53823
Rw688 gnd__i90 gnd__i267 4.53823
Rw689 gnd__i96 gnd__p25 9.18301
Rw690 gnd__i100 gnd__i31 9.11
Rw691 gnd__i132 gnd__i93 9.11
Rw692 gnd__i291 gnd__i148 9.03375
Rw693 gnd__i208 gnd__i290 9.15025
Rw694 gnd__i227 gnd__i286 9.05721
Rw695 gnd__i61 gnd__p57 9.77841
Rw696 gnd__i31 gnd__p4 10.5828
Rw697 gnd__i121 gnd__p52 9.44503
Rw698 gnd__p36 gnd__i122 18.4183
Rw699 gnd__i56 gnd__p39 10.4068
Rw700 gnd__i48 gnd__i57 12.4254
Rw701 gnd__i285 gnd__p47 10.135
Rw702 gnd__i285 gnd__p48 9.42641
Rw703 gnd__i133 gnd__p49 9.33776
Rw704 gnd__p44 gnd__i97 18.4814
Rw705 gnd__p15 gnd__i135 19.3728
Rw706 gnd__p17 gnd__i136 19.3728
Rw707 gnd__i152 gnd__i6 11.5062
Rw708 gnd__i287 gnd__i45 4.88373
Rw709 gnd gnd__i122 12.9781
Rw710 gnd__p59 gnd__i209 0.143
Rw711 gnd__p27 gnd__p26 19.4416
Rw712 gnd__i0 gnd__p32 19.6503
Rw713 gnd__i4 gnd__i145 31.6414
Rw714 gnd__i3 gnd__i5 21.8249
Rw715 gnd__p42 gnd__i97 31.6436
Rw716 gnd__i59 gnd__i211 27.528
Rw717 gnd__i1 gnd__i0 28.0303
Rw718 gnd__i19 gnd__p55 10.5504
Rw719 gnd__i120 gnd__p13 19.9694
Rw720 gnd__i122 gnd__i53 20.515
Rw721 gnd__p40 gnd__i55 36.9498
Rw722 gnd__p37 gnd__i53 37.1371
Rw723 gnd__i210 gnd__p43 27.8013
Rw724 gnd__p53 gnd__i57 36.7784
Rw725 gnd__p56 gnd__i60 36.5437
Rw726 gnd__i144 gnd__p24 18.8165
Rw727 gnd__i100 gnd__i167 3.89642
Rw728 gnd__i151 gnd__i145 9.24445
Rw729 gnd__i146 gnd__i5 67.0418
Rw730 gnd__i6 gnd__i4 38.7023
Rw731 gnd__i206 gnd__i121 32.778
Rw732 gnd__i208 gnd__i3 31.8174
Rw733 gnd__p41 gnd__i55 38.1308
Rw734 gnd__i66 gnd__i224 24.1746
Rw735 gnd__i227 gnd__p50 27.5336
Rw736 gnd__i132 gnd__i248 4.24842
Rw737 gnd__p64 gnd__i251 0.489473
Rw738 gnd__i252 gnd__p45 27.986
Rw739 gnd__i66 gnd__p46 36.835
Rw740 gnd__i0 gnd__p65 87.9496
Rw741 gnd__i1 gnd__i2 109.05
Rw742 gnd__i209 gnd__i61 32.1376
Rw743 gnd__p35 gnd__i2 47.6465
Rw744 in0n in0n__p0 30.4372
Rw745 in0n in0n__p1 1231.24
Rw746 in0n__p0 in0n__p1 9.97273
Rw747 in0p in0p__p0 56.0447
Rw748 in0p in0p__p1 897.293
Rw749 in0p__p0 in0p__p1 9.95162
Rw750 in1n in1n__p0 37.6382
Rw751 in1n in1n__p1 884.93
Rw752 in1n__p0 in1n__p1 10.015
Rw753 in1p in1p__p0 32.6056
Rw754 in1p in1p__p1 495.158
Rw755 in1p__p0 in1p__p1 10.1323
Rw756 lsb_n lsb_n__p1 19.3605
Rw757 lsb_n lsb_n__p2 218.249
Rw758 lsb_n__p1 lsb_n__p2 222.023
Rw759 lsb_p lsb_p__p1 18.528
Rw760 lsb_p lsb_p__p2 144.128
Rw761 nr nr__p1 46.253
Rw762 on on__p0 3639.95
Rw763 on on__p1 3326.22
Rw764 on on__p2 781.288
Rw765 on on__p3 107.802
Rw766 on on__p4 123.815
Rw767 on on__p5 504.098
Rw768 on on__p6 571.955
Rw769 on__p0 on__p1 58.5448
Rw770 on__p0 on__p2 81.5711
Rw771 on__p0 on__p3 912.304
Rw772 on__p0 on__p4 1047.82
Rw773 on__p0 on__p5 661.584
Rw774 on__p0 on__p6 750.64
Rw775 on__p1 on__p2 74.5403
Rw776 on__p1 on__p3 833.67
Rw777 on__p1 on__p4 957.506
Rw778 on__p1 on__p5 604.56
Rw779 on__p1 on__p6 685.94
Rw780 on__p2 on__p3 195.819
Rw781 on__p2 on__p4 224.907
Rw782 on__p2 on__p5 142.004
Rw783 on__p2 on__p6 161.119
Rw784 on__p3 on__p4 27.9852
Rw785 on__p3 on__p5 126.345
Rw786 on__p3 on__p6 143.353
Rw787 on__p4 on__p5 145.113
Rw788 on__p4 on__p6 164.647
Rw789 on__p5 on__p6 80.7998
Rw790 onn onn__p0 4523.83
Rw791 onn onn__p1 363.978
Rw792 onn onn__p2 354.84
Rw793 onn onn__p3 92.84
Rw794 onn onn__p4 604.056
Rw795 onn onn__p5 669.299
Rw796 onn onn__p6 761.621
Rw797 onn__p0 onn__p1 4200.68
Rw798 onn__p0 onn__p2 4095.23
Rw799 onn__p0 onn__p3 938.345
Rw800 onn__p0 onn__p4 514.377
Rw801 onn__p0 onn__p5 493.832
Rw802 onn__p0 onn__p6 92.5825
Rw803 onn__p1 onn__p2 59.5242
Rw804 onn__p1 onn__p3 86.2083
Rw805 onn__p1 onn__p4 560.907
Rw806 onn__p1 onn__p5 621.49
Rw807 onn__p1 onn__p6 707.217
Rw808 onn__p2 onn__p3 84.044
Rw809 onn__p2 onn__p4 546.825
Rw810 onn__p2 onn__p5 605.887
Rw811 onn__p2 onn__p6 689.462
Rw812 onn__p3 onn__p4 125.295
Rw813 onn__p3 onn__p5 138.828
Rw814 onn__p3 onn__p6 157.977
Rw815 onn__p4 onn__p5 76.102
Rw816 onn__p4 onn__p6 86.5993
Rw817 onn__p5 onn__p6 83.1404
Rw818 onp onp__p3 136.601
Rw819 onp onp__p4 171.926
Rw820 onp onp__p5 196.867
Rw821 onp__p0 onp__p5 261.417
Rw822 onp__p0 onp__p6 83.8305
Rw823 onp__p1 onp__p2 19.2467
Rw824 onp__p2 onp__p3 0.7029
Rw825 onp__p3 onp__p4 86.3151
Rw826 onp__p3 onp__p5 98.8366
Rw827 onp__p4 onp__p5 23.6141
Rw828 onp__p5 onp__p6 0.705438
Rw829 op op__p2 321.819
Rw830 op op__p3 107.43
Rw831 op op__p4 521.446
Rw832 op op__p5 602.952
Rw833 op__p0 op__p1 19.4601
Rw834 op__p1 op__p2 0.704
Rw835 op__p2 op__p3 63.9007
Rw836 op__p2 op__p4 310.163
Rw837 op__p2 op__p5 358.644
Rw838 op__p3 op__p4 82.7954
Rw839 op__p3 op__p5 95.7369
Rw840 op__p4 op__p5 23.5511
Rw841 op__p5 op__p6 0.704
Rw842 rstb rstb__p1 54.4453
Rw843 rstb rstb__p2 182.82
Rw844 rstb rstb__p3 151.068
Rw845 rstb__p1 rstb__p2 779.597
Rw846 rstb__p1 rstb__p3 644.2
Rw847 rstb__p2 rstb__p3 22.0156
Rw848 rstb_n rstb_n__p1 88.824
Rw849 rstb_n rstb_n__p3 101.63
Rw850 rstb_n rstb_n__p4 96.0304
Rw851 rstb_n__p1 rstb_n__p3 37.1031
Rw852 rstb_n__p1 rstb_n__p4 35.059
Rw853 rstb_n__p2 rstb_n__p3 0.6534
Rw854 rstb_n__p3 rstb_n__p4 30.359
Rw855 t0 t0__p1 83.757
Rw856 t0 t0__p2 41.5709
Rw857 t0 t0__p3 142.74
Rw858 t0 t0__p4 148.984
Rw859 t0 t0__p5 121.196
Rw860 t0__p1 t0__p2 95.5872
Rw861 t0__p1 t0__p3 328.212
Rw862 t0__p1 t0__p4 662.421
Rw863 t0__p1 t0__p5 538.867
Rw864 t0__p2 t0__p3 65.702
Rw865 t0__p2 t0__p4 328.778
Rw866 t0__p2 t0__p5 267.454
Rw867 t0__p3 t0__p4 1128.91
Rw868 t0__p3 t0__p5 918.342
Rw869 t0__p4 t0__p5 23.8098
Rw870 t0b t0b__p1 24.1404
Rw871 t0b t0b__p2 138.839
Rw872 t0b t0b__p3 159.221
Rw873 t0b t0b__p7 27.9723
Rw874 t0b__p1 t0b__p2 120.423
Rw875 t0b__p1 t0b__p3 138.101
Rw876 t0b__p1 t0b__p7 3558.33
Rw877 t0b__p2 t0b__p3 23.5258
Rw878 t0b__p2 t0b__p7 20465.1
Rw879 t0b__p3 t0b__p7 23469.4
Rw880 t0b__p4 t0b__p5 36.6424
Rw881 t0b__p4 t0b__p6 265.156
Rw882 t0b__p4 t0b__p7 49.4116
Rw883 t0b__p4 t0b__p8 44.1235
Rw884 t0b__p4 t0b__p9 221.176
Rw885 t0b__p5 t0b__p6 289.099
Rw886 t0b__p5 t0b__p7 53.8734
Rw887 t0b__p5 t0b__p8 48.1077
Rw888 t0b__p5 t0b__p9 241.148
Rw889 t0b__p6 t0b__p7 232.691
Rw890 t0b__p6 t0b__p8 207.788
Rw891 t0b__p6 t0b__p9 24.6537
Rw892 t0b__p7 t0b__p8 38.7211
Rw893 t0b__p7 t0b__p9 194.096
Rw894 t0b__p8 t0b__p9 173.323
Rw895 t1 t1__p1 45.9484
Rw896 t1 t1__p2 6190.96
Rw897 t1 t1__p3 2616.66
Rw898 t1 t1__p4 394.914
Rw899 t1 t1__p5 489.344
Rw900 t1__p1 t1__p2 74.9216
Rw901 t1__p1 t1__p3 31.6662
Rw902 t1__p1 t1__p4 438.181
Rw903 t1__p1 t1__p5 542.957
Rw904 t1__p2 t1__p3 65.6945
Rw905 t1__p2 t1__p4 59039.4
Rw906 t1__p2 t1__p5 73156.6
Rw907 t1__p3 t1__p4 24953.4
Rw908 t1__p3 t1__p5 30920.2
Rw909 t1__p4 t1__p5 21.5492
Rw910 t1b t1b__p1 88.9721
Rw911 t1b t1b__p2 256.061
Rw912 t1b t1b__p3 812.777
Rw913 t1b t1b__p5 2205.13
Rw914 t1b t1b__p6 736.68
Rw915 t1b t1b__p7 3266.75
Rw916 t1b t1b__p8 2799.65
Rw917 t1b t1b__p9 558.379
Rw918 t1b__p1 t1b__p2 104.493
Rw919 t1b__p1 t1b__p3 331.676
Rw920 t1b__p1 t1b__p5 2613.11
Rw921 t1b__p1 t1b__p6 872.978
Rw922 t1b__p1 t1b__p7 3871.15
Rw923 t1b__p1 t1b__p8 3317.63
Rw924 t1b__p1 t1b__p9 661.689
Rw925 t1b__p2 t1b__p3 44.3811
Rw926 t1b__p2 t1b__p5 7520.52
Rw927 t1b__p2 t1b__p6 2512.43
Rw928 t1b__p2 t1b__p7 11141.1
Rw929 t1b__p2 t1b__p8 9548.11
Rw930 t1b__p2 t1b__p9 1904.34
Rw931 t1b__p3 t1b__p5 23871.3
Rw932 t1b__p3 t1b__p6 7974.82
Rw933 t1b__p3 t1b__p7 35363.7
Rw934 t1b__p3 t1b__p8 30307.2
Rw935 t1b__p3 t1b__p9 6044.66
Rw936 t1b__p4 t1b__p5 1.26262
Rw937 t1b__p5 t1b__p6 69.5617
Rw938 t1b__p5 t1b__p7 500.76
Rw939 t1b__p5 t1b__p8 429.158
Rw940 t1b__p5 t1b__p9 89.7555
Rw941 t1b__p6 t1b__p7 167.292
Rw942 t1b__p6 t1b__p8 143.371
Rw943 t1b__p6 t1b__p9 29.9852
Rw944 t1b__p7 t1b__p8 23.9948
Rw945 t1b__p7 t1b__p9 132.967
Rw946 t1b__p8 t1b__p9 113.954
Rw947 top_n top_n__p1 0.001
Rw948 top_n top_n__p2 0.001
Rw949 top_n__p1 top_n__p3 66.9798
Rw950 top_n__p1 top_n__p4 209.815
Rw951 top_n__p3 top_n__p4 44.2197
Rw952 top_p top_p__p1 0.001
Rw953 top_p top_p__p2 0.001
Rw954 top_p__p1 top_p__p3 31.2837
Rw955 top_p__p1 top_p__p4 82.8984
Rw956 top_p__p3 top_p__p4 163.124
Rw957 trk0 trk0__p0 226.64
Rw958 trk0 trk0__p1 190.709
Rw959 trk0__p0 trk0__p1 21.4958
Rw960 trk1 trk1__p1 50.425
Rw961 trk1__p0 trk1__p1 19.7769
Rw962 vdd vdd__p0 142.94
Rw963 vdd vdd__p1 1062.11
Rw964 vdd vdd__p12 74.6987
Rw965 vdd vdd__p13 76.1977
Rw966 vdd vdd__p14 58.6084
Rw967 vdd vdd__p15 27.1348
Rw968 vdd vdd__p16 60.5745
Rw969 vdd vdd__p17 64.238
Rw970 vdd vdd__p18 67.0368
Rw971 vdd vdd__p19 1151.56
Rw972 vdd vdd__p2 219.72
Rw973 vdd vdd__p20 1222.61
Rw974 vdd vdd__p21 1866.48
Rw975 vdd vdd__p22 4217.77
Rw976 vdd vdd__p24 1753.01
Rw977 vdd vdd__p25 493659
Rw978 vdd vdd__p26 81.5875
Rw979 vdd vdd__p27 86.4282
Rw980 vdd vdd__p28 94.2697
Rw981 vdd vdd__p29 116.772
Rw982 vdd vdd__p3 11990.7
Rw983 vdd vdd__p30 125.575
Rw984 vdd vdd__p31 135.74
Rw985 vdd vdd__p32 146.129
Rw986 vdd vdd__p33 155.574
Rw987 vdd vdd__p34 167.898
Rw988 vdd vdd__p36 9.53316
Rw989 vdd vdd__p37 38.7872
Rw990 vdd vdd__p38 71.2134
Rw991 vdd vdd__p4 91839.8
Rw992 vdd vdd__p5 18363.7
Rw993 vdd vdd__p6 1321.55
Rw994 vdd vdd__p8 6985.51
Rw995 vdd__p0 vdd__p1 438.819
Rw996 vdd__p0 vdd__p12 14846.3
Rw997 vdd__p0 vdd__p13 130.731
Rw998 vdd__p0 vdd__p14 2297.2
Rw999 vdd__p0 vdd__p15 2799.13
Rw1000 vdd__p0 vdd__p16 2656.29
Rw1001 vdd__p0 vdd__p17 2816.94
Rw1002 vdd__p0 vdd__p18 2939.67
Rw1003 vdd__p0 vdd__p19 50497.8
Rw1004 vdd__p0 vdd__p2 90.779
Rw1005 vdd__p0 vdd__p20 53613.4
Rw1006 vdd__p0 vdd__p21 81848.1
Rw1007 vdd__p0 vdd__p22 184956
Rw1008 vdd__p0 vdd__p24 76872.5
Rw1009 vdd__p0 vdd__p26 3577.75
Rw1010 vdd__p0 vdd__p27 3790.02
Rw1011 vdd__p0 vdd__p28 4133.89
Rw1012 vdd__p0 vdd__p29 5120.64
Rw1013 vdd__p0 vdd__p3 4954.06
Rw1014 vdd__p0 vdd__p30 5506.66
Rw1015 vdd__p0 vdd__p31 5952.44
Rw1016 vdd__p0 vdd__p32 6408
Rw1017 vdd__p0 vdd__p33 6822.2
Rw1018 vdd__p0 vdd__p34 7362.62
Rw1019 vdd__p0 vdd__p36 418.045
Rw1020 vdd__p0 vdd__p37 1700.88
Rw1021 vdd__p0 vdd__p38 3122.83
Rw1022 vdd__p0 vdd__p4 37944.4
Rw1023 vdd__p0 vdd__p5 7587.1
Rw1024 vdd__p0 vdd__p6 57952.2
Rw1025 vdd__p0 vdd__p8 306326
Rw1026 vdd__p1 vdd__p12 110314
Rw1027 vdd__p1 vdd__p13 971.388
Rw1028 vdd__p1 vdd__p14 17069.2
Rw1029 vdd__p1 vdd__p15 20798.8
Rw1030 vdd__p1 vdd__p16 19737.4
Rw1031 vdd__p1 vdd__p17 20931.1
Rw1032 vdd__p1 vdd__p18 21843.1
Rw1033 vdd__p1 vdd__p19 375221
Rw1034 vdd__p1 vdd__p2 91.9344
Rw1035 vdd__p1 vdd__p20 398371
Rw1036 vdd__p1 vdd__p21 608168
Rw1037 vdd__p1 vdd__p24 571197
Rw1038 vdd__p1 vdd__p26 26584.3
Rw1039 vdd__p1 vdd__p27 28161.5
Rw1040 vdd__p1 vdd__p28 30716.6
Rw1041 vdd__p1 vdd__p29 38048.6
Rw1042 vdd__p1 vdd__p3 138.755
Rw1043 vdd__p1 vdd__p30 40916.9
Rw1044 vdd__p1 vdd__p31 44229.3
Rw1045 vdd__p1 vdd__p32 47614.2
Rw1046 vdd__p1 vdd__p33 50691.9
Rw1047 vdd__p1 vdd__p34 54707.5
Rw1048 vdd__p1 vdd__p36 3106.26
Rw1049 vdd__p1 vdd__p37 12638.3
Rw1050 vdd__p1 vdd__p38 23204
Rw1051 vdd__p1 vdd__p4 1062.76
Rw1052 vdd__p1 vdd__p5 212.502
Rw1053 vdd__p1 vdd__p6 430610
Rw1054 vdd__p10 vdd__p11 186.138
Rw1055 vdd__p10 vdd__p6 165.006
Rw1056 vdd__p10 vdd__p7 514.971
Rw1057 vdd__p10 vdd__p9 40.9163
Rw1058 vdd__p11 vdd__p6 427.044
Rw1059 vdd__p11 vdd__p7 1332.77
Rw1060 vdd__p11 vdd__p9 105.893
Rw1061 vdd__p12 vdd__p13 7914.16
Rw1062 vdd__p12 vdd__p14 6087.27
Rw1063 vdd__p12 vdd__p15 2818.31
Rw1064 vdd__p12 vdd__p16 6291.48
Rw1065 vdd__p12 vdd__p17 6671.98
Rw1066 vdd__p12 vdd__p18 6962.67
Rw1067 vdd__p12 vdd__p19 119605
Rw1068 vdd__p12 vdd__p2 22820.9
Rw1069 vdd__p12 vdd__p20 126984
Rw1070 vdd__p12 vdd__p21 193859
Rw1071 vdd__p12 vdd__p22 438073
Rw1072 vdd__p12 vdd__p24 182074
Rw1073 vdd__p12 vdd__p26 8473.96
Rw1074 vdd__p12 vdd__p27 8976.73
Rw1075 vdd__p12 vdd__p28 9791.18
Rw1076 vdd__p12 vdd__p29 12128.3
Rw1077 vdd__p12 vdd__p30 13042.6
Rw1078 vdd__p12 vdd__p31 14098.5
Rw1079 vdd__p12 vdd__p32 15177.5
Rw1080 vdd__p12 vdd__p33 16158.5
Rw1081 vdd__p12 vdd__p34 17438.5
Rw1082 vdd__p12 vdd__p36 990.148
Rw1083 vdd__p12 vdd__p37 4028.57
Rw1084 vdd__p12 vdd__p38 7396.47
Rw1085 vdd__p12 vdd__p6 137261
Rw1086 vdd__p12 vdd__p8 725539
Rw1087 vdd__p13 vdd__p14 1224.58
Rw1088 vdd__p13 vdd__p15 1492.14
Rw1089 vdd__p13 vdd__p16 1416
Rw1090 vdd__p13 vdd__p17 1501.64
Rw1091 vdd__p13 vdd__p18 1567.06
Rw1092 vdd__p13 vdd__p19 26919.1
Rw1093 vdd__p13 vdd__p2 200.952
Rw1094 vdd__p13 vdd__p20 28579.9
Rw1095 vdd__p13 vdd__p21 43631.1
Rw1096 vdd__p13 vdd__p22 98595.4
Rw1097 vdd__p13 vdd__p24 40978.7
Rw1098 vdd__p13 vdd__p26 1907.2
Rw1099 vdd__p13 vdd__p27 2020.36
Rw1100 vdd__p13 vdd__p28 2203.67
Rw1101 vdd__p13 vdd__p29 2729.68
Rw1102 vdd__p13 vdd__p3 10966.5
Rw1103 vdd__p13 vdd__p30 2935.46
Rw1104 vdd__p13 vdd__p31 3173.09
Rw1105 vdd__p13 vdd__p32 3415.93
Rw1106 vdd__p13 vdd__p33 3636.73
Rw1107 vdd__p13 vdd__p34 3924.82
Rw1108 vdd__p13 vdd__p36 222.849
Rw1109 vdd__p13 vdd__p37 906.696
Rw1110 vdd__p13 vdd__p38 1664.7
Rw1111 vdd__p13 vdd__p4 83995.2
Rw1112 vdd__p13 vdd__p5 16795.1
Rw1113 vdd__p13 vdd__p6 30892.8
Rw1114 vdd__p13 vdd__p8 163294
Rw1115 vdd__p14 vdd__p15 1147.7
Rw1116 vdd__p14 vdd__p16 1089.13
Rw1117 vdd__p14 vdd__p17 1155
Rw1118 vdd__p14 vdd__p18 1205.33
Rw1119 vdd__p14 vdd__p19 20705.1
Rw1120 vdd__p14 vdd__p2 3531.13
Rw1121 vdd__p14 vdd__p20 21982.6
Rw1122 vdd__p14 vdd__p21 33559.4
Rw1123 vdd__p14 vdd__p22 75835.9
Rw1124 vdd__p14 vdd__p24 31519.3
Rw1125 vdd__p14 vdd__p26 1466.95
Rw1126 vdd__p14 vdd__p27 1553.99
Rw1127 vdd__p14 vdd__p28 1694.98
Rw1128 vdd__p14 vdd__p29 2099.57
Rw1129 vdd__p14 vdd__p3 192703
Rw1130 vdd__p14 vdd__p30 2257.84
Rw1131 vdd__p14 vdd__p31 2440.62
Rw1132 vdd__p14 vdd__p32 2627.41
Rw1133 vdd__p14 vdd__p33 2797.24
Rw1134 vdd__p14 vdd__p34 3018.82
Rw1135 vdd__p14 vdd__p36 171.407
Rw1136 vdd__p14 vdd__p37 697.397
Rw1137 vdd__p14 vdd__p38 1280.42
Rw1138 vdd__p14 vdd__p5 295124
Rw1139 vdd__p14 vdd__p6 23761.6
Rw1140 vdd__p14 vdd__p8 125600
Rw1141 vdd__p15 vdd__p16 1186.2
Rw1142 vdd__p15 vdd__p17 1257.94
Rw1143 vdd__p15 vdd__p18 1312.75
Rw1144 vdd__p15 vdd__p19 22550.4
Rw1145 vdd__p15 vdd__p2 4302.67
Rw1146 vdd__p15 vdd__p20 23941.7
Rw1147 vdd__p15 vdd__p21 36550.3
Rw1148 vdd__p15 vdd__p22 82594.6
Rw1149 vdd__p15 vdd__p24 34328.4
Rw1150 vdd__p15 vdd__p26 1597.69
Rw1151 vdd__p15 vdd__p27 1692.48
Rw1152 vdd__p15 vdd__p28 1846.04
Rw1153 vdd__p15 vdd__p29 2286.69
Rw1154 vdd__p15 vdd__p3 234808
Rw1155 vdd__p15 vdd__p30 2459.07
Rw1156 vdd__p15 vdd__p31 2658.14
Rw1157 vdd__p15 vdd__p32 2861.57
Rw1158 vdd__p15 vdd__p33 3046.54
Rw1159 vdd__p15 vdd__p34 3287.87
Rw1160 vdd__p15 vdd__p36 186.683
Rw1161 vdd__p15 vdd__p37 759.551
Rw1162 vdd__p15 vdd__p38 1394.54
Rw1163 vdd__p15 vdd__p5 359607
Rw1164 vdd__p15 vdd__p6 25879.3
Rw1165 vdd__p15 vdd__p8 136794
Rw1166 vdd__p16 vdd__p17 1061.98
Rw1167 vdd__p16 vdd__p18 1108.25
Rw1168 vdd__p16 vdd__p19 19037.6
Rw1169 vdd__p16 vdd__p2 4083.11
Rw1170 vdd__p16 vdd__p20 20212.1
Rw1171 vdd__p16 vdd__p21 30856.6
Rw1172 vdd__p16 vdd__p22 69728.2
Rw1173 vdd__p16 vdd__p24 28980.8
Rw1174 vdd__p16 vdd__p26 1348.8
Rw1175 vdd__p16 vdd__p27 1428.83
Rw1176 vdd__p16 vdd__p28 1558.47
Rw1177 vdd__p16 vdd__p29 1930.47
Rw1178 vdd__p16 vdd__p3 222826
Rw1179 vdd__p16 vdd__p30 2076
Rw1180 vdd__p16 vdd__p31 2244.06
Rw1181 vdd__p16 vdd__p32 2415.8
Rw1182 vdd__p16 vdd__p33 2571.95
Rw1183 vdd__p16 vdd__p34 2775.69
Rw1184 vdd__p16 vdd__p36 157.602
Rw1185 vdd__p16 vdd__p37 641.229
Rw1186 vdd__p16 vdd__p38 1177.3
Rw1187 vdd__p16 vdd__p5 341257
Rw1188 vdd__p16 vdd__p6 21847.9
Rw1189 vdd__p16 vdd__p8 115484
Rw1190 vdd__p17 vdd__p18 1077.58
Rw1191 vdd__p17 vdd__p19 18510.6
Rw1192 vdd__p17 vdd__p2 4330.05
Rw1193 vdd__p17 vdd__p20 19652.7
Rw1194 vdd__p17 vdd__p21 30002.5
Rw1195 vdd__p17 vdd__p22 67798.2
Rw1196 vdd__p17 vdd__p24 28178.6
Rw1197 vdd__p17 vdd__p26 1311.47
Rw1198 vdd__p17 vdd__p27 1389.28
Rw1199 vdd__p17 vdd__p28 1515.33
Rw1200 vdd__p17 vdd__p29 1877.04
Rw1201 vdd__p17 vdd__p3 236302
Rw1202 vdd__p17 vdd__p30 2018.54
Rw1203 vdd__p17 vdd__p31 2181.94
Rw1204 vdd__p17 vdd__p32 2348.93
Rw1205 vdd__p17 vdd__p33 2500.76
Rw1206 vdd__p17 vdd__p34 2698.86
Rw1207 vdd__p17 vdd__p36 153.24
Rw1208 vdd__p17 vdd__p37 623.481
Rw1209 vdd__p17 vdd__p38 1144.71
Rw1210 vdd__p17 vdd__p5 361896
Rw1211 vdd__p17 vdd__p6 21243.1
Rw1212 vdd__p17 vdd__p8 112288
Rw1213 vdd__p18 vdd__p19 16750.7
Rw1214 vdd__p18 vdd__p2 4518.7
Rw1215 vdd__p18 vdd__p20 17784.2
Rw1216 vdd__p18 vdd__p21 27150
Rw1217 vdd__p18 vdd__p22 61352.3
Rw1218 vdd__p18 vdd__p24 25499.6
Rw1219 vdd__p18 vdd__p26 1186.78
Rw1220 vdd__p18 vdd__p27 1257.2
Rw1221 vdd__p18 vdd__p28 1371.26
Rw1222 vdd__p18 vdd__p29 1698.58
Rw1223 vdd__p18 vdd__p3 246598
Rw1224 vdd__p18 vdd__p30 1826.63
Rw1225 vdd__p18 vdd__p31 1974.5
Rw1226 vdd__p18 vdd__p32 2125.61
Rw1227 vdd__p18 vdd__p33 2263.01
Rw1228 vdd__p18 vdd__p34 2442.27
Rw1229 vdd__p18 vdd__p36 138.671
Rw1230 vdd__p18 vdd__p37 564.204
Rw1231 vdd__p18 vdd__p38 1035.88
Rw1232 vdd__p18 vdd__p5 377663
Rw1233 vdd__p18 vdd__p6 19223.5
Rw1234 vdd__p18 vdd__p8 101612
Rw1235 vdd__p19 vdd__p2 77622.4
Rw1236 vdd__p19 vdd__p20 1003.31
Rw1237 vdd__p19 vdd__p21 1531.69
Rw1238 vdd__p19 vdd__p22 14428.1
Rw1239 vdd__p19 vdd__p24 5996.67
Rw1240 vdd__p19 vdd__p26 13425.3
Rw1241 vdd__p19 vdd__p27 12722.2
Rw1242 vdd__p19 vdd__p28 12408
Rw1243 vdd__p19 vdd__p29 10025.5
Rw1244 vdd__p19 vdd__p30 9573.38
Rw1245 vdd__p19 vdd__p31 9163.51
Rw1246 vdd__p19 vdd__p32 8709.1
Rw1247 vdd__p19 vdd__p33 8158.77
Rw1248 vdd__p19 vdd__p34 7720.91
Rw1249 vdd__p19 vdd__p36 438.389
Rw1250 vdd__p19 vdd__p37 95.0287
Rw1251 vdd__p19 vdd__p38 58.4399
Rw1252 vdd__p19 vdd__p6 1114.17
Rw1253 vdd__p19 vdd__p8 5889.32
Rw1254 vdd__p2 vdd__p20 82411.6
Rw1255 vdd__p2 vdd__p21 125812
Rw1256 vdd__p2 vdd__p22 284305
Rw1257 vdd__p2 vdd__p24 118164
Rw1258 vdd__p2 vdd__p26 5499.52
Rw1259 vdd__p2 vdd__p27 5825.81
Rw1260 vdd__p2 vdd__p28 6354.38
Rw1261 vdd__p2 vdd__p29 7871.16
Rw1262 vdd__p2 vdd__p3 1037.89
Rw1263 vdd__p2 vdd__p30 8464.53
Rw1264 vdd__p2 vdd__p31 9149.76
Rw1265 vdd__p2 vdd__p32 9850.02
Rw1266 vdd__p2 vdd__p33 10486.7
Rw1267 vdd__p2 vdd__p34 11317.4
Rw1268 vdd__p2 vdd__p36 642.596
Rw1269 vdd__p2 vdd__p37 2614.5
Rw1270 vdd__p2 vdd__p38 4800.24
Rw1271 vdd__p2 vdd__p4 7949.5
Rw1272 vdd__p2 vdd__p5 1589.53
Rw1273 vdd__p2 vdd__p6 89080.9
Rw1274 vdd__p2 vdd__p8 470868
Rw1275 vdd__p20 vdd__p21 1459.1
Rw1276 vdd__p20 vdd__p22 15318.2
Rw1277 vdd__p20 vdd__p24 6366.65
Rw1278 vdd__p20 vdd__p26 14253.6
Rw1279 vdd__p20 vdd__p27 13507.1
Rw1280 vdd__p20 vdd__p28 13173.5
Rw1281 vdd__p20 vdd__p29 10644.1
Rw1282 vdd__p20 vdd__p30 10164
Rw1283 vdd__p20 vdd__p31 9728.87
Rw1284 vdd__p20 vdd__p32 9246.43
Rw1285 vdd__p20 vdd__p33 8662.15
Rw1286 vdd__p20 vdd__p34 8197.27
Rw1287 vdd__p20 vdd__p36 465.436
Rw1288 vdd__p20 vdd__p37 100.892
Rw1289 vdd__p20 vdd__p38 55.6704
Rw1290 vdd__p20 vdd__p6 1182.91
Rw1291 vdd__p20 vdd__p8 6252.68
Rw1292 vdd__p21 vdd__p22 23385.4
Rw1293 vdd__p21 vdd__p24 9719.55
Rw1294 vdd__p21 vdd__p26 21760.1
Rw1295 vdd__p21 vdd__p27 20620.4
Rw1296 vdd__p21 vdd__p28 20111.2
Rw1297 vdd__p21 vdd__p29 16249.6
Rw1298 vdd__p21 vdd__p30 15516.8
Rw1299 vdd__p21 vdd__p31 14852.4
Rw1300 vdd__p21 vdd__p32 14115.9
Rw1301 vdd__p21 vdd__p33 13223.9
Rw1302 vdd__p21 vdd__p34 12514.2
Rw1303 vdd__p21 vdd__p36 710.551
Rw1304 vdd__p21 vdd__p37 154.025
Rw1305 vdd__p21 vdd__p38 24.1115
Rw1306 vdd__p21 vdd__p6 1805.87
Rw1307 vdd__p21 vdd__p8 9545.56
Rw1308 vdd__p22 vdd__p23 38.5317
Rw1309 vdd__p22 vdd__p24 80.4689
Rw1310 vdd__p22 vdd__p25 22660.5
Rw1311 vdd__p22 vdd__p26 49172.4
Rw1312 vdd__p22 vdd__p27 46597.1
Rw1313 vdd__p22 vdd__p28 45446.3
Rw1314 vdd__p22 vdd__p29 36720.1
Rw1315 vdd__p22 vdd__p30 35064.1
Rw1316 vdd__p22 vdd__p31 33562.8
Rw1317 vdd__p22 vdd__p32 31898.5
Rw1318 vdd__p22 vdd__p33 29882.8
Rw1319 vdd__p22 vdd__p34 28279.1
Rw1320 vdd__p22 vdd__p36 1605.67
Rw1321 vdd__p22 vdd__p37 485.971
Rw1322 vdd__p22 vdd__p38 892.244
Rw1323 vdd__p22 vdd__p6 16557.9
Rw1324 vdd__p22 vdd__p8 87522.5
Rw1325 vdd__p24 vdd__p25 38.6225
Rw1326 vdd__p24 vdd__p26 20437.3
Rw1327 vdd__p24 vdd__p27 19366.9
Rw1328 vdd__p24 vdd__p28 18888.6
Rw1329 vdd__p24 vdd__p29 15261.8
Rw1330 vdd__p24 vdd__p30 14573.5
Rw1331 vdd__p24 vdd__p31 13949.6
Rw1332 vdd__p24 vdd__p32 13257.8
Rw1333 vdd__p24 vdd__p33 12420.1
Rw1334 vdd__p24 vdd__p34 11753.5
Rw1335 vdd__p24 vdd__p36 667.357
Rw1336 vdd__p24 vdd__p37 201.982
Rw1337 vdd__p24 vdd__p38 370.839
Rw1338 vdd__p24 vdd__p6 6881.88
Rw1339 vdd__p24 vdd__p8 36376.5
Rw1340 vdd__p25 vdd__p36 187932
Rw1341 vdd__p25 vdd__p37 56879.2
Rw1342 vdd__p25 vdd__p38 104430
Rw1343 vdd__p26 vdd__p27 1007.61
Rw1344 vdd__p26 vdd__p28 1099.03
Rw1345 vdd__p26 vdd__p29 1361.37
Rw1346 vdd__p26 vdd__p3 300123
Rw1347 vdd__p26 vdd__p30 1464
Rw1348 vdd__p26 vdd__p31 1582.51
Rw1349 vdd__p26 vdd__p32 1703.63
Rw1350 vdd__p26 vdd__p33 1813.75
Rw1351 vdd__p26 vdd__p34 1957.42
Rw1352 vdd__p26 vdd__p36 111.141
Rw1353 vdd__p26 vdd__p37 452.196
Rw1354 vdd__p26 vdd__p38 830.233
Rw1355 vdd__p26 vdd__p5 459637
Rw1356 vdd__p26 vdd__p6 15407.1
Rw1357 vdd__p26 vdd__p8 81439.7
Rw1358 vdd__p27 vdd__p28 1041.47
Rw1359 vdd__p27 vdd__p29 1290.07
Rw1360 vdd__p27 vdd__p3 317930
Rw1361 vdd__p27 vdd__p30 1387.32
Rw1362 vdd__p27 vdd__p31 1499.63
Rw1363 vdd__p27 vdd__p32 1614.4
Rw1364 vdd__p27 vdd__p33 1718.75
Rw1365 vdd__p27 vdd__p34 1854.9
Rw1366 vdd__p27 vdd__p36 105.32
Rw1367 vdd__p27 vdd__p37 428.512
Rw1368 vdd__p27 vdd__p38 786.75
Rw1369 vdd__p27 vdd__p5 486908
Rw1370 vdd__p27 vdd__p6 14600.2
Rw1371 vdd__p27 vdd__p8 77174.4
Rw1372 vdd__p28 vdd__p29 1258.21
Rw1373 vdd__p28 vdd__p3 346776
Rw1374 vdd__p28 vdd__p30 1353.06
Rw1375 vdd__p28 vdd__p31 1462.59
Rw1376 vdd__p28 vdd__p32 1574.53
Rw1377 vdd__p28 vdd__p33 1676.31
Rw1378 vdd__p28 vdd__p34 1809.09
Rw1379 vdd__p28 vdd__p36 102.719
Rw1380 vdd__p28 vdd__p37 417.93
Rw1381 vdd__p28 vdd__p38 767.321
Rw1382 vdd__p28 vdd__p5 531085
Rw1383 vdd__p28 vdd__p6 14239.6
Rw1384 vdd__p28 vdd__p8 75268.5
Rw1385 vdd__p29 vdd__p3 429550
Rw1386 vdd__p29 vdd__p30 1093.26
Rw1387 vdd__p29 vdd__p31 1181.76
Rw1388 vdd__p29 vdd__p32 1272.2
Rw1389 vdd__p29 vdd__p33 1354.44
Rw1390 vdd__p29 vdd__p34 1461.73
Rw1391 vdd__p29 vdd__p36 82.996
Rw1392 vdd__p29 vdd__p37 337.682
Rw1393 vdd__p29 vdd__p38 619.986
Rw1394 vdd__p29 vdd__p5 657854
Rw1395 vdd__p29 vdd__p6 11505.5
Rw1396 vdd__p29 vdd__p8 60816
Rw1397 vdd__p3 vdd__p30 461932
Rw1398 vdd__p3 vdd__p31 499327
Rw1399 vdd__p3 vdd__p32 537542
Rw1400 vdd__p3 vdd__p33 572288
Rw1401 vdd__p3 vdd__p34 617621
Rw1402 vdd__p3 vdd__p36 35068.2
Rw1403 vdd__p3 vdd__p37 142680
Rw1404 vdd__p3 vdd__p38 261962
Rw1405 vdd__p3 vdd__p4 297.859
Rw1406 vdd__p3 vdd__p5 59.5579
Rw1407 vdd__p30 vdd__p31 1128.46
Rw1408 vdd__p30 vdd__p32 1214.83
Rw1409 vdd__p30 vdd__p33 1293.35
Rw1410 vdd__p30 vdd__p34 1395.81
Rw1411 vdd__p30 vdd__p36 79.2531
Rw1412 vdd__p30 vdd__p37 322.454
Rw1413 vdd__p30 vdd__p38 592.026
Rw1414 vdd__p30 vdd__p5 707446
Rw1415 vdd__p30 vdd__p6 10986.6
Rw1416 vdd__p30 vdd__p8 58073.4
Rw1417 vdd__p31 vdd__p32 1162.82
Rw1418 vdd__p31 vdd__p33 1237.98
Rw1419 vdd__p31 vdd__p34 1336.05
Rw1420 vdd__p31 vdd__p36 75.8599
Rw1421 vdd__p31 vdd__p37 308.648
Rw1422 vdd__p31 vdd__p38 566.679
Rw1423 vdd__p31 vdd__p5 764716
Rw1424 vdd__p31 vdd__p6 10516.2
Rw1425 vdd__p31 vdd__p8 55587
Rw1426 vdd__p32 vdd__p33 1176.59
Rw1427 vdd__p32 vdd__p34 1269.79
Rw1428 vdd__p32 vdd__p36 72.0981
Rw1429 vdd__p32 vdd__p37 293.343
Rw1430 vdd__p32 vdd__p38 538.578
Rw1431 vdd__p32 vdd__p5 823242
Rw1432 vdd__p32 vdd__p6 9994.72
Rw1433 vdd__p32 vdd__p8 52830.5
Rw1434 vdd__p33 vdd__p34 1189.56
Rw1435 vdd__p33 vdd__p36 67.5423
Rw1436 vdd__p33 vdd__p37 274.806
Rw1437 vdd__p33 vdd__p38 504.545
Rw1438 vdd__p33 vdd__p5 876455
Rw1439 vdd__p33 vdd__p6 9363.16
Rw1440 vdd__p33 vdd__p8 49492.2
Rw1441 vdd__p34 vdd__p36 31.2443
Rw1442 vdd__p34 vdd__p37 260.058
Rw1443 vdd__p34 vdd__p38 477.467
Rw1444 vdd__p34 vdd__p5 945883
Rw1445 vdd__p34 vdd__p6 8860.65
Rw1446 vdd__p34 vdd__p8 46836
Rw1447 vdd__p36 vdd__p37 14.7659
Rw1448 vdd__p36 vdd__p38 27.1103
Rw1449 vdd__p36 vdd__p4 268596
Rw1450 vdd__p36 vdd__p5 53706.7
Rw1451 vdd__p36 vdd__p6 503.103
Rw1452 vdd__p36 vdd__p8 2659.32
Rw1453 vdd__p37 vdd__p38 5.87665
Rw1454 vdd__p37 vdd__p5 218514
Rw1455 vdd__p37 vdd__p6 109.057
Rw1456 vdd__p37 vdd__p8 576.456
Rw1457 vdd__p38 vdd__p5 401193
Rw1458 vdd__p38 vdd__p6 68.9011
Rw1459 vdd__p38 vdd__p8 364.2
Rw1460 vdd__p4 vdd__p5 69.9669
Rw1461 vdd__p6 vdd__p7 12.8501
Rw1462 vdd__p6 vdd__p8 79.0852
Rw1463 vdd__p6 vdd__p9 73.4804
Rw1464 vdd__p7 vdd__p9 229.326
Rw1465 vref vref__p0 37.8501
Rw1466 vref vref__p1 36.462
Rw1467 vref vref__p11 36.7663
Rw1468 vref vref__p12 47.8742
Rw1469 vref vref__p2 34.0556
Rw1470 vref vref__p3 19.1317
Rw1471 vref vref__p4 39.0922
Rw1472 vref vref__p5 146.284
Rw1473 vref vref__p6 53.0763
Rw1474 vref vref__p7 188.985
Rw1475 vref vref__p8 63.294
Rw1476 vref vref__p9 65.7068
Rw1477 vref__p0 vref__p1 31.9297
Rw1478 vref__p0 vref__p11 53.8972
Rw1479 vref__p0 vref__p12 70.1805
Rw1480 vref__p0 vref__p2 39.3748
Rw1481 vref__p0 vref__p3 151.241
Rw1482 vref__p0 vref__p4 57.3067
Rw1483 vref__p0 vref__p5 214.444
Rw1484 vref__p0 vref__p6 77.8066
Rw1485 vref__p0 vref__p7 277.04
Rw1486 vref__p0 vref__p8 92.7851
Rw1487 vref__p0 vref__p9 96.322
Rw1488 vref__p1 vref__p11 51.9206
Rw1489 vref__p1 vref__p12 67.6068
Rw1490 vref__p1 vref__p2 37.9308
Rw1491 vref__p1 vref__p3 145.695
Rw1492 vref__p1 vref__p4 55.2051
Rw1493 vref__p1 vref__p5 206.579
Rw1494 vref__p1 vref__p6 74.9532
Rw1495 vref__p1 vref__p7 266.88
Rw1496 vref__p1 vref__p8 89.3824
Rw1497 vref__p1 vref__p9 92.7896
Rw1498 vref__p11 vref__p12 35.5995
Rw1499 vref__p11 vref__p2 48.494
Rw1500 vref__p11 vref__p3 141.005
Rw1501 vref__p11 vref__p4 37.6875
Rw1502 vref__p11 vref__p5 19.3163
Rw1503 vref__p11 vref__p6 39.4679
Rw1504 vref__p11 vref__p7 140.531
Rw1505 vref__p11 vref__p8 47.0658
Rw1506 vref__p11 vref__p9 48.86
Rw1507 vref__p12 vref__p2 63.145
Rw1508 vref__p12 vref__p3 183.605
Rw1509 vref__p12 vref__p4 49.0736
Rw1510 vref__p12 vref__p5 135.651
Rw1511 vref__p12 vref__p6 34.6862
Rw1512 vref__p12 vref__p7 18.9097
Rw1513 vref__p12 vref__p8 32.4965
Rw1514 vref__p12 vref__p9 33.7353
Rw1515 vref__p2 vref__p3 136.08
Rw1516 vref__p2 vref__p4 51.5617
Rw1517 vref__p2 vref__p5 192.946
Rw1518 vref__p2 vref__p6 70.0066
Rw1519 vref__p2 vref__p7 249.267
Rw1520 vref__p2 vref__p8 83.4835
Rw1521 vref__p2 vref__p9 86.6658
Rw1522 vref__p3 vref__p4 149.925
Rw1523 vref__p3 vref__p5 561.025
Rw1524 vref__p3 vref__p6 203.557
Rw1525 vref__p3 vref__p7 724.789
Rw1526 vref__p3 vref__p8 242.743
Rw1527 vref__p3 vref__p9 251.996
Rw1528 vref__p4 vref__p5 149.949
Rw1529 vref__p4 vref__p6 54.4061
Rw1530 vref__p4 vref__p7 193.72
Rw1531 vref__p4 vref__p8 64.8798
Rw1532 vref__p4 vref__p9 67.353
Rw1533 vref__p5 vref__p6 150.392
Rw1534 vref__p5 vref__p7 535.489
Rw1535 vref__p5 vref__p8 179.344
Rw1536 vref__p5 vref__p9 186.18
Rw1537 vref__p6 vref__p7 136.925
Rw1538 vref__p6 vref__p8 45.8584
Rw1539 vref__p6 vref__p9 47.6065
Rw1540 vref__p7 vref__p8 123.42
Rw1541 vref__p7 vref__p9 128.124
Rw1542 vref__p8 vref__p9 31.9637
Rw1543 vrefl vrefl__p0 36.1912
Rw1544 vrefl vrefl__p1 34.864
Rw1545 vrefl vrefl__p10 10873
Rw1546 vrefl vrefl__p11 10115.9
Rw1547 vrefl vrefl__p12 9688.32
Rw1548 vrefl vrefl__p13 11145.8
Rw1549 vrefl vrefl__p14 12654.8
Rw1550 vrefl vrefl__p15 14018.3
Rw1551 vrefl vrefl__p16 15067.5
Rw1552 vrefl vrefl__p17 15641.8
Rw1553 vrefl vrefl__p19 23.5375
Rw1554 vrefl vrefl__p2 32.4364
Rw1555 vrefl vrefl__p3 29.2813
Rw1556 vrefl vrefl__p4 34.6149
Rw1557 vrefl vrefl__p5 54.1611
Rw1558 vrefl vrefl__p6 29.6978
Rw1559 vrefl vrefl__p7 31.9204
Rw1560 vrefl vrefl__p8 33.1372
Rw1561 vrefl vrefl__p9 11286.9
Rw1562 vrefl__p0 vrefl__p1 28.5577
Rw1563 vrefl__p0 vrefl__p19 12228.9
Rw1564 vrefl__p0 vrefl__p2 33.8538
Rw1565 vrefl__p0 vrefl__p3 39.7034
Rw1566 vrefl__p0 vrefl__p4 371.992
Rw1567 vrefl__p0 vrefl__p5 105.073
Rw1568 vrefl__p0 vrefl__p6 57.614
Rw1569 vrefl__p0 vrefl__p7 61.9258
Rw1570 vrefl__p0 vrefl__p8 64.2864
Rw1571 vrefl__p1 vrefl__p19 11780.5
Rw1572 vrefl__p1 vrefl__p2 32.6123
Rw1573 vrefl__p1 vrefl__p3 38.2473
Rw1574 vrefl__p1 vrefl__p4 358.35
Rw1575 vrefl__p1 vrefl__p5 101.22
Rw1576 vrefl__p1 vrefl__p6 55.5011
Rw1577 vrefl__p1 vrefl__p7 59.6548
Rw1578 vrefl__p1 vrefl__p8 61.9288
Rw1579 vrefl__p10 vrefl__p11 34.923
Rw1580 vrefl__p10 vrefl__p12 155.608
Rw1581 vrefl__p10 vrefl__p13 47.5836
Rw1582 vrefl__p10 vrefl__p14 54.0259
Rw1583 vrefl__p10 vrefl__p15 59.8471
Rw1584 vrefl__p10 vrefl__p16 64.3261
Rw1585 vrefl__p10 vrefl__p17 66.7782
Rw1586 vrefl__p10 vrefl__p19 32.2863
Rw1587 vrefl__p10 vrefl__p9 30.1219
Rw1588 vrefl__p11 vrefl__p12 144.773
Rw1589 vrefl__p11 vrefl__p13 44.2704
Rw1590 vrefl__p11 vrefl__p14 50.264
Rw1591 vrefl__p11 vrefl__p15 55.6799
Rw1592 vrefl__p11 vrefl__p16 59.847
Rw1593 vrefl__p11 vrefl__p17 62.1284
Rw1594 vrefl__p11 vrefl__p19 30.0382
Rw1595 vrefl__p11 vrefl__p9 36.2525
Rw1596 vrefl__p12 vrefl__p13 149.347
Rw1597 vrefl__p12 vrefl__p14 169.567
Rw1598 vrefl__p12 vrefl__p15 187.838
Rw1599 vrefl__p12 vrefl__p16 201.896
Rw1600 vrefl__p12 vrefl__p17 209.592
Rw1601 vrefl__p12 vrefl__p19 28.7686
Rw1602 vrefl__p12 vrefl__p9 161.532
Rw1603 vrefl__p13 vrefl__p14 39.159
Rw1604 vrefl__p13 vrefl__p15 43.3783
Rw1605 vrefl__p13 vrefl__p16 46.6247
Rw1606 vrefl__p13 vrefl__p17 48.4021
Rw1607 vrefl__p13 vrefl__p19 33.0964
Rw1608 vrefl__p13 vrefl__p9 49.3951
Rw1609 vrefl__p14 vrefl__p15 37.0529
Rw1610 vrefl__p14 vrefl__p16 39.826
Rw1611 vrefl__p14 vrefl__p17 41.3441
Rw1612 vrefl__p14 vrefl__p19 37.5772
Rw1613 vrefl__p14 vrefl__p9 56.0826
Rw1614 vrefl__p15 vrefl__p16 33.6385
Rw1615 vrefl__p15 vrefl__p17 34.9208
Rw1616 vrefl__p15 vrefl__p19 41.6261
Rw1617 vrefl__p15 vrefl__p9 62.1254
Rw1618 vrefl__p16 vrefl__p17 29.2596
Rw1619 vrefl__p16 vrefl__p19 44.7414
Rw1620 vrefl__p16 vrefl__p9 66.7749
Rw1621 vrefl__p17 vrefl__p19 46.447
Rw1622 vrefl__p17 vrefl__p9 69.3204
Rw1623 vrefl__p19 vrefl__p2 10960.2
Rw1624 vrefl__p19 vrefl__p3 9894.09
Rw1625 vrefl__p19 vrefl__p4 11696.3
Rw1626 vrefl__p19 vrefl__p5 18300.9
Rw1627 vrefl__p19 vrefl__p6 10034.8
Rw1628 vrefl__p19 vrefl__p7 10785.8
Rw1629 vrefl__p19 vrefl__p8 11197
Rw1630 vrefl__p19 vrefl__p9 33.5155
Rw1631 vrefl__p2 vrefl__p3 35.5842
Rw1632 vrefl__p2 vrefl__p4 333.398
Rw1633 vrefl__p2 vrefl__p5 94.1716
Rw1634 vrefl__p2 vrefl__p6 51.6365
Rw1635 vrefl__p2 vrefl__p7 55.501
Rw1636 vrefl__p2 vrefl__p8 57.6167
Rw1637 vrefl__p3 vrefl__p4 300.968
Rw1638 vrefl__p3 vrefl__p5 85.0116
Rw1639 vrefl__p3 vrefl__p6 46.6139
Rw1640 vrefl__p3 vrefl__p7 50.1025
Rw1641 vrefl__p3 vrefl__p8 52.0124
Rw1642 vrefl__p4 vrefl__p5 556.696
Rw1643 vrefl__p4 vrefl__p6 305.25
Rw1644 vrefl__p4 vrefl__p7 328.094
Rw1645 vrefl__p4 vrefl__p8 340.601
Rw1646 vrefl__p5 vrefl__p6 70.567
Rw1647 vrefl__p5 vrefl__p7 75.8482
Rw1648 vrefl__p5 vrefl__p8 78.7396
Rw1649 vrefl__p6 vrefl__p7 32.6227
Rw1650 vrefl__p6 vrefl__p8 33.8663
Rw1651 vrefl__p7 vrefl__p8 28.5662
Rw1652 xc4_din xc4_din__p1 50.079
Rw1653 xc4_din xc4_din__p2 545.998
Rw1654 xc4_din__p1 xc4_din__p2 132.076
Rw1655 xc4_dip xc4_dip__p1 47.4141
Rw1656 xc4_dip xc4_dip__p2 510.375
Rw1657 xc4_dip__p1 xc4_dip__p2 134.889
Rw1658 xc4_lt xc4_lt__p1 10.8365
Rw1659 xc4_lt xc4_lt__p2 12.6193
Rw1660 xc4_lt__p1 xc4_lt__p2 120.796
Rw1661 xc4_outnb xc4_outnb__p1 47.718
Rw1662 xc4_outpb xc4_outpb__p1 47.4062
Rw1663 xc4_xs1_tail xc4_xs1_tail__p1 71.5986
Rw1664 xc4_xs1_tail xc4_xs1_tail__p2 142.261
Rw1665 xc4_xs1_tail__p1 xc4_xs1_tail__p2 154.206
Rw1666 xc4_xs1_tail0 xc4_xs1_tail0__p1 29.2884
Rw1667 xc5_din xc5_din__p1 130.063
Rw1668 xc5_din xc5_din__p2 74.042
Rw1669 xc5_din__p1 xc5_din__p2 66.6396
Rw1670 xc5_dip xc5_dip__p1 129.665
Rw1671 xc5_dip xc5_dip__p2 75.5526
Rw1672 xc5_dip__p1 xc5_dip__p2 65.1387
Rw1673 xc5_lt xc5_lt__p1 166.767
Rw1674 xc5_lt xc5_lt__p2 166.904
Rw1675 xc5_lt__p1 xc5_lt__p2 20.8804
Rw1676 xc5_outnb xc5_outnb__p1 44.1702
Rw1677 xc5_outpb xc5_outpb__p1 44.13
Rw1678 xc5_xs1_tail xc5_xs1_tail__p1 59.2156
Rw1679 xc5_xs1_tail__p1 xc5_xs1_tail__p2 19.0185
Rw1680 xc5_xs1_tail0 xc5_xs1_tail0__p1 29.0295
Rw1681 xs0n_cbn xs0n_cbn__p1 1089.56
Rw1682 xs0n_cbn xs0n_cbn__p2 16589.4
Rw1683 xs0n_cbn xs0n_cbn__p3 784.446
Rw1684 xs0n_cbn xs0n_cbn__p4 21.0451
Rw1685 xs0n_cbn__p1 xs0n_cbn__p2 9.96169
Rw1686 xs0n_cbn__p1 xs0n_cbn__p3 1561.64
Rw1687 xs0n_cbn__p1 xs0n_cbn__p4 21.0507
Rw1688 xs0n_cbn__p2 xs0n_cbn__p3 23777.3
Rw1689 xs0n_cbn__p2 xs0n_cbn__p4 320.514
Rw1690 xs0n_cbn__p3 xs0n_cbn__p4 30.1636
Rw1691 xs0n_cbp xs0n_cbp__p1 9.57598
Rw1692 xs0n_cbp xs0n_cbp__p2 59.1671
Rw1693 xs0n_cbp__p1 xs0n_cbp__p2 1243.71
Rw1694 xs0n_g xs0n_g__p1 0.67694
Rw1695 xs0n_g__p1 xs0n_g__p2 24.2416
Rw1696 xs0n_g__p1 xs0n_g__p3 150.395
Rw1697 xs0n_g__p1 xs0n_g__p4 168.461
Rw1698 xs0n_g__p1 xs0n_g__p5 530.563
Rw1699 xs0n_g__p2 xs0n_g__p3 120.065
Rw1700 xs0n_g__p2 xs0n_g__p4 134.488
Rw1701 xs0n_g__p2 xs0n_g__p5 423.564
Rw1702 xs0n_g__p3 xs0n_g__p4 25.4716
Rw1703 xs0n_g__p3 xs0n_g__p5 80.2217
Rw1704 xs0n_g__p4 xs0n_g__p5 73.9032
Rw1705 xs0n_n10 xs0n_n10__p1 46.1685
Rw1706 xs0n_x xs0n_x__p1 1.00106
Rw1707 xs0n_x xs0n_x__p2 42.3238
Rw1708 xs0n_x xs0n_x__p3 128.542
Rw1709 xs0n_x__p1 xs0n_x__p2 59.8854
Rw1710 xs0n_x__p1 xs0n_x__p3 181.879
Rw1711 xs0n_x__p2 xs0n_x__p3 62.5209
Rw1712 xs0p_cbn xs0p_cbn__p1 90.3104
Rw1713 xs0p_cbn xs0p_cbn__p2 2073.02
Rw1714 xs0p_cbn xs0p_cbn__p3 36.3159
Rw1715 xs0p_cbn xs0p_cbn__p4 107.321
Rw1716 xs0p_cbn__p1 xs0p_cbn__p2 9.87285
Rw1717 xs0p_cbn__p1 xs0p_cbn__p3 160.393
Rw1718 xs0p_cbn__p1 xs0p_cbn__p4 26.4214
Rw1719 xs0p_cbn__p2 xs0p_cbn__p3 3681.73
Rw1720 xs0p_cbn__p2 xs0p_cbn__p4 606.486
Rw1721 xs0p_cbn__p3 xs0p_cbn__p4 190.604
Rw1722 xs0p_cbp xs0p_cbp__p1 9.5749
Rw1723 xs0p_cbp xs0p_cbp__p2 60.089
Rw1724 xs0p_cbp__p1 xs0p_cbp__p2 1263.09
Rw1725 xs0p_g xs0p_g__p1 0.67694
Rw1726 xs0p_g__p1 xs0p_g__p2 25.3095
Rw1727 xs0p_g__p1 xs0p_g__p3 210.736
Rw1728 xs0p_g__p1 xs0p_g__p4 198.917
Rw1729 xs0p_g__p1 xs0p_g__p5 133.595
Rw1730 xs0p_g__p2 xs0p_g__p3 167.229
Rw1731 xs0p_g__p2 xs0p_g__p4 157.85
Rw1732 xs0p_g__p2 xs0p_g__p5 106.014
Rw1733 xs0p_g__p3 xs0p_g__p4 23.652
Rw1734 xs0p_g__p3 xs0p_g__p5 102.411
Rw1735 xs0p_g__p4 xs0p_g__p5 96.6677
Rw1736 xs0p_n10 xs0p_n10__p1 46.1685
Rw1737 xs0p_x xs0p_x__p1 1.00103
Rw1738 xs0p_x xs0p_x__p2 42.4237
Rw1739 xs0p_x xs0p_x__p3 128.846
Rw1740 xs0p_x__p1 xs0p_x__p2 60.0267
Rw1741 xs0p_x__p1 xs0p_x__p3 182.308
Rw1742 xs0p_x__p2 xs0p_x__p3 62.4292
Rw1743 xs1n_cbn xs1n_cbn__p1 31.8519
Rw1744 xs1n_cbn xs1n_cbn__p2 1322.86
Rw1745 xs1n_cbn xs1n_cbn__p3 4642.13
Rw1746 xs1n_cbn xs1n_cbn__p4 31.2064
Rw1747 xs1n_cbn__p1 xs1n_cbn__p2 9.86018
Rw1748 xs1n_cbn__p1 xs1n_cbn__p3 4014.48
Rw1749 xs1n_cbn__p1 xs1n_cbn__p4 26.987
Rw1750 xs1n_cbn__p2 xs1n_cbn__p3 166728
Rw1751 xs1n_cbn__p2 xs1n_cbn__p4 1120.82
Rw1752 xs1n_cbn__p3 xs1n_cbn__p4 29.2982
Rw1753 xs1n_cbp xs1n_cbp__p1 9.54422
Rw1754 xs1n_cbp xs1n_cbp__p2 58.8
Rw1755 xs1n_cbp__p1 xs1n_cbp__p2 1320.09
Rw1756 xs1n_g xs1n_g__p1 0.6347
Rw1757 xs1n_g__p1 xs1n_g__p2 24.2895
Rw1758 xs1n_g__p1 xs1n_g__p3 175.634
Rw1759 xs1n_g__p1 xs1n_g__p4 203.273
Rw1760 xs1n_g__p1 xs1n_g__p5 241.574
Rw1761 xs1n_g__p2 xs1n_g__p3 140.557
Rw1762 xs1n_g__p2 xs1n_g__p4 162.676
Rw1763 xs1n_g__p2 xs1n_g__p5 193.328
Rw1764 xs1n_g__p3 xs1n_g__p4 30.8519
Rw1765 xs1n_g__p3 xs1n_g__p5 36.6651
Rw1766 xs1n_g__p4 xs1n_g__p5 33.514
Rw1767 xs1n_n10 xs1n_n10__p1 10.7757
Rw1768 xs1n_x xs1n_x__p1 1.43436
Rw1769 xs1n_x xs1n_x__p2 61.0361
Rw1770 xs1n_x xs1n_x__p3 177.702
Rw1771 xs1n_x__p1 xs1n_x__p2 42.6192
Rw1772 xs1n_x__p1 xs1n_x__p3 124.083
Rw1773 xs1n_x__p2 xs1n_x__p3 61.9394
Rw1774 xs1p_cbn xs1p_cbn__p1 90.6795
Rw1775 xs1p_cbn xs1p_cbn__p2 1917.8
Rw1776 xs1p_cbn xs1p_cbn__p3 36.2644
Rw1777 xs1p_cbn xs1p_cbn__p4 107.009
Rw1778 xs1p_cbn__p1 xs1p_cbn__p2 9.94467
Rw1779 xs1p_cbn__p1 xs1p_cbn__p3 161.481
Rw1780 xs1p_cbn__p1 xs1p_cbn__p4 26.5667
Rw1781 xs1p_cbn__p2 xs1p_cbn__p3 3415.2
Rw1782 xs1p_cbn__p2 xs1p_cbn__p4 561.866
Rw1783 xs1p_cbn__p3 xs1p_cbn__p4 190.561
Rw1784 xs1p_cbp xs1p_cbp__p1 9.54302
Rw1785 xs1p_cbp xs1p_cbp__p2 59.8889
Rw1786 xs1p_cbp__p1 xs1p_cbp__p2 1344.53
Rw1787 xs1p_g xs1p_g__p1 0.6347
Rw1788 xs1p_g__p1 xs1p_g__p2 25.0282
Rw1789 xs1p_g__p1 xs1p_g__p3 227.075
Rw1790 xs1p_g__p1 xs1p_g__p4 204.371
Rw1791 xs1p_g__p1 xs1p_g__p5 130.835
Rw1792 xs1p_g__p2 xs1p_g__p3 181.724
Rw1793 xs1p_g__p2 xs1p_g__p4 163.555
Rw1794 xs1p_g__p2 xs1p_g__p5 104.705
Rw1795 xs1p_g__p3 xs1p_g__p4 24.22
Rw1796 xs1p_g__p3 xs1p_g__p5 104.731
Rw1797 xs1p_g__p4 xs1p_g__p5 94.2599
Rw1798 xs1p_n10 xs1p_n10__p1 46.209
Rw1799 xs1p_x xs1p_x__p1 1.00105
Rw1800 xs1p_x xs1p_x__p2 42.5398
Rw1801 xs1p_x xs1p_x__p3 126.923
Rw1802 xs1p_x__p1 xs1p_x__p2 60.1909
Rw1803 xs1p_x__p1 xs1p_x__p3 179.588
Rw1804 xs1p_x__p2 xs1p_x__p3 61.4978
Cp0 bn0 bn1 2.453e-16
Cp1 bn0 bn10 4.539e-17
Cp2 bn0 bn11 4.486e-17
Cp3 bn0 bn12 6.037e-17
Cp4 bn0 bn2 7.057e-15
Cp5 bn0 bn3 2.247e-16
Cp6 bn0 bn4 2.663e-16
Cp7 bn0 bn5 1.004e-15
Cp8 bn0 bn6 9.647e-16
Cp9 bn0 bn7 1.72e-15
Cp10 bn0 bn8 4.759e-17
Cp11 bn0 bn9 4.682e-17
Cp12 bn0 bp11 1.837e-16
Cp13 bn0 bp12 6.813e-16
Cp14 bn0 cn0 6.999e-16
Cp15 bn0 cn1 2.046e-16
Cp16 bn0 cn10 4.723e-17
Cp17 bn0 cn11 4.944e-17
Cp18 bn0 cn12 5.082e-17
Cp19 bn0 cn2 1.58e-16
Cp20 bn0 cn3 1.863e-16
Cp21 bn0 cn4 1.463e-16
Cp22 bn0 cn5 6.454e-17
Cp23 bn0 cn6 1.559e-16
Cp24 bn0 cn7 7.723e-17
Cp25 bn0 cn8 1.526e-16
Cp26 bn0 cn9 7.977e-17
Cp27 bn0 cp10 4.285e-19
Cp28 bn0 cp11 5.485e-17
Cp29 bn0 cp12 9.435e-17
Cp30 bn0 gnd 3.037e-15
Cp31 bn0 lsb_n 2.271e-16
Cp32 bn0 on 1.895e-16
Cp33 bn0 op 1.134e-16
Cp34 bn0 vdd 4.063e-17
Cp35 bn0 vrefl 7.354e-16
Cp36 bn0 xc4_din 1.034e-16
Cp37 bn0 xc4_dip 1.62e-16
Cp38 bn0 xc4_outnb 5.524e-17
Cp39 bn0 xc4_outpb 2.678e-17
Cp40 bn1 bn10 7.366e-17
Cp41 bn1 bn11 5.327e-16
Cp42 bn1 bn12 5.054e-16
Cp43 bn1 bn2 1.025e-15
Cp44 bn1 bn3 8.078e-16
Cp45 bn1 bn4 5.045e-16
Cp46 bn1 bn5 1.047e-15
Cp47 bn1 bn6 1.975e-15
Cp48 bn1 bn7 1.573e-15
Cp49 bn1 bn8 5.488e-17
Cp50 bn1 bn9 5.508e-17
Cp51 bn1 bp12 1.302e-17
Cp52 bn1 cn0 6.511e-18
Cp53 bn1 cn1 5.659e-16
Cp54 bn1 cn10 6.124e-17
Cp55 bn1 cn11 1.302e-16
Cp56 bn1 cn12 1.224e-16
Cp57 bn1 cn2 8.994e-17
Cp58 bn1 cn3 5.156e-17
Cp59 bn1 cn4 6.843e-17
Cp60 bn1 cn5 7.204e-17
Cp61 bn1 cn6 5.111e-17
Cp62 bn1 cn7 5.104e-17
Cp63 bn1 cn8 5.131e-17
Cp64 bn1 cn9 5.539e-17
Cp65 bn1 cp12 1.831e-17
Cp66 bn1 gnd 2.099e-15
Cp67 bn1 lsb_n 4.428e-16
Cp68 bn1 on 1.015e-16
Cp69 bn1 op 1.501e-16
Cp70 bn1 vdd 2.948e-16
Cp71 bn1 vrefl 6.295e-16
Cp72 bn1 xc4_din 9.482e-17
Cp73 bn1 xc4_dip 1.347e-15
Cp74 bn1 xc4_outnb 5.479e-17
Cp75 bn1 xc4_outpb 2.967e-17
Cp76 bn10 bn11 2.088e-14
Cp77 bn10 bn12 5.857e-15
Cp78 bn10 bn2 3.845e-17
Cp79 bn10 bn3 3.845e-17
Cp80 bn10 bn4 3.845e-17
Cp81 bn10 bn5 4.892e-16
Cp82 bn10 bn6 2.085e-15
Cp83 bn10 bn7 2.301e-15
Cp84 bn10 bn8 1.114e-15
Cp85 bn10 bn9 1.299e-14
Cp86 bn10 bp0 4.911e-17
Cp87 bn10 bp1 4.662e-17
Cp88 bn10 bp10 2.248e-15
Cp89 bn10 bp11 5.365e-17
Cp90 bn10 bp12 3.882e-17
Cp91 bn10 bp2 4.145e-17
Cp92 bn10 bp3 3.846e-17
Cp93 bn10 bp4 3.882e-17
Cp94 bn10 bp5 3.882e-17
Cp95 bn10 bp6 3.882e-17
Cp96 bn10 bp7 3.882e-17
Cp97 bn10 bp8 2.021e-16
Cp98 bn10 bp9 7.85e-17
Cp99 bn10 clkb 2.703e-17
Cp100 bn10 clkn 3.68e-17
Cp101 bn10 cn0 3.24e-17
Cp102 bn10 cn1 3.852e-17
Cp103 bn10 cn10 5.553e-16
Cp104 bn10 cn11 7.476e-16
Cp105 bn10 cn12 4.036e-17
Cp106 bn10 cn2 3.24e-17
Cp107 bn10 cn3 3.977e-17
Cp108 bn10 cn4 3.24e-17
Cp109 bn10 cn5 4.026e-17
Cp110 bn10 cn6 5.504e-17
Cp111 bn10 cn7 1.244e-16
Cp112 bn10 cn8 1.073e-16
Cp113 bn10 cn9 3.425e-16
Cp114 bn10 cp0 4.691e-17
Cp115 bn10 cp1 4.747e-17
Cp116 bn10 cp10 3.799e-17
Cp117 bn10 cp11 3.799e-17
Cp118 bn10 cp12 3.799e-17
Cp119 bn10 cp2 4.691e-17
Cp120 bn10 cp3 4.117e-17
Cp121 bn10 cp4 4.009e-17
Cp122 bn10 cp5 3.311e-17
Cp123 bn10 cp6 3.357e-17
Cp124 bn10 cp7 3.289e-17
Cp125 bn10 cp8 6.571e-17
Cp126 bn10 cp9 3.799e-17
Cp127 bn10 gnd 4.674e-15
Cp128 bn10 lsb_n 6.709e-16
Cp129 bn10 lsb_p 2.444e-16
Cp130 bn10 on 3.713e-17
Cp131 bn10 onp 1.628e-19
Cp132 bn10 op 3.311e-17
Cp133 bn10 rstb 1.456e-16
Cp134 bn10 vdd 3.565e-17
Cp135 bn10 vref 1.201e-15
Cp136 bn10 xc4_din 1.058e-16
Cp137 bn10 xc4_dip 2.133e-16
Cp138 bn11 bn12 3.436e-14
Cp139 bn11 bn2 3.792e-17
Cp140 bn11 bn3 3.792e-17
Cp141 bn11 bn4 3.792e-17
Cp142 bn11 bn5 6.931e-17
Cp143 bn11 bn6 2.96e-15
Cp144 bn11 bn7 3.34e-15
Cp145 bn11 bn8 5.258e-16
Cp146 bn11 bn9 5.975e-16
Cp147 bn11 bp0 9.649e-17
Cp148 bn11 bp1 3.792e-17
Cp149 bn11 bp10 5.724e-16
Cp150 bn11 bp11 4.597e-15
Cp151 bn11 bp12 2.96e-16
Cp152 bn11 bp2 3.275e-17
Cp153 bn11 bp3 3.846e-17
Cp154 bn11 bp4 4.971e-17
Cp155 bn11 bp5 4.698e-16
Cp156 bn11 bp6 4.754e-16
Cp157 bn11 bp7 5.071e-17
Cp158 bn11 bp8 1.873e-16
Cp159 bn11 bp9 2.237e-16
Cp160 bn11 clkb 3.549e-17
Cp161 bn11 clkn 3.915e-17
Cp162 bn11 cn0 2.596e-17
Cp163 bn11 cn1 3.186e-17
Cp164 bn11 cn10 2.678e-16
Cp165 bn11 cn11 4.527e-16
Cp166 bn11 cn12 6.907e-16
Cp167 bn11 cn2 2.574e-17
Cp168 bn11 cn3 6.985e-17
Cp169 bn11 cn4 2.559e-17
Cp170 bn11 cn5 1.153e-16
Cp171 bn11 cn6 3.278e-17
Cp172 bn11 cn7 6.503e-17
Cp173 bn11 cn8 4.726e-17
Cp174 bn11 cn9 8.05e-16
Cp175 bn11 cp0 3.255e-17
Cp176 bn11 cp1 7.792e-17
Cp177 bn11 cp10 1.165e-16
Cp178 bn11 cp11 5.647e-17
Cp179 bn11 cp12 4.002e-17
Cp180 bn11 cp2 3.255e-17
Cp181 bn11 cp3 2.965e-17
Cp182 bn11 cp4 2.574e-17
Cp183 bn11 cp5 9.671e-17
Cp184 bn11 cp6 3.357e-17
Cp185 bn11 cp7 5.33e-17
Cp186 bn11 cp8 3.919e-17
Cp187 bn11 cp9 8e-17
Cp188 bn11 gnd 5.421e-15
Cp189 bn11 lsb_n 6.01e-16
Cp190 bn11 lsb_p 3.851e-17
Cp191 bn11 on 3.186e-17
Cp192 bn11 onp 1.17e-16
Cp193 bn11 op 3.351e-17
Cp194 bn11 rstb 1.185e-16
Cp195 bn11 vdd 2.406e-17
Cp196 bn11 vref 9.161e-16
Cp197 bn11 xc4_din 1.075e-16
Cp198 bn11 xc4_dip 7.097e-17
Cp199 bn12 bn2 3.882e-17
Cp200 bn12 bn3 3.882e-17
Cp201 bn12 bn4 3.882e-17
Cp202 bn12 bn5 4.317e-17
Cp203 bn12 bn6 5.074e-15
Cp204 bn12 bn7 5.504e-15
Cp205 bn12 bn8 1.243e-15
Cp206 bn12 bn9 3.1e-15
Cp207 bn12 bp0 4.93e-16
Cp208 bn12 bp1 4.199e-16
Cp209 bn12 bp10 3.477e-16
Cp210 bn12 bp11 5.515e-16
Cp211 bn12 bp12 1.022e-14
Cp212 bn12 bp2 4.482e-17
Cp213 bn12 bp3 3.104e-16
Cp214 bn12 bp4 5.713e-16
Cp215 bn12 bp5 8.047e-17
Cp216 bn12 bp6 7.773e-17
Cp217 bn12 bp7 5.569e-16
Cp218 bn12 bp8 8.083e-16
Cp219 bn12 bp9 8.831e-16
Cp220 bn12 clkb 4.943e-17
Cp221 bn12 clkn 8.496e-17
Cp222 bn12 cn0 7.86e-17
Cp223 bn12 cn1 8.131e-17
Cp224 bn12 cn10 3.03e-16
Cp225 bn12 cn11 2.568e-16
Cp226 bn12 cn12 9.765e-16
Cp227 bn12 cn2 7.649e-17
Cp228 bn12 cn3 9.572e-17
Cp229 bn12 cn4 8.256e-17
Cp230 bn12 cn5 9.749e-17
Cp231 bn12 cn6 1.172e-16
Cp232 bn12 cn7 9.73e-17
Cp233 bn12 cn8 1.096e-16
Cp234 bn12 cn9 1.029e-16
Cp235 bn12 cp0 9.851e-17
Cp236 bn12 cp1 7.198e-17
Cp237 bn12 cp10 4.202e-17
Cp238 bn12 cp11 9.82e-17
Cp239 bn12 cp12 1.905e-16
Cp240 bn12 cp2 5.39e-17
Cp241 bn12 cp3 2.965e-17
Cp242 bn12 cp4 4.395e-17
Cp243 bn12 cp5 4.973e-17
Cp244 bn12 cp6 3.357e-17
Cp245 bn12 cp7 6.653e-17
Cp246 bn12 cp8 1.152e-16
Cp247 bn12 cp9 7.393e-17
Cp248 bn12 gnd 7.758e-15
Cp249 bn12 lsb_n 1.732e-14
Cp250 bn12 lsb_p 3.336e-16
Cp251 bn12 on 4.877e-17
Cp252 bn12 onp 1.289e-16
Cp253 bn12 op 7.339e-17
Cp254 bn12 rstb 1.523e-16
Cp255 bn12 top_n 1.311e-17
Cp256 bn12 vdd 2.817e-17
Cp257 bn12 vref 1.374e-15
Cp258 bn12 xc4_din 1.372e-16
Cp259 bn12 xc4_dip 8.934e-17
Cp260 bn2 bn3 1.443e-14
Cp261 bn2 bn4 4.306e-16
Cp262 bn2 bn5 3.373e-15
Cp263 bn2 bn6 1.876e-15
Cp264 bn2 bn7 2.699e-15
Cp265 bn2 bn8 4.065e-17
Cp266 bn2 bn9 3.988e-17
Cp267 bn2 bp0 5.211e-16
Cp268 bn2 bp1 4.677e-16
Cp269 bn2 bp10 4.595e-17
Cp270 bn2 bp11 4.598e-17
Cp271 bn2 bp12 3.024e-17
Cp272 bn2 bp2 5.659e-17
Cp273 bn2 bp3 4.685e-17
Cp274 bn2 bp4 4.632e-17
Cp275 bn2 bp5 4.632e-17
Cp276 bn2 bp6 4.632e-17
Cp277 bn2 bp7 4.632e-17
Cp278 bn2 bp8 4.776e-17
Cp279 bn2 bp9 4.542e-17
Cp280 bn2 clkn 4.918e-17
Cp281 bn2 cn0 5.865e-17
Cp282 bn2 cn1 8.908e-17
Cp283 bn2 cn10 3.688e-17
Cp284 bn2 cn11 3.799e-17
Cp285 bn2 cn12 3.799e-17
Cp286 bn2 cn2 7.964e-16
Cp287 bn2 cn3 9.587e-17
Cp288 bn2 cn4 1.481e-16
Cp289 bn2 cn5 4.362e-17
Cp290 bn2 cn6 4.949e-17
Cp291 bn2 cn7 3.324e-17
Cp292 bn2 cn8 5.241e-17
Cp293 bn2 cn9 7.828e-17
Cp294 bn2 cp0 8.862e-17
Cp295 bn2 cp1 3.633e-17
Cp296 bn2 cp10 5.037e-17
Cp297 bn2 cp11 5.037e-17
Cp298 bn2 cp12 3.799e-17
Cp299 bn2 cp2 6.625e-17
Cp300 bn2 cp3 4.202e-17
Cp301 bn2 cp4 2.188e-17
Cp302 bn2 cp5 5.274e-17
Cp303 bn2 cp6 4.594e-17
Cp304 bn2 cp7 6.84e-17
Cp305 bn2 cp8 5.994e-17
Cp306 bn2 cp9 5.152e-17
Cp307 bn2 gnd 3.062e-15
Cp308 bn2 lsb_n 1.58e-16
Cp309 bn2 lsb_p 4.776e-17
Cp310 bn2 on 7.043e-17
Cp311 bn2 op 4.766e-16
Cp312 bn2 vdd 1.185e-16
Cp313 bn2 vrefl 6.626e-16
Cp314 bn2 xc4_din 9.621e-17
Cp315 bn2 xc4_dip 3.764e-16
Cp316 bn2 xc4_outnb 5.815e-17
Cp317 bn2 xc4_outpb 9.793e-17
Cp318 bn3 bn4 2.36e-14
Cp319 bn3 bn5 5.931e-15
Cp320 bn3 bn6 3.468e-15
Cp321 bn3 bn7 3.98e-15
Cp322 bn3 bn8 4.065e-17
Cp323 bn3 bn9 3.988e-17
Cp324 bn3 bp0 4.399e-17
Cp325 bn3 bp1 3.601e-17
Cp326 bn3 bp10 3.845e-17
Cp327 bn3 bp11 3.849e-17
Cp328 bn3 bp12 3.024e-17
Cp329 bn3 bp2 3.845e-17
Cp330 bn3 bp3 3.935e-17
Cp331 bn3 bp4 3.882e-17
Cp332 bn3 bp5 3.882e-17
Cp333 bn3 bp6 7.995e-17
Cp334 bn3 bp7 6.755e-16
Cp335 bn3 bp8 4.026e-17
Cp336 bn3 bp9 3.792e-17
Cp337 bn3 clkb 5.08e-17
Cp338 bn3 clkn 3.68e-17
Cp339 bn3 cn0 4.451e-17
Cp340 bn3 cn1 3.204e-17
Cp341 bn3 cn10 3.799e-17
Cp342 bn3 cn11 3.799e-17
Cp343 bn3 cn12 3.799e-17
Cp344 bn3 cn2 3.105e-17
Cp345 bn3 cn3 3.707e-16
Cp346 bn3 cn4 9.648e-17
Cp347 bn3 cn5 1.326e-16
Cp348 bn3 cn6 7.178e-17
Cp349 bn3 cn7 8.295e-17
Cp350 bn3 cn8 4.549e-17
Cp351 bn3 cn9 4.77e-17
Cp352 bn3 cp0 4.554e-17
Cp353 bn3 cp1 4.61e-17
Cp354 bn3 cp10 3.799e-17
Cp355 bn3 cp11 3.799e-17
Cp356 bn3 cp12 3.799e-17
Cp357 bn3 cp2 3.255e-17
Cp358 bn3 cp3 2.965e-17
Cp359 bn3 cp4 3.873e-17
Cp360 bn3 cp5 5.102e-17
Cp361 bn3 cp6 3.357e-17
Cp362 bn3 cp7 3.786e-17
Cp363 bn3 cp8 7.027e-17
Cp364 bn3 cp9 3.882e-17
Cp365 bn3 gnd 4.41e-15
Cp366 bn3 lsb_n 2.123e-16
Cp367 bn3 lsb_p 3.398e-16
Cp368 bn3 on 3.309e-17
Cp369 bn3 onp 7.234e-17
Cp370 bn3 op 4.92e-17
Cp371 bn3 vdd 2.703e-16
Cp372 bn3 vrefl 1.328e-15
Cp373 bn3 xc4_din 1.14e-16
Cp374 bn3 xc4_dip 5.338e-16
Cp375 bn3 xc4_outnb 1.24e-16
Cp376 bn3 xc4_outpb 2.503e-19
Cp377 bn4 bn5 3.789e-14
Cp378 bn4 bn6 5.494e-15
Cp379 bn4 bn7 5.631e-15
Cp380 bn4 bn8 5.675e-16
Cp381 bn4 bn9 2.682e-16
Cp382 bn4 bp0 3.777e-17
Cp383 bn4 bp1 3.601e-17
Cp384 bn4 bp10 4.598e-17
Cp385 bn4 bp11 3.849e-17
Cp386 bn4 bp12 3.024e-17
Cp387 bn4 bp2 3.845e-17
Cp388 bn4 bp3 3.181e-16
Cp389 bn4 bp4 6.238e-16
Cp390 bn4 bp5 8.256e-17
Cp391 bn4 bp6 3.882e-17
Cp392 bn4 bp7 2.969e-17
Cp393 bn4 bp8 5.161e-16
Cp394 bn4 bp9 4.129e-16
Cp395 bn4 clkb 2.574e-17
Cp396 bn4 clkn 8.899e-17
Cp397 bn4 cn0 2.584e-17
Cp398 bn4 cn1 3.186e-17
Cp399 bn4 cn10 3.814e-17
Cp400 bn4 cn11 3.799e-17
Cp401 bn4 cn12 3.799e-17
Cp402 bn4 cn2 2.574e-17
Cp403 bn4 cn3 4.96e-17
Cp404 bn4 cn4 9.092e-16
Cp405 bn4 cn5 3.374e-16
Cp406 bn4 cn6 1.202e-16
Cp407 bn4 cn7 9.688e-17
Cp408 bn4 cn8 7.052e-17
Cp409 bn4 cn9 4.278e-17
Cp410 bn4 cp0 3.255e-17
Cp411 bn4 cp1 3.927e-17
Cp412 bn4 cp10 3.799e-17
Cp413 bn4 cp11 3.799e-17
Cp414 bn4 cp12 3.799e-17
Cp415 bn4 cp2 3.255e-17
Cp416 bn4 cp3 2.95e-17
Cp417 bn4 cp4 2.574e-17
Cp418 bn4 cp5 3.386e-17
Cp419 bn4 cp6 3.357e-17
Cp420 bn4 cp7 1.012e-16
Cp421 bn4 cp8 1.351e-16
Cp422 bn4 cp9 7.738e-17
Cp423 bn4 gnd 4.985e-15
Cp424 bn4 lsb_n 1.892e-16
Cp425 bn4 lsb_p 4.213e-17
Cp426 bn4 on 3.208e-17
Cp427 bn4 onp 6.404e-17
Cp428 bn4 op 6.074e-17
Cp429 bn4 vdd 5.388e-16
Cp430 bn4 vrefl 1.647e-15
Cp431 bn4 xc4_din 1.176e-16
Cp432 bn4 xc4_dip 5.195e-16
Cp433 bn4 xc4_outnb 4.343e-19
Cp434 bn5 bn6 1.211e-14
Cp435 bn5 bn7 1.739e-14
Cp436 bn5 bn8 1.194e-16
Cp437 bn5 bn9 3.529e-16
Cp438 bn5 bp0 9.703e-17
Cp439 bn5 bp1 9.466e-17
Cp440 bn5 bp10 5.215e-16
Cp441 bn5 bp11 2.356e-16
Cp442 bn5 bp12 4.034e-17
Cp443 bn5 bp2 5.141e-16
Cp444 bn5 bp3 2.481e-16
Cp445 bn5 bp4 4.992e-17
Cp446 bn5 bp5 4.665e-16
Cp447 bn5 bp6 4.717e-16
Cp448 bn5 bp7 5.137e-17
Cp449 bn5 bp8 9.334e-17
Cp450 bn5 bp9 1.033e-16
Cp451 bn5 clk 7.569e-18
Cp452 bn5 clkb 6.456e-17
Cp453 bn5 clkn 6.776e-17
Cp454 bn5 cn0 3.822e-17
Cp455 bn5 cn1 6.616e-17
Cp456 bn5 cn10 1.734e-16
Cp457 bn5 cn11 7.658e-17
Cp458 bn5 cn12 5.037e-17
Cp459 bn5 cn2 3.831e-17
Cp460 bn5 cn3 1.231e-16
Cp461 bn5 cn4 4.336e-17
Cp462 bn5 cn5 1.825e-15
Cp463 bn5 cn6 2.053e-16
Cp464 bn5 cn7 1.404e-16
Cp465 bn5 cn8 9.134e-17
Cp466 bn5 cn9 1.413e-16
Cp467 bn5 cp0 5.325e-17
Cp468 bn5 cp1 9.369e-17
Cp469 bn5 cp10 1.342e-16
Cp470 bn5 cp11 7.347e-17
Cp471 bn5 cp12 5.121e-17
Cp472 bn5 cp2 7.458e-17
Cp473 bn5 cp3 9.662e-17
Cp474 bn5 cp4 3.812e-17
Cp475 bn5 cp5 1.162e-16
Cp476 bn5 cp6 1.044e-16
Cp477 bn5 cp7 7.505e-17
Cp478 bn5 cp8 1.258e-16
Cp479 bn5 cp9 1.077e-16
Cp480 bn5 gnd 9.721e-15
Cp481 bn5 lsb_n 5.019e-16
Cp482 bn5 lsb_p 2.451e-16
Cp483 bn5 on 1.06e-16
Cp484 bn5 onp 1.275e-16
Cp485 bn5 op 9.692e-17
Cp486 bn5 rstb 9.677e-17
Cp487 bn5 top_n 1.26e-19
Cp488 bn5 top_p 7.569e-18
Cp489 bn5 vdd 3.935e-16
Cp490 bn5 vrefl 5.513e-16
Cp491 bn5 xc4_din 1.142e-16
Cp492 bn5 xc4_dip 5.319e-16
Cp493 bn5 xs1n_cbp 2.091e-19
Cp494 bn5 xs1n_n10 4.667e-19
Cp495 bn6 bn7 1.162e-14
Cp496 bn6 bn8 7.425e-16
Cp497 bn6 bn9 1.986e-15
Cp498 bn6 bp0 6.733e-16
Cp499 bn6 bp1 5.426e-16
Cp500 bn6 bp10 6.568e-16
Cp501 bn6 bp11 5.943e-16
Cp502 bn6 bp12 8.08e-16
Cp503 bn6 bp2 6.364e-16
Cp504 bn6 bp3 6.091e-16
Cp505 bn6 bp4 9.209e-16
Cp506 bn6 bp5 5.852e-16
Cp507 bn6 bp6 5.901e-16
Cp508 bn6 bp7 8.532e-16
Cp509 bn6 bp8 6.868e-16
Cp510 bn6 bp9 5.326e-16
Cp511 bn6 clk 7.569e-18
Cp512 bn6 clkb 1.395e-16
Cp513 bn6 clkn 1.538e-16
Cp514 bn6 cn0 3e-16
Cp515 bn6 cn1 4.152e-16
Cp516 bn6 cn10 3.495e-16
Cp517 bn6 cn11 2.639e-16
Cp518 bn6 cn12 1.851e-16
Cp519 bn6 cn2 3.435e-16
Cp520 bn6 cn3 3.628e-16
Cp521 bn6 cn4 3.307e-16
Cp522 bn6 cn5 3.958e-16
Cp523 bn6 cn6 8.153e-16
Cp524 bn6 cn7 2.93e-16
Cp525 bn6 cn8 1.672e-16
Cp526 bn6 cn9 2.734e-16
Cp527 bn6 cp0 1.639e-16
Cp528 bn6 cp1 1.664e-16
Cp529 bn6 cp10 1.861e-16
Cp530 bn6 cp11 1.79e-16
Cp531 bn6 cp12 1.645e-16
Cp532 bn6 cp2 1.235e-16
Cp533 bn6 cp3 1.352e-16
Cp534 bn6 cp4 7.653e-17
Cp535 bn6 cp5 1.783e-16
Cp536 bn6 cp6 1.42e-16
Cp537 bn6 cp7 1.379e-16
Cp538 bn6 cp8 2.158e-16
Cp539 bn6 cp9 1.705e-16
Cp540 bn6 gnd 2.734e-14
Cp541 bn6 lsb_n 1.744e-15
Cp542 bn6 lsb_p 6.124e-16
Cp543 bn6 on 3.63e-16
Cp544 bn6 onn 6.68e-17
Cp545 bn6 onp 3.529e-16
Cp546 bn6 op 2.118e-16
Cp547 bn6 rstb 4.527e-17
Cp548 bn6 top_n 5.775e-18
Cp549 bn6 top_p 7.569e-18
Cp550 bn6 vdd 1.416e-15
Cp551 bn6 vrefl 6.353e-16
Cp552 bn6 xc4_din 1.501e-16
Cp553 bn6 xc4_dip 3.256e-15
Cp554 bn7 bn8 3.58e-15
Cp555 bn7 bn9 2.056e-15
Cp556 bn7 bp0 1.24e-15
Cp557 bn7 bp1 1.033e-15
Cp558 bn7 bp10 1.198e-15
Cp559 bn7 bp11 1.112e-15
Cp560 bn7 bp12 1.388e-15
Cp561 bn7 bp2 1.174e-15
Cp562 bn7 bp3 1.155e-15
Cp563 bn7 bp4 1.523e-15
Cp564 bn7 bp5 1.108e-15
Cp565 bn7 bp6 1.116e-15
Cp566 bn7 bp7 1.453e-15
Cp567 bn7 bp8 1.256e-15
Cp568 bn7 bp9 1.016e-15
Cp569 bn7 clk 1.514e-17
Cp570 bn7 clkb 1.932e-16
Cp571 bn7 clkn 2.658e-16
Cp572 bn7 cn0 2.1e-16
Cp573 bn7 cn1 2.665e-16
Cp574 bn7 cn10 4.922e-16
Cp575 bn7 cn11 5.986e-16
Cp576 bn7 cn12 5.864e-16
Cp577 bn7 cn2 2.02e-16
Cp578 bn7 cn3 3.388e-16
Cp579 bn7 cn4 2.175e-16
Cp580 bn7 cn5 8.568e-16
Cp581 bn7 cn6 6.237e-16
Cp582 bn7 cn7 1.22e-15
Cp583 bn7 cn8 4.569e-16
Cp584 bn7 cn9 3.934e-16
Cp585 bn7 cp0 4.618e-16
Cp586 bn7 cp1 4.812e-16
Cp587 bn7 cp10 7.535e-16
Cp588 bn7 cp11 7.434e-16
Cp589 bn7 cp12 5.889e-16
Cp590 bn7 cp2 4.936e-16
Cp591 bn7 cp3 3.195e-16
Cp592 bn7 cp4 3.229e-16
Cp593 bn7 cp5 4.384e-16
Cp594 bn7 cp6 3.16e-16
Cp595 bn7 cp7 4.617e-16
Cp596 bn7 cp8 1.416e-15
Cp597 bn7 cp9 8.345e-16
Cp598 bn7 gnd 4.056e-14
Cp599 bn7 lsb_n 2.049e-15
Cp600 bn7 lsb_p 1.153e-15
Cp601 bn7 on 2.889e-16
Cp602 bn7 onp 4.68e-16
Cp603 bn7 op 3.355e-16
Cp604 bn7 rstb 1.932e-16
Cp605 bn7 t1b 4.486e-17
Cp606 bn7 top_n 8.596e-18
Cp607 bn7 top_p 1.514e-17
Cp608 bn7 vdd 2.357e-15
Cp609 bn7 vrefl 6.66e-16
Cp610 bn7 xc4_din 3.955e-15
Cp611 bn7 xc4_dip 6.687e-16
Cp612 bn8 bn9 4.395e-15
Cp613 bn8 bp12 6.613e-18
Cp614 bn8 clk 7.569e-18
Cp615 bn8 clkb 4.923e-17
Cp616 bn8 cn0 4.614e-17
Cp617 bn8 cn1 5.227e-17
Cp618 bn8 cn10 8.197e-19
Cp619 bn8 cn2 4.614e-17
Cp620 bn8 cn3 5.352e-17
Cp621 bn8 cn4 4.614e-17
Cp622 bn8 cn5 3.528e-16
Cp623 bn8 cn6 3.084e-16
Cp624 bn8 cn7 1.45e-16
Cp625 bn8 cn8 5.802e-16
Cp626 bn8 cn9 1.728e-16
Cp627 bn8 gnd 5.433e-15
Cp628 bn8 lsb_n 5.426e-16
Cp629 bn8 lsb_p 1.028e-15
Cp630 bn8 on 5.087e-17
Cp631 bn8 onp 6.342e-17
Cp632 bn8 op 4.686e-17
Cp633 bn8 rstb 9.158e-16
Cp634 bn8 top_n 2.126e-16
Cp635 bn8 top_p 3.132e-18
Cp636 bn8 vdd 1.278e-16
Cp637 bn8 vref 3.502e-16
Cp638 bn8 vrefl 1.895e-16
Cp639 bn8 xc4_din 8.254e-16
Cp640 bn8 xc4_dip 4.618e-16
Cp641 bn9 bp1 5.089e-17
Cp642 bn9 bp10 6.415e-17
Cp643 bn9 bp11 4.808e-17
Cp644 bn9 bp12 4.742e-17
Cp645 bn9 bp2 5.494e-16
Cp646 bn9 bp3 2.762e-16
Cp647 bn9 bp4 4.742e-17
Cp648 bn9 bp5 4.742e-17
Cp649 bn9 bp6 4.742e-17
Cp650 bn9 bp7 4.742e-17
Cp651 bn9 bp8 9.705e-17
Cp652 bn9 bp9 1.172e-15
Cp653 bn9 clkn 6.571e-17
Cp654 bn9 cn0 7.304e-19
Cp655 bn9 cn1 2.58e-17
Cp656 bn9 cn10 1.084e-16
Cp657 bn9 cn11 5.226e-17
Cp658 bn9 cn12 5.218e-17
Cp659 bn9 cn2 1.56e-18
Cp660 bn9 cn3 4.839e-19
Cp661 bn9 cn4 1.056e-18
Cp662 bn9 cn5 8.139e-16
Cp663 bn9 cn6 8.331e-16
Cp664 bn9 cn7 5.971e-16
Cp665 bn9 cn8 6.651e-16
Cp666 bn9 cn9 8.238e-16
Cp667 bn9 cp0 8.434e-18
Cp668 bn9 cp10 5.218e-17
Cp669 bn9 cp11 5.218e-17
Cp670 bn9 cp12 5.218e-17
Cp671 bn9 cp2 3.224e-17
Cp672 bn9 cp3 7.664e-17
Cp673 bn9 cp5 4.731e-17
Cp674 bn9 cp6 1.056e-16
Cp675 bn9 cp7 4.708e-17
Cp676 bn9 cp8 5.343e-17
Cp677 bn9 cp9 5.218e-17
Cp678 bn9 gnd 4.067e-15
Cp679 bn9 lsb_n 1.612e-16
Cp680 bn9 lsb_p 4.886e-17
Cp681 bn9 on 8.05e-17
Cp682 bn9 op 9.24e-17
Cp683 bn9 rstb 1.926e-16
Cp684 bn9 vdd 6.036e-17
Cp685 bn9 vref 4.532e-16
Cp686 bn9 vrefl 5.574e-18
Cp687 bn9 xc4_din 1.019e-15
Cp688 bn9 xc4_dip 2.2e-16
Cp689 bp0 bp1 2.182e-15
Cp690 bp0 bp10 4.444e-17
Cp691 bp0 bp11 9.649e-17
Cp692 bp0 bp12 5.005e-16
Cp693 bp0 bp2 1.931e-15
Cp694 bp0 bp3 9.685e-16
Cp695 bp0 bp4 5.15e-16
Cp696 bp0 bp5 7.397e-16
Cp697 bp0 bp6 1.791e-15
Cp698 bp0 bp7 8.897e-16
Cp699 bp0 bp8 5.138e-17
Cp700 bp0 clkn 9.262e-17
Cp701 bp0 cn11 8.507e-19
Cp702 bp0 cn12 4.673e-18
Cp703 bp0 cp0 6.454e-16
Cp704 bp0 cp1 2.67e-16
Cp705 bp0 cp10 6.66e-17
Cp706 bp0 cp11 1.338e-16
Cp707 bp0 cp12 7.987e-17
Cp708 bp0 cp2 2.209e-16
Cp709 bp0 cp3 8.837e-16
Cp710 bp0 cp4 1.098e-15
Cp711 bp0 cp5 5.377e-17
Cp712 bp0 cp6 8.668e-16
Cp713 bp0 cp7 2.234e-16
Cp714 bp0 cp8 6.292e-17
Cp715 bp0 cp9 6.361e-17
Cp716 bp0 gnd 4.748e-15
Cp717 bp0 lsb_n 4.735e-17
Cp718 bp0 lsb_p 5.029e-17
Cp719 bp0 onp 4.168e-17
Cp720 bp0 vdd 1.84e-16
Cp721 bp0 vrefl 3.833e-16
Cp722 bp0 xc4_din 6.946e-17
Cp723 bp0 xc4_dip 7.224e-17
Cp724 bp1 bp10 4.195e-17
Cp725 bp1 bp11 3.792e-17
Cp726 bp1 bp12 4.274e-16
Cp727 bp1 bp2 8.653e-15
Cp728 bp1 bp3 2.409e-16
Cp729 bp1 bp4 2.976e-16
Cp730 bp1 bp5 1.348e-15
Cp731 bp1 bp6 1.206e-15
Cp732 bp1 bp7 2.271e-15
Cp733 bp1 bp8 4.889e-17
Cp734 bp1 bp9 5.089e-17
Cp735 bp1 clkn 8.385e-17
Cp736 bp1 cn10 9.992e-19
Cp737 bp1 cn11 5.902e-17
Cp738 bp1 cn12 1.33e-16
Cp739 bp1 cp0 1.571e-15
Cp740 bp1 cp1 3.447e-16
Cp741 bp1 cp10 4.944e-17
Cp742 bp1 cp11 4.985e-17
Cp743 bp1 cp12 6.752e-17
Cp744 bp1 cp2 3.202e-16
Cp745 bp1 cp3 2.579e-16
Cp746 bp1 cp4 3.349e-16
Cp747 bp1 cp5 5.32e-17
Cp748 bp1 cp6 1.887e-16
Cp749 bp1 cp7 1.536e-16
Cp750 bp1 cp8 5.203e-17
Cp751 bp1 cp9 4.944e-17
Cp752 bp1 gnd 3.73e-15
Cp753 bp1 lsb_n 4.486e-17
Cp754 bp1 lsb_p 4.095e-17
Cp755 bp1 onp 4.714e-16
Cp756 bp1 vdd 2.573e-17
Cp757 bp1 vrefl 8.597e-16
Cp758 bp1 xc4_din 7.265e-17
Cp759 bp1 xc4_dip 6.855e-17
Cp760 bp10 bp11 2.059e-14
Cp761 bp10 bp12 5.803e-15
Cp762 bp10 bp2 3.679e-17
Cp763 bp10 bp3 3.846e-17
Cp764 bp10 bp4 3.882e-17
Cp765 bp10 bp5 3.882e-17
Cp766 bp10 bp6 1.262e-15
Cp767 bp10 bp7 1.234e-15
Cp768 bp10 bp8 1.221e-15
Cp769 bp10 bp9 1.414e-14
Cp770 bp10 clkb 2.703e-17
Cp771 bp10 clkn 3.68e-17
Cp772 bp10 cn0 3.916e-17
Cp773 bp10 cn1 4.529e-17
Cp774 bp10 cn10 3.764e-17
Cp775 bp10 cn11 4.574e-16
Cp776 bp10 cn12 2.705e-16
Cp777 bp10 cn2 3.916e-17
Cp778 bp10 cn3 4.654e-17
Cp779 bp10 cn4 3.916e-17
Cp780 bp10 cn5 4.026e-17
Cp781 bp10 cn6 5.813e-17
Cp782 bp10 cn7 3.307e-17
Cp783 bp10 cn8 7.255e-17
Cp784 bp10 cn9 3.811e-17
Cp785 bp10 cp0 3.921e-17
Cp786 bp10 cp1 3.977e-17
Cp787 bp10 cp10 7.559e-16
Cp788 bp10 cp11 3.169e-16
Cp789 bp10 cp12 3.21e-16
Cp790 bp10 cp2 3.921e-17
Cp791 bp10 cp3 3.491e-17
Cp792 bp10 cp4 3.24e-17
Cp793 bp10 cp5 3.311e-17
Cp794 bp10 cp6 3.357e-17
Cp795 bp10 cp7 3.289e-17
Cp796 bp10 cp8 6.397e-17
Cp797 bp10 cp9 6.629e-16
Cp798 bp10 gnd 4.233e-15
Cp799 bp10 lsb_n 6.515e-17
Cp800 bp10 lsb_p 5.368e-16
Cp801 bp10 on 4.262e-17
Cp802 bp10 onp 1.628e-19
Cp803 bp10 op 3.311e-17
Cp804 bp10 rstb 1.197e-16
Cp805 bp10 vdd 8.428e-17
Cp806 bp10 vref 9.805e-16
Cp807 bp10 xc4_din 2.697e-16
Cp808 bp10 xc4_dip 9.682e-17
Cp809 bp11 bp12 3.369e-14
Cp810 bp11 bp2 3.275e-17
Cp811 bp11 bp3 3.846e-17
Cp812 bp11 bp4 4.971e-17
Cp813 bp11 bp5 4.698e-16
Cp814 bp11 bp6 2.927e-15
Cp815 bp11 bp7 2.409e-15
Cp816 bp11 bp8 5.256e-16
Cp817 bp11 bp9 7.243e-16
Cp818 bp11 clkb 3.948e-17
Cp819 bp11 clkn 3.91e-17
Cp820 bp11 cn0 2.596e-17
Cp821 bp11 cn1 3.186e-17
Cp822 bp11 cn10 1.362e-16
Cp823 bp11 cn11 5.456e-16
Cp824 bp11 cn12 6.099e-16
Cp825 bp11 cn2 2.574e-17
Cp826 bp11 cn3 6.985e-17
Cp827 bp11 cn4 2.559e-17
Cp828 bp11 cn5 1.153e-16
Cp829 bp11 cn6 3.257e-17
Cp830 bp11 cn7 5.819e-17
Cp831 bp11 cn8 3.924e-17
Cp832 bp11 cn9 6.146e-17
Cp833 bp11 cp0 3.255e-17
Cp834 bp11 cp1 7.792e-17
Cp835 bp11 cp10 2.085e-16
Cp836 bp11 cp11 1.097e-15
Cp837 bp11 cp12 2.974e-16
Cp838 bp11 cp2 3.255e-17
Cp839 bp11 cp3 2.965e-17
Cp840 bp11 cp4 2.574e-17
Cp841 bp11 cp5 9.671e-17
Cp842 bp11 cp6 3.357e-17
Cp843 bp11 cp7 5.33e-17
Cp844 bp11 cp8 3.919e-17
Cp845 bp11 cp9 9.305e-17
Cp846 bp11 gnd 5.322e-15
Cp847 bp11 lsb_n 7.699e-17
Cp848 bp11 lsb_p 6.188e-16
Cp849 bp11 on 3.186e-17
Cp850 bp11 onp 1.21e-16
Cp851 bp11 op 3.353e-17
Cp852 bp11 rstb 1.212e-16
Cp853 bp11 vdd 7.028e-17
Cp854 bp11 vref 1.499e-15
Cp855 bp11 xc4_din 3.177e-16
Cp856 bp11 xc4_dip 8.922e-17
Cp857 bp12 bp2 5.232e-17
Cp858 bp12 bp3 3.179e-16
Cp859 bp12 bp4 5.788e-16
Cp860 bp12 bp5 8.797e-17
Cp861 bp12 bp6 5.778e-15
Cp862 bp12 bp7 5.302e-15
Cp863 bp12 bp8 1.224e-15
Cp864 bp12 bp9 3.168e-15
Cp865 bp12 clkb 3.573e-17
Cp866 bp12 clkn 9.722e-17
Cp867 bp12 cn0 6.518e-17
Cp868 bp12 cn1 6.798e-17
Cp869 bp12 cn10 7.958e-16
Cp870 bp12 cn11 1.473e-15
Cp871 bp12 cn12 7.712e-16
Cp872 bp12 cn2 6.307e-17
Cp873 bp12 cn3 8.235e-17
Cp874 bp12 cn4 6.868e-17
Cp875 bp12 cn5 8.45e-17
Cp876 bp12 cn6 1.026e-16
Cp877 bp12 cn7 8.447e-17
Cp878 bp12 cn8 1.145e-16
Cp879 bp12 cn9 9.801e-17
Cp880 bp12 cp0 1.108e-16
Cp881 bp12 cp1 8.43e-17
Cp882 bp12 cp10 4.303e-17
Cp883 bp12 cp11 2.788e-16
Cp884 bp12 cp12 4.822e-16
Cp885 bp12 cp2 6.619e-17
Cp886 bp12 cp3 4.202e-17
Cp887 bp12 cp4 5.633e-17
Cp888 bp12 cp5 6.211e-17
Cp889 bp12 cp6 4.594e-17
Cp890 bp12 cp7 7.89e-17
Cp891 bp12 cp8 1.2e-16
Cp892 bp12 cp9 7.75e-17
Cp893 bp12 gnd 7.445e-15
Cp894 bp12 lsb_n 1.036e-16
Cp895 bp12 lsb_p 1.762e-14
Cp896 bp12 on 3.55e-17
Cp897 bp12 onp 1.151e-16
Cp898 bp12 op 6.04e-17
Cp899 bp12 rstb 1.013e-16
Cp900 bp12 top_p 1.311e-17
Cp901 bp12 vdd 3.516e-17
Cp902 bp12 vref 1.124e-15
Cp903 bp12 xc4_din 1.638e-16
Cp904 bp12 xc4_dip 7.1e-17
Cp905 bp2 bp3 1.424e-14
Cp906 bp2 bp4 4.471e-16
Cp907 bp2 bp5 3.429e-15
Cp908 bp2 bp6 1.844e-15
Cp909 bp2 bp7 2.839e-15
Cp910 bp2 bp8 4.942e-17
Cp911 bp2 bp9 5.494e-16
Cp912 bp2 clkn 9.267e-17
Cp913 bp2 cn0 5.517e-17
Cp914 bp2 cn1 8.264e-17
Cp915 bp2 cn10 5.034e-17
Cp916 bp2 cn11 5.037e-17
Cp917 bp2 cn12 3.799e-17
Cp918 bp2 cn2 7.934e-17
Cp919 bp2 cn3 5.602e-17
Cp920 bp2 cn4 8.511e-17
Cp921 bp2 cn5 5.264e-17
Cp922 bp2 cn6 4.49e-17
Cp923 bp2 cn7 4.526e-17
Cp924 bp2 cn8 5.162e-17
Cp925 bp2 cn9 5.037e-17
Cp926 bp2 cp0 8.498e-17
Cp927 bp2 cp1 1.622e-16
Cp928 bp2 cp10 3.799e-17
Cp929 bp2 cp11 3.799e-17
Cp930 bp2 cp12 3.799e-17
Cp931 bp2 cp2 7.419e-16
Cp932 bp2 cp3 3.439e-16
Cp933 bp2 cp4 1.83e-15
Cp934 bp2 cp5 5.807e-16
Cp935 bp2 cp6 5.357e-16
Cp936 bp2 cp7 2.041e-16
Cp937 bp2 cp8 3.029e-16
Cp938 bp2 cp9 3.799e-17
Cp939 bp2 gnd 4.11e-15
Cp940 bp2 lsb_n 4.539e-17
Cp941 bp2 lsb_p 5.153e-17
Cp942 bp2 on 4.835e-17
Cp943 bp2 op 4.588e-17
Cp944 bp2 vdd 3.562e-17
Cp945 bp2 vrefl 8.278e-16
Cp946 bp2 xc4_din 1.727e-16
Cp947 bp2 xc4_dip 5.733e-17
Cp948 bp3 bp4 2.418e-14
Cp949 bp3 bp5 6.295e-15
Cp950 bp3 bp6 3.567e-15
Cp951 bp3 bp7 4.6e-15
Cp952 bp3 bp8 4.629e-17
Cp953 bp3 bp9 2.676e-16
Cp954 bp3 clkb 4.943e-17
Cp955 bp3 clkn 7.932e-16
Cp956 bp3 cn0 3.873e-17
Cp957 bp3 cn1 3.186e-17
Cp958 bp3 cn10 3.799e-17
Cp959 bp3 cn11 3.799e-17
Cp960 bp3 cn12 3.799e-17
Cp961 bp3 cn2 2.574e-17
Cp962 bp3 cn3 4.61e-17
Cp963 bp3 cn4 2.559e-17
Cp964 bp3 cn5 4.837e-17
Cp965 bp3 cn6 1.114e-16
Cp966 bp3 cn7 9.071e-17
Cp967 bp3 cn8 4.171e-17
Cp968 bp3 cn9 3.799e-17
Cp969 bp3 cp0 3.921e-17
Cp970 bp3 cp1 4.747e-17
Cp971 bp3 cp10 3.799e-17
Cp972 bp3 cp11 3.799e-17
Cp973 bp3 cp12 3.799e-17
Cp974 bp3 cp2 3.655e-17
Cp975 bp3 cp3 1.699e-16
Cp976 bp3 cp4 4.841e-17
Cp977 bp3 cp5 2.977e-16
Cp978 bp3 cp6 7.335e-16
Cp979 bp3 cp7 6.235e-16
Cp980 bp3 cp8 1.923e-16
Cp981 bp3 cp9 3.799e-17
Cp982 bp3 gnd 6.061e-15
Cp983 bp3 lsb_n 4.629e-17
Cp984 bp3 lsb_p 9.646e-17
Cp985 bp3 on 3.186e-17
Cp986 bp3 onp 7.234e-17
Cp987 bp3 op 3.311e-17
Cp988 bp3 rstb 7.777e-19
Cp989 bp3 t1 1.58e-19
Cp990 bp3 vdd 1.355e-16
Cp991 bp3 vrefl 7.931e-16
Cp992 bp3 xc4_din 7.181e-16
Cp993 bp3 xc4_dip 1.658e-15
Cp994 bp4 bp5 4.039e-14
Cp995 bp4 bp6 5.815e-15
Cp996 bp4 bp7 5.671e-15
Cp997 bp4 bp8 4.576e-17
Cp998 bp4 bp9 3.882e-17
Cp999 bp4 clkb 2.574e-17
Cp1000 bp4 clkn 2.11e-16
Cp1001 bp4 cn0 2.574e-17
Cp1002 bp4 cn1 3.186e-17
Cp1003 bp4 cn10 4.026e-17
Cp1004 bp4 cn11 3.799e-17
Cp1005 bp4 cn12 3.833e-17
Cp1006 bp4 cn2 2.574e-17
Cp1007 bp4 cn3 3.631e-17
Cp1008 bp4 cn4 2.653e-17
Cp1009 bp4 cn5 8.043e-17
Cp1010 bp4 cn6 3.257e-17
Cp1011 bp4 cn7 3.289e-17
Cp1012 bp4 cn8 1.185e-16
Cp1013 bp4 cn9 1.032e-16
Cp1014 bp4 cp0 3.255e-17
Cp1015 bp4 cp1 3.927e-17
Cp1016 bp4 cp10 3.88e-17
Cp1017 bp4 cp11 5.458e-17
Cp1018 bp4 cp12 3.44e-16
Cp1019 bp4 cp2 3.273e-17
Cp1020 bp4 cp3 6.26e-17
Cp1021 bp4 cp4 2.603e-16
Cp1022 bp4 cp5 2.705e-16
Cp1023 bp4 cp6 2.929e-16
Cp1024 bp4 cp7 3.411e-16
Cp1025 bp4 cp8 7.376e-16
Cp1026 bp4 cp9 8.697e-17
Cp1027 bp4 gnd 6.048e-15
Cp1028 bp4 lsb_n 4.576e-17
Cp1029 bp4 lsb_p 6.522e-17
Cp1030 bp4 on 3.261e-17
Cp1031 bp4 onp 6.298e-17
Cp1032 bp4 op 6.288e-17
Cp1033 bp4 rstb 7.94e-17
Cp1034 bp4 vdd 5.954e-17
Cp1035 bp4 vref 1.474e-19
Cp1036 bp4 vrefl 2.148e-15
Cp1037 bp4 xc4_din 2.596e-16
Cp1038 bp4 xc4_dip 7.121e-17
Cp1039 bp5 bp6 1.273e-14
Cp1040 bp5 bp7 1.788e-14
Cp1041 bp5 bp8 7.048e-17
Cp1042 bp5 bp9 3.882e-17
Cp1043 bp5 clk 7.569e-18
Cp1044 bp5 clkb 6.274e-17
Cp1045 bp5 clkn 6.785e-17
Cp1046 bp5 cn0 3.827e-17
Cp1047 bp5 cn1 6.813e-17
Cp1048 bp5 cn10 1.472e-16
Cp1049 bp5 cn11 8.756e-17
Cp1050 bp5 cn12 5.82e-17
Cp1051 bp5 cn2 3.984e-17
Cp1052 bp5 cn3 8.495e-17
Cp1053 bp5 cn4 3.836e-17
Cp1054 bp5 cn5 1.373e-16
Cp1055 bp5 cn6 7.42e-17
Cp1056 bp5 cn7 7.261e-17
Cp1057 bp5 cn8 8.724e-17
Cp1058 bp5 cn9 7.571e-17
Cp1059 bp5 cp0 5.456e-17
Cp1060 bp5 cp1 9.551e-17
Cp1061 bp5 cp10 1.532e-16
Cp1062 bp5 cp11 1.57e-16
Cp1063 bp5 cp12 4.146e-16
Cp1064 bp5 cp2 7.504e-17
Cp1065 bp5 cp3 9.709e-17
Cp1066 bp5 cp4 1.771e-16
Cp1067 bp5 cp5 1.473e-15
Cp1068 bp5 cp6 1.043e-15
Cp1069 bp5 cp7 4.767e-16
Cp1070 bp5 cp8 4.488e-16
Cp1071 bp5 cp9 1.414e-16
Cp1072 bp5 gnd 1.09e-14
Cp1073 bp5 lsb_n 4.576e-17
Cp1074 bp5 lsb_p 8.819e-17
Cp1075 bp5 on 1.106e-16
Cp1076 bp5 onp 1.244e-16
Cp1077 bp5 op 1.051e-16
Cp1078 bp5 rstb 8.389e-18
Cp1079 bp5 top_p 3.138e-19
Cp1080 bp5 vdd 1.027e-16
Cp1081 bp5 vref 2.932e-19
Cp1082 bp5 vrefl 6.84e-16
Cp1083 bp5 xc4_din 3.11e-16
Cp1084 bp5 xc4_dip 5.801e-17
Cp1085 bp5 xs0p_x 1.189e-19
Cp1086 bp5 xs1p_n10 1.9e-18
Cp1087 bp6 bp7 1.438e-14
Cp1088 bp6 bp8 8.036e-16
Cp1089 bp6 bp9 6.632e-16
Cp1090 bp6 clk 7.569e-18
Cp1091 bp6 clkb 1.072e-16
Cp1092 bp6 clkn 1.536e-16
Cp1093 bp6 cn0 1.253e-16
Cp1094 bp6 cn1 1.518e-16
Cp1095 bp6 cn10 2.085e-16
Cp1096 bp6 cn11 1.949e-16
Cp1097 bp6 cn12 2.127e-16
Cp1098 bp6 cn2 1.43e-16
Cp1099 bp6 cn3 1.887e-16
Cp1100 bp6 cn4 1.522e-16
Cp1101 bp6 cn5 2.523e-16
Cp1102 bp6 cn6 2.426e-16
Cp1103 bp6 cn7 1.844e-16
Cp1104 bp6 cn8 2.333e-16
Cp1105 bp6 cn9 1.962e-16
Cp1106 bp6 cp0 1.635e-16
Cp1107 bp6 cp1 1.664e-16
Cp1108 bp6 cp10 3e-16
Cp1109 bp6 cp11 7.204e-16
Cp1110 bp6 cp12 7.486e-16
Cp1111 bp6 cp2 1.231e-16
Cp1112 bp6 cp3 1.35e-16
Cp1113 bp6 cp4 7.615e-17
Cp1114 bp6 cp5 3.473e-16
Cp1115 bp6 cp6 3.64e-16
Cp1116 bp6 cp7 2.411e-16
Cp1117 bp6 cp8 6.988e-16
Cp1118 bp6 cp9 2.175e-16
Cp1119 bp6 gnd 3.013e-14
Cp1120 bp6 lsb_n 4.586e-17
Cp1121 bp6 lsb_p 3.939e-16
Cp1122 bp6 on 1.957e-16
Cp1123 bp6 onn 6.46e-17
Cp1124 bp6 onp 2.424e-16
Cp1125 bp6 op 1.943e-16
Cp1126 bp6 rstb 2.045e-17
Cp1127 bp6 top_p 1.027e-17
Cp1128 bp6 vdd 1.313e-16
Cp1129 bp6 vref 2.287e-17
Cp1130 bp6 vrefl 1.231e-15
Cp1131 bp6 xc4_din 3.433e-16
Cp1132 bp6 xc4_dip 1.416e-15
Cp1133 bp7 bp8 1.69e-15
Cp1134 bp7 bp9 7.844e-16
Cp1135 bp7 clk 1.514e-17
Cp1136 bp7 clkb 1.951e-16
Cp1137 bp7 clkn 3.393e-16
Cp1138 bp7 cn0 2.167e-16
Cp1139 bp7 cn1 2.747e-16
Cp1140 bp7 cn10 3.874e-16
Cp1141 bp7 cn11 3.673e-16
Cp1142 bp7 cn12 3.878e-16
Cp1143 bp7 cn2 2.082e-16
Cp1144 bp7 cn3 3.431e-16
Cp1145 bp7 cn4 2.241e-16
Cp1146 bp7 cn5 4.733e-16
Cp1147 bp7 cn6 3.813e-16
Cp1148 bp7 cn7 3.364e-16
Cp1149 bp7 cn8 4.336e-16
Cp1150 bp7 cn9 3.624e-16
Cp1151 bp7 cp0 3.322e-16
Cp1152 bp7 cp1 3.464e-16
Cp1153 bp7 cp10 6.989e-16
Cp1154 bp7 cp11 5.201e-16
Cp1155 bp7 cp12 8.795e-16
Cp1156 bp7 cp2 3.186e-16
Cp1157 bp7 cp3 2.592e-16
Cp1158 bp7 cp4 2.639e-16
Cp1159 bp7 cp5 3.227e-16
Cp1160 bp7 cp6 4.584e-16
Cp1161 bp7 cp7 5.177e-16
Cp1162 bp7 cp8 5.77e-16
Cp1163 bp7 cp9 5.039e-16
Cp1164 bp7 gnd 4.689e-14
Cp1165 bp7 lsb_n 4.576e-17
Cp1166 bp7 lsb_p 3.374e-15
Cp1167 bp7 on 2.98e-16
Cp1168 bp7 onp 4.703e-16
Cp1169 bp7 op 3.542e-16
Cp1170 bp7 rstb 3.109e-17
Cp1171 bp7 top_p 4.329e-18
Cp1172 bp7 vdd 3.464e-16
Cp1173 bp7 vref 7.834e-17
Cp1174 bp7 vrefl 3.215e-16
Cp1175 bp7 xc4_din 3.474e-16
Cp1176 bp7 xc4_dip 9.804e-16
Cp1177 bp7 xs1p_cbp 2.091e-19
Cp1178 bp7 xs1p_g 5.339e-19
Cp1179 bp8 bp9 4.589e-15
Cp1180 bp8 clkn 4.825e-17
Cp1181 bp8 cn12 7.083e-16
Cp1182 bp8 cp0 5.067e-17
Cp1183 bp8 cp1 5.123e-17
Cp1184 bp8 cp10 5.802e-16
Cp1185 bp8 cp11 8.411e-17
Cp1186 bp8 cp12 2.711e-16
Cp1187 bp8 cp2 5.067e-17
Cp1188 bp8 cp3 4.637e-17
Cp1189 bp8 cp4 4.385e-17
Cp1190 bp8 cp5 4.457e-17
Cp1191 bp8 cp6 3.526e-16
Cp1192 bp8 cp7 4.593e-17
Cp1193 bp8 cp8 5.144e-16
Cp1194 bp8 cp9 4.001e-16
Cp1195 bp8 gnd 4.698e-15
Cp1196 bp8 lsb_n 2.353e-15
Cp1197 bp8 lsb_p 2.318e-16
Cp1198 bp8 rstb 8.538e-17
Cp1199 bp8 t1b 2.339e-19
Cp1200 bp8 top_n 3.779e-18
Cp1201 bp8 top_p 2.178e-16
Cp1202 bp8 vdd 1.09e-16
Cp1203 bp8 vref 4.59e-16
Cp1204 bp8 vrefl 5.572e-18
Cp1205 bp8 xc4_din 3.58e-16
Cp1206 bp8 xc4_dip 1.04e-16
Cp1207 bp9 clkn 5.159e-17
Cp1208 bp9 cn0 7.304e-19
Cp1209 bp9 cn1 2.58e-17
Cp1210 bp9 cn10 5.037e-17
Cp1211 bp9 cn11 5.071e-17
Cp1212 bp9 cn12 2.572e-16
Cp1213 bp9 cn2 1.56e-18
Cp1214 bp9 cn3 4.839e-19
Cp1215 bp9 cn4 1.056e-18
Cp1216 bp9 cn5 5.701e-17
Cp1217 bp9 cn6 4.607e-17
Cp1218 bp9 cn7 4.587e-17
Cp1219 bp9 cn8 5.162e-17
Cp1220 bp9 cn9 5.037e-17
Cp1221 bp9 cp0 8.434e-18
Cp1222 bp9 cp10 4.067e-16
Cp1223 bp9 cp11 1.488e-16
Cp1224 bp9 cp12 1.063e-15
Cp1225 bp9 cp2 3.224e-17
Cp1226 bp9 cp3 7.359e-17
Cp1227 bp9 cp5 3.311e-17
Cp1228 bp9 cp6 9.143e-17
Cp1229 bp9 cp7 3.289e-17
Cp1230 bp9 cp8 2.244e-16
Cp1231 bp9 cp9 1.334e-15
Cp1232 bp9 gnd 3.405e-15
Cp1233 bp9 lsb_n 5.488e-16
Cp1234 bp9 lsb_p 1.564e-16
Cp1235 bp9 on 8.306e-17
Cp1236 bp9 op 1.054e-16
Cp1237 bp9 rstb 8.618e-17
Cp1238 bp9 vdd 8.488e-17
Cp1239 bp9 vref 8.308e-16
Cp1240 bp9 xc4_din 2.513e-16
Cp1241 bp9 xc4_dip 6.788e-17
Cp1242 clk gnd 1.344e-14
Cp1243 clk in0n 1.024e-19
Cp1244 clk lsb_n 1.689e-16
Cp1245 clk lsb_p 8.392e-16
Cp1246 clk on 1.366e-17
Cp1247 clk onn 1.471e-16
Cp1248 clk onp 5.098e-17
Cp1249 clk op 1.742e-18
Cp1250 clk t0 1.613e-18
Cp1251 clk top_n 5.021e-17
Cp1252 clk top_p 2.556e-15
Cp1253 clk trk0 1.831e-17
Cp1254 clk trk1 6.043e-18
Cp1255 clk vdd 6.443e-18
Cp1256 clk xc4_lt 4.99e-17
Cp1257 clk xc5_outnb 7.715e-17
Cp1258 clk xc5_outpb 6.025e-17
Cp1259 clk xs0n_cbn 5.636e-17
Cp1260 clk xs0n_cbp 3.117e-18
Cp1261 clk xs0n_g 1.344e-19
Cp1262 clk xs0n_x 1.605e-18
Cp1263 clk xs0p_cbn 5.658e-17
Cp1264 clk xs0p_cbp 3.097e-18
Cp1265 clk xs0p_g 2.345e-19
Cp1266 clk xs0p_x 9.284e-18
Cp1267 clkb clkn 1.057e-16
Cp1268 clkb cp7 2.172e-19
Cp1269 clkb gnd 4.303e-14
Cp1270 clkb lsb_n 6.145e-17
Cp1271 clkb lsb_p 9.846e-17
Cp1272 clkb on 1.727e-16
Cp1273 clkb onn 3.095e-16
Cp1274 clkb onp 1.115e-16
Cp1275 clkb op 1.111e-16
Cp1276 clkb rstb 6.083e-17
Cp1277 clkb t1 4.91e-17
Cp1278 clkb t1b 5.061e-17
Cp1279 clkb top_p 5.329e-17
Cp1280 clkb vbp 1.012e-16
Cp1281 clkb vdd 1.102e-14
Cp1282 clkb vref 5.167e-16
Cp1283 clkb vrefl 3.46e-16
Cp1284 clkb xc4_din 2.919e-16
Cp1285 clkb xc4_dip 4.52e-16
Cp1286 clkb xc4_outnb 5.61e-17
Cp1287 clkb xc4_outpb 5.537e-17
Cp1288 clkb xc4_xs1_tail 1.189e-16
Cp1289 clkb xc4_xs1_tail0 3.606e-16
Cp1290 clkb xc5_din 1.076e-16
Cp1291 clkb xc5_dip 5.018e-17
Cp1292 clkb xc5_lt 5.145e-17
Cp1293 clkb xc5_outnb 2.101e-17
Cp1294 clkb xc5_outpb 2.937e-19
Cp1295 clkb xc5_xs1_tail 7.963e-17
Cp1296 clkn clknb 6.38e-17
Cp1297 clkn cp0 3.492e-17
Cp1298 clkn cp1 5.388e-17
Cp1299 clkn cp2 1.46e-16
Cp1300 clkn cp3 2.233e-16
Cp1301 clkn cp4 1.445e-16
Cp1302 clkn cp5 1.617e-17
Cp1303 clkn cp6 2.135e-15
Cp1304 clkn cp7 6.287e-16
Cp1305 clkn cp8 7.701e-17
Cp1306 clkn gnd 2.697e-14
Cp1307 clkn lsb_n 4.825e-17
Cp1308 clkn lsb_p 7.313e-19
Cp1309 clkn onn 4.207e-17
Cp1310 clkn onp 3.531e-17
Cp1311 clkn t1 4.936e-17
Cp1312 clkn t1b 4.188e-17
Cp1313 clkn top_n 1.042e-15
Cp1314 clkn top_p 1.204e-15
Cp1315 clkn vbn 7.474e-17
Cp1316 clkn vbp 4.883e-19
Cp1317 clkn vdd 9.999e-16
Cp1318 clkn vrefl 4.094e-16
Cp1319 clkn xc4_din 6.59e-16
Cp1320 clkn xc4_dip 7.533e-17
Cp1321 clkn xc4_xs1_tail 7.976e-17
Cp1322 clkn xc5_din 3.363e-16
Cp1323 clkn xc5_dip 2.671e-16
Cp1324 clkn xc5_lt 5.352e-17
Cp1325 clkn xc5_xs1_tail 8.439e-17
Cp1326 clkn xc5_xs1_tail0 2.502e-16
Cp1327 clknb gnd 2.198e-14
Cp1328 clknb in1n 7.532e-17
Cp1329 clknb in1p 2.905e-15
Cp1330 clknb t1 2.882e-16
Cp1331 clknb t1b 1.658e-16
Cp1332 clknb top_n 1.26e-18
Cp1333 clknb top_p 5.743e-19
Cp1334 clknb vdd 7.64e-16
Cp1335 clknb xc5_din 9.299e-19
Cp1336 clknb xc5_lt 2.999e-16
Cp1337 clknb xs1n_cbn 1.983e-16
Cp1338 clknb xs1n_cbp 2.811e-18
Cp1339 clknb xs1n_g 2.252e-18
Cp1340 clknb xs1n_n10 1.382e-18
Cp1341 clknb xs1n_x 8.691e-17
Cp1342 clknb xs1p_cbn 1.978e-16
Cp1343 clknb xs1p_cbp 7.959e-18
Cp1344 clknb xs1p_g 4.611e-17
Cp1345 clknb xs1p_n10 1.822e-18
Cp1346 clknb xs1p_x 8.041e-17
Cp1347 cn0 cn1 2.27e-16
Cp1348 cn0 cn2 3.685e-17
Cp1349 cn0 cn3 9.643e-15
Cp1350 cn0 cn4 9.334e-15
Cp1351 cn0 gnd 2.965e-15
Cp1352 cn0 lsb_n 6.82e-17
Cp1353 cn0 lsb_p 3.812e-17
Cp1354 cn0 on 1.416e-16
Cp1355 cn0 onp 1.344e-19
Cp1356 cn0 op 4.996e-17
Cp1357 cn0 vdd 7.656e-18
Cp1358 cn0 vrefl 5.271e-17
Cp1359 cn0 xc4_din 4.316e-17
Cp1360 cn0 xc4_dip 7.752e-17
Cp1361 cn0 xc4_outnb 4.378e-17
Cp1362 cn0 xc4_outpb 6.236e-17
Cp1363 cn1 cn2 8.348e-15
Cp1364 cn1 cn3 1.128e-16
Cp1365 cn1 cn4 1.045e-15
Cp1366 cn1 gnd 3.702e-15
Cp1367 cn1 lsb_n 7.917e-17
Cp1368 cn1 lsb_p 4.424e-17
Cp1369 cn1 on 1.788e-15
Cp1370 cn1 op 6.066e-16
Cp1371 cn1 vdd 1.363e-16
Cp1372 cn1 vrefl 9.066e-17
Cp1373 cn1 xc4_din 6.771e-16
Cp1374 cn1 xc4_dip 2.576e-16
Cp1375 cn1 xc4_outnb 4.282e-17
Cp1376 cn1 xc4_outpb 7.411e-17
Cp1377 cn10 cn11 2.742e-15
Cp1378 cn10 cn12 1.199e-16
Cp1379 cn10 cn5 1.115e-19
Cp1380 cn10 cn6 1.645e-17
Cp1381 cn10 cn7 7.015e-16
Cp1382 cn10 cn8 2.538e-16
Cp1383 cn10 cn9 2.032e-15
Cp1384 cn10 cp12 1.061e-16
Cp1385 cn10 gnd 6.094e-15
Cp1386 cn10 lsb_n 5.037e-17
Cp1387 cn10 lsb_p 5.034e-17
Cp1388 cn10 rstb 1.375e-16
Cp1389 cn10 vdd 8.127e-17
Cp1390 cn10 vref 1.343e-15
Cp1391 cn10 xc4_din 6.256e-17
Cp1392 cn10 xc4_dip 7.099e-17
Cp1393 cn11 cn12 1.986e-15
Cp1394 cn11 cn7 3.132e-18
Cp1395 cn11 cn8 2.667e-19
Cp1396 cn11 cn9 1.306e-16
Cp1397 cn11 cp10 9.939e-17
Cp1398 cn11 cp11 3.866e-16
Cp1399 cn11 cp12 2.141e-17
Cp1400 cn11 cp9 5.147e-19
Cp1401 cn11 gnd 5.653e-15
Cp1402 cn11 lsb_n 5.037e-17
Cp1403 cn11 lsb_p 5.037e-17
Cp1404 cn11 rstb 1.135e-16
Cp1405 cn11 vdd 5.383e-17
Cp1406 cn11 vref 2.497e-15
Cp1407 cn11 xc4_din 6.076e-16
Cp1408 cn11 xc4_dip 5.196e-16
Cp1409 cn12 cn9 2.754e-18
Cp1410 cn12 cp10 1.313e-16
Cp1411 cn12 cp11 1.644e-15
Cp1412 cn12 cp12 3.393e-15
Cp1413 cn12 cp6 1.115e-19
Cp1414 cn12 cp8 1.113e-16
Cp1415 cn12 cp9 1.387e-16
Cp1416 cn12 gnd 5.64e-15
Cp1417 cn12 lsb_n 5.037e-17
Cp1418 cn12 lsb_p 5.037e-17
Cp1419 cn12 rstb 1.255e-16
Cp1420 cn12 vdd 1.705e-16
Cp1421 cn12 vref 1.643e-15
Cp1422 cn12 vrefl 2.02e-18
Cp1423 cn12 xc4_din 4.692e-16
Cp1424 cn12 xc4_dip 8.066e-16
Cp1425 cn2 cn3 7.991e-16
Cp1426 cn2 cn4 8.021e-15
Cp1427 cn2 gnd 3.08e-15
Cp1428 cn2 lsb_n 7.209e-17
Cp1429 cn2 lsb_p 3.812e-17
Cp1430 cn2 on 1.085e-16
Cp1431 cn2 op 7.824e-16
Cp1432 cn2 vdd 4.646e-17
Cp1433 cn2 vrefl 9.855e-16
Cp1434 cn2 xc4_din 4.726e-17
Cp1435 cn2 xc4_dip 5.158e-16
Cp1436 cn2 xc4_outnb 2.028e-16
Cp1437 cn2 xc4_outpb 3.35e-16
Cp1438 cn3 cn4 1.519e-15
Cp1439 cn3 cn5 1.2e-19
Cp1440 cn3 gnd 5.795e-15
Cp1441 cn3 lsb_n 7.243e-17
Cp1442 cn3 lsb_p 4.549e-17
Cp1443 cn3 on 1.639e-16
Cp1444 cn3 onn 1.024e-19
Cp1445 cn3 onp 1.282e-16
Cp1446 cn3 op 2.202e-16
Cp1447 cn3 vdd 4.642e-18
Cp1448 cn3 vrefl 3.866e-16
Cp1449 cn3 xc4_din 4.071e-17
Cp1450 cn3 xc4_dip 7.196e-17
Cp1451 cn3 xc4_outnb 2.813e-15
Cp1452 cn3 xc4_outpb 3.511e-18
Cp1453 cn4 cn5 7.168e-16
Cp1454 cn4 cn6 5.597e-18
Cp1455 cn4 gnd 3.849e-15
Cp1456 cn4 lsb_n 7.611e-17
Cp1457 cn4 lsb_p 3.796e-17
Cp1458 cn4 on 6.82e-16
Cp1459 cn4 onp 1.024e-19
Cp1460 cn4 op 1.058e-16
Cp1461 cn4 rstb 3.622e-17
Cp1462 cn4 vdd 1.67e-17
Cp1463 cn4 vrefl 1.134e-15
Cp1464 cn4 xc4_din 4.123e-17
Cp1465 cn4 xc4_dip 6.342e-16
Cp1466 cn4 xc4_outnb 2.12e-17
Cp1467 cn4 xc4_outpb 4.74e-19
Cp1468 cn5 cn6 3.645e-16
Cp1469 cn5 cn7 3.022e-15
Cp1470 cn5 cn8 8.239e-17
Cp1471 cn5 cn9 3.239e-17
Cp1472 cn5 gnd 5.982e-15
Cp1473 cn5 lsb_n 1.378e-15
Cp1474 cn5 lsb_p 5.264e-17
Cp1475 cn5 on 5.948e-18
Cp1476 cn5 rstb 3.612e-16
Cp1477 cn5 vdd 6.457e-16
Cp1478 cn5 vref 4.192e-16
Cp1479 cn5 vrefl 1.516e-15
Cp1480 cn5 xc4_din 1.758e-16
Cp1481 cn5 xc4_dip 9.002e-16
Cp1482 cn5 xc4_outnb 1.024e-19
Cp1483 cn6 cn7 9.118e-15
Cp1484 cn6 cn8 2.141e-15
Cp1485 cn6 cn9 9.16e-17
Cp1486 cn6 gnd 5.316e-15
Cp1487 cn6 lsb_n 5.531e-17
Cp1488 cn6 lsb_p 4.49e-17
Cp1489 cn6 on 2.166e-18
Cp1490 cn6 rstb 3.436e-16
Cp1491 cn6 vdd 2.138e-16
Cp1492 cn6 vref 1.703e-16
Cp1493 cn6 vrefl 1.815e-16
Cp1494 cn6 xc4_din 5.19e-17
Cp1495 cn6 xc4_dip 9.647e-16
Cp1496 cn7 cn8 3.349e-16
Cp1497 cn7 cn9 9.845e-16
Cp1498 cn7 gnd 4.386e-15
Cp1499 cn7 lsb_n 3.326e-17
Cp1500 cn7 lsb_p 4.526e-17
Cp1501 cn7 rstb 6.551e-16
Cp1502 cn7 vdd 1.1e-16
Cp1503 cn7 vref 4.466e-16
Cp1504 cn7 vrefl 1.645e-16
Cp1505 cn7 xc4_din 5.461e-17
Cp1506 cn7 xc4_dip 3.569e-16
Cp1507 cn8 cn9 2.416e-15
Cp1508 cn8 gnd 5.91e-15
Cp1509 cn8 lsb_n 8.545e-17
Cp1510 cn8 lsb_p 5.162e-17
Cp1511 cn8 rstb 8.455e-16
Cp1512 cn8 vdd 1.182e-16
Cp1513 cn8 vref 4.038e-16
Cp1514 cn8 vrefl 1.107e-17
Cp1515 cn8 xc4_din 9.391e-17
Cp1516 cn8 xc4_dip 7.24e-16
Cp1517 cn9 gnd 5.261e-15
Cp1518 cn9 lsb_n 5.037e-17
Cp1519 cn9 lsb_p 5.037e-17
Cp1520 cn9 rstb 1.965e-16
Cp1521 cn9 vdd 1.835e-16
Cp1522 cn9 vref 1.328e-15
Cp1523 cn9 vrefl 4.221e-19
Cp1524 cn9 xc4_din 5.622e-17
Cp1525 cn9 xc4_dip 2.147e-16
Cp1526 cp0 cp1 4.376e-16
Cp1527 cp0 cp2 3.304e-15
Cp1528 cp0 cp3 2.065e-16
Cp1529 cp0 cp4 8.847e-15
Cp1530 cp0 cp6 5.192e-16
Cp1531 cp0 cp7 2.585e-16
Cp1532 cp0 gnd 4.295e-15
Cp1533 cp0 lsb_n 4.401e-17
Cp1534 cp0 lsb_p 4.261e-17
Cp1535 cp0 onp 6.111e-16
Cp1536 cp0 t1 6.332e-19
Cp1537 cp0 vdd 9.941e-17
Cp1538 cp0 vrefl 1.203e-16
Cp1539 cp0 xc4_din 5.601e-17
Cp1540 cp0 xc4_dip 3.573e-17
Cp1541 cp1 cp2 2.788e-16
Cp1542 cp1 cp3 8.963e-16
Cp1543 cp1 cp4 8.69e-15
Cp1544 cp1 cp6 4.878e-17
Cp1545 cp1 cp7 5.767e-17
Cp1546 cp1 gnd 6.267e-15
Cp1547 cp1 lsb_n 4.457e-17
Cp1548 cp1 lsb_p 5.056e-17
Cp1549 cp1 onp 1.499e-16
Cp1550 cp1 t1 1.92e-16
Cp1551 cp1 vdd 2.355e-16
Cp1552 cp1 vrefl 3.93e-16
Cp1553 cp1 xc4_din 4.939e-17
Cp1554 cp1 xc4_dip 1.356e-15
Cp1555 cp10 cp11 3.281e-15
Cp1556 cp10 cp12 2.876e-16
Cp1557 cp10 cp6 3.838e-18
Cp1558 cp10 cp7 3.438e-18
Cp1559 cp10 cp8 2.492e-16
Cp1560 cp10 cp9 3.056e-15
Cp1561 cp10 gnd 6.004e-15
Cp1562 cp10 lsb_n 5.037e-17
Cp1563 cp10 lsb_p 6.33e-17
Cp1564 cp10 rstb 2.095e-16
Cp1565 cp10 t1 1.549e-18
Cp1566 cp10 vdd 2.497e-16
Cp1567 cp10 vref 1.121e-15
Cp1568 cp10 vrefl 3.535e-19
Cp1569 cp10 xc4_din 8.497e-16
Cp1570 cp10 xc4_dip 4.185e-17
Cp1571 cp11 cp12 3.548e-15
Cp1572 cp11 cp7 5.471e-17
Cp1573 cp11 cp8 8.336e-17
Cp1574 cp11 cp9 1.641e-16
Cp1575 cp11 gnd 4.84e-15
Cp1576 cp11 lsb_n 5.037e-17
Cp1577 cp11 lsb_p 5.61e-17
Cp1578 cp11 rstb 1.021e-16
Cp1579 cp11 t1 2.172e-19
Cp1580 cp11 vdd 2.797e-16
Cp1581 cp11 vref 1.496e-15
Cp1582 cp11 vrefl 1.678e-17
Cp1583 cp11 xc4_din 7.903e-16
Cp1584 cp11 xc4_dip 4.317e-17
Cp1585 cp12 cp5 5.497e-18
Cp1586 cp12 cp6 6.701e-17
Cp1587 cp12 cp7 7.609e-17
Cp1588 cp12 cp8 5.57e-17
Cp1589 cp12 cp9 3.336e-16
Cp1590 cp12 gnd 6.191e-15
Cp1591 cp12 lsb_n 5.037e-17
Cp1592 cp12 lsb_p 6.285e-17
Cp1593 cp12 rstb 2.53e-16
Cp1594 cp12 t1 2.527e-18
Cp1595 cp12 vdd 2.238e-16
Cp1596 cp12 vref 1.083e-15
Cp1597 cp12 vrefl 1.697e-16
Cp1598 cp12 xc4_din 7.12e-16
Cp1599 cp12 xc4_dip 7.57e-17
Cp1600 cp2 cp3 9.903e-15
Cp1601 cp2 cp4 6.787e-16
Cp1602 cp2 cp5 5.624e-18
Cp1603 cp2 cp6 2.022e-15
Cp1604 cp2 cp7 4.35e-17
Cp1605 cp2 cp8 4.199e-19
Cp1606 cp2 gnd 5.256e-15
Cp1607 cp2 lsb_n 4.401e-17
Cp1608 cp2 lsb_p 4.078e-17
Cp1609 cp2 onp 2.819e-17
Cp1610 cp2 t1 6.332e-19
Cp1611 cp2 vdd 2.343e-16
Cp1612 cp2 vrefl 4.066e-16
Cp1613 cp2 xc4_din 6.523e-17
Cp1614 cp2 xc4_dip 3.575e-17
Cp1615 cp3 cp4 3.911e-16
Cp1616 cp3 cp5 2.704e-17
Cp1617 cp3 cp6 2.284e-15
Cp1618 cp3 cp7 4.03e-17
Cp1619 cp3 cp8 6.013e-19
Cp1620 cp3 gnd 5.178e-15
Cp1621 cp3 lsb_n 4.111e-17
Cp1622 cp3 lsb_p 2.163e-16
Cp1623 cp3 onp 3.556e-18
Cp1624 cp3 t1 7.418e-19
Cp1625 cp3 vdd 1.257e-16
Cp1626 cp3 vrefl 1.537e-15
Cp1627 cp3 xc4_din 7.61e-17
Cp1628 cp3 xc4_dip 4.537e-17
Cp1629 cp4 cp5 6.222e-16
Cp1630 cp4 cp6 2.312e-15
Cp1631 cp4 cp7 9.238e-17
Cp1632 cp4 cp8 1.009e-15
Cp1633 cp4 gnd 4.108e-15
Cp1634 cp4 lsb_n 3.719e-17
Cp1635 cp4 lsb_p 1.944e-16
Cp1636 cp4 onp 5.619e-17
Cp1637 cp4 rstb 4.304e-19
Cp1638 cp4 t1 6.332e-19
Cp1639 cp4 vdd 9.553e-17
Cp1640 cp4 vrefl 4.641e-16
Cp1641 cp4 xc4_din 6.153e-17
Cp1642 cp4 xc4_dip 3.698e-17
Cp1643 cp5 cp6 1.091e-15
Cp1644 cp5 cp7 7.547e-15
Cp1645 cp5 cp8 2.163e-15
Cp1646 cp5 gnd 4.747e-15
Cp1647 cp5 lsb_n 4.457e-17
Cp1648 cp5 lsb_p 1.952e-16
Cp1649 cp5 rstb 3.503e-19
Cp1650 cp5 vdd 3.029e-16
Cp1651 cp5 vrefl 9.016e-16
Cp1652 cp5 xc4_din 5.574e-16
Cp1653 cp5 xc4_dip 4.249e-17
Cp1654 cp6 cp7 6.938e-16
Cp1655 cp6 cp8 1.913e-15
Cp1656 cp6 cp9 5.599e-18
Cp1657 cp6 gnd 5.168e-15
Cp1658 cp6 lsb_n 4.502e-17
Cp1659 cp6 lsb_p 1.17e-16
Cp1660 cp6 onp 3.467e-17
Cp1661 cp6 rstb 1.572e-18
Cp1662 cp6 t1 6.332e-19
Cp1663 cp6 vdd 4.322e-16
Cp1664 cp6 vref 2.514e-18
Cp1665 cp6 vrefl 4.948e-16
Cp1666 cp6 xc4_din 5.674e-16
Cp1667 cp6 xc4_dip 1.168e-15
Cp1668 cp7 cp8 1.641e-16
Cp1669 cp7 cp9 2.68e-17
Cp1670 cp7 gnd 8.446e-15
Cp1671 cp7 lsb_n 4.434e-17
Cp1672 cp7 lsb_p 2.808e-15
Cp1673 cp7 rstb 3.184e-17
Cp1674 cp7 t1 2.901e-15
Cp1675 cp7 vdd 6.018e-16
Cp1676 cp7 vref 1.432e-17
Cp1677 cp7 vrefl 8.586e-16
Cp1678 cp7 xc4_din 1.748e-15
Cp1679 cp7 xc4_dip 4.418e-17
Cp1680 cp8 cp9 1.219e-15
Cp1681 cp8 gnd 7.266e-15
Cp1682 cp8 lsb_n 5.157e-17
Cp1683 cp8 lsb_p 1.947e-16
Cp1684 cp8 rstb 1.318e-17
Cp1685 cp8 t1 1.086e-19
Cp1686 cp8 vdd 7.094e-16
Cp1687 cp8 vref 2.995e-16
Cp1688 cp8 vrefl 1.554e-15
Cp1689 cp8 xc4_din 1.002e-15
Cp1690 cp8 xc4_dip 6.852e-16
Cp1691 cp9 gnd 4.646e-15
Cp1692 cp9 lsb_n 5.037e-17
Cp1693 cp9 lsb_p 6.516e-17
Cp1694 cp9 rstb 6.47e-17
Cp1695 cp9 t1 1.086e-19
Cp1696 cp9 vdd 4.944e-16
Cp1697 cp9 vref 8.659e-16
Cp1698 cp9 xc4_din 1.881e-15
Cp1699 cp9 xc4_dip 4.903e-17
Cp1700 gnd in0n 1.027e-15
Cp1701 gnd in0p 1.674e-15
Cp1702 gnd in1n 2.397e-15
Cp1703 gnd in1p 2.014e-15
Cp1704 gnd lsb_n 1.332e-14
Cp1705 gnd lsb_p 1.767e-14
Cp1706 gnd nr 9.126e-16
Cp1707 gnd on 1.213e-14
Cp1708 gnd onn 2.15e-14
Cp1709 gnd onp 1.985e-14
Cp1710 gnd op 1.066e-14
Cp1711 gnd rstb 7.173e-15
Cp1712 gnd rstb_n 2.426e-15
Cp1713 gnd t0 6.719e-15
Cp1714 gnd t0b 9.65e-15
Cp1715 gnd t1 2.558e-14
Cp1716 gnd t1b 2.009e-14
Cp1717 gnd top_n 1.742e-14
Cp1718 gnd top_p 1.642e-14
Cp1719 gnd trk0 9.441e-15
Cp1720 gnd trk1 4.621e-15
Cp1721 gnd vbn 1.372e-15
Cp1722 gnd vbp 7.395e-15
Cp1723 gnd vdd 8.726e-14
Cp1724 gnd vref 2.02e-14
Cp1725 gnd vrefl 2.314e-14
Cp1726 gnd xc4_din 4.752e-14
Cp1727 gnd xc4_dip 4.881e-14
Cp1728 gnd xc4_lt 1.87e-15
Cp1729 gnd xc4_outnb 2.578e-15
Cp1730 gnd xc4_outpb 2.892e-15
Cp1731 gnd xc4_xs1_tail 7.163e-15
Cp1732 gnd xc4_xs1_tail0 1.86e-15
Cp1733 gnd xc5_din 2.357e-14
Cp1734 gnd xc5_dip 2.615e-14
Cp1735 gnd xc5_lt 6.503e-15
Cp1736 gnd xc5_outnb 2.862e-15
Cp1737 gnd xc5_outpb 2.207e-15
Cp1738 gnd xc5_xs1_tail 4.102e-15
Cp1739 gnd xc5_xs1_tail0 2.974e-15
Cp1740 gnd xs0n_cbn 3.654e-15
Cp1741 gnd xs0n_cbp 2.066e-15
Cp1742 gnd xs0n_g 5.346e-15
Cp1743 gnd xs0n_n10 1.177e-15
Cp1744 gnd xs0n_x 1.811e-15
Cp1745 gnd xs0p_cbn 5.544e-15
Cp1746 gnd xs0p_cbp 2.183e-15
Cp1747 gnd xs0p_g 4.303e-15
Cp1748 gnd xs0p_n10 1.251e-15
Cp1749 gnd xs0p_x 1.952e-15
Cp1750 gnd xs1n_cbn 5.067e-15
Cp1751 gnd xs1n_cbp 2.565e-15
Cp1752 gnd xs1n_g 4.493e-15
Cp1753 gnd xs1n_n10 1.424e-15
Cp1754 gnd xs1n_x 3.512e-15
Cp1755 gnd xs1p_cbn 6.112e-15
Cp1756 gnd xs1p_cbp 1.863e-15
Cp1757 gnd xs1p_g 6.18e-15
Cp1758 gnd xs1p_n10 1.182e-15
Cp1759 gnd xs1p_x 2.507e-15
Cp1760 in0n in0p 1.139e-16
Cp1761 in0n lsb_n 1.287e-17
Cp1762 in0n onn 1.84e-19
Cp1763 in0n t0 5.811e-16
Cp1764 in0n t0b 1.412e-15
Cp1765 in0n top_n 9.095e-16
Cp1766 in0n trk0 3.725e-18
Cp1767 in0n trk1 2.667e-19
Cp1768 in0n vdd 7.106e-16
Cp1769 in0n xs0n_cbn 1.535e-15
Cp1770 in0n xs0n_cbp 1.743e-17
Cp1771 in0n xs0n_g 1.43e-15
Cp1772 in0n xs0n_n10 1.653e-16
Cp1773 in0n xs0n_x 4.515e-17
Cp1774 in0p lsb_n 6.513e-18
Cp1775 in0p lsb_p 3.531e-19
Cp1776 in0p t0 7.568e-16
Cp1777 in0p t0b 7.761e-16
Cp1778 in0p top_n 9.177e-17
Cp1779 in0p top_p 8.779e-16
Cp1780 in0p trk0 2.003e-19
Cp1781 in0p trk1 1.328e-16
Cp1782 in0p vdd 1.259e-15
Cp1783 in0p xs0n_cbn 1.355e-15
Cp1784 in0p xs0n_cbp 1.518e-16
Cp1785 in0p xs0n_g 5.851e-16
Cp1786 in0p xs0n_n10 3.01e-17
Cp1787 in0p xs0n_x 1.541e-15
Cp1788 in0p xs0p_cbn 2.736e-16
Cp1789 in0p xs0p_g 2.204e-16
Cp1790 in1n in1p 2.488e-16
Cp1791 in1n t1 7.673e-16
Cp1792 in1n t1b 1.054e-15
Cp1793 in1n top_n 9.623e-16
Cp1794 in1n vdd 1.162e-15
Cp1795 in1n xs1n_cbn 1.276e-15
Cp1796 in1n xs1n_cbp 3.758e-18
Cp1797 in1n xs1n_g 1.987e-16
Cp1798 in1n xs1n_n10 5.198e-19
Cp1799 in1n xs1n_x 3.421e-17
Cp1800 in1n xs1p_cbn 8.349e-19
Cp1801 in1n xs1p_g 3.356e-19
Cp1802 in1p t1 2.9e-15
Cp1803 in1p t1b 7.823e-17
Cp1804 in1p top_n 1.523e-16
Cp1805 in1p top_p 7.779e-16
Cp1806 in1p vdd 7.687e-16
Cp1807 in1p xs1n_cbn 5.943e-19
Cp1808 in1p xs1n_g 2.425e-19
Cp1809 in1p xs1n_x 4.658e-17
Cp1810 in1p xs1p_cbn 4.273e-16
Cp1811 in1p xs1p_cbp 5.649e-18
Cp1812 in1p xs1p_g 2.33e-16
Cp1813 in1p xs1p_n10 1.342e-18
Cp1814 in1p xs1p_x 1.473e-17
Cp1815 lsb_n lsb_p 1.276e-16
Cp1816 lsb_n on 1.001e-16
Cp1817 lsb_n onn 2.725e-16
Cp1818 lsb_n onp 1.592e-16
Cp1819 lsb_n op 6.983e-16
Cp1820 lsb_n rstb 3.135e-17
Cp1821 lsb_n t0 8.931e-17
Cp1822 lsb_n t0b 1.4e-18
Cp1823 lsb_n top_n 9.784e-16
Cp1824 lsb_n top_p 2.101e-17
Cp1825 lsb_n trk0 7.019e-16
Cp1826 lsb_n trk1 1.531e-15
Cp1827 lsb_n vdd 6.279e-16
Cp1828 lsb_n vref 5.674e-18
Cp1829 lsb_n vrefl 1.089e-15
Cp1830 lsb_n xc4_din 2.825e-15
Cp1831 lsb_n xc4_dip 7.842e-16
Cp1832 lsb_n xc4_lt 2.934e-18
Cp1833 lsb_n xs0n_cbn 5.475e-16
Cp1834 lsb_n xs0n_cbp 2.29e-17
Cp1835 lsb_n xs0n_g 8.93e-17
Cp1836 lsb_n xs0n_n10 2.966e-18
Cp1837 lsb_n xs0n_x 5.279e-16
Cp1838 lsb_p on 1.212e-16
Cp1839 lsb_p onn 1.071e-15
Cp1840 lsb_p onp 2.405e-16
Cp1841 lsb_p op 1.427e-16
Cp1842 lsb_p rstb 4.228e-16
Cp1843 lsb_p rstb_n 2.948e-17
Cp1844 lsb_p t0 2.671e-16
Cp1845 lsb_p t0b 1.693e-18
Cp1846 lsb_p t1 1.123e-16
Cp1847 lsb_p t1b 9.278e-17
Cp1848 lsb_p top_n 5.571e-17
Cp1849 lsb_p top_p 7.801e-16
Cp1850 lsb_p trk0 1.536e-15
Cp1851 lsb_p trk1 6.255e-16
Cp1852 lsb_p vbp 5.048e-17
Cp1853 lsb_p vdd 1.217e-14
Cp1854 lsb_p vref 4.794e-16
Cp1855 lsb_p vrefl 1.273e-15
Cp1856 lsb_p xc4_din 3.632e-16
Cp1857 lsb_p xc4_dip 5.559e-17
Cp1858 lsb_p xc4_lt 1.973e-16
Cp1859 lsb_p xc4_outpb 2.264e-19
Cp1860 lsb_p xc4_xs1_tail 4.793e-17
Cp1861 lsb_p xc4_xs1_tail0 3.09e-18
Cp1862 lsb_p xc5_din 2.921e-18
Cp1863 lsb_p xc5_dip 2.314e-18
Cp1864 lsb_p xc5_lt 1.384e-14
Cp1865 lsb_p xc5_outnb 2.754e-16
Cp1866 lsb_p xc5_outpb 5.673e-17
Cp1867 lsb_p xs0n_cbn 1.822e-17
Cp1868 lsb_p xs0n_x 5.607e-18
Cp1869 lsb_p xs0p_cbn 2.934e-17
Cp1870 lsb_p xs0p_g 3.239e-16
Cp1871 lsb_p xs0p_x 6.99e-17
Cp1872 nr rstb 1.182e-17
Cp1873 nr rstb_n 6.318e-16
Cp1874 nr t0b 2.276e-16
Cp1875 nr t1 1.254e-16
Cp1876 nr t1b 2.171e-16
Cp1877 nr trk1 1.142e-19
Cp1878 nr vdd 2.353e-17
Cp1879 on onn 6.63e-17
Cp1880 on onp 7.609e-16
Cp1881 on op 8.229e-15
Cp1882 on rstb 2.104e-18
Cp1883 on t1b 8.692e-19
Cp1884 on vbp 7.455e-19
Cp1885 on vdd 2.51e-15
Cp1886 on vrefl 2.942e-16
Cp1887 on xc4_din 2.391e-15
Cp1888 on xc4_dip 1.883e-15
Cp1889 on xc4_lt 4.163e-16
Cp1890 on xc4_outnb 9.375e-16
Cp1891 on xc4_outpb 4.491e-16
Cp1892 on xc4_xs1_tail 9.663e-18
Cp1893 on xc4_xs1_tail0 9.131e-18
Cp1894 on xc5_lt 3.843e-18
Cp1895 on xc5_outnb 1.93e-16
Cp1896 on xc5_outpb 3.967e-16
Cp1897 onn onp 1.742e-14
Cp1898 onn op 1.26e-16
Cp1899 onn rstb 4.866e-15
Cp1900 onn rstb_n 1.482e-18
Cp1901 onn t0 1.983e-15
Cp1902 onn t0b 5.427e-17
Cp1903 onn t1 5.275e-17
Cp1904 onn t1b 1.868e-16
Cp1905 onn top_n 3.259e-16
Cp1906 onn top_p 5.654e-16
Cp1907 onn trk0 3.625e-15
Cp1908 onn trk1 2.784e-15
Cp1909 onn vbp 4.802e-17
Cp1910 onn vdd 4.375e-15
Cp1911 onn vref 5.472e-16
Cp1912 onn vrefl 3.362e-16
Cp1913 onn xc4_din 9.418e-19
Cp1914 onn xc4_dip 5.087e-17
Cp1915 onn xc4_outnb 5.919e-17
Cp1916 onn xc4_outpb 5.566e-17
Cp1917 onn xc4_xs1_tail 5.386e-17
Cp1918 onn xc4_xs1_tail0 8.11e-16
Cp1919 onn xc5_din 1.166e-16
Cp1920 onn xc5_dip 5.455e-18
Cp1921 onn xc5_lt 4.162e-15
Cp1922 onn xc5_outnb 1.393e-16
Cp1923 onn xc5_outpb 3.927e-16
Cp1924 onn xc5_xs1_tail 7.053e-18
Cp1925 onn xc5_xs1_tail0 1.406e-18
Cp1926 onn xs0n_cbn 2.348e-16
Cp1927 onn xs0n_cbp 2.837e-18
Cp1928 onn xs0n_g 5.671e-19
Cp1929 onn xs0n_x 2.384e-16
Cp1930 onn xs0p_cbn 3.729e-16
Cp1931 onn xs0p_cbp 4.525e-18
Cp1932 onn xs0p_g 2.241e-18
Cp1933 onn xs0p_n10 7.942e-19
Cp1934 onn xs0p_x 2.463e-16
Cp1935 onp op 1.941e-15
Cp1936 onp rstb 2.468e-16
Cp1937 onp t0 1.198e-16
Cp1938 onp t0b 1.229e-16
Cp1939 onp t1 1.147e-16
Cp1940 onp t1b 1.45e-14
Cp1941 onp trk0 3.143e-19
Cp1942 onp trk1 3.433e-16
Cp1943 onp vbp 1.967e-16
Cp1944 onp vdd 2.279e-15
Cp1945 onp vref 4.422e-16
Cp1946 onp vrefl 3.205e-16
Cp1947 onp xc4_din 6.01e-19
Cp1948 onp xc4_dip 1.475e-16
Cp1949 onp xc4_lt 1.969e-18
Cp1950 onp xc4_outnb 1.328e-16
Cp1951 onp xc4_outpb 1.172e-16
Cp1952 onp xc4_xs1_tail 1.329e-16
Cp1953 onp xc4_xs1_tail0 8.373e-16
Cp1954 onp xc5_din 1.508e-17
Cp1955 onp xc5_dip 1.155e-16
Cp1956 onp xc5_lt 1.655e-15
Cp1957 onp xc5_outnb 2.976e-16
Cp1958 onp xc5_outpb 6.172e-16
Cp1959 onp xc5_xs1_tail 1.026e-17
Cp1960 onp xc5_xs1_tail0 2.901e-18
Cp1961 op rstb 5.781e-17
Cp1962 op t1 7.725e-17
Cp1963 op t1b 6.324e-17
Cp1964 op vbp 4.066e-18
Cp1965 op vdd 3.151e-15
Cp1966 op vrefl 3.741e-17
Cp1967 op xc4_din 1.887e-15
Cp1968 op xc4_dip 2.406e-15
Cp1969 op xc4_lt 6.646e-16
Cp1970 op xc4_outnb 4.674e-17
Cp1971 op xc4_outpb 5.327e-16
Cp1972 op xc4_xs1_tail 8.18e-17
Cp1973 op xc4_xs1_tail0 8.233e-19
Cp1974 op xc5_lt 5.975e-17
Cp1975 op xc5_outnb 2.304e-15
Cp1976 op xc5_outpb 1.357e-16
Cp1977 rstb rstb_n 2.06e-16
Cp1978 rstb t1 8.294e-17
Cp1979 rstb t1b 3.498e-16
Cp1980 rstb vbp 4.61e-17
Cp1981 rstb vdd 1.432e-15
Cp1982 rstb vref 1.936e-16
Cp1983 rstb vrefl 1.019e-15
Cp1984 rstb xc4_din 5.43e-16
Cp1985 rstb xc4_dip 3.419e-16
Cp1986 rstb xc4_outnb 3.319e-19
Cp1987 rstb xc4_outpb 1.49e-19
Cp1988 rstb xc4_xs1_tail 4.555e-17
Cp1989 rstb xc4_xs1_tail0 1.454e-18
Cp1990 rstb xc5_lt 5.795e-15
Cp1991 rstb_n t0b 1.639e-16
Cp1992 rstb_n t1 6.46e-16
Cp1993 rstb_n t1b 4.75e-16
Cp1994 rstb_n vdd 9.995e-16
Cp1995 t0 t0b 2.156e-15
Cp1996 t0 t1 9.198e-18
Cp1997 t0 t1b 3.496e-18
Cp1998 t0 top_n 1.811e-16
Cp1999 t0 top_p 3.038e-16
Cp2000 t0 trk0 1.886e-16
Cp2001 t0 trk1 2.919e-15
Cp2002 t0 vdd 5.398e-15
Cp2003 t0 xc5_outpb 1.55e-17
Cp2004 t0 xs0n_cbn 1.092e-15
Cp2005 t0 xs0n_cbp 7.937e-16
Cp2006 t0 xs0n_g 5.268e-16
Cp2007 t0 xs0n_n10 5.81e-17
Cp2008 t0 xs0n_x 2.683e-16
Cp2009 t0 xs0p_cbn 3.625e-16
Cp2010 t0 xs0p_cbp 6.811e-18
Cp2011 t0 xs0p_g 1.821e-16
Cp2012 t0 xs0p_n10 1.171e-18
Cp2013 t0 xs0p_x 8.399e-17
Cp2014 t0b t1 4.779e-16
Cp2015 t0b t1b 7.629e-16
Cp2016 t0b top_n 1.042e-16
Cp2017 t0b top_p 1.06e-16
Cp2018 t0b trk0 2.571e-15
Cp2019 t0b trk1 1.003e-16
Cp2020 t0b vdd 3.978e-15
Cp2021 t0b xc5_outpb 1.415e-19
Cp2022 t0b xs0n_cbn 6.588e-16
Cp2023 t0b xs0n_cbp 1.496e-16
Cp2024 t0b xs0n_g 1.041e-15
Cp2025 t0b xs0n_n10 5.382e-17
Cp2026 t0b xs0n_x 7.969e-18
Cp2027 t0b xs0p_cbn 3.969e-16
Cp2028 t0b xs0p_cbp 2.396e-18
Cp2029 t0b xs0p_g 8.924e-17
Cp2030 t0b xs0p_n10 3.409e-17
Cp2031 t0b xs0p_x 8.313e-17
Cp2032 t1 t1b 2.498e-15
Cp2033 t1 top_n 1.928e-16
Cp2034 t1 top_p 5.602e-17
Cp2035 t1 trk1 1.944e-18
Cp2036 t1 vbp 2.32e-16
Cp2037 t1 vdd 2.961e-15
Cp2038 t1 vref 2.769e-15
Cp2039 t1 vrefl 6.642e-16
Cp2040 t1 xc4_din 6.085e-17
Cp2041 t1 xc4_dip 6.097e-17
Cp2042 t1 xc4_xs1_tail 1.337e-15
Cp2043 t1 xc5_dip 5.837e-16
Cp2044 t1 xc5_lt 5.114e-17
Cp2045 t1 xs1n_cbn 1.139e-15
Cp2046 t1 xs1n_cbp 3.21e-17
Cp2047 t1 xs1n_g 1.66e-15
Cp2048 t1 xs1n_n10 8.606e-18
Cp2049 t1 xs1n_x 1.133e-15
Cp2050 t1 xs1p_cbn 3.123e-16
Cp2051 t1 xs1p_cbp 6.332e-18
Cp2052 t1 xs1p_g 1.037e-16
Cp2053 t1 xs1p_n10 9.282e-19
Cp2054 t1 xs1p_x 1.187e-16
Cp2055 t1b top_n 6.154e-16
Cp2056 t1b top_p 5.276e-16
Cp2057 t1b trk1 2.232e-16
Cp2058 t1b vbn 1.178e-19
Cp2059 t1b vbp 5.789e-17
Cp2060 t1b vdd 5.483e-15
Cp2061 t1b vref 5.474e-16
Cp2062 t1b vrefl 3.712e-16
Cp2063 t1b xc4_din 2.382e-16
Cp2064 t1b xc4_dip 5.092e-17
Cp2065 t1b xc4_xs1_tail 4.94e-15
Cp2066 t1b xc4_xs1_tail0 5.488e-19
Cp2067 t1b xc5_din 6.164e-17
Cp2068 t1b xc5_dip 6.269e-16
Cp2069 t1b xc5_lt 1.499e-16
Cp2070 t1b xc5_xs1_tail 1.214e-18
Cp2071 t1b xc5_xs1_tail0 2.503e-18
Cp2072 t1b xs1n_cbn 2.368e-15
Cp2073 t1b xs1n_cbp 4.365e-16
Cp2074 t1b xs1n_g 1.252e-15
Cp2075 t1b xs1n_n10 1.003e-16
Cp2076 t1b xs1n_x 8.395e-17
Cp2077 t1b xs1p_cbn 6.752e-16
Cp2078 t1b xs1p_cbp 2.555e-18
Cp2079 t1b xs1p_g 6.252e-17
Cp2080 t1b xs1p_n10 4.582e-17
Cp2081 t1b xs1p_x 1.031e-16
Cp2082 top_n top_p 4.511e-15
Cp2083 top_n trk0 1.059e-16
Cp2084 top_n trk1 8.361e-16
Cp2085 top_n vdd 1.76e-15
Cp2086 top_n xc4_din 1.419e-15
Cp2087 top_n xc4_dip 6.064e-17
Cp2088 top_n xc4_xs1_tail 1.358e-15
Cp2089 top_n xc5_din 1.532e-15
Cp2090 top_n xc5_dip 7.229e-17
Cp2091 top_n xc5_lt 6.856e-17
Cp2092 top_n xc5_xs1_tail 9.804e-16
Cp2093 top_n xs0n_cbn 1.059e-15
Cp2094 top_n xs0n_cbp 3.93e-18
Cp2095 top_n xs0n_g 4.61e-16
Cp2096 top_n xs0n_n10 1.167e-18
Cp2097 top_n xs0n_x 1.715e-16
Cp2098 top_n xs0p_g 1.348e-18
Cp2099 top_n xs1n_cbn 1.015e-15
Cp2100 top_n xs1n_cbp 1.587e-16
Cp2101 top_n xs1n_g 2.954e-16
Cp2102 top_n xs1n_n10 4.489e-17
Cp2103 top_n xs1n_x 5.754e-16
Cp2104 top_n xs1p_cbn 3.946e-18
Cp2105 top_n xs1p_g 4.756e-17
Cp2106 top_p trk0 1.564e-15
Cp2107 top_p trk1 9.546e-17
Cp2108 top_p vdd 6.755e-15
Cp2109 top_p xc4_din 3.077e-16
Cp2110 top_p xc4_dip 1.276e-15
Cp2111 top_p xc4_xs1_tail 1.469e-15
Cp2112 top_p xc5_din 6.41e-16
Cp2113 top_p xc5_dip 6.505e-16
Cp2114 top_p xc5_lt 6.367e-17
Cp2115 top_p xc5_xs1_tail 1.1e-15
Cp2116 top_p xs0p_cbn 2.356e-16
Cp2117 top_p xs0p_cbp 3.641e-18
Cp2118 top_p xs0p_g 1.393e-16
Cp2119 top_p xs0p_x 7.636e-17
Cp2120 top_p xs1n_cbn 2.078e-16
Cp2121 top_p xs1n_cbp 6.99e-18
Cp2122 top_p xs1n_g 2.97e-16
Cp2123 top_p xs1n_n10 2.649e-17
Cp2124 top_p xs1p_cbn 5.337e-18
Cp2125 top_p xs1p_g 8.611e-17
Cp2126 top_p xs1p_n10 2.171e-19
Cp2127 trk0 trk1 2.571e-15
Cp2128 trk0 vdd 1.274e-15
Cp2129 trk0 xs0n_cbn 9.62e-17
Cp2130 trk0 xs0n_cbp 1.634e-18
Cp2131 trk0 xs0n_g 2.521e-17
Cp2132 trk0 xs0n_n10 6.184e-18
Cp2133 trk0 xs0n_x 3.038e-16
Cp2134 trk0 xs0p_cbn 7.147e-16
Cp2135 trk0 xs0p_cbp 5.054e-18
Cp2136 trk0 xs0p_g 2.252e-16
Cp2137 trk0 xs0p_n10 1.062e-19
Cp2138 trk0 xs0p_x 2.271e-16
Cp2139 trk1 vdd 2.056e-15
Cp2140 trk1 xc5_outpb 1.927e-16
Cp2141 trk1 xs0n_cbn 3.264e-16
Cp2142 trk1 xs0n_cbp 4.219e-17
Cp2143 trk1 xs0n_g 1.141e-17
Cp2144 trk1 xs0n_n10 5.278e-19
Cp2145 trk1 xs0n_x 7.115e-16
Cp2146 trk1 xs0p_cbn 2.719e-16
Cp2147 trk1 xs0p_cbp 7.368e-18
Cp2148 trk1 xs0p_g 7.312e-16
Cp2149 trk1 xs0p_n10 1.822e-18
Cp2150 trk1 xs0p_x 1.074e-16
Cp2151 vbn vbp 6.554e-16
Cp2152 vbn vrefl 8.977e-18
Cp2153 vbn xc4_xs1_tail 4.133e-18
Cp2154 vbn xc5_din 1.291e-17
Cp2155 vbn xc5_dip 4.802e-17
Cp2156 vbn xc5_xs1_tail 1.148e-16
Cp2157 vbn xc5_xs1_tail0 3.218e-16
Cp2158 vbp vdd 5.953e-16
Cp2159 vbp vref 4.899e-16
Cp2160 vbp vrefl 8.126e-15
Cp2161 vbp xc4_dip 4.722e-17
Cp2162 vbp xc4_xs1_tail 1.505e-15
Cp2163 vbp xc4_xs1_tail0 1e-15
Cp2164 vbp xc5_din 2.095e-17
Cp2165 vbp xc5_dip 1.216e-16
Cp2166 vbp xc5_lt 4.693e-17
Cp2167 vbp xc5_outnb 1.859e-18
Cp2168 vbp xc5_xs1_tail0 2.468e-18
Cp2169 vdd vref 2.435e-15
Cp2170 vdd vrefl 2.249e-15
Cp2171 vdd xc4_din 1.582e-14
Cp2172 vdd xc4_dip 1.627e-14
Cp2173 vdd xc4_outnb 2.193e-16
Cp2174 vdd xc4_outpb 3.04e-16
Cp2175 vdd xc4_xs1_tail 1.292e-15
Cp2176 vdd xc4_xs1_tail0 2.503e-15
Cp2177 vdd xc5_din 2.747e-15
Cp2178 vdd xc5_dip 2.364e-15
Cp2179 vdd xc5_lt 4.762e-15
Cp2180 vdd xc5_outnb 4.318e-16
Cp2181 vdd xc5_outpb 2.958e-16
Cp2182 vdd xc5_xs1_tail 3.041e-16
Cp2183 vdd xs0n_cbn 4.066e-15
Cp2184 vdd xs0n_cbp 6.869e-16
Cp2185 vdd xs0n_g 2.067e-15
Cp2186 vdd xs0n_n10 1.024e-15
Cp2187 vdd xs0n_x 5.214e-16
Cp2188 vdd xs0p_cbn 3.532e-15
Cp2189 vdd xs0p_cbp 6.607e-16
Cp2190 vdd xs0p_g 1.611e-15
Cp2191 vdd xs0p_n10 1.098e-16
Cp2192 vdd xs0p_x 1.211e-15
Cp2193 vdd xs1n_cbn 3.418e-15
Cp2194 vdd xs1n_cbp 3.767e-16
Cp2195 vdd xs1n_g 9.535e-16
Cp2196 vdd xs1n_n10 3.544e-16
Cp2197 vdd xs1n_x 4.34e-16
Cp2198 vdd xs1p_cbn 3.241e-15
Cp2199 vdd xs1p_cbp 5.114e-16
Cp2200 vdd xs1p_g 1.358e-15
Cp2201 vdd xs1p_n10 7.43e-16
Cp2202 vdd xs1p_x 3.999e-16
Cp2203 vref vrefl 1.193e-15
Cp2204 vref xc4_din 9.557e-17
Cp2205 vref xc4_dip 1.283e-15
Cp2206 vref xc4_xs1_tail 7.211e-16
Cp2207 vref xc5_din 5.329e-16
Cp2208 vref xc5_dip 1.574e-15
Cp2209 vref xc5_lt 5.472e-16
Cp2210 vrefl xc4_din 1.106e-15
Cp2211 vrefl xc4_dip 9.309e-16
Cp2212 vrefl xc4_outnb 3.123e-16
Cp2213 vrefl xc4_outpb 7.324e-18
Cp2214 vrefl xc4_xs1_tail 4.806e-16
Cp2215 vrefl xc5_din 1.678e-15
Cp2216 vrefl xc5_dip 6.761e-16
Cp2217 vrefl xc5_lt 3.344e-16
Cp2218 xc4_din xc4_dip 7.855e-15
Cp2219 xc4_din xc4_outnb 4.033e-17
Cp2220 xc4_din xc4_outpb 5.331e-17
Cp2221 xc4_din xc4_xs1_tail 7.615e-15
Cp2222 xc4_din xc5_din 6.554e-16
Cp2223 xc4_din xc5_dip 2.806e-16
Cp2224 xc4_din xc5_lt 1.022e-16
Cp2225 xc4_din xc5_xs1_tail 1.185e-17
Cp2226 xc4_dip xc4_outnb 5.082e-17
Cp2227 xc4_dip xc4_outpb 6.049e-17
Cp2228 xc4_dip xc4_xs1_tail 3.968e-15
Cp2229 xc4_dip xc4_xs1_tail0 1.267e-17
Cp2230 xc4_dip xc5_din 2.44e-15
Cp2231 xc4_dip xc5_dip 1.254e-16
Cp2232 xc4_dip xc5_lt 8.043e-17
Cp2233 xc4_dip xc5_outnb 1.84e-19
Cp2234 xc4_dip xc5_xs1_tail 6.523e-16
Cp2235 xc4_lt xc4_outnb 4.937e-19
Cp2236 xc4_lt xc4_outpb 7.066e-19
Cp2237 xc4_lt xc5_outnb 3.628e-17
Cp2238 xc4_lt xc5_outpb 3.963e-17
Cp2239 xc4_outnb xc4_outpb 4.558e-15
Cp2240 xc4_outnb xc5_outnb 2.008e-17
Cp2241 xc4_outnb xc5_outpb 1.916e-17
Cp2242 xc4_outpb xc5_lt 1.818e-19
Cp2243 xc4_outpb xc5_outnb 1.509e-16
Cp2244 xc4_outpb xc5_outpb 1.157e-15
Cp2245 xc4_xs1_tail xc4_xs1_tail0 7.512e-16
Cp2246 xc4_xs1_tail xc5_din 8.543e-16
Cp2247 xc4_xs1_tail xc5_dip 1.229e-15
Cp2248 xc4_xs1_tail xc5_lt 4.894e-17
Cp2249 xc4_xs1_tail xc5_xs1_tail 3.014e-16
Cp2250 xc4_xs1_tail xc5_xs1_tail0 1.649e-17
Cp2251 xc4_xs1_tail0 xc5_lt 2.07e-18
Cp2252 xc4_xs1_tail0 xc5_outnb 8.383e-18
Cp2253 xc5_din xc5_dip 6.111e-15
Cp2254 xc5_din xc5_lt 5.551e-17
Cp2255 xc5_din xc5_xs1_tail 1.235e-15
Cp2256 xc5_din xc5_xs1_tail0 7.181e-17
Cp2257 xc5_dip xc5_lt 9.493e-16
Cp2258 xc5_dip xc5_xs1_tail 1.189e-15
Cp2259 xc5_dip xc5_xs1_tail0 6.357e-17
Cp2260 xc5_lt xc5_outnb 1.102e-19
Cp2261 xc5_lt xc5_outpb 9.651e-18
Cp2262 xc5_lt xc5_xs1_tail 3.02e-19
Cp2263 xc5_lt xc5_xs1_tail0 6.861e-19
Cp2264 xc5_outnb xc5_outpb 2.774e-15
Cp2265 xc5_xs1_tail xc5_xs1_tail0 2.31e-16
Cp2266 xs0n_cbn xs0n_cbp 3.369e-16
Cp2267 xs0n_cbn xs0n_g 9.357e-16
Cp2268 xs0n_cbn xs0n_n10 4.184e-16
Cp2269 xs0n_cbn xs0n_x 8.079e-16
Cp2270 xs0n_cbp xs0n_g 5.319e-16
Cp2271 xs0n_cbp xs0n_n10 1.412e-17
Cp2272 xs0n_cbp xs0n_x 1.013e-16
Cp2273 xs0n_cbp xs0p_g 2.454e-17
Cp2274 xs0n_g xs0n_n10 4.537e-16
Cp2275 xs0n_g xs0n_x 6.461e-16
Cp2276 xs0n_g xs0p_g 7.039e-18
Cp2277 xs0n_n10 xs0n_x 1.403e-17
Cp2278 xs0n_x xs0p_g 1.4e-17
Cp2279 xs0p_cbn xs0p_cbp 9.792e-16
Cp2280 xs0p_cbn xs0p_g 1.643e-15
Cp2281 xs0p_cbn xs0p_n10 6.457e-16
Cp2282 xs0p_cbn xs0p_x 1.239e-15
Cp2283 xs0p_cbp xs0p_g 6.505e-16
Cp2284 xs0p_cbp xs0p_n10 7.432e-17
Cp2285 xs0p_cbp xs0p_x 6.865e-16
Cp2286 xs0p_g xs0p_n10 5.012e-16
Cp2287 xs0p_g xs0p_x 1.588e-15
Cp2288 xs0p_n10 xs0p_x 2.417e-17
Cp2289 xs1n_cbn xs1n_cbp 3.622e-16
Cp2290 xs1n_cbn xs1n_g 1.996e-15
Cp2291 xs1n_cbn xs1n_n10 1.342e-16
Cp2292 xs1n_cbn xs1n_x 9.598e-16
Cp2293 xs1n_cbp xs1n_g 7.312e-16
Cp2294 xs1n_cbp xs1n_n10 1.349e-16
Cp2295 xs1n_cbp xs1n_x 8.788e-17
Cp2296 xs1n_cbp xs1p_g 1.064e-17
Cp2297 xs1n_g xs1n_n10 5.655e-16
Cp2298 xs1n_g xs1n_x 1.812e-16
Cp2299 xs1n_g xs1p_g 2.597e-17
Cp2300 xs1n_n10 xs1n_x 2.448e-17
Cp2301 xs1n_x xs1p_g 1.662e-17
Cp2302 xs1p_cbn xs1p_cbp 1.054e-15
Cp2303 xs1p_cbn xs1p_g 1.73e-15
Cp2304 xs1p_cbn xs1p_n10 5.149e-16
Cp2305 xs1p_cbn xs1p_x 1.162e-15
Cp2306 xs1p_cbp xs1p_g 5.801e-16
Cp2307 xs1p_cbp xs1p_n10 7.28e-17
Cp2308 xs1p_cbp xs1p_x 7.252e-16
Cp2309 xs1p_g xs1p_n10 4.625e-16
Cp2310 xs1p_g xs1p_x 1.816e-15
Cp2311 xs1p_n10 xs1p_x 2.417e-17
.ends
.subckt r1_adc_lay adc_hold is_smp clk adc_start adc_sel adc_valid_a adc_raw_a_0 adc_raw_a_1 adc_raw_a_2 adc_raw_a_3 adc_raw_a_4 adc_raw_a_5 adc_raw_a_6 adc_raw_a_7 adc_raw_a_8 adc_raw_a_9 adc_raw_a_10 adc_raw_a_11 adc_raw_a_12 adc_raw_a_13 adc_valid_b adc_raw_b_0 adc_raw_b_1 adc_raw_b_2 adc_raw_b_3 adc_raw_b_4 adc_raw_b_5 adc_raw_b_6 adc_raw_b_7 adc_raw_b_8 adc_raw_b_9 adc_raw_b_10 adc_raw_b_11 adc_raw_b_12 adc_raw_b_13 por_n ain_sin_p ain_sin_n ain_cos_p ain_cos_n vcm2 ibias ain_isa_p ain_isa_n ain_isb_p ain_isb_n vcm vdda vdd vss vref_in topap topan topbp topbn sar_clka sar_clkab sar_clkb sar_clkbb sar_clkna sar_clknab sar_clknb sar_clknbb sar_cna0 sar_cna1 sar_cna10 sar_cna11 sar_cna12 sar_cna2 sar_cna3 sar_cna4 sar_cna5 sar_cna6 sar_cna7 sar_cna8 sar_cna9 sar_cnb0 sar_cnb1 sar_cnb10 sar_cnb11 sar_cnb12 sar_cnb2 sar_cnb3 sar_cnb4 sar_cnb5 sar_cnb6 sar_cnb7 sar_cnb8 sar_cnb9 sar_cpa0 sar_cpa1 sar_cpa10 sar_cpa11 sar_cpa12 sar_cpa2 sar_cpa3 sar_cpa4 sar_cpa5 sar_cpa6 sar_cpa7 sar_cpa8 sar_cpa9 sar_cpb0 sar_cpb1 sar_cpb10 sar_cpb11 sar_cpb12 sar_cpb2 sar_cpb3 sar_cpb4 sar_cpb5 sar_cpb6 sar_cpb7 sar_cpb8 sar_cpb9 sar_oan sar_oann sar_oanp sar_oap sar_obn sar_obnn sar_obnp sar_obp sar_trka0 sar_trka1 sar_trkb0 sar_trkb1 sar_mclk
Xxckg_xpd0 xckg_d0__p1 clk vdd__p2 vdd sg13_lv_pmos w=1u l=0.5u ng=1 m=1
Xxckg_xnd0 xckg_d0 clk vss__p9 vss sg13_lv_nmos w=0.5u l=0.5u ng=1 m=1
Xxckg_cd0 xckg_d0__p2 vss__p16 cap_cmim w=2.53u l=2.53u m=1
Xxckg_xpd1 xckg_d1__p1 xckg_d0 vdd__p3 vdd sg13_lv_pmos w=1u l=0.5u ng=1 m=1
Xxckg_xnd1 xckg_d1 xckg_d0 vss__p10 vss sg13_lv_nmos w=0.5u l=0.5u ng=1 m=1
Xxckg_cd1 xckg_d1__p2 vss__p17 cap_cmim w=2.53u l=2.53u m=1
Xxckg_xpd2 xckg_d2__p1 xckg_d1 vdd__p4 vdd sg13_lv_pmos w=1u l=0.5u ng=1 m=1
Xxckg_xnd2 xckg_d2 xckg_d1 vss__p11 vss sg13_lv_nmos w=0.5u l=0.5u ng=1 m=1
Xxckg_cd2 xckg_d2__p2 vss__p18 cap_cmim w=2.53u l=2.53u m=1
Xxckg_xpd3 xckg_d3__p1 xckg_d2 vdd__p5 vdd sg13_lv_pmos w=1u l=0.5u ng=1 m=1
Xxckg_xnd3 xckg_d3 xckg_d2 vss__p12 vss sg13_lv_nmos w=0.5u l=0.5u ng=1 m=1
Xxckg_cd3 xckg_d3__p2 vss__p19 cap_cmim w=2.53u l=2.53u m=1
Xxckg_xpd4 xckg_x__p2 xckg_d3 vdd__p6 vdd sg13_lv_pmos w=1u l=0.5u ng=1 m=1
Xxckg_xnd4 xckg_x xckg_d3 vss__p13 vss sg13_lv_nmos w=0.5u l=0.5u ng=1 m=1
Xxckg_cd4 xckg_x__p4 vss__p20 cap_cmim w=2.53u l=2.53u m=1
Xxckg_xpa sar_mclk__p2 clk__p1 vdd__p7 vdd sg13_lv_pmos w=2u l=0.13u ng=1 m=1
Xxckg_xpb sar_mclk__p3 xckg_x__p3 vdd__p8 vdd sg13_lv_pmos w=2u l=0.13u ng=1 m=1
Xxckg_xna sar_mclk__p0 clk__p0 xckg_nn vss sg13_lv_nmos w=2u l=0.13u ng=1 m=1
Xxckg_xnb xckg_nn__p1 xckg_x__p1 vss__p14 vss sg13_lv_nmos w=2u l=0.13u ng=1 m=1
Xxckg_xpi mclkb__p1 sar_mclk__p4 vdd__p9 vdd sg13_lv_pmos w=2u l=0.13u ng=1 m=1
Xxckg_xni mclkb sar_mclk__p1 vss__p15 vss sg13_lv_nmos w=1u l=0.13u ng=1 m=1
Xxcbias_xmbd vbp__p1 vbp vdd__p1 vdd sg13_lv_pmos w=0.8u l=0.5u ng=1 m=1
Xxcbias_xrb_g0 vbp xcbias_xrb_s1 vss rppd w=1u l=40u m=1 b=0
Xxcbias_xrb_g1 xcbias_xrb_s1 xcbias_xrb_s2 vss rppd w=1u l=40u m=1 b=0
Xxcbias_xrb_g2 xcbias_xrb_s2 xcbias_xrb_s3 vss rppd w=1u l=40u m=1 b=0
Xxcbias_xrb_g3 xcbias_xrb_s3 vss__p7 vss rppd w=1u l=40u m=1 b=0
Xxcbiasn_xmbd vbn__p1 vbn vss__p8 vss sg13_lv_nmos w=0.2u l=0.5u ng=1 m=1
Xxcbiasn_xrb_g0 vdd__p0 xcbiasn_xrb_s1 vss rppd w=1u l=40u m=1 b=0
Xxcbiasn_xrb_g1 xcbiasn_xrb_s1 xcbiasn_xrb_s2 vss rppd w=1u l=40u m=1 b=0
Xxcbiasn_xrb_g2 xcbiasn_xrb_s2 xcbiasn_xrb_s3 vss rppd w=1u l=40u m=1 b=0
Xxcbiasn_xrb_g3 xcbiasn_xrb_s3 vbn vss rppd w=1u l=40u m=1 b=0
Xxref_xmb0 ibias__p0 ibias vss__p5 vss sg13_hv_nmos w=2u l=1u ng=1 m=1
Xxref_xmt xref_ntl ibias vss__p6 vss sg13_hv_nmos w=2u l=8u ng=1 m=1
Xxref_xm1 xref_na vref_in xref_ntl__p1 vss sg13_hv_nmos w=10u l=1u ng=2 m=1
Xxref_xm2 xref_ng vref xref_ntl__p2 vss sg13_hv_nmos w=10u l=1u ng=2 m=1
Xxref_xm3 xref_na__p1 xref_na vdda__p5 vdda sg13_hv_pmos w=4u l=1u ng=1 m=1
Xxref_xm4 xref_ng__p1 xref_na vdda__p6 vdda sg13_hv_pmos w=4u l=1u ng=1 m=1
Xxref_xcg_u0 vss xref_ng__p2 cap_cmim w=26.32u l=95u m=1
Xxref_xmsf_s0 vdda__p1 xref_ng vref vss sg13_hv_nmos w=80u l=0.45u ng=32 m=1
Xxref_xmsf_s1 vdda__p2 xref_ng vref__p5 vss sg13_hv_nmos w=80u l=0.45u ng=32 m=1
Xxref_xmsf_s2 vdda__p3 xref_ng vref__p6 vss sg13_hv_nmos w=80u l=0.45u ng=32 m=1
Xxref_xmsf_s3 vdda__p4 xref_ng vref__p7 vss sg13_hv_nmos w=80u l=0.45u ng=32 m=1
Xxref_xmib_s0 vref__p0 ibias vss__p0 vss sg13_hv_nmos w=80u l=1u ng=40 m=1
Xxref_xmib_s1 vref__p1 ibias vss__p1 vss sg13_hv_nmos w=80u l=1u ng=40 m=1
Xxref_xmib_s2 vref__p2 ibias vss__p2 vss sg13_hv_nmos w=80u l=1u ng=40 m=1
Xxref_xmib_s3 vref__p3 ibias vss__p3 vss sg13_hv_nmos w=80u l=1u ng=40 m=1
Xxref_xcd_u0 vss vref__p8 cap_cmim w=51.58u l=95u m=1
Xxref_xcd_u1 vss vref__p9 cap_cmim w=51.58u l=95u m=1
Xxref_xcd_u2 vss vref__p10 cap_cmim w=51.58u l=95u m=1
Xxref_xcd_u3 vss vref__p11 cap_cmim w=51.58u l=95u m=1
Xxref_xmsfl_s0 vdda__p0 xref_ng vrefl vss sg13_hv_nmos w=80u l=0.45u ng=32 m=1
Xxref_xmibl_s0 vrefl__p0 ibias vss__p4 vss sg13_hv_nmos w=80u l=1u ng=40 m=1
Xxref_xcdl_u0 vss vrefl__p2 cap_cmim w=51.58u l=95u m=1
Xxref_xcdl_u1 vss vrefl__p3 cap_cmim w=51.58u l=95u m=1
Xxfilt_xcf_u0 vss vref_in__p1 cap_cmim w=37.36u l=90u m=1
Xxfilt_xcf_u1 vss vref_in__p2 cap_cmim w=37.36u l=90u m=1
Xslice_a ain_sin_p__p1 ain_sin_n__p1 ain_isa_p__p1 ain_isa_n__p1 sar_trka0__p1 sar_trka1__p1 sar_cpa0__p1 sar_cpa1__p1 sar_cpa2__p1 sar_cpa3__p1 sar_cpa4__p1 sar_cpa5__p1 sar_cpa6__p1 sar_cpa7__p1 sar_cpa8__p1 sar_cpa9__p1 sar_cpa10__p1 sar_cpa11__p1 sar_cpa12__p1 sar_cna0__p1 sar_cna1__p1 sar_cna2__p1 sar_cna3__p1 sar_cna4__p1 sar_cna5__p1 sar_cna6__p1 sar_cna7__p1 sar_cna8__p1 sar_cna9__p1 sar_cna10__p1 sar_cna11__p1 sar_cna12__p1 sar_clka__p1 sar_clkab__p1 sar_clkna__p1 sar_clknab__p1 sar_oap__p1 sar_oan__p1 sar_oanp__p1 sar_oann__p1 vbp__p2 vbn__p2 vref__p12 vref__p13 vref__p14 vrefl__p4 vrefl__p5 topap topan vdd__p12 vdd__p13 vdd__p14 vdd__p15 xslice_a_gnd_nc0 vss__p23 xslice_a_gnd_nc2 vss__p24 xslice_a_gnd_nc4 vss__p25 xslice_a_gnd_nc6 vss__p26 r1_adc_slice_post
Xslice_b ain_cos_p__p1 ain_cos_n__p1 ain_isb_p__p1 ain_isb_n__p1 sar_trkb0__p1 sar_trkb1__p1 sar_cpb0__p1 sar_cpb1__p1 sar_cpb2__p1 sar_cpb3__p1 sar_cpb4__p1 sar_cpb5__p1 sar_cpb6__p1 sar_cpb7__p1 sar_cpb8__p1 sar_cpb9__p1 sar_cpb10__p1 sar_cpb11__p1 sar_cpb12__p1 sar_cnb0__p1 sar_cnb1__p1 sar_cnb2__p1 sar_cnb3__p1 sar_cnb4__p1 sar_cnb5__p1 sar_cnb6__p1 sar_cnb7__p1 sar_cnb8__p1 sar_cnb9__p1 sar_cnb10__p1 sar_cnb11__p1 sar_cnb12__p1 sar_clkb__p1 sar_clkbb__p1 sar_clknb__p1 sar_clknbb__p1 sar_obp__p1 sar_obn__p1 sar_obnp__p1 sar_obnn__p1 vbp__p3 vbn__p3 vref__p15 vref__p16 vref__p17 vrefl__p6 vrefl__p7 topbp topbn vdd__p16 vdd__p17 vdd__p18 vdd__p19 vss__p27 xslice_b_gnd_nc1 vss__p28 xslice_b_gnd_nc3 vss__p29 xslice_b_gnd_nc5 vss__p30 xslice_b_gnd_nc7 r1_adc_slice_post
Rt0 ain_cos_n ain_cos_n__p1 126.828
Rt1 ain_cos_p ain_cos_p__p1 128.647
Rt2 ain_isa_n ain_isa_n__p1 127.972
Rt3 ain_isa_p ain_isa_p__p1 129.791
Rt4 ain_isb_n ain_isb_n__p1 0.198
Rt5 ain_isb_p ain_isb_p__p1 0.198
Rt6 ain_sin_n ain_sin_n__p1 0.308
Rt7 ain_sin_p ain_sin_p__p1 0.308
Rt8 clk clk__p0 141.519
Rt9 clk clk__p1 195.072
Rt10 clk__p0 clk__p1 49.582
Rt11 ibias ibias__p0 200.561
Rt12 mclkb mclkb__p1 43.3194
Rt13 sar_clka sar_clka__p1 12.3244
Rt14 sar_clkab sar_clkab__p1 12.3303
Rt15 sar_clkb sar_clkb__p1 12.498
Rt16 sar_clkbb sar_clkbb__p1 12.3244
Rt17 sar_clkna sar_clkna__p1 12.3244
Rt18 sar_clknab sar_clknab__p1 12.322
Rt19 sar_clknb sar_clknb__p1 12.3303
Rt20 sar_clknbb sar_clknbb__p1 12.3303
Rt21 sar_cna0 sar_cna0__p1 12.3244
Rt22 sar_cna1 sar_cna1__p1 12.3303
Rt23 sar_cna10 sar_cna10__p1 12.3244
Rt24 sar_cna11 sar_cna11__p1 12.3244
Rt25 sar_cna12 sar_cna12__p1 12.322
Rt26 sar_cna2 sar_cna2__p1 12.3303
Rt27 sar_cna3 sar_cna3__p1 12.3244
Rt28 sar_cna4 sar_cna4__p1 12.3303
Rt29 sar_cna5 sar_cna5__p1 12.3303
Rt30 sar_cna6 sar_cna6__p1 12.3244
Rt31 sar_cna7 sar_cna7__p1 12.3303
Rt32 sar_cna8 sar_cna8__p1 12.3244
Rt33 sar_cna9 sar_cna9__p1 12.322
Rt34 sar_cnb0 sar_cnb0__p1 12.498
Rt35 sar_cnb1 sar_cnb1__p1 12.322
Rt36 sar_cnb10 sar_cnb10__p1 12.498
Rt37 sar_cnb11 sar_cnb11__p1 12.3303
Rt38 sar_cnb12 sar_cnb12__p1 12.3303
Rt39 sar_cnb2 sar_cnb2__p1 12.3244
Rt40 sar_cnb3 sar_cnb3__p1 12.498
Rt41 sar_cnb4 sar_cnb4__p1 12.322
Rt42 sar_cnb5 sar_cnb5__p1 12.3244
Rt43 sar_cnb6 sar_cnb6__p1 12.498
Rt44 sar_cnb7 sar_cnb7__p1 12.322
Rt45 sar_cnb8 sar_cnb8__p1 12.3303
Rt46 sar_cnb9 sar_cnb9__p1 12.3303
Rt47 sar_cpa0 sar_cpa0__p1 12.3303
Rt48 sar_cpa1 sar_cpa1__p1 12.3244
Rt49 sar_cpa10 sar_cpa10__p1 12.322
Rt50 sar_cpa11 sar_cpa11__p1 12.3244
Rt51 sar_cpa12 sar_cpa12__p1 12.3244
Rt52 sar_cpa2 sar_cpa2__p1 12.3303
Rt53 sar_cpa3 sar_cpa3__p1 12.7425
Rt54 sar_cpa4 sar_cpa4__p1 12.3244
Rt55 sar_cpa5 sar_cpa5__p1 12.3303
Rt56 sar_cpa6 sar_cpa6__p1 12.3303
Rt57 sar_cpa7 sar_cpa7__p1 12.3244
Rt58 sar_cpa8 sar_cpa8__p1 12.3244
Rt59 sar_cpa9 sar_cpa9__p1 12.3244
Rt60 sar_cpb0 sar_cpb0__p1 12.322
Rt61 sar_cpb1 sar_cpb1__p1 12.498
Rt62 sar_cpb10 sar_cpb10__p1 12.3303
Rt63 sar_cpb11 sar_cpb11__p1 12.3303
Rt64 sar_cpb12 sar_cpb12__p1 12.498
Rt65 sar_cpb2 sar_cpb2__p1 12.3244
Rt66 sar_cpb3 sar_cpb3__p1 12.759
Rt67 sar_cpb4 sar_cpb4__p1 12.498
Rt68 sar_cpb5 sar_cpb5__p1 12.3244
Rt69 sar_cpb6 sar_cpb6__p1 12.322
Rt70 sar_cpb7 sar_cpb7__p1 12.498
Rt71 sar_cpb8 sar_cpb8__p1 12.3303
Rt72 sar_cpb9 sar_cpb9__p1 12.498
Rt73 sar_mclk sar_mclk__p0 170.374
Rt74 sar_mclk sar_mclk__p1 196.812
Rt75 sar_mclk sar_mclk__p2 307.715
Rt76 sar_mclk sar_mclk__p4 333.321
Rt77 sar_mclk__p0 sar_mclk__p1 70.5716
Rt78 sar_mclk__p0 sar_mclk__p2 110.338
Rt79 sar_mclk__p0 sar_mclk__p4 119.52
Rt80 sar_mclk__p1 sar_mclk__p2 101.952
Rt81 sar_mclk__p1 sar_mclk__p4 110.436
Rt82 sar_mclk__p2 sar_mclk__p3 0.6204
Rt83 sar_mclk__p2 sar_mclk__p4 64.7625
Rt84 sar_oan sar_oan__p1 12.3244
Rt85 sar_oann sar_oann__p1 12.3303
Rt86 sar_oanp sar_oanp__p1 12.3244
Rt87 sar_oap sar_oap__p1 12.322
Rt88 sar_obn sar_obn__p1 12.5344
Rt89 sar_obnn sar_obnn__p1 12.322
Rt90 sar_obnp sar_obnp__p1 12.498
Rt91 sar_obp sar_obp__p1 12.3303
Rt92 sar_trka0 sar_trka0__p1 12.3303
Rt93 sar_trka1 sar_trka1__p1 12.3303
Rt94 sar_trkb0 sar_trkb0__p1 12.3244
Rt95 sar_trkb1 sar_trkb1__p1 12.322
Rt96 vbn vbn__p1 68.8436
Rt97 vbn vbn__p2 240.016
Rt98 vbn vbn__p3 784.574
Rt99 vbn__p1 vbn__p2 217.489
Rt100 vbn__p1 vbn__p3 710.938
Rt101 vbn__p2 vbn__p3 168.032
Rt102 vbp vbp__p1 73.6975
Rt103 vbp vbp__p2 245.763
Rt104 vbp vbp__p3 1260.46
Rt105 vbp__p1 vbp__p2 195.517
Rt106 vbp__p1 vbp__p3 1002.76
Rt107 vbp__p2 vbp__p3 154.24
Rt108 vdd vdd__p0 34389.1
Rt109 vdd vdd__p1 40943
Rt110 vdd vdd__p11 68132.9
Rt111 vdd vdd__p12 82.2115
Rt112 vdd vdd__p13 11.0679
Rt113 vdd vdd__p14 29.2479
Rt114 vdd vdd__p15 437.715
Rt115 vdd vdd__p16 3424.56
Rt116 vdd vdd__p17 42939.2
Rt117 vdd vdd__p18 786782
Rt118 vdd__p0 vdd__p1 119.607
Rt119 vdd__p0 vdd__p12 99.6158
Rt120 vdd__p0 vdd__p13 288.609
Rt121 vdd__p0 vdd__p14 7716.14
Rt122 vdd__p0 vdd__p15 115478
Rt123 vdd__p0 vdd__p16 903464
Rt124 vdd__p1 vdd__p12 118.601
Rt125 vdd__p1 vdd__p13 343.612
Rt126 vdd__p1 vdd__p14 9186.68
Rt127 vdd__p1 vdd__p15 137485
Rt128 vdd__p11 vdd__p12 42970.9
Rt129 vdd__p11 vdd__p13 5785.07
Rt130 vdd__p11 vdd__p14 90.208
Rt131 vdd__p11 vdd__p15 12.7553
Rt132 vdd__p11 vdd__p16 14.0525
Rt133 vdd__p11 vdd__p17 160.888
Rt134 vdd__p11 vdd__p18 2947.98
Rt135 vdd__p11 vdd__p19 40686.4
Rt136 vdd__p11 vdd__p2 463.671
Rt137 vdd__p11 vdd__p3 424.895
Rt138 vdd__p11 vdd__p4 361.688
Rt139 vdd__p11 vdd__p5 291.702
Rt140 vdd__p11 vdd__p6 227.058
Rt141 vdd__p11 vdd__p7 29.9714
Rt142 vdd__p11 vdd__p8 158.698
Rt143 vdd__p11 vdd__p9 29.2186
Rt144 vdd__p12 vdd__p13 0.697261
Rt145 vdd__p12 vdd__p14 18.4464
Rt146 vdd__p12 vdd__p15 276.063
Rt147 vdd__p12 vdd__p16 2159.85
Rt148 vdd__p12 vdd__p17 27081.4
Rt149 vdd__p12 vdd__p18 496217
Rt150 vdd__p13 vdd__p14 2.48339
Rt151 vdd__p13 vdd__p15 37.1657
Rt152 vdd__p13 vdd__p16 290.775
Rt153 vdd__p13 vdd__p17 3645.91
Rt154 vdd__p13 vdd__p18 66804.5
Rt155 vdd__p13 vdd__p19 922000
Rt156 vdd__p13 vdd__p6 939934
Rt157 vdd__p13 vdd__p7 180555
Rt158 vdd__p13 vdd__p8 656946
Rt159 vdd__p13 vdd__p9 176021
Rt160 vdd__p14 vdd__p15 0.527112
Rt161 vdd__p14 vdd__p16 4.53412
Rt162 vdd__p14 vdd__p17 56.8516
Rt163 vdd__p14 vdd__p18 1041.7
Rt164 vdd__p14 vdd__p19 14377
Rt165 vdd__p14 vdd__p2 29930
Rt166 vdd__p14 vdd__p3 27427
Rt167 vdd__p14 vdd__p4 23347
Rt168 vdd__p14 vdd__p5 18829.3
Rt169 vdd__p14 vdd__p6 14656.6
Rt170 vdd__p14 vdd__p7 2815.45
Rt171 vdd__p14 vdd__p8 10243.9
Rt172 vdd__p14 vdd__p9 2744.73
Rt173 vdd__p15 vdd__p16 0.372867
Rt174 vdd__p15 vdd__p17 7.12045
Rt175 vdd__p15 vdd__p18 130.469
Rt176 vdd__p15 vdd__p19 1800.66
Rt177 vdd__p15 vdd__p2 4232.07
Rt178 vdd__p15 vdd__p3 3878.14
Rt179 vdd__p15 vdd__p4 3301.24
Rt180 vdd__p15 vdd__p5 2662.45
Rt181 vdd__p15 vdd__p6 2072.43
Rt182 vdd__p15 vdd__p7 398.102
Rt183 vdd__p15 vdd__p8 1448.48
Rt184 vdd__p15 vdd__p9 388.103
Rt185 vdd__p16 vdd__p17 0.804871
Rt186 vdd__p16 vdd__p18 14.9541
Rt187 vdd__p16 vdd__p19 206.388
Rt188 vdd__p16 vdd__p2 4662.44
Rt189 vdd__p16 vdd__p3 4272.53
Rt190 vdd__p16 vdd__p4 3636.95
Rt191 vdd__p16 vdd__p5 2933.2
Rt192 vdd__p16 vdd__p6 2283.19
Rt193 vdd__p16 vdd__p7 438.586
Rt194 vdd__p16 vdd__p8 1595.78
Rt195 vdd__p16 vdd__p9 427.57
Rt196 vdd__p17 vdd__p18 2.61782
Rt197 vdd__p17 vdd__p19 36.1298
Rt198 vdd__p17 vdd__p2 53380.8
Rt199 vdd__p17 vdd__p3 48916.6
Rt200 vdd__p17 vdd__p4 41639.9
Rt201 vdd__p17 vdd__p5 33582.6
Rt202 vdd__p17 vdd__p6 26140.5
Rt203 vdd__p17 vdd__p7 5021.42
Rt204 vdd__p17 vdd__p8 18270.3
Rt205 vdd__p17 vdd__p9 4895.3
Rt206 vdd__p18 vdd__p19 0.487307
Rt207 vdd__p18 vdd__p2 978105
Rt208 vdd__p18 vdd__p3 896307
Rt209 vdd__p18 vdd__p4 762974
Rt210 vdd__p18 vdd__p5 615339
Rt211 vdd__p18 vdd__p6 478976
Rt212 vdd__p18 vdd__p7 92008.3
Rt213 vdd__p18 vdd__p8 334770
Rt214 vdd__p18 vdd__p9 89697.3
Rt215 vdd__p2 vdd__p3 88.2674
Rt216 vdd__p2 vdd__p4 114.618
Rt217 vdd__p2 vdd__p5 144.634
Rt218 vdd__p2 vdd__p6 174.434
Rt219 vdd__p2 vdd__p7 14471.4
Rt220 vdd__p2 vdd__p8 225.153
Rt221 vdd__p2 vdd__p9 14108
Rt222 vdd__p3 vdd__p4 105.033
Rt223 vdd__p3 vdd__p5 132.538
Rt224 vdd__p3 vdd__p6 159.846
Rt225 vdd__p3 vdd__p7 13261.2
Rt226 vdd__p3 vdd__p8 206.324
Rt227 vdd__p3 vdd__p9 12928.1
Rt228 vdd__p4 vdd__p5 112.822
Rt229 vdd__p4 vdd__p6 136.068
Rt230 vdd__p4 vdd__p7 11288.5
Rt231 vdd__p4 vdd__p8 175.631
Rt232 vdd__p4 vdd__p9 11005
Rt233 vdd__p5 vdd__p6 109.739
Rt234 vdd__p5 vdd__p7 9104.19
Rt235 vdd__p5 vdd__p8 141.647
Rt236 vdd__p5 vdd__p9 8875.52
Rt237 vdd__p6 vdd__p7 7086.64
Rt238 vdd__p6 vdd__p8 110.257
Rt239 vdd__p6 vdd__p9 6908.64
Rt240 vdd__p7 vdd__p8 4953.05
Rt241 vdd__p7 vdd__p9 574.85
Rt242 vdd__p8 vdd__p9 4828.65
Rt243 vdda vdda__p1 41.3489
Rt244 vdda vdda__p2 278.578
Rt245 vdda vdda__p3 56.012
Rt246 vdda vdda__p5 261.48
Rt247 vdda vdda__p6 203.591
Rt248 vdda__p0 vdda__p3 62.8025
Rt249 vdda__p0 vdda__p4 67.5999
Rt250 vdda__p1 vdda__p2 1202.37
Rt251 vdda__p1 vdda__p3 241.754
Rt252 vdda__p1 vdda__p5 1128.58
Rt253 vdda__p1 vdda__p6 878.722
Rt254 vdda__p2 vdda__p3 256.165
Rt255 vdda__p2 vdda__p5 63.6193
Rt256 vdda__p2 vdda__p6 79.0683
Rt257 vdda__p3 vdda__p4 23.0314
Rt258 vdda__p3 vdda__p5 240.442
Rt259 vdda__p3 vdda__p6 187.211
Rt260 vdda__p5 vdda__p6 74.2153
Rt261 vref vref__p0 114.65
Rt262 vref vref__p1 6.10169
Rt263 vref vref__p10 186.142
Rt264 vref vref__p11 8271.36
Rt265 vref vref__p12 1487.93
Rt266 vref vref__p13 808.459
Rt267 vref vref__p14 372.871
Rt268 vref vref__p15 1459.54
Rt269 vref vref__p16 3157.02
Rt270 vref vref__p17 5801
Rt271 vref vref__p2 370.329
Rt272 vref vref__p3 10248.9
Rt273 vref vref__p5 428.96
Rt274 vref vref__p6 1135.72
Rt275 vref vref__p7 3138.93
Rt276 vref vref__p8 2223.31
Rt277 vref vref__p9 50.9452
Rt278 vref__p0 vref__p1 5.08178
Rt279 vref__p0 vref__p10 1372.92
Rt280 vref__p0 vref__p11 61005.8
Rt281 vref__p0 vref__p12 11330.2
Rt282 vref__p0 vref__p13 6156.32
Rt283 vref__p0 vref__p14 2839.43
Rt284 vref__p0 vref__p15 10764.9
Rt285 vref__p0 vref__p16 23284.7
Rt286 vref__p0 vref__p17 42785.5
Rt287 vref__p0 vref__p2 2151.06
Rt288 vref__p0 vref__p3 74645.3
Rt289 vref__p0 vref__p5 1782.68
Rt290 vref__p0 vref__p6 6979.82
Rt291 vref__p0 vref__p7 23027.9
Rt292 vref__p0 vref__p8 16928.7
Rt293 vref__p0 vref__p9 387.793
Rt294 vref__p1 vref__p10 27.2286
Rt295 vref__p1 vref__p11 1209.68
Rt296 vref__p1 vref__p12 366.189
Rt297 vref__p1 vref__p13 199.066
Rt298 vref__p1 vref__p14 91.8501
Rt299 vref__p1 vref__p15 213.441
Rt300 vref__p1 vref__p16 461.684
Rt301 vref__p1 vref__p17 848.354
Rt302 vref__p1 vref__p2 8.38761
Rt303 vref__p1 vref__p3 1193.26
Rt304 vref__p1 vref__p5 6.38445
Rt305 vref__p1 vref__p6 32.923
Rt306 vref__p1 vref__p7 414.228
Rt307 vref__p1 vref__p8 546.455
Rt308 vref__p1 vref__p9 12.4499
Rt309 vref__p10 vref__p11 1.96723
Rt310 vref__p10 vref__p12 390.352
Rt311 vref__p10 vref__p13 212.377
Rt312 vref__p10 vref__p14 98.0606
Rt313 vref__p10 vref__p15 1.88326
Rt314 vref__p10 vref__p16 2.58285
Rt315 vref__p10 vref__p17 2.96452
Rt316 vref__p10 vref__p2 13.5031
Rt317 vref__p10 vref__p3 151.839
Rt318 vref__p10 vref__p5 105.826
Rt319 vref__p10 vref__p6 71.6163
Rt320 vref__p10 vref__p7 45.7002
Rt321 vref__p10 vref__p8 581.257
Rt322 vref__p10 vref__p9 13.1189
Rt323 vref__p11 vref__p12 17345.9
Rt324 vref__p11 vref__p13 9437.27
Rt325 vref__p11 vref__p14 4357.47
Rt326 vref__p11 vref__p15 11.7242
Rt327 vref__p11 vref__p16 6.70636
Rt328 vref__p11 vref__p17 3.30899
Rt329 vref__p11 vref__p2 588.996
Rt330 vref__p11 vref__p3 6559.22
Rt331 vref__p11 vref__p5 4701.78
Rt332 vref__p11 vref__p6 3179.28
Rt333 vref__p11 vref__p7 1973.95
Rt334 vref__p11 vref__p8 25829
Rt335 vref__p11 vref__p9 582.958
Rt336 vref__p12 vref__p13 2.76051
Rt337 vref__p12 vref__p14 5.69068
Rt338 vref__p12 vref__p15 3060.82
Rt339 vref__p12 vref__p16 6620.62
Rt340 vref__p12 vref__p17 12165.3
Rt341 vref__p12 vref__p2 961.871
Rt342 vref__p12 vref__p3 21690.6
Rt343 vref__p12 vref__p5 2025.57
Rt344 vref__p12 vref__p6 2781.47
Rt345 vref__p12 vref__p7 6608.37
Rt346 vref__p12 vref__p8 3.41549
Rt347 vref__p12 vref__p9 2.8795
Rt348 vref__p13 vref__p14 2.76481
Rt349 vref__p13 vref__p15 1665.29
Rt350 vref__p13 vref__p16 3602.05
Rt351 vref__p13 vref__p17 6618.72
Rt352 vref__p13 vref__p2 523.306
Rt353 vref__p13 vref__p3 11801.1
Rt354 vref__p13 vref__p5 1101.86
Rt355 vref__p13 vref__p6 1513.26
Rt356 vref__p13 vref__p7 3595.37
Rt357 vref__p13 vref__p8 6.9687
Rt358 vref__p13 vref__p9 2.56608
Rt359 vref__p14 vref__p15 768.912
Rt360 vref__p14 vref__p16 1663.17
Rt361 vref__p14 vref__p17 3056.06
Rt362 vref__p14 vref__p2 241.621
Rt363 vref__p14 vref__p3 5448.89
Rt364 vref__p14 vref__p5 508.693
Rt365 vref__p14 vref__p6 698.702
Rt366 vref__p14 vref__p7 1660.09
Rt367 vref__p14 vref__p8 12.1708
Rt368 vref__p14 vref__p9 1.86726
Rt369 vref__p15 vref__p16 2.76621
Rt370 vref__p15 vref__p17 5.68373
Rt371 vref__p15 vref__p2 103.213
Rt372 vref__p15 vref__p3 1145.31
Rt373 vref__p15 vref__p5 829.619
Rt374 vref__p15 vref__p6 560.804
Rt375 vref__p15 vref__p7 344.658
Rt376 vref__p15 vref__p8 4557.75
Rt377 vref__p15 vref__p9 102.868
Rt378 vref__p16 vref__p17 2.75986
Rt379 vref__p16 vref__p2 223.556
Rt380 vref__p16 vref__p3 2482.45
Rt381 vref__p16 vref__p5 1794.5
Rt382 vref__p16 vref__p6 1213.12
Rt383 vref__p16 vref__p7 747.047
Rt384 vref__p16 vref__p8 9858.5
Rt385 vref__p16 vref__p9 222.505
Rt386 vref__p17 vref__p2 411.407
Rt387 vref__p17 vref__p3 4571.97
Rt388 vref__p17 vref__p5 3297.42
Rt389 vref__p17 vref__p6 2229.27
Rt390 vref__p17 vref__p7 1375.86
Rt391 vref__p17 vref__p8 18114.9
Rt392 vref__p17 vref__p9 408.851
Rt393 vref__p2 vref__p3 5.49374
Rt394 vref__p2 vref__p5 65.7993
Rt395 vref__p2 vref__p6 7.45703
Rt396 vref__p2 vref__p7 6.5906
Rt397 vref__p2 vref__p8 1432.38
Rt398 vref__p2 vref__p9 32.3382
Rt399 vref__p3 vref__p5 5279.01
Rt400 vref__p3 vref__p6 2064.28
Rt401 vref__p3 vref__p7 48.2546
Rt402 vref__p3 vref__p8 32298.7
Rt403 vref__p3 vref__p9 728.99
Rt404 vref__p5 vref__p6 244.984
Rt405 vref__p5 vref__p7 1709.1
Rt406 vref__p5 vref__p8 3017.46
Rt407 vref__p5 vref__p9 68.2281
Rt408 vref__p6 vref__p7 871.249
Rt409 vref__p6 vref__p8 4142.06
Rt410 vref__p6 vref__p9 93.5132
Rt411 vref__p7 vref__p8 9840.28
Rt412 vref__p7 vref__p9 222.096
Rt413 vref__p8 vref__p9 1.94076
Rt414 vref_in vref_in__p1 0.001
Rt415 vref_in vref_in__p2 0.001
Rt416 vrefl vrefl__p0 31.2586
Rt417 vrefl vrefl__p2 93.437
Rt418 vrefl vrefl__p3 7.18444
Rt419 vrefl vrefl__p4 7325.4
Rt420 vrefl vrefl__p5 4916.21
Rt421 vrefl vrefl__p6 359.98
Rt422 vrefl vrefl__p7 574.557
Rt423 vrefl__p0 vrefl__p2 18.0283
Rt424 vrefl__p0 vrefl__p3 12.5916
Rt425 vrefl__p0 vrefl__p4 63.5642
Rt426 vrefl__p0 vrefl__p5 72.9525
Rt427 vrefl__p0 vrefl__p6 631.93
Rt428 vrefl__p0 vrefl__p7 1009.16
Rt429 vrefl__p2 vrefl__p3 2.16812
Rt430 vrefl__p2 vrefl__p4 8.30061
Rt431 vrefl__p2 vrefl__p5 5.37046
Rt432 vrefl__p2 vrefl__p6 117.734
Rt433 vrefl__p2 vrefl__p7 192.433
Rt434 vrefl__p3 vrefl__p4 211.164
Rt435 vrefl__p3 vrefl__p5 128.531
Rt436 vrefl__p3 vrefl__p6 5.07096
Rt437 vrefl__p3 vrefl__p7 7.53987
Rt438 vrefl__p4 vrefl__p5 31.8717
Rt439 vrefl__p4 vrefl__p6 11315.9
Rt440 vrefl__p4 vrefl__p7 18493.5
Rt441 vrefl__p5 vrefl__p6 6889.67
Rt442 vrefl__p5 vrefl__p7 11261.9
Rt443 vrefl__p6 vrefl__p7 32.2289
Rt444 vss vss__p0 34.9503
Rt445 vss vss__p1 372.756
Rt446 vss vss__p10 18233.6
Rt447 vss vss__p11 33061.6
Rt448 vss vss__p12 32281.5
Rt449 vss vss__p13 55884.9
Rt450 vss vss__p14 78141.4
Rt451 vss vss__p15 250270
Rt452 vss vss__p16 358.209
Rt453 vss vss__p17 3653.28
Rt454 vss vss__p18 96113.9
Rt455 vss vss__p19 74114.8
Rt456 vss vss__p2 152.168
Rt457 vss vss__p20 138679
Rt458 vss vss__p22 0.001
Rt459 vss vss__p23 2
Rt460 vss vss__p24 2
Rt461 vss vss__p25 2
Rt462 vss vss__p26 2
Rt463 vss vss__p27 2
Rt464 vss vss__p28 2
Rt465 vss vss__p29 2
Rt466 vss vss__p3 89.0698
Rt467 vss vss__p30 2
Rt468 vss vss__p4 1076.06
Rt469 vss vss__p5 1332.84
Rt470 vss vss__p6 1752.7
Rt471 vss vss__p7 37.7353
Rt472 vss vss__p8 41.2417
Rt473 vss vss__p9 13512
Rt474 vss__p0 vss__p1 169.257
Rt475 vss__p0 vss__p10 782087
Rt476 vss__p0 vss__p16 15364.5
Rt477 vss__p0 vss__p17 156699
Rt478 vss__p0 vss__p2 6656.8
Rt479 vss__p0 vss__p3 3896.48
Rt480 vss__p0 vss__p4 488.606
Rt481 vss__p0 vss__p5 605.203
Rt482 vss__p0 vss__p6 795.845
Rt483 vss__p0 vss__p7 445.256
Rt484 vss__p0 vss__p8 490.044
Rt485 vss__p0 vss__p9 579567
Rt486 vss__p1 vss__p16 163868
Rt487 vss__p1 vss__p2 70997
Rt488 vss__p1 vss__p3 41557.2
Rt489 vss__p1 vss__p4 340.811
Rt490 vss__p1 vss__p5 422.139
Rt491 vss__p1 vss__p6 555.115
Rt492 vss__p1 vss__p7 4748.8
Rt493 vss__p1 vss__p8 5226.48
Rt494 vss__p10 vss__p11 184.446
Rt495 vss__p10 vss__p12 176.62
Rt496 vss__p10 vss__p13 307.671
Rt497 vss__p10 vss__p14 433.768
Rt498 vss__p10 vss__p15 1374.05
Rt499 vss__p10 vss__p16 139.567
Rt500 vss__p10 vss__p17 158.772
Rt501 vss__p10 vss__p18 555.994
Rt502 vss__p10 vss__p19 420.703
Rt503 vss__p10 vss__p2 352658
Rt504 vss__p10 vss__p20 808.124
Rt505 vss__p10 vss__p3 206424
Rt506 vss__p10 vss__p7 729352
Rt507 vss__p10 vss__p8 877308
Rt508 vss__p10 vss__p9 116.749
Rt509 vss__p11 vss__p12 195.406
Rt510 vss__p11 vss__p13 338.903
Rt511 vss__p11 vss__p14 475.02
Rt512 vss__p11 vss__p15 1516.48
Rt513 vss__p11 vss__p16 178.921
Rt514 vss__p11 vss__p17 29.8046
Rt515 vss__p11 vss__p18 591.254
Rt516 vss__p11 vss__p19 453.468
Rt517 vss__p11 vss__p2 639448
Rt518 vss__p11 vss__p20 854.867
Rt519 vss__p11 vss__p3 374293
Rt520 vss__p11 vss__p9 216.223
Rt521 vss__p12 vss__p13 190.25
Rt522 vss__p12 vss__p14 268.323
Rt523 vss__p12 vss__p15 849.545
Rt524 vss__p12 vss__p16 238.363
Rt525 vss__p12 vss__p17 142.029
Rt526 vss__p12 vss__p18 344.585
Rt527 vss__p12 vss__p19 260.506
Rt528 vss__p12 vss__p2 624361
Rt529 vss__p12 vss__p20 501.021
Rt530 vss__p12 vss__p3 365462
Rt531 vss__p12 vss__p9 207.081
Rt532 vss__p13 vss__p14 258.166
Rt533 vss__p13 vss__p15 860.032
Rt534 vss__p13 vss__p16 369.321
Rt535 vss__p13 vss__p17 80.5843
Rt536 vss__p13 vss__p18 42.4547
Rt537 vss__p13 vss__p19 227.381
Rt538 vss__p13 vss__p20 393.238
Rt539 vss__p13 vss__p3 632678
Rt540 vss__p13 vss__p9 360.715
Rt541 vss__p14 vss__p15 564.732
Rt542 vss__p14 vss__p16 453.74
Rt543 vss__p14 vss__p17 59.7988
Rt544 vss__p14 vss__p18 294.155
Rt545 vss__p14 vss__p19 55.3288
Rt546 vss__p14 vss__p20 194.885
Rt547 vss__p14 vss__p3 884646
Rt548 vss__p14 vss__p9 508.519
Rt549 vss__p15 vss__p16 1734.54
Rt550 vss__p15 vss__p17 513.739
Rt551 vss__p15 vss__p18 1398.8
Rt552 vss__p15 vss__p19 33.7794
Rt553 vss__p15 vss__p20 860.442
Rt554 vss__p15 vss__p9 1610.98
Rt555 vss__p16 vss__p17 1.54041
Rt556 vss__p16 vss__p18 350.696
Rt557 vss__p16 vss__p19 325.248
Rt558 vss__p16 vss__p2 6928.16
Rt559 vss__p16 vss__p20 475.339
Rt560 vss__p16 vss__p3 4055.32
Rt561 vss__p16 vss__p4 473049
Rt562 vss__p16 vss__p5 585932
Rt563 vss__p16 vss__p6 770504
Rt564 vss__p16 vss__p7 14328.5
Rt565 vss__p16 vss__p8 17235.2
Rt566 vss__p16 vss__p9 104.892
Rt567 vss__p17 vss__p18 22.3758
Rt568 vss__p17 vss__p19 25.21
Rt569 vss__p17 vss__p2 70658.6
Rt570 vss__p17 vss__p20 28.8059
Rt571 vss__p17 vss__p3 41359.2
Rt572 vss__p17 vss__p7 146133
Rt573 vss__p17 vss__p8 175777
Rt574 vss__p17 vss__p9 176.386
Rt575 vss__p18 vss__p19 169.03
Rt576 vss__p18 vss__p20 217.768
Rt577 vss__p18 vss__p9 651.585
Rt578 vss__p19 vss__p20 98.6071
Rt579 vss__p19 vss__p3 839061
Rt580 vss__p19 vss__p9 493.112
Rt581 vss__p2 vss__p3 63.5786
Rt582 vss__p2 vss__p4 204952
Rt583 vss__p2 vss__p5 253860
Rt584 vss__p2 vss__p6 333827
Rt585 vss__p2 vss__p7 6636.18
Rt586 vss__p2 vss__p8 7704.98
Rt587 vss__p2 vss__p9 261338
Rt588 vss__p20 vss__p9 947.006
Rt589 vss__p3 vss__p4 119966
Rt590 vss__p3 vss__p5 148594
Rt591 vss__p3 vss__p6 195402
Rt592 vss__p3 vss__p7 3884.41
Rt593 vss__p3 vss__p8 4510.02
Rt594 vss__p3 vss__p9 152971
Rt595 vss__p4 vss__p5 99.6258
Rt596 vss__p4 vss__p6 131.008
Rt597 vss__p4 vss__p7 13708.7
Rt598 vss__p4 vss__p8 15087.7
Rt599 vss__p5 vss__p6 57.9371
Rt600 vss__p5 vss__p7 16980
Rt601 vss__p5 vss__p8 18688
Rt602 vss__p6 vss__p7 22328.8
Rt603 vss__p6 vss__p8 24574.9
Rt604 vss__p7 vss__p8 217.113
Rt605 vss__p7 vss__p9 540488
Rt606 vss__p8 vss__p9 650130
Rt607 xckg_d0 xckg_d0__p1 158.064
Rt608 xckg_d0 xckg_d0__p2 32.5
Rt609 xckg_d0__p1 xckg_d0__p2 72.9819
Rt610 xckg_d1 xckg_d1__p1 160.822
Rt611 xckg_d1 xckg_d1__p2 33.3377
Rt612 xckg_d1__p1 xckg_d1__p2 71.7995
Rt613 xckg_d2 xckg_d2__p1 253.776
Rt614 xckg_d2 xckg_d2__p2 56.8495
Rt615 xckg_d2__p1 xckg_d2__p2 62.5432
Rt616 xckg_d3 xckg_d3__p1 116.773
Rt617 xckg_d3 xckg_d3__p2 66.8961
Rt618 xckg_d3__p1 xckg_d3__p2 71.2846
Rt619 xckg_nn xckg_nn__p1 46.1928
Rt620 xckg_x xckg_x__p1 101.928
Rt621 xckg_x xckg_x__p2 247.825
Rt622 xckg_x xckg_x__p3 173.816
Rt623 xckg_x xckg_x__p4 124.476
Rt624 xckg_x__p1 xckg_x__p2 156.926
Rt625 xckg_x__p1 xckg_x__p3 110.063
Rt626 xckg_x__p1 xckg_x__p4 78.82
Rt627 xckg_x__p2 xckg_x__p3 94.6454
Rt628 xckg_x__p2 xckg_x__p4 142.468
Rt629 xckg_x__p3 xckg_x__p4 99.922
Rt630 xref_na xref_na__p1 77.984
Rt631 xref_ng xref_ng__p1 1225.95
Rt632 xref_ng xref_ng__p2 132.884
Rt633 xref_ng__p1 xref_ng__p2 31.5508
Rt634 xref_ntl xref_ntl__p1 60.2546
Rt635 xref_ntl__p1 xref_ntl__p2 19.318
Cq0 ain_cos_n ain_cos_p 2.707e-14
Cq1 ain_cos_n ain_isa_n 3.445e-17
Cq2 ain_cos_n ain_isa_p 4.604e-17
Cq3 ain_cos_n ibias 1.097e-16
Cq4 ain_cos_n sar_clka 2.933e-17
Cq5 ain_cos_n sar_clkab 2.933e-17
Cq6 ain_cos_n sar_clkna 2.933e-17
Cq7 ain_cos_n sar_clknab 2.946e-17
Cq8 ain_cos_n sar_cna0 4.649e-17
Cq9 ain_cos_n sar_cna1 4.481e-17
Cq10 ain_cos_n sar_cna10 4.578e-17
Cq11 ain_cos_n sar_cna11 4.578e-17
Cq12 ain_cos_n sar_cna12 4.578e-17
Cq13 ain_cos_n sar_cna2 3.756e-17
Cq14 ain_cos_n sar_cna3 3.984e-17
Cq15 ain_cos_n sar_cna4 4.481e-17
Cq16 ain_cos_n sar_cna5 4.481e-17
Cq17 ain_cos_n sar_cna6 4.537e-17
Cq18 ain_cos_n sar_cna7 4.802e-17
Cq19 ain_cos_n sar_cna8 4.746e-17
Cq20 ain_cos_n sar_cna9 4.578e-17
Cq21 ain_cos_n sar_cpa0 4.649e-17
Cq22 ain_cos_n sar_cpa1 4.537e-17
Cq23 ain_cos_n sar_cpa10 4.578e-17
Cq24 ain_cos_n sar_cpa11 4.578e-17
Cq25 ain_cos_n sar_cpa12 4.578e-17
Cq26 ain_cos_n sar_cpa2 4.337e-17
Cq27 ain_cos_n sar_cpa3 3.579e-17
Cq28 ain_cos_n sar_cpa4 4.337e-17
Cq29 ain_cos_n sar_cpa5 4.634e-17
Cq30 ain_cos_n sar_cpa6 4.481e-17
Cq31 ain_cos_n sar_cpa7 4.649e-17
Cq32 ain_cos_n sar_cpa8 4.746e-17
Cq33 ain_cos_n sar_cpa9 4.578e-17
Cq34 ain_cos_n sar_oan 4.184e-17
Cq35 ain_cos_n sar_oann 4.384e-17
Cq36 ain_cos_n sar_oanp 4.649e-17
Cq37 ain_cos_n sar_oap 3.459e-17
Cq38 ain_cos_n sar_trka0 5.23e-17
Cq39 ain_cos_n sar_trka1 4.808e-17
Cq40 ain_cos_n sar_trkb0 1.443e-17
Cq41 ain_cos_n vdd 3.063e-15
Cq42 ain_cos_n vss 3.507e-14
Cq43 ain_cos_n xckg_d0 4.043e-19
Cq44 ain_cos_n xckg_d1 7.338e-19
Cq45 ain_cos_n xckg_d2 8.525e-19
Cq46 ain_cos_n xckg_d3 1.362e-18
Cq47 ain_cos_n xckg_x 2.674e-17
Cq48 ain_cos_p ain_isa_n 3.424e-17
Cq49 ain_cos_p ain_isa_p 4.84e-17
Cq50 ain_cos_p ibias 2.317e-16
Cq51 ain_cos_p sar_clka 2.933e-17
Cq52 ain_cos_p sar_clkab 2.933e-17
Cq53 ain_cos_p sar_clkna 2.933e-17
Cq54 ain_cos_p sar_clknab 2.951e-17
Cq55 ain_cos_p sar_cna0 4.649e-17
Cq56 ain_cos_p sar_cna1 4.481e-17
Cq57 ain_cos_p sar_cna10 4.578e-17
Cq58 ain_cos_p sar_cna11 4.578e-17
Cq59 ain_cos_p sar_cna12 4.578e-17
Cq60 ain_cos_p sar_cna2 3.756e-17
Cq61 ain_cos_p sar_cna3 3.984e-17
Cq62 ain_cos_p sar_cna4 4.481e-17
Cq63 ain_cos_p sar_cna5 4.481e-17
Cq64 ain_cos_p sar_cna6 4.537e-17
Cq65 ain_cos_p sar_cna7 4.802e-17
Cq66 ain_cos_p sar_cna8 4.746e-17
Cq67 ain_cos_p sar_cna9 4.578e-17
Cq68 ain_cos_p sar_cpa0 4.649e-17
Cq69 ain_cos_p sar_cpa1 4.537e-17
Cq70 ain_cos_p sar_cpa10 4.578e-17
Cq71 ain_cos_p sar_cpa11 4.578e-17
Cq72 ain_cos_p sar_cpa12 4.578e-17
Cq73 ain_cos_p sar_cpa2 4.337e-17
Cq74 ain_cos_p sar_cpa3 3.788e-17
Cq75 ain_cos_p sar_cpa4 4.337e-17
Cq76 ain_cos_p sar_cpa5 4.634e-17
Cq77 ain_cos_p sar_cpa6 4.481e-17
Cq78 ain_cos_p sar_cpa7 4.649e-17
Cq79 ain_cos_p sar_cpa8 4.746e-17
Cq80 ain_cos_p sar_cpa9 4.578e-17
Cq81 ain_cos_p sar_oan 4.184e-17
Cq82 ain_cos_p sar_oann 4.384e-17
Cq83 ain_cos_p sar_oanp 4.649e-17
Cq84 ain_cos_p sar_oap 3.459e-17
Cq85 ain_cos_p sar_trka0 5.315e-17
Cq86 ain_cos_p sar_trka1 4.808e-17
Cq87 ain_cos_p sar_trkb0 4.662e-19
Cq88 ain_cos_p vdd 2.211e-15
Cq89 ain_cos_p vss 3.544e-14
Cq90 ain_cos_p xckg_d3 3.348e-19
Cq91 ain_cos_p xckg_x 2.003e-17
Cq92 ain_isa_n ain_isa_p 2.783e-14
Cq93 ain_isa_n ain_isb_n 6.15e-17
Cq94 ain_isa_n ain_isb_p 6.417e-17
Cq95 ain_isa_n sar_clkb 4.864e-17
Cq96 ain_isa_n sar_clkbb 4.746e-17
Cq97 ain_isa_n sar_clknab 9.415e-19
Cq98 ain_isa_n sar_clknb 4.184e-17
Cq99 ain_isa_n sar_clknbb 2.965e-17
Cq100 ain_isa_n sar_cnb0 4.649e-17
Cq101 ain_isa_n sar_cnb1 4.481e-17
Cq102 ain_isa_n sar_cnb10 4.578e-17
Cq103 ain_isa_n sar_cnb11 4.578e-17
Cq104 ain_isa_n sar_cnb12 4.578e-17
Cq105 ain_isa_n sar_cnb2 3.756e-17
Cq106 ain_isa_n sar_cnb3 3.984e-17
Cq107 ain_isa_n sar_cnb4 4.481e-17
Cq108 ain_isa_n sar_cnb5 4.481e-17
Cq109 ain_isa_n sar_cnb6 4.537e-17
Cq110 ain_isa_n sar_cnb7 4.802e-17
Cq111 ain_isa_n sar_cnb8 4.746e-17
Cq112 ain_isa_n sar_cnb9 4.578e-17
Cq113 ain_isa_n sar_cpb0 4.649e-17
Cq114 ain_isa_n sar_cpb1 4.537e-17
Cq115 ain_isa_n sar_cpb10 4.578e-17
Cq116 ain_isa_n sar_cpb11 4.578e-17
Cq117 ain_isa_n sar_cpb12 4.578e-17
Cq118 ain_isa_n sar_cpb2 4.537e-17
Cq119 ain_isa_n sar_cpb3 4.024e-17
Cq120 ain_isa_n sar_cpb4 4.337e-17
Cq121 ain_isa_n sar_cpb5 4.634e-17
Cq122 ain_isa_n sar_cpb6 4.481e-17
Cq123 ain_isa_n sar_cpb7 4.649e-17
Cq124 ain_isa_n sar_cpb8 4.746e-17
Cq125 ain_isa_n sar_cpb9 4.578e-17
Cq126 ain_isa_n sar_obn 4.184e-17
Cq127 ain_isa_n sar_obnn 4.481e-17
Cq128 ain_isa_n sar_obnp 4.649e-17
Cq129 ain_isa_n sar_obp 3.459e-17
Cq130 ain_isa_n sar_trkb0 4.883e-17
Cq131 ain_isa_n sar_trkb1 4.833e-17
Cq132 ain_isa_n vdd 8.828e-17
Cq133 ain_isa_n vss 3.302e-14
Cq134 ain_isa_p ain_isb_n 7.645e-17
Cq135 ain_isa_p ain_isb_p 7.912e-17
Cq136 ain_isa_p sar_clkb 4.864e-17
Cq137 ain_isa_p sar_clkbb 4.746e-17
Cq138 ain_isa_p sar_clknab 7.019e-19
Cq139 ain_isa_p sar_clknb 4.184e-17
Cq140 ain_isa_p sar_clknbb 3.499e-17
Cq141 ain_isa_p sar_cnb0 4.649e-17
Cq142 ain_isa_p sar_cnb1 4.481e-17
Cq143 ain_isa_p sar_cnb10 4.578e-17
Cq144 ain_isa_p sar_cnb11 4.578e-17
Cq145 ain_isa_p sar_cnb12 4.578e-17
Cq146 ain_isa_p sar_cnb2 3.756e-17
Cq147 ain_isa_p sar_cnb3 3.984e-17
Cq148 ain_isa_p sar_cnb4 4.481e-17
Cq149 ain_isa_p sar_cnb5 4.481e-17
Cq150 ain_isa_p sar_cnb6 4.537e-17
Cq151 ain_isa_p sar_cnb7 4.802e-17
Cq152 ain_isa_p sar_cnb8 4.746e-17
Cq153 ain_isa_p sar_cnb9 4.578e-17
Cq154 ain_isa_p sar_cpb0 4.649e-17
Cq155 ain_isa_p sar_cpb1 4.537e-17
Cq156 ain_isa_p sar_cpb10 4.578e-17
Cq157 ain_isa_p sar_cpb11 4.578e-17
Cq158 ain_isa_p sar_cpb12 4.578e-17
Cq159 ain_isa_p sar_cpb2 4.537e-17
Cq160 ain_isa_p sar_cpb3 4.047e-17
Cq161 ain_isa_p sar_cpb4 4.337e-17
Cq162 ain_isa_p sar_cpb5 4.634e-17
Cq163 ain_isa_p sar_cpb6 4.481e-17
Cq164 ain_isa_p sar_cpb7 4.649e-17
Cq165 ain_isa_p sar_cpb8 4.746e-17
Cq166 ain_isa_p sar_cpb9 4.578e-17
Cq167 ain_isa_p sar_mclk 2.531e-18
Cq168 ain_isa_p sar_obn 4.184e-17
Cq169 ain_isa_p sar_obnn 4.481e-17
Cq170 ain_isa_p sar_obnp 4.649e-17
Cq171 ain_isa_p sar_obp 3.459e-17
Cq172 ain_isa_p sar_trkb0 5.684e-17
Cq173 ain_isa_p sar_trkb1 4.833e-17
Cq174 ain_isa_p vdd 1.13e-16
Cq175 ain_isa_p vss 3.362e-14
Cq176 ain_isb_n ain_isb_p 7.431e-17
Cq177 ain_isb_n vss 9.265e-16
Cq178 ain_isb_p vss 8.611e-16
Cq179 ain_sin_n ain_sin_p 8.625e-17
Cq180 ain_sin_n ibias 9.686e-17
Cq181 ain_sin_n vss 7.977e-16
Cq182 ain_sin_p ibias 9.686e-17
Cq183 ain_sin_p vss 7.924e-16
Cq184 clk mclkb 1.252e-18
Cq185 clk sar_clka 3.704e-17
Cq186 clk sar_clkab 2.773e-17
Cq187 clk sar_clkna 3.212e-17
Cq188 clk sar_clknab 4.043e-18
Cq189 clk sar_cna0 4.953e-17
Cq190 clk sar_cna1 4.301e-17
Cq191 clk sar_cna10 4.59e-17
Cq192 clk sar_cna11 4.59e-17
Cq193 clk sar_cna12 4.443e-17
Cq194 clk sar_cna2 3.644e-17
Cq195 clk sar_cna3 3.581e-17
Cq196 clk sar_cna4 4.301e-17
Cq197 clk sar_cna5 4.301e-17
Cq198 clk sar_cna6 4.534e-17
Cq199 clk sar_cna7 5.255e-17
Cq200 clk sar_cna8 5.168e-17
Cq201 clk sar_cna9 4.443e-17
Cq202 clk sar_cpa0 4.489e-17
Cq203 clk sar_cpa1 4.592e-17
Cq204 clk sar_cpa10 4.443e-17
Cq205 clk sar_cpa11 4.59e-17
Cq206 clk sar_cpa12 4.59e-17
Cq207 clk sar_cpa2 4.223e-17
Cq208 clk sar_cpa3 3.127e-17
Cq209 clk sar_cpa4 4.339e-17
Cq210 clk sar_cpa5 4.676e-17
Cq211 clk sar_cpa6 4.301e-17
Cq212 clk sar_cpa7 4.953e-17
Cq213 clk sar_cpa8 5.168e-17
Cq214 clk sar_cpa9 4.59e-17
Cq215 clk sar_mclk 4.18e-16
Cq216 clk sar_oan 3.87e-17
Cq217 clk sar_oann 4.086e-17
Cq218 clk sar_oanp 4.931e-17
Cq219 clk sar_oap 3.067e-17
Cq220 clk sar_trka0 6.343e-17
Cq221 clk sar_trka1 5.755e-17
Cq222 clk vdd 1.554e-15
Cq223 clk vss 2.921e-14
Cq224 clk xckg_d0 3.206e-16
Cq225 clk xckg_d1 1.883e-16
Cq226 clk xckg_d2 1.491e-16
Cq227 clk xckg_d3 2.541e-16
Cq228 clk xckg_nn 2.492e-17
Cq229 clk xckg_x 3.281e-16
Cq230 ibias sar_trka0 1.287e-17
Cq231 ibias vbn 2.266e-15
Cq232 ibias vbp 6.102e-17
Cq233 ibias vdd 4.502e-15
Cq234 ibias vdda 2.216e-16
Cq235 ibias vref 4.11e-14
Cq236 ibias vref_in 9.847e-15
Cq237 ibias vrefl 1.687e-14
Cq238 ibias vss 1.681e-13
Cq239 ibias xref_ng 2.101e-15
Cq240 ibias xref_ntl 1.737e-16
Cq241 mclkb sar_clknab 4.044e-17
Cq242 mclkb sar_mclk 2.778e-16
Cq243 mclkb sar_trkb0 2.442e-18
Cq244 mclkb vdd 1.741e-15
Cq245 mclkb vss 5.564e-15
Cq246 mclkb xckg_d0 1.25e-15
Cq247 mclkb xckg_d1 2.7e-16
Cq248 mclkb xckg_d2 2.182e-16
Cq249 mclkb xckg_d3 1.483e-17
Cq250 mclkb xckg_nn 2.576e-17
Cq251 mclkb xckg_x 1.907e-17
Cq252 sar_clka sar_trka1 4.996e-17
Cq253 sar_clka vdd 5.939e-18
Cq254 sar_clka vss 4.415e-15
Cq255 sar_clkab sar_mclk 3.485e-17
Cq256 sar_clkab sar_oann 9.641e-17
Cq257 sar_clkab vdd 5.391e-18
Cq258 sar_clkab vss 4.557e-15
Cq259 sar_clkb sar_trkb1 1.541e-16
Cq260 sar_clkb vdd 9.721e-18
Cq261 sar_clkb vss 1.963e-15
Cq262 sar_clkbb sar_obnn 3.064e-16
Cq263 sar_clkbb sar_obnp 3.919e-19
Cq264 sar_clkbb vdd 6.807e-18
Cq265 sar_clkbb vss 1.715e-15
Cq266 sar_clkna sar_cpa2 1.689e-16
Cq267 sar_clkna sar_cpa3 7.355e-16
Cq268 sar_clkna sar_cpa4 1.185e-17
Cq269 sar_clkna sar_mclk 3.502e-17
Cq270 sar_clkna vdd 5.939e-18
Cq271 sar_clkna vss 3.965e-15
Cq272 sar_clknab sar_mclk 1.264e-16
Cq273 sar_clknab vdd 1.914e-16
Cq274 sar_clknab vss 4.193e-15
Cq275 sar_clknab xckg_x 7.189e-17
Cq276 sar_clknb sar_cpb1 2.496e-19
Cq277 sar_clknb sar_cpb2 4.387e-16
Cq278 sar_clknb sar_cpb3 1.131e-15
Cq279 sar_clknb sar_cpb4 6.245e-19
Cq280 sar_clknb sar_cpb5 4.845e-18
Cq281 sar_clknb vdd 6.26e-18
Cq282 sar_clknb vss 1.056e-15
Cq283 sar_clknbb vss 4.526e-15
Cq284 sar_cna0 sar_cna1 4.187e-16
Cq285 sar_cna0 sar_mclk 5.35e-17
Cq286 sar_cna0 vdd 5.939e-18
Cq287 sar_cna0 vss 2e-15
Cq288 sar_cna1 sar_cna2 3.064e-16
Cq289 sar_cna1 sar_mclk 5.151e-17
Cq290 sar_cna1 vdd 5.391e-18
Cq291 sar_cna1 vss 1.682e-15
Cq292 sar_cna10 sar_cna11 2.981e-16
Cq293 sar_cna10 sar_cna9 3.064e-16
Cq294 sar_cna10 sar_mclk 5.273e-17
Cq295 sar_cna10 vdd 5.939e-18
Cq296 sar_cna10 vss 1.797e-15
Cq297 sar_cna11 sar_cna12 3.064e-16
Cq298 sar_cna11 sar_mclk 5.273e-17
Cq299 sar_cna11 vdd 5.939e-18
Cq300 sar_cna11 vss 1.797e-15
Cq301 sar_cna12 sar_cpa12 3.064e-16
Cq302 sar_cna12 sar_mclk 5.238e-17
Cq303 sar_cna12 vdd 4.844e-18
Cq304 sar_cna12 vss 1.756e-15
Cq305 sar_cna2 sar_mclk 4.37e-17
Cq306 sar_cna2 sar_oap 2.214e-15
Cq307 sar_cna2 vdd 5.391e-18
Cq308 sar_cna2 vss 1.347e-15
Cq309 sar_cna3 sar_mclk 4.634e-17
Cq310 sar_cna3 sar_oan 8.01e-16
Cq311 sar_cna3 sar_oap 7.036e-16
Cq312 sar_cna3 vdd 5.939e-18
Cq313 sar_cna3 vss 1.328e-15
Cq314 sar_cna4 sar_cna5 3.064e-16
Cq315 sar_cna4 sar_mclk 5.151e-17
Cq316 sar_cna4 sar_oan 4.187e-16
Cq317 sar_cna4 vdd 5.391e-18
Cq318 sar_cna4 vss 1.682e-15
Cq319 sar_cna5 sar_cna6 4.187e-16
Cq320 sar_cna5 sar_mclk 5.151e-17
Cq321 sar_cna5 vdd 5.391e-18
Cq322 sar_cna5 vss 1.682e-15
Cq323 sar_cna6 sar_cna7 2.361e-16
Cq324 sar_cna6 sar_mclk 5.229e-17
Cq325 sar_cna6 vdd 5.939e-18
Cq326 sar_cna6 vss 1.777e-15
Cq327 sar_cna7 sar_mclk 5.497e-17
Cq328 sar_cna7 vdd 5.391e-18
Cq329 sar_cna7 vss 2.151e-15
Cq330 sar_cna8 sar_cna9 3.064e-16
Cq331 sar_cna8 sar_mclk 5.454e-17
Cq332 sar_cna8 vdd 5.939e-18
Cq333 sar_cna8 vss 2.09e-15
Cq334 sar_cna9 sar_mclk 5.238e-17
Cq335 sar_cna9 vdd 4.844e-18
Cq336 sar_cna9 vss 1.756e-15
Cq337 sar_cnb0 sar_cnb1 4.047e-16
Cq338 sar_cnb0 sar_cnb2 3.919e-19
Cq339 sar_cnb0 sar_cnb3 3.99e-18
Cq340 sar_cnb0 sar_obp 2.496e-19
Cq341 sar_cnb0 vdd 8.551e-18
Cq342 sar_cnb0 vss 1.677e-15
Cq343 sar_cnb1 sar_cnb2 3.064e-16
Cq344 sar_cnb1 sar_cnb3 2.688e-19
Cq345 sar_cnb1 vdd 5.712e-18
Cq346 sar_cnb1 vss 1.327e-15
Cq347 sar_cnb10 sar_cnb11 2.978e-16
Cq348 sar_cnb10 sar_cnb12 2.496e-19
Cq349 sar_cnb10 sar_cnb8 2.496e-19
Cq350 sar_cnb10 sar_cnb9 2.879e-16
Cq351 sar_cnb10 vdd 8.551e-18
Cq352 sar_cnb10 vss 1.483e-15
Cq353 sar_cnb11 sar_cnb12 3.064e-16
Cq354 sar_cnb11 sar_cnb9 5.494e-18
Cq355 sar_cnb11 sar_cpb12 2.496e-19
Cq356 sar_cnb11 vdd 6.26e-18
Cq357 sar_cnb11 vss 1.418e-15
Cq358 sar_cnb12 sar_cpb11 5.494e-18
Cq359 sar_cnb12 sar_cpb12 2.978e-16
Cq360 sar_cnb12 vdd 6.26e-18
Cq361 sar_cnb12 vss 1.418e-15
Cq362 sar_cnb2 sar_cnb3 1.939e-18
Cq363 sar_cnb2 sar_obp 2.249e-15
Cq364 sar_cnb2 vdd 6.807e-18
Cq365 sar_cnb2 vss 1.063e-15
Cq366 sar_cnb3 sar_cnb4 5.334e-19
Cq367 sar_cnb3 sar_cnb5 1.521e-19
Cq368 sar_cnb3 sar_obn 7.769e-16
Cq369 sar_cnb3 sar_obp 6.642e-16
Cq370 sar_cnb3 vdd 9.721e-18
Cq371 sar_cnb3 vss 1.11e-15
Cq372 sar_cnb4 sar_cnb5 3.064e-16
Cq373 sar_cnb4 sar_cnb6 2.688e-19
Cq374 sar_cnb4 sar_obn 4.558e-16
Cq375 sar_cnb4 vdd 5.712e-18
Cq376 sar_cnb4 vss 1.294e-15
Cq377 sar_cnb5 sar_cnb6 3.976e-16
Cq378 sar_cnb5 sar_cnb7 5.494e-18
Cq379 sar_cnb5 vdd 6.807e-18
Cq380 sar_cnb5 vss 1.363e-15
Cq381 sar_cnb6 sar_cnb7 2.371e-16
Cq382 sar_cnb6 sar_obn 1.389e-19
Cq383 sar_cnb6 vdd 9.721e-18
Cq384 sar_cnb6 vss 1.495e-15
Cq385 sar_cnb7 vdd 5.712e-18
Cq386 sar_cnb7 vss 1.754e-15
Cq387 sar_cnb8 sar_cnb9 3.064e-16
Cq388 sar_cnb8 vdd 6.26e-18
Cq389 sar_cnb8 vss 1.7e-15
Cq390 sar_cnb9 vdd 6.26e-18
Cq391 sar_cnb9 vss 1.427e-15
Cq392 sar_cpa0 sar_cpa1 4.187e-16
Cq393 sar_cpa0 sar_mclk 4.832e-17
Cq394 sar_cpa0 vdd 5.391e-18
Cq395 sar_cpa0 vss 2.217e-15
Cq396 sar_cpa0 xckg_d0 3.136e-18
Cq397 sar_cpa1 sar_cpa2 2.361e-16
Cq398 sar_cpa1 sar_cpa3 1.221e-19
Cq399 sar_cpa1 sar_mclk 5.229e-17
Cq400 sar_cpa1 vdd 5.939e-18
Cq401 sar_cpa1 vss 1.785e-15
Cq402 sar_cpa1 xckg_d0 1.203e-18
Cq403 sar_cpa10 sar_cpa11 3.064e-16
Cq404 sar_cpa10 sar_cpa9 3.064e-16
Cq405 sar_cpa10 sar_mclk 5.238e-17
Cq406 sar_cpa10 vdd 4.844e-18
Cq407 sar_cpa10 vss 1.756e-15
Cq408 sar_cpa11 sar_cpa12 2.981e-16
Cq409 sar_cpa11 sar_mclk 5.273e-17
Cq410 sar_cpa11 vdd 5.939e-18
Cq411 sar_cpa11 vss 1.797e-15
Cq412 sar_cpa12 sar_mclk 5.273e-17
Cq413 sar_cpa12 vdd 5.939e-18
Cq414 sar_cpa12 vss 1.797e-15
Cq415 sar_cpa2 sar_cpa3 6.567e-19
Cq416 sar_cpa2 sar_mclk 4.997e-17
Cq417 sar_cpa2 vdd 5.391e-18
Cq418 sar_cpa2 vss 2.126e-15
Cq419 sar_cpa3 sar_cpa4 6.012e-16
Cq420 sar_cpa3 sar_cpa5 3.174e-19
Cq421 sar_cpa3 sar_mclk 4.094e-17
Cq422 sar_cpa3 vdd 8.305e-18
Cq423 sar_cpa3 vss 2.792e-15
Cq424 sar_cpa4 sar_cpa5 2.361e-16
Cq425 sar_cpa4 sar_mclk 5.014e-17
Cq426 sar_cpa4 vdd 5.939e-18
Cq427 sar_cpa4 vss 1.697e-15
Cq428 sar_cpa5 sar_cpa6 3.064e-16
Cq429 sar_cpa5 sar_mclk 5.316e-17
Cq430 sar_cpa5 vdd 5.391e-18
Cq431 sar_cpa5 vss 1.851e-15
Cq432 sar_cpa6 sar_cpa7 4.187e-16
Cq433 sar_cpa6 sar_mclk 5.151e-17
Cq434 sar_cpa6 vdd 5.391e-18
Cq435 sar_cpa6 vss 1.682e-15
Cq436 sar_cpa7 sar_mclk 5.35e-17
Cq437 sar_cpa7 vdd 5.939e-18
Cq438 sar_cpa7 vss 2e-15
Cq439 sar_cpa8 sar_cpa9 2.981e-16
Cq440 sar_cpa8 sar_mclk 5.454e-17
Cq441 sar_cpa8 vdd 5.939e-18
Cq442 sar_cpa8 vss 2.097e-15
Cq443 sar_cpa9 sar_mclk 5.273e-17
Cq444 sar_cpa9 vdd 5.939e-18
Cq445 sar_cpa9 vss 1.797e-15
Cq446 sar_cpb0 sar_cpb1 4.047e-16
Cq447 sar_cpb0 sar_cpb2 5.494e-18
Cq448 sar_cpb0 vdd 5.712e-18
Cq449 sar_cpb0 vss 1.612e-15
Cq450 sar_cpb1 sar_cpb2 2.289e-16
Cq451 sar_cpb1 sar_cpb3 4.295e-18
Cq452 sar_cpb1 vdd 8.551e-18
Cq453 sar_cpb1 vss 1.468e-15
Cq454 sar_cpb10 sar_cpb11 3.064e-16
Cq455 sar_cpb10 sar_cpb12 2.496e-19
Cq456 sar_cpb10 sar_cpb8 5.494e-18
Cq457 sar_cpb10 sar_cpb9 2.978e-16
Cq458 sar_cpb10 vdd 6.26e-18
Cq459 sar_cpb10 vss 1.418e-15
Cq460 sar_cpb11 sar_cpb12 2.879e-16
Cq461 sar_cpb11 sar_cpb9 2.496e-19
Cq462 sar_cpb11 vdd 6.26e-18
Cq463 sar_cpb11 vss 1.427e-15
Cq464 sar_cpb12 vdd 8.551e-18
Cq465 sar_cpb12 vss 1.483e-15
Cq466 sar_cpb2 sar_cpb3 7.915e-19
Cq467 sar_cpb2 vdd 6.807e-18
Cq468 sar_cpb2 vss 1.411e-15
Cq469 sar_cpb3 sar_cpb4 6.208e-16
Cq470 sar_cpb3 sar_cpb5 2.003e-19
Cq471 sar_cpb3 vdd 8.626e-18
Cq472 sar_cpb3 vss 1.109e-15
Cq473 sar_cpb4 sar_cpb5 2.289e-16
Cq474 sar_cpb4 vdd 8.551e-18
Cq475 sar_cpb4 vss 1.383e-15
Cq476 sar_cpb5 sar_cpb6 3.064e-16
Cq477 sar_cpb5 sar_cpb7 3.919e-19
Cq478 sar_cpb5 vdd 6.807e-18
Cq479 sar_cpb5 vss 1.507e-15
Cq480 sar_cpb6 sar_cpb7 4.047e-16
Cq481 sar_cpb6 vdd 5.712e-18
Cq482 sar_cpb6 vss 1.327e-15
Cq483 sar_cpb7 vdd 8.551e-18
Cq484 sar_cpb7 vss 1.678e-15
Cq485 sar_cpb8 sar_cpb9 2.879e-16
Cq486 sar_cpb8 vdd 6.26e-18
Cq487 sar_cpb8 vss 1.715e-15
Cq488 sar_cpb9 vdd 8.551e-18
Cq489 sar_cpb9 vss 1.484e-15
Cq490 sar_mclk sar_oan 4.849e-17
Cq491 sar_mclk sar_oann 5.047e-17
Cq492 sar_mclk sar_oanp 5.344e-17
Cq493 sar_mclk sar_oap 4.033e-17
Cq494 sar_mclk vdd 9.835e-16
Cq495 sar_mclk vss 5.569e-14
Cq496 sar_mclk xckg_d0 2.428e-16
Cq497 sar_mclk xckg_d1 2.372e-16
Cq498 sar_mclk xckg_d2 3.312e-16
Cq499 sar_mclk xckg_d3 2.272e-16
Cq500 sar_mclk xckg_nn 3.925e-16
Cq501 sar_mclk xckg_x 2.915e-16
Cq502 sar_oan vdd 5.939e-18
Cq503 sar_oan vss 1.46e-15
Cq504 sar_oann sar_oanp 4.187e-16
Cq505 sar_oann vdd 5.391e-18
Cq506 sar_oann vss 1.911e-15
Cq507 sar_oanp vdd 5.939e-18
Cq508 sar_oanp vss 2.018e-15
Cq509 sar_oap vdd 4.844e-18
Cq510 sar_oap vss 1.109e-15
Cq511 sar_obn sar_obp 1.052e-17
Cq512 sar_obn vdd 8.116e-18
Cq513 sar_obn vss 1.165e-15
Cq514 sar_obnn sar_obnp 4.047e-16
Cq515 sar_obnn vdd 5.712e-18
Cq516 sar_obnn vss 1.327e-15
Cq517 sar_obnp vdd 8.551e-18
Cq518 sar_obnp vss 1.678e-15
Cq519 sar_obp vdd 6.26e-18
Cq520 sar_obp vss 8.685e-16
Cq521 sar_trka0 sar_trka1 1.399e-16
Cq522 sar_trka0 vss 2.19e-15
Cq523 sar_trka1 vss 2.16e-15
Cq524 sar_trkb0 sar_trkb1 1.399e-16
Cq525 sar_trkb0 vdd 9.908e-17
Cq526 sar_trkb0 vss 1.928e-15
Cq527 sar_trkb1 vdd 5.712e-18
Cq528 sar_trkb1 vss 1.802e-15
Cq529 vbn vbp 2.899e-14
Cq530 vbn vdd 2.028e-15
Cq531 vbn vdda 5.091e-17
Cq532 vbn vref 1.786e-14
Cq533 vbn vref_in 4.127e-15
Cq534 vbn vrefl 2.52e-14
Cq535 vbn vss 1.155e-14
Cq536 vbn xref_na 7.746e-19
Cq537 vbn xref_ng 1.886e-15
Cq538 vbp vdd 1.803e-15
Cq539 vbp vdda 8.761e-15
Cq540 vbp vref 1.878e-14
Cq541 vbp vref_in 4.205e-15
Cq542 vbp vrefl 1.08e-14
Cq543 vbp vss 1.857e-14
Cq544 vbp xref_na 9.789e-18
Cq545 vbp xref_ng 2.371e-15
Cq546 vdd vdda 5.954e-16
Cq547 vdd vref 1.718e-13
Cq548 vdd vref_in 4.013e-14
Cq549 vdd vrefl 5.877e-14
Cq550 vdd vss 1.157e-13
Cq551 vdd xckg_d0 2.688e-16
Cq552 vdd xckg_d1 2.766e-16
Cq553 vdd xckg_d2 3.357e-16
Cq554 vdd xckg_d3 4.504e-16
Cq555 vdd xckg_nn 2.848e-18
Cq556 vdd xckg_x 4.879e-16
Cq557 vdd xref_ng 2.468e-14
Cq558 vdda vref 4.398e-14
Cq559 vdda vref_in 3.223e-16
Cq560 vdda vrefl 2.519e-14
Cq561 vdda vss 3.507e-14
Cq562 vdda xref_na 1.249e-15
Cq563 vdda xref_ng 2.299e-14
Cq564 vdda xref_ntl 9.96e-18
Cq565 vref vref_in 4.54e-14
Cq566 vref vrefl 1.67e-13
Cq567 vref vss 3.743e-13
Cq568 vref xref_na 1.322e-16
Cq569 vref xref_ng 4.971e-14
Cq570 vref xref_ntl 1.685e-15
Cq571 vref_in vrefl 3.08e-14
Cq572 vref_in vss 9.388e-14
Cq573 vref_in xref_na 4.042e-16
Cq574 vref_in xref_ng 3.421e-15
Cq575 vref_in xref_ntl 1.606e-15
Cq576 vrefl vss 1.926e-13
Cq577 vrefl xref_na 1.039e-16
Cq578 vrefl xref_ng 3.178e-14
Cq579 vrefl xref_ntl 2.185e-15
Cq580 vss xckg_d0 5.11e-15
Cq581 vss xckg_d1 4.339e-15
Cq582 vss xckg_d2 6.346e-15
Cq583 vss xckg_d3 8.13e-15
Cq584 vss xckg_nn 1.937e-15
Cq585 vss xckg_x 6.625e-15
Cq586 vss xref_na 4.437e-15
Cq587 vss xref_ng 8.769e-14
Cq588 vss xref_ntl 3.71e-15
Cq589 xckg_d0 xckg_d1 3.909e-15
Cq590 xckg_d0 xckg_d2 1.218e-15
Cq591 xckg_d0 xckg_d3 1.494e-17
Cq592 xckg_d0 xckg_nn 5.565e-16
Cq593 xckg_d0 xckg_x 4.057e-17
Cq594 xckg_d1 xckg_d2 3.755e-15
Cq595 xckg_d1 xckg_d3 3.433e-17
Cq596 xckg_d1 xckg_nn 6.939e-18
Cq597 xckg_d1 xckg_x 1.218e-17
Cq598 xckg_d2 xckg_d3 6.227e-16
Cq599 xckg_d2 xckg_nn 1.283e-16
Cq600 xckg_d2 xckg_x 1.227e-16
Cq601 xckg_d3 xckg_nn 3.139e-18
Cq602 xckg_d3 xckg_x 4.209e-15
Cq603 xckg_nn xckg_x 6.716e-17
Cq604 xref_na xref_ng 2.554e-15
Cq605 xref_na xref_ntl 2.584e-16
Cq606 xref_ng xref_ntl 2.12e-15
.ends
.subckt r1_adc_lay_pr adc_hold is_smp clk adc_start adc_sel adc_valid_a adc_raw_a_0 adc_raw_a_1 adc_raw_a_2 adc_raw_a_3 adc_raw_a_4 adc_raw_a_5 adc_raw_a_6 adc_raw_a_7 adc_raw_a_8 adc_raw_a_9 adc_raw_a_10 adc_raw_a_11 adc_raw_a_12 adc_raw_a_13 adc_valid_b adc_raw_b_0 adc_raw_b_1 adc_raw_b_2 adc_raw_b_3 adc_raw_b_4 adc_raw_b_5 adc_raw_b_6 adc_raw_b_7 adc_raw_b_8 adc_raw_b_9 adc_raw_b_10 adc_raw_b_11 adc_raw_b_12 adc_raw_b_13 por_n ain_sin_p ain_sin_n ain_cos_p ain_cos_n vcm2 ibias ain_isa_p ain_isa_n ain_isb_p ain_isb_n vcm vdda vdd vss vref_in topap topan topbp topbn sar_clka sar_clkab sar_clkb sar_clkbb sar_clkna sar_clknab sar_clknb sar_clknbb sar_cna0 sar_cna1 sar_cna10 sar_cna11 sar_cna12 sar_cna2 sar_cna3 sar_cna4 sar_cna5 sar_cna6 sar_cna7 sar_cna8 sar_cna9 sar_cnb0 sar_cnb1 sar_cnb10 sar_cnb11 sar_cnb12 sar_cnb2 sar_cnb3 sar_cnb4 sar_cnb5 sar_cnb6 sar_cnb7 sar_cnb8 sar_cnb9 sar_cpa0 sar_cpa1 sar_cpa10 sar_cpa11 sar_cpa12 sar_cpa2 sar_cpa3 sar_cpa4 sar_cpa5 sar_cpa6 sar_cpa7 sar_cpa8 sar_cpa9 sar_cpb0 sar_cpb1 sar_cpb10 sar_cpb11 sar_cpb12 sar_cpb2 sar_cpb3 sar_cpb4 sar_cpb5 sar_cpb6 sar_cpb7 sar_cpb8 sar_cpb9 sar_oan sar_oann sar_oanp sar_oap sar_obn sar_obnn sar_obnp sar_obp sar_trka0 sar_trka1 sar_trkb0 sar_trkb1 sar_mclk vref vrefl
Xxckg_xpd0 xckg_d0__p1 clk vdd__p2 vdd sg13_lv_pmos w=1u l=0.5u ng=1 m=1
Xxckg_xnd0 xckg_d0 clk vss__p9 vss sg13_lv_nmos w=0.5u l=0.5u ng=1 m=1
Xxckg_cd0 xckg_d0__p2 vss__p16 cap_cmim w=2.53u l=2.53u m=1
Xxckg_xpd1 xckg_d1__p1 xckg_d0 vdd__p3 vdd sg13_lv_pmos w=1u l=0.5u ng=1 m=1
Xxckg_xnd1 xckg_d1 xckg_d0 vss__p10 vss sg13_lv_nmos w=0.5u l=0.5u ng=1 m=1
Xxckg_cd1 xckg_d1__p2 vss__p17 cap_cmim w=2.53u l=2.53u m=1
Xxckg_xpd2 xckg_d2__p1 xckg_d1 vdd__p4 vdd sg13_lv_pmos w=1u l=0.5u ng=1 m=1
Xxckg_xnd2 xckg_d2 xckg_d1 vss__p11 vss sg13_lv_nmos w=0.5u l=0.5u ng=1 m=1
Xxckg_cd2 xckg_d2__p2 vss__p18 cap_cmim w=2.53u l=2.53u m=1
Xxckg_xpd3 xckg_d3__p1 xckg_d2 vdd__p5 vdd sg13_lv_pmos w=1u l=0.5u ng=1 m=1
Xxckg_xnd3 xckg_d3 xckg_d2 vss__p12 vss sg13_lv_nmos w=0.5u l=0.5u ng=1 m=1
Xxckg_cd3 xckg_d3__p2 vss__p19 cap_cmim w=2.53u l=2.53u m=1
Xxckg_xpd4 xckg_x__p2 xckg_d3 vdd__p6 vdd sg13_lv_pmos w=1u l=0.5u ng=1 m=1
Xxckg_xnd4 xckg_x xckg_d3 vss__p13 vss sg13_lv_nmos w=0.5u l=0.5u ng=1 m=1
Xxckg_cd4 xckg_x__p4 vss__p20 cap_cmim w=2.53u l=2.53u m=1
Xxckg_xpa sar_mclk__p2 clk__p1 vdd__p7 vdd sg13_lv_pmos w=2u l=0.13u ng=1 m=1
Xxckg_xpb sar_mclk__p3 xckg_x__p3 vdd__p8 vdd sg13_lv_pmos w=2u l=0.13u ng=1 m=1
Xxckg_xna sar_mclk__p0 clk__p0 xckg_nn vss sg13_lv_nmos w=2u l=0.13u ng=1 m=1
Xxckg_xnb xckg_nn__p1 xckg_x__p1 vss__p14 vss sg13_lv_nmos w=2u l=0.13u ng=1 m=1
Xxckg_xpi mclkb__p1 sar_mclk__p4 vdd__p9 vdd sg13_lv_pmos w=2u l=0.13u ng=1 m=1
Xxckg_xni mclkb sar_mclk__p1 vss__p15 vss sg13_lv_nmos w=1u l=0.13u ng=1 m=1
Xxcbias_xmbd vbp__p1 vbp vdd__p1 vdd sg13_lv_pmos w=0.8u l=0.5u ng=1 m=1
Xxcbias_xrb_g0 vbp xcbias_xrb_s1 vss rppd w=1u l=40u m=1 b=0
Xxcbias_xrb_g1 xcbias_xrb_s1 xcbias_xrb_s2 vss rppd w=1u l=40u m=1 b=0
Xxcbias_xrb_g2 xcbias_xrb_s2 xcbias_xrb_s3 vss rppd w=1u l=40u m=1 b=0
Xxcbias_xrb_g3 xcbias_xrb_s3 vss__p7 vss rppd w=1u l=40u m=1 b=0
Xxcbiasn_xmbd vbn__p1 vbn vss__p8 vss sg13_lv_nmos w=0.2u l=0.5u ng=1 m=1
Xxcbiasn_xrb_g0 vdd__p0 xcbiasn_xrb_s1 vss rppd w=1u l=40u m=1 b=0
Xxcbiasn_xrb_g1 xcbiasn_xrb_s1 xcbiasn_xrb_s2 vss rppd w=1u l=40u m=1 b=0
Xxcbiasn_xrb_g2 xcbiasn_xrb_s2 xcbiasn_xrb_s3 vss rppd w=1u l=40u m=1 b=0
Xxcbiasn_xrb_g3 xcbiasn_xrb_s3 vbn vss rppd w=1u l=40u m=1 b=0
Xxref_xmb0 ibias__p0 ibias vss__p5 vss sg13_hv_nmos w=2u l=1u ng=1 m=1
Xxref_xmt xref_ntl ibias vss__p6 vss sg13_hv_nmos w=2u l=8u ng=1 m=1
Xxref_xm1 xref_na vref_in xref_ntl__p1 vss sg13_hv_nmos w=10u l=1u ng=2 m=1
Xxref_xm2 xref_ng vref xref_ntl__p2 vss sg13_hv_nmos w=10u l=1u ng=2 m=1
Xxref_xm3 xref_na__p1 xref_na vdda__p5 vdda sg13_hv_pmos w=4u l=1u ng=1 m=1
Xxref_xm4 xref_ng__p1 xref_na vdda__p6 vdda sg13_hv_pmos w=4u l=1u ng=1 m=1
Xxref_xcg_u0 vss xref_ng__p2 cap_cmim w=26.32u l=95u m=1
Xxref_xmsf_s0 vdda__p1 xref_ng vref vss sg13_hv_nmos w=80u l=0.45u ng=32 m=1
Xxref_xmsf_s1 vdda__p2 xref_ng vref__p5 vss sg13_hv_nmos w=80u l=0.45u ng=32 m=1
Xxref_xmsf_s2 vdda__p3 xref_ng vref__p6 vss sg13_hv_nmos w=80u l=0.45u ng=32 m=1
Xxref_xmsf_s3 vdda__p4 xref_ng vref__p7 vss sg13_hv_nmos w=80u l=0.45u ng=32 m=1
Xxref_xmib_s0 vref__p0 ibias vss__p0 vss sg13_hv_nmos w=80u l=1u ng=40 m=1
Xxref_xmib_s1 vref__p1 ibias vss__p1 vss sg13_hv_nmos w=80u l=1u ng=40 m=1
Xxref_xmib_s2 vref__p2 ibias vss__p2 vss sg13_hv_nmos w=80u l=1u ng=40 m=1
Xxref_xmib_s3 vref__p3 ibias vss__p3 vss sg13_hv_nmos w=80u l=1u ng=40 m=1
Xxref_xcd_u0 vss vref__p8 cap_cmim w=51.58u l=95u m=1
Xxref_xcd_u1 vss vref__p9 cap_cmim w=51.58u l=95u m=1
Xxref_xcd_u2 vss vref__p10 cap_cmim w=51.58u l=95u m=1
Xxref_xcd_u3 vss vref__p11 cap_cmim w=51.58u l=95u m=1
Xxref_xmsfl_s0 vdda__p0 xref_ng vrefl vss sg13_hv_nmos w=80u l=0.45u ng=32 m=1
Xxref_xmibl_s0 vrefl__p0 ibias vss__p4 vss sg13_hv_nmos w=80u l=1u ng=40 m=1
Xxref_xcdl_u0 vss vrefl__p2 cap_cmim w=51.58u l=95u m=1
Xxref_xcdl_u1 vss vrefl__p3 cap_cmim w=51.58u l=95u m=1
Xxfilt_xcf_u0 vss vref_in__p1 cap_cmim w=37.36u l=90u m=1
Xxfilt_xcf_u1 vss vref_in__p2 cap_cmim w=37.36u l=90u m=1
Xslice_a ain_sin_p__p1 ain_sin_n__p1 ain_isa_p__p1 ain_isa_n__p1 sar_trka0__p1 sar_trka1__p1 sar_cpa0__p1 sar_cpa1__p1 sar_cpa2__p1 sar_cpa3__p1 sar_cpa4__p1 sar_cpa5__p1 sar_cpa6__p1 sar_cpa7__p1 sar_cpa8__p1 sar_cpa9__p1 sar_cpa10__p1 sar_cpa11__p1 sar_cpa12__p1 sar_cna0__p1 sar_cna1__p1 sar_cna2__p1 sar_cna3__p1 sar_cna4__p1 sar_cna5__p1 sar_cna6__p1 sar_cna7__p1 sar_cna8__p1 sar_cna9__p1 sar_cna10__p1 sar_cna11__p1 sar_cna12__p1 sar_clka__p1 sar_clkab__p1 sar_clkna__p1 sar_clknab__p1 sar_oap__p1 sar_oan__p1 sar_oanp__p1 sar_oann__p1 vbp__p2 vbn__p2 sp_vref__p12_a sp_vref__p13_a sp_vref__p14_a sp_vrefl__p4_a sp_vrefl__p5_a topap topan vdd__p12 vdd__p13 vdd__p14 vdd__p15 xslice_a_gnd_nc0 vss__p23 xslice_a_gnd_nc2 vss__p24 xslice_a_gnd_nc4 vss__p25 xslice_a_gnd_nc6 vss__p26 r1_adc_slice_post
Vsp_vref__p12_a sp_vref__p12_a 0 DC 1.049761
Vsp_vref__p13_a sp_vref__p13_a 0 DC 1.049761
Vsp_vref__p14_a sp_vref__p14_a 0 DC 1.049761
Vsp_vrefl__p4_a sp_vrefl__p4_a 0 DC 1.058123
Vsp_vrefl__p5_a sp_vrefl__p5_a 0 DC 1.058142
Xslice_b ain_cos_p__p1 ain_cos_n__p1 ain_isb_p__p1 ain_isb_n__p1 sar_trkb0__p1 sar_trkb1__p1 sar_cpb0__p1 sar_cpb1__p1 sar_cpb2__p1 sar_cpb3__p1 sar_cpb4__p1 sar_cpb5__p1 sar_cpb6__p1 sar_cpb7__p1 sar_cpb8__p1 sar_cpb9__p1 sar_cpb10__p1 sar_cpb11__p1 sar_cpb12__p1 sar_cnb0__p1 sar_cnb1__p1 sar_cnb2__p1 sar_cnb3__p1 sar_cnb4__p1 sar_cnb5__p1 sar_cnb6__p1 sar_cnb7__p1 sar_cnb8__p1 sar_cnb9__p1 sar_cnb10__p1 sar_cnb11__p1 sar_cnb12__p1 sar_clkb__p1 sar_clkbb__p1 sar_clknb__p1 sar_clknbb__p1 sar_obp__p1 sar_obn__p1 sar_obnp__p1 sar_obnn__p1 vbp__p3 vbn__p3 sp_vref__p15_b sp_vref__p16_b sp_vref__p17_b sp_vrefl__p6_b sp_vrefl__p7_b topbp topbn vdd__p16 vdd__p17 vdd__p18 vdd__p19 vss__p27 xslice_b_gnd_nc1 vss__p28 xslice_b_gnd_nc3 vss__p29 xslice_b_gnd_nc5 vss__p30 xslice_b_gnd_nc7 r1_adc_slice_post
Vsp_vref__p15_b sp_vref__p15_b 0 DC 1.049738
Vsp_vref__p16_b sp_vref__p16_b 0 DC 1.049738
Vsp_vref__p17_b sp_vref__p17_b 0 DC 1.049738
Vsp_vrefl__p6_b sp_vrefl__p6_b 0 DC 1.058302
Vsp_vrefl__p7_b sp_vrefl__p7_b 0 DC 1.058302
Rt0 ain_cos_n ain_cos_n__p1 126.828
Rt1 ain_cos_p ain_cos_p__p1 128.647
Rt2 ain_isa_n ain_isa_n__p1 127.972
Rt3 ain_isa_p ain_isa_p__p1 129.791
Rt4 ain_isb_n ain_isb_n__p1 0.198
Rt5 ain_isb_p ain_isb_p__p1 0.198
Rt6 ain_sin_n ain_sin_n__p1 0.308
Rt7 ain_sin_p ain_sin_p__p1 0.308
Rt8 clk clk__p0 141.519
Rt9 clk clk__p1 195.072
Rt10 clk__p0 clk__p1 49.582
Rt11 ibias ibias__p0 200.561
Rt12 mclkb mclkb__p1 43.3194
Rt13 sar_clka sar_clka__p1 12.3244
Rt14 sar_clkab sar_clkab__p1 12.3303
Rt15 sar_clkb sar_clkb__p1 12.498
Rt16 sar_clkbb sar_clkbb__p1 12.3244
Rt17 sar_clkna sar_clkna__p1 12.3244
Rt18 sar_clknab sar_clknab__p1 12.322
Rt19 sar_clknb sar_clknb__p1 12.3303
Rt20 sar_clknbb sar_clknbb__p1 12.3303
Rt21 sar_cna0 sar_cna0__p1 12.3244
Rt22 sar_cna1 sar_cna1__p1 12.3303
Rt23 sar_cna10 sar_cna10__p1 12.3244
Rt24 sar_cna11 sar_cna11__p1 12.3244
Rt25 sar_cna12 sar_cna12__p1 12.322
Rt26 sar_cna2 sar_cna2__p1 12.3303
Rt27 sar_cna3 sar_cna3__p1 12.3244
Rt28 sar_cna4 sar_cna4__p1 12.3303
Rt29 sar_cna5 sar_cna5__p1 12.3303
Rt30 sar_cna6 sar_cna6__p1 12.3244
Rt31 sar_cna7 sar_cna7__p1 12.3303
Rt32 sar_cna8 sar_cna8__p1 12.3244
Rt33 sar_cna9 sar_cna9__p1 12.322
Rt34 sar_cnb0 sar_cnb0__p1 12.498
Rt35 sar_cnb1 sar_cnb1__p1 12.322
Rt36 sar_cnb10 sar_cnb10__p1 12.498
Rt37 sar_cnb11 sar_cnb11__p1 12.3303
Rt38 sar_cnb12 sar_cnb12__p1 12.3303
Rt39 sar_cnb2 sar_cnb2__p1 12.3244
Rt40 sar_cnb3 sar_cnb3__p1 12.498
Rt41 sar_cnb4 sar_cnb4__p1 12.322
Rt42 sar_cnb5 sar_cnb5__p1 12.3244
Rt43 sar_cnb6 sar_cnb6__p1 12.498
Rt44 sar_cnb7 sar_cnb7__p1 12.322
Rt45 sar_cnb8 sar_cnb8__p1 12.3303
Rt46 sar_cnb9 sar_cnb9__p1 12.3303
Rt47 sar_cpa0 sar_cpa0__p1 12.3303
Rt48 sar_cpa1 sar_cpa1__p1 12.3244
Rt49 sar_cpa10 sar_cpa10__p1 12.322
Rt50 sar_cpa11 sar_cpa11__p1 12.3244
Rt51 sar_cpa12 sar_cpa12__p1 12.3244
Rt52 sar_cpa2 sar_cpa2__p1 12.3303
Rt53 sar_cpa3 sar_cpa3__p1 12.7425
Rt54 sar_cpa4 sar_cpa4__p1 12.3244
Rt55 sar_cpa5 sar_cpa5__p1 12.3303
Rt56 sar_cpa6 sar_cpa6__p1 12.3303
Rt57 sar_cpa7 sar_cpa7__p1 12.3244
Rt58 sar_cpa8 sar_cpa8__p1 12.3244
Rt59 sar_cpa9 sar_cpa9__p1 12.3244
Rt60 sar_cpb0 sar_cpb0__p1 12.322
Rt61 sar_cpb1 sar_cpb1__p1 12.498
Rt62 sar_cpb10 sar_cpb10__p1 12.3303
Rt63 sar_cpb11 sar_cpb11__p1 12.3303
Rt64 sar_cpb12 sar_cpb12__p1 12.498
Rt65 sar_cpb2 sar_cpb2__p1 12.3244
Rt66 sar_cpb3 sar_cpb3__p1 12.759
Rt67 sar_cpb4 sar_cpb4__p1 12.498
Rt68 sar_cpb5 sar_cpb5__p1 12.3244
Rt69 sar_cpb6 sar_cpb6__p1 12.322
Rt70 sar_cpb7 sar_cpb7__p1 12.498
Rt71 sar_cpb8 sar_cpb8__p1 12.3303
Rt72 sar_cpb9 sar_cpb9__p1 12.498
Rt73 sar_mclk sar_mclk__p0 170.374
Rt74 sar_mclk sar_mclk__p1 196.812
Rt75 sar_mclk sar_mclk__p2 307.715
Rt76 sar_mclk sar_mclk__p4 333.321
Rt77 sar_mclk__p0 sar_mclk__p1 70.5716
Rt78 sar_mclk__p0 sar_mclk__p2 110.338
Rt79 sar_mclk__p0 sar_mclk__p4 119.52
Rt80 sar_mclk__p1 sar_mclk__p2 101.952
Rt81 sar_mclk__p1 sar_mclk__p4 110.436
Rt82 sar_mclk__p2 sar_mclk__p3 0.6204
Rt83 sar_mclk__p2 sar_mclk__p4 64.7625
Rt84 sar_oan sar_oan__p1 12.3244
Rt85 sar_oann sar_oann__p1 12.3303
Rt86 sar_oanp sar_oanp__p1 12.3244
Rt87 sar_oap sar_oap__p1 12.322
Rt88 sar_obn sar_obn__p1 12.5344
Rt89 sar_obnn sar_obnn__p1 12.322
Rt90 sar_obnp sar_obnp__p1 12.498
Rt91 sar_obp sar_obp__p1 12.3303
Rt92 sar_trka0 sar_trka0__p1 12.3303
Rt93 sar_trka1 sar_trka1__p1 12.3303
Rt94 sar_trkb0 sar_trkb0__p1 12.3244
Rt95 sar_trkb1 sar_trkb1__p1 12.322
Rt96 vbn vbn__p1 68.8436
Rt97 vbn vbn__p2 240.016
Rt98 vbn vbn__p3 784.574
Rt99 vbn__p1 vbn__p2 217.489
Rt100 vbn__p1 vbn__p3 710.938
Rt101 vbn__p2 vbn__p3 168.032
Rt102 vbp vbp__p1 73.6975
Rt103 vbp vbp__p2 245.763
Rt104 vbp vbp__p3 1260.46
Rt105 vbp__p1 vbp__p2 195.517
Rt106 vbp__p1 vbp__p3 1002.76
Rt107 vbp__p2 vbp__p3 154.24
Rt108 vdd vdd__p0 34389.1
Rt109 vdd vdd__p1 40943
Rt110 vdd vdd__p11 68132.9
Rt111 vdd vdd__p12 82.2115
Rt112 vdd vdd__p13 11.0679
Rt113 vdd vdd__p14 29.2479
Rt114 vdd vdd__p15 437.715
Rt115 vdd vdd__p16 3424.56
Rt116 vdd vdd__p17 42939.2
Rt117 vdd vdd__p18 786782
Rt118 vdd__p0 vdd__p1 119.607
Rt119 vdd__p0 vdd__p12 99.6158
Rt120 vdd__p0 vdd__p13 288.609
Rt121 vdd__p0 vdd__p14 7716.14
Rt122 vdd__p0 vdd__p15 115478
Rt123 vdd__p0 vdd__p16 903464
Rt124 vdd__p1 vdd__p12 118.601
Rt125 vdd__p1 vdd__p13 343.612
Rt126 vdd__p1 vdd__p14 9186.68
Rt127 vdd__p1 vdd__p15 137485
Rt128 vdd__p11 vdd__p12 42970.9
Rt129 vdd__p11 vdd__p13 5785.07
Rt130 vdd__p11 vdd__p14 90.208
Rt131 vdd__p11 vdd__p15 12.7553
Rt132 vdd__p11 vdd__p16 14.0525
Rt133 vdd__p11 vdd__p17 160.888
Rt134 vdd__p11 vdd__p18 2947.98
Rt135 vdd__p11 vdd__p19 40686.4
Rt136 vdd__p11 vdd__p2 463.671
Rt137 vdd__p11 vdd__p3 424.895
Rt138 vdd__p11 vdd__p4 361.688
Rt139 vdd__p11 vdd__p5 291.702
Rt140 vdd__p11 vdd__p6 227.058
Rt141 vdd__p11 vdd__p7 29.9714
Rt142 vdd__p11 vdd__p8 158.698
Rt143 vdd__p11 vdd__p9 29.2186
Rt144 vdd__p12 vdd__p13 0.697261
Rt145 vdd__p12 vdd__p14 18.4464
Rt146 vdd__p12 vdd__p15 276.063
Rt147 vdd__p12 vdd__p16 2159.85
Rt148 vdd__p12 vdd__p17 27081.4
Rt149 vdd__p12 vdd__p18 496217
Rt150 vdd__p13 vdd__p14 2.48339
Rt151 vdd__p13 vdd__p15 37.1657
Rt152 vdd__p13 vdd__p16 290.775
Rt153 vdd__p13 vdd__p17 3645.91
Rt154 vdd__p13 vdd__p18 66804.5
Rt155 vdd__p13 vdd__p19 922000
Rt156 vdd__p13 vdd__p6 939934
Rt157 vdd__p13 vdd__p7 180555
Rt158 vdd__p13 vdd__p8 656946
Rt159 vdd__p13 vdd__p9 176021
Rt160 vdd__p14 vdd__p15 0.527112
Rt161 vdd__p14 vdd__p16 4.53412
Rt162 vdd__p14 vdd__p17 56.8516
Rt163 vdd__p14 vdd__p18 1041.7
Rt164 vdd__p14 vdd__p19 14377
Rt165 vdd__p14 vdd__p2 29930
Rt166 vdd__p14 vdd__p3 27427
Rt167 vdd__p14 vdd__p4 23347
Rt168 vdd__p14 vdd__p5 18829.3
Rt169 vdd__p14 vdd__p6 14656.6
Rt170 vdd__p14 vdd__p7 2815.45
Rt171 vdd__p14 vdd__p8 10243.9
Rt172 vdd__p14 vdd__p9 2744.73
Rt173 vdd__p15 vdd__p16 0.372867
Rt174 vdd__p15 vdd__p17 7.12045
Rt175 vdd__p15 vdd__p18 130.469
Rt176 vdd__p15 vdd__p19 1800.66
Rt177 vdd__p15 vdd__p2 4232.07
Rt178 vdd__p15 vdd__p3 3878.14
Rt179 vdd__p15 vdd__p4 3301.24
Rt180 vdd__p15 vdd__p5 2662.45
Rt181 vdd__p15 vdd__p6 2072.43
Rt182 vdd__p15 vdd__p7 398.102
Rt183 vdd__p15 vdd__p8 1448.48
Rt184 vdd__p15 vdd__p9 388.103
Rt185 vdd__p16 vdd__p17 0.804871
Rt186 vdd__p16 vdd__p18 14.9541
Rt187 vdd__p16 vdd__p19 206.388
Rt188 vdd__p16 vdd__p2 4662.44
Rt189 vdd__p16 vdd__p3 4272.53
Rt190 vdd__p16 vdd__p4 3636.95
Rt191 vdd__p16 vdd__p5 2933.2
Rt192 vdd__p16 vdd__p6 2283.19
Rt193 vdd__p16 vdd__p7 438.586
Rt194 vdd__p16 vdd__p8 1595.78
Rt195 vdd__p16 vdd__p9 427.57
Rt196 vdd__p17 vdd__p18 2.61782
Rt197 vdd__p17 vdd__p19 36.1298
Rt198 vdd__p17 vdd__p2 53380.8
Rt199 vdd__p17 vdd__p3 48916.6
Rt200 vdd__p17 vdd__p4 41639.9
Rt201 vdd__p17 vdd__p5 33582.6
Rt202 vdd__p17 vdd__p6 26140.5
Rt203 vdd__p17 vdd__p7 5021.42
Rt204 vdd__p17 vdd__p8 18270.3
Rt205 vdd__p17 vdd__p9 4895.3
Rt206 vdd__p18 vdd__p19 0.487307
Rt207 vdd__p18 vdd__p2 978105
Rt208 vdd__p18 vdd__p3 896307
Rt209 vdd__p18 vdd__p4 762974
Rt210 vdd__p18 vdd__p5 615339
Rt211 vdd__p18 vdd__p6 478976
Rt212 vdd__p18 vdd__p7 92008.3
Rt213 vdd__p18 vdd__p8 334770
Rt214 vdd__p18 vdd__p9 89697.3
Rt215 vdd__p2 vdd__p3 88.2674
Rt216 vdd__p2 vdd__p4 114.618
Rt217 vdd__p2 vdd__p5 144.634
Rt218 vdd__p2 vdd__p6 174.434
Rt219 vdd__p2 vdd__p7 14471.4
Rt220 vdd__p2 vdd__p8 225.153
Rt221 vdd__p2 vdd__p9 14108
Rt222 vdd__p3 vdd__p4 105.033
Rt223 vdd__p3 vdd__p5 132.538
Rt224 vdd__p3 vdd__p6 159.846
Rt225 vdd__p3 vdd__p7 13261.2
Rt226 vdd__p3 vdd__p8 206.324
Rt227 vdd__p3 vdd__p9 12928.1
Rt228 vdd__p4 vdd__p5 112.822
Rt229 vdd__p4 vdd__p6 136.068
Rt230 vdd__p4 vdd__p7 11288.5
Rt231 vdd__p4 vdd__p8 175.631
Rt232 vdd__p4 vdd__p9 11005
Rt233 vdd__p5 vdd__p6 109.739
Rt234 vdd__p5 vdd__p7 9104.19
Rt235 vdd__p5 vdd__p8 141.647
Rt236 vdd__p5 vdd__p9 8875.52
Rt237 vdd__p6 vdd__p7 7086.64
Rt238 vdd__p6 vdd__p8 110.257
Rt239 vdd__p6 vdd__p9 6908.64
Rt240 vdd__p7 vdd__p8 4953.05
Rt241 vdd__p7 vdd__p9 574.85
Rt242 vdd__p8 vdd__p9 4828.65
Rt243 vdda vdda__p1 41.3489
Rt244 vdda vdda__p2 278.578
Rt245 vdda vdda__p3 56.012
Rt246 vdda vdda__p5 261.48
Rt247 vdda vdda__p6 203.591
Rt248 vdda__p0 vdda__p3 62.8025
Rt249 vdda__p0 vdda__p4 67.5999
Rt250 vdda__p1 vdda__p2 1202.37
Rt251 vdda__p1 vdda__p3 241.754
Rt252 vdda__p1 vdda__p5 1128.58
Rt253 vdda__p1 vdda__p6 878.722
Rt254 vdda__p2 vdda__p3 256.165
Rt255 vdda__p2 vdda__p5 63.6193
Rt256 vdda__p2 vdda__p6 79.0683
Rt257 vdda__p3 vdda__p4 23.0314
Rt258 vdda__p3 vdda__p5 240.442
Rt259 vdda__p3 vdda__p6 187.211
Rt260 vdda__p5 vdda__p6 74.2153
Rt261 vref vref__p0 114.65
Rt262 vref vref__p1 6.10169
Rt263 vref vref__p10 186.142
Rt264 vref vref__p11 8271.36
Rt265 vref vref__p12 1487.93
Rt266 vref vref__p13 808.459
Rt267 vref vref__p14 372.871
Rt268 vref vref__p15 1459.54
Rt269 vref vref__p16 3157.02
Rt270 vref vref__p17 5801
Rt271 vref vref__p2 370.329
Rt272 vref vref__p3 10248.9
Rt273 vref vref__p5 428.96
Rt274 vref vref__p6 1135.72
Rt275 vref vref__p7 3138.93
Rt276 vref vref__p8 2223.31
Rt277 vref vref__p9 50.9452
Rt278 vref__p0 vref__p1 5.08178
Rt279 vref__p0 vref__p10 1372.92
Rt280 vref__p0 vref__p11 61005.8
Rt281 vref__p0 vref__p12 11330.2
Rt282 vref__p0 vref__p13 6156.32
Rt283 vref__p0 vref__p14 2839.43
Rt284 vref__p0 vref__p15 10764.9
Rt285 vref__p0 vref__p16 23284.7
Rt286 vref__p0 vref__p17 42785.5
Rt287 vref__p0 vref__p2 2151.06
Rt288 vref__p0 vref__p3 74645.3
Rt289 vref__p0 vref__p5 1782.68
Rt290 vref__p0 vref__p6 6979.82
Rt291 vref__p0 vref__p7 23027.9
Rt292 vref__p0 vref__p8 16928.7
Rt293 vref__p0 vref__p9 387.793
Rt294 vref__p1 vref__p10 27.2286
Rt295 vref__p1 vref__p11 1209.68
Rt296 vref__p1 vref__p12 366.189
Rt297 vref__p1 vref__p13 199.066
Rt298 vref__p1 vref__p14 91.8501
Rt299 vref__p1 vref__p15 213.441
Rt300 vref__p1 vref__p16 461.684
Rt301 vref__p1 vref__p17 848.354
Rt302 vref__p1 vref__p2 8.38761
Rt303 vref__p1 vref__p3 1193.26
Rt304 vref__p1 vref__p5 6.38445
Rt305 vref__p1 vref__p6 32.923
Rt306 vref__p1 vref__p7 414.228
Rt307 vref__p1 vref__p8 546.455
Rt308 vref__p1 vref__p9 12.4499
Rt309 vref__p10 vref__p11 1.96723
Rt310 vref__p10 vref__p12 390.352
Rt311 vref__p10 vref__p13 212.377
Rt312 vref__p10 vref__p14 98.0606
Rt313 vref__p10 vref__p15 1.88326
Rt314 vref__p10 vref__p16 2.58285
Rt315 vref__p10 vref__p17 2.96452
Rt316 vref__p10 vref__p2 13.5031
Rt317 vref__p10 vref__p3 151.839
Rt318 vref__p10 vref__p5 105.826
Rt319 vref__p10 vref__p6 71.6163
Rt320 vref__p10 vref__p7 45.7002
Rt321 vref__p10 vref__p8 581.257
Rt322 vref__p10 vref__p9 13.1189
Rt323 vref__p11 vref__p12 17345.9
Rt324 vref__p11 vref__p13 9437.27
Rt325 vref__p11 vref__p14 4357.47
Rt326 vref__p11 vref__p15 11.7242
Rt327 vref__p11 vref__p16 6.70636
Rt328 vref__p11 vref__p17 3.30899
Rt329 vref__p11 vref__p2 588.996
Rt330 vref__p11 vref__p3 6559.22
Rt331 vref__p11 vref__p5 4701.78
Rt332 vref__p11 vref__p6 3179.28
Rt333 vref__p11 vref__p7 1973.95
Rt334 vref__p11 vref__p8 25829
Rt335 vref__p11 vref__p9 582.958
Rt336 vref__p12 vref__p13 2.76051
Rt337 vref__p12 vref__p14 5.69068
Rt338 vref__p12 vref__p15 3060.82
Rt339 vref__p12 vref__p16 6620.62
Rt340 vref__p12 vref__p17 12165.3
Rt341 vref__p12 vref__p2 961.871
Rt342 vref__p12 vref__p3 21690.6
Rt343 vref__p12 vref__p5 2025.57
Rt344 vref__p12 vref__p6 2781.47
Rt345 vref__p12 vref__p7 6608.37
Rt346 vref__p12 vref__p8 3.41549
Rt347 vref__p12 vref__p9 2.8795
Rt348 vref__p13 vref__p14 2.76481
Rt349 vref__p13 vref__p15 1665.29
Rt350 vref__p13 vref__p16 3602.05
Rt351 vref__p13 vref__p17 6618.72
Rt352 vref__p13 vref__p2 523.306
Rt353 vref__p13 vref__p3 11801.1
Rt354 vref__p13 vref__p5 1101.86
Rt355 vref__p13 vref__p6 1513.26
Rt356 vref__p13 vref__p7 3595.37
Rt357 vref__p13 vref__p8 6.9687
Rt358 vref__p13 vref__p9 2.56608
Rt359 vref__p14 vref__p15 768.912
Rt360 vref__p14 vref__p16 1663.17
Rt361 vref__p14 vref__p17 3056.06
Rt362 vref__p14 vref__p2 241.621
Rt363 vref__p14 vref__p3 5448.89
Rt364 vref__p14 vref__p5 508.693
Rt365 vref__p14 vref__p6 698.702
Rt366 vref__p14 vref__p7 1660.09
Rt367 vref__p14 vref__p8 12.1708
Rt368 vref__p14 vref__p9 1.86726
Rt369 vref__p15 vref__p16 2.76621
Rt370 vref__p15 vref__p17 5.68373
Rt371 vref__p15 vref__p2 103.213
Rt372 vref__p15 vref__p3 1145.31
Rt373 vref__p15 vref__p5 829.619
Rt374 vref__p15 vref__p6 560.804
Rt375 vref__p15 vref__p7 344.658
Rt376 vref__p15 vref__p8 4557.75
Rt377 vref__p15 vref__p9 102.868
Rt378 vref__p16 vref__p17 2.75986
Rt379 vref__p16 vref__p2 223.556
Rt380 vref__p16 vref__p3 2482.45
Rt381 vref__p16 vref__p5 1794.5
Rt382 vref__p16 vref__p6 1213.12
Rt383 vref__p16 vref__p7 747.047
Rt384 vref__p16 vref__p8 9858.5
Rt385 vref__p16 vref__p9 222.505
Rt386 vref__p17 vref__p2 411.407
Rt387 vref__p17 vref__p3 4571.97
Rt388 vref__p17 vref__p5 3297.42
Rt389 vref__p17 vref__p6 2229.27
Rt390 vref__p17 vref__p7 1375.86
Rt391 vref__p17 vref__p8 18114.9
Rt392 vref__p17 vref__p9 408.851
Rt393 vref__p2 vref__p3 5.49374
Rt394 vref__p2 vref__p5 65.7993
Rt395 vref__p2 vref__p6 7.45703
Rt396 vref__p2 vref__p7 6.5906
Rt397 vref__p2 vref__p8 1432.38
Rt398 vref__p2 vref__p9 32.3382
Rt399 vref__p3 vref__p5 5279.01
Rt400 vref__p3 vref__p6 2064.28
Rt401 vref__p3 vref__p7 48.2546
Rt402 vref__p3 vref__p8 32298.7
Rt403 vref__p3 vref__p9 728.99
Rt404 vref__p5 vref__p6 244.984
Rt405 vref__p5 vref__p7 1709.1
Rt406 vref__p5 vref__p8 3017.46
Rt407 vref__p5 vref__p9 68.2281
Rt408 vref__p6 vref__p7 871.249
Rt409 vref__p6 vref__p8 4142.06
Rt410 vref__p6 vref__p9 93.5132
Rt411 vref__p7 vref__p8 9840.28
Rt412 vref__p7 vref__p9 222.096
Rt413 vref__p8 vref__p9 1.94076
Rt414 vref_in vref_in__p1 0.001
Rt415 vref_in vref_in__p2 0.001
Rt416 vrefl vrefl__p0 31.2586
Rt417 vrefl vrefl__p2 93.437
Rt418 vrefl vrefl__p3 7.18444
Rt419 vrefl vrefl__p4 7325.4
Rt420 vrefl vrefl__p5 4916.21
Rt421 vrefl vrefl__p6 359.98
Rt422 vrefl vrefl__p7 574.557
Rt423 vrefl__p0 vrefl__p2 18.0283
Rt424 vrefl__p0 vrefl__p3 12.5916
Rt425 vrefl__p0 vrefl__p4 63.5642
Rt426 vrefl__p0 vrefl__p5 72.9525
Rt427 vrefl__p0 vrefl__p6 631.93
Rt428 vrefl__p0 vrefl__p7 1009.16
Rt429 vrefl__p2 vrefl__p3 2.16812
Rt430 vrefl__p2 vrefl__p4 8.30061
Rt431 vrefl__p2 vrefl__p5 5.37046
Rt432 vrefl__p2 vrefl__p6 117.734
Rt433 vrefl__p2 vrefl__p7 192.433
Rt434 vrefl__p3 vrefl__p4 211.164
Rt435 vrefl__p3 vrefl__p5 128.531
Rt436 vrefl__p3 vrefl__p6 5.07096
Rt437 vrefl__p3 vrefl__p7 7.53987
Rt438 vrefl__p4 vrefl__p5 31.8717
Rt439 vrefl__p4 vrefl__p6 11315.9
Rt440 vrefl__p4 vrefl__p7 18493.5
Rt441 vrefl__p5 vrefl__p6 6889.67
Rt442 vrefl__p5 vrefl__p7 11261.9
Rt443 vrefl__p6 vrefl__p7 32.2289
Rt444 vss vss__p0 34.9503
Rt445 vss vss__p1 372.756
Rt446 vss vss__p10 18233.6
Rt447 vss vss__p11 33061.6
Rt448 vss vss__p12 32281.5
Rt449 vss vss__p13 55884.9
Rt450 vss vss__p14 78141.4
Rt451 vss vss__p15 250270
Rt452 vss vss__p16 358.209
Rt453 vss vss__p17 3653.28
Rt454 vss vss__p18 96113.9
Rt455 vss vss__p19 74114.8
Rt456 vss vss__p2 152.168
Rt457 vss vss__p20 138679
Rt458 vss vss__p22 0.001
Rt459 vss vss__p23 2
Rt460 vss vss__p24 2
Rt461 vss vss__p25 2
Rt462 vss vss__p26 2
Rt463 vss vss__p27 2
Rt464 vss vss__p28 2
Rt465 vss vss__p29 2
Rt466 vss vss__p3 89.0698
Rt467 vss vss__p30 2
Rt468 vss vss__p4 1076.06
Rt469 vss vss__p5 1332.84
Rt470 vss vss__p6 1752.7
Rt471 vss vss__p7 37.7353
Rt472 vss vss__p8 41.2417
Rt473 vss vss__p9 13512
Rt474 vss__p0 vss__p1 169.257
Rt475 vss__p0 vss__p10 782087
Rt476 vss__p0 vss__p16 15364.5
Rt477 vss__p0 vss__p17 156699
Rt478 vss__p0 vss__p2 6656.8
Rt479 vss__p0 vss__p3 3896.48
Rt480 vss__p0 vss__p4 488.606
Rt481 vss__p0 vss__p5 605.203
Rt482 vss__p0 vss__p6 795.845
Rt483 vss__p0 vss__p7 445.256
Rt484 vss__p0 vss__p8 490.044
Rt485 vss__p0 vss__p9 579567
Rt486 vss__p1 vss__p16 163868
Rt487 vss__p1 vss__p2 70997
Rt488 vss__p1 vss__p3 41557.2
Rt489 vss__p1 vss__p4 340.811
Rt490 vss__p1 vss__p5 422.139
Rt491 vss__p1 vss__p6 555.115
Rt492 vss__p1 vss__p7 4748.8
Rt493 vss__p1 vss__p8 5226.48
Rt494 vss__p10 vss__p11 184.446
Rt495 vss__p10 vss__p12 176.62
Rt496 vss__p10 vss__p13 307.671
Rt497 vss__p10 vss__p14 433.768
Rt498 vss__p10 vss__p15 1374.05
Rt499 vss__p10 vss__p16 139.567
Rt500 vss__p10 vss__p17 158.772
Rt501 vss__p10 vss__p18 555.994
Rt502 vss__p10 vss__p19 420.703
Rt503 vss__p10 vss__p2 352658
Rt504 vss__p10 vss__p20 808.124
Rt505 vss__p10 vss__p3 206424
Rt506 vss__p10 vss__p7 729352
Rt507 vss__p10 vss__p8 877308
Rt508 vss__p10 vss__p9 116.749
Rt509 vss__p11 vss__p12 195.406
Rt510 vss__p11 vss__p13 338.903
Rt511 vss__p11 vss__p14 475.02
Rt512 vss__p11 vss__p15 1516.48
Rt513 vss__p11 vss__p16 178.921
Rt514 vss__p11 vss__p17 29.8046
Rt515 vss__p11 vss__p18 591.254
Rt516 vss__p11 vss__p19 453.468
Rt517 vss__p11 vss__p2 639448
Rt518 vss__p11 vss__p20 854.867
Rt519 vss__p11 vss__p3 374293
Rt520 vss__p11 vss__p9 216.223
Rt521 vss__p12 vss__p13 190.25
Rt522 vss__p12 vss__p14 268.323
Rt523 vss__p12 vss__p15 849.545
Rt524 vss__p12 vss__p16 238.363
Rt525 vss__p12 vss__p17 142.029
Rt526 vss__p12 vss__p18 344.585
Rt527 vss__p12 vss__p19 260.506
Rt528 vss__p12 vss__p2 624361
Rt529 vss__p12 vss__p20 501.021
Rt530 vss__p12 vss__p3 365462
Rt531 vss__p12 vss__p9 207.081
Rt532 vss__p13 vss__p14 258.166
Rt533 vss__p13 vss__p15 860.032
Rt534 vss__p13 vss__p16 369.321
Rt535 vss__p13 vss__p17 80.5843
Rt536 vss__p13 vss__p18 42.4547
Rt537 vss__p13 vss__p19 227.381
Rt538 vss__p13 vss__p20 393.238
Rt539 vss__p13 vss__p3 632678
Rt540 vss__p13 vss__p9 360.715
Rt541 vss__p14 vss__p15 564.732
Rt542 vss__p14 vss__p16 453.74
Rt543 vss__p14 vss__p17 59.7988
Rt544 vss__p14 vss__p18 294.155
Rt545 vss__p14 vss__p19 55.3288
Rt546 vss__p14 vss__p20 194.885
Rt547 vss__p14 vss__p3 884646
Rt548 vss__p14 vss__p9 508.519
Rt549 vss__p15 vss__p16 1734.54
Rt550 vss__p15 vss__p17 513.739
Rt551 vss__p15 vss__p18 1398.8
Rt552 vss__p15 vss__p19 33.7794
Rt553 vss__p15 vss__p20 860.442
Rt554 vss__p15 vss__p9 1610.98
Rt555 vss__p16 vss__p17 1.54041
Rt556 vss__p16 vss__p18 350.696
Rt557 vss__p16 vss__p19 325.248
Rt558 vss__p16 vss__p2 6928.16
Rt559 vss__p16 vss__p20 475.339
Rt560 vss__p16 vss__p3 4055.32
Rt561 vss__p16 vss__p4 473049
Rt562 vss__p16 vss__p5 585932
Rt563 vss__p16 vss__p6 770504
Rt564 vss__p16 vss__p7 14328.5
Rt565 vss__p16 vss__p8 17235.2
Rt566 vss__p16 vss__p9 104.892
Rt567 vss__p17 vss__p18 22.3758
Rt568 vss__p17 vss__p19 25.21
Rt569 vss__p17 vss__p2 70658.6
Rt570 vss__p17 vss__p20 28.8059
Rt571 vss__p17 vss__p3 41359.2
Rt572 vss__p17 vss__p7 146133
Rt573 vss__p17 vss__p8 175777
Rt574 vss__p17 vss__p9 176.386
Rt575 vss__p18 vss__p19 169.03
Rt576 vss__p18 vss__p20 217.768
Rt577 vss__p18 vss__p9 651.585
Rt578 vss__p19 vss__p20 98.6071
Rt579 vss__p19 vss__p3 839061
Rt580 vss__p19 vss__p9 493.112
Rt581 vss__p2 vss__p3 63.5786
Rt582 vss__p2 vss__p4 204952
Rt583 vss__p2 vss__p5 253860
Rt584 vss__p2 vss__p6 333827
Rt585 vss__p2 vss__p7 6636.18
Rt586 vss__p2 vss__p8 7704.98
Rt587 vss__p2 vss__p9 261338
Rt588 vss__p20 vss__p9 947.006
Rt589 vss__p3 vss__p4 119966
Rt590 vss__p3 vss__p5 148594
Rt591 vss__p3 vss__p6 195402
Rt592 vss__p3 vss__p7 3884.41
Rt593 vss__p3 vss__p8 4510.02
Rt594 vss__p3 vss__p9 152971
Rt595 vss__p4 vss__p5 99.6258
Rt596 vss__p4 vss__p6 131.008
Rt597 vss__p4 vss__p7 13708.7
Rt598 vss__p4 vss__p8 15087.7
Rt599 vss__p5 vss__p6 57.9371
Rt600 vss__p5 vss__p7 16980
Rt601 vss__p5 vss__p8 18688
Rt602 vss__p6 vss__p7 22328.8
Rt603 vss__p6 vss__p8 24574.9
Rt604 vss__p7 vss__p8 217.113
Rt605 vss__p7 vss__p9 540488
Rt606 vss__p8 vss__p9 650130
Rt607 xckg_d0 xckg_d0__p1 158.064
Rt608 xckg_d0 xckg_d0__p2 32.5
Rt609 xckg_d0__p1 xckg_d0__p2 72.9819
Rt610 xckg_d1 xckg_d1__p1 160.822
Rt611 xckg_d1 xckg_d1__p2 33.3377
Rt612 xckg_d1__p1 xckg_d1__p2 71.7995
Rt613 xckg_d2 xckg_d2__p1 253.776
Rt614 xckg_d2 xckg_d2__p2 56.8495
Rt615 xckg_d2__p1 xckg_d2__p2 62.5432
Rt616 xckg_d3 xckg_d3__p1 116.773
Rt617 xckg_d3 xckg_d3__p2 66.8961
Rt618 xckg_d3__p1 xckg_d3__p2 71.2846
Rt619 xckg_nn xckg_nn__p1 46.1928
Rt620 xckg_x xckg_x__p1 101.928
Rt621 xckg_x xckg_x__p2 247.825
Rt622 xckg_x xckg_x__p3 173.816
Rt623 xckg_x xckg_x__p4 124.476
Rt624 xckg_x__p1 xckg_x__p2 156.926
Rt625 xckg_x__p1 xckg_x__p3 110.063
Rt626 xckg_x__p1 xckg_x__p4 78.82
Rt627 xckg_x__p2 xckg_x__p3 94.6454
Rt628 xckg_x__p2 xckg_x__p4 142.468
Rt629 xckg_x__p3 xckg_x__p4 99.922
Rt630 xref_na xref_na__p1 77.984
Rt631 xref_ng xref_ng__p1 1225.95
Rt632 xref_ng xref_ng__p2 132.884
Rt633 xref_ng__p1 xref_ng__p2 31.5508
Rt634 xref_ntl xref_ntl__p1 60.2546
Rt635 xref_ntl__p1 xref_ntl__p2 19.318
Cq0 ain_cos_n ain_cos_p 2.707e-14
Cq1 ain_cos_n ain_isa_n 3.445e-17
Cq2 ain_cos_n ain_isa_p 4.604e-17
Cq3 ain_cos_n ibias 1.097e-16
Cq4 ain_cos_n sar_clka 2.933e-17
Cq5 ain_cos_n sar_clkab 2.933e-17
Cq6 ain_cos_n sar_clkna 2.933e-17
Cq7 ain_cos_n sar_clknab 2.946e-17
Cq8 ain_cos_n sar_cna0 4.649e-17
Cq9 ain_cos_n sar_cna1 4.481e-17
Cq10 ain_cos_n sar_cna10 4.578e-17
Cq11 ain_cos_n sar_cna11 4.578e-17
Cq12 ain_cos_n sar_cna12 4.578e-17
Cq13 ain_cos_n sar_cna2 3.756e-17
Cq14 ain_cos_n sar_cna3 3.984e-17
Cq15 ain_cos_n sar_cna4 4.481e-17
Cq16 ain_cos_n sar_cna5 4.481e-17
Cq17 ain_cos_n sar_cna6 4.537e-17
Cq18 ain_cos_n sar_cna7 4.802e-17
Cq19 ain_cos_n sar_cna8 4.746e-17
Cq20 ain_cos_n sar_cna9 4.578e-17
Cq21 ain_cos_n sar_cpa0 4.649e-17
Cq22 ain_cos_n sar_cpa1 4.537e-17
Cq23 ain_cos_n sar_cpa10 4.578e-17
Cq24 ain_cos_n sar_cpa11 4.578e-17
Cq25 ain_cos_n sar_cpa12 4.578e-17
Cq26 ain_cos_n sar_cpa2 4.337e-17
Cq27 ain_cos_n sar_cpa3 3.579e-17
Cq28 ain_cos_n sar_cpa4 4.337e-17
Cq29 ain_cos_n sar_cpa5 4.634e-17
Cq30 ain_cos_n sar_cpa6 4.481e-17
Cq31 ain_cos_n sar_cpa7 4.649e-17
Cq32 ain_cos_n sar_cpa8 4.746e-17
Cq33 ain_cos_n sar_cpa9 4.578e-17
Cq34 ain_cos_n sar_oan 4.184e-17
Cq35 ain_cos_n sar_oann 4.384e-17
Cq36 ain_cos_n sar_oanp 4.649e-17
Cq37 ain_cos_n sar_oap 3.459e-17
Cq38 ain_cos_n sar_trka0 5.23e-17
Cq39 ain_cos_n sar_trka1 4.808e-17
Cq40 ain_cos_n sar_trkb0 1.443e-17
Cq41 ain_cos_n vdd 3.063e-15
Cq42 ain_cos_n vss 3.507e-14
Cq43 ain_cos_n xckg_d0 4.043e-19
Cq44 ain_cos_n xckg_d1 7.338e-19
Cq45 ain_cos_n xckg_d2 8.525e-19
Cq46 ain_cos_n xckg_d3 1.362e-18
Cq47 ain_cos_n xckg_x 2.674e-17
Cq48 ain_cos_p ain_isa_n 3.424e-17
Cq49 ain_cos_p ain_isa_p 4.84e-17
Cq50 ain_cos_p ibias 2.317e-16
Cq51 ain_cos_p sar_clka 2.933e-17
Cq52 ain_cos_p sar_clkab 2.933e-17
Cq53 ain_cos_p sar_clkna 2.933e-17
Cq54 ain_cos_p sar_clknab 2.951e-17
Cq55 ain_cos_p sar_cna0 4.649e-17
Cq56 ain_cos_p sar_cna1 4.481e-17
Cq57 ain_cos_p sar_cna10 4.578e-17
Cq58 ain_cos_p sar_cna11 4.578e-17
Cq59 ain_cos_p sar_cna12 4.578e-17
Cq60 ain_cos_p sar_cna2 3.756e-17
Cq61 ain_cos_p sar_cna3 3.984e-17
Cq62 ain_cos_p sar_cna4 4.481e-17
Cq63 ain_cos_p sar_cna5 4.481e-17
Cq64 ain_cos_p sar_cna6 4.537e-17
Cq65 ain_cos_p sar_cna7 4.802e-17
Cq66 ain_cos_p sar_cna8 4.746e-17
Cq67 ain_cos_p sar_cna9 4.578e-17
Cq68 ain_cos_p sar_cpa0 4.649e-17
Cq69 ain_cos_p sar_cpa1 4.537e-17
Cq70 ain_cos_p sar_cpa10 4.578e-17
Cq71 ain_cos_p sar_cpa11 4.578e-17
Cq72 ain_cos_p sar_cpa12 4.578e-17
Cq73 ain_cos_p sar_cpa2 4.337e-17
Cq74 ain_cos_p sar_cpa3 3.788e-17
Cq75 ain_cos_p sar_cpa4 4.337e-17
Cq76 ain_cos_p sar_cpa5 4.634e-17
Cq77 ain_cos_p sar_cpa6 4.481e-17
Cq78 ain_cos_p sar_cpa7 4.649e-17
Cq79 ain_cos_p sar_cpa8 4.746e-17
Cq80 ain_cos_p sar_cpa9 4.578e-17
Cq81 ain_cos_p sar_oan 4.184e-17
Cq82 ain_cos_p sar_oann 4.384e-17
Cq83 ain_cos_p sar_oanp 4.649e-17
Cq84 ain_cos_p sar_oap 3.459e-17
Cq85 ain_cos_p sar_trka0 5.315e-17
Cq86 ain_cos_p sar_trka1 4.808e-17
Cq87 ain_cos_p sar_trkb0 4.662e-19
Cq88 ain_cos_p vdd 2.211e-15
Cq89 ain_cos_p vss 3.544e-14
Cq90 ain_cos_p xckg_d3 3.348e-19
Cq91 ain_cos_p xckg_x 2.003e-17
Cq92 ain_isa_n ain_isa_p 2.783e-14
Cq93 ain_isa_n ain_isb_n 6.15e-17
Cq94 ain_isa_n ain_isb_p 6.417e-17
Cq95 ain_isa_n sar_clkb 4.864e-17
Cq96 ain_isa_n sar_clkbb 4.746e-17
Cq97 ain_isa_n sar_clknab 9.415e-19
Cq98 ain_isa_n sar_clknb 4.184e-17
Cq99 ain_isa_n sar_clknbb 2.965e-17
Cq100 ain_isa_n sar_cnb0 4.649e-17
Cq101 ain_isa_n sar_cnb1 4.481e-17
Cq102 ain_isa_n sar_cnb10 4.578e-17
Cq103 ain_isa_n sar_cnb11 4.578e-17
Cq104 ain_isa_n sar_cnb12 4.578e-17
Cq105 ain_isa_n sar_cnb2 3.756e-17
Cq106 ain_isa_n sar_cnb3 3.984e-17
Cq107 ain_isa_n sar_cnb4 4.481e-17
Cq108 ain_isa_n sar_cnb5 4.481e-17
Cq109 ain_isa_n sar_cnb6 4.537e-17
Cq110 ain_isa_n sar_cnb7 4.802e-17
Cq111 ain_isa_n sar_cnb8 4.746e-17
Cq112 ain_isa_n sar_cnb9 4.578e-17
Cq113 ain_isa_n sar_cpb0 4.649e-17
Cq114 ain_isa_n sar_cpb1 4.537e-17
Cq115 ain_isa_n sar_cpb10 4.578e-17
Cq116 ain_isa_n sar_cpb11 4.578e-17
Cq117 ain_isa_n sar_cpb12 4.578e-17
Cq118 ain_isa_n sar_cpb2 4.537e-17
Cq119 ain_isa_n sar_cpb3 4.024e-17
Cq120 ain_isa_n sar_cpb4 4.337e-17
Cq121 ain_isa_n sar_cpb5 4.634e-17
Cq122 ain_isa_n sar_cpb6 4.481e-17
Cq123 ain_isa_n sar_cpb7 4.649e-17
Cq124 ain_isa_n sar_cpb8 4.746e-17
Cq125 ain_isa_n sar_cpb9 4.578e-17
Cq126 ain_isa_n sar_obn 4.184e-17
Cq127 ain_isa_n sar_obnn 4.481e-17
Cq128 ain_isa_n sar_obnp 4.649e-17
Cq129 ain_isa_n sar_obp 3.459e-17
Cq130 ain_isa_n sar_trkb0 4.883e-17
Cq131 ain_isa_n sar_trkb1 4.833e-17
Cq132 ain_isa_n vdd 8.828e-17
Cq133 ain_isa_n vss 3.302e-14
Cq134 ain_isa_p ain_isb_n 7.645e-17
Cq135 ain_isa_p ain_isb_p 7.912e-17
Cq136 ain_isa_p sar_clkb 4.864e-17
Cq137 ain_isa_p sar_clkbb 4.746e-17
Cq138 ain_isa_p sar_clknab 7.019e-19
Cq139 ain_isa_p sar_clknb 4.184e-17
Cq140 ain_isa_p sar_clknbb 3.499e-17
Cq141 ain_isa_p sar_cnb0 4.649e-17
Cq142 ain_isa_p sar_cnb1 4.481e-17
Cq143 ain_isa_p sar_cnb10 4.578e-17
Cq144 ain_isa_p sar_cnb11 4.578e-17
Cq145 ain_isa_p sar_cnb12 4.578e-17
Cq146 ain_isa_p sar_cnb2 3.756e-17
Cq147 ain_isa_p sar_cnb3 3.984e-17
Cq148 ain_isa_p sar_cnb4 4.481e-17
Cq149 ain_isa_p sar_cnb5 4.481e-17
Cq150 ain_isa_p sar_cnb6 4.537e-17
Cq151 ain_isa_p sar_cnb7 4.802e-17
Cq152 ain_isa_p sar_cnb8 4.746e-17
Cq153 ain_isa_p sar_cnb9 4.578e-17
Cq154 ain_isa_p sar_cpb0 4.649e-17
Cq155 ain_isa_p sar_cpb1 4.537e-17
Cq156 ain_isa_p sar_cpb10 4.578e-17
Cq157 ain_isa_p sar_cpb11 4.578e-17
Cq158 ain_isa_p sar_cpb12 4.578e-17
Cq159 ain_isa_p sar_cpb2 4.537e-17
Cq160 ain_isa_p sar_cpb3 4.047e-17
Cq161 ain_isa_p sar_cpb4 4.337e-17
Cq162 ain_isa_p sar_cpb5 4.634e-17
Cq163 ain_isa_p sar_cpb6 4.481e-17
Cq164 ain_isa_p sar_cpb7 4.649e-17
Cq165 ain_isa_p sar_cpb8 4.746e-17
Cq166 ain_isa_p sar_cpb9 4.578e-17
Cq167 ain_isa_p sar_mclk 2.531e-18
Cq168 ain_isa_p sar_obn 4.184e-17
Cq169 ain_isa_p sar_obnn 4.481e-17
Cq170 ain_isa_p sar_obnp 4.649e-17
Cq171 ain_isa_p sar_obp 3.459e-17
Cq172 ain_isa_p sar_trkb0 5.684e-17
Cq173 ain_isa_p sar_trkb1 4.833e-17
Cq174 ain_isa_p vdd 1.13e-16
Cq175 ain_isa_p vss 3.362e-14
Cq176 ain_isb_n ain_isb_p 7.431e-17
Cq177 ain_isb_n vss 9.265e-16
Cq178 ain_isb_p vss 8.611e-16
Cq179 ain_sin_n ain_sin_p 8.625e-17
Cq180 ain_sin_n ibias 9.686e-17
Cq181 ain_sin_n vss 7.977e-16
Cq182 ain_sin_p ibias 9.686e-17
Cq183 ain_sin_p vss 7.924e-16
Cq184 clk mclkb 1.252e-18
Cq185 clk sar_clka 3.704e-17
Cq186 clk sar_clkab 2.773e-17
Cq187 clk sar_clkna 3.212e-17
Cq188 clk sar_clknab 4.043e-18
Cq189 clk sar_cna0 4.953e-17
Cq190 clk sar_cna1 4.301e-17
Cq191 clk sar_cna10 4.59e-17
Cq192 clk sar_cna11 4.59e-17
Cq193 clk sar_cna12 4.443e-17
Cq194 clk sar_cna2 3.644e-17
Cq195 clk sar_cna3 3.581e-17
Cq196 clk sar_cna4 4.301e-17
Cq197 clk sar_cna5 4.301e-17
Cq198 clk sar_cna6 4.534e-17
Cq199 clk sar_cna7 5.255e-17
Cq200 clk sar_cna8 5.168e-17
Cq201 clk sar_cna9 4.443e-17
Cq202 clk sar_cpa0 4.489e-17
Cq203 clk sar_cpa1 4.592e-17
Cq204 clk sar_cpa10 4.443e-17
Cq205 clk sar_cpa11 4.59e-17
Cq206 clk sar_cpa12 4.59e-17
Cq207 clk sar_cpa2 4.223e-17
Cq208 clk sar_cpa3 3.127e-17
Cq209 clk sar_cpa4 4.339e-17
Cq210 clk sar_cpa5 4.676e-17
Cq211 clk sar_cpa6 4.301e-17
Cq212 clk sar_cpa7 4.953e-17
Cq213 clk sar_cpa8 5.168e-17
Cq214 clk sar_cpa9 4.59e-17
Cq215 clk sar_mclk 4.18e-16
Cq216 clk sar_oan 3.87e-17
Cq217 clk sar_oann 4.086e-17
Cq218 clk sar_oanp 4.931e-17
Cq219 clk sar_oap 3.067e-17
Cq220 clk sar_trka0 6.343e-17
Cq221 clk sar_trka1 5.755e-17
Cq222 clk vdd 1.554e-15
Cq223 clk vss 2.921e-14
Cq224 clk xckg_d0 3.206e-16
Cq225 clk xckg_d1 1.883e-16
Cq226 clk xckg_d2 1.491e-16
Cq227 clk xckg_d3 2.541e-16
Cq228 clk xckg_nn 2.492e-17
Cq229 clk xckg_x 3.281e-16
Cq230 ibias sar_trka0 1.287e-17
Cq231 ibias vbn 2.266e-15
Cq232 ibias vbp 6.102e-17
Cq233 ibias vdd 4.502e-15
Cq234 ibias vdda 2.216e-16
Cq235 ibias vref 4.11e-14
Cq236 ibias vref_in 9.847e-15
Cq237 ibias vrefl 1.687e-14
Cq238 ibias vss 1.681e-13
Cq239 ibias xref_ng 2.101e-15
Cq240 ibias xref_ntl 1.737e-16
Cq241 mclkb sar_clknab 4.044e-17
Cq242 mclkb sar_mclk 2.778e-16
Cq243 mclkb sar_trkb0 2.442e-18
Cq244 mclkb vdd 1.741e-15
Cq245 mclkb vss 5.564e-15
Cq246 mclkb xckg_d0 1.25e-15
Cq247 mclkb xckg_d1 2.7e-16
Cq248 mclkb xckg_d2 2.182e-16
Cq249 mclkb xckg_d3 1.483e-17
Cq250 mclkb xckg_nn 2.576e-17
Cq251 mclkb xckg_x 1.907e-17
Cq252 sar_clka sar_trka1 4.996e-17
Cq253 sar_clka vdd 5.939e-18
Cq254 sar_clka vss 4.415e-15
Cq255 sar_clkab sar_mclk 3.485e-17
Cq256 sar_clkab sar_oann 9.641e-17
Cq257 sar_clkab vdd 5.391e-18
Cq258 sar_clkab vss 4.557e-15
Cq259 sar_clkb sar_trkb1 1.541e-16
Cq260 sar_clkb vdd 9.721e-18
Cq261 sar_clkb vss 1.963e-15
Cq262 sar_clkbb sar_obnn 3.064e-16
Cq263 sar_clkbb sar_obnp 3.919e-19
Cq264 sar_clkbb vdd 6.807e-18
Cq265 sar_clkbb vss 1.715e-15
Cq266 sar_clkna sar_cpa2 1.689e-16
Cq267 sar_clkna sar_cpa3 7.355e-16
Cq268 sar_clkna sar_cpa4 1.185e-17
Cq269 sar_clkna sar_mclk 3.502e-17
Cq270 sar_clkna vdd 5.939e-18
Cq271 sar_clkna vss 3.965e-15
Cq272 sar_clknab sar_mclk 1.264e-16
Cq273 sar_clknab vdd 1.914e-16
Cq274 sar_clknab vss 4.193e-15
Cq275 sar_clknab xckg_x 7.189e-17
Cq276 sar_clknb sar_cpb1 2.496e-19
Cq277 sar_clknb sar_cpb2 4.387e-16
Cq278 sar_clknb sar_cpb3 1.131e-15
Cq279 sar_clknb sar_cpb4 6.245e-19
Cq280 sar_clknb sar_cpb5 4.845e-18
Cq281 sar_clknb vdd 6.26e-18
Cq282 sar_clknb vss 1.056e-15
Cq283 sar_clknbb vss 4.526e-15
Cq284 sar_cna0 sar_cna1 4.187e-16
Cq285 sar_cna0 sar_mclk 5.35e-17
Cq286 sar_cna0 vdd 5.939e-18
Cq287 sar_cna0 vss 2e-15
Cq288 sar_cna1 sar_cna2 3.064e-16
Cq289 sar_cna1 sar_mclk 5.151e-17
Cq290 sar_cna1 vdd 5.391e-18
Cq291 sar_cna1 vss 1.682e-15
Cq292 sar_cna10 sar_cna11 2.981e-16
Cq293 sar_cna10 sar_cna9 3.064e-16
Cq294 sar_cna10 sar_mclk 5.273e-17
Cq295 sar_cna10 vdd 5.939e-18
Cq296 sar_cna10 vss 1.797e-15
Cq297 sar_cna11 sar_cna12 3.064e-16
Cq298 sar_cna11 sar_mclk 5.273e-17
Cq299 sar_cna11 vdd 5.939e-18
Cq300 sar_cna11 vss 1.797e-15
Cq301 sar_cna12 sar_cpa12 3.064e-16
Cq302 sar_cna12 sar_mclk 5.238e-17
Cq303 sar_cna12 vdd 4.844e-18
Cq304 sar_cna12 vss 1.756e-15
Cq305 sar_cna2 sar_mclk 4.37e-17
Cq306 sar_cna2 sar_oap 2.214e-15
Cq307 sar_cna2 vdd 5.391e-18
Cq308 sar_cna2 vss 1.347e-15
Cq309 sar_cna3 sar_mclk 4.634e-17
Cq310 sar_cna3 sar_oan 8.01e-16
Cq311 sar_cna3 sar_oap 7.036e-16
Cq312 sar_cna3 vdd 5.939e-18
Cq313 sar_cna3 vss 1.328e-15
Cq314 sar_cna4 sar_cna5 3.064e-16
Cq315 sar_cna4 sar_mclk 5.151e-17
Cq316 sar_cna4 sar_oan 4.187e-16
Cq317 sar_cna4 vdd 5.391e-18
Cq318 sar_cna4 vss 1.682e-15
Cq319 sar_cna5 sar_cna6 4.187e-16
Cq320 sar_cna5 sar_mclk 5.151e-17
Cq321 sar_cna5 vdd 5.391e-18
Cq322 sar_cna5 vss 1.682e-15
Cq323 sar_cna6 sar_cna7 2.361e-16
Cq324 sar_cna6 sar_mclk 5.229e-17
Cq325 sar_cna6 vdd 5.939e-18
Cq326 sar_cna6 vss 1.777e-15
Cq327 sar_cna7 sar_mclk 5.497e-17
Cq328 sar_cna7 vdd 5.391e-18
Cq329 sar_cna7 vss 2.151e-15
Cq330 sar_cna8 sar_cna9 3.064e-16
Cq331 sar_cna8 sar_mclk 5.454e-17
Cq332 sar_cna8 vdd 5.939e-18
Cq333 sar_cna8 vss 2.09e-15
Cq334 sar_cna9 sar_mclk 5.238e-17
Cq335 sar_cna9 vdd 4.844e-18
Cq336 sar_cna9 vss 1.756e-15
Cq337 sar_cnb0 sar_cnb1 4.047e-16
Cq338 sar_cnb0 sar_cnb2 3.919e-19
Cq339 sar_cnb0 sar_cnb3 3.99e-18
Cq340 sar_cnb0 sar_obp 2.496e-19
Cq341 sar_cnb0 vdd 8.551e-18
Cq342 sar_cnb0 vss 1.677e-15
Cq343 sar_cnb1 sar_cnb2 3.064e-16
Cq344 sar_cnb1 sar_cnb3 2.688e-19
Cq345 sar_cnb1 vdd 5.712e-18
Cq346 sar_cnb1 vss 1.327e-15
Cq347 sar_cnb10 sar_cnb11 2.978e-16
Cq348 sar_cnb10 sar_cnb12 2.496e-19
Cq349 sar_cnb10 sar_cnb8 2.496e-19
Cq350 sar_cnb10 sar_cnb9 2.879e-16
Cq351 sar_cnb10 vdd 8.551e-18
Cq352 sar_cnb10 vss 1.483e-15
Cq353 sar_cnb11 sar_cnb12 3.064e-16
Cq354 sar_cnb11 sar_cnb9 5.494e-18
Cq355 sar_cnb11 sar_cpb12 2.496e-19
Cq356 sar_cnb11 vdd 6.26e-18
Cq357 sar_cnb11 vss 1.418e-15
Cq358 sar_cnb12 sar_cpb11 5.494e-18
Cq359 sar_cnb12 sar_cpb12 2.978e-16
Cq360 sar_cnb12 vdd 6.26e-18
Cq361 sar_cnb12 vss 1.418e-15
Cq362 sar_cnb2 sar_cnb3 1.939e-18
Cq363 sar_cnb2 sar_obp 2.249e-15
Cq364 sar_cnb2 vdd 6.807e-18
Cq365 sar_cnb2 vss 1.063e-15
Cq366 sar_cnb3 sar_cnb4 5.334e-19
Cq367 sar_cnb3 sar_cnb5 1.521e-19
Cq368 sar_cnb3 sar_obn 7.769e-16
Cq369 sar_cnb3 sar_obp 6.642e-16
Cq370 sar_cnb3 vdd 9.721e-18
Cq371 sar_cnb3 vss 1.11e-15
Cq372 sar_cnb4 sar_cnb5 3.064e-16
Cq373 sar_cnb4 sar_cnb6 2.688e-19
Cq374 sar_cnb4 sar_obn 4.558e-16
Cq375 sar_cnb4 vdd 5.712e-18
Cq376 sar_cnb4 vss 1.294e-15
Cq377 sar_cnb5 sar_cnb6 3.976e-16
Cq378 sar_cnb5 sar_cnb7 5.494e-18
Cq379 sar_cnb5 vdd 6.807e-18
Cq380 sar_cnb5 vss 1.363e-15
Cq381 sar_cnb6 sar_cnb7 2.371e-16
Cq382 sar_cnb6 sar_obn 1.389e-19
Cq383 sar_cnb6 vdd 9.721e-18
Cq384 sar_cnb6 vss 1.495e-15
Cq385 sar_cnb7 vdd 5.712e-18
Cq386 sar_cnb7 vss 1.754e-15
Cq387 sar_cnb8 sar_cnb9 3.064e-16
Cq388 sar_cnb8 vdd 6.26e-18
Cq389 sar_cnb8 vss 1.7e-15
Cq390 sar_cnb9 vdd 6.26e-18
Cq391 sar_cnb9 vss 1.427e-15
Cq392 sar_cpa0 sar_cpa1 4.187e-16
Cq393 sar_cpa0 sar_mclk 4.832e-17
Cq394 sar_cpa0 vdd 5.391e-18
Cq395 sar_cpa0 vss 2.217e-15
Cq396 sar_cpa0 xckg_d0 3.136e-18
Cq397 sar_cpa1 sar_cpa2 2.361e-16
Cq398 sar_cpa1 sar_cpa3 1.221e-19
Cq399 sar_cpa1 sar_mclk 5.229e-17
Cq400 sar_cpa1 vdd 5.939e-18
Cq401 sar_cpa1 vss 1.785e-15
Cq402 sar_cpa1 xckg_d0 1.203e-18
Cq403 sar_cpa10 sar_cpa11 3.064e-16
Cq404 sar_cpa10 sar_cpa9 3.064e-16
Cq405 sar_cpa10 sar_mclk 5.238e-17
Cq406 sar_cpa10 vdd 4.844e-18
Cq407 sar_cpa10 vss 1.756e-15
Cq408 sar_cpa11 sar_cpa12 2.981e-16
Cq409 sar_cpa11 sar_mclk 5.273e-17
Cq410 sar_cpa11 vdd 5.939e-18
Cq411 sar_cpa11 vss 1.797e-15
Cq412 sar_cpa12 sar_mclk 5.273e-17
Cq413 sar_cpa12 vdd 5.939e-18
Cq414 sar_cpa12 vss 1.797e-15
Cq415 sar_cpa2 sar_cpa3 6.567e-19
Cq416 sar_cpa2 sar_mclk 4.997e-17
Cq417 sar_cpa2 vdd 5.391e-18
Cq418 sar_cpa2 vss 2.126e-15
Cq419 sar_cpa3 sar_cpa4 6.012e-16
Cq420 sar_cpa3 sar_cpa5 3.174e-19
Cq421 sar_cpa3 sar_mclk 4.094e-17
Cq422 sar_cpa3 vdd 8.305e-18
Cq423 sar_cpa3 vss 2.792e-15
Cq424 sar_cpa4 sar_cpa5 2.361e-16
Cq425 sar_cpa4 sar_mclk 5.014e-17
Cq426 sar_cpa4 vdd 5.939e-18
Cq427 sar_cpa4 vss 1.697e-15
Cq428 sar_cpa5 sar_cpa6 3.064e-16
Cq429 sar_cpa5 sar_mclk 5.316e-17
Cq430 sar_cpa5 vdd 5.391e-18
Cq431 sar_cpa5 vss 1.851e-15
Cq432 sar_cpa6 sar_cpa7 4.187e-16
Cq433 sar_cpa6 sar_mclk 5.151e-17
Cq434 sar_cpa6 vdd 5.391e-18
Cq435 sar_cpa6 vss 1.682e-15
Cq436 sar_cpa7 sar_mclk 5.35e-17
Cq437 sar_cpa7 vdd 5.939e-18
Cq438 sar_cpa7 vss 2e-15
Cq439 sar_cpa8 sar_cpa9 2.981e-16
Cq440 sar_cpa8 sar_mclk 5.454e-17
Cq441 sar_cpa8 vdd 5.939e-18
Cq442 sar_cpa8 vss 2.097e-15
Cq443 sar_cpa9 sar_mclk 5.273e-17
Cq444 sar_cpa9 vdd 5.939e-18
Cq445 sar_cpa9 vss 1.797e-15
Cq446 sar_cpb0 sar_cpb1 4.047e-16
Cq447 sar_cpb0 sar_cpb2 5.494e-18
Cq448 sar_cpb0 vdd 5.712e-18
Cq449 sar_cpb0 vss 1.612e-15
Cq450 sar_cpb1 sar_cpb2 2.289e-16
Cq451 sar_cpb1 sar_cpb3 4.295e-18
Cq452 sar_cpb1 vdd 8.551e-18
Cq453 sar_cpb1 vss 1.468e-15
Cq454 sar_cpb10 sar_cpb11 3.064e-16
Cq455 sar_cpb10 sar_cpb12 2.496e-19
Cq456 sar_cpb10 sar_cpb8 5.494e-18
Cq457 sar_cpb10 sar_cpb9 2.978e-16
Cq458 sar_cpb10 vdd 6.26e-18
Cq459 sar_cpb10 vss 1.418e-15
Cq460 sar_cpb11 sar_cpb12 2.879e-16
Cq461 sar_cpb11 sar_cpb9 2.496e-19
Cq462 sar_cpb11 vdd 6.26e-18
Cq463 sar_cpb11 vss 1.427e-15
Cq464 sar_cpb12 vdd 8.551e-18
Cq465 sar_cpb12 vss 1.483e-15
Cq466 sar_cpb2 sar_cpb3 7.915e-19
Cq467 sar_cpb2 vdd 6.807e-18
Cq468 sar_cpb2 vss 1.411e-15
Cq469 sar_cpb3 sar_cpb4 6.208e-16
Cq470 sar_cpb3 sar_cpb5 2.003e-19
Cq471 sar_cpb3 vdd 8.626e-18
Cq472 sar_cpb3 vss 1.109e-15
Cq473 sar_cpb4 sar_cpb5 2.289e-16
Cq474 sar_cpb4 vdd 8.551e-18
Cq475 sar_cpb4 vss 1.383e-15
Cq476 sar_cpb5 sar_cpb6 3.064e-16
Cq477 sar_cpb5 sar_cpb7 3.919e-19
Cq478 sar_cpb5 vdd 6.807e-18
Cq479 sar_cpb5 vss 1.507e-15
Cq480 sar_cpb6 sar_cpb7 4.047e-16
Cq481 sar_cpb6 vdd 5.712e-18
Cq482 sar_cpb6 vss 1.327e-15
Cq483 sar_cpb7 vdd 8.551e-18
Cq484 sar_cpb7 vss 1.678e-15
Cq485 sar_cpb8 sar_cpb9 2.879e-16
Cq486 sar_cpb8 vdd 6.26e-18
Cq487 sar_cpb8 vss 1.715e-15
Cq488 sar_cpb9 vdd 8.551e-18
Cq489 sar_cpb9 vss 1.484e-15
Cq490 sar_mclk sar_oan 4.849e-17
Cq491 sar_mclk sar_oann 5.047e-17
Cq492 sar_mclk sar_oanp 5.344e-17
Cq493 sar_mclk sar_oap 4.033e-17
Cq494 sar_mclk vdd 9.835e-16
Cq495 sar_mclk vss 5.569e-14
Cq496 sar_mclk xckg_d0 2.428e-16
Cq497 sar_mclk xckg_d1 2.372e-16
Cq498 sar_mclk xckg_d2 3.312e-16
Cq499 sar_mclk xckg_d3 2.272e-16
Cq500 sar_mclk xckg_nn 3.925e-16
Cq501 sar_mclk xckg_x 2.915e-16
Cq502 sar_oan vdd 5.939e-18
Cq503 sar_oan vss 1.46e-15
Cq504 sar_oann sar_oanp 4.187e-16
Cq505 sar_oann vdd 5.391e-18
Cq506 sar_oann vss 1.911e-15
Cq507 sar_oanp vdd 5.939e-18
Cq508 sar_oanp vss 2.018e-15
Cq509 sar_oap vdd 4.844e-18
Cq510 sar_oap vss 1.109e-15
Cq511 sar_obn sar_obp 1.052e-17
Cq512 sar_obn vdd 8.116e-18
Cq513 sar_obn vss 1.165e-15
Cq514 sar_obnn sar_obnp 4.047e-16
Cq515 sar_obnn vdd 5.712e-18
Cq516 sar_obnn vss 1.327e-15
Cq517 sar_obnp vdd 8.551e-18
Cq518 sar_obnp vss 1.678e-15
Cq519 sar_obp vdd 6.26e-18
Cq520 sar_obp vss 8.685e-16
Cq521 sar_trka0 sar_trka1 1.399e-16
Cq522 sar_trka0 vss 2.19e-15
Cq523 sar_trka1 vss 2.16e-15
Cq524 sar_trkb0 sar_trkb1 1.399e-16
Cq525 sar_trkb0 vdd 9.908e-17
Cq526 sar_trkb0 vss 1.928e-15
Cq527 sar_trkb1 vdd 5.712e-18
Cq528 sar_trkb1 vss 1.802e-15
Cq529 vbn vbp 2.899e-14
Cq530 vbn vdd 2.028e-15
Cq531 vbn vdda 5.091e-17
Cq532 vbn vref 1.786e-14
Cq533 vbn vref_in 4.127e-15
Cq534 vbn vrefl 2.52e-14
Cq535 vbn vss 1.155e-14
Cq536 vbn xref_na 7.746e-19
Cq537 vbn xref_ng 1.886e-15
Cq538 vbp vdd 1.803e-15
Cq539 vbp vdda 8.761e-15
Cq540 vbp vref 1.878e-14
Cq541 vbp vref_in 4.205e-15
Cq542 vbp vrefl 1.08e-14
Cq543 vbp vss 1.857e-14
Cq544 vbp xref_na 9.789e-18
Cq545 vbp xref_ng 2.371e-15
Cq546 vdd vdda 5.954e-16
Cq547 vdd vref 1.718e-13
Cq548 vdd vref_in 4.013e-14
Cq549 vdd vrefl 5.877e-14
Cq550 vdd vss 1.157e-13
Cq551 vdd xckg_d0 2.688e-16
Cq552 vdd xckg_d1 2.766e-16
Cq553 vdd xckg_d2 3.357e-16
Cq554 vdd xckg_d3 4.504e-16
Cq555 vdd xckg_nn 2.848e-18
Cq556 vdd xckg_x 4.879e-16
Cq557 vdd xref_ng 2.468e-14
Cq558 vdda vref 4.398e-14
Cq559 vdda vref_in 3.223e-16
Cq560 vdda vrefl 2.519e-14
Cq561 vdda vss 3.507e-14
Cq562 vdda xref_na 1.249e-15
Cq563 vdda xref_ng 2.299e-14
Cq564 vdda xref_ntl 9.96e-18
Cq565 vref vref_in 4.54e-14
Cq566 vref vrefl 1.67e-13
Cq567 vref vss 3.743e-13
Cq568 vref xref_na 1.322e-16
Cq569 vref xref_ng 4.971e-14
Cq570 vref xref_ntl 1.685e-15
Cq571 vref_in vrefl 3.08e-14
Cq572 vref_in vss 9.388e-14
Cq573 vref_in xref_na 4.042e-16
Cq574 vref_in xref_ng 3.421e-15
Cq575 vref_in xref_ntl 1.606e-15
Cq576 vrefl vss 1.926e-13
Cq577 vrefl xref_na 1.039e-16
Cq578 vrefl xref_ng 3.178e-14
Cq579 vrefl xref_ntl 2.185e-15
Cq580 vss xckg_d0 5.11e-15
Cq581 vss xckg_d1 4.339e-15
Cq582 vss xckg_d2 6.346e-15
Cq583 vss xckg_d3 8.13e-15
Cq584 vss xckg_nn 1.937e-15
Cq585 vss xckg_x 6.625e-15
Cq586 vss xref_na 4.437e-15
Cq587 vss xref_ng 8.769e-14
Cq588 vss xref_ntl 3.71e-15
Cq589 xckg_d0 xckg_d1 3.909e-15
Cq590 xckg_d0 xckg_d2 1.218e-15
Cq591 xckg_d0 xckg_d3 1.494e-17
Cq592 xckg_d0 xckg_nn 5.565e-16
Cq593 xckg_d0 xckg_x 4.057e-17
Cq594 xckg_d1 xckg_d2 3.755e-15
Cq595 xckg_d1 xckg_d3 3.433e-17
Cq596 xckg_d1 xckg_nn 6.939e-18
Cq597 xckg_d1 xckg_x 1.218e-17
Cq598 xckg_d2 xckg_d3 6.227e-16
Cq599 xckg_d2 xckg_nn 1.283e-16
Cq600 xckg_d2 xckg_x 1.227e-16
Cq601 xckg_d3 xckg_nn 3.139e-18
Cq602 xckg_d3 xckg_x 4.209e-15
Cq603 xckg_nn xckg_x 6.716e-17
Cq604 xref_na xref_ng 2.554e-15
Cq605 xref_na xref_ntl 2.584e-16
Cq606 xref_ng xref_ntl 2.12e-15
.ends
.subckt r1_adc_lay_sar adc_hold is_smp clk adc_start adc_sel adc_valid_a adc_raw_a_0 adc_raw_a_1 adc_raw_a_2 adc_raw_a_3 adc_raw_a_4 adc_raw_a_5 adc_raw_a_6 adc_raw_a_7 adc_raw_a_8 adc_raw_a_9 adc_raw_a_10 adc_raw_a_11 adc_raw_a_12 adc_raw_a_13 adc_valid_b adc_raw_b_0 adc_raw_b_1 adc_raw_b_2 adc_raw_b_3 adc_raw_b_4 adc_raw_b_5 adc_raw_b_6 adc_raw_b_7 adc_raw_b_8 adc_raw_b_9 adc_raw_b_10 adc_raw_b_11 adc_raw_b_12 adc_raw_b_13 por_n ain_sin_p ain_sin_n ain_cos_p ain_cos_n vcm2 ibias ain_isa_p ain_isa_n ain_isb_p ain_isb_n vcm vdda vdd vss vref_in topap topan topbp topbn sar_clka sar_clkab sar_clkb sar_clkbb sar_clkna sar_clknab sar_clknb sar_clknbb sar_cna0 sar_cna1 sar_cna10 sar_cna11 sar_cna12 sar_cna2 sar_cna3 sar_cna4 sar_cna5 sar_cna6 sar_cna7 sar_cna8 sar_cna9 sar_cnb0 sar_cnb1 sar_cnb10 sar_cnb11 sar_cnb12 sar_cnb2 sar_cnb3 sar_cnb4 sar_cnb5 sar_cnb6 sar_cnb7 sar_cnb8 sar_cnb9 sar_cpa0 sar_cpa1 sar_cpa10 sar_cpa11 sar_cpa12 sar_cpa2 sar_cpa3 sar_cpa4 sar_cpa5 sar_cpa6 sar_cpa7 sar_cpa8 sar_cpa9 sar_cpb0 sar_cpb1 sar_cpb10 sar_cpb11 sar_cpb12 sar_cpb2 sar_cpb3 sar_cpb4 sar_cpb5 sar_cpb6 sar_cpb7 sar_cpb8 sar_cpb9 sar_oan sar_oann sar_oanp sar_oap sar_obn sar_obnn sar_obnp sar_obp sar_trka0 sar_trka1 sar_trkb0 sar_trkb1 sar_mclk vref vrefl vdd_sar vss_sar
Rsar_vdd vdd_sar vdd__p11 1m
Rsar_vss vss_sar vss__p22 1m
Xxckg_xpd0 xckg_d0__p1 clk vdd__p2 vdd sg13_lv_pmos w=1u l=0.5u ng=1 m=1
Xxckg_xnd0 xckg_d0 clk vss__p9 vss sg13_lv_nmos w=0.5u l=0.5u ng=1 m=1
Xxckg_cd0 xckg_d0__p2 vss__p16 cap_cmim w=2.53u l=2.53u m=1
Xxckg_xpd1 xckg_d1__p1 xckg_d0 vdd__p3 vdd sg13_lv_pmos w=1u l=0.5u ng=1 m=1
Xxckg_xnd1 xckg_d1 xckg_d0 vss__p10 vss sg13_lv_nmos w=0.5u l=0.5u ng=1 m=1
Xxckg_cd1 xckg_d1__p2 vss__p17 cap_cmim w=2.53u l=2.53u m=1
Xxckg_xpd2 xckg_d2__p1 xckg_d1 vdd__p4 vdd sg13_lv_pmos w=1u l=0.5u ng=1 m=1
Xxckg_xnd2 xckg_d2 xckg_d1 vss__p11 vss sg13_lv_nmos w=0.5u l=0.5u ng=1 m=1
Xxckg_cd2 xckg_d2__p2 vss__p18 cap_cmim w=2.53u l=2.53u m=1
Xxckg_xpd3 xckg_d3__p1 xckg_d2 vdd__p5 vdd sg13_lv_pmos w=1u l=0.5u ng=1 m=1
Xxckg_xnd3 xckg_d3 xckg_d2 vss__p12 vss sg13_lv_nmos w=0.5u l=0.5u ng=1 m=1
Xxckg_cd3 xckg_d3__p2 vss__p19 cap_cmim w=2.53u l=2.53u m=1
Xxckg_xpd4 xckg_x__p2 xckg_d3 vdd__p6 vdd sg13_lv_pmos w=1u l=0.5u ng=1 m=1
Xxckg_xnd4 xckg_x xckg_d3 vss__p13 vss sg13_lv_nmos w=0.5u l=0.5u ng=1 m=1
Xxckg_cd4 xckg_x__p4 vss__p20 cap_cmim w=2.53u l=2.53u m=1
Xxckg_xpa sar_mclk__p2 clk__p1 vdd__p7 vdd sg13_lv_pmos w=2u l=0.13u ng=1 m=1
Xxckg_xpb sar_mclk__p3 xckg_x__p3 vdd__p8 vdd sg13_lv_pmos w=2u l=0.13u ng=1 m=1
Xxckg_xna sar_mclk__p0 clk__p0 xckg_nn vss sg13_lv_nmos w=2u l=0.13u ng=1 m=1
Xxckg_xnb xckg_nn__p1 xckg_x__p1 vss__p14 vss sg13_lv_nmos w=2u l=0.13u ng=1 m=1
Xxckg_xpi mclkb__p1 sar_mclk__p4 vdd__p9 vdd sg13_lv_pmos w=2u l=0.13u ng=1 m=1
Xxckg_xni mclkb sar_mclk__p1 vss__p15 vss sg13_lv_nmos w=1u l=0.13u ng=1 m=1
Xxcbias_xmbd vbp__p1 vbp vdd__p1 vdd sg13_lv_pmos w=0.8u l=0.5u ng=1 m=1
Xxcbias_xrb_g0 vbp xcbias_xrb_s1 vss rppd w=1u l=40u m=1 b=0
Xxcbias_xrb_g1 xcbias_xrb_s1 xcbias_xrb_s2 vss rppd w=1u l=40u m=1 b=0
Xxcbias_xrb_g2 xcbias_xrb_s2 xcbias_xrb_s3 vss rppd w=1u l=40u m=1 b=0
Xxcbias_xrb_g3 xcbias_xrb_s3 vss__p7 vss rppd w=1u l=40u m=1 b=0
Xxcbiasn_xmbd vbn__p1 vbn vss__p8 vss sg13_lv_nmos w=0.2u l=0.5u ng=1 m=1
Xxcbiasn_xrb_g0 vdd__p0 xcbiasn_xrb_s1 vss rppd w=1u l=40u m=1 b=0
Xxcbiasn_xrb_g1 xcbiasn_xrb_s1 xcbiasn_xrb_s2 vss rppd w=1u l=40u m=1 b=0
Xxcbiasn_xrb_g2 xcbiasn_xrb_s2 xcbiasn_xrb_s3 vss rppd w=1u l=40u m=1 b=0
Xxcbiasn_xrb_g3 xcbiasn_xrb_s3 vbn vss rppd w=1u l=40u m=1 b=0
Xxref_xmb0 ibias__p0 ibias vss__p5 vss sg13_hv_nmos w=2u l=1u ng=1 m=1
Xxref_xmt xref_ntl ibias vss__p6 vss sg13_hv_nmos w=2u l=8u ng=1 m=1
Xxref_xm1 xref_na vref_in xref_ntl__p1 vss sg13_hv_nmos w=10u l=1u ng=2 m=1
Xxref_xm2 xref_ng vref xref_ntl__p2 vss sg13_hv_nmos w=10u l=1u ng=2 m=1
Xxref_xm3 xref_na__p1 xref_na vdda__p5 vdda sg13_hv_pmos w=4u l=1u ng=1 m=1
Xxref_xm4 xref_ng__p1 xref_na vdda__p6 vdda sg13_hv_pmos w=4u l=1u ng=1 m=1
Xxref_xcg_u0 vss xref_ng__p2 cap_cmim w=26.32u l=95u m=1
Xxref_xmsf_s0 vdda__p1 xref_ng vref vss sg13_hv_nmos w=80u l=0.45u ng=32 m=1
Xxref_xmsf_s1 vdda__p2 xref_ng vref__p5 vss sg13_hv_nmos w=80u l=0.45u ng=32 m=1
Xxref_xmsf_s2 vdda__p3 xref_ng vref__p6 vss sg13_hv_nmos w=80u l=0.45u ng=32 m=1
Xxref_xmsf_s3 vdda__p4 xref_ng vref__p7 vss sg13_hv_nmos w=80u l=0.45u ng=32 m=1
Xxref_xmib_s0 vref__p0 ibias vss__p0 vss sg13_hv_nmos w=80u l=1u ng=40 m=1
Xxref_xmib_s1 vref__p1 ibias vss__p1 vss sg13_hv_nmos w=80u l=1u ng=40 m=1
Xxref_xmib_s2 vref__p2 ibias vss__p2 vss sg13_hv_nmos w=80u l=1u ng=40 m=1
Xxref_xmib_s3 vref__p3 ibias vss__p3 vss sg13_hv_nmos w=80u l=1u ng=40 m=1
Xxref_xcd_u0 vss vref__p8 cap_cmim w=51.58u l=95u m=1
Xxref_xcd_u1 vss vref__p9 cap_cmim w=51.58u l=95u m=1
Xxref_xcd_u2 vss vref__p10 cap_cmim w=51.58u l=95u m=1
Xxref_xcd_u3 vss vref__p11 cap_cmim w=51.58u l=95u m=1
Xxref_xmsfl_s0 vdda__p0 xref_ng vrefl vss sg13_hv_nmos w=80u l=0.45u ng=32 m=1
Xxref_xmibl_s0 vrefl__p0 ibias vss__p4 vss sg13_hv_nmos w=80u l=1u ng=40 m=1
Xxref_xcdl_u0 vss vrefl__p2 cap_cmim w=51.58u l=95u m=1
Xxref_xcdl_u1 vss vrefl__p3 cap_cmim w=51.58u l=95u m=1
Xxfilt_xcf_u0 vss vref_in__p1 cap_cmim w=37.36u l=90u m=1
Xxfilt_xcf_u1 vss vref_in__p2 cap_cmim w=37.36u l=90u m=1
Xslice_a ain_sin_p__p1 ain_sin_n__p1 ain_isa_p__p1 ain_isa_n__p1 sar_trka0__p1 sar_trka1__p1 sar_cpa0__p1 sar_cpa1__p1 sar_cpa2__p1 sar_cpa3__p1 sar_cpa4__p1 sar_cpa5__p1 sar_cpa6__p1 sar_cpa7__p1 sar_cpa8__p1 sar_cpa9__p1 sar_cpa10__p1 sar_cpa11__p1 sar_cpa12__p1 sar_cna0__p1 sar_cna1__p1 sar_cna2__p1 sar_cna3__p1 sar_cna4__p1 sar_cna5__p1 sar_cna6__p1 sar_cna7__p1 sar_cna8__p1 sar_cna9__p1 sar_cna10__p1 sar_cna11__p1 sar_cna12__p1 sar_clka__p1 sar_clkab__p1 sar_clkna__p1 sar_clknab__p1 sar_oap__p1 sar_oan__p1 sar_oanp__p1 sar_oann__p1 vbp__p2 vbn__p2 sp_vref__p12_a sp_vref__p13_a sp_vref__p14_a sp_vrefl__p4_a sp_vrefl__p5_a topap topan vdd__p12 vdd__p13 vdd__p14 vdd__p15 xslice_a_gnd_nc0 vss__p23 xslice_a_gnd_nc2 vss__p24 xslice_a_gnd_nc4 vss__p25 xslice_a_gnd_nc6 vss__p26 r1_adc_slice_post
Vsp_vref__p12_a sp_vref__p12_a 0 DC 1.049761
Vsp_vref__p13_a sp_vref__p13_a 0 DC 1.049761
Vsp_vref__p14_a sp_vref__p14_a 0 DC 1.049761
Vsp_vrefl__p4_a sp_vrefl__p4_a 0 DC 1.058123
Vsp_vrefl__p5_a sp_vrefl__p5_a 0 DC 1.058142
Xslice_b ain_cos_p__p1 ain_cos_n__p1 ain_isb_p__p1 ain_isb_n__p1 sar_trkb0__p1 sar_trkb1__p1 sar_cpb0__p1 sar_cpb1__p1 sar_cpb2__p1 sar_cpb3__p1 sar_cpb4__p1 sar_cpb5__p1 sar_cpb6__p1 sar_cpb7__p1 sar_cpb8__p1 sar_cpb9__p1 sar_cpb10__p1 sar_cpb11__p1 sar_cpb12__p1 sar_cnb0__p1 sar_cnb1__p1 sar_cnb2__p1 sar_cnb3__p1 sar_cnb4__p1 sar_cnb5__p1 sar_cnb6__p1 sar_cnb7__p1 sar_cnb8__p1 sar_cnb9__p1 sar_cnb10__p1 sar_cnb11__p1 sar_cnb12__p1 sar_clkb__p1 sar_clkbb__p1 sar_clknb__p1 sar_clknbb__p1 sar_obp__p1 sar_obn__p1 sar_obnp__p1 sar_obnn__p1 vbp__p3 vbn__p3 sp_vref__p15_b sp_vref__p16_b sp_vref__p17_b sp_vrefl__p6_b sp_vrefl__p7_b topbp topbn vdd__p16 vdd__p17 vdd__p18 vdd__p19 vss__p27 xslice_b_gnd_nc1 vss__p28 xslice_b_gnd_nc3 vss__p29 xslice_b_gnd_nc5 vss__p30 xslice_b_gnd_nc7 r1_adc_slice_post
Vsp_vref__p15_b sp_vref__p15_b 0 DC 1.049738
Vsp_vref__p16_b sp_vref__p16_b 0 DC 1.049738
Vsp_vref__p17_b sp_vref__p17_b 0 DC 1.049738
Vsp_vrefl__p6_b sp_vrefl__p6_b 0 DC 1.058302
Vsp_vrefl__p7_b sp_vrefl__p7_b 0 DC 1.058302
Rt0 ain_cos_n ain_cos_n__p1 126.828
Rt1 ain_cos_p ain_cos_p__p1 128.647
Rt2 ain_isa_n ain_isa_n__p1 127.972
Rt3 ain_isa_p ain_isa_p__p1 129.791
Rt4 ain_isb_n ain_isb_n__p1 0.198
Rt5 ain_isb_p ain_isb_p__p1 0.198
Rt6 ain_sin_n ain_sin_n__p1 0.308
Rt7 ain_sin_p ain_sin_p__p1 0.308
Rt8 clk clk__p0 141.519
Rt9 clk clk__p1 195.072
Rt10 clk__p0 clk__p1 49.582
Rt11 ibias ibias__p0 200.561
Rt12 mclkb mclkb__p1 43.3194
Rt13 sar_clka sar_clka__p1 12.3244
Rt14 sar_clkab sar_clkab__p1 12.3303
Rt15 sar_clkb sar_clkb__p1 12.498
Rt16 sar_clkbb sar_clkbb__p1 12.3244
Rt17 sar_clkna sar_clkna__p1 12.3244
Rt18 sar_clknab sar_clknab__p1 12.322
Rt19 sar_clknb sar_clknb__p1 12.3303
Rt20 sar_clknbb sar_clknbb__p1 12.3303
Rt21 sar_cna0 sar_cna0__p1 12.3244
Rt22 sar_cna1 sar_cna1__p1 12.3303
Rt23 sar_cna10 sar_cna10__p1 12.3244
Rt24 sar_cna11 sar_cna11__p1 12.3244
Rt25 sar_cna12 sar_cna12__p1 12.322
Rt26 sar_cna2 sar_cna2__p1 12.3303
Rt27 sar_cna3 sar_cna3__p1 12.3244
Rt28 sar_cna4 sar_cna4__p1 12.3303
Rt29 sar_cna5 sar_cna5__p1 12.3303
Rt30 sar_cna6 sar_cna6__p1 12.3244
Rt31 sar_cna7 sar_cna7__p1 12.3303
Rt32 sar_cna8 sar_cna8__p1 12.3244
Rt33 sar_cna9 sar_cna9__p1 12.322
Rt34 sar_cnb0 sar_cnb0__p1 12.498
Rt35 sar_cnb1 sar_cnb1__p1 12.322
Rt36 sar_cnb10 sar_cnb10__p1 12.498
Rt37 sar_cnb11 sar_cnb11__p1 12.3303
Rt38 sar_cnb12 sar_cnb12__p1 12.3303
Rt39 sar_cnb2 sar_cnb2__p1 12.3244
Rt40 sar_cnb3 sar_cnb3__p1 12.498
Rt41 sar_cnb4 sar_cnb4__p1 12.322
Rt42 sar_cnb5 sar_cnb5__p1 12.3244
Rt43 sar_cnb6 sar_cnb6__p1 12.498
Rt44 sar_cnb7 sar_cnb7__p1 12.322
Rt45 sar_cnb8 sar_cnb8__p1 12.3303
Rt46 sar_cnb9 sar_cnb9__p1 12.3303
Rt47 sar_cpa0 sar_cpa0__p1 12.3303
Rt48 sar_cpa1 sar_cpa1__p1 12.3244
Rt49 sar_cpa10 sar_cpa10__p1 12.322
Rt50 sar_cpa11 sar_cpa11__p1 12.3244
Rt51 sar_cpa12 sar_cpa12__p1 12.3244
Rt52 sar_cpa2 sar_cpa2__p1 12.3303
Rt53 sar_cpa3 sar_cpa3__p1 12.7425
Rt54 sar_cpa4 sar_cpa4__p1 12.3244
Rt55 sar_cpa5 sar_cpa5__p1 12.3303
Rt56 sar_cpa6 sar_cpa6__p1 12.3303
Rt57 sar_cpa7 sar_cpa7__p1 12.3244
Rt58 sar_cpa8 sar_cpa8__p1 12.3244
Rt59 sar_cpa9 sar_cpa9__p1 12.3244
Rt60 sar_cpb0 sar_cpb0__p1 12.322
Rt61 sar_cpb1 sar_cpb1__p1 12.498
Rt62 sar_cpb10 sar_cpb10__p1 12.3303
Rt63 sar_cpb11 sar_cpb11__p1 12.3303
Rt64 sar_cpb12 sar_cpb12__p1 12.498
Rt65 sar_cpb2 sar_cpb2__p1 12.3244
Rt66 sar_cpb3 sar_cpb3__p1 12.759
Rt67 sar_cpb4 sar_cpb4__p1 12.498
Rt68 sar_cpb5 sar_cpb5__p1 12.3244
Rt69 sar_cpb6 sar_cpb6__p1 12.322
Rt70 sar_cpb7 sar_cpb7__p1 12.498
Rt71 sar_cpb8 sar_cpb8__p1 12.3303
Rt72 sar_cpb9 sar_cpb9__p1 12.498
Rt73 sar_mclk sar_mclk__p0 170.374
Rt74 sar_mclk sar_mclk__p1 196.812
Rt75 sar_mclk sar_mclk__p2 307.715
Rt76 sar_mclk sar_mclk__p4 333.321
Rt77 sar_mclk__p0 sar_mclk__p1 70.5716
Rt78 sar_mclk__p0 sar_mclk__p2 110.338
Rt79 sar_mclk__p0 sar_mclk__p4 119.52
Rt80 sar_mclk__p1 sar_mclk__p2 101.952
Rt81 sar_mclk__p1 sar_mclk__p4 110.436
Rt82 sar_mclk__p2 sar_mclk__p3 0.6204
Rt83 sar_mclk__p2 sar_mclk__p4 64.7625
Rt84 sar_oan sar_oan__p1 12.3244
Rt85 sar_oann sar_oann__p1 12.3303
Rt86 sar_oanp sar_oanp__p1 12.3244
Rt87 sar_oap sar_oap__p1 12.322
Rt88 sar_obn sar_obn__p1 12.5344
Rt89 sar_obnn sar_obnn__p1 12.322
Rt90 sar_obnp sar_obnp__p1 12.498
Rt91 sar_obp sar_obp__p1 12.3303
Rt92 sar_trka0 sar_trka0__p1 12.3303
Rt93 sar_trka1 sar_trka1__p1 12.3303
Rt94 sar_trkb0 sar_trkb0__p1 12.3244
Rt95 sar_trkb1 sar_trkb1__p1 12.322
Rt96 vbn vbn__p1 68.8436
Rt97 vbn vbn__p2 240.016
Rt98 vbn vbn__p3 784.574
Rt99 vbn__p1 vbn__p2 217.489
Rt100 vbn__p1 vbn__p3 710.938
Rt101 vbn__p2 vbn__p3 168.032
Rt102 vbp vbp__p1 73.6975
Rt103 vbp vbp__p2 245.763
Rt104 vbp vbp__p3 1260.46
Rt105 vbp__p1 vbp__p2 195.517
Rt106 vbp__p1 vbp__p3 1002.76
Rt107 vbp__p2 vbp__p3 154.24
Rt108 vdd vdd__p0 34389.1
Rt109 vdd vdd__p1 40943
Rt110 vdd vdd__p11 68132.9
Rt111 vdd vdd__p12 82.2115
Rt112 vdd vdd__p13 11.0679
Rt113 vdd vdd__p14 29.2479
Rt114 vdd vdd__p15 437.715
Rt115 vdd vdd__p16 3424.56
Rt116 vdd vdd__p17 42939.2
Rt117 vdd vdd__p18 786782
Rt118 vdd__p0 vdd__p1 119.607
Rt119 vdd__p0 vdd__p12 99.6158
Rt120 vdd__p0 vdd__p13 288.609
Rt121 vdd__p0 vdd__p14 7716.14
Rt122 vdd__p0 vdd__p15 115478
Rt123 vdd__p0 vdd__p16 903464
Rt124 vdd__p1 vdd__p12 118.601
Rt125 vdd__p1 vdd__p13 343.612
Rt126 vdd__p1 vdd__p14 9186.68
Rt127 vdd__p1 vdd__p15 137485
Rt128 vdd__p11 vdd__p12 42970.9
Rt129 vdd__p11 vdd__p13 5785.07
Rt130 vdd__p11 vdd__p14 90.208
Rt131 vdd__p11 vdd__p15 12.7553
Rt132 vdd__p11 vdd__p16 14.0525
Rt133 vdd__p11 vdd__p17 160.888
Rt134 vdd__p11 vdd__p18 2947.98
Rt135 vdd__p11 vdd__p19 40686.4
Rt136 vdd__p11 vdd__p2 463.671
Rt137 vdd__p11 vdd__p3 424.895
Rt138 vdd__p11 vdd__p4 361.688
Rt139 vdd__p11 vdd__p5 291.702
Rt140 vdd__p11 vdd__p6 227.058
Rt141 vdd__p11 vdd__p7 29.9714
Rt142 vdd__p11 vdd__p8 158.698
Rt143 vdd__p11 vdd__p9 29.2186
Rt144 vdd__p12 vdd__p13 0.697261
Rt145 vdd__p12 vdd__p14 18.4464
Rt146 vdd__p12 vdd__p15 276.063
Rt147 vdd__p12 vdd__p16 2159.85
Rt148 vdd__p12 vdd__p17 27081.4
Rt149 vdd__p12 vdd__p18 496217
Rt150 vdd__p13 vdd__p14 2.48339
Rt151 vdd__p13 vdd__p15 37.1657
Rt152 vdd__p13 vdd__p16 290.775
Rt153 vdd__p13 vdd__p17 3645.91
Rt154 vdd__p13 vdd__p18 66804.5
Rt155 vdd__p13 vdd__p19 922000
Rt156 vdd__p13 vdd__p6 939934
Rt157 vdd__p13 vdd__p7 180555
Rt158 vdd__p13 vdd__p8 656946
Rt159 vdd__p13 vdd__p9 176021
Rt160 vdd__p14 vdd__p15 0.527112
Rt161 vdd__p14 vdd__p16 4.53412
Rt162 vdd__p14 vdd__p17 56.8516
Rt163 vdd__p14 vdd__p18 1041.7
Rt164 vdd__p14 vdd__p19 14377
Rt165 vdd__p14 vdd__p2 29930
Rt166 vdd__p14 vdd__p3 27427
Rt167 vdd__p14 vdd__p4 23347
Rt168 vdd__p14 vdd__p5 18829.3
Rt169 vdd__p14 vdd__p6 14656.6
Rt170 vdd__p14 vdd__p7 2815.45
Rt171 vdd__p14 vdd__p8 10243.9
Rt172 vdd__p14 vdd__p9 2744.73
Rt173 vdd__p15 vdd__p16 0.372867
Rt174 vdd__p15 vdd__p17 7.12045
Rt175 vdd__p15 vdd__p18 130.469
Rt176 vdd__p15 vdd__p19 1800.66
Rt177 vdd__p15 vdd__p2 4232.07
Rt178 vdd__p15 vdd__p3 3878.14
Rt179 vdd__p15 vdd__p4 3301.24
Rt180 vdd__p15 vdd__p5 2662.45
Rt181 vdd__p15 vdd__p6 2072.43
Rt182 vdd__p15 vdd__p7 398.102
Rt183 vdd__p15 vdd__p8 1448.48
Rt184 vdd__p15 vdd__p9 388.103
Rt185 vdd__p16 vdd__p17 0.804871
Rt186 vdd__p16 vdd__p18 14.9541
Rt187 vdd__p16 vdd__p19 206.388
Rt188 vdd__p16 vdd__p2 4662.44
Rt189 vdd__p16 vdd__p3 4272.53
Rt190 vdd__p16 vdd__p4 3636.95
Rt191 vdd__p16 vdd__p5 2933.2
Rt192 vdd__p16 vdd__p6 2283.19
Rt193 vdd__p16 vdd__p7 438.586
Rt194 vdd__p16 vdd__p8 1595.78
Rt195 vdd__p16 vdd__p9 427.57
Rt196 vdd__p17 vdd__p18 2.61782
Rt197 vdd__p17 vdd__p19 36.1298
Rt198 vdd__p17 vdd__p2 53380.8
Rt199 vdd__p17 vdd__p3 48916.6
Rt200 vdd__p17 vdd__p4 41639.9
Rt201 vdd__p17 vdd__p5 33582.6
Rt202 vdd__p17 vdd__p6 26140.5
Rt203 vdd__p17 vdd__p7 5021.42
Rt204 vdd__p17 vdd__p8 18270.3
Rt205 vdd__p17 vdd__p9 4895.3
Rt206 vdd__p18 vdd__p19 0.487307
Rt207 vdd__p18 vdd__p2 978105
Rt208 vdd__p18 vdd__p3 896307
Rt209 vdd__p18 vdd__p4 762974
Rt210 vdd__p18 vdd__p5 615339
Rt211 vdd__p18 vdd__p6 478976
Rt212 vdd__p18 vdd__p7 92008.3
Rt213 vdd__p18 vdd__p8 334770
Rt214 vdd__p18 vdd__p9 89697.3
Rt215 vdd__p2 vdd__p3 88.2674
Rt216 vdd__p2 vdd__p4 114.618
Rt217 vdd__p2 vdd__p5 144.634
Rt218 vdd__p2 vdd__p6 174.434
Rt219 vdd__p2 vdd__p7 14471.4
Rt220 vdd__p2 vdd__p8 225.153
Rt221 vdd__p2 vdd__p9 14108
Rt222 vdd__p3 vdd__p4 105.033
Rt223 vdd__p3 vdd__p5 132.538
Rt224 vdd__p3 vdd__p6 159.846
Rt225 vdd__p3 vdd__p7 13261.2
Rt226 vdd__p3 vdd__p8 206.324
Rt227 vdd__p3 vdd__p9 12928.1
Rt228 vdd__p4 vdd__p5 112.822
Rt229 vdd__p4 vdd__p6 136.068
Rt230 vdd__p4 vdd__p7 11288.5
Rt231 vdd__p4 vdd__p8 175.631
Rt232 vdd__p4 vdd__p9 11005
Rt233 vdd__p5 vdd__p6 109.739
Rt234 vdd__p5 vdd__p7 9104.19
Rt235 vdd__p5 vdd__p8 141.647
Rt236 vdd__p5 vdd__p9 8875.52
Rt237 vdd__p6 vdd__p7 7086.64
Rt238 vdd__p6 vdd__p8 110.257
Rt239 vdd__p6 vdd__p9 6908.64
Rt240 vdd__p7 vdd__p8 4953.05
Rt241 vdd__p7 vdd__p9 574.85
Rt242 vdd__p8 vdd__p9 4828.65
Rt243 vdda vdda__p1 41.3489
Rt244 vdda vdda__p2 278.578
Rt245 vdda vdda__p3 56.012
Rt246 vdda vdda__p5 261.48
Rt247 vdda vdda__p6 203.591
Rt248 vdda__p0 vdda__p3 62.8025
Rt249 vdda__p0 vdda__p4 67.5999
Rt250 vdda__p1 vdda__p2 1202.37
Rt251 vdda__p1 vdda__p3 241.754
Rt252 vdda__p1 vdda__p5 1128.58
Rt253 vdda__p1 vdda__p6 878.722
Rt254 vdda__p2 vdda__p3 256.165
Rt255 vdda__p2 vdda__p5 63.6193
Rt256 vdda__p2 vdda__p6 79.0683
Rt257 vdda__p3 vdda__p4 23.0314
Rt258 vdda__p3 vdda__p5 240.442
Rt259 vdda__p3 vdda__p6 187.211
Rt260 vdda__p5 vdda__p6 74.2153
Rt261 vref vref__p0 114.65
Rt262 vref vref__p1 6.10169
Rt263 vref vref__p10 186.142
Rt264 vref vref__p11 8271.36
Rt265 vref vref__p12 1487.93
Rt266 vref vref__p13 808.459
Rt267 vref vref__p14 372.871
Rt268 vref vref__p15 1459.54
Rt269 vref vref__p16 3157.02
Rt270 vref vref__p17 5801
Rt271 vref vref__p2 370.329
Rt272 vref vref__p3 10248.9
Rt273 vref vref__p5 428.96
Rt274 vref vref__p6 1135.72
Rt275 vref vref__p7 3138.93
Rt276 vref vref__p8 2223.31
Rt277 vref vref__p9 50.9452
Rt278 vref__p0 vref__p1 5.08178
Rt279 vref__p0 vref__p10 1372.92
Rt280 vref__p0 vref__p11 61005.8
Rt281 vref__p0 vref__p12 11330.2
Rt282 vref__p0 vref__p13 6156.32
Rt283 vref__p0 vref__p14 2839.43
Rt284 vref__p0 vref__p15 10764.9
Rt285 vref__p0 vref__p16 23284.7
Rt286 vref__p0 vref__p17 42785.5
Rt287 vref__p0 vref__p2 2151.06
Rt288 vref__p0 vref__p3 74645.3
Rt289 vref__p0 vref__p5 1782.68
Rt290 vref__p0 vref__p6 6979.82
Rt291 vref__p0 vref__p7 23027.9
Rt292 vref__p0 vref__p8 16928.7
Rt293 vref__p0 vref__p9 387.793
Rt294 vref__p1 vref__p10 27.2286
Rt295 vref__p1 vref__p11 1209.68
Rt296 vref__p1 vref__p12 366.189
Rt297 vref__p1 vref__p13 199.066
Rt298 vref__p1 vref__p14 91.8501
Rt299 vref__p1 vref__p15 213.441
Rt300 vref__p1 vref__p16 461.684
Rt301 vref__p1 vref__p17 848.354
Rt302 vref__p1 vref__p2 8.38761
Rt303 vref__p1 vref__p3 1193.26
Rt304 vref__p1 vref__p5 6.38445
Rt305 vref__p1 vref__p6 32.923
Rt306 vref__p1 vref__p7 414.228
Rt307 vref__p1 vref__p8 546.455
Rt308 vref__p1 vref__p9 12.4499
Rt309 vref__p10 vref__p11 1.96723
Rt310 vref__p10 vref__p12 390.352
Rt311 vref__p10 vref__p13 212.377
Rt312 vref__p10 vref__p14 98.0606
Rt313 vref__p10 vref__p15 1.88326
Rt314 vref__p10 vref__p16 2.58285
Rt315 vref__p10 vref__p17 2.96452
Rt316 vref__p10 vref__p2 13.5031
Rt317 vref__p10 vref__p3 151.839
Rt318 vref__p10 vref__p5 105.826
Rt319 vref__p10 vref__p6 71.6163
Rt320 vref__p10 vref__p7 45.7002
Rt321 vref__p10 vref__p8 581.257
Rt322 vref__p10 vref__p9 13.1189
Rt323 vref__p11 vref__p12 17345.9
Rt324 vref__p11 vref__p13 9437.27
Rt325 vref__p11 vref__p14 4357.47
Rt326 vref__p11 vref__p15 11.7242
Rt327 vref__p11 vref__p16 6.70636
Rt328 vref__p11 vref__p17 3.30899
Rt329 vref__p11 vref__p2 588.996
Rt330 vref__p11 vref__p3 6559.22
Rt331 vref__p11 vref__p5 4701.78
Rt332 vref__p11 vref__p6 3179.28
Rt333 vref__p11 vref__p7 1973.95
Rt334 vref__p11 vref__p8 25829
Rt335 vref__p11 vref__p9 582.958
Rt336 vref__p12 vref__p13 2.76051
Rt337 vref__p12 vref__p14 5.69068
Rt338 vref__p12 vref__p15 3060.82
Rt339 vref__p12 vref__p16 6620.62
Rt340 vref__p12 vref__p17 12165.3
Rt341 vref__p12 vref__p2 961.871
Rt342 vref__p12 vref__p3 21690.6
Rt343 vref__p12 vref__p5 2025.57
Rt344 vref__p12 vref__p6 2781.47
Rt345 vref__p12 vref__p7 6608.37
Rt346 vref__p12 vref__p8 3.41549
Rt347 vref__p12 vref__p9 2.8795
Rt348 vref__p13 vref__p14 2.76481
Rt349 vref__p13 vref__p15 1665.29
Rt350 vref__p13 vref__p16 3602.05
Rt351 vref__p13 vref__p17 6618.72
Rt352 vref__p13 vref__p2 523.306
Rt353 vref__p13 vref__p3 11801.1
Rt354 vref__p13 vref__p5 1101.86
Rt355 vref__p13 vref__p6 1513.26
Rt356 vref__p13 vref__p7 3595.37
Rt357 vref__p13 vref__p8 6.9687
Rt358 vref__p13 vref__p9 2.56608
Rt359 vref__p14 vref__p15 768.912
Rt360 vref__p14 vref__p16 1663.17
Rt361 vref__p14 vref__p17 3056.06
Rt362 vref__p14 vref__p2 241.621
Rt363 vref__p14 vref__p3 5448.89
Rt364 vref__p14 vref__p5 508.693
Rt365 vref__p14 vref__p6 698.702
Rt366 vref__p14 vref__p7 1660.09
Rt367 vref__p14 vref__p8 12.1708
Rt368 vref__p14 vref__p9 1.86726
Rt369 vref__p15 vref__p16 2.76621
Rt370 vref__p15 vref__p17 5.68373
Rt371 vref__p15 vref__p2 103.213
Rt372 vref__p15 vref__p3 1145.31
Rt373 vref__p15 vref__p5 829.619
Rt374 vref__p15 vref__p6 560.804
Rt375 vref__p15 vref__p7 344.658
Rt376 vref__p15 vref__p8 4557.75
Rt377 vref__p15 vref__p9 102.868
Rt378 vref__p16 vref__p17 2.75986
Rt379 vref__p16 vref__p2 223.556
Rt380 vref__p16 vref__p3 2482.45
Rt381 vref__p16 vref__p5 1794.5
Rt382 vref__p16 vref__p6 1213.12
Rt383 vref__p16 vref__p7 747.047
Rt384 vref__p16 vref__p8 9858.5
Rt385 vref__p16 vref__p9 222.505
Rt386 vref__p17 vref__p2 411.407
Rt387 vref__p17 vref__p3 4571.97
Rt388 vref__p17 vref__p5 3297.42
Rt389 vref__p17 vref__p6 2229.27
Rt390 vref__p17 vref__p7 1375.86
Rt391 vref__p17 vref__p8 18114.9
Rt392 vref__p17 vref__p9 408.851
Rt393 vref__p2 vref__p3 5.49374
Rt394 vref__p2 vref__p5 65.7993
Rt395 vref__p2 vref__p6 7.45703
Rt396 vref__p2 vref__p7 6.5906
Rt397 vref__p2 vref__p8 1432.38
Rt398 vref__p2 vref__p9 32.3382
Rt399 vref__p3 vref__p5 5279.01
Rt400 vref__p3 vref__p6 2064.28
Rt401 vref__p3 vref__p7 48.2546
Rt402 vref__p3 vref__p8 32298.7
Rt403 vref__p3 vref__p9 728.99
Rt404 vref__p5 vref__p6 244.984
Rt405 vref__p5 vref__p7 1709.1
Rt406 vref__p5 vref__p8 3017.46
Rt407 vref__p5 vref__p9 68.2281
Rt408 vref__p6 vref__p7 871.249
Rt409 vref__p6 vref__p8 4142.06
Rt410 vref__p6 vref__p9 93.5132
Rt411 vref__p7 vref__p8 9840.28
Rt412 vref__p7 vref__p9 222.096
Rt413 vref__p8 vref__p9 1.94076
Rt414 vref_in vref_in__p1 0.001
Rt415 vref_in vref_in__p2 0.001
Rt416 vrefl vrefl__p0 31.2586
Rt417 vrefl vrefl__p2 93.437
Rt418 vrefl vrefl__p3 7.18444
Rt419 vrefl vrefl__p4 7325.4
Rt420 vrefl vrefl__p5 4916.21
Rt421 vrefl vrefl__p6 359.98
Rt422 vrefl vrefl__p7 574.557
Rt423 vrefl__p0 vrefl__p2 18.0283
Rt424 vrefl__p0 vrefl__p3 12.5916
Rt425 vrefl__p0 vrefl__p4 63.5642
Rt426 vrefl__p0 vrefl__p5 72.9525
Rt427 vrefl__p0 vrefl__p6 631.93
Rt428 vrefl__p0 vrefl__p7 1009.16
Rt429 vrefl__p2 vrefl__p3 2.16812
Rt430 vrefl__p2 vrefl__p4 8.30061
Rt431 vrefl__p2 vrefl__p5 5.37046
Rt432 vrefl__p2 vrefl__p6 117.734
Rt433 vrefl__p2 vrefl__p7 192.433
Rt434 vrefl__p3 vrefl__p4 211.164
Rt435 vrefl__p3 vrefl__p5 128.531
Rt436 vrefl__p3 vrefl__p6 5.07096
Rt437 vrefl__p3 vrefl__p7 7.53987
Rt438 vrefl__p4 vrefl__p5 31.8717
Rt439 vrefl__p4 vrefl__p6 11315.9
Rt440 vrefl__p4 vrefl__p7 18493.5
Rt441 vrefl__p5 vrefl__p6 6889.67
Rt442 vrefl__p5 vrefl__p7 11261.9
Rt443 vrefl__p6 vrefl__p7 32.2289
Rt444 vss vss__p0 34.9503
Rt445 vss vss__p1 372.756
Rt446 vss vss__p10 18233.6
Rt447 vss vss__p11 33061.6
Rt448 vss vss__p12 32281.5
Rt449 vss vss__p13 55884.9
Rt450 vss vss__p14 78141.4
Rt451 vss vss__p15 250270
Rt452 vss vss__p16 358.209
Rt453 vss vss__p17 3653.28
Rt454 vss vss__p18 96113.9
Rt455 vss vss__p19 74114.8
Rt456 vss vss__p2 152.168
Rt457 vss vss__p20 138679
Rt458 vss vss__p22 0.001
Rt459 vss vss__p23 2
Rt460 vss vss__p24 2
Rt461 vss vss__p25 2
Rt462 vss vss__p26 2
Rt463 vss vss__p27 2
Rt464 vss vss__p28 2
Rt465 vss vss__p29 2
Rt466 vss vss__p3 89.0698
Rt467 vss vss__p30 2
Rt468 vss vss__p4 1076.06
Rt469 vss vss__p5 1332.84
Rt470 vss vss__p6 1752.7
Rt471 vss vss__p7 37.7353
Rt472 vss vss__p8 41.2417
Rt473 vss vss__p9 13512
Rt474 vss__p0 vss__p1 169.257
Rt475 vss__p0 vss__p10 782087
Rt476 vss__p0 vss__p16 15364.5
Rt477 vss__p0 vss__p17 156699
Rt478 vss__p0 vss__p2 6656.8
Rt479 vss__p0 vss__p3 3896.48
Rt480 vss__p0 vss__p4 488.606
Rt481 vss__p0 vss__p5 605.203
Rt482 vss__p0 vss__p6 795.845
Rt483 vss__p0 vss__p7 445.256
Rt484 vss__p0 vss__p8 490.044
Rt485 vss__p0 vss__p9 579567
Rt486 vss__p1 vss__p16 163868
Rt487 vss__p1 vss__p2 70997
Rt488 vss__p1 vss__p3 41557.2
Rt489 vss__p1 vss__p4 340.811
Rt490 vss__p1 vss__p5 422.139
Rt491 vss__p1 vss__p6 555.115
Rt492 vss__p1 vss__p7 4748.8
Rt493 vss__p1 vss__p8 5226.48
Rt494 vss__p10 vss__p11 184.446
Rt495 vss__p10 vss__p12 176.62
Rt496 vss__p10 vss__p13 307.671
Rt497 vss__p10 vss__p14 433.768
Rt498 vss__p10 vss__p15 1374.05
Rt499 vss__p10 vss__p16 139.567
Rt500 vss__p10 vss__p17 158.772
Rt501 vss__p10 vss__p18 555.994
Rt502 vss__p10 vss__p19 420.703
Rt503 vss__p10 vss__p2 352658
Rt504 vss__p10 vss__p20 808.124
Rt505 vss__p10 vss__p3 206424
Rt506 vss__p10 vss__p7 729352
Rt507 vss__p10 vss__p8 877308
Rt508 vss__p10 vss__p9 116.749
Rt509 vss__p11 vss__p12 195.406
Rt510 vss__p11 vss__p13 338.903
Rt511 vss__p11 vss__p14 475.02
Rt512 vss__p11 vss__p15 1516.48
Rt513 vss__p11 vss__p16 178.921
Rt514 vss__p11 vss__p17 29.8046
Rt515 vss__p11 vss__p18 591.254
Rt516 vss__p11 vss__p19 453.468
Rt517 vss__p11 vss__p2 639448
Rt518 vss__p11 vss__p20 854.867
Rt519 vss__p11 vss__p3 374293
Rt520 vss__p11 vss__p9 216.223
Rt521 vss__p12 vss__p13 190.25
Rt522 vss__p12 vss__p14 268.323
Rt523 vss__p12 vss__p15 849.545
Rt524 vss__p12 vss__p16 238.363
Rt525 vss__p12 vss__p17 142.029
Rt526 vss__p12 vss__p18 344.585
Rt527 vss__p12 vss__p19 260.506
Rt528 vss__p12 vss__p2 624361
Rt529 vss__p12 vss__p20 501.021
Rt530 vss__p12 vss__p3 365462
Rt531 vss__p12 vss__p9 207.081
Rt532 vss__p13 vss__p14 258.166
Rt533 vss__p13 vss__p15 860.032
Rt534 vss__p13 vss__p16 369.321
Rt535 vss__p13 vss__p17 80.5843
Rt536 vss__p13 vss__p18 42.4547
Rt537 vss__p13 vss__p19 227.381
Rt538 vss__p13 vss__p20 393.238
Rt539 vss__p13 vss__p3 632678
Rt540 vss__p13 vss__p9 360.715
Rt541 vss__p14 vss__p15 564.732
Rt542 vss__p14 vss__p16 453.74
Rt543 vss__p14 vss__p17 59.7988
Rt544 vss__p14 vss__p18 294.155
Rt545 vss__p14 vss__p19 55.3288
Rt546 vss__p14 vss__p20 194.885
Rt547 vss__p14 vss__p3 884646
Rt548 vss__p14 vss__p9 508.519
Rt549 vss__p15 vss__p16 1734.54
Rt550 vss__p15 vss__p17 513.739
Rt551 vss__p15 vss__p18 1398.8
Rt552 vss__p15 vss__p19 33.7794
Rt553 vss__p15 vss__p20 860.442
Rt554 vss__p15 vss__p9 1610.98
Rt555 vss__p16 vss__p17 1.54041
Rt556 vss__p16 vss__p18 350.696
Rt557 vss__p16 vss__p19 325.248
Rt558 vss__p16 vss__p2 6928.16
Rt559 vss__p16 vss__p20 475.339
Rt560 vss__p16 vss__p3 4055.32
Rt561 vss__p16 vss__p4 473049
Rt562 vss__p16 vss__p5 585932
Rt563 vss__p16 vss__p6 770504
Rt564 vss__p16 vss__p7 14328.5
Rt565 vss__p16 vss__p8 17235.2
Rt566 vss__p16 vss__p9 104.892
Rt567 vss__p17 vss__p18 22.3758
Rt568 vss__p17 vss__p19 25.21
Rt569 vss__p17 vss__p2 70658.6
Rt570 vss__p17 vss__p20 28.8059
Rt571 vss__p17 vss__p3 41359.2
Rt572 vss__p17 vss__p7 146133
Rt573 vss__p17 vss__p8 175777
Rt574 vss__p17 vss__p9 176.386
Rt575 vss__p18 vss__p19 169.03
Rt576 vss__p18 vss__p20 217.768
Rt577 vss__p18 vss__p9 651.585
Rt578 vss__p19 vss__p20 98.6071
Rt579 vss__p19 vss__p3 839061
Rt580 vss__p19 vss__p9 493.112
Rt581 vss__p2 vss__p3 63.5786
Rt582 vss__p2 vss__p4 204952
Rt583 vss__p2 vss__p5 253860
Rt584 vss__p2 vss__p6 333827
Rt585 vss__p2 vss__p7 6636.18
Rt586 vss__p2 vss__p8 7704.98
Rt587 vss__p2 vss__p9 261338
Rt588 vss__p20 vss__p9 947.006
Rt589 vss__p3 vss__p4 119966
Rt590 vss__p3 vss__p5 148594
Rt591 vss__p3 vss__p6 195402
Rt592 vss__p3 vss__p7 3884.41
Rt593 vss__p3 vss__p8 4510.02
Rt594 vss__p3 vss__p9 152971
Rt595 vss__p4 vss__p5 99.6258
Rt596 vss__p4 vss__p6 131.008
Rt597 vss__p4 vss__p7 13708.7
Rt598 vss__p4 vss__p8 15087.7
Rt599 vss__p5 vss__p6 57.9371
Rt600 vss__p5 vss__p7 16980
Rt601 vss__p5 vss__p8 18688
Rt602 vss__p6 vss__p7 22328.8
Rt603 vss__p6 vss__p8 24574.9
Rt604 vss__p7 vss__p8 217.113
Rt605 vss__p7 vss__p9 540488
Rt606 vss__p8 vss__p9 650130
Rt607 xckg_d0 xckg_d0__p1 158.064
Rt608 xckg_d0 xckg_d0__p2 32.5
Rt609 xckg_d0__p1 xckg_d0__p2 72.9819
Rt610 xckg_d1 xckg_d1__p1 160.822
Rt611 xckg_d1 xckg_d1__p2 33.3377
Rt612 xckg_d1__p1 xckg_d1__p2 71.7995
Rt613 xckg_d2 xckg_d2__p1 253.776
Rt614 xckg_d2 xckg_d2__p2 56.8495
Rt615 xckg_d2__p1 xckg_d2__p2 62.5432
Rt616 xckg_d3 xckg_d3__p1 116.773
Rt617 xckg_d3 xckg_d3__p2 66.8961
Rt618 xckg_d3__p1 xckg_d3__p2 71.2846
Rt619 xckg_nn xckg_nn__p1 46.1928
Rt620 xckg_x xckg_x__p1 101.928
Rt621 xckg_x xckg_x__p2 247.825
Rt622 xckg_x xckg_x__p3 173.816
Rt623 xckg_x xckg_x__p4 124.476
Rt624 xckg_x__p1 xckg_x__p2 156.926
Rt625 xckg_x__p1 xckg_x__p3 110.063
Rt626 xckg_x__p1 xckg_x__p4 78.82
Rt627 xckg_x__p2 xckg_x__p3 94.6454
Rt628 xckg_x__p2 xckg_x__p4 142.468
Rt629 xckg_x__p3 xckg_x__p4 99.922
Rt630 xref_na xref_na__p1 77.984
Rt631 xref_ng xref_ng__p1 1225.95
Rt632 xref_ng xref_ng__p2 132.884
Rt633 xref_ng__p1 xref_ng__p2 31.5508
Rt634 xref_ntl xref_ntl__p1 60.2546
Rt635 xref_ntl__p1 xref_ntl__p2 19.318
Cq0 ain_cos_n ain_cos_p 2.707e-14
Cq1 ain_cos_n ain_isa_n 3.445e-17
Cq2 ain_cos_n ain_isa_p 4.604e-17
Cq3 ain_cos_n ibias 1.097e-16
Cq4 ain_cos_n sar_clka 2.933e-17
Cq5 ain_cos_n sar_clkab 2.933e-17
Cq6 ain_cos_n sar_clkna 2.933e-17
Cq7 ain_cos_n sar_clknab 2.946e-17
Cq8 ain_cos_n sar_cna0 4.649e-17
Cq9 ain_cos_n sar_cna1 4.481e-17
Cq10 ain_cos_n sar_cna10 4.578e-17
Cq11 ain_cos_n sar_cna11 4.578e-17
Cq12 ain_cos_n sar_cna12 4.578e-17
Cq13 ain_cos_n sar_cna2 3.756e-17
Cq14 ain_cos_n sar_cna3 3.984e-17
Cq15 ain_cos_n sar_cna4 4.481e-17
Cq16 ain_cos_n sar_cna5 4.481e-17
Cq17 ain_cos_n sar_cna6 4.537e-17
Cq18 ain_cos_n sar_cna7 4.802e-17
Cq19 ain_cos_n sar_cna8 4.746e-17
Cq20 ain_cos_n sar_cna9 4.578e-17
Cq21 ain_cos_n sar_cpa0 4.649e-17
Cq22 ain_cos_n sar_cpa1 4.537e-17
Cq23 ain_cos_n sar_cpa10 4.578e-17
Cq24 ain_cos_n sar_cpa11 4.578e-17
Cq25 ain_cos_n sar_cpa12 4.578e-17
Cq26 ain_cos_n sar_cpa2 4.337e-17
Cq27 ain_cos_n sar_cpa3 3.579e-17
Cq28 ain_cos_n sar_cpa4 4.337e-17
Cq29 ain_cos_n sar_cpa5 4.634e-17
Cq30 ain_cos_n sar_cpa6 4.481e-17
Cq31 ain_cos_n sar_cpa7 4.649e-17
Cq32 ain_cos_n sar_cpa8 4.746e-17
Cq33 ain_cos_n sar_cpa9 4.578e-17
Cq34 ain_cos_n sar_oan 4.184e-17
Cq35 ain_cos_n sar_oann 4.384e-17
Cq36 ain_cos_n sar_oanp 4.649e-17
Cq37 ain_cos_n sar_oap 3.459e-17
Cq38 ain_cos_n sar_trka0 5.23e-17
Cq39 ain_cos_n sar_trka1 4.808e-17
Cq40 ain_cos_n sar_trkb0 1.443e-17
Cq41 ain_cos_n vdd 3.063e-15
Cq42 ain_cos_n vss 3.507e-14
Cq43 ain_cos_n xckg_d0 4.043e-19
Cq44 ain_cos_n xckg_d1 7.338e-19
Cq45 ain_cos_n xckg_d2 8.525e-19
Cq46 ain_cos_n xckg_d3 1.362e-18
Cq47 ain_cos_n xckg_x 2.674e-17
Cq48 ain_cos_p ain_isa_n 3.424e-17
Cq49 ain_cos_p ain_isa_p 4.84e-17
Cq50 ain_cos_p ibias 2.317e-16
Cq51 ain_cos_p sar_clka 2.933e-17
Cq52 ain_cos_p sar_clkab 2.933e-17
Cq53 ain_cos_p sar_clkna 2.933e-17
Cq54 ain_cos_p sar_clknab 2.951e-17
Cq55 ain_cos_p sar_cna0 4.649e-17
Cq56 ain_cos_p sar_cna1 4.481e-17
Cq57 ain_cos_p sar_cna10 4.578e-17
Cq58 ain_cos_p sar_cna11 4.578e-17
Cq59 ain_cos_p sar_cna12 4.578e-17
Cq60 ain_cos_p sar_cna2 3.756e-17
Cq61 ain_cos_p sar_cna3 3.984e-17
Cq62 ain_cos_p sar_cna4 4.481e-17
Cq63 ain_cos_p sar_cna5 4.481e-17
Cq64 ain_cos_p sar_cna6 4.537e-17
Cq65 ain_cos_p sar_cna7 4.802e-17
Cq66 ain_cos_p sar_cna8 4.746e-17
Cq67 ain_cos_p sar_cna9 4.578e-17
Cq68 ain_cos_p sar_cpa0 4.649e-17
Cq69 ain_cos_p sar_cpa1 4.537e-17
Cq70 ain_cos_p sar_cpa10 4.578e-17
Cq71 ain_cos_p sar_cpa11 4.578e-17
Cq72 ain_cos_p sar_cpa12 4.578e-17
Cq73 ain_cos_p sar_cpa2 4.337e-17
Cq74 ain_cos_p sar_cpa3 3.788e-17
Cq75 ain_cos_p sar_cpa4 4.337e-17
Cq76 ain_cos_p sar_cpa5 4.634e-17
Cq77 ain_cos_p sar_cpa6 4.481e-17
Cq78 ain_cos_p sar_cpa7 4.649e-17
Cq79 ain_cos_p sar_cpa8 4.746e-17
Cq80 ain_cos_p sar_cpa9 4.578e-17
Cq81 ain_cos_p sar_oan 4.184e-17
Cq82 ain_cos_p sar_oann 4.384e-17
Cq83 ain_cos_p sar_oanp 4.649e-17
Cq84 ain_cos_p sar_oap 3.459e-17
Cq85 ain_cos_p sar_trka0 5.315e-17
Cq86 ain_cos_p sar_trka1 4.808e-17
Cq87 ain_cos_p sar_trkb0 4.662e-19
Cq88 ain_cos_p vdd 2.211e-15
Cq89 ain_cos_p vss 3.544e-14
Cq90 ain_cos_p xckg_d3 3.348e-19
Cq91 ain_cos_p xckg_x 2.003e-17
Cq92 ain_isa_n ain_isa_p 2.783e-14
Cq93 ain_isa_n ain_isb_n 6.15e-17
Cq94 ain_isa_n ain_isb_p 6.417e-17
Cq95 ain_isa_n sar_clkb 4.864e-17
Cq96 ain_isa_n sar_clkbb 4.746e-17
Cq97 ain_isa_n sar_clknab 9.415e-19
Cq98 ain_isa_n sar_clknb 4.184e-17
Cq99 ain_isa_n sar_clknbb 2.965e-17
Cq100 ain_isa_n sar_cnb0 4.649e-17
Cq101 ain_isa_n sar_cnb1 4.481e-17
Cq102 ain_isa_n sar_cnb10 4.578e-17
Cq103 ain_isa_n sar_cnb11 4.578e-17
Cq104 ain_isa_n sar_cnb12 4.578e-17
Cq105 ain_isa_n sar_cnb2 3.756e-17
Cq106 ain_isa_n sar_cnb3 3.984e-17
Cq107 ain_isa_n sar_cnb4 4.481e-17
Cq108 ain_isa_n sar_cnb5 4.481e-17
Cq109 ain_isa_n sar_cnb6 4.537e-17
Cq110 ain_isa_n sar_cnb7 4.802e-17
Cq111 ain_isa_n sar_cnb8 4.746e-17
Cq112 ain_isa_n sar_cnb9 4.578e-17
Cq113 ain_isa_n sar_cpb0 4.649e-17
Cq114 ain_isa_n sar_cpb1 4.537e-17
Cq115 ain_isa_n sar_cpb10 4.578e-17
Cq116 ain_isa_n sar_cpb11 4.578e-17
Cq117 ain_isa_n sar_cpb12 4.578e-17
Cq118 ain_isa_n sar_cpb2 4.537e-17
Cq119 ain_isa_n sar_cpb3 4.024e-17
Cq120 ain_isa_n sar_cpb4 4.337e-17
Cq121 ain_isa_n sar_cpb5 4.634e-17
Cq122 ain_isa_n sar_cpb6 4.481e-17
Cq123 ain_isa_n sar_cpb7 4.649e-17
Cq124 ain_isa_n sar_cpb8 4.746e-17
Cq125 ain_isa_n sar_cpb9 4.578e-17
Cq126 ain_isa_n sar_obn 4.184e-17
Cq127 ain_isa_n sar_obnn 4.481e-17
Cq128 ain_isa_n sar_obnp 4.649e-17
Cq129 ain_isa_n sar_obp 3.459e-17
Cq130 ain_isa_n sar_trkb0 4.883e-17
Cq131 ain_isa_n sar_trkb1 4.833e-17
Cq132 ain_isa_n vdd 8.828e-17
Cq133 ain_isa_n vss 3.302e-14
Cq134 ain_isa_p ain_isb_n 7.645e-17
Cq135 ain_isa_p ain_isb_p 7.912e-17
Cq136 ain_isa_p sar_clkb 4.864e-17
Cq137 ain_isa_p sar_clkbb 4.746e-17
Cq138 ain_isa_p sar_clknab 7.019e-19
Cq139 ain_isa_p sar_clknb 4.184e-17
Cq140 ain_isa_p sar_clknbb 3.499e-17
Cq141 ain_isa_p sar_cnb0 4.649e-17
Cq142 ain_isa_p sar_cnb1 4.481e-17
Cq143 ain_isa_p sar_cnb10 4.578e-17
Cq144 ain_isa_p sar_cnb11 4.578e-17
Cq145 ain_isa_p sar_cnb12 4.578e-17
Cq146 ain_isa_p sar_cnb2 3.756e-17
Cq147 ain_isa_p sar_cnb3 3.984e-17
Cq148 ain_isa_p sar_cnb4 4.481e-17
Cq149 ain_isa_p sar_cnb5 4.481e-17
Cq150 ain_isa_p sar_cnb6 4.537e-17
Cq151 ain_isa_p sar_cnb7 4.802e-17
Cq152 ain_isa_p sar_cnb8 4.746e-17
Cq153 ain_isa_p sar_cnb9 4.578e-17
Cq154 ain_isa_p sar_cpb0 4.649e-17
Cq155 ain_isa_p sar_cpb1 4.537e-17
Cq156 ain_isa_p sar_cpb10 4.578e-17
Cq157 ain_isa_p sar_cpb11 4.578e-17
Cq158 ain_isa_p sar_cpb12 4.578e-17
Cq159 ain_isa_p sar_cpb2 4.537e-17
Cq160 ain_isa_p sar_cpb3 4.047e-17
Cq161 ain_isa_p sar_cpb4 4.337e-17
Cq162 ain_isa_p sar_cpb5 4.634e-17
Cq163 ain_isa_p sar_cpb6 4.481e-17
Cq164 ain_isa_p sar_cpb7 4.649e-17
Cq165 ain_isa_p sar_cpb8 4.746e-17
Cq166 ain_isa_p sar_cpb9 4.578e-17
Cq167 ain_isa_p sar_mclk 2.531e-18
Cq168 ain_isa_p sar_obn 4.184e-17
Cq169 ain_isa_p sar_obnn 4.481e-17
Cq170 ain_isa_p sar_obnp 4.649e-17
Cq171 ain_isa_p sar_obp 3.459e-17
Cq172 ain_isa_p sar_trkb0 5.684e-17
Cq173 ain_isa_p sar_trkb1 4.833e-17
Cq174 ain_isa_p vdd 1.13e-16
Cq175 ain_isa_p vss 3.362e-14
Cq176 ain_isb_n ain_isb_p 7.431e-17
Cq177 ain_isb_n vss 9.265e-16
Cq178 ain_isb_p vss 8.611e-16
Cq179 ain_sin_n ain_sin_p 8.625e-17
Cq180 ain_sin_n ibias 9.686e-17
Cq181 ain_sin_n vss 7.977e-16
Cq182 ain_sin_p ibias 9.686e-17
Cq183 ain_sin_p vss 7.924e-16
Cq184 clk mclkb 1.252e-18
Cq185 clk sar_clka 3.704e-17
Cq186 clk sar_clkab 2.773e-17
Cq187 clk sar_clkna 3.212e-17
Cq188 clk sar_clknab 4.043e-18
Cq189 clk sar_cna0 4.953e-17
Cq190 clk sar_cna1 4.301e-17
Cq191 clk sar_cna10 4.59e-17
Cq192 clk sar_cna11 4.59e-17
Cq193 clk sar_cna12 4.443e-17
Cq194 clk sar_cna2 3.644e-17
Cq195 clk sar_cna3 3.581e-17
Cq196 clk sar_cna4 4.301e-17
Cq197 clk sar_cna5 4.301e-17
Cq198 clk sar_cna6 4.534e-17
Cq199 clk sar_cna7 5.255e-17
Cq200 clk sar_cna8 5.168e-17
Cq201 clk sar_cna9 4.443e-17
Cq202 clk sar_cpa0 4.489e-17
Cq203 clk sar_cpa1 4.592e-17
Cq204 clk sar_cpa10 4.443e-17
Cq205 clk sar_cpa11 4.59e-17
Cq206 clk sar_cpa12 4.59e-17
Cq207 clk sar_cpa2 4.223e-17
Cq208 clk sar_cpa3 3.127e-17
Cq209 clk sar_cpa4 4.339e-17
Cq210 clk sar_cpa5 4.676e-17
Cq211 clk sar_cpa6 4.301e-17
Cq212 clk sar_cpa7 4.953e-17
Cq213 clk sar_cpa8 5.168e-17
Cq214 clk sar_cpa9 4.59e-17
Cq215 clk sar_mclk 4.18e-16
Cq216 clk sar_oan 3.87e-17
Cq217 clk sar_oann 4.086e-17
Cq218 clk sar_oanp 4.931e-17
Cq219 clk sar_oap 3.067e-17
Cq220 clk sar_trka0 6.343e-17
Cq221 clk sar_trka1 5.755e-17
Cq222 clk vdd 1.554e-15
Cq223 clk vss 2.921e-14
Cq224 clk xckg_d0 3.206e-16
Cq225 clk xckg_d1 1.883e-16
Cq226 clk xckg_d2 1.491e-16
Cq227 clk xckg_d3 2.541e-16
Cq228 clk xckg_nn 2.492e-17
Cq229 clk xckg_x 3.281e-16
Cq230 ibias sar_trka0 1.287e-17
Cq231 ibias vbn 2.266e-15
Cq232 ibias vbp 6.102e-17
Cq233 ibias vdd 4.502e-15
Cq234 ibias vdda 2.216e-16
Cq235 ibias vref 4.11e-14
Cq236 ibias vref_in 9.847e-15
Cq237 ibias vrefl 1.687e-14
Cq238 ibias vss 1.681e-13
Cq239 ibias xref_ng 2.101e-15
Cq240 ibias xref_ntl 1.737e-16
Cq241 mclkb sar_clknab 4.044e-17
Cq242 mclkb sar_mclk 2.778e-16
Cq243 mclkb sar_trkb0 2.442e-18
Cq244 mclkb vdd 1.741e-15
Cq245 mclkb vss 5.564e-15
Cq246 mclkb xckg_d0 1.25e-15
Cq247 mclkb xckg_d1 2.7e-16
Cq248 mclkb xckg_d2 2.182e-16
Cq249 mclkb xckg_d3 1.483e-17
Cq250 mclkb xckg_nn 2.576e-17
Cq251 mclkb xckg_x 1.907e-17
Cq252 sar_clka sar_trka1 4.996e-17
Cq253 sar_clka vdd 5.939e-18
Cq254 sar_clka vss 4.415e-15
Cq255 sar_clkab sar_mclk 3.485e-17
Cq256 sar_clkab sar_oann 9.641e-17
Cq257 sar_clkab vdd 5.391e-18
Cq258 sar_clkab vss 4.557e-15
Cq259 sar_clkb sar_trkb1 1.541e-16
Cq260 sar_clkb vdd 9.721e-18
Cq261 sar_clkb vss 1.963e-15
Cq262 sar_clkbb sar_obnn 3.064e-16
Cq263 sar_clkbb sar_obnp 3.919e-19
Cq264 sar_clkbb vdd 6.807e-18
Cq265 sar_clkbb vss 1.715e-15
Cq266 sar_clkna sar_cpa2 1.689e-16
Cq267 sar_clkna sar_cpa3 7.355e-16
Cq268 sar_clkna sar_cpa4 1.185e-17
Cq269 sar_clkna sar_mclk 3.502e-17
Cq270 sar_clkna vdd 5.939e-18
Cq271 sar_clkna vss 3.965e-15
Cq272 sar_clknab sar_mclk 1.264e-16
Cq273 sar_clknab vdd 1.914e-16
Cq274 sar_clknab vss 4.193e-15
Cq275 sar_clknab xckg_x 7.189e-17
Cq276 sar_clknb sar_cpb1 2.496e-19
Cq277 sar_clknb sar_cpb2 4.387e-16
Cq278 sar_clknb sar_cpb3 1.131e-15
Cq279 sar_clknb sar_cpb4 6.245e-19
Cq280 sar_clknb sar_cpb5 4.845e-18
Cq281 sar_clknb vdd 6.26e-18
Cq282 sar_clknb vss 1.056e-15
Cq283 sar_clknbb vss 4.526e-15
Cq284 sar_cna0 sar_cna1 4.187e-16
Cq285 sar_cna0 sar_mclk 5.35e-17
Cq286 sar_cna0 vdd 5.939e-18
Cq287 sar_cna0 vss 2e-15
Cq288 sar_cna1 sar_cna2 3.064e-16
Cq289 sar_cna1 sar_mclk 5.151e-17
Cq290 sar_cna1 vdd 5.391e-18
Cq291 sar_cna1 vss 1.682e-15
Cq292 sar_cna10 sar_cna11 2.981e-16
Cq293 sar_cna10 sar_cna9 3.064e-16
Cq294 sar_cna10 sar_mclk 5.273e-17
Cq295 sar_cna10 vdd 5.939e-18
Cq296 sar_cna10 vss 1.797e-15
Cq297 sar_cna11 sar_cna12 3.064e-16
Cq298 sar_cna11 sar_mclk 5.273e-17
Cq299 sar_cna11 vdd 5.939e-18
Cq300 sar_cna11 vss 1.797e-15
Cq301 sar_cna12 sar_cpa12 3.064e-16
Cq302 sar_cna12 sar_mclk 5.238e-17
Cq303 sar_cna12 vdd 4.844e-18
Cq304 sar_cna12 vss 1.756e-15
Cq305 sar_cna2 sar_mclk 4.37e-17
Cq306 sar_cna2 sar_oap 2.214e-15
Cq307 sar_cna2 vdd 5.391e-18
Cq308 sar_cna2 vss 1.347e-15
Cq309 sar_cna3 sar_mclk 4.634e-17
Cq310 sar_cna3 sar_oan 8.01e-16
Cq311 sar_cna3 sar_oap 7.036e-16
Cq312 sar_cna3 vdd 5.939e-18
Cq313 sar_cna3 vss 1.328e-15
Cq314 sar_cna4 sar_cna5 3.064e-16
Cq315 sar_cna4 sar_mclk 5.151e-17
Cq316 sar_cna4 sar_oan 4.187e-16
Cq317 sar_cna4 vdd 5.391e-18
Cq318 sar_cna4 vss 1.682e-15
Cq319 sar_cna5 sar_cna6 4.187e-16
Cq320 sar_cna5 sar_mclk 5.151e-17
Cq321 sar_cna5 vdd 5.391e-18
Cq322 sar_cna5 vss 1.682e-15
Cq323 sar_cna6 sar_cna7 2.361e-16
Cq324 sar_cna6 sar_mclk 5.229e-17
Cq325 sar_cna6 vdd 5.939e-18
Cq326 sar_cna6 vss 1.777e-15
Cq327 sar_cna7 sar_mclk 5.497e-17
Cq328 sar_cna7 vdd 5.391e-18
Cq329 sar_cna7 vss 2.151e-15
Cq330 sar_cna8 sar_cna9 3.064e-16
Cq331 sar_cna8 sar_mclk 5.454e-17
Cq332 sar_cna8 vdd 5.939e-18
Cq333 sar_cna8 vss 2.09e-15
Cq334 sar_cna9 sar_mclk 5.238e-17
Cq335 sar_cna9 vdd 4.844e-18
Cq336 sar_cna9 vss 1.756e-15
Cq337 sar_cnb0 sar_cnb1 4.047e-16
Cq338 sar_cnb0 sar_cnb2 3.919e-19
Cq339 sar_cnb0 sar_cnb3 3.99e-18
Cq340 sar_cnb0 sar_obp 2.496e-19
Cq341 sar_cnb0 vdd 8.551e-18
Cq342 sar_cnb0 vss 1.677e-15
Cq343 sar_cnb1 sar_cnb2 3.064e-16
Cq344 sar_cnb1 sar_cnb3 2.688e-19
Cq345 sar_cnb1 vdd 5.712e-18
Cq346 sar_cnb1 vss 1.327e-15
Cq347 sar_cnb10 sar_cnb11 2.978e-16
Cq348 sar_cnb10 sar_cnb12 2.496e-19
Cq349 sar_cnb10 sar_cnb8 2.496e-19
Cq350 sar_cnb10 sar_cnb9 2.879e-16
Cq351 sar_cnb10 vdd 8.551e-18
Cq352 sar_cnb10 vss 1.483e-15
Cq353 sar_cnb11 sar_cnb12 3.064e-16
Cq354 sar_cnb11 sar_cnb9 5.494e-18
Cq355 sar_cnb11 sar_cpb12 2.496e-19
Cq356 sar_cnb11 vdd 6.26e-18
Cq357 sar_cnb11 vss 1.418e-15
Cq358 sar_cnb12 sar_cpb11 5.494e-18
Cq359 sar_cnb12 sar_cpb12 2.978e-16
Cq360 sar_cnb12 vdd 6.26e-18
Cq361 sar_cnb12 vss 1.418e-15
Cq362 sar_cnb2 sar_cnb3 1.939e-18
Cq363 sar_cnb2 sar_obp 2.249e-15
Cq364 sar_cnb2 vdd 6.807e-18
Cq365 sar_cnb2 vss 1.063e-15
Cq366 sar_cnb3 sar_cnb4 5.334e-19
Cq367 sar_cnb3 sar_cnb5 1.521e-19
Cq368 sar_cnb3 sar_obn 7.769e-16
Cq369 sar_cnb3 sar_obp 6.642e-16
Cq370 sar_cnb3 vdd 9.721e-18
Cq371 sar_cnb3 vss 1.11e-15
Cq372 sar_cnb4 sar_cnb5 3.064e-16
Cq373 sar_cnb4 sar_cnb6 2.688e-19
Cq374 sar_cnb4 sar_obn 4.558e-16
Cq375 sar_cnb4 vdd 5.712e-18
Cq376 sar_cnb4 vss 1.294e-15
Cq377 sar_cnb5 sar_cnb6 3.976e-16
Cq378 sar_cnb5 sar_cnb7 5.494e-18
Cq379 sar_cnb5 vdd 6.807e-18
Cq380 sar_cnb5 vss 1.363e-15
Cq381 sar_cnb6 sar_cnb7 2.371e-16
Cq382 sar_cnb6 sar_obn 1.389e-19
Cq383 sar_cnb6 vdd 9.721e-18
Cq384 sar_cnb6 vss 1.495e-15
Cq385 sar_cnb7 vdd 5.712e-18
Cq386 sar_cnb7 vss 1.754e-15
Cq387 sar_cnb8 sar_cnb9 3.064e-16
Cq388 sar_cnb8 vdd 6.26e-18
Cq389 sar_cnb8 vss 1.7e-15
Cq390 sar_cnb9 vdd 6.26e-18
Cq391 sar_cnb9 vss 1.427e-15
Cq392 sar_cpa0 sar_cpa1 4.187e-16
Cq393 sar_cpa0 sar_mclk 4.832e-17
Cq394 sar_cpa0 vdd 5.391e-18
Cq395 sar_cpa0 vss 2.217e-15
Cq396 sar_cpa0 xckg_d0 3.136e-18
Cq397 sar_cpa1 sar_cpa2 2.361e-16
Cq398 sar_cpa1 sar_cpa3 1.221e-19
Cq399 sar_cpa1 sar_mclk 5.229e-17
Cq400 sar_cpa1 vdd 5.939e-18
Cq401 sar_cpa1 vss 1.785e-15
Cq402 sar_cpa1 xckg_d0 1.203e-18
Cq403 sar_cpa10 sar_cpa11 3.064e-16
Cq404 sar_cpa10 sar_cpa9 3.064e-16
Cq405 sar_cpa10 sar_mclk 5.238e-17
Cq406 sar_cpa10 vdd 4.844e-18
Cq407 sar_cpa10 vss 1.756e-15
Cq408 sar_cpa11 sar_cpa12 2.981e-16
Cq409 sar_cpa11 sar_mclk 5.273e-17
Cq410 sar_cpa11 vdd 5.939e-18
Cq411 sar_cpa11 vss 1.797e-15
Cq412 sar_cpa12 sar_mclk 5.273e-17
Cq413 sar_cpa12 vdd 5.939e-18
Cq414 sar_cpa12 vss 1.797e-15
Cq415 sar_cpa2 sar_cpa3 6.567e-19
Cq416 sar_cpa2 sar_mclk 4.997e-17
Cq417 sar_cpa2 vdd 5.391e-18
Cq418 sar_cpa2 vss 2.126e-15
Cq419 sar_cpa3 sar_cpa4 6.012e-16
Cq420 sar_cpa3 sar_cpa5 3.174e-19
Cq421 sar_cpa3 sar_mclk 4.094e-17
Cq422 sar_cpa3 vdd 8.305e-18
Cq423 sar_cpa3 vss 2.792e-15
Cq424 sar_cpa4 sar_cpa5 2.361e-16
Cq425 sar_cpa4 sar_mclk 5.014e-17
Cq426 sar_cpa4 vdd 5.939e-18
Cq427 sar_cpa4 vss 1.697e-15
Cq428 sar_cpa5 sar_cpa6 3.064e-16
Cq429 sar_cpa5 sar_mclk 5.316e-17
Cq430 sar_cpa5 vdd 5.391e-18
Cq431 sar_cpa5 vss 1.851e-15
Cq432 sar_cpa6 sar_cpa7 4.187e-16
Cq433 sar_cpa6 sar_mclk 5.151e-17
Cq434 sar_cpa6 vdd 5.391e-18
Cq435 sar_cpa6 vss 1.682e-15
Cq436 sar_cpa7 sar_mclk 5.35e-17
Cq437 sar_cpa7 vdd 5.939e-18
Cq438 sar_cpa7 vss 2e-15
Cq439 sar_cpa8 sar_cpa9 2.981e-16
Cq440 sar_cpa8 sar_mclk 5.454e-17
Cq441 sar_cpa8 vdd 5.939e-18
Cq442 sar_cpa8 vss 2.097e-15
Cq443 sar_cpa9 sar_mclk 5.273e-17
Cq444 sar_cpa9 vdd 5.939e-18
Cq445 sar_cpa9 vss 1.797e-15
Cq446 sar_cpb0 sar_cpb1 4.047e-16
Cq447 sar_cpb0 sar_cpb2 5.494e-18
Cq448 sar_cpb0 vdd 5.712e-18
Cq449 sar_cpb0 vss 1.612e-15
Cq450 sar_cpb1 sar_cpb2 2.289e-16
Cq451 sar_cpb1 sar_cpb3 4.295e-18
Cq452 sar_cpb1 vdd 8.551e-18
Cq453 sar_cpb1 vss 1.468e-15
Cq454 sar_cpb10 sar_cpb11 3.064e-16
Cq455 sar_cpb10 sar_cpb12 2.496e-19
Cq456 sar_cpb10 sar_cpb8 5.494e-18
Cq457 sar_cpb10 sar_cpb9 2.978e-16
Cq458 sar_cpb10 vdd 6.26e-18
Cq459 sar_cpb10 vss 1.418e-15
Cq460 sar_cpb11 sar_cpb12 2.879e-16
Cq461 sar_cpb11 sar_cpb9 2.496e-19
Cq462 sar_cpb11 vdd 6.26e-18
Cq463 sar_cpb11 vss 1.427e-15
Cq464 sar_cpb12 vdd 8.551e-18
Cq465 sar_cpb12 vss 1.483e-15
Cq466 sar_cpb2 sar_cpb3 7.915e-19
Cq467 sar_cpb2 vdd 6.807e-18
Cq468 sar_cpb2 vss 1.411e-15
Cq469 sar_cpb3 sar_cpb4 6.208e-16
Cq470 sar_cpb3 sar_cpb5 2.003e-19
Cq471 sar_cpb3 vdd 8.626e-18
Cq472 sar_cpb3 vss 1.109e-15
Cq473 sar_cpb4 sar_cpb5 2.289e-16
Cq474 sar_cpb4 vdd 8.551e-18
Cq475 sar_cpb4 vss 1.383e-15
Cq476 sar_cpb5 sar_cpb6 3.064e-16
Cq477 sar_cpb5 sar_cpb7 3.919e-19
Cq478 sar_cpb5 vdd 6.807e-18
Cq479 sar_cpb5 vss 1.507e-15
Cq480 sar_cpb6 sar_cpb7 4.047e-16
Cq481 sar_cpb6 vdd 5.712e-18
Cq482 sar_cpb6 vss 1.327e-15
Cq483 sar_cpb7 vdd 8.551e-18
Cq484 sar_cpb7 vss 1.678e-15
Cq485 sar_cpb8 sar_cpb9 2.879e-16
Cq486 sar_cpb8 vdd 6.26e-18
Cq487 sar_cpb8 vss 1.715e-15
Cq488 sar_cpb9 vdd 8.551e-18
Cq489 sar_cpb9 vss 1.484e-15
Cq490 sar_mclk sar_oan 4.849e-17
Cq491 sar_mclk sar_oann 5.047e-17
Cq492 sar_mclk sar_oanp 5.344e-17
Cq493 sar_mclk sar_oap 4.033e-17
Cq494 sar_mclk vdd 9.835e-16
Cq495 sar_mclk vss 5.569e-14
Cq496 sar_mclk xckg_d0 2.428e-16
Cq497 sar_mclk xckg_d1 2.372e-16
Cq498 sar_mclk xckg_d2 3.312e-16
Cq499 sar_mclk xckg_d3 2.272e-16
Cq500 sar_mclk xckg_nn 3.925e-16
Cq501 sar_mclk xckg_x 2.915e-16
Cq502 sar_oan vdd 5.939e-18
Cq503 sar_oan vss 1.46e-15
Cq504 sar_oann sar_oanp 4.187e-16
Cq505 sar_oann vdd 5.391e-18
Cq506 sar_oann vss 1.911e-15
Cq507 sar_oanp vdd 5.939e-18
Cq508 sar_oanp vss 2.018e-15
Cq509 sar_oap vdd 4.844e-18
Cq510 sar_oap vss 1.109e-15
Cq511 sar_obn sar_obp 1.052e-17
Cq512 sar_obn vdd 8.116e-18
Cq513 sar_obn vss 1.165e-15
Cq514 sar_obnn sar_obnp 4.047e-16
Cq515 sar_obnn vdd 5.712e-18
Cq516 sar_obnn vss 1.327e-15
Cq517 sar_obnp vdd 8.551e-18
Cq518 sar_obnp vss 1.678e-15
Cq519 sar_obp vdd 6.26e-18
Cq520 sar_obp vss 8.685e-16
Cq521 sar_trka0 sar_trka1 1.399e-16
Cq522 sar_trka0 vss 2.19e-15
Cq523 sar_trka1 vss 2.16e-15
Cq524 sar_trkb0 sar_trkb1 1.399e-16
Cq525 sar_trkb0 vdd 9.908e-17
Cq526 sar_trkb0 vss 1.928e-15
Cq527 sar_trkb1 vdd 5.712e-18
Cq528 sar_trkb1 vss 1.802e-15
Cq529 vbn vbp 2.899e-14
Cq530 vbn vdd 2.028e-15
Cq531 vbn vdda 5.091e-17
Cq532 vbn vref 1.786e-14
Cq533 vbn vref_in 4.127e-15
Cq534 vbn vrefl 2.52e-14
Cq535 vbn vss 1.155e-14
Cq536 vbn xref_na 7.746e-19
Cq537 vbn xref_ng 1.886e-15
Cq538 vbp vdd 1.803e-15
Cq539 vbp vdda 8.761e-15
Cq540 vbp vref 1.878e-14
Cq541 vbp vref_in 4.205e-15
Cq542 vbp vrefl 1.08e-14
Cq543 vbp vss 1.857e-14
Cq544 vbp xref_na 9.789e-18
Cq545 vbp xref_ng 2.371e-15
Cq546 vdd vdda 5.954e-16
Cq547 vdd vref 1.718e-13
Cq548 vdd vref_in 4.013e-14
Cq549 vdd vrefl 5.877e-14
Cq550 vdd vss 1.157e-13
Cq551 vdd xckg_d0 2.688e-16
Cq552 vdd xckg_d1 2.766e-16
Cq553 vdd xckg_d2 3.357e-16
Cq554 vdd xckg_d3 4.504e-16
Cq555 vdd xckg_nn 2.848e-18
Cq556 vdd xckg_x 4.879e-16
Cq557 vdd xref_ng 2.468e-14
Cq558 vdda vref 4.398e-14
Cq559 vdda vref_in 3.223e-16
Cq560 vdda vrefl 2.519e-14
Cq561 vdda vss 3.507e-14
Cq562 vdda xref_na 1.249e-15
Cq563 vdda xref_ng 2.299e-14
Cq564 vdda xref_ntl 9.96e-18
Cq565 vref vref_in 4.54e-14
Cq566 vref vrefl 1.67e-13
Cq567 vref vss 3.743e-13
Cq568 vref xref_na 1.322e-16
Cq569 vref xref_ng 4.971e-14
Cq570 vref xref_ntl 1.685e-15
Cq571 vref_in vrefl 3.08e-14
Cq572 vref_in vss 9.388e-14
Cq573 vref_in xref_na 4.042e-16
Cq574 vref_in xref_ng 3.421e-15
Cq575 vref_in xref_ntl 1.606e-15
Cq576 vrefl vss 1.926e-13
Cq577 vrefl xref_na 1.039e-16
Cq578 vrefl xref_ng 3.178e-14
Cq579 vrefl xref_ntl 2.185e-15
Cq580 vss xckg_d0 5.11e-15
Cq581 vss xckg_d1 4.339e-15
Cq582 vss xckg_d2 6.346e-15
Cq583 vss xckg_d3 8.13e-15
Cq584 vss xckg_nn 1.937e-15
Cq585 vss xckg_x 6.625e-15
Cq586 vss xref_na 4.437e-15
Cq587 vss xref_ng 8.769e-14
Cq588 vss xref_ntl 3.71e-15
Cq589 xckg_d0 xckg_d1 3.909e-15
Cq590 xckg_d0 xckg_d2 1.218e-15
Cq591 xckg_d0 xckg_d3 1.494e-17
Cq592 xckg_d0 xckg_nn 5.565e-16
Cq593 xckg_d0 xckg_x 4.057e-17
Cq594 xckg_d1 xckg_d2 3.755e-15
Cq595 xckg_d1 xckg_d3 3.433e-17
Cq596 xckg_d1 xckg_nn 6.939e-18
Cq597 xckg_d1 xckg_x 1.218e-17
Cq598 xckg_d2 xckg_d3 6.227e-16
Cq599 xckg_d2 xckg_nn 1.283e-16
Cq600 xckg_d2 xckg_x 1.227e-16
Cq601 xckg_d3 xckg_nn 3.139e-18
Cq602 xckg_d3 xckg_x 4.209e-15
Cq603 xckg_nn xckg_x 6.716e-17
Cq604 xref_na xref_ng 2.554e-15
Cq605 xref_na xref_ntl 2.584e-16
Cq606 xref_ng xref_ntl 2.12e-15
.ends
