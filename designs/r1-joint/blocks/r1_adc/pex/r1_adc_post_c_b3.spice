* r1_adc post-layout netlist, layout B (C only), written by pex/pex_build.py; see its docstring
* devices: LVS reference of layout/r1_adc_netlist.py; R: KLayout RNetExtractor Metal1-5/Via1-4; C: kpex 0.3.12 2.5D CC
* requires cornerMOSlv/hv.lib, cornerCAP.lib, cornerRES.lib
.subckt r1_adc_slice_post in0p in0n in1p in1n trk0 trk1 cp0 cp1 cp2 cp3 cp4 cp5 cp6 cp7 cp8 cp9 cp10 cp11 cp12 cn0 cn1 cn2 cn3 cn4 cn5 cn6 cn7 cn8 cn9 cn10 cn11 cn12 clk clkb clkn clknb op on onp onn vbp vbn vref vrefl top_p top_n vdd gnd
Xxpt0a t0b trk0 vdd vdd sg13_lv_pmos w=2u l=0.13u ng=1 m=1
Xxnt0a t0b trk0 gnd gnd sg13_lv_nmos w=1u l=0.13u ng=1 m=1
Xxpt0b t0 t0b vdd vdd sg13_lv_pmos w=4u l=0.13u ng=1 m=1
Xxnt0b t0 t0b gnd gnd sg13_lv_nmos w=2u l=0.13u ng=1 m=1
Xxpt1a t1b trk1 vdd vdd sg13_lv_pmos w=2u l=0.13u ng=1 m=1
Xxnt1a t1b trk1 gnd gnd sg13_lv_nmos w=1u l=0.13u ng=1 m=1
Xxpt1b t1 t1b vdd vdd sg13_lv_pmos w=4u l=0.13u ng=1 m=1
Xxnt1b t1 t1b gnd gnd sg13_lv_nmos w=2u l=0.13u ng=1 m=1
Xxs0p_xms in0p xs0p_g top_p gnd sg13_lv_nmos w=6u l=0.13u ng=2 m=1
Xxs0p_cboot xs0p_cbp xs0p_cbn cap_cmim w=11.49u l=11.49u m=1
Xxs0p_xm1 xs0p_cbn t0b gnd gnd sg13_lv_nmos w=1u l=0.13u ng=1 m=1
Xxs0p_xm3 xs0p_cbp xs0p_g vdd xs0p_cbp sg13_lv_pmos w=1u l=0.13u ng=1 m=1
Xxs0p_xm8 xs0p_g xs0p_x xs0p_cbp xs0p_cbp sg13_lv_pmos w=2u l=0.13u ng=1 m=1
Xxs0p_xm4 xs0p_x t0 vdd vdd sg13_lv_pmos w=0.5u l=0.13u ng=1 m=1
Xxs0p_xm5 xs0p_x t0 xs0p_cbn gnd sg13_lv_nmos w=1u l=0.13u ng=1 m=1
Xxs0p_xm7 xs0p_x xs0p_g xs0p_cbn gnd sg13_lv_nmos w=0.5u l=0.13u ng=1 m=1
Xxs0p_xm9 xs0p_cbn xs0p_g in0p gnd sg13_lv_nmos w=2u l=0.13u ng=1 m=1
Xxs0p_xm10 xs0p_g vdd xs0p_n10 gnd sg13_lv_nmos w=2u l=0.13u ng=1 m=1
Xxs0p_xm11 xs0p_n10 t0b gnd gnd sg13_lv_nmos w=2u l=0.13u ng=1 m=1
Xxs0n_xms in0n xs0n_g top_n gnd sg13_lv_nmos w=6u l=0.13u ng=2 m=1
Xxs0n_cboot xs0n_cbp xs0n_cbn cap_cmim w=11.49u l=11.49u m=1
Xxs0n_xm1 xs0n_cbn t0b gnd gnd sg13_lv_nmos w=1u l=0.13u ng=1 m=1
Xxs0n_xm3 xs0n_cbp xs0n_g vdd xs0n_cbp sg13_lv_pmos w=1u l=0.13u ng=1 m=1
Xxs0n_xm8 xs0n_g xs0n_x xs0n_cbp xs0n_cbp sg13_lv_pmos w=2u l=0.13u ng=1 m=1
Xxs0n_xm4 xs0n_x t0 vdd vdd sg13_lv_pmos w=0.5u l=0.13u ng=1 m=1
Xxs0n_xm5 xs0n_x t0 xs0n_cbn gnd sg13_lv_nmos w=1u l=0.13u ng=1 m=1
Xxs0n_xm7 xs0n_x xs0n_g xs0n_cbn gnd sg13_lv_nmos w=0.5u l=0.13u ng=1 m=1
Xxs0n_xm9 xs0n_cbn xs0n_g in0n gnd sg13_lv_nmos w=2u l=0.13u ng=1 m=1
Xxs0n_xm10 xs0n_g vdd xs0n_n10 gnd sg13_lv_nmos w=2u l=0.13u ng=1 m=1
Xxs0n_xm11 xs0n_n10 t0b gnd gnd sg13_lv_nmos w=2u l=0.13u ng=1 m=1
Xxs1p_xms in1p xs1p_g top_p gnd sg13_lv_nmos w=6u l=0.13u ng=2 m=1
Xxs1p_cboot xs1p_cbp xs1p_cbn cap_cmim w=11.49u l=11.49u m=1
Xxs1p_xm1 xs1p_cbn t1b gnd gnd sg13_lv_nmos w=1u l=0.13u ng=1 m=1
Xxs1p_xm3 xs1p_cbp xs1p_g vdd xs1p_cbp sg13_lv_pmos w=1u l=0.13u ng=1 m=1
Xxs1p_xm8 xs1p_g xs1p_x xs1p_cbp xs1p_cbp sg13_lv_pmos w=2u l=0.13u ng=1 m=1
Xxs1p_xm4 xs1p_x t1 vdd vdd sg13_lv_pmos w=0.5u l=0.13u ng=1 m=1
Xxs1p_xm5 xs1p_x t1 xs1p_cbn gnd sg13_lv_nmos w=1u l=0.13u ng=1 m=1
Xxs1p_xm7 xs1p_x xs1p_g xs1p_cbn gnd sg13_lv_nmos w=0.5u l=0.13u ng=1 m=1
Xxs1p_xm9 xs1p_cbn xs1p_g in1p gnd sg13_lv_nmos w=2u l=0.13u ng=1 m=1
Xxs1p_xm10 xs1p_g vdd xs1p_n10 gnd sg13_lv_nmos w=2u l=0.13u ng=1 m=1
Xxs1p_xm11 xs1p_n10 t1b gnd gnd sg13_lv_nmos w=2u l=0.13u ng=1 m=1
Xxs1n_xms in1n xs1n_g top_n gnd sg13_lv_nmos w=6u l=0.13u ng=2 m=1
Xxs1n_cboot xs1n_cbp xs1n_cbn cap_cmim w=11.49u l=11.49u m=1
Xxs1n_xm1 xs1n_cbn t1b gnd gnd sg13_lv_nmos w=1u l=0.13u ng=1 m=1
Xxs1n_xm3 xs1n_cbp xs1n_g vdd xs1n_cbp sg13_lv_pmos w=1u l=0.13u ng=1 m=1
Xxs1n_xm8 xs1n_g xs1n_x xs1n_cbp xs1n_cbp sg13_lv_pmos w=2u l=0.13u ng=1 m=1
Xxs1n_xm4 xs1n_x t1 vdd vdd sg13_lv_pmos w=0.5u l=0.13u ng=1 m=1
Xxs1n_xm5 xs1n_x t1 xs1n_cbn gnd sg13_lv_nmos w=1u l=0.13u ng=1 m=1
Xxs1n_xm7 xs1n_x xs1n_g xs1n_cbn gnd sg13_lv_nmos w=0.5u l=0.13u ng=1 m=1
Xxs1n_xm9 xs1n_cbn xs1n_g in1n gnd sg13_lv_nmos w=2u l=0.13u ng=1 m=1
Xxs1n_xm10 xs1n_g vdd xs1n_n10 gnd sg13_lv_nmos w=2u l=0.13u ng=1 m=1
Xxs1n_xm11 xs1n_n10 t1b gnd gnd sg13_lv_nmos w=2u l=0.13u ng=1 m=1
Xxpr1 rstb_n t0b vdd vdd sg13_lv_pmos w=1u l=0.13u ng=1 m=1
Xxpr2 rstb_n t1b vdd vdd sg13_lv_pmos w=1u l=0.13u ng=1 m=1
Xxnr1 rstb_n t0b nr gnd sg13_lv_nmos w=1u l=0.13u ng=1 m=1
Xxnr2 nr t1b gnd gnd sg13_lv_nmos w=1u l=0.13u ng=1 m=1
Xxpr3 rstb rstb_n vdd vdd sg13_lv_pmos w=1u l=0.13u ng=1 m=1
Xxnr3 rstb rstb_n gnd gnd sg13_lv_nmos w=0.5u l=0.13u ng=1 m=1
Xxlrp lsb_p rstb vrefl vrefl sg13_lv_pmos w=1u l=0.13u ng=1 m=1
Xxlrn lsb_n rstb vrefl vrefl sg13_lv_pmos w=1u l=0.13u ng=1 m=1
Xxdp12_xmp bp12 cp12 vref vref sg13_lv_pmos w=2u l=0.13u ng=1 m=1
Xxdp12_xmn bp12 cp12 gnd gnd sg13_lv_nmos w=1u l=0.13u ng=1 m=1
Xxdp11_xmp bp11 cp11 vref vref sg13_lv_pmos w=2u l=0.13u ng=1 m=1
Xxdp11_xmn bp11 cp11 gnd gnd sg13_lv_nmos w=1u l=0.13u ng=1 m=1
Xxdp10_xmp bp10 cp10 vref vref sg13_lv_pmos w=2u l=0.13u ng=1 m=1
Xxdp10_xmn bp10 cp10 gnd gnd sg13_lv_nmos w=1u l=0.13u ng=1 m=1
Xxdp9_xmp bp9 cp9 vref vref sg13_lv_pmos w=1u l=0.13u ng=1 m=1
Xxdp9_xmn bp9 cp9 gnd gnd sg13_lv_nmos w=0.5u l=0.13u ng=1 m=1
Xxdp8_xmp bp8 cp8 vref vref sg13_lv_pmos w=1u l=0.13u ng=1 m=1
Xxdp8_xmn bp8 cp8 gnd gnd sg13_lv_nmos w=0.5u l=0.13u ng=1 m=1
Xxdp7_xmp bp7 cp7 vrefl vrefl sg13_lv_pmos w=1u l=0.13u ng=1 m=1
Xxdp7_xmn bp7 cp7 gnd gnd sg13_lv_nmos w=0.5u l=0.13u ng=1 m=1
Xxdp6_xmp bp6 cp6 vrefl vrefl sg13_lv_pmos w=1u l=0.13u ng=1 m=1
Xxdp6_xmn bp6 cp6 gnd gnd sg13_lv_nmos w=0.5u l=0.13u ng=1 m=1
Xxdp5_xmp bp5 cp5 vrefl vrefl sg13_lv_pmos w=1u l=0.13u ng=1 m=1
Xxdp5_xmn bp5 cp5 gnd gnd sg13_lv_nmos w=0.5u l=0.13u ng=1 m=1
Xxdp4_xmp bp4 cp4 vrefl vrefl sg13_lv_pmos w=1u l=0.13u ng=1 m=1
Xxdp4_xmn bp4 cp4 gnd gnd sg13_lv_nmos w=0.5u l=0.13u ng=1 m=1
Xxdp3_xmp bp3 cp3 vrefl vrefl sg13_lv_pmos w=1u l=0.13u ng=1 m=1
Xxdp3_xmn bp3 cp3 gnd gnd sg13_lv_nmos w=0.5u l=0.13u ng=1 m=1
Xxdp2_xmp bp2 cp2 vrefl vrefl sg13_lv_pmos w=1u l=0.13u ng=1 m=1
Xxdp2_xmn bp2 cp2 gnd gnd sg13_lv_nmos w=0.5u l=0.13u ng=1 m=1
Xxdp1_xmp bp1 cp1 vrefl vrefl sg13_lv_pmos w=1u l=0.13u ng=1 m=1
Xxdp1_xmn bp1 cp1 gnd gnd sg13_lv_nmos w=0.5u l=0.13u ng=1 m=1
Xxdp0_xmp bp0 cp0 vrefl vrefl sg13_lv_pmos w=1u l=0.13u ng=1 m=1
Xxdp0_xmn bp0 cp0 gnd gnd sg13_lv_nmos w=0.5u l=0.13u ng=1 m=1
Xxdn12_xmp bn12 cn12 vref vref sg13_lv_pmos w=2u l=0.13u ng=1 m=1
Xxdn12_xmn bn12 cn12 gnd gnd sg13_lv_nmos w=1u l=0.13u ng=1 m=1
Xxdn11_xmp bn11 cn11 vref vref sg13_lv_pmos w=2u l=0.13u ng=1 m=1
Xxdn11_xmn bn11 cn11 gnd gnd sg13_lv_nmos w=1u l=0.13u ng=1 m=1
Xxdn10_xmp bn10 cn10 vref vref sg13_lv_pmos w=2u l=0.13u ng=1 m=1
Xxdn10_xmn bn10 cn10 gnd gnd sg13_lv_nmos w=1u l=0.13u ng=1 m=1
Xxdn9_xmp bn9 cn9 vref vref sg13_lv_pmos w=1u l=0.13u ng=1 m=1
Xxdn9_xmn bn9 cn9 gnd gnd sg13_lv_nmos w=0.5u l=0.13u ng=1 m=1
Xxdn8_xmp bn8 cn8 vref vref sg13_lv_pmos w=1u l=0.13u ng=1 m=1
Xxdn8_xmn bn8 cn8 gnd gnd sg13_lv_nmos w=0.5u l=0.13u ng=1 m=1
Xxdn7_xmp bn7 cn7 vrefl vrefl sg13_lv_pmos w=1u l=0.13u ng=1 m=1
Xxdn7_xmn bn7 cn7 gnd gnd sg13_lv_nmos w=0.5u l=0.13u ng=1 m=1
Xxdn6_xmp bn6 cn6 vrefl vrefl sg13_lv_pmos w=1u l=0.13u ng=1 m=1
Xxdn6_xmn bn6 cn6 gnd gnd sg13_lv_nmos w=0.5u l=0.13u ng=1 m=1
Xxdn5_xmp bn5 cn5 vrefl vrefl sg13_lv_pmos w=1u l=0.13u ng=1 m=1
Xxdn5_xmn bn5 cn5 gnd gnd sg13_lv_nmos w=0.5u l=0.13u ng=1 m=1
Xxdn4_xmp bn4 cn4 vrefl vrefl sg13_lv_pmos w=1u l=0.13u ng=1 m=1
Xxdn4_xmn bn4 cn4 gnd gnd sg13_lv_nmos w=0.5u l=0.13u ng=1 m=1
Xxdn3_xmp bn3 cn3 vrefl vrefl sg13_lv_pmos w=1u l=0.13u ng=1 m=1
Xxdn3_xmn bn3 cn3 gnd gnd sg13_lv_nmos w=0.5u l=0.13u ng=1 m=1
Xxdn2_xmp bn2 cn2 vrefl vrefl sg13_lv_pmos w=1u l=0.13u ng=1 m=1
Xxdn2_xmn bn2 cn2 gnd gnd sg13_lv_nmos w=0.5u l=0.13u ng=1 m=1
Xxdn1_xmp bn1 cn1 vrefl vrefl sg13_lv_pmos w=1u l=0.13u ng=1 m=1
Xxdn1_xmn bn1 cn1 gnd gnd sg13_lv_nmos w=0.5u l=0.13u ng=1 m=1
Xxdn0_xmp bn0 cn0 vrefl vrefl sg13_lv_pmos w=1u l=0.13u ng=1 m=1
Xxdn0_xmn bn0 cn0 gnd gnd sg13_lv_nmos w=0.5u l=0.13u ng=1 m=1
Xxc4_xs1_xmt1 xc4_xs1_tail0 clkb vdd vdd sg13_lv_pmos w=16u l=0.13u ng=4 m=1
Xxc4_xs1_xmtc xc4_xs1_tail vbp xc4_xs1_tail0 vdd sg13_lv_pmos w=16u l=0.5u ng=4 m=1
Xxc4_xs1_xm1 xc4_dip top_p xc4_xs1_tail vdd sg13_lv_pmos w=48u l=0.3u ng=12 m=1
Xxc4_xs1_xm2 xc4_din top_n xc4_xs1_tail vdd sg13_lv_pmos w=48u l=0.3u ng=12 m=1
Xxc4_xci1 vdd xc4_dip vdd vdd sg13_lv_pmos w=80u l=4u ng=8 m=1
Xxc4_xci2 vdd xc4_din vdd vdd sg13_lv_pmos w=80u l=4u ng=8 m=1
Xxc4_xmr1 xc4_dip clkb gnd gnd sg13_lv_nmos w=20u l=0.13u ng=2 m=1
Xxc4_xmr2 xc4_din clkb gnd gnd sg13_lv_nmos w=20u l=0.13u ng=2 m=1
Xxc4_xmt2 xc4_lt clk gnd gnd sg13_lv_nmos w=4u l=0.13u ng=1 m=1
Xxc4_xmn1 op on xc4_lt gnd sg13_lv_nmos w=2u l=0.13u ng=1 m=1
Xxc4_xmn2 on op xc4_lt gnd sg13_lv_nmos w=2u l=0.13u ng=1 m=1
Xxc4_xmp1 op on vdd vdd sg13_lv_pmos w=2u l=0.13u ng=1 m=1
Xxc4_xmp2 on op vdd vdd sg13_lv_pmos w=2u l=0.13u ng=1 m=1
Xxc4_xmh1 op xc4_dip vdd vdd sg13_lv_pmos w=8u l=0.13u ng=2 m=1
Xxc4_xmh2 on xc4_din vdd vdd sg13_lv_pmos w=8u l=0.13u ng=2 m=1
Xxc4_xbp1 xc4_outpb op vdd vdd sg13_lv_pmos w=1u l=0.13u ng=1 m=1
Xxc4_xbn1 xc4_outpb op gnd gnd sg13_lv_nmos w=0.5u l=0.13u ng=1 m=1
Xxc4_xbp2 xc4_outnb on vdd vdd sg13_lv_pmos w=1u l=0.13u ng=1 m=1
Xxc4_xbn2 xc4_outnb on gnd gnd sg13_lv_nmos w=0.5u l=0.13u ng=1 m=1
Xxc5_xs1_xmt1 xc5_xs1_tail0 clkn gnd gnd sg13_lv_nmos w=8u l=0.13u ng=2 m=1
Xxc5_xs1_xmtc xc5_xs1_tail vbn xc5_xs1_tail0 gnd sg13_lv_nmos w=4u l=0.5u ng=1 m=1
Xxc5_xs1_xm1 xc5_dip top_p xc5_xs1_tail gnd sg13_lv_nmos w=16u l=0.5u ng=4 m=1
Xxc5_xs1_xm2 xc5_din top_n xc5_xs1_tail gnd sg13_lv_nmos w=16u l=0.5u ng=4 m=1
Xxc5_xci1 gnd xc5_dip gnd gnd sg13_lv_nmos w=30u l=4u ng=4 m=1
Xxc5_xci2 gnd xc5_din gnd gnd sg13_lv_nmos w=30u l=4u ng=4 m=1
Xxc5_xmr1 xc5_dip clkn vdd vdd sg13_lv_pmos w=16u l=0.13u ng=2 m=1
Xxc5_xmr2 xc5_din clkn vdd vdd sg13_lv_pmos w=16u l=0.13u ng=2 m=1
Xxc5_xmt2 xc5_lt clknb vdd vdd sg13_lv_pmos w=8u l=0.13u ng=1 m=1
Xxc5_xmp1 onp onn xc5_lt vdd sg13_lv_pmos w=4u l=0.13u ng=1 m=1
Xxc5_xmp2 onn onp xc5_lt vdd sg13_lv_pmos w=4u l=0.13u ng=1 m=1
Xxc5_xmn1 onp onn gnd gnd sg13_lv_nmos w=1u l=0.13u ng=1 m=1
Xxc5_xmn2 onn onp gnd gnd sg13_lv_nmos w=1u l=0.13u ng=1 m=1
Xxc5_xmh1 onp xc5_dip gnd gnd sg13_lv_nmos w=8u l=0.13u ng=1 m=1
Xxc5_xmh2 onn xc5_din gnd gnd sg13_lv_nmos w=8u l=0.13u ng=1 m=1
Xxc5_xbp1 xc5_outpb onp vdd vdd sg13_lv_pmos w=1u l=0.13u ng=1 m=1
Xxc5_xbn1 xc5_outpb onp gnd gnd sg13_lv_nmos w=0.5u l=0.13u ng=1 m=1
Xxc5_xbp2 xc5_outnb onn vdd vdd sg13_lv_pmos w=1u l=0.13u ng=1 m=1
Xxc5_xbn2 xc5_outnb onn gnd gnd sg13_lv_nmos w=0.5u l=0.13u ng=1 m=1
Xxdacp_xc12_u0 top_p bp12 cap_cmim w=3.78u l=3.78u m=1
Xxdacp_xc12_u1 top_p bp12 cap_cmim w=3.78u l=3.78u m=1
Xxdacp_xc12_u2 top_p bp12 cap_cmim w=3.78u l=3.78u m=1
Xxdacp_xc12_u3 top_p bp12 cap_cmim w=3.78u l=3.78u m=1
Xxdacp_xc12_u4 top_p bp12 cap_cmim w=3.78u l=3.78u m=1
Xxdacp_xc12_u5 top_p bp12 cap_cmim w=3.78u l=3.78u m=1
Xxdacp_xc12_u6 top_p bp12 cap_cmim w=3.78u l=3.78u m=1
Xxdacp_xc12_u7 top_p bp12 cap_cmim w=3.78u l=3.78u m=1
Xxdacp_xc12_u8 top_p bp12 cap_cmim w=3.78u l=3.78u m=1
Xxdacp_xc12_u9 top_p bp12 cap_cmim w=3.78u l=3.78u m=1
Xxdacp_xc12_u10 top_p bp12 cap_cmim w=3.78u l=3.78u m=1
Xxdacp_xc12_u11 top_p bp12 cap_cmim w=3.78u l=3.78u m=1
Xxdacp_xc12_u12 top_p bp12 cap_cmim w=3.78u l=3.78u m=1
Xxdacp_xc12_u13 top_p bp12 cap_cmim w=3.78u l=3.78u m=1
Xxdacp_xc12_u14 top_p bp12 cap_cmim w=3.78u l=3.78u m=1
Xxdacp_xc12_u15 top_p bp12 cap_cmim w=3.78u l=3.78u m=1
Xxdacp_xc11_u0 top_p bp11 cap_cmim w=3.78u l=3.78u m=1
Xxdacp_xc11_u1 top_p bp11 cap_cmim w=3.78u l=3.78u m=1
Xxdacp_xc11_u2 top_p bp11 cap_cmim w=3.78u l=3.78u m=1
Xxdacp_xc11_u3 top_p bp11 cap_cmim w=3.78u l=3.78u m=1
Xxdacp_xc11_u4 top_p bp11 cap_cmim w=3.78u l=3.78u m=1
Xxdacp_xc11_u5 top_p bp11 cap_cmim w=3.78u l=3.78u m=1
Xxdacp_xc11_u6 top_p bp11 cap_cmim w=3.78u l=3.78u m=1
Xxdacp_xc11_u7 top_p bp11 cap_cmim w=3.78u l=3.78u m=1
Xxdacp_xc10_u0 top_p bp10 cap_cmim w=3.78u l=3.78u m=1
Xxdacp_xc10_u1 top_p bp10 cap_cmim w=3.78u l=3.78u m=1
Xxdacp_xc10_u2 top_p bp10 cap_cmim w=3.78u l=3.78u m=1
Xxdacp_xc10_u3 top_p bp10 cap_cmim w=3.78u l=3.78u m=1
Xxdacp_xc9_u0 top_p bp9 cap_cmim w=3.78u l=3.78u m=1
Xxdacp_xc9_u1 top_p bp9 cap_cmim w=3.78u l=3.78u m=1
Xxdacp_xc8_u0 top_p bp8 cap_cmim w=3.78u l=3.78u m=1
Xxdacp_xcb top_p lsb_p cap_cmim w=4.23u l=4.23u m=1
Xxdacp_xc7_u0 lsb_p bp7 cap_cmim w=3.78u l=3.78u m=1
Xxdacp_xc7_u1 lsb_p bp7 cap_cmim w=3.78u l=3.78u m=1
Xxdacp_xc7_u2 lsb_p bp7 cap_cmim w=3.78u l=3.78u m=1
Xxdacp_xc7_u3 lsb_p bp7 cap_cmim w=3.78u l=3.78u m=1
Xxdacp_xc7_u4 lsb_p bp7 cap_cmim w=3.78u l=3.78u m=1
Xxdacp_xc7_u5 lsb_p bp7 cap_cmim w=3.78u l=3.78u m=1
Xxdacp_xc7_u6 lsb_p bp7 cap_cmim w=3.78u l=3.78u m=1
Xxdacp_xc7_u7 lsb_p bp7 cap_cmim w=3.78u l=3.78u m=1
Xxdacp_xc7_u8 lsb_p bp7 cap_cmim w=3.78u l=3.78u m=1
Xxdacp_xc7_u9 lsb_p bp7 cap_cmim w=3.78u l=3.78u m=1
Xxdacp_xc7_u10 lsb_p bp7 cap_cmim w=3.78u l=3.78u m=1
Xxdacp_xc7_u11 lsb_p bp7 cap_cmim w=3.78u l=3.78u m=1
Xxdacp_xc7_u12 lsb_p bp7 cap_cmim w=3.78u l=3.78u m=1
Xxdacp_xc7_u13 lsb_p bp7 cap_cmim w=3.78u l=3.78u m=1
Xxdacp_xc7_u14 lsb_p bp7 cap_cmim w=3.78u l=3.78u m=1
Xxdacp_xc7_u15 lsb_p bp7 cap_cmim w=3.78u l=3.78u m=1
Xxdacp_xc7_u16 lsb_p bp7 cap_cmim w=3.78u l=3.78u m=1
Xxdacp_xc7_u17 lsb_p bp7 cap_cmim w=3.78u l=3.78u m=1
Xxdacp_xc7_u18 lsb_p bp7 cap_cmim w=3.78u l=3.78u m=1
Xxdacp_xc7_u19 lsb_p bp7 cap_cmim w=3.78u l=3.78u m=1
Xxdacp_xc7_u20 lsb_p bp7 cap_cmim w=3.78u l=3.78u m=1
Xxdacp_xc7_u21 lsb_p bp7 cap_cmim w=3.78u l=3.78u m=1
Xxdacp_xc7_u22 lsb_p bp7 cap_cmim w=3.78u l=3.78u m=1
Xxdacp_xc7_u23 lsb_p bp7 cap_cmim w=3.78u l=3.78u m=1
Xxdacp_xc7_u24 lsb_p bp7 cap_cmim w=3.78u l=3.78u m=1
Xxdacp_xc7_u25 lsb_p bp7 cap_cmim w=3.78u l=3.78u m=1
Xxdacp_xc7_u26 lsb_p bp7 cap_cmim w=3.78u l=3.78u m=1
Xxdacp_xc7_u27 lsb_p bp7 cap_cmim w=3.78u l=3.78u m=1
Xxdacp_xc7_u28 lsb_p bp7 cap_cmim w=3.78u l=3.78u m=1
Xxdacp_xc7_u29 lsb_p bp7 cap_cmim w=3.78u l=3.78u m=1
Xxdacp_xc7_u30 lsb_p bp7 cap_cmim w=3.78u l=3.78u m=1
Xxdacp_xc7_u31 lsb_p bp7 cap_cmim w=3.78u l=3.78u m=1
Xxdacp_xc7_u32 lsb_p bp7 cap_cmim w=3.78u l=3.78u m=1
Xxdacp_xc7_u33 lsb_p bp7 cap_cmim w=3.78u l=3.78u m=1
Xxdacp_xc7_u34 lsb_p bp7 cap_cmim w=3.78u l=3.78u m=1
Xxdacp_xc7_u35 lsb_p bp7 cap_cmim w=3.78u l=3.78u m=1
Xxdacp_xc7_u36 lsb_p bp7 cap_cmim w=3.78u l=3.78u m=1
Xxdacp_xc7_u37 lsb_p bp7 cap_cmim w=3.78u l=3.78u m=1
Xxdacp_xc7_u38 lsb_p bp7 cap_cmim w=3.78u l=3.78u m=1
Xxdacp_xc7_u39 lsb_p bp7 cap_cmim w=3.78u l=3.78u m=1
Xxdacp_xc7_u40 lsb_p bp7 cap_cmim w=3.78u l=3.78u m=1
Xxdacp_xc7_u41 lsb_p bp7 cap_cmim w=3.78u l=3.78u m=1
Xxdacp_xc7_u42 lsb_p bp7 cap_cmim w=3.78u l=3.78u m=1
Xxdacp_xc7_u43 lsb_p bp7 cap_cmim w=3.78u l=3.78u m=1
Xxdacp_xc7_u44 lsb_p bp7 cap_cmim w=3.78u l=3.78u m=1
Xxdacp_xc7_u45 lsb_p bp7 cap_cmim w=3.78u l=3.78u m=1
Xxdacp_xc7_u46 lsb_p bp7 cap_cmim w=3.78u l=3.78u m=1
Xxdacp_xc7_u47 lsb_p bp7 cap_cmim w=3.78u l=3.78u m=1
Xxdacp_xc7_u48 lsb_p bp7 cap_cmim w=3.78u l=3.78u m=1
Xxdacp_xc7_u49 lsb_p bp7 cap_cmim w=3.78u l=3.78u m=1
Xxdacp_xc7_u50 lsb_p bp7 cap_cmim w=3.78u l=3.78u m=1
Xxdacp_xc7_u51 lsb_p bp7 cap_cmim w=3.78u l=3.78u m=1
Xxdacp_xc7_u52 lsb_p bp7 cap_cmim w=3.78u l=3.78u m=1
Xxdacp_xc7_u53 lsb_p bp7 cap_cmim w=3.78u l=3.78u m=1
Xxdacp_xc7_u54 lsb_p bp7 cap_cmim w=3.78u l=3.78u m=1
Xxdacp_xc7_u55 lsb_p bp7 cap_cmim w=3.78u l=3.78u m=1
Xxdacp_xc7_u56 lsb_p bp7 cap_cmim w=3.78u l=3.78u m=1
Xxdacp_xc7_u57 lsb_p bp7 cap_cmim w=3.78u l=3.78u m=1
Xxdacp_xc7_u58 lsb_p bp7 cap_cmim w=3.78u l=3.78u m=1
Xxdacp_xc7_u59 lsb_p bp7 cap_cmim w=3.78u l=3.78u m=1
Xxdacp_xc7_u60 lsb_p bp7 cap_cmim w=3.78u l=3.78u m=1
Xxdacp_xc7_u61 lsb_p bp7 cap_cmim w=3.78u l=3.78u m=1
Xxdacp_xc7_u62 lsb_p bp7 cap_cmim w=3.78u l=3.78u m=1
Xxdacp_xc7_u63 lsb_p bp7 cap_cmim w=3.78u l=3.78u m=1
Xxdacp_xc6_u0 lsb_p bp6 cap_cmim w=3.78u l=3.78u m=1
Xxdacp_xc6_u1 lsb_p bp6 cap_cmim w=3.78u l=3.78u m=1
Xxdacp_xc6_u2 lsb_p bp6 cap_cmim w=3.78u l=3.78u m=1
Xxdacp_xc6_u3 lsb_p bp6 cap_cmim w=3.78u l=3.78u m=1
Xxdacp_xc6_u4 lsb_p bp6 cap_cmim w=3.78u l=3.78u m=1
Xxdacp_xc6_u5 lsb_p bp6 cap_cmim w=3.78u l=3.78u m=1
Xxdacp_xc6_u6 lsb_p bp6 cap_cmim w=3.78u l=3.78u m=1
Xxdacp_xc6_u7 lsb_p bp6 cap_cmim w=3.78u l=3.78u m=1
Xxdacp_xc6_u8 lsb_p bp6 cap_cmim w=3.78u l=3.78u m=1
Xxdacp_xc6_u9 lsb_p bp6 cap_cmim w=3.78u l=3.78u m=1
Xxdacp_xc6_u10 lsb_p bp6 cap_cmim w=3.78u l=3.78u m=1
Xxdacp_xc6_u11 lsb_p bp6 cap_cmim w=3.78u l=3.78u m=1
Xxdacp_xc6_u12 lsb_p bp6 cap_cmim w=3.78u l=3.78u m=1
Xxdacp_xc6_u13 lsb_p bp6 cap_cmim w=3.78u l=3.78u m=1
Xxdacp_xc6_u14 lsb_p bp6 cap_cmim w=3.78u l=3.78u m=1
Xxdacp_xc6_u15 lsb_p bp6 cap_cmim w=3.78u l=3.78u m=1
Xxdacp_xc6_u16 lsb_p bp6 cap_cmim w=3.78u l=3.78u m=1
Xxdacp_xc6_u17 lsb_p bp6 cap_cmim w=3.78u l=3.78u m=1
Xxdacp_xc6_u18 lsb_p bp6 cap_cmim w=3.78u l=3.78u m=1
Xxdacp_xc6_u19 lsb_p bp6 cap_cmim w=3.78u l=3.78u m=1
Xxdacp_xc6_u20 lsb_p bp6 cap_cmim w=3.78u l=3.78u m=1
Xxdacp_xc6_u21 lsb_p bp6 cap_cmim w=3.78u l=3.78u m=1
Xxdacp_xc6_u22 lsb_p bp6 cap_cmim w=3.78u l=3.78u m=1
Xxdacp_xc6_u23 lsb_p bp6 cap_cmim w=3.78u l=3.78u m=1
Xxdacp_xc6_u24 lsb_p bp6 cap_cmim w=3.78u l=3.78u m=1
Xxdacp_xc6_u25 lsb_p bp6 cap_cmim w=3.78u l=3.78u m=1
Xxdacp_xc6_u26 lsb_p bp6 cap_cmim w=3.78u l=3.78u m=1
Xxdacp_xc6_u27 lsb_p bp6 cap_cmim w=3.78u l=3.78u m=1
Xxdacp_xc6_u28 lsb_p bp6 cap_cmim w=3.78u l=3.78u m=1
Xxdacp_xc6_u29 lsb_p bp6 cap_cmim w=3.78u l=3.78u m=1
Xxdacp_xc6_u30 lsb_p bp6 cap_cmim w=3.78u l=3.78u m=1
Xxdacp_xc6_u31 lsb_p bp6 cap_cmim w=3.78u l=3.78u m=1
Xxdacp_xc5_u0 lsb_p bp5 cap_cmim w=3.78u l=3.78u m=1
Xxdacp_xc5_u1 lsb_p bp5 cap_cmim w=3.78u l=3.78u m=1
Xxdacp_xc5_u2 lsb_p bp5 cap_cmim w=3.78u l=3.78u m=1
Xxdacp_xc5_u3 lsb_p bp5 cap_cmim w=3.78u l=3.78u m=1
Xxdacp_xc5_u4 lsb_p bp5 cap_cmim w=3.78u l=3.78u m=1
Xxdacp_xc5_u5 lsb_p bp5 cap_cmim w=3.78u l=3.78u m=1
Xxdacp_xc5_u6 lsb_p bp5 cap_cmim w=3.78u l=3.78u m=1
Xxdacp_xc5_u7 lsb_p bp5 cap_cmim w=3.78u l=3.78u m=1
Xxdacp_xc5_u8 lsb_p bp5 cap_cmim w=3.78u l=3.78u m=1
Xxdacp_xc5_u9 lsb_p bp5 cap_cmim w=3.78u l=3.78u m=1
Xxdacp_xc5_u10 lsb_p bp5 cap_cmim w=3.78u l=3.78u m=1
Xxdacp_xc5_u11 lsb_p bp5 cap_cmim w=3.78u l=3.78u m=1
Xxdacp_xc5_u12 lsb_p bp5 cap_cmim w=3.78u l=3.78u m=1
Xxdacp_xc5_u13 lsb_p bp5 cap_cmim w=3.78u l=3.78u m=1
Xxdacp_xc5_u14 lsb_p bp5 cap_cmim w=3.78u l=3.78u m=1
Xxdacp_xc5_u15 lsb_p bp5 cap_cmim w=3.78u l=3.78u m=1
Xxdacp_xc4_u0 lsb_p bp4 cap_cmim w=3.78u l=3.78u m=1
Xxdacp_xc4_u1 lsb_p bp4 cap_cmim w=3.78u l=3.78u m=1
Xxdacp_xc4_u2 lsb_p bp4 cap_cmim w=3.78u l=3.78u m=1
Xxdacp_xc4_u3 lsb_p bp4 cap_cmim w=3.78u l=3.78u m=1
Xxdacp_xc4_u4 lsb_p bp4 cap_cmim w=3.78u l=3.78u m=1
Xxdacp_xc4_u5 lsb_p bp4 cap_cmim w=3.78u l=3.78u m=1
Xxdacp_xc4_u6 lsb_p bp4 cap_cmim w=3.78u l=3.78u m=1
Xxdacp_xc4_u7 lsb_p bp4 cap_cmim w=3.78u l=3.78u m=1
Xxdacp_xc3_u0 lsb_p bp3 cap_cmim w=3.78u l=3.78u m=1
Xxdacp_xc3_u1 lsb_p bp3 cap_cmim w=3.78u l=3.78u m=1
Xxdacp_xc3_u2 lsb_p bp3 cap_cmim w=3.78u l=3.78u m=1
Xxdacp_xc3_u3 lsb_p bp3 cap_cmim w=3.78u l=3.78u m=1
Xxdacp_xc2_u0 lsb_p bp2 cap_cmim w=3.78u l=3.78u m=1
Xxdacp_xc2_u1 lsb_p bp2 cap_cmim w=3.78u l=3.78u m=1
Xxdacp_xc1_u0 lsb_p bp1 cap_cmim w=3.78u l=3.78u m=1
Xxdacp_xc0 lsb_p bp0 cap_cmim w=2.67u l=2.67u m=1
Xxdacn_xc12_u0 top_n bn12 cap_cmim w=3.78u l=3.78u m=1
Xxdacn_xc12_u1 top_n bn12 cap_cmim w=3.78u l=3.78u m=1
Xxdacn_xc12_u2 top_n bn12 cap_cmim w=3.78u l=3.78u m=1
Xxdacn_xc12_u3 top_n bn12 cap_cmim w=3.78u l=3.78u m=1
Xxdacn_xc12_u4 top_n bn12 cap_cmim w=3.78u l=3.78u m=1
Xxdacn_xc12_u5 top_n bn12 cap_cmim w=3.78u l=3.78u m=1
Xxdacn_xc12_u6 top_n bn12 cap_cmim w=3.78u l=3.78u m=1
Xxdacn_xc12_u7 top_n bn12 cap_cmim w=3.78u l=3.78u m=1
Xxdacn_xc12_u8 top_n bn12 cap_cmim w=3.78u l=3.78u m=1
Xxdacn_xc12_u9 top_n bn12 cap_cmim w=3.78u l=3.78u m=1
Xxdacn_xc12_u10 top_n bn12 cap_cmim w=3.78u l=3.78u m=1
Xxdacn_xc12_u11 top_n bn12 cap_cmim w=3.78u l=3.78u m=1
Xxdacn_xc12_u12 top_n bn12 cap_cmim w=3.78u l=3.78u m=1
Xxdacn_xc12_u13 top_n bn12 cap_cmim w=3.78u l=3.78u m=1
Xxdacn_xc12_u14 top_n bn12 cap_cmim w=3.78u l=3.78u m=1
Xxdacn_xc12_u15 top_n bn12 cap_cmim w=3.78u l=3.78u m=1
Xxdacn_xc11_u0 top_n bn11 cap_cmim w=3.78u l=3.78u m=1
Xxdacn_xc11_u1 top_n bn11 cap_cmim w=3.78u l=3.78u m=1
Xxdacn_xc11_u2 top_n bn11 cap_cmim w=3.78u l=3.78u m=1
Xxdacn_xc11_u3 top_n bn11 cap_cmim w=3.78u l=3.78u m=1
Xxdacn_xc11_u4 top_n bn11 cap_cmim w=3.78u l=3.78u m=1
Xxdacn_xc11_u5 top_n bn11 cap_cmim w=3.78u l=3.78u m=1
Xxdacn_xc11_u6 top_n bn11 cap_cmim w=3.78u l=3.78u m=1
Xxdacn_xc11_u7 top_n bn11 cap_cmim w=3.78u l=3.78u m=1
Xxdacn_xc10_u0 top_n bn10 cap_cmim w=3.78u l=3.78u m=1
Xxdacn_xc10_u1 top_n bn10 cap_cmim w=3.78u l=3.78u m=1
Xxdacn_xc10_u2 top_n bn10 cap_cmim w=3.78u l=3.78u m=1
Xxdacn_xc10_u3 top_n bn10 cap_cmim w=3.78u l=3.78u m=1
Xxdacn_xc9_u0 top_n bn9 cap_cmim w=3.78u l=3.78u m=1
Xxdacn_xc9_u1 top_n bn9 cap_cmim w=3.78u l=3.78u m=1
Xxdacn_xc8_u0 top_n bn8 cap_cmim w=3.78u l=3.78u m=1
Xxdacn_xcb top_n lsb_n cap_cmim w=4.23u l=4.23u m=1
Xxdacn_xc7_u0 lsb_n bn7 cap_cmim w=3.78u l=3.78u m=1
Xxdacn_xc7_u1 lsb_n bn7 cap_cmim w=3.78u l=3.78u m=1
Xxdacn_xc7_u2 lsb_n bn7 cap_cmim w=3.78u l=3.78u m=1
Xxdacn_xc7_u3 lsb_n bn7 cap_cmim w=3.78u l=3.78u m=1
Xxdacn_xc7_u4 lsb_n bn7 cap_cmim w=3.78u l=3.78u m=1
Xxdacn_xc7_u5 lsb_n bn7 cap_cmim w=3.78u l=3.78u m=1
Xxdacn_xc7_u6 lsb_n bn7 cap_cmim w=3.78u l=3.78u m=1
Xxdacn_xc7_u7 lsb_n bn7 cap_cmim w=3.78u l=3.78u m=1
Xxdacn_xc7_u8 lsb_n bn7 cap_cmim w=3.78u l=3.78u m=1
Xxdacn_xc7_u9 lsb_n bn7 cap_cmim w=3.78u l=3.78u m=1
Xxdacn_xc7_u10 lsb_n bn7 cap_cmim w=3.78u l=3.78u m=1
Xxdacn_xc7_u11 lsb_n bn7 cap_cmim w=3.78u l=3.78u m=1
Xxdacn_xc7_u12 lsb_n bn7 cap_cmim w=3.78u l=3.78u m=1
Xxdacn_xc7_u13 lsb_n bn7 cap_cmim w=3.78u l=3.78u m=1
Xxdacn_xc7_u14 lsb_n bn7 cap_cmim w=3.78u l=3.78u m=1
Xxdacn_xc7_u15 lsb_n bn7 cap_cmim w=3.78u l=3.78u m=1
Xxdacn_xc7_u16 lsb_n bn7 cap_cmim w=3.78u l=3.78u m=1
Xxdacn_xc7_u17 lsb_n bn7 cap_cmim w=3.78u l=3.78u m=1
Xxdacn_xc7_u18 lsb_n bn7 cap_cmim w=3.78u l=3.78u m=1
Xxdacn_xc7_u19 lsb_n bn7 cap_cmim w=3.78u l=3.78u m=1
Xxdacn_xc7_u20 lsb_n bn7 cap_cmim w=3.78u l=3.78u m=1
Xxdacn_xc7_u21 lsb_n bn7 cap_cmim w=3.78u l=3.78u m=1
Xxdacn_xc7_u22 lsb_n bn7 cap_cmim w=3.78u l=3.78u m=1
Xxdacn_xc7_u23 lsb_n bn7 cap_cmim w=3.78u l=3.78u m=1
Xxdacn_xc7_u24 lsb_n bn7 cap_cmim w=3.78u l=3.78u m=1
Xxdacn_xc7_u25 lsb_n bn7 cap_cmim w=3.78u l=3.78u m=1
Xxdacn_xc7_u26 lsb_n bn7 cap_cmim w=3.78u l=3.78u m=1
Xxdacn_xc7_u27 lsb_n bn7 cap_cmim w=3.78u l=3.78u m=1
Xxdacn_xc7_u28 lsb_n bn7 cap_cmim w=3.78u l=3.78u m=1
Xxdacn_xc7_u29 lsb_n bn7 cap_cmim w=3.78u l=3.78u m=1
Xxdacn_xc7_u30 lsb_n bn7 cap_cmim w=3.78u l=3.78u m=1
Xxdacn_xc7_u31 lsb_n bn7 cap_cmim w=3.78u l=3.78u m=1
Xxdacn_xc7_u32 lsb_n bn7 cap_cmim w=3.78u l=3.78u m=1
Xxdacn_xc7_u33 lsb_n bn7 cap_cmim w=3.78u l=3.78u m=1
Xxdacn_xc7_u34 lsb_n bn7 cap_cmim w=3.78u l=3.78u m=1
Xxdacn_xc7_u35 lsb_n bn7 cap_cmim w=3.78u l=3.78u m=1
Xxdacn_xc7_u36 lsb_n bn7 cap_cmim w=3.78u l=3.78u m=1
Xxdacn_xc7_u37 lsb_n bn7 cap_cmim w=3.78u l=3.78u m=1
Xxdacn_xc7_u38 lsb_n bn7 cap_cmim w=3.78u l=3.78u m=1
Xxdacn_xc7_u39 lsb_n bn7 cap_cmim w=3.78u l=3.78u m=1
Xxdacn_xc7_u40 lsb_n bn7 cap_cmim w=3.78u l=3.78u m=1
Xxdacn_xc7_u41 lsb_n bn7 cap_cmim w=3.78u l=3.78u m=1
Xxdacn_xc7_u42 lsb_n bn7 cap_cmim w=3.78u l=3.78u m=1
Xxdacn_xc7_u43 lsb_n bn7 cap_cmim w=3.78u l=3.78u m=1
Xxdacn_xc7_u44 lsb_n bn7 cap_cmim w=3.78u l=3.78u m=1
Xxdacn_xc7_u45 lsb_n bn7 cap_cmim w=3.78u l=3.78u m=1
Xxdacn_xc7_u46 lsb_n bn7 cap_cmim w=3.78u l=3.78u m=1
Xxdacn_xc7_u47 lsb_n bn7 cap_cmim w=3.78u l=3.78u m=1
Xxdacn_xc7_u48 lsb_n bn7 cap_cmim w=3.78u l=3.78u m=1
Xxdacn_xc7_u49 lsb_n bn7 cap_cmim w=3.78u l=3.78u m=1
Xxdacn_xc7_u50 lsb_n bn7 cap_cmim w=3.78u l=3.78u m=1
Xxdacn_xc7_u51 lsb_n bn7 cap_cmim w=3.78u l=3.78u m=1
Xxdacn_xc7_u52 lsb_n bn7 cap_cmim w=3.78u l=3.78u m=1
Xxdacn_xc7_u53 lsb_n bn7 cap_cmim w=3.78u l=3.78u m=1
Xxdacn_xc7_u54 lsb_n bn7 cap_cmim w=3.78u l=3.78u m=1
Xxdacn_xc7_u55 lsb_n bn7 cap_cmim w=3.78u l=3.78u m=1
Xxdacn_xc7_u56 lsb_n bn7 cap_cmim w=3.78u l=3.78u m=1
Xxdacn_xc7_u57 lsb_n bn7 cap_cmim w=3.78u l=3.78u m=1
Xxdacn_xc7_u58 lsb_n bn7 cap_cmim w=3.78u l=3.78u m=1
Xxdacn_xc7_u59 lsb_n bn7 cap_cmim w=3.78u l=3.78u m=1
Xxdacn_xc7_u60 lsb_n bn7 cap_cmim w=3.78u l=3.78u m=1
Xxdacn_xc7_u61 lsb_n bn7 cap_cmim w=3.78u l=3.78u m=1
Xxdacn_xc7_u62 lsb_n bn7 cap_cmim w=3.78u l=3.78u m=1
Xxdacn_xc7_u63 lsb_n bn7 cap_cmim w=3.78u l=3.78u m=1
Xxdacn_xc6_u0 lsb_n bn6 cap_cmim w=3.78u l=3.78u m=1
Xxdacn_xc6_u1 lsb_n bn6 cap_cmim w=3.78u l=3.78u m=1
Xxdacn_xc6_u2 lsb_n bn6 cap_cmim w=3.78u l=3.78u m=1
Xxdacn_xc6_u3 lsb_n bn6 cap_cmim w=3.78u l=3.78u m=1
Xxdacn_xc6_u4 lsb_n bn6 cap_cmim w=3.78u l=3.78u m=1
Xxdacn_xc6_u5 lsb_n bn6 cap_cmim w=3.78u l=3.78u m=1
Xxdacn_xc6_u6 lsb_n bn6 cap_cmim w=3.78u l=3.78u m=1
Xxdacn_xc6_u7 lsb_n bn6 cap_cmim w=3.78u l=3.78u m=1
Xxdacn_xc6_u8 lsb_n bn6 cap_cmim w=3.78u l=3.78u m=1
Xxdacn_xc6_u9 lsb_n bn6 cap_cmim w=3.78u l=3.78u m=1
Xxdacn_xc6_u10 lsb_n bn6 cap_cmim w=3.78u l=3.78u m=1
Xxdacn_xc6_u11 lsb_n bn6 cap_cmim w=3.78u l=3.78u m=1
Xxdacn_xc6_u12 lsb_n bn6 cap_cmim w=3.78u l=3.78u m=1
Xxdacn_xc6_u13 lsb_n bn6 cap_cmim w=3.78u l=3.78u m=1
Xxdacn_xc6_u14 lsb_n bn6 cap_cmim w=3.78u l=3.78u m=1
Xxdacn_xc6_u15 lsb_n bn6 cap_cmim w=3.78u l=3.78u m=1
Xxdacn_xc6_u16 lsb_n bn6 cap_cmim w=3.78u l=3.78u m=1
Xxdacn_xc6_u17 lsb_n bn6 cap_cmim w=3.78u l=3.78u m=1
Xxdacn_xc6_u18 lsb_n bn6 cap_cmim w=3.78u l=3.78u m=1
Xxdacn_xc6_u19 lsb_n bn6 cap_cmim w=3.78u l=3.78u m=1
Xxdacn_xc6_u20 lsb_n bn6 cap_cmim w=3.78u l=3.78u m=1
Xxdacn_xc6_u21 lsb_n bn6 cap_cmim w=3.78u l=3.78u m=1
Xxdacn_xc6_u22 lsb_n bn6 cap_cmim w=3.78u l=3.78u m=1
Xxdacn_xc6_u23 lsb_n bn6 cap_cmim w=3.78u l=3.78u m=1
Xxdacn_xc6_u24 lsb_n bn6 cap_cmim w=3.78u l=3.78u m=1
Xxdacn_xc6_u25 lsb_n bn6 cap_cmim w=3.78u l=3.78u m=1
Xxdacn_xc6_u26 lsb_n bn6 cap_cmim w=3.78u l=3.78u m=1
Xxdacn_xc6_u27 lsb_n bn6 cap_cmim w=3.78u l=3.78u m=1
Xxdacn_xc6_u28 lsb_n bn6 cap_cmim w=3.78u l=3.78u m=1
Xxdacn_xc6_u29 lsb_n bn6 cap_cmim w=3.78u l=3.78u m=1
Xxdacn_xc6_u30 lsb_n bn6 cap_cmim w=3.78u l=3.78u m=1
Xxdacn_xc6_u31 lsb_n bn6 cap_cmim w=3.78u l=3.78u m=1
Xxdacn_xc5_u0 lsb_n bn5 cap_cmim w=3.78u l=3.78u m=1
Xxdacn_xc5_u1 lsb_n bn5 cap_cmim w=3.78u l=3.78u m=1
Xxdacn_xc5_u2 lsb_n bn5 cap_cmim w=3.78u l=3.78u m=1
Xxdacn_xc5_u3 lsb_n bn5 cap_cmim w=3.78u l=3.78u m=1
Xxdacn_xc5_u4 lsb_n bn5 cap_cmim w=3.78u l=3.78u m=1
Xxdacn_xc5_u5 lsb_n bn5 cap_cmim w=3.78u l=3.78u m=1
Xxdacn_xc5_u6 lsb_n bn5 cap_cmim w=3.78u l=3.78u m=1
Xxdacn_xc5_u7 lsb_n bn5 cap_cmim w=3.78u l=3.78u m=1
Xxdacn_xc5_u8 lsb_n bn5 cap_cmim w=3.78u l=3.78u m=1
Xxdacn_xc5_u9 lsb_n bn5 cap_cmim w=3.78u l=3.78u m=1
Xxdacn_xc5_u10 lsb_n bn5 cap_cmim w=3.78u l=3.78u m=1
Xxdacn_xc5_u11 lsb_n bn5 cap_cmim w=3.78u l=3.78u m=1
Xxdacn_xc5_u12 lsb_n bn5 cap_cmim w=3.78u l=3.78u m=1
Xxdacn_xc5_u13 lsb_n bn5 cap_cmim w=3.78u l=3.78u m=1
Xxdacn_xc5_u14 lsb_n bn5 cap_cmim w=3.78u l=3.78u m=1
Xxdacn_xc5_u15 lsb_n bn5 cap_cmim w=3.78u l=3.78u m=1
Xxdacn_xc4_u0 lsb_n bn4 cap_cmim w=3.78u l=3.78u m=1
Xxdacn_xc4_u1 lsb_n bn4 cap_cmim w=3.78u l=3.78u m=1
Xxdacn_xc4_u2 lsb_n bn4 cap_cmim w=3.78u l=3.78u m=1
Xxdacn_xc4_u3 lsb_n bn4 cap_cmim w=3.78u l=3.78u m=1
Xxdacn_xc4_u4 lsb_n bn4 cap_cmim w=3.78u l=3.78u m=1
Xxdacn_xc4_u5 lsb_n bn4 cap_cmim w=3.78u l=3.78u m=1
Xxdacn_xc4_u6 lsb_n bn4 cap_cmim w=3.78u l=3.78u m=1
Xxdacn_xc4_u7 lsb_n bn4 cap_cmim w=3.78u l=3.78u m=1
Xxdacn_xc3_u0 lsb_n bn3 cap_cmim w=3.78u l=3.78u m=1
Xxdacn_xc3_u1 lsb_n bn3 cap_cmim w=3.78u l=3.78u m=1
Xxdacn_xc3_u2 lsb_n bn3 cap_cmim w=3.78u l=3.78u m=1
Xxdacn_xc3_u3 lsb_n bn3 cap_cmim w=3.78u l=3.78u m=1
Xxdacn_xc2_u0 lsb_n bn2 cap_cmim w=3.78u l=3.78u m=1
Xxdacn_xc2_u1 lsb_n bn2 cap_cmim w=3.78u l=3.78u m=1
Xxdacn_xc1_u0 lsb_n bn1 cap_cmim w=3.78u l=3.78u m=1
Xxdacn_xc0 lsb_n bn0 cap_cmim w=2.67u l=2.67u m=1
Xxdmy_u0 gnd gnd cap_cmim w=3.78u l=3.78u m=1
Xxdmy_u1 gnd gnd cap_cmim w=3.78u l=3.78u m=1
Xxdmy_u2 gnd gnd cap_cmim w=3.78u l=3.78u m=1
Xxdmy_u3 gnd gnd cap_cmim w=3.78u l=3.78u m=1
Xxdmy_u4 gnd gnd cap_cmim w=3.78u l=3.78u m=1
Xxdmy_u5 gnd gnd cap_cmim w=3.78u l=3.78u m=1
Xxdmy_u6 gnd gnd cap_cmim w=3.78u l=3.78u m=1
Xxdmy_u7 gnd gnd cap_cmim w=3.78u l=3.78u m=1
Xxdmy_u8 gnd gnd cap_cmim w=3.78u l=3.78u m=1
Xxdmy_u9 gnd gnd cap_cmim w=3.78u l=3.78u m=1
Xxdmy_u10 gnd gnd cap_cmim w=3.78u l=3.78u m=1
Xxdmy_u11 gnd gnd cap_cmim w=3.78u l=3.78u m=1
Xxdmy_u12 gnd gnd cap_cmim w=3.78u l=3.78u m=1
Xxdmy_u13 gnd gnd cap_cmim w=3.78u l=3.78u m=1
Xxdmy_u14 gnd gnd cap_cmim w=3.78u l=3.78u m=1
Xxdmy_u15 gnd gnd cap_cmim w=3.78u l=3.78u m=1
Xxdmy_u16 gnd gnd cap_cmim w=3.78u l=3.78u m=1
Xxdmy_u17 gnd gnd cap_cmim w=3.78u l=3.78u m=1
Xxdmy_u18 gnd gnd cap_cmim w=3.78u l=3.78u m=1
Xxdmy_u19 gnd gnd cap_cmim w=3.78u l=3.78u m=1
Xxdmy_u20 gnd gnd cap_cmim w=3.78u l=3.78u m=1
Xxdmy_u21 gnd gnd cap_cmim w=3.78u l=3.78u m=1
Xxdmy_u22 gnd gnd cap_cmim w=3.78u l=3.78u m=1
Xxdmy_u23 gnd gnd cap_cmim w=3.78u l=3.78u m=1
Xxdmy_u24 gnd gnd cap_cmim w=3.78u l=3.78u m=1
Xxdmy_u25 gnd gnd cap_cmim w=3.78u l=3.78u m=1
Xxdmy_u26 gnd gnd cap_cmim w=3.78u l=3.78u m=1
Xxdmy_u27 gnd gnd cap_cmim w=3.78u l=3.78u m=1
Xxdmy_u28 gnd gnd cap_cmim w=3.78u l=3.78u m=1
Xxdmy_u29 gnd gnd cap_cmim w=3.78u l=3.78u m=1
Xxdmy_u30 gnd gnd cap_cmim w=3.78u l=3.78u m=1
Xxdmy_u31 gnd gnd cap_cmim w=3.78u l=3.78u m=1
Xxdmy_u32 gnd gnd cap_cmim w=3.78u l=3.78u m=1
Xxdmy_u33 gnd gnd cap_cmim w=3.78u l=3.78u m=1
Xxdmy_u34 gnd gnd cap_cmim w=3.78u l=3.78u m=1
Xxdmy_u35 gnd gnd cap_cmim w=3.78u l=3.78u m=1
Xxdmy_u36 gnd gnd cap_cmim w=3.78u l=3.78u m=1
Xxdmy_u37 gnd gnd cap_cmim w=3.78u l=3.78u m=1
Xxdmy_u38 gnd gnd cap_cmim w=3.78u l=3.78u m=1
Xxdmy_u39 gnd gnd cap_cmim w=3.78u l=3.78u m=1
Xxdmy_u40 gnd gnd cap_cmim w=3.78u l=3.78u m=1
Xxdmy_u41 gnd gnd cap_cmim w=3.78u l=3.78u m=1
Xxdmy_u42 gnd gnd cap_cmim w=3.78u l=3.78u m=1
Xxdmy_u43 gnd gnd cap_cmim w=3.78u l=3.78u m=1
Xxdmy_u44 gnd gnd cap_cmim w=3.78u l=3.78u m=1
Xxdmy_u45 gnd gnd cap_cmim w=3.78u l=3.78u m=1
Xxdmy_u46 gnd gnd cap_cmim w=3.78u l=3.78u m=1
Xxdmy_u47 gnd gnd cap_cmim w=3.78u l=3.78u m=1
Xxdmy_u48 gnd gnd cap_cmim w=3.78u l=3.78u m=1
Xxdmy_u49 gnd gnd cap_cmim w=3.78u l=3.78u m=1
Xxdmy_u50 gnd gnd cap_cmim w=3.78u l=3.78u m=1
Xxdmy_u51 gnd gnd cap_cmim w=3.78u l=3.78u m=1
Xxdmy_u52 gnd gnd cap_cmim w=3.78u l=3.78u m=1
Xxdmy_u53 gnd gnd cap_cmim w=3.78u l=3.78u m=1
Xxdmy_u54 gnd gnd cap_cmim w=3.78u l=3.78u m=1
Xxdmy_u55 gnd gnd cap_cmim w=3.78u l=3.78u m=1
Xxdmy_u56 gnd gnd cap_cmim w=3.78u l=3.78u m=1
Xxdmy_u57 gnd gnd cap_cmim w=3.78u l=3.78u m=1
Xxdmy_u58 gnd gnd cap_cmim w=3.78u l=3.78u m=1
Xxdmy_u59 gnd gnd cap_cmim w=3.78u l=3.78u m=1
Xxdmy_u60 gnd gnd cap_cmim w=3.78u l=3.78u m=1
Xxdmy_u61 gnd gnd cap_cmim w=3.78u l=3.78u m=1
Xxdmy_u62 gnd gnd cap_cmim w=3.78u l=3.78u m=1
Xxdmy_u63 gnd gnd cap_cmim w=3.78u l=3.78u m=1
Xxdmy_u64 gnd gnd cap_cmim w=3.78u l=3.78u m=1
Xxdmy_u65 gnd gnd cap_cmim w=3.78u l=3.78u m=1
Xxdmy_u66 gnd gnd cap_cmim w=3.78u l=3.78u m=1
Xxdmy_u67 gnd gnd cap_cmim w=3.78u l=3.78u m=1
Xxdmy_u68 gnd gnd cap_cmim w=3.78u l=3.78u m=1
Xxdmy_u69 gnd gnd cap_cmim w=3.78u l=3.78u m=1
Xxdmy_u70 gnd gnd cap_cmim w=3.78u l=3.78u m=1
Xxdmy_u71 gnd gnd cap_cmim w=3.78u l=3.78u m=1
Xxdmy_u72 gnd gnd cap_cmim w=3.78u l=3.78u m=1
Xxdmy_u73 gnd gnd cap_cmim w=3.78u l=3.78u m=1
Xxdmy_u74 gnd gnd cap_cmim w=3.78u l=3.78u m=1
Xxdmy_u75 gnd gnd cap_cmim w=3.78u l=3.78u m=1
Xxdmy_u76 gnd gnd cap_cmim w=3.78u l=3.78u m=1
Xxdmy_u77 gnd gnd cap_cmim w=3.78u l=3.78u m=1
Xxdmy_u78 gnd gnd cap_cmim w=3.78u l=3.78u m=1
Xxdmy_u79 gnd gnd cap_cmim w=3.78u l=3.78u m=1
Xxdmy_u80 gnd gnd cap_cmim w=3.78u l=3.78u m=1
Xxdmy_u81 gnd gnd cap_cmim w=3.78u l=3.78u m=1
Cld_xc4_outpb xc4_outpb gnd 3f
Cld_xc4_outnb xc4_outnb gnd 3f
Cld_xc5_outpb xc5_outpb gnd 3f
Cld_xc5_outnb xc5_outnb gnd 3f
Cp0 bn0 bn1 2.632e-16
Cp1 bn0 bn10 4.539e-17
Cp2 bn0 bn11 4.486e-17
Cp3 bn0 bn12 6.037e-17
Cp4 bn0 bn2 7.057e-15
Cp5 bn0 bn3 2.248e-16
Cp6 bn0 bn4 2.663e-16
Cp7 bn0 bn5 1.004e-15
Cp8 bn0 bn6 9.648e-16
Cp9 bn0 bn7 1.721e-15
Cp10 bn0 bn8 4.759e-17
Cp11 bn0 bn9 4.682e-17
Cp12 bn0 bp11 1.837e-16
Cp13 bn0 bp12 6.813e-16
Cp14 bn0 cn0 5.872e-16
Cp15 bn0 cn1 7.702e-17
Cp16 bn0 cn2 2.003e-19
Cp17 bn0 gnd 3.555e-15
Cp18 bn0 lsb_n 1.472e-16
Cp19 bn0 lsb_p 6.004e-17
Cp20 bn0 on 5.532e-19
Cp21 bn0 onp 1.625e-17
Cp22 bn0 op 2.31e-18
Cp23 bn0 rstb 7.712e-17
Cp24 bn0 vdd 1.525e-16
Cp25 bn0 vrefl 6.398e-16
Cp26 bn0 xc4_din 5.426e-17
Cp27 bn0 xc4_dip 3.417e-16
Cp28 bn0 xc4_outnb 6.863e-17
Cp29 bn0 xc4_outpb 6.983e-19
Cp30 bn1 bn10 7.366e-17
Cp31 bn1 bn11 5.327e-16
Cp32 bn1 bn12 5.054e-16
Cp33 bn1 bn2 1.009e-15
Cp34 bn1 bn3 8.083e-16
Cp35 bn1 bn4 5.046e-16
Cp36 bn1 bn5 1.047e-15
Cp37 bn1 bn6 1.98e-15
Cp38 bn1 bn7 1.573e-15
Cp39 bn1 bn8 5.488e-17
Cp40 bn1 bn9 5.508e-17
Cp41 bn1 bp12 1.302e-17
Cp42 bn1 cn1 2.505e-16
Cp43 bn1 cn2 1.52e-16
Cp44 bn1 gnd 2.383e-15
Cp45 bn1 lsb_n 1.641e-16
Cp46 bn1 lsb_p 6.444e-17
Cp47 bn1 on 1.137e-18
Cp48 bn1 onp 2.523e-17
Cp49 bn1 rstb 6.776e-17
Cp50 bn1 vdd 3.414e-16
Cp51 bn1 vrefl 6.215e-16
Cp52 bn1 xc4_din 9.675e-17
Cp53 bn1 xc4_dip 1.564e-15
Cp54 bn1 xc4_outnb 7.002e-17
Cp55 bn1 xc4_outpb 1.411e-18
Cp56 bn10 bn11 2.101e-14
Cp57 bn10 bn12 5.769e-15
Cp58 bn10 bn2 3.845e-17
Cp59 bn10 bn3 3.845e-17
Cp60 bn10 bn4 3.845e-17
Cp61 bn10 bn5 4.892e-16
Cp62 bn10 bn6 2.086e-15
Cp63 bn10 bn7 2.302e-15
Cp64 bn10 bn8 1.201e-15
Cp65 bn10 bn9 1.323e-14
Cp66 bn10 bp0 4.911e-17
Cp67 bn10 bp1 4.662e-17
Cp68 bn10 bp10 2.248e-15
Cp69 bn10 bp11 5.365e-17
Cp70 bn10 bp12 3.882e-17
Cp71 bn10 bp2 4.145e-17
Cp72 bn10 bp3 3.846e-17
Cp73 bn10 bp4 3.882e-17
Cp74 bn10 bp5 3.882e-17
Cp75 bn10 bp6 3.882e-17
Cp76 bn10 bp7 3.882e-17
Cp77 bn10 bp8 2.021e-16
Cp78 bn10 bp9 7.85e-17
Cp79 bn10 cn10 8.432e-17
Cp80 bn10 cn11 1.224e-18
Cp81 bn10 cn8 1.924e-17
Cp82 bn10 cn9 1.31e-16
Cp83 bn10 gnd 5.289e-15
Cp84 bn10 lsb_n 6.709e-16
Cp85 bn10 lsb_p 3.655e-16
Cp86 bn10 onp 3.178e-18
Cp87 bn10 rstb 7.419e-17
Cp88 bn10 vdd 9.049e-17
Cp89 bn10 vref 1.122e-15
Cp90 bn10 vrefl 5.527e-17
Cp91 bn10 xc4_din 1.53e-16
Cp92 bn10 xc4_dip 1.431e-16
Cp93 bn11 bn12 3.381e-14
Cp94 bn11 bn2 3.792e-17
Cp95 bn11 bn3 3.792e-17
Cp96 bn11 bn4 3.792e-17
Cp97 bn11 bn5 6.931e-17
Cp98 bn11 bn6 2.969e-15
Cp99 bn11 bn7 3.341e-15
Cp100 bn11 bn8 5.258e-16
Cp101 bn11 bn9 7.8e-16
Cp102 bn11 bp0 9.649e-17
Cp103 bn11 bp1 3.792e-17
Cp104 bn11 bp10 5.726e-16
Cp105 bn11 bp11 4.598e-15
Cp106 bn11 bp12 5.17e-17
Cp107 bn11 bp2 3.275e-17
Cp108 bn11 bp3 3.846e-17
Cp109 bn11 bp4 4.971e-17
Cp110 bn11 bp5 4.698e-16
Cp111 bn11 bp6 4.754e-16
Cp112 bn11 bp7 5.071e-17
Cp113 bn11 bp8 1.873e-16
Cp114 bn11 bp9 2.238e-16
Cp115 bn11 cn10 4.854e-16
Cp116 bn11 cn11 1.638e-16
Cp117 bn11 cn12 5.376e-19
Cp118 bn11 cn9 1.422e-17
Cp119 bn11 gnd 5.732e-15
Cp120 bn11 lsb_n 6.01e-16
Cp121 bn11 lsb_p 3.889e-16
Cp122 bn11 onp 1.634e-18
Cp123 bn11 rstb 3.611e-17
Cp124 bn11 vdd 5.249e-17
Cp125 bn11 vref 7.54e-16
Cp126 bn11 vrefl 7.831e-17
Cp127 bn11 xc4_din 6.785e-16
Cp128 bn11 xc4_dip 7.984e-17
Cp129 bn12 bn2 3.882e-17
Cp130 bn12 bn3 3.882e-17
Cp131 bn12 bn4 3.882e-17
Cp132 bn12 bn5 4.317e-17
Cp133 bn12 bn6 5.082e-15
Cp134 bn12 bn7 5.501e-15
Cp135 bn12 bn8 1.244e-15
Cp136 bn12 bn9 3.1e-15
Cp137 bn12 bp0 4.93e-16
Cp138 bn12 bp1 4.199e-16
Cp139 bn12 bp10 3.49e-16
Cp140 bn12 bp11 5.593e-16
Cp141 bn12 bp12 1.034e-14
Cp142 bn12 bp2 4.482e-17
Cp143 bn12 bp3 3.104e-16
Cp144 bn12 bp4 5.713e-16
Cp145 bn12 bp5 8.047e-17
Cp146 bn12 bp6 7.773e-17
Cp147 bn12 bp7 5.569e-16
Cp148 bn12 bp8 8.083e-16
Cp149 bn12 bp9 8.832e-16
Cp150 bn12 cn10 9.143e-17
Cp151 bn12 cn11 4.825e-16
Cp152 bn12 cn12 4.622e-16
Cp153 bn12 cp12 8.781e-18
Cp154 bn12 gnd 8.421e-15
Cp155 bn12 lsb_n 1.732e-14
Cp156 bn12 lsb_p 3.728e-16
Cp157 bn12 onp 3.965e-18
Cp158 bn12 rstb 3.759e-17
Cp159 bn12 top_n 1.311e-17
Cp160 bn12 vdd 4.324e-17
Cp161 bn12 vref 1.249e-15
Cp162 bn12 vrefl 1.192e-16
Cp163 bn12 xc4_din 2.078e-16
Cp164 bn12 xc4_dip 5.425e-17
Cp165 bn2 bn3 1.449e-14
Cp166 bn2 bn4 4.308e-16
Cp167 bn2 bn5 3.373e-15
Cp168 bn2 bn6 1.877e-15
Cp169 bn2 bn7 2.699e-15
Cp170 bn2 bn8 4.065e-17
Cp171 bn2 bn9 3.988e-17
Cp172 bn2 bp0 5.211e-16
Cp173 bn2 bp1 4.677e-16
Cp174 bn2 bp10 4.595e-17
Cp175 bn2 bp11 4.598e-17
Cp176 bn2 bp12 3.024e-17
Cp177 bn2 bp2 5.659e-17
Cp178 bn2 bp3 4.685e-17
Cp179 bn2 bp4 4.632e-17
Cp180 bn2 bp5 4.632e-17
Cp181 bn2 bp6 4.632e-17
Cp182 bn2 bp7 4.632e-17
Cp183 bn2 bp8 4.776e-17
Cp184 bn2 bp9 4.542e-17
Cp185 bn2 cn2 2.503e-16
Cp186 bn2 cn3 1.52e-16
Cp187 bn2 gnd 3.46e-15
Cp188 bn2 lsb_n 1.429e-16
Cp189 bn2 lsb_p 1.125e-16
Cp190 bn2 onp 2.523e-17
Cp191 bn2 rstb 6.614e-17
Cp192 bn2 vdd 1.423e-16
Cp193 bn2 vrefl 6.116e-16
Cp194 bn2 xc4_din 5.849e-17
Cp195 bn2 xc4_dip 5.04e-16
Cp196 bn2 xc4_outnb 7.321e-17
Cp197 bn2 xc4_outpb 1.596e-18
Cp198 bn3 bn4 2.359e-14
Cp199 bn3 bn5 5.932e-15
Cp200 bn3 bn6 3.465e-15
Cp201 bn3 bn7 3.98e-15
Cp202 bn3 bn8 4.065e-17
Cp203 bn3 bn9 3.988e-17
Cp204 bn3 bp0 4.399e-17
Cp205 bn3 bp1 3.601e-17
Cp206 bn3 bp10 3.845e-17
Cp207 bn3 bp11 3.849e-17
Cp208 bn3 bp12 3.024e-17
Cp209 bn3 bp2 3.845e-17
Cp210 bn3 bp3 3.935e-17
Cp211 bn3 bp4 3.882e-17
Cp212 bn3 bp5 3.882e-17
Cp213 bn3 bp6 7.995e-17
Cp214 bn3 bp7 6.755e-16
Cp215 bn3 bp8 4.026e-17
Cp216 bn3 bp9 3.792e-17
Cp217 bn3 cn2 3.974e-19
Cp218 bn3 cn3 5.114e-16
Cp219 bn3 cn4 5.026e-16
Cp220 bn3 gnd 4.432e-15
Cp221 bn3 lsb_n 2.092e-16
Cp222 bn3 lsb_p 3.915e-16
Cp223 bn3 onp 1.292e-17
Cp224 bn3 rstb 5.586e-17
Cp225 bn3 vdd 2.521e-16
Cp226 bn3 vrefl 5.81e-16
Cp227 bn3 xc4_din 7.648e-17
Cp228 bn3 xc4_dip 6.106e-16
Cp229 bn3 xc4_outnb 1.311e-16
Cp230 bn4 bn5 3.794e-14
Cp231 bn4 bn6 5.494e-15
Cp232 bn4 bn7 5.632e-15
Cp233 bn4 bn8 5.675e-16
Cp234 bn4 bn9 2.682e-16
Cp235 bn4 bp0 3.777e-17
Cp236 bn4 bp1 3.601e-17
Cp237 bn4 bp10 4.598e-17
Cp238 bn4 bp11 3.849e-17
Cp239 bn4 bp12 3.024e-17
Cp240 bn4 bp2 3.845e-17
Cp241 bn4 bp3 3.181e-16
Cp242 bn4 bp4 6.238e-16
Cp243 bn4 bp5 8.256e-17
Cp244 bn4 bp6 3.882e-17
Cp245 bn4 bp7 2.969e-17
Cp246 bn4 bp8 5.161e-16
Cp247 bn4 bp9 4.129e-16
Cp248 bn4 cn3 2.742e-19
Cp249 bn4 cn4 4.424e-17
Cp250 bn4 cn5 1.495e-16
Cp251 bn4 gnd 5.226e-15
Cp252 bn4 lsb_n 1.971e-16
Cp253 bn4 lsb_p 1.036e-16
Cp254 bn4 onp 6.847e-18
Cp255 bn4 rstb 5.59e-17
Cp256 bn4 vdd 6.359e-16
Cp257 bn4 vrefl 1.603e-15
Cp258 bn4 xc4_din 9.987e-17
Cp259 bn4 xc4_dip 6.246e-16
Cp260 bn4 xc4_outnb 2.156e-18
Cp261 bn5 bn6 1.213e-14
Cp262 bn5 bn7 1.74e-14
Cp263 bn5 bn8 1.194e-16
Cp264 bn5 bn9 3.529e-16
Cp265 bn5 bp0 9.703e-17
Cp266 bn5 bp1 9.466e-17
Cp267 bn5 bp10 5.215e-16
Cp268 bn5 bp11 2.356e-16
Cp269 bn5 bp12 4.034e-17
Cp270 bn5 bp2 5.141e-16
Cp271 bn5 bp3 2.481e-16
Cp272 bn5 bp4 4.992e-17
Cp273 bn5 bp5 4.665e-16
Cp274 bn5 bp6 4.717e-16
Cp275 bn5 bp7 5.137e-17
Cp276 bn5 bp8 9.334e-17
Cp277 bn5 bp9 1.033e-16
Cp278 bn5 cn5 2.504e-16
Cp279 bn5 cn6 1.522e-16
Cp280 bn5 gnd 1.032e-14
Cp281 bn5 lsb_n 5.513e-16
Cp282 bn5 lsb_p 3.089e-16
Cp283 bn5 onp 3.623e-18
Cp284 bn5 rstb 6.715e-17
Cp285 bn5 top_n 1.26e-19
Cp286 bn5 top_p 7.569e-18
Cp287 bn5 vdd 5.21e-16
Cp288 bn5 vrefl 6.179e-16
Cp289 bn5 xc4_din 1.013e-16
Cp290 bn5 xc4_dip 6.583e-16
Cp291 bn5 xc4_outnb 9.225e-19
Cp292 bn5 xs1n_cbp 2.091e-19
Cp293 bn5 xs1n_n10 2.244e-18
Cp294 bn6 bn7 1.163e-14
Cp295 bn6 bn8 7.423e-16
Cp296 bn6 bn9 1.994e-15
Cp297 bn6 bp0 6.733e-16
Cp298 bn6 bp1 5.426e-16
Cp299 bn6 bp10 6.568e-16
Cp300 bn6 bp11 5.943e-16
Cp301 bn6 bp12 8.081e-16
Cp302 bn6 bp2 6.364e-16
Cp303 bn6 bp3 6.091e-16
Cp304 bn6 bp4 9.209e-16
Cp305 bn6 bp5 5.852e-16
Cp306 bn6 bp6 5.901e-16
Cp307 bn6 bp7 8.532e-16
Cp308 bn6 bp8 6.868e-16
Cp309 bn6 bp9 5.326e-16
Cp310 bn6 cn6 2.505e-16
Cp311 bn6 cn7 1.523e-16
Cp312 bn6 cn8 1.024e-19
Cp313 bn6 gnd 2.876e-14
Cp314 bn6 lsb_n 1.803e-15
Cp315 bn6 lsb_p 6.762e-16
Cp316 bn6 onp 3.623e-18
Cp317 bn6 rstb 6.715e-17
Cp318 bn6 top_n 5.775e-18
Cp319 bn6 top_p 7.569e-18
Cp320 bn6 vdd 1.355e-15
Cp321 bn6 vrefl 6.176e-16
Cp322 bn6 xc4_din 9.78e-17
Cp323 bn6 xc4_dip 3.713e-15
Cp324 bn6 xs1n_g 2.467e-19
Cp325 bn7 bn8 3.597e-15
Cp326 bn7 bn9 2.051e-15
Cp327 bn7 bp0 1.241e-15
Cp328 bn7 bp1 1.033e-15
Cp329 bn7 bp10 1.198e-15
Cp330 bn7 bp11 1.116e-15
Cp331 bn7 bp12 1.393e-15
Cp332 bn7 bp2 1.174e-15
Cp333 bn7 bp3 1.142e-15
Cp334 bn7 bp4 1.533e-15
Cp335 bn7 bp5 1.108e-15
Cp336 bn7 bp6 1.12e-15
Cp337 bn7 bp7 1.45e-15
Cp338 bn7 bp8 1.256e-15
Cp339 bn7 bp9 1.016e-15
Cp340 bn7 cn7 2.505e-16
Cp341 bn7 cn8 6.101e-17
Cp342 bn7 gnd 4.292e-14
Cp343 bn7 lsb_n 2.155e-15
Cp344 bn7 lsb_p 1.23e-15
Cp345 bn7 onp 3.623e-18
Cp346 bn7 rstb 7.887e-17
Cp347 bn7 t0 3.223e-19
Cp348 bn7 t1b 5.677e-18
Cp349 bn7 top_n 6.005e-18
Cp350 bn7 top_p 1.514e-17
Cp351 bn7 vdd 2.461e-15
Cp352 bn7 vrefl 6.209e-16
Cp353 bn7 xc4_din 4.852e-15
Cp354 bn7 xc4_dip 8.65e-16
Cp355 bn8 bn9 5.234e-15
Cp356 bn8 bp12 6.613e-18
Cp357 bn8 cn7 6.18e-19
Cp358 bn8 cn8 7.077e-16
Cp359 bn8 cn9 1.777e-17
Cp360 bn8 gnd 5.821e-15
Cp361 bn8 lsb_n 3.437e-16
Cp362 bn8 lsb_p 1.097e-15
Cp363 bn8 onp 1.034e-18
Cp364 bn8 rstb 9.064e-17
Cp365 bn8 top_n 2.126e-16
Cp366 bn8 top_p 3.132e-18
Cp367 bn8 vdd 1.493e-16
Cp368 bn8 vref 3.089e-16
Cp369 bn8 vrefl 2.441e-16
Cp370 bn8 xc4_din 1.703e-16
Cp371 bn8 xc4_dip 6.616e-16
Cp372 bn9 bp1 5.089e-17
Cp373 bn9 bp10 6.415e-17
Cp374 bn9 bp11 4.808e-17
Cp375 bn9 bp12 4.742e-17
Cp376 bn9 bp2 5.494e-16
Cp377 bn9 bp3 2.762e-16
Cp378 bn9 bp4 4.742e-17
Cp379 bn9 bp5 4.742e-17
Cp380 bn9 bp6 4.742e-17
Cp381 bn9 bp7 4.742e-17
Cp382 bn9 bp8 9.711e-17
Cp383 bn9 bp9 1.172e-15
Cp384 bn9 cn10 3.335e-18
Cp385 bn9 cn11 4.295e-19
Cp386 bn9 cn7 1.2e-19
Cp387 bn9 cn8 5.647e-17
Cp388 bn9 cn9 5.89e-16
Cp389 bn9 gnd 4.745e-15
Cp390 bn9 lsb_n 1.581e-16
Cp391 bn9 lsb_p 1.091e-16
Cp392 bn9 onp 7.507e-19
Cp393 bn9 rstb 7.074e-17
Cp394 bn9 vdd 2.099e-16
Cp395 bn9 vref 5.373e-16
Cp396 bn9 vrefl 8.711e-17
Cp397 bn9 xc4_din 7.791e-16
Cp398 bn9 xc4_dip 3.74e-16
Cp399 bp0 bp1 1.19e-15
Cp400 bp0 bp10 4.444e-17
Cp401 bp0 bp11 9.649e-17
Cp402 bp0 bp12 5.005e-16
Cp403 bp0 bp2 1.374e-15
Cp404 bp0 bp3 1.807e-15
Cp405 bp0 bp4 5.152e-16
Cp406 bp0 bp5 7.4e-16
Cp407 bp0 bp6 1.791e-15
Cp408 bp0 bp7 8.897e-16
Cp409 bp0 bp8 5.138e-17
Cp410 bp0 cp0 2.746e-16
Cp411 bp0 cp1 9.713e-17
Cp412 bp0 cp2 7.798e-17
Cp413 bp0 cp3 9.015e-17
Cp414 bp0 cp4 1.549e-17
Cp415 bp0 cp6 2.003e-19
Cp416 bp0 gnd 5.685e-15
Cp417 bp0 lsb_n 4.735e-17
Cp418 bp0 onp 7.507e-19
Cp419 bp0 vdd 1.787e-17
Cp420 bp0 vrefl 6.224e-16
Cp421 bp0 xc4_din 4.378e-16
Cp422 bp0 xc4_dip 1.706e-16
Cp423 bp1 bp10 4.195e-17
Cp424 bp1 bp11 3.792e-17
Cp425 bp1 bp12 4.274e-16
Cp426 bp1 bp2 8.644e-15
Cp427 bp1 bp3 1.287e-15
Cp428 bp1 bp4 2.977e-16
Cp429 bp1 bp5 1.349e-15
Cp430 bp1 bp6 1.21e-15
Cp431 bp1 bp7 2.272e-15
Cp432 bp1 bp8 4.889e-17
Cp433 bp1 bp9 5.089e-17
Cp434 bp1 cp0 1.909e-15
Cp435 bp1 cp1 4.414e-16
Cp436 bp1 cp2 6.607e-17
Cp437 bp1 cp3 5.605e-17
Cp438 bp1 cp4 9.684e-19
Cp439 bp1 cp5 1.117e-17
Cp440 bp1 cp6 1.885e-18
Cp441 bp1 gnd 4.062e-15
Cp442 bp1 lsb_n 4.486e-17
Cp443 bp1 onp 3.386e-19
Cp444 bp1 vdd 2.767e-17
Cp445 bp1 vrefl 1.033e-15
Cp446 bp1 xc4_din 1.636e-16
Cp447 bp1 xc4_dip 7.788e-17
Cp448 bp10 bp11 2.034e-14
Cp449 bp10 bp12 6.1e-15
Cp450 bp10 bp2 3.679e-17
Cp451 bp10 bp3 3.846e-17
Cp452 bp10 bp4 3.882e-17
Cp453 bp10 bp5 3.882e-17
Cp454 bp10 bp6 1.262e-15
Cp455 bp10 bp7 1.223e-15
Cp456 bp10 bp8 1.429e-15
Cp457 bp10 bp9 1.426e-14
Cp458 bp10 cn11 1.344e-19
Cp459 bp10 cn12 2.667e-19
Cp460 bp10 cp10 5.676e-16
Cp461 bp10 cp11 6.123e-17
Cp462 bp10 cp12 1.253e-16
Cp463 bp10 cp8 1.344e-19
Cp464 bp10 cp9 3.877e-16
Cp465 bp10 gnd 4.481e-15
Cp466 bp10 lsb_n 6.515e-17
Cp467 bp10 lsb_p 5.755e-16
Cp468 bp10 onp 3.354e-19
Cp469 bp10 rstb 3.625e-17
Cp470 bp10 vdd 1.271e-16
Cp471 bp10 vref 1.079e-15
Cp472 bp10 vrefl 8.027e-16
Cp473 bp10 xc4_din 4.588e-16
Cp474 bp10 xc4_dip 7.11e-17
Cp475 bp11 bp12 3.412e-14
Cp476 bp11 bp2 3.275e-17
Cp477 bp11 bp3 3.846e-17
Cp478 bp11 bp4 4.971e-17
Cp479 bp11 bp5 4.698e-16
Cp480 bp11 bp6 2.927e-15
Cp481 bp11 bp7 2.409e-15
Cp482 bp11 bp8 5.197e-16
Cp483 bp11 bp9 5.585e-16
Cp484 bp11 cn11 2.184e-18
Cp485 bp11 cn12 4.681e-16
Cp486 bp11 cp10 3.367e-18
Cp487 bp11 cp11 7.574e-17
Cp488 bp11 cp12 9.58e-17
Cp489 bp11 gnd 5.873e-15
Cp490 bp11 lsb_n 7.72e-17
Cp491 bp11 lsb_p 6.335e-16
Cp492 bp11 onp 3.793e-18
Cp493 bp11 rstb 4.721e-17
Cp494 bp11 vdd 2.137e-16
Cp495 bp11 vref 1.683e-15
Cp496 bp11 vrefl 9.182e-17
Cp497 bp11 xc4_din 6.571e-16
Cp498 bp11 xc4_dip 5.14e-17
Cp499 bp12 bp2 5.232e-17
Cp500 bp12 bp3 3.179e-16
Cp501 bp12 bp4 5.788e-16
Cp502 bp12 bp5 8.797e-17
Cp503 bp12 bp6 5.779e-15
Cp504 bp12 bp7 5.302e-15
Cp505 bp12 bp8 1.224e-15
Cp506 bp12 bp9 3.187e-15
Cp507 bp12 cn10 1.344e-19
Cp508 bp12 cn11 1.155e-16
Cp509 bp12 cn12 1.034e-16
Cp510 bp12 cp10 3.526e-17
Cp511 bp12 cp11 4.784e-16
Cp512 bp12 cp12 1.373e-15
Cp513 bp12 gnd 7.936e-15
Cp514 bp12 lsb_n 1.038e-16
Cp515 bp12 lsb_p 1.766e-14
Cp516 bp12 onp 1.634e-18
Cp517 bp12 rstb 3.496e-17
Cp518 bp12 top_p 1.311e-17
Cp519 bp12 vdd 6.029e-17
Cp520 bp12 vref 9.889e-16
Cp521 bp12 vrefl 2.819e-16
Cp522 bp12 xc4_din 1.047e-16
Cp523 bp12 xc4_dip 6.262e-17
Cp524 bp2 bp3 1.516e-14
Cp525 bp2 bp4 4.479e-16
Cp526 bp2 bp5 4.264e-15
Cp527 bp2 bp6 2.072e-15
Cp528 bp2 bp7 2.839e-15
Cp529 bp2 bp8 4.942e-17
Cp530 bp2 bp9 5.494e-16
Cp531 bp2 cp0 1.252e-18
Cp532 bp2 cp1 1.33e-16
Cp533 bp2 cp2 1.987e-16
Cp534 bp2 cp3 6.424e-17
Cp535 bp2 cp4 8.439e-17
Cp536 bp2 cp5 3.778e-18
Cp537 bp2 cp6 2.958e-16
Cp538 bp2 cp7 8.328e-18
Cp539 bp2 gnd 4.665e-15
Cp540 bp2 lsb_n 4.539e-17
Cp541 bp2 onp 2.878e-18
Cp542 bp2 vdd 3.919e-17
Cp543 bp2 vrefl 1.396e-15
Cp544 bp2 xc4_din 1.695e-16
Cp545 bp2 xc4_dip 8.051e-17
Cp546 bp3 bp4 2.42e-14
Cp547 bp3 bp5 6.307e-15
Cp548 bp3 bp6 3.832e-15
Cp549 bp3 bp7 4.161e-15
Cp550 bp3 bp8 4.629e-17
Cp551 bp3 bp9 2.676e-16
Cp552 bp3 cp0 3.02e-18
Cp553 bp3 cp1 8.679e-19
Cp554 bp3 cp2 4.374e-16
Cp555 bp3 cp3 1.675e-16
Cp556 bp3 cp4 2.605e-18
Cp557 bp3 cp5 2.35e-18
Cp558 bp3 cp6 1.028e-16
Cp559 bp3 cp7 2.226e-16
Cp560 bp3 gnd 5.993e-15
Cp561 bp3 lsb_n 4.629e-17
Cp562 bp3 onp 2.396e-18
Cp563 bp3 t1 1.038e-19
Cp564 bp3 vdd 7.308e-17
Cp565 bp3 vrefl 9.381e-16
Cp566 bp3 xc4_din 4.193e-16
Cp567 bp3 xc4_dip 8.461e-17
Cp568 bp4 bp5 3.893e-14
Cp569 bp4 bp6 6.406e-15
Cp570 bp4 bp7 6.093e-15
Cp571 bp4 bp8 4.576e-17
Cp572 bp4 bp9 3.882e-17
Cp573 bp4 cp3 1.175e-17
Cp574 bp4 cp4 2.054e-16
Cp575 bp4 cp5 4.919e-17
Cp576 bp4 cp6 5.111e-17
Cp577 bp4 cp7 1.29e-16
Cp578 bp4 gnd 6.804e-15
Cp579 bp4 lsb_n 4.576e-17
Cp580 bp4 lsb_p 7.713e-17
Cp581 bp4 onp 4.716e-18
Cp582 bp4 rstb 6.182e-17
Cp583 bp4 t1 3.747e-19
Cp584 bp4 vdd 1.417e-16
Cp585 bp4 vrefl 7.519e-16
Cp586 bp4 xc4_din 1.803e-15
Cp587 bp4 xc4_dip 1.019e-16
Cp588 bp5 bp6 1.266e-14
Cp589 bp5 bp7 1.818e-14
Cp590 bp5 bp8 4.576e-17
Cp591 bp5 bp9 3.882e-17
Cp592 bp5 cp0 1.438e-19
Cp593 bp5 cp3 4.593e-19
Cp594 bp5 cp4 3.057e-16
Cp595 bp5 cp5 2.154e-15
Cp596 bp5 cp6 5.936e-17
Cp597 bp5 cp7 6.705e-17
Cp598 bp5 cp8 4.677e-18
Cp599 bp5 gnd 1.152e-14
Cp600 bp5 lsb_n 4.576e-17
Cp601 bp5 lsb_p 9.171e-19
Cp602 bp5 onp 6.999e-19
Cp603 bp5 rstb 8.786e-17
Cp604 bp5 t0 2.382e-18
Cp605 bp5 top_p 3.138e-19
Cp606 bp5 vdd 1.148e-16
Cp607 bp5 vref 1.84e-18
Cp608 bp5 vrefl 1.533e-15
Cp609 bp5 xc4_din 4.655e-16
Cp610 bp5 xc4_dip 8.634e-17
Cp611 bp5 xs0p_x 1.022e-19
Cp612 bp5 xs1p_n10 1.9e-18
Cp613 bp6 bp7 1.386e-14
Cp614 bp6 bp8 7.798e-16
Cp615 bp6 bp9 6.872e-16
Cp616 bp6 cp10 3.789e-19
Cp617 bp6 cp2 3.469e-18
Cp618 bp6 cp4 1.112e-16
Cp619 bp6 cp5 9.447e-17
Cp620 bp6 cp6 5.973e-16
Cp621 bp6 cp7 1.886e-16
Cp622 bp6 cp8 1.263e-16
Cp623 bp6 cp9 1.266e-18
Cp624 bp6 gnd 3.151e-14
Cp625 bp6 lsb_n 4.586e-17
Cp626 bp6 lsb_p 3.713e-16
Cp627 bp6 onp 5.475e-19
Cp628 bp6 rstb 2.133e-18
Cp629 bp6 top_p 1.027e-17
Cp630 bp6 vdd 1.417e-16
Cp631 bp6 vref 5.433e-18
Cp632 bp6 vrefl 1.279e-15
Cp633 bp6 xc4_din 5.081e-16
Cp634 bp6 xc4_dip 8.046e-17
Cp635 bp7 bp8 8.496e-16
Cp636 bp7 bp9 8.002e-16
Cp637 bp7 cp10 2.553e-18
Cp638 bp7 cp4 7.826e-18
Cp639 bp7 cp5 6.068e-17
Cp640 bp7 cp6 3.514e-16
Cp641 bp7 cp7 2.074e-16
Cp642 bp7 cp8 1.368e-16
Cp643 bp7 cp9 7.834e-17
Cp644 bp7 gnd 4.906e-14
Cp645 bp7 lsb_n 4.576e-17
Cp646 bp7 lsb_p 4.131e-15
Cp647 bp7 onp 7.672e-18
Cp648 bp7 rstb 9.59e-17
Cp649 bp7 t0 5.596e-18
Cp650 bp7 t1 1.806e-19
Cp651 bp7 top_p 4.329e-18
Cp652 bp7 vdd 1.407e-16
Cp653 bp7 vref 7.974e-17
Cp654 bp7 vrefl 4.143e-16
Cp655 bp7 xc4_din 1.37e-15
Cp656 bp7 xc4_dip 7.421e-17
Cp657 bp7 xs1p_cbp 2.091e-19
Cp658 bp7 xs1p_g 5.339e-19
Cp659 bp8 bp9 4.763e-15
Cp660 bp8 cp10 2.992e-16
Cp661 bp8 cp12 5.406e-19
Cp662 bp8 cp6 3.132e-19
Cp663 bp8 cp8 4.658e-16
Cp664 bp8 cp9 6.55e-17
Cp665 bp8 gnd 4.868e-15
Cp666 bp8 lsb_n 2.353e-15
Cp667 bp8 lsb_p 7.26e-16
Cp668 bp8 onp 4.121e-19
Cp669 bp8 rstb 4.908e-17
Cp670 bp8 top_n 3.779e-18
Cp671 bp8 top_p 2.178e-16
Cp672 bp8 vdd 1.286e-16
Cp673 bp8 vref 7.274e-16
Cp674 bp8 vrefl 1.193e-15
Cp675 bp8 xc4_din 5.367e-16
Cp676 bp8 xc4_dip 7.066e-17
Cp677 bp9 cp10 2.472e-16
Cp678 bp9 cp11 1.19e-16
Cp679 bp9 cp12 4.796e-18
Cp680 bp9 cp7 2.03e-17
Cp681 bp9 cp8 7.059e-17
Cp682 bp9 cp9 3.054e-16
Cp683 bp9 gnd 4.019e-15
Cp684 bp9 lsb_n 5.491e-16
Cp685 bp9 lsb_p 4.541e-16
Cp686 bp9 onp 9.943e-18
Cp687 bp9 rstb 5.216e-17
Cp688 bp9 vdd 1.039e-16
Cp689 bp9 vref 8.212e-16
Cp690 bp9 vrefl 5.841e-17
Cp691 bp9 xc4_din 4.484e-16
Cp692 bp9 xc4_dip 7.898e-17
Cp693 clkb clkn 4.749e-17
Cp694 clkb gnd 2.129e-14
Cp695 clkb on 1.229e-16
Cp696 clkb onn 3.375e-17
Cp697 clkb onp 6.031e-17
Cp698 clkb op 5.945e-17
Cp699 clkb t1 5.189e-17
Cp700 clkb t1b 5.804e-17
Cp701 clkb top_p 5.329e-17
Cp702 clkb vbp 1.055e-16
Cp703 clkb vdd 1.1e-14
Cp704 clkb vref 5.062e-16
Cp705 clkb vrefl 3.518e-16
Cp706 clkb xc4_din 2.92e-16
Cp707 clkb xc4_dip 4.512e-16
Cp708 clkb xc4_outnb 1.662e-17
Cp709 clkb xc4_outpb 1.119e-17
Cp710 clkb xc4_xs1_tail 1.245e-16
Cp711 clkb xc4_xs1_tail0 3.84e-16
Cp712 clkb xc5_din 1.076e-16
Cp713 clkb xc5_dip 5.043e-17
Cp714 clkb xc5_lt 4.817e-17
Cp715 clkb xc5_outnb 9.657e-18
Cp716 clkb xc5_outpb 1.593e-19
Cp717 clkb xc5_xs1_tail 7.844e-17
Cp718 clkn gnd 1.942e-14
Cp719 clkn onn 2.96e-19
Cp720 clkn onp 4.965e-19
Cp721 clkn top_n 4.691e-16
Cp722 clkn top_p 3.08e-16
Cp723 clkn vbn 7.469e-17
Cp724 clkn vbp 4.883e-19
Cp725 clkn vdd 6.745e-16
Cp726 clkn vrefl 1.432e-19
Cp727 clkn xc4_din 6.48e-18
Cp728 clkn xc4_dip 2.315e-18
Cp729 clkn xc4_xs1_tail 8.205e-18
Cp730 clkn xc5_din 2.437e-16
Cp731 clkn xc5_dip 2.303e-16
Cp732 clkn xc5_lt 5.977e-18
Cp733 clkn xc5_xs1_tail 7.919e-17
Cp734 clkn xc5_xs1_tail0 1.778e-16
Cp735 cn0 cn1 4.899e-17
Cp736 cn0 gnd 8.907e-16
Cp737 cn0 lsb_p 5.698e-17
Cp738 cn0 on 3.502e-18
Cp739 cn0 onp 5.463e-17
Cp740 cn0 op 2.678e-18
Cp741 cn0 rstb 3.231e-17
Cp742 cn0 vdd 3.859e-18
Cp743 cn0 vrefl 2.489e-16
Cp744 cn0 xc4_din 1.741e-18
Cp745 cn0 xc4_dip 1.912e-16
Cp746 cn0 xc4_outnb 5.701e-17
Cp747 cn0 xc4_outpb 2.399e-18
Cp748 cn1 cn2 3.997e-17
Cp749 cn1 gnd 9.54e-16
Cp750 cn1 lsb_p 6.476e-17
Cp751 cn1 on 4.556e-18
Cp752 cn1 onp 5.422e-17
Cp753 cn1 rstb 3.22e-17
Cp754 cn1 vdd 1.291e-18
Cp755 cn1 vrefl 2.567e-16
Cp756 cn1 xc4_din 2.245e-19
Cp757 cn1 xc4_dip 3.439e-18
Cp758 cn1 xc4_outnb 6.482e-17
Cp759 cn1 xc4_outpb 2.5e-18
Cp760 cn10 cn11 2.417e-16
Cp761 cn10 cn12 1.15e-16
Cp762 cn10 cn8 2.495e-19
Cp763 cn10 cn9 6.482e-17
Cp764 cn10 cp12 3.277e-19
Cp765 cn10 gnd 1.771e-15
Cp766 cn10 lsb_p 5.547e-17
Cp767 cn10 onp 8.095e-16
Cp768 cn10 rstb 4.675e-17
Cp769 cn10 vdd 1.418e-18
Cp770 cn10 vref 3.596e-16
Cp771 cn10 vrefl 1.098e-16
Cp772 cn10 xc4_dip 4.329e-19
Cp773 cn11 cn12 2.35e-16
Cp774 cn11 cn9 9.934e-18
Cp775 cn11 cp12 2.1e-16
Cp776 cn11 gnd 1.371e-15
Cp777 cn11 lsb_p 8.349e-17
Cp778 cn11 onp 8.431e-17
Cp779 cn11 rstb 4.302e-17
Cp780 cn11 vdd 1.66e-18
Cp781 cn11 vref 5.07e-16
Cp782 cn11 vrefl 2.644e-16
Cp783 cn11 xc4_din 3.861e-19
Cp784 cn11 xc4_dip 8.925e-19
Cp785 cn12 cp10 1.933e-19
Cp786 cn12 cp11 1.146e-16
Cp787 cn12 cp12 4.077e-16
Cp788 cn12 gnd 1.121e-15
Cp789 cn12 lsb_p 5.317e-17
Cp790 cn12 onp 7.988e-16
Cp791 cn12 rstb 3.564e-17
Cp792 cn12 vdd 1.418e-18
Cp793 cn12 vref 5.639e-16
Cp794 cn12 vrefl 8.731e-17
Cp795 cn12 xc4_din 4.335e-19
Cp796 cn12 xc4_dip 4.329e-19
Cp797 cn2 cn3 3.997e-17
Cp798 cn2 gnd 9.314e-16
Cp799 cn2 lsb_p 6.261e-17
Cp800 cn2 on 4.161e-18
Cp801 cn2 onp 5.414e-17
Cp802 cn2 rstb 3.211e-17
Cp803 cn2 vdd 1.291e-18
Cp804 cn2 vrefl 2.542e-16
Cp805 cn2 xc4_din 2.245e-19
Cp806 cn2 xc4_dip 3.569e-18
Cp807 cn2 xc4_outnb 6.369e-17
Cp808 cn2 xc4_outpb 2.533e-18
Cp809 cn3 cn4 9.824e-17
Cp810 cn3 gnd 8.193e-16
Cp811 cn3 lsb_p 5.695e-17
Cp812 cn3 onp 5.229e-17
Cp813 cn3 rstb 2.86e-17
Cp814 cn3 vdd 1.291e-18
Cp815 cn3 vrefl 2.358e-16
Cp816 cn3 xc4_din 1.006e-19
Cp817 cn3 xc4_dip 3.504e-18
Cp818 cn3 xc4_outnb 3.051e-16
Cp819 cn4 cn5 2.356e-17
Cp820 cn4 gnd 8.721e-16
Cp821 cn4 lsb_n 7.729e-19
Cp822 cn4 lsb_p 5.691e-17
Cp823 cn4 onp 7.094e-17
Cp824 cn4 rstb 5.05e-17
Cp825 cn4 vdd 2.213e-18
Cp826 cn4 vrefl 1.222e-15
Cp827 cn4 xc4_din 1.284e-18
Cp828 cn4 xc4_dip 1.173e-17
Cp829 cn4 xc4_outnb 2.488e-16
Cp830 cn5 cn6 5.105e-17
Cp831 cn5 gnd 8.606e-16
Cp832 cn5 lsb_p 6.732e-17
Cp833 cn5 onp 6.84e-17
Cp834 cn5 rstb 3.156e-17
Cp835 cn5 vdd 1.291e-18
Cp836 cn5 vrefl 2.96e-16
Cp837 cn5 xc4_din 2.245e-19
Cp838 cn5 xc4_dip 3.569e-18
Cp839 cn5 xc4_outnb 6.519e-19
Cp840 cn6 cn7 5.105e-17
Cp841 cn6 gnd 8.396e-16
Cp842 cn6 lsb_p 6.732e-17
Cp843 cn6 onp 7.107e-17
Cp844 cn6 rstb 3.211e-17
Cp845 cn6 vdd 1.291e-18
Cp846 cn6 vrefl 2.543e-16
Cp847 cn6 xc4_din 2.245e-19
Cp848 cn6 xc4_dip 3.569e-18
Cp849 cn7 cn8 3.268e-17
Cp850 cn7 gnd 8.474e-16
Cp851 cn7 lsb_p 6.732e-17
Cp852 cn7 onp 7.207e-17
Cp853 cn7 rstb 4.171e-17
Cp854 cn7 vdd 1.291e-18
Cp855 cn7 vrefl 2.544e-16
Cp856 cn7 xc4_din 2.245e-19
Cp857 cn7 xc4_dip 3.569e-18
Cp858 cn8 cn9 3.872e-16
Cp859 cn8 gnd 1.102e-15
Cp860 cn8 lsb_p 1.29e-16
Cp861 cn8 onp 7.095e-17
Cp862 cn8 rstb 3.611e-16
Cp863 cn8 vdd 1.69e-18
Cp864 cn8 vref 2.877e-16
Cp865 cn8 vrefl 5.627e-16
Cp866 cn8 xc4_din 4.041e-19
Cp867 cn8 xc4_dip 3.347e-17
Cp868 cn9 gnd 1.139e-15
Cp869 cn9 lsb_p 1.089e-16
Cp870 cn9 onp 7.252e-17
Cp871 cn9 rstb 4.318e-16
Cp872 cn9 vdd 2.444e-18
Cp873 cn9 vref 8.527e-16
Cp874 cn9 vrefl 6.025e-17
Cp875 cn9 xc4_din 6.328e-19
Cp876 cn9 xc4_dip 4.953e-18
Cp877 cp0 cp1 1.292e-15
Cp878 cp0 cp2 1.094e-16
Cp879 cp0 cp3 1.165e-16
Cp880 cp0 cp4 5.987e-18
Cp881 cp0 cp6 1.024e-19
Cp882 cp0 gnd 1.127e-15
Cp883 cp0 onp 1.664e-16
Cp884 cp0 t1 8.088e-19
Cp885 cp0 vdd 1.428e-18
Cp886 cp0 vrefl 1.802e-16
Cp887 cp0 xc4_din 2.931e-18
Cp888 cp0 xc4_dip 1.413e-17
Cp889 cp1 cp2 1.31e-15
Cp890 cp1 cp3 5.766e-17
Cp891 cp1 cp4 1.749e-19
Cp892 cp1 cp5 1.336e-19
Cp893 cp1 cp6 7.065e-18
Cp894 cp1 gnd 1.194e-15
Cp895 cp1 onp 1.742e-16
Cp896 cp1 t1 4.583e-19
Cp897 cp1 vdd 1.447e-18
Cp898 cp1 vrefl 5.71e-16
Cp899 cp1 xc4_din 6.307e-18
Cp900 cp1 xc4_dip 1.082e-18
Cp901 cp10 cp11 4.89e-16
Cp902 cp10 cp12 1.599e-16
Cp903 cp10 cp6 3.807e-18
Cp904 cp10 cp8 2.81e-18
Cp905 cp10 cp9 6.564e-16
Cp906 cp10 gnd 1.179e-15
Cp907 cp10 lsb_p 5.179e-17
Cp908 cp10 onp 6.592e-17
Cp909 cp10 rstb 4.302e-17
Cp910 cp10 t1 1.086e-19
Cp911 cp10 vdd 1.955e-18
Cp912 cp10 vref 7.642e-16
Cp913 cp10 vrefl 4.372e-17
Cp914 cp10 xc4_din 3.865e-18
Cp915 cp10 xc4_dip 1.15e-18
Cp916 cp11 cp12 2.115e-16
Cp917 cp11 cp9 1.137e-16
Cp918 cp11 gnd 1.098e-15
Cp919 cp11 lsb_p 5.359e-17
Cp920 cp11 onp 7.94e-16
Cp921 cp11 rstb 4.327e-17
Cp922 cp11 t1 6.332e-19
Cp923 cp11 vdd 1.418e-18
Cp924 cp11 vref 6.493e-16
Cp925 cp11 vrefl 1.001e-16
Cp926 cp11 xc4_din 7.475e-19
Cp927 cp11 xc4_dip 2.814e-19
Cp928 cp12 gnd 1.211e-15
Cp929 cp12 lsb_p 5.238e-17
Cp930 cp12 onp 5.866e-17
Cp931 cp12 rstb 4.302e-17
Cp932 cp12 t1 2.924e-18
Cp933 cp12 vdd 1.617e-18
Cp934 cp12 vref 7.164e-16
Cp935 cp12 vrefl 1.07e-16
Cp936 cp12 xc4_din 1.616e-19
Cp937 cp12 xc4_dip 5.786e-19
Cp938 cp2 cp3 1.202e-16
Cp939 cp2 cp4 4.699e-19
Cp940 cp2 cp6 1.533e-16
Cp941 cp2 cp7 1.06e-17
Cp942 cp2 gnd 1.282e-15
Cp943 cp2 onp 1.68e-15
Cp944 cp2 t1 5.246e-19
Cp945 cp2 vdd 1.447e-18
Cp946 cp2 vrefl 3.738e-16
Cp947 cp2 xc4_din 6.508e-18
Cp948 cp2 xc4_dip 1.082e-18
Cp949 cp3 cp4 3.536e-17
Cp950 cp3 cp6 1.5e-18
Cp951 cp3 cp7 6.388e-18
Cp952 cp3 gnd 1.933e-15
Cp953 cp3 onp 1.798e-15
Cp954 cp3 t1 1.177e-17
Cp955 cp3 vdd 1.311e-18
Cp956 cp3 vrefl 5.073e-16
Cp957 cp3 xc4_din 5.999e-18
Cp958 cp3 xc4_dip 7.684e-19
Cp959 cp4 cp5 1.7e-15
Cp960 cp4 cp6 7.529e-17
Cp961 cp4 cp7 7.71e-17
Cp962 cp4 cp8 4.602e-19
Cp963 cp4 gnd 1.019e-15
Cp964 cp4 lsb_p 1.799e-18
Cp965 cp4 onp 5.416e-17
Cp966 cp4 rstb 3.411e-16
Cp967 cp4 t1 3.512e-19
Cp968 cp4 vdd 3.01e-18
Cp969 cp4 vref 1.474e-19
Cp970 cp4 vrefl 1.743e-15
Cp971 cp4 xc4_din 6.198e-18
Cp972 cp4 xc4_dip 1.082e-18
Cp973 cp5 cp6 1.467e-16
Cp974 cp5 cp7 9.873e-17
Cp975 cp5 cp8 1.839e-17
Cp976 cp5 gnd 1.085e-15
Cp977 cp5 lsb_p 6.983e-19
Cp978 cp5 onp 6.41e-17
Cp979 cp5 rstb 2.775e-16
Cp980 cp5 vdd 1.798e-18
Cp981 cp5 vref 1.219e-18
Cp982 cp5 vrefl 4.651e-16
Cp983 cp5 xc4_din 3.504e-18
Cp984 cp5 xc4_dip 4.86e-19
Cp985 cp6 cp7 1.476e-15
Cp986 cp6 cp8 2.679e-16
Cp987 cp6 cp9 8.706e-18
Cp988 cp6 gnd 1.066e-15
Cp989 cp6 lsb_p 1.174e-19
Cp990 cp6 onp 1.393e-16
Cp991 cp6 rstb 3.977e-19
Cp992 cp6 t1 6.332e-19
Cp993 cp6 vdd 4.185e-18
Cp994 cp6 vref 5.933e-18
Cp995 cp6 vrefl 8.341e-16
Cp996 cp6 xc4_din 1.05e-18
Cp997 cp6 xc4_dip 1.623e-19
Cp998 cp7 cp8 5.916e-17
Cp999 cp7 cp9 1.14e-16
Cp1000 cp7 gnd 1.232e-15
Cp1001 cp7 onp 1.784e-15
Cp1002 cp7 rstb 9.143e-18
Cp1003 cp7 t1 6.332e-19
Cp1004 cp7 vdd 1.291e-18
Cp1005 cp7 vref 2.835e-18
Cp1006 cp7 vrefl 2.606e-16
Cp1007 cp7 xc4_din 3.479e-18
Cp1008 cp7 xc4_dip 3.139e-19
Cp1009 cp8 cp9 3.194e-17
Cp1010 cp8 gnd 1.668e-15
Cp1011 cp8 lsb_p 4.595e-17
Cp1012 cp8 onp 1.014e-15
Cp1013 cp8 rstb 6.411e-17
Cp1014 cp8 t1 6.471e-19
Cp1015 cp8 vdd 1.491e-18
Cp1016 cp8 vref 3.449e-16
Cp1017 cp8 vrefl 5.31e-17
Cp1018 cp8 xc4_din 3.255e-18
Cp1019 cp8 xc4_dip 2.539e-19
Cp1020 cp9 gnd 1.13e-15
Cp1021 cp9 lsb_p 5.867e-17
Cp1022 cp9 onp 7.938e-16
Cp1023 cp9 rstb 4.543e-17
Cp1024 cp9 t1 1.086e-19
Cp1025 cp9 vdd 1.762e-18
Cp1026 cp9 vref 4.332e-16
Cp1027 cp9 vrefl 4.518e-17
Cp1028 cp9 xc4_din 6.09e-18
Cp1029 cp9 xc4_dip 1.049e-18
Cp1030 gnd in0n 1.477e-15
Cp1031 gnd in0p 1.738e-15
Cp1032 gnd in1n 1.734e-15
Cp1033 gnd in1p 1.956e-15
Cp1034 gnd lsb_n 1.197e-14
Cp1035 gnd lsb_p 1.174e-14
Cp1036 gnd nr 9.241e-16
Cp1037 gnd on 5.226e-15
Cp1038 gnd onn 1.124e-14
Cp1039 gnd onp 1.633e-14
Cp1040 gnd op 4.912e-15
Cp1041 gnd rstb 5.687e-15
Cp1042 gnd rstb_n 2.471e-15
Cp1043 gnd t0 6.533e-15
Cp1044 gnd t0b 1.143e-14
Cp1045 gnd t1 2.082e-14
Cp1046 gnd t1b 1.352e-14
Cp1047 gnd top_n 1.703e-14
Cp1048 gnd top_p 2.116e-14
Cp1049 gnd trk0 2.158e-15
Cp1050 gnd trk1 1.137e-15
Cp1051 gnd vbn 1.368e-15
Cp1052 gnd vbp 8.44e-15
Cp1053 gnd vdd 8.214e-14
Cp1054 gnd vref 2.135e-14
Cp1055 gnd vrefl 2.299e-14
Cp1056 gnd xc4_din 4.976e-14
Cp1057 gnd xc4_dip 5.103e-14
Cp1058 gnd xc4_lt 1.902e-15
Cp1059 gnd xc4_outnb 2.329e-15
Cp1060 gnd xc4_outpb 4.034e-15
Cp1061 gnd xc4_xs1_tail 7.661e-15
Cp1062 gnd xc4_xs1_tail0 2.029e-15
Cp1063 gnd xc5_din 2.38e-14
Cp1064 gnd xc5_dip 2.562e-14
Cp1065 gnd xc5_lt 7.516e-15
Cp1066 gnd xc5_outnb 2.144e-15
Cp1067 gnd xc5_outpb 1.861e-15
Cp1068 gnd xc5_xs1_tail 4.094e-15
Cp1069 gnd xc5_xs1_tail0 2.375e-15
Cp1070 gnd xs0n_cbn 4.051e-15
Cp1071 gnd xs0n_cbp 1.817e-15
Cp1072 gnd xs0n_g 4.78e-15
Cp1073 gnd xs0n_n10 1.165e-15
Cp1074 gnd xs0n_x 1.671e-15
Cp1075 gnd xs0p_cbn 6.326e-15
Cp1076 gnd xs0p_cbp 2.138e-15
Cp1077 gnd xs0p_g 4.536e-15
Cp1078 gnd xs0p_n10 1.353e-15
Cp1079 gnd xs0p_x 2.477e-15
Cp1080 gnd xs1n_cbn 5.643e-15
Cp1081 gnd xs1n_cbp 2.373e-15
Cp1082 gnd xs1n_g 5.426e-15
Cp1083 gnd xs1n_n10 1.523e-15
Cp1084 gnd xs1n_x 1.754e-15
Cp1085 gnd xs1p_cbn 5.312e-15
Cp1086 gnd xs1p_cbp 1.729e-15
Cp1087 gnd xs1p_g 3.834e-15
Cp1088 gnd xs1p_n10 1.184e-15
Cp1089 gnd xs1p_x 1.852e-15
Cp1090 in0n in0p 1.859e-16
Cp1091 in0n lsb_n 1.024e-19
Cp1092 in0n lsb_p 1.344e-19
Cp1093 in0n t0 1.918e-18
Cp1094 in0n t0b 1.39e-15
Cp1095 in0n top_n 9.124e-16
Cp1096 in0n top_p 1.605e-18
Cp1097 in0n vdd 1.109e-15
Cp1098 in0n xs0n_cbn 1.972e-15
Cp1099 in0n xs0n_cbp 3.402e-18
Cp1100 in0n xs0n_g 2.009e-16
Cp1101 in0n xs0n_n10 8.707e-17
Cp1102 in0n xs0n_x 4.197e-17
Cp1103 in0p t0 1.012e-16
Cp1104 in0p t0b 1.021e-15
Cp1105 in0p top_n 9.216e-17
Cp1106 in0p top_p 1.019e-15
Cp1107 in0p vdd 3.463e-16
Cp1108 in0p xs0n_cbn 1.409e-15
Cp1109 in0p xs0n_cbp 1.657e-16
Cp1110 in0p xs0n_g 5.902e-16
Cp1111 in0p xs0n_n10 4.326e-17
Cp1112 in0p xs0n_x 1.456e-15
Cp1113 in0p xs0p_cbn 2.744e-16
Cp1114 in0p xs0p_g 2.342e-16
Cp1115 in1n in1p 2.149e-16
Cp1116 in1n t1 5.303e-16
Cp1117 in1n t1b 2.368e-15
Cp1118 in1n top_n 1.207e-15
Cp1119 in1n top_p 1.079e-18
Cp1120 in1n vdd 1.475e-15
Cp1121 in1n xs1n_cbn 1.003e-15
Cp1122 in1n xs1n_cbp 8.311e-18
Cp1123 in1n xs1n_g 1.488e-15
Cp1124 in1n xs1n_n10 2.129e-18
Cp1125 in1n xs1n_x 1.343e-16
Cp1126 in1n xs1p_cbn 4.766e-18
Cp1127 in1n xs1p_g 3.31e-18
Cp1128 in1p t1 1.234e-15
Cp1129 in1p t1b 3.149e-16
Cp1130 in1p top_n 2.154e-15
Cp1131 in1p top_p 7.945e-16
Cp1132 in1p vdd 1.26e-15
Cp1133 in1p xs1n_cbn 2.813e-16
Cp1134 in1p xs1n_cbp 3.05e-17
Cp1135 in1p xs1n_g 5.762e-17
Cp1136 in1p xs1n_n10 8.925e-18
Cp1137 in1p xs1n_x 1.462e-15
Cp1138 in1p xs1p_cbn 3.085e-16
Cp1139 in1p xs1p_g 4.599e-16
Cp1140 in1p xs1p_x 1.47e-18
Cp1141 lsb_n lsb_p 2.962e-15
Cp1142 lsb_n on 2.076e-19
Cp1143 lsb_n rstb 4.042e-16
Cp1144 lsb_n t0 1.606e-16
Cp1145 lsb_n top_n 5.501e-16
Cp1146 lsb_n top_p 2.556e-17
Cp1147 lsb_n vdd 9.262e-16
Cp1148 lsb_n vref 1.216e-17
Cp1149 lsb_n vrefl 2.75e-16
Cp1150 lsb_n xc4_din 3.618e-15
Cp1151 lsb_n xc4_dip 7.512e-16
Cp1152 lsb_n xc4_lt 1.875e-18
Cp1153 lsb_n xs0n_cbn 6.394e-17
Cp1154 lsb_n xs0n_cbp 3.117e-18
Cp1155 lsb_n xs0n_g 2.345e-19
Cp1156 lsb_n xs0n_x 2.147e-17
Cp1157 lsb_n xs1p_g 1.34e-19
Cp1158 lsb_p on 1.589e-17
Cp1159 lsb_p onn 1.371e-18
Cp1160 lsb_p onp 5.362e-17
Cp1161 lsb_p op 2.335e-17
Cp1162 lsb_p rstb 4.692e-15
Cp1163 lsb_p t0 2.264e-15
Cp1164 lsb_p t0b 1.693e-18
Cp1165 lsb_p top_n 6.452e-17
Cp1166 lsb_p top_p 5.789e-16
Cp1167 lsb_p vdd 3.627e-15
Cp1168 lsb_p vref 2.837e-15
Cp1169 lsb_p vrefl 1.845e-15
Cp1170 lsb_p xc4_din 1.032e-15
Cp1171 lsb_p xc4_dip 1.4e-16
Cp1172 lsb_p xc4_lt 1.033e-16
Cp1173 lsb_p xc4_outnb 1.633e-15
Cp1174 lsb_p xc4_outpb 3.417e-18
Cp1175 lsb_p xc5_outnb 4.03e-16
Cp1176 lsb_p xc5_outpb 2.86e-17
Cp1177 lsb_p xs0n_cbn 1.276e-16
Cp1178 lsb_p xs0n_cbp 3.66e-18
Cp1179 lsb_p xs0n_g 4.502e-19
Cp1180 lsb_p xs0n_n10 4.893e-19
Cp1181 lsb_p xs0n_x 1.104e-16
Cp1182 lsb_p xs0p_cbn 8.584e-18
Cp1183 lsb_p xs0p_g 4.202e-18
Cp1184 lsb_p xs0p_x 1.802e-17
Cp1185 nr rstb 1.182e-17
Cp1186 nr rstb_n 6.318e-16
Cp1187 nr t0b 2.323e-16
Cp1188 nr t1 5.569e-17
Cp1189 nr t1b 2.391e-16
Cp1190 nr trk1 1.142e-19
Cp1191 nr vdd 2.449e-17
Cp1192 on onn 8.114e-18
Cp1193 on onp 3.508e-16
Cp1194 on op 5.074e-15
Cp1195 on rstb 5.446e-16
Cp1196 on t1 4.475e-18
Cp1197 on t1b 8.692e-19
Cp1198 on vdd 2.847e-15
Cp1199 on vrefl 2.149e-17
Cp1200 on xc4_din 1.031e-15
Cp1201 on xc4_dip 7.102e-16
Cp1202 on xc4_lt 3.482e-16
Cp1203 on xc4_outnb 5.739e-17
Cp1204 on xc4_outpb 4.03e-15
Cp1205 on xc4_xs1_tail 1.736e-18
Cp1206 on xc4_xs1_tail0 1.21e-18
Cp1207 on xc5_lt 3.356e-18
Cp1208 on xc5_outnb 1.279e-16
Cp1209 on xc5_outpb 1.062e-16
Cp1210 onn onp 1.068e-15
Cp1211 onn op 2.319e-18
Cp1212 onn rstb 7.305e-17
Cp1213 onn rstb_n 1.619e-18
Cp1214 onn t0 5.881e-16
Cp1215 onn t0b 1.635e-15
Cp1216 onn t1 7.138e-17
Cp1217 onn t1b 1.449e-14
Cp1218 onn trk0 2.377e-18
Cp1219 onn vbp 4.673e-17
Cp1220 onn vdd 5.019e-15
Cp1221 onn vref 4.419e-16
Cp1222 onn vrefl 3.014e-16
Cp1223 onn xc4_din 1.008e-18
Cp1224 onn xc4_dip 2.497e-18
Cp1225 onn xc4_outpb 9.539e-19
Cp1226 onn xc4_xs1_tail 5.342e-17
Cp1227 onn xc4_xs1_tail0 6.395e-18
Cp1228 onn xc5_din 1.26e-16
Cp1229 onn xc5_dip 6.498e-18
Cp1230 onn xc5_lt 1.532e-14
Cp1231 onn xc5_outnb 6.513e-17
Cp1232 onn xc5_outpb 5.364e-17
Cp1233 onn xc5_xs1_tail 7.318e-18
Cp1234 onn xc5_xs1_tail0 2.363e-18
Cp1235 onp op 4.163e-15
Cp1236 onp rstb 7.939e-17
Cp1237 onp t0 2.253e-16
Cp1238 onp t0b 1.348e-16
Cp1239 onp t1 1.682e-16
Cp1240 onp t1b 1.781e-17
Cp1241 onp vdd 1.245e-15
Cp1242 onp vref 5.464e-16
Cp1243 onp vrefl 4.44e-16
Cp1244 onp xc4_din 5.701e-17
Cp1245 onp xc4_dip 1.258e-16
Cp1246 onp xc4_lt 1.839e-17
Cp1247 onp xc4_outnb 8.825e-16
Cp1248 onp xc4_outpb 1.961e-16
Cp1249 onp xc4_xs1_tail 1.142e-17
Cp1250 onp xc4_xs1_tail0 6.943e-19
Cp1251 onp xc5_din 9.826e-18
Cp1252 onp xc5_dip 1.02e-16
Cp1253 onp xc5_lt 1.475e-15
Cp1254 onp xc5_outnb 1.977e-16
Cp1255 onp xc5_outpb 3.336e-15
Cp1256 onp xc5_xs1_tail 9.628e-18
Cp1257 onp xc5_xs1_tail0 1.138e-18
Cp1258 op rstb 1.774e-16
Cp1259 op t1 6.093e-18
Cp1260 op t1b 1.433e-18
Cp1261 op vdd 3.198e-15
Cp1262 op xc4_din 5.372e-17
Cp1263 op xc4_dip 1.051e-15
Cp1264 op xc4_lt 6.731e-16
Cp1265 op xc4_outnb 2.587e-18
Cp1266 op xc4_outpb 3.007e-16
Cp1267 op xc4_xs1_tail 7.617e-18
Cp1268 op xc4_xs1_tail0 8.644e-19
Cp1269 op xc5_lt 2.709e-18
Cp1270 op xc5_outnb 1.552e-16
Cp1271 op xc5_outpb 1.275e-16
Cp1272 rstb rstb_n 2.029e-16
Cp1273 rstb t1 7.422e-17
Cp1274 rstb t1b 9.633e-17
Cp1275 rstb vdd 8.733e-16
Cp1276 rstb vref 9.084e-16
Cp1277 rstb vrefl 7.377e-15
Cp1278 rstb xc4_din 8.533e-17
Cp1279 rstb xc4_dip 1.39e-16
Cp1280 rstb xc4_lt 8.046e-18
Cp1281 rstb xc4_outnb 6.262e-18
Cp1282 rstb xc4_outpb 4.126e-17
Cp1283 rstb xc5_lt 6.637e-17
Cp1284 rstb xc5_outnb 5.335e-17
Cp1285 rstb xc5_outpb 4.364e-17
Cp1286 rstb_n t0b 1.639e-16
Cp1287 rstb_n t1 6.266e-17
Cp1288 rstb_n t1b 5.498e-16
Cp1289 rstb_n vdd 1.03e-15
Cp1290 t0 t0b 5.261e-16
Cp1291 t0 t1 8.863e-18
Cp1292 t0 t1b 8.669e-18
Cp1293 t0 top_n 8.324e-16
Cp1294 t0 top_p 4.745e-16
Cp1295 t0 trk0 2.258e-19
Cp1296 t0 trk1 1.315e-16
Cp1297 t0 vdd 8.3e-15
Cp1298 t0 xc4_lt 2.343e-18
Cp1299 t0 xc5_outpb 1.123e-16
Cp1300 t0 xs0n_cbn 1.145e-15
Cp1301 t0 xs0n_cbp 4.879e-18
Cp1302 t0 xs0n_g 2.101e-16
Cp1303 t0 xs0n_n10 7.613e-19
Cp1304 t0 xs0n_x 2.131e-16
Cp1305 t0 xs0p_cbn 3e-16
Cp1306 t0 xs0p_cbp 4.624e-18
Cp1307 t0 xs0p_g 8.374e-17
Cp1308 t0 xs0p_x 1.153e-16
Cp1309 t0b t1 5.507e-16
Cp1310 t0b t1b 7.66e-16
Cp1311 t0b top_n 1.091e-16
Cp1312 t0b top_p 1.28e-16
Cp1313 t0b trk0 2.445e-16
Cp1314 t0b trk1 8.183e-17
Cp1315 t0b vdd 2.109e-15
Cp1316 t0b xs0n_cbn 9.509e-16
Cp1317 t0b xs0n_cbp 5.402e-16
Cp1318 t0b xs0n_g 2.139e-16
Cp1319 t0b xs0n_n10 1.374e-16
Cp1320 t0b xs0n_x 8.698e-17
Cp1321 t0b xs0p_cbn 4.628e-16
Cp1322 t0b xs0p_cbp 2.112e-18
Cp1323 t0b xs0p_g 8.877e-17
Cp1324 t0b xs0p_n10 3.396e-17
Cp1325 t0b xs0p_x 1.257e-16
Cp1326 t1 t1b 2.052e-15
Cp1327 t1 top_n 2.173e-16
Cp1328 t1 top_p 6.185e-17
Cp1329 t1 trk1 2.742e-19
Cp1330 t1 vbp 6.179e-17
Cp1331 t1 vdd 1.564e-14
Cp1332 t1 vref 1.773e-15
Cp1333 t1 vrefl 4.14e-16
Cp1334 t1 xc4_din 6.791e-17
Cp1335 t1 xc4_dip 6.773e-17
Cp1336 t1 xc4_outnb 2.264e-19
Cp1337 t1 xc4_xs1_tail 5.76e-17
Cp1338 t1 xc4_xs1_tail0 4.956e-18
Cp1339 t1 xc5_dip 5.523e-18
Cp1340 t1 xc5_lt 1.858e-15
Cp1341 t1 xc5_outnb 2.264e-19
Cp1342 t1 xc5_outpb 1.372e-19
Cp1343 t1 xs1n_cbn 1.124e-15
Cp1344 t1 xs1n_cbp 4.779e-18
Cp1345 t1 xs1n_g 1.59e-15
Cp1346 t1 xs1n_n10 1.012e-18
Cp1347 t1 xs1n_x 2.076e-16
Cp1348 t1 xs1p_cbn 2.892e-16
Cp1349 t1 xs1p_cbp 4.816e-18
Cp1350 t1 xs1p_g 1.047e-16
Cp1351 t1 xs1p_n10 1.062e-19
Cp1352 t1 xs1p_x 1.101e-16
Cp1353 t1b top_n 3.211e-16
Cp1354 t1b top_p 1.317e-15
Cp1355 t1b trk1 1.496e-16
Cp1356 t1b vbn 1.178e-19
Cp1357 t1b vbp 5.329e-17
Cp1358 t1b vdd 3.855e-15
Cp1359 t1b vref 5.577e-16
Cp1360 t1b vrefl 3.714e-16
Cp1361 t1b xc4_din 2.429e-16
Cp1362 t1b xc4_dip 6.727e-17
Cp1363 t1b xc4_xs1_tail 5.94e-15
Cp1364 t1b xc4_xs1_tail0 9.605e-19
Cp1365 t1b xc5_din 6.363e-17
Cp1366 t1b xc5_dip 4.237e-15
Cp1367 t1b xc5_lt 8.039e-16
Cp1368 t1b xc5_xs1_tail 1.214e-18
Cp1369 t1b xc5_xs1_tail0 3.185e-18
Cp1370 t1b xs1n_cbn 1.406e-15
Cp1371 t1b xs1n_cbp 1.242e-17
Cp1372 t1b xs1n_g 6.746e-17
Cp1373 t1b xs1n_n10 3.726e-17
Cp1374 t1b xs1n_x 1.445e-15
Cp1375 t1b xs1p_cbn 6.678e-16
Cp1376 t1b xs1p_cbp 4.44e-17
Cp1377 t1b xs1p_g 7.513e-16
Cp1378 t1b xs1p_n10 4.782e-17
Cp1379 t1b xs1p_x 4.703e-16
Cp1380 top_n top_p 5.622e-15
Cp1381 top_n vdd 2.191e-15
Cp1382 top_n xc4_din 1.14e-15
Cp1383 top_n xc4_dip 5.962e-17
Cp1384 top_n xc4_xs1_tail 1.248e-15
Cp1385 top_n xc5_din 1.529e-15
Cp1386 top_n xc5_dip 8.425e-17
Cp1387 top_n xc5_lt 6.037e-17
Cp1388 top_n xc5_xs1_tail 9.994e-16
Cp1389 top_n xs0n_cbn 9.937e-16
Cp1390 top_n xs0n_cbp 8.507e-18
Cp1391 top_n xs0n_g 3.453e-16
Cp1392 top_n xs0n_n10 1.796e-18
Cp1393 top_n xs0n_x 1.404e-16
Cp1394 top_n xs0p_g 2.937e-18
Cp1395 top_n xs1n_cbn 1.085e-15
Cp1396 top_n xs1n_cbp 1.829e-16
Cp1397 top_n xs1n_g 2.624e-16
Cp1398 top_n xs1n_n10 4.801e-17
Cp1399 top_n xs1n_x 1.665e-16
Cp1400 top_n xs1p_cbn 3.88e-18
Cp1401 top_n xs1p_g 5.831e-17
Cp1402 top_p vdd 1.848e-15
Cp1403 top_p xc4_din 2.088e-16
Cp1404 top_p xc4_dip 1.14e-15
Cp1405 top_p xc4_xs1_tail 1.273e-15
Cp1406 top_p xc5_din 5.615e-16
Cp1407 top_p xc5_dip 6.38e-16
Cp1408 top_p xc5_lt 5.718e-17
Cp1409 top_p xc5_xs1_tail 1.158e-15
Cp1410 top_p xs0n_cbn 1.069e-16
Cp1411 top_p xs0n_cbp 1.124e-17
Cp1412 top_p xs0n_g 1.068e-15
Cp1413 top_p xs0n_n10 2.662e-18
Cp1414 top_p xs0n_x 2.05e-16
Cp1415 top_p xs0p_cbn 1.025e-16
Cp1416 top_p xs0p_g 7.132e-16
Cp1417 top_p xs0p_x 1.984e-18
Cp1418 top_p xs1n_cbn 3e-16
Cp1419 top_p xs1n_cbp 1.01e-17
Cp1420 top_p xs1n_g 2.612e-16
Cp1421 top_p xs1n_n10 4.825e-17
Cp1422 top_p xs1p_cbn 6.037e-18
Cp1423 top_p xs1p_g 9.266e-17
Cp1424 trk0 vdd 7.362e-17
Cp1425 trk1 vdd 3.129e-16
Cp1426 vbn vbp 6.554e-16
Cp1427 vbn vrefl 8.977e-18
Cp1428 vbn xc4_xs1_tail 4.133e-18
Cp1429 vbn xc5_din 1.317e-17
Cp1430 vbn xc5_dip 4.828e-17
Cp1431 vbn xc5_xs1_tail 1.148e-16
Cp1432 vbn xc5_xs1_tail0 3.221e-16
Cp1433 vbp vdd 6.588e-16
Cp1434 vbp vref 6.655e-16
Cp1435 vbp vrefl 4.531e-16
Cp1436 vbp xc4_dip 5.068e-17
Cp1437 vbp xc4_xs1_tail 1.637e-15
Cp1438 vbp xc4_xs1_tail0 1.03e-15
Cp1439 vbp xc5_din 5.145e-16
Cp1440 vbp xc5_dip 3.871e-16
Cp1441 vbp xc5_lt 5.674e-17
Cp1442 vbp xc5_outnb 1.781e-18
Cp1443 vbp xc5_xs1_tail0 2.468e-18
Cp1444 vdd vref 2.449e-15
Cp1445 vdd vrefl 2.334e-15
Cp1446 vdd xc4_din 1.49e-14
Cp1447 vdd xc4_dip 1.317e-14
Cp1448 vdd xc4_lt 2.462e-18
Cp1449 vdd xc4_outnb 3.729e-16
Cp1450 vdd xc4_outpb 3.097e-16
Cp1451 vdd xc4_xs1_tail 9.684e-16
Cp1452 vdd xc4_xs1_tail0 2.805e-15
Cp1453 vdd xc5_din 2.746e-15
Cp1454 vdd xc5_dip 2.263e-15
Cp1455 vdd xc5_lt 3.764e-15
Cp1456 vdd xc5_outnb 4.903e-16
Cp1457 vdd xc5_outpb 6.227e-16
Cp1458 vdd xc5_xs1_tail 2.875e-16
Cp1459 vdd xc5_xs1_tail0 2.925e-19
Cp1460 vdd xs0n_cbn 2.397e-15
Cp1461 vdd xs0n_cbp 5.276e-16
Cp1462 vdd xs0n_g 7.833e-16
Cp1463 vdd xs0n_n10 1.751e-16
Cp1464 vdd xs0n_x 9.861e-16
Cp1465 vdd xs0p_cbn 2.811e-15
Cp1466 vdd xs0p_cbp 7.317e-16
Cp1467 vdd xs0p_g 9.595e-16
Cp1468 vdd xs0p_n10 8.833e-17
Cp1469 vdd xs0p_x 9.978e-16
Cp1470 vdd xs1n_cbn 1.775e-15
Cp1471 vdd xs1n_cbp 5.751e-16
Cp1472 vdd xs1n_g 1.878e-15
Cp1473 vdd xs1n_n10 4.703e-17
Cp1474 vdd xs1n_x 1.03e-15
Cp1475 vdd xs1p_cbn 1.253e-15
Cp1476 vdd xs1p_cbp 4.04e-16
Cp1477 vdd xs1p_g 1.226e-15
Cp1478 vdd xs1p_n10 2.655e-16
Cp1479 vdd xs1p_x 4.537e-16
Cp1480 vref vrefl 1.266e-15
Cp1481 vref xc4_din 1.428e-16
Cp1482 vref xc4_dip 3.358e-15
Cp1483 vref xc4_xs1_tail 7.49e-16
Cp1484 vref xc5_din 5.725e-16
Cp1485 vref xc5_dip 1.619e-15
Cp1486 vref xc5_lt 6.021e-16
Cp1487 vrefl xc4_din 2.224e-16
Cp1488 vrefl xc4_dip 5.368e-15
Cp1489 vrefl xc4_outnb 3.251e-16
Cp1490 vrefl xc4_outpb 1.337e-18
Cp1491 vrefl xc4_xs1_tail 4.984e-16
Cp1492 vrefl xc5_din 4.371e-16
Cp1493 vrefl xc5_dip 2.097e-16
Cp1494 vrefl xc5_lt 4.056e-16
Cp1495 xc4_din xc4_dip 1.758e-14
Cp1496 xc4_din xc4_outnb 5.701e-17
Cp1497 xc4_din xc4_outpb 4.564e-17
Cp1498 xc4_din xc4_xs1_tail 7.635e-15
Cp1499 xc4_din xc5_din 5.158e-16
Cp1500 xc4_din xc5_dip 1.114e-16
Cp1501 xc4_din xc5_lt 9.893e-17
Cp1502 xc4_din xc5_xs1_tail 1.185e-17
Cp1503 xc4_dip xc4_outnb 6.3e-17
Cp1504 xc4_dip xc4_outpb 2.419e-16
Cp1505 xc4_dip xc4_xs1_tail 3.967e-15
Cp1506 xc4_dip xc4_xs1_tail0 3.176e-18
Cp1507 xc4_dip xc5_din 2.442e-15
Cp1508 xc4_dip xc5_dip 1.255e-16
Cp1509 xc4_dip xc5_lt 6.32e-17
Cp1510 xc4_dip xc5_xs1_tail 6.523e-16
Cp1511 xc4_lt xc4_outpb 3.852e-19
Cp1512 xc4_lt xc5_outnb 5.522e-17
Cp1513 xc4_lt xc5_outpb 2.073e-17
Cp1514 xc4_outnb xc4_outpb 1.27e-16
Cp1515 xc4_outnb xc5_outnb 1.209e-15
Cp1516 xc4_outnb xc5_outpb 2.485e-17
Cp1517 xc4_outpb xc4_xs1_tail 2.568e-18
Cp1518 xc4_outpb xc4_xs1_tail0 1.751e-18
Cp1519 xc4_outpb xc5_lt 6.419e-19
Cp1520 xc4_outpb xc5_outnb 1.386e-16
Cp1521 xc4_outpb xc5_outpb 1.343e-16
Cp1522 xc4_xs1_tail xc4_xs1_tail0 8.297e-16
Cp1523 xc4_xs1_tail xc5_din 8.598e-16
Cp1524 xc4_xs1_tail xc5_dip 8.847e-16
Cp1525 xc4_xs1_tail xc5_lt 6.132e-17
Cp1526 xc4_xs1_tail xc5_xs1_tail 3.014e-16
Cp1527 xc4_xs1_tail xc5_xs1_tail0 2.353e-17
Cp1528 xc4_xs1_tail0 xc5_lt 1.752e-18
Cp1529 xc4_xs1_tail0 xc5_outnb 2.086e-17
Cp1530 xc4_xs1_tail0 xc5_outpb 1.36e-19
Cp1531 xc5_din xc5_dip 6.147e-15
Cp1532 xc5_din xc5_lt 7.892e-17
Cp1533 xc5_din xc5_xs1_tail 1.235e-15
Cp1534 xc5_din xc5_xs1_tail0 8.337e-17
Cp1535 xc5_dip xc5_lt 4.681e-15
Cp1536 xc5_dip xc5_xs1_tail 1.189e-15
Cp1537 xc5_dip xc5_xs1_tail0 7.261e-17
Cp1538 xc5_lt xc5_outpb 9.421e-18
Cp1539 xc5_lt xc5_xs1_tail 5.865e-19
Cp1540 xc5_lt xc5_xs1_tail0 1.655e-18
Cp1541 xc5_outnb xc5_outpb 2.911e-15
Cp1542 xc5_xs1_tail xc5_xs1_tail0 2.314e-16
Cp1543 xs0n_cbn xs0n_cbp 3.563e-16
Cp1544 xs0n_cbn xs0n_g 6.205e-16
Cp1545 xs0n_cbn xs0n_n10 4.518e-16
Cp1546 xs0n_cbn xs0n_x 8.617e-16
Cp1547 xs0n_cbp xs0n_g 7.229e-16
Cp1548 xs0n_cbp xs0n_n10 3.831e-17
Cp1549 xs0n_cbp xs0n_x 1.037e-16
Cp1550 xs0n_cbp xs0p_g 2.295e-17
Cp1551 xs0n_g xs0n_n10 4.961e-16
Cp1552 xs0n_g xs0n_x 1.329e-15
Cp1553 xs0n_g xs0p_g 7.106e-18
Cp1554 xs0n_n10 xs0n_x 2.348e-17
Cp1555 xs0n_x xs0p_g 1.341e-17
Cp1556 xs0p_cbn xs0p_cbp 9.998e-16
Cp1557 xs0p_cbn xs0p_g 1.547e-15
Cp1558 xs0p_cbn xs0p_n10 6.098e-16
Cp1559 xs0p_cbn xs0p_x 1.097e-15
Cp1560 xs0p_cbp xs0p_g 6.461e-16
Cp1561 xs0p_cbp xs0p_n10 7.24e-17
Cp1562 xs0p_cbp xs0p_x 6.7e-16
Cp1563 xs0p_g xs0p_n10 5.16e-16
Cp1564 xs0p_g xs0p_x 1.545e-15
Cp1565 xs0p_n10 xs0p_x 2.417e-17
Cp1566 xs1n_cbn xs1n_cbp 3.679e-16
Cp1567 xs1n_cbn xs1n_g 1.218e-15
Cp1568 xs1n_cbn xs1n_n10 1.386e-16
Cp1569 xs1n_cbn xs1n_x 1.007e-15
Cp1570 xs1n_cbp xs1n_g 7.571e-16
Cp1571 xs1n_cbp xs1n_n10 1.43e-16
Cp1572 xs1n_cbp xs1n_x 9.054e-17
Cp1573 xs1n_cbp xs1p_g 1.064e-17
Cp1574 xs1n_g xs1n_n10 5.827e-16
Cp1575 xs1n_g xs1n_x 2.003e-16
Cp1576 xs1n_g xs1p_g 2.935e-17
Cp1577 xs1n_n10 xs1n_x 2.723e-17
Cp1578 xs1n_x xs1p_g 1.662e-17
Cp1579 xs1p_cbn xs1p_cbp 1.18e-15
Cp1580 xs1p_cbn xs1p_g 1.964e-15
Cp1581 xs1p_cbn xs1p_n10 6.628e-16
Cp1582 xs1p_cbn xs1p_x 1.271e-15
Cp1583 xs1p_cbp xs1p_g 5.906e-16
Cp1584 xs1p_cbp xs1p_n10 8.011e-17
Cp1585 xs1p_cbp xs1p_x 7.189e-16
Cp1586 xs1p_g xs1p_n10 5.182e-16
Cp1587 xs1p_g xs1p_x 1.825e-15
Cp1588 xs1p_n10 xs1p_x 1.858e-17
.ends
.subckt r1_adc_lay adc_hold is_smp clk adc_start adc_sel adc_valid_a adc_raw_a_0 adc_raw_a_1 adc_raw_a_2 adc_raw_a_3 adc_raw_a_4 adc_raw_a_5 adc_raw_a_6 adc_raw_a_7 adc_raw_a_8 adc_raw_a_9 adc_raw_a_10 adc_raw_a_11 adc_raw_a_12 adc_raw_a_13 adc_valid_b adc_raw_b_0 adc_raw_b_1 adc_raw_b_2 adc_raw_b_3 adc_raw_b_4 adc_raw_b_5 adc_raw_b_6 adc_raw_b_7 adc_raw_b_8 adc_raw_b_9 adc_raw_b_10 adc_raw_b_11 adc_raw_b_12 adc_raw_b_13 por_n ain_sin_p ain_sin_n ain_cos_p ain_cos_n vcm2 ibias ain_isa_p ain_isa_n ain_isb_p ain_isb_n vcm vdda vdd vss vref_in topap topan topbp topbn sar_clka sar_clkab sar_clkb sar_clkbb sar_clkna sar_clknab sar_clknb sar_clknbb sar_cna0 sar_cna1 sar_cna10 sar_cna11 sar_cna12 sar_cna2 sar_cna3 sar_cna4 sar_cna5 sar_cna6 sar_cna7 sar_cna8 sar_cna9 sar_cnb0 sar_cnb1 sar_cnb10 sar_cnb11 sar_cnb12 sar_cnb2 sar_cnb3 sar_cnb4 sar_cnb5 sar_cnb6 sar_cnb7 sar_cnb8 sar_cnb9 sar_cpa0 sar_cpa1 sar_cpa10 sar_cpa11 sar_cpa12 sar_cpa2 sar_cpa3 sar_cpa4 sar_cpa5 sar_cpa6 sar_cpa7 sar_cpa8 sar_cpa9 sar_cpb0 sar_cpb1 sar_cpb10 sar_cpb11 sar_cpb12 sar_cpb2 sar_cpb3 sar_cpb4 sar_cpb5 sar_cpb6 sar_cpb7 sar_cpb8 sar_cpb9 sar_oan sar_oann sar_oanp sar_oap sar_obn sar_obnn sar_obnp sar_obp sar_trka0 sar_trka1 sar_trkb0 sar_trkb1 sar_mclk
Xxckg_xpd0 xckg_d0 clk vdd vdd sg13_lv_pmos w=1u l=0.5u ng=1 m=1
Xxckg_xnd0 xckg_d0 clk vss vss sg13_lv_nmos w=0.5u l=0.5u ng=1 m=1
Xxckg_cd0 xckg_d0 vss cap_cmim w=2.53u l=2.53u m=1
Xxckg_xpd1 xckg_d1 xckg_d0 vdd vdd sg13_lv_pmos w=1u l=0.5u ng=1 m=1
Xxckg_xnd1 xckg_d1 xckg_d0 vss vss sg13_lv_nmos w=0.5u l=0.5u ng=1 m=1
Xxckg_cd1 xckg_d1 vss cap_cmim w=2.53u l=2.53u m=1
Xxckg_xpd2 xckg_d2 xckg_d1 vdd vdd sg13_lv_pmos w=1u l=0.5u ng=1 m=1
Xxckg_xnd2 xckg_d2 xckg_d1 vss vss sg13_lv_nmos w=0.5u l=0.5u ng=1 m=1
Xxckg_cd2 xckg_d2 vss cap_cmim w=2.53u l=2.53u m=1
Xxckg_xpd3 xckg_d3 xckg_d2 vdd vdd sg13_lv_pmos w=1u l=0.5u ng=1 m=1
Xxckg_xnd3 xckg_d3 xckg_d2 vss vss sg13_lv_nmos w=0.5u l=0.5u ng=1 m=1
Xxckg_cd3 xckg_d3 vss cap_cmim w=2.53u l=2.53u m=1
Xxckg_xpd4 xckg_x xckg_d3 vdd vdd sg13_lv_pmos w=1u l=0.5u ng=1 m=1
Xxckg_xnd4 xckg_x xckg_d3 vss vss sg13_lv_nmos w=0.5u l=0.5u ng=1 m=1
Xxckg_cd4 xckg_x vss cap_cmim w=2.53u l=2.53u m=1
Xxckg_xpa sar_mclk clk vdd vdd sg13_lv_pmos w=2u l=0.13u ng=1 m=1
Xxckg_xpb sar_mclk xckg_x vdd vdd sg13_lv_pmos w=2u l=0.13u ng=1 m=1
Xxckg_xna sar_mclk clk xckg_nn vss sg13_lv_nmos w=2u l=0.13u ng=1 m=1
Xxckg_xnb xckg_nn xckg_x vss vss sg13_lv_nmos w=2u l=0.13u ng=1 m=1
Xxckg_xpi mclkb sar_mclk vdd vdd sg13_lv_pmos w=2u l=0.13u ng=1 m=1
Xxckg_xni mclkb sar_mclk vss vss sg13_lv_nmos w=1u l=0.13u ng=1 m=1
Xxcbias_xmbd vbp vbp vdd vdd sg13_lv_pmos w=0.8u l=0.5u ng=1 m=1
Xxcbias_xrb_g0 vbp xcbias_xrb_s1 vss rppd w=1u l=40u m=1 b=0
Xxcbias_xrb_g1 xcbias_xrb_s1 xcbias_xrb_s2 vss rppd w=1u l=40u m=1 b=0
Xxcbias_xrb_g2 xcbias_xrb_s2 xcbias_xrb_s3 vss rppd w=1u l=40u m=1 b=0
Xxcbias_xrb_g3 xcbias_xrb_s3 vss vss rppd w=1u l=40u m=1 b=0
Xxcbiasn_xmbd vbn vbn vss vss sg13_lv_nmos w=0.2u l=0.5u ng=1 m=1
Xxcbiasn_xrb_g0 vdd xcbiasn_xrb_s1 vss rppd w=1u l=40u m=1 b=0
Xxcbiasn_xrb_g1 xcbiasn_xrb_s1 xcbiasn_xrb_s2 vss rppd w=1u l=40u m=1 b=0
Xxcbiasn_xrb_g2 xcbiasn_xrb_s2 xcbiasn_xrb_s3 vss rppd w=1u l=40u m=1 b=0
Xxcbiasn_xrb_g3 xcbiasn_xrb_s3 vbn vss rppd w=1u l=40u m=1 b=0
Xxref_xmb0 ibias ibias vss vss sg13_hv_nmos w=2u l=1u ng=1 m=1
Xxref_xmt xref_ntl ibias vss vss sg13_hv_nmos w=2u l=8u ng=1 m=1
Xxref_xm1 xref_na vref_in xref_ntl vss sg13_hv_nmos w=10u l=1u ng=2 m=1
Xxref_xm2 xref_ng vref xref_ntl vss sg13_hv_nmos w=10u l=1u ng=2 m=1
Xxref_xm3 xref_na xref_na vdda vdda sg13_hv_pmos w=4u l=1u ng=1 m=1
Xxref_xm4 xref_ng xref_na vdda vdda sg13_hv_pmos w=4u l=1u ng=1 m=1
Xxref_xcg_u0 vss xref_ng cap_cmim w=26.32u l=95u m=1
Xxref_xmsf_s0 vdda xref_ng vref vss sg13_hv_nmos w=80u l=0.45u ng=32 m=1
Xxref_xmsf_s1 vdda xref_ng vref vss sg13_hv_nmos w=80u l=0.45u ng=32 m=1
Xxref_xmsf_s2 vdda xref_ng vref vss sg13_hv_nmos w=80u l=0.45u ng=32 m=1
Xxref_xmsf_s3 vdda xref_ng vref vss sg13_hv_nmos w=80u l=0.45u ng=32 m=1
Xxref_xmib_s0 vref ibias vss vss sg13_hv_nmos w=80u l=1u ng=40 m=1
Xxref_xmib_s1 vref ibias vss vss sg13_hv_nmos w=80u l=1u ng=40 m=1
Xxref_xmib_s2 vref ibias vss vss sg13_hv_nmos w=80u l=1u ng=40 m=1
Xxref_xmib_s3 vref ibias vss vss sg13_hv_nmos w=80u l=1u ng=40 m=1
Xxref_xcd_u0 vss vref cap_cmim w=51.58u l=95u m=1
Xxref_xcd_u1 vss vref cap_cmim w=51.58u l=95u m=1
Xxref_xcd_u2 vss vref cap_cmim w=51.58u l=95u m=1
Xxref_xcd_u3 vss vref cap_cmim w=51.58u l=95u m=1
Xxref_xmsfl_s0 vdda xref_ng vrefl vss sg13_hv_nmos w=80u l=0.45u ng=32 m=1
Xxref_xmibl_s0 vrefl ibias vss vss sg13_hv_nmos w=80u l=1u ng=40 m=1
Xxref_xcdl_u0 vss vrefl cap_cmim w=51.58u l=95u m=1
Xxref_xcdl_u1 vss vrefl cap_cmim w=51.58u l=95u m=1
Xxfilt_xcf_u0 vss vref_in cap_cmim w=37.36u l=90u m=1
Xxfilt_xcf_u1 vss vref_in cap_cmim w=37.36u l=90u m=1
Xslice_a ain_sin_p ain_sin_n ain_isa_p ain_isa_n sar_trka0 sar_trka1 sar_cpa0 sar_cpa1 sar_cpa2 sar_cpa3 sar_cpa4 sar_cpa5 sar_cpa6 sar_cpa7 sar_cpa8 sar_cpa9 sar_cpa10 sar_cpa11 sar_cpa12 sar_cna0 sar_cna1 sar_cna2 sar_cna3 sar_cna4 sar_cna5 sar_cna6 sar_cna7 sar_cna8 sar_cna9 sar_cna10 sar_cna11 sar_cna12 sar_clka sar_clkab sar_clkna sar_clknab sar_oap sar_oan sar_oanp sar_oann vbp vbn vref vrefl topap topan vdd vss r1_adc_slice_post
Xslice_b ain_cos_p ain_cos_n ain_isb_p ain_isb_n sar_trkb0 sar_trkb1 sar_cpb0 sar_cpb1 sar_cpb2 sar_cpb3 sar_cpb4 sar_cpb5 sar_cpb6 sar_cpb7 sar_cpb8 sar_cpb9 sar_cpb10 sar_cpb11 sar_cpb12 sar_cnb0 sar_cnb1 sar_cnb2 sar_cnb3 sar_cnb4 sar_cnb5 sar_cnb6 sar_cnb7 sar_cnb8 sar_cnb9 sar_cnb10 sar_cnb11 sar_cnb12 sar_clkb sar_clkbb sar_clknb sar_clknbb sar_obp sar_obn sar_obnp sar_obnn vbp vbn vref vrefl topbp topbn vdd vss r1_adc_slice_post
Cq0 ain_cos_n ain_cos_p 2.707e-14
Cq1 ain_cos_n ain_isa_n 3.593e-17
Cq2 ain_cos_n ain_isa_p 4.589e-17
Cq3 ain_cos_n ibias 1.098e-16
Cq4 ain_cos_n vdd 7.405e-16
Cq5 ain_cos_n vss 3.272e-14
Cq6 ain_cos_n xckg_d0 9.755e-19
Cq7 ain_cos_n xckg_d1 9.755e-19
Cq8 ain_cos_n xckg_d2 9.755e-19
Cq9 ain_cos_n xckg_d3 1.006e-18
Cq10 ain_cos_n xckg_x 5.633e-18
Cq11 ain_cos_p ain_isa_n 3.579e-17
Cq12 ain_cos_p ain_isa_p 4.832e-17
Cq13 ain_cos_p ibias 6.162e-17
Cq14 ain_cos_p vdd 1.923e-15
Cq15 ain_cos_p vss 3.653e-14
Cq16 ain_isa_n ain_isa_p 2.783e-14
Cq17 ain_isa_n ain_isb_n 6.95e-17
Cq18 ain_isa_n ain_isb_p 6.95e-17
Cq19 ain_isa_n vdd 1.357e-15
Cq20 ain_isa_n vss 3.109e-14
Cq21 ain_isa_p ain_isb_n 8.473e-17
Cq22 ain_isa_p ain_isb_p 8.473e-17
Cq23 ain_isa_p vdd 1.764e-15
Cq24 ain_isa_p vss 3.146e-14
Cq25 ain_isb_n ain_isb_p 7.431e-17
Cq26 ain_isb_n vss 7.586e-16
Cq27 ain_isb_p vss 7.532e-16
Cq28 ain_sin_n ain_sin_p 8.625e-17
Cq29 ain_sin_n ibias 7.283e-17
Cq30 ain_sin_n vss 1.026e-15
Cq31 ain_sin_p ibias 7.607e-17
Cq32 ain_sin_p vss 9.168e-16
Cq33 clk mclkb 2.216e-18
Cq34 clk sar_mclk 1.431e-16
Cq35 clk vdd 4.256e-16
Cq36 clk vss 1.851e-14
Cq37 clk xckg_d0 2.205e-16
Cq38 clk xckg_d1 1.236e-16
Cq39 clk xckg_d2 1.227e-16
Cq40 clk xckg_d3 1.663e-16
Cq41 clk xckg_nn 2.534e-17
Cq42 clk xckg_x 1.452e-16
Cq43 ibias vbn 2.266e-15
Cq44 ibias vbp 6.102e-17
Cq45 ibias vdd 4.481e-15
Cq46 ibias vdda 2.216e-16
Cq47 ibias vref 4.109e-14
Cq48 ibias vref_in 9.277e-15
Cq49 ibias vrefl 1.686e-14
Cq50 ibias vss 1.742e-13
Cq51 ibias xref_ng 2.101e-15
Cq52 ibias xref_ntl 1.737e-16
Cq53 mclkb sar_mclk 2.613e-16
Cq54 mclkb vdd 3.878e-16
Cq55 mclkb vss 1.226e-15
Cq56 mclkb xckg_d0 5.591e-17
Cq57 mclkb xckg_d1 3.991e-15
Cq58 mclkb xckg_d2 3.955e-15
Cq59 mclkb xckg_d3 6.865e-17
Cq60 mclkb xckg_nn 1.864e-17
Cq61 mclkb xckg_x 9.569e-17
Cq62 sar_mclk vdd 1.621e-15
Cq63 sar_mclk vss 6.739e-15
Cq64 sar_mclk xckg_d0 4.707e-15
Cq65 sar_mclk xckg_d1 2.058e-16
Cq66 sar_mclk xckg_d2 7.519e-17
Cq67 sar_mclk xckg_d3 9.271e-17
Cq68 sar_mclk xckg_nn 4.141e-16
Cq69 sar_mclk xckg_x 1.044e-15
Cq70 vbn vbp 2.899e-14
Cq71 vbn vdd 2.028e-15
Cq72 vbn vdda 5.091e-17
Cq73 vbn vref 1.786e-14
Cq74 vbn vref_in 4.127e-15
Cq75 vbn vrefl 2.52e-14
Cq76 vbn vss 1.155e-14
Cq77 vbn xref_na 7.746e-19
Cq78 vbn xref_ng 1.886e-15
Cq79 vbp vdd 1.803e-15
Cq80 vbp vdda 8.761e-15
Cq81 vbp vref 1.878e-14
Cq82 vbp vref_in 4.205e-15
Cq83 vbp vrefl 1.08e-14
Cq84 vbp vss 1.857e-14
Cq85 vbp xref_na 9.789e-18
Cq86 vbp xref_ng 2.371e-15
Cq87 vdd vdda 5.954e-16
Cq88 vdd vref 1.718e-13
Cq89 vdd vref_in 4.013e-14
Cq90 vdd vrefl 5.877e-14
Cq91 vdd vss 9.496e-14
Cq92 vdd xckg_d0 5.453e-16
Cq93 vdd xckg_d1 3.963e-16
Cq94 vdd xckg_d2 2.615e-16
Cq95 vdd xckg_d3 3.642e-16
Cq96 vdd xckg_x 1.101e-15
Cq97 vdd xref_ng 1.71e-14
Cq98 vdda vref 4.398e-14
Cq99 vdda vref_in 3.223e-16
Cq100 vdda vrefl 2.519e-14
Cq101 vdda vss 3.507e-14
Cq102 vdda xref_na 1.249e-15
Cq103 vdda xref_ng 2.299e-14
Cq104 vdda xref_ntl 9.96e-18
Cq105 vref vref_in 4.54e-14
Cq106 vref vrefl 1.67e-13
Cq107 vref vss 3.743e-13
Cq108 vref xref_na 1.322e-16
Cq109 vref xref_ng 4.971e-14
Cq110 vref xref_ntl 1.685e-15
Cq111 vref_in vrefl 3.08e-14
Cq112 vref_in vss 9.461e-14
Cq113 vref_in xref_na 4.042e-16
Cq114 vref_in xref_ng 3.421e-15
Cq115 vref_in xref_ntl 1.606e-15
Cq116 vrefl vss 1.926e-13
Cq117 vrefl xref_na 1.039e-16
Cq118 vrefl xref_ng 3.178e-14
Cq119 vrefl xref_ntl 2.185e-15
Cq120 vss xckg_d0 4.966e-15
Cq121 vss xckg_d1 4.102e-15
Cq122 vss xckg_d2 4.829e-15
Cq123 vss xckg_d3 5.853e-15
Cq124 vss xckg_nn 1.117e-15
Cq125 vss xckg_x 1.086e-14
Cq126 vss xref_na 4.437e-15
Cq127 vss xref_ng 8.811e-14
Cq128 vss xref_ntl 3.71e-15
Cq129 xckg_d0 xckg_d1 8.434e-15
Cq130 xckg_d0 xckg_d2 2.37e-16
Cq131 xckg_d0 xckg_d3 1.818e-16
Cq132 xckg_d0 xckg_nn 2.011e-17
Cq133 xckg_d0 xckg_x 6.919e-16
Cq134 xckg_d1 xckg_d2 2.001e-15
Cq135 xckg_d1 xckg_d3 1.378e-16
Cq136 xckg_d1 xckg_nn 5.907e-16
Cq137 xckg_d1 xckg_x 4.219e-16
Cq138 xckg_d2 xckg_d3 8.547e-15
Cq139 xckg_d2 xckg_nn 5.574e-16
Cq140 xckg_d2 xckg_x 4.153e-16
Cq141 xckg_d3 xckg_nn 3.667e-17
Cq142 xckg_d3 xckg_x 5.111e-15
Cq143 xckg_nn xckg_x 1.118e-16
Cq144 xref_na xref_ng 2.554e-15
Cq145 xref_na xref_ntl 2.584e-16
Cq146 xref_ng xref_ntl 2.12e-15
.ends
.subckt r1_adc_lay_pr adc_hold is_smp clk adc_start adc_sel adc_valid_a adc_raw_a_0 adc_raw_a_1 adc_raw_a_2 adc_raw_a_3 adc_raw_a_4 adc_raw_a_5 adc_raw_a_6 adc_raw_a_7 adc_raw_a_8 adc_raw_a_9 adc_raw_a_10 adc_raw_a_11 adc_raw_a_12 adc_raw_a_13 adc_valid_b adc_raw_b_0 adc_raw_b_1 adc_raw_b_2 adc_raw_b_3 adc_raw_b_4 adc_raw_b_5 adc_raw_b_6 adc_raw_b_7 adc_raw_b_8 adc_raw_b_9 adc_raw_b_10 adc_raw_b_11 adc_raw_b_12 adc_raw_b_13 por_n ain_sin_p ain_sin_n ain_cos_p ain_cos_n vcm2 ibias ain_isa_p ain_isa_n ain_isb_p ain_isb_n vcm vdda vdd vss vref_in topap topan topbp topbn sar_clka sar_clkab sar_clkb sar_clkbb sar_clkna sar_clknab sar_clknb sar_clknbb sar_cna0 sar_cna1 sar_cna10 sar_cna11 sar_cna12 sar_cna2 sar_cna3 sar_cna4 sar_cna5 sar_cna6 sar_cna7 sar_cna8 sar_cna9 sar_cnb0 sar_cnb1 sar_cnb10 sar_cnb11 sar_cnb12 sar_cnb2 sar_cnb3 sar_cnb4 sar_cnb5 sar_cnb6 sar_cnb7 sar_cnb8 sar_cnb9 sar_cpa0 sar_cpa1 sar_cpa10 sar_cpa11 sar_cpa12 sar_cpa2 sar_cpa3 sar_cpa4 sar_cpa5 sar_cpa6 sar_cpa7 sar_cpa8 sar_cpa9 sar_cpb0 sar_cpb1 sar_cpb10 sar_cpb11 sar_cpb12 sar_cpb2 sar_cpb3 sar_cpb4 sar_cpb5 sar_cpb6 sar_cpb7 sar_cpb8 sar_cpb9 sar_oan sar_oann sar_oanp sar_oap sar_obn sar_obnn sar_obnp sar_obp sar_trka0 sar_trka1 sar_trkb0 sar_trkb1 sar_mclk vref vrefl
Xxckg_xpd0 xckg_d0 clk vdd vdd sg13_lv_pmos w=1u l=0.5u ng=1 m=1
Xxckg_xnd0 xckg_d0 clk vss vss sg13_lv_nmos w=0.5u l=0.5u ng=1 m=1
Xxckg_cd0 xckg_d0 vss cap_cmim w=2.53u l=2.53u m=1
Xxckg_xpd1 xckg_d1 xckg_d0 vdd vdd sg13_lv_pmos w=1u l=0.5u ng=1 m=1
Xxckg_xnd1 xckg_d1 xckg_d0 vss vss sg13_lv_nmos w=0.5u l=0.5u ng=1 m=1
Xxckg_cd1 xckg_d1 vss cap_cmim w=2.53u l=2.53u m=1
Xxckg_xpd2 xckg_d2 xckg_d1 vdd vdd sg13_lv_pmos w=1u l=0.5u ng=1 m=1
Xxckg_xnd2 xckg_d2 xckg_d1 vss vss sg13_lv_nmos w=0.5u l=0.5u ng=1 m=1
Xxckg_cd2 xckg_d2 vss cap_cmim w=2.53u l=2.53u m=1
Xxckg_xpd3 xckg_d3 xckg_d2 vdd vdd sg13_lv_pmos w=1u l=0.5u ng=1 m=1
Xxckg_xnd3 xckg_d3 xckg_d2 vss vss sg13_lv_nmos w=0.5u l=0.5u ng=1 m=1
Xxckg_cd3 xckg_d3 vss cap_cmim w=2.53u l=2.53u m=1
Xxckg_xpd4 xckg_x xckg_d3 vdd vdd sg13_lv_pmos w=1u l=0.5u ng=1 m=1
Xxckg_xnd4 xckg_x xckg_d3 vss vss sg13_lv_nmos w=0.5u l=0.5u ng=1 m=1
Xxckg_cd4 xckg_x vss cap_cmim w=2.53u l=2.53u m=1
Xxckg_xpa sar_mclk clk vdd vdd sg13_lv_pmos w=2u l=0.13u ng=1 m=1
Xxckg_xpb sar_mclk xckg_x vdd vdd sg13_lv_pmos w=2u l=0.13u ng=1 m=1
Xxckg_xna sar_mclk clk xckg_nn vss sg13_lv_nmos w=2u l=0.13u ng=1 m=1
Xxckg_xnb xckg_nn xckg_x vss vss sg13_lv_nmos w=2u l=0.13u ng=1 m=1
Xxckg_xpi mclkb sar_mclk vdd vdd sg13_lv_pmos w=2u l=0.13u ng=1 m=1
Xxckg_xni mclkb sar_mclk vss vss sg13_lv_nmos w=1u l=0.13u ng=1 m=1
Xxcbias_xmbd vbp vbp vdd vdd sg13_lv_pmos w=0.8u l=0.5u ng=1 m=1
Xxcbias_xrb_g0 vbp xcbias_xrb_s1 vss rppd w=1u l=40u m=1 b=0
Xxcbias_xrb_g1 xcbias_xrb_s1 xcbias_xrb_s2 vss rppd w=1u l=40u m=1 b=0
Xxcbias_xrb_g2 xcbias_xrb_s2 xcbias_xrb_s3 vss rppd w=1u l=40u m=1 b=0
Xxcbias_xrb_g3 xcbias_xrb_s3 vss vss rppd w=1u l=40u m=1 b=0
Xxcbiasn_xmbd vbn vbn vss vss sg13_lv_nmos w=0.2u l=0.5u ng=1 m=1
Xxcbiasn_xrb_g0 vdd xcbiasn_xrb_s1 vss rppd w=1u l=40u m=1 b=0
Xxcbiasn_xrb_g1 xcbiasn_xrb_s1 xcbiasn_xrb_s2 vss rppd w=1u l=40u m=1 b=0
Xxcbiasn_xrb_g2 xcbiasn_xrb_s2 xcbiasn_xrb_s3 vss rppd w=1u l=40u m=1 b=0
Xxcbiasn_xrb_g3 xcbiasn_xrb_s3 vbn vss rppd w=1u l=40u m=1 b=0
Xxref_xmb0 ibias ibias vss vss sg13_hv_nmos w=2u l=1u ng=1 m=1
Xxref_xmt xref_ntl ibias vss vss sg13_hv_nmos w=2u l=8u ng=1 m=1
Xxref_xm1 xref_na vref_in xref_ntl vss sg13_hv_nmos w=10u l=1u ng=2 m=1
Xxref_xm2 xref_ng vref xref_ntl vss sg13_hv_nmos w=10u l=1u ng=2 m=1
Xxref_xm3 xref_na xref_na vdda vdda sg13_hv_pmos w=4u l=1u ng=1 m=1
Xxref_xm4 xref_ng xref_na vdda vdda sg13_hv_pmos w=4u l=1u ng=1 m=1
Xxref_xcg_u0 vss xref_ng cap_cmim w=26.32u l=95u m=1
Xxref_xmsf_s0 vdda xref_ng vref vss sg13_hv_nmos w=80u l=0.45u ng=32 m=1
Xxref_xmsf_s1 vdda xref_ng vref vss sg13_hv_nmos w=80u l=0.45u ng=32 m=1
Xxref_xmsf_s2 vdda xref_ng vref vss sg13_hv_nmos w=80u l=0.45u ng=32 m=1
Xxref_xmsf_s3 vdda xref_ng vref vss sg13_hv_nmos w=80u l=0.45u ng=32 m=1
Xxref_xmib_s0 vref ibias vss vss sg13_hv_nmos w=80u l=1u ng=40 m=1
Xxref_xmib_s1 vref ibias vss vss sg13_hv_nmos w=80u l=1u ng=40 m=1
Xxref_xmib_s2 vref ibias vss vss sg13_hv_nmos w=80u l=1u ng=40 m=1
Xxref_xmib_s3 vref ibias vss vss sg13_hv_nmos w=80u l=1u ng=40 m=1
Xxref_xcd_u0 vss vref cap_cmim w=51.58u l=95u m=1
Xxref_xcd_u1 vss vref cap_cmim w=51.58u l=95u m=1
Xxref_xcd_u2 vss vref cap_cmim w=51.58u l=95u m=1
Xxref_xcd_u3 vss vref cap_cmim w=51.58u l=95u m=1
Xxref_xmsfl_s0 vdda xref_ng vrefl vss sg13_hv_nmos w=80u l=0.45u ng=32 m=1
Xxref_xmibl_s0 vrefl ibias vss vss sg13_hv_nmos w=80u l=1u ng=40 m=1
Xxref_xcdl_u0 vss vrefl cap_cmim w=51.58u l=95u m=1
Xxref_xcdl_u1 vss vrefl cap_cmim w=51.58u l=95u m=1
Xxfilt_xcf_u0 vss vref_in cap_cmim w=37.36u l=90u m=1
Xxfilt_xcf_u1 vss vref_in cap_cmim w=37.36u l=90u m=1
Xslice_a ain_sin_p ain_sin_n ain_isa_p ain_isa_n sar_trka0 sar_trka1 sar_cpa0 sar_cpa1 sar_cpa2 sar_cpa3 sar_cpa4 sar_cpa5 sar_cpa6 sar_cpa7 sar_cpa8 sar_cpa9 sar_cpa10 sar_cpa11 sar_cpa12 sar_cna0 sar_cna1 sar_cna2 sar_cna3 sar_cna4 sar_cna5 sar_cna6 sar_cna7 sar_cna8 sar_cna9 sar_cna10 sar_cna11 sar_cna12 sar_clka sar_clkab sar_clkna sar_clknab sar_oap sar_oan sar_oanp sar_oann vbp vbn vref vrefl topap topan vdd vss r1_adc_slice_post
Xslice_b ain_cos_p ain_cos_n ain_isb_p ain_isb_n sar_trkb0 sar_trkb1 sar_cpb0 sar_cpb1 sar_cpb2 sar_cpb3 sar_cpb4 sar_cpb5 sar_cpb6 sar_cpb7 sar_cpb8 sar_cpb9 sar_cpb10 sar_cpb11 sar_cpb12 sar_cnb0 sar_cnb1 sar_cnb2 sar_cnb3 sar_cnb4 sar_cnb5 sar_cnb6 sar_cnb7 sar_cnb8 sar_cnb9 sar_cnb10 sar_cnb11 sar_cnb12 sar_clkb sar_clkbb sar_clknb sar_clknbb sar_obp sar_obn sar_obnp sar_obnn vbp vbn vref vrefl topbp topbn vdd vss r1_adc_slice_post
Cq0 ain_cos_n ain_cos_p 2.707e-14
Cq1 ain_cos_n ain_isa_n 3.593e-17
Cq2 ain_cos_n ain_isa_p 4.589e-17
Cq3 ain_cos_n ibias 1.098e-16
Cq4 ain_cos_n vdd 7.405e-16
Cq5 ain_cos_n vss 3.272e-14
Cq6 ain_cos_n xckg_d0 9.755e-19
Cq7 ain_cos_n xckg_d1 9.755e-19
Cq8 ain_cos_n xckg_d2 9.755e-19
Cq9 ain_cos_n xckg_d3 1.006e-18
Cq10 ain_cos_n xckg_x 5.633e-18
Cq11 ain_cos_p ain_isa_n 3.579e-17
Cq12 ain_cos_p ain_isa_p 4.832e-17
Cq13 ain_cos_p ibias 6.162e-17
Cq14 ain_cos_p vdd 1.923e-15
Cq15 ain_cos_p vss 3.653e-14
Cq16 ain_isa_n ain_isa_p 2.783e-14
Cq17 ain_isa_n ain_isb_n 6.95e-17
Cq18 ain_isa_n ain_isb_p 6.95e-17
Cq19 ain_isa_n vdd 1.357e-15
Cq20 ain_isa_n vss 3.109e-14
Cq21 ain_isa_p ain_isb_n 8.473e-17
Cq22 ain_isa_p ain_isb_p 8.473e-17
Cq23 ain_isa_p vdd 1.764e-15
Cq24 ain_isa_p vss 3.146e-14
Cq25 ain_isb_n ain_isb_p 7.431e-17
Cq26 ain_isb_n vss 7.586e-16
Cq27 ain_isb_p vss 7.532e-16
Cq28 ain_sin_n ain_sin_p 8.625e-17
Cq29 ain_sin_n ibias 7.283e-17
Cq30 ain_sin_n vss 1.026e-15
Cq31 ain_sin_p ibias 7.607e-17
Cq32 ain_sin_p vss 9.168e-16
Cq33 clk mclkb 2.216e-18
Cq34 clk sar_mclk 1.431e-16
Cq35 clk vdd 4.256e-16
Cq36 clk vss 1.851e-14
Cq37 clk xckg_d0 2.205e-16
Cq38 clk xckg_d1 1.236e-16
Cq39 clk xckg_d2 1.227e-16
Cq40 clk xckg_d3 1.663e-16
Cq41 clk xckg_nn 2.534e-17
Cq42 clk xckg_x 1.452e-16
Cq43 ibias vbn 2.266e-15
Cq44 ibias vbp 6.102e-17
Cq45 ibias vdd 4.481e-15
Cq46 ibias vdda 2.216e-16
Cq47 ibias vref 4.109e-14
Cq48 ibias vref_in 9.277e-15
Cq49 ibias vrefl 1.686e-14
Cq50 ibias vss 1.742e-13
Cq51 ibias xref_ng 2.101e-15
Cq52 ibias xref_ntl 1.737e-16
Cq53 mclkb sar_mclk 2.613e-16
Cq54 mclkb vdd 3.878e-16
Cq55 mclkb vss 1.226e-15
Cq56 mclkb xckg_d0 5.591e-17
Cq57 mclkb xckg_d1 3.991e-15
Cq58 mclkb xckg_d2 3.955e-15
Cq59 mclkb xckg_d3 6.865e-17
Cq60 mclkb xckg_nn 1.864e-17
Cq61 mclkb xckg_x 9.569e-17
Cq62 sar_mclk vdd 1.621e-15
Cq63 sar_mclk vss 6.739e-15
Cq64 sar_mclk xckg_d0 4.707e-15
Cq65 sar_mclk xckg_d1 2.058e-16
Cq66 sar_mclk xckg_d2 7.519e-17
Cq67 sar_mclk xckg_d3 9.271e-17
Cq68 sar_mclk xckg_nn 4.141e-16
Cq69 sar_mclk xckg_x 1.044e-15
Cq70 vbn vbp 2.899e-14
Cq71 vbn vdd 2.028e-15
Cq72 vbn vdda 5.091e-17
Cq73 vbn vref 1.786e-14
Cq74 vbn vref_in 4.127e-15
Cq75 vbn vrefl 2.52e-14
Cq76 vbn vss 1.155e-14
Cq77 vbn xref_na 7.746e-19
Cq78 vbn xref_ng 1.886e-15
Cq79 vbp vdd 1.803e-15
Cq80 vbp vdda 8.761e-15
Cq81 vbp vref 1.878e-14
Cq82 vbp vref_in 4.205e-15
Cq83 vbp vrefl 1.08e-14
Cq84 vbp vss 1.857e-14
Cq85 vbp xref_na 9.789e-18
Cq86 vbp xref_ng 2.371e-15
Cq87 vdd vdda 5.954e-16
Cq88 vdd vref 1.718e-13
Cq89 vdd vref_in 4.013e-14
Cq90 vdd vrefl 5.877e-14
Cq91 vdd vss 9.496e-14
Cq92 vdd xckg_d0 5.453e-16
Cq93 vdd xckg_d1 3.963e-16
Cq94 vdd xckg_d2 2.615e-16
Cq95 vdd xckg_d3 3.642e-16
Cq96 vdd xckg_x 1.101e-15
Cq97 vdd xref_ng 1.71e-14
Cq98 vdda vref 4.398e-14
Cq99 vdda vref_in 3.223e-16
Cq100 vdda vrefl 2.519e-14
Cq101 vdda vss 3.507e-14
Cq102 vdda xref_na 1.249e-15
Cq103 vdda xref_ng 2.299e-14
Cq104 vdda xref_ntl 9.96e-18
Cq105 vref vref_in 4.54e-14
Cq106 vref vrefl 1.67e-13
Cq107 vref vss 3.743e-13
Cq108 vref xref_na 1.322e-16
Cq109 vref xref_ng 4.971e-14
Cq110 vref xref_ntl 1.685e-15
Cq111 vref_in vrefl 3.08e-14
Cq112 vref_in vss 9.461e-14
Cq113 vref_in xref_na 4.042e-16
Cq114 vref_in xref_ng 3.421e-15
Cq115 vref_in xref_ntl 1.606e-15
Cq116 vrefl vss 1.926e-13
Cq117 vrefl xref_na 1.039e-16
Cq118 vrefl xref_ng 3.178e-14
Cq119 vrefl xref_ntl 2.185e-15
Cq120 vss xckg_d0 4.966e-15
Cq121 vss xckg_d1 4.102e-15
Cq122 vss xckg_d2 4.829e-15
Cq123 vss xckg_d3 5.853e-15
Cq124 vss xckg_nn 1.117e-15
Cq125 vss xckg_x 1.086e-14
Cq126 vss xref_na 4.437e-15
Cq127 vss xref_ng 8.811e-14
Cq128 vss xref_ntl 3.71e-15
Cq129 xckg_d0 xckg_d1 8.434e-15
Cq130 xckg_d0 xckg_d2 2.37e-16
Cq131 xckg_d0 xckg_d3 1.818e-16
Cq132 xckg_d0 xckg_nn 2.011e-17
Cq133 xckg_d0 xckg_x 6.919e-16
Cq134 xckg_d1 xckg_d2 2.001e-15
Cq135 xckg_d1 xckg_d3 1.378e-16
Cq136 xckg_d1 xckg_nn 5.907e-16
Cq137 xckg_d1 xckg_x 4.219e-16
Cq138 xckg_d2 xckg_d3 8.547e-15
Cq139 xckg_d2 xckg_nn 5.574e-16
Cq140 xckg_d2 xckg_x 4.153e-16
Cq141 xckg_d3 xckg_nn 3.667e-17
Cq142 xckg_d3 xckg_x 5.111e-15
Cq143 xckg_nn xckg_x 1.118e-16
Cq144 xref_na xref_ng 2.554e-15
Cq145 xref_na xref_ntl 2.584e-16
Cq146 xref_ng xref_ntl 2.12e-15
.ends
