* sar/sim/tb_gl_mux.cir -- generated by sar/sim/gen_gl_deck.py (T2j, D21); do not edit.
* r5 mux-sequence deck (frames ecee) with the gate-level r1_adc_sar (GLNET) and the r1_gate protocol.
* Substitutions: CORNER TEMP VDD SAVELIST RAW GLNET.
.lib /foss/pdks/ihp-sg13g2/libs.tech/ngspice/models/cornerMOSlv.lib CORNER
.lib /foss/pdks/ihp-sg13g2/libs.tech/ngspice/models/cornerCAP.lib cap_typ
.lib /foss/pdks/ihp-sg13g2/libs.tech/ngspice/models/cornerMOShv.lib CORNER
.lib /foss/pdks/ihp-sg13g2/libs.tech/ngspice/models/cornerRES.lib res_typ
.include schematic/r1_adc_r5.spice
.include /foss/pdks/ihp-sg13g2/libs.ref/sg13g2_stdcell/spice/sg13g2_stdcell.spice
.include GLNET
.temp TEMP
* options as the r5 decks without 'klu': with the cell netlists the KLU operating point fails (run
* t2j-ms-e-tt-c: timestep too small at vbg); the default SPARSE solver finds it
.option reltol=1e-4 vntol=1e-6 abstol=1e-12 method=trap seed=1
Vdd vdd 0 VDD
Vdda vdda 0 3.3
Vbgi vbgw 0 DC 1.045 TRNOISE(0.0004646 4.73e-08 0 0)
Vbgf vbgi vbgw DC 0 TRNOISE(0 4.73e-08 1.15 1.285e-05)
Rbg vbgi vbg 190k
XCF vbg 0 r1_reffilt5 w=82u
Ibref vdda nbr 5u
XREF vbg vref vrefl nbr vdda 0 r1_refbuf5 ndec=4 ndecl=2
Vtvrefa vrefa vref 0
Vtvrefb vrefb vref 0
Vtvrefla vrefla vrefl 0
Vtvreflb vreflb vrefl 0
Vcme vcme 0 0.6
Vcmi vcmi 0 0.6
Vsin vsin 0 PWL(0 0.40 1.012u 0.40 1.022u -0.40 2.352u -0.40 2.362u 0.72 6u 0.72)
Visa visa 0 0.85
Esp sinp vcme vsin 0 0.5
Esn sinn vcme vsin 0 -0.5
Ecp cosp vcme vsin 0 -0.5
Ecn cosn vcme vsin 0 0.5
Eap isap vcmi visa 0 0.5
Ean isan vcmi visa 0 -0.5
Ebp isbp vcmi visa 0 -0.5
Ebn isbn vcmi visa 0 0.5
* clk30 as sim/r5/gen_timing_r5.py
Vclk30 clk 0 PULSE(0 VDD 33.3333333n 50p 50p 16.6166667n 33.3333333n)
Vpor por_n 0 PWL(0 0 50n 0 50.05n VDD)
Vadc_start adc_start 0 PWL(0 0 600.3000n 0 600.3500n VDD 633.6333n VDD 633.6833n 0 1333.6333n 0 1333.6833n VDD 1366.9667n VDD 1367.0167n 0 2066.9667n 0 2067.0167n VDD 2100.3000n VDD 2100.3500n 0 2800.3000n 0 2800.3500n VDD 2833.6333n VDD 2833.6833n 0)
Vadc_hold adc_hold 0 PWL(0 0 100.3000n 0 100.3500n VDD 166.9667n VDD 167.0167n 0 600.3000n 0 600.3500n VDD 1100.3000n VDD 1100.3500n 0 2066.9667n 0 2067.0167n VDD 2566.9667n VDD 2567.0167n 0 2800.3000n 0 2800.3500n VDD 3300.3000n VDD 3300.3500n 0)
Vis_smp is_smp 0 PWL(0 0 1333.6333n 0 1333.6833n VDD 1833.6333n VDD 1833.6833n 0)
Vcur_trk cur_trk 0 PWL(0 0 1000.3000n 0 1000.3500n VDD 1366.9667n VDD 1367.0167n 0)
Vsel adc_sel 0 0
* analog core: r1_adc5_core without XSAR
XCKG clk mclk mclkb vdd 0 r1_cmp4_clkgen
XTHA sinp sinn isap isan trka0 trka1 topap topan cpa12 cpa11 cpa10 cpa9 cpa8 cpa7 cpa6 cpa5 cpa4 cpa3 cpa2 cpa1 cpa0 cna12 cna11 cna10 cna9 cna8 cna7 cna6 cna5 cna4 cna3 cna2 cna1 cna0 vdd vrefa vrefla 0 r1_th4
XCBIAS vbp vdd 0 r1_cmp4_bias
XCBIASN vbn vdd 0 r1_cmp5n_bias
XCMPA topap topan clka clkab oap oan vbp vdd 0 r1_cmp4
XCMPNA topap topan clkna clknab oanp oann vbn vdd 0 r1_cmp5n
XTHB cosp cosn isbp isbn trkb0 trkb1 topbp topbn cpb12 cpb11 cpb10 cpb9 cpb8 cpb7 cpb6 cpb5 cpb4 cpb3 cpb2 cpb1 cpb0 cnb12 cnb11 cnb10 cnb9 cnb8 cnb7 cnb6 cnb5 cnb4 cnb3 cnb2 cnb1 cnb0 vdd vrefb vreflb 0 r1_th4
XCMPB topbp topbn clkb clkbb obp obn vbp vdd 0 r1_cmp4
XCMPNB topbp topbn clknb clknbb obnp obnn vbn vdd 0 r1_cmp5n
* gate-level SAR logic and sequencer
XSAR adc_hold adc_sel adc_start adc_valid_a adc_valid_b clk clka clkab clkb clkbb clkna clknab clknb clknbb cur_trk is_smp mclk oan oann oanp oap obn obnn obnp obp por_n trka0 trka1 trkb0 trkb1 adc_raw_a_13 adc_raw_a_12 adc_raw_a_11 adc_raw_a_10 adc_raw_a_9 adc_raw_a_8 adc_raw_a_7 adc_raw_a_6 adc_raw_a_5 adc_raw_a_4 adc_raw_a_3 adc_raw_a_2 adc_raw_a_1 adc_raw_a_0 adc_raw_b_13 adc_raw_b_12 adc_raw_b_11 adc_raw_b_10 adc_raw_b_9 adc_raw_b_8 adc_raw_b_7 adc_raw_b_6 adc_raw_b_5 adc_raw_b_4 adc_raw_b_3 adc_raw_b_2 adc_raw_b_1 adc_raw_b_0 cna12 cna11 cna10 cna9 cna8 cna7 cna6 cna5 cna4 cna3 cna2 cna1 cna0 cnb12 cnb11 cnb10 cnb9 cnb8 cnb7 cnb6 cnb5 cnb4 cnb3 cnb2 cnb1 cnb0 cpa12 cpa11 cpa10 cpa9 cpa8 cpa7 cpa6 cpa5 cpa4 cpa3 cpa2 cpa1 cpa0 cpb12 cpb11 cpb10 cpb9 cpb8 cpb7 cpb6 cpb5 cpb4 cpb3 cpb2 cpb1 cpb0 vdd 0 r1_adc_sar_gl
.control
set num_threads=1
save SAVELIST
tran 1n 3.31u 0 0.2n
write RAW/sar.raw
.endc
.end
