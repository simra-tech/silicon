* r1_bgr generated by gen_r1_bgr.py n1=12 n2=48 n3=4 m=8 r1=84u r2=347.5u rb=500u rx=192u
.subckt r1_bgr vdd vss vref iptat pbias pcasc vbe dvbe
XMP1_0 d1_0 pbias vdd vdd sg13_hv_pmos w=10u l=4u ng=1 m=1 mm_ok=1
XMC1_0 n1 pcasc d1_0 d1_0 sg13_hv_pmos w=10u l=4u ng=1 m=1 mm_ok=1
XMNC1_0 n1 vb2 vbe vss sg13_hv_nmos w=20u l=1u ng=1 m=1 mm_ok=1
XMP1_1 d1_1 pbias vdd vdd sg13_hv_pmos w=10u l=4u ng=1 m=1 mm_ok=1
XMC1_1 n1 pcasc d1_1 d1_1 sg13_hv_pmos w=10u l=4u ng=1 m=1 mm_ok=1
XMNC1_1 n1 vb2 vbe vss sg13_hv_nmos w=20u l=1u ng=1 m=1 mm_ok=1
XMP1_2 d1_2 pbias vdd vdd sg13_hv_pmos w=10u l=4u ng=1 m=1 mm_ok=1
XMC1_2 n1 pcasc d1_2 d1_2 sg13_hv_pmos w=10u l=4u ng=1 m=1 mm_ok=1
XMNC1_2 n1 vb2 vbe vss sg13_hv_nmos w=20u l=1u ng=1 m=1 mm_ok=1
XMP1_3 d1_3 pbias vdd vdd sg13_hv_pmos w=10u l=4u ng=1 m=1 mm_ok=1
XMC1_3 n1 pcasc d1_3 d1_3 sg13_hv_pmos w=10u l=4u ng=1 m=1 mm_ok=1
XMNC1_3 n1 vb2 vbe vss sg13_hv_nmos w=20u l=1u ng=1 m=1 mm_ok=1
XMP1_4 d1_4 pbias vdd vdd sg13_hv_pmos w=10u l=4u ng=1 m=1 mm_ok=1
XMC1_4 n1 pcasc d1_4 d1_4 sg13_hv_pmos w=10u l=4u ng=1 m=1 mm_ok=1
XMNC1_4 n1 vb2 vbe vss sg13_hv_nmos w=20u l=1u ng=1 m=1 mm_ok=1
XMP1_5 d1_5 pbias vdd vdd sg13_hv_pmos w=10u l=4u ng=1 m=1 mm_ok=1
XMC1_5 n1 pcasc d1_5 d1_5 sg13_hv_pmos w=10u l=4u ng=1 m=1 mm_ok=1
XMNC1_5 n1 vb2 vbe vss sg13_hv_nmos w=20u l=1u ng=1 m=1 mm_ok=1
XMP1_6 d1_6 pbias vdd vdd sg13_hv_pmos w=10u l=4u ng=1 m=1 mm_ok=1
XMC1_6 n1 pcasc d1_6 d1_6 sg13_hv_pmos w=10u l=4u ng=1 m=1 mm_ok=1
XMNC1_6 n1 vb2 vbe vss sg13_hv_nmos w=20u l=1u ng=1 m=1 mm_ok=1
XMP1_7 d1_7 pbias vdd vdd sg13_hv_pmos w=10u l=4u ng=1 m=1 mm_ok=1
XMC1_7 n1 pcasc d1_7 d1_7 sg13_hv_pmos w=10u l=4u ng=1 m=1 mm_ok=1
XMNC1_7 n1 vb2 vbe vss sg13_hv_nmos w=20u l=1u ng=1 m=1 mm_ok=1
XMP2 d2 pbias vdd vdd sg13_hv_pmos w=10u l=4u ng=1 m=1 mm_ok=1
XMC2 pbias pcasc d2 d2 sg13_hv_pmos w=10u l=4u ng=1 m=1 mm_ok=1
XRB pbias pcasc sub! rppd w=1u l=500u m=1 b=0 mm_ok=1
XMNC2 pcasc vb2 c2 vss sg13_hv_nmos w=20u l=1u ng=1 m=1 mm_ok=1
XMP5 d5 pbias vdd vdd sg13_hv_pmos w=10u l=4u ng=1 m=1 mm_ok=1
XMC5 vb2 pcasc d5 d5 sg13_hv_pmos w=10u l=4u ng=1 m=1 mm_ok=1
XRX vb2 vd1 sub! rppd w=1u l=192u m=1 b=0 mm_ok=1
XQD1 vd1 vd1 vd2 vss npn13G2 Nx=1 mm_ok=1
XQD2 vd2 vd2 vss vss npn13G2 Nx=1 mm_ok=1
XQ1_0 vbe vbe vss vss npn13G2 Nx=1 mm_ok=1
XQ1_1 vbe vbe vss vss npn13G2 Nx=1 mm_ok=1
XQ1_2 vbe vbe vss vss npn13G2 Nx=1 mm_ok=1
XQ1_3 vbe vbe vss vss npn13G2 Nx=1 mm_ok=1
XQ1_4 vbe vbe vss vss npn13G2 Nx=1 mm_ok=1
XQ1_5 vbe vbe vss vss npn13G2 Nx=1 mm_ok=1
XQ1_6 vbe vbe vss vss npn13G2 Nx=1 mm_ok=1
XQ1_7 vbe vbe vss vss npn13G2 Nx=1 mm_ok=1
XQ1_8 vbe vbe vss vss npn13G2 Nx=1 mm_ok=1
XQ1_9 vbe vbe vss vss npn13G2 Nx=1 mm_ok=1
XQ1_10 vbe vbe vss vss npn13G2 Nx=1 mm_ok=1
XQ1_11 vbe vbe vss vss npn13G2 Nx=1 mm_ok=1
XQ2_0 c2 vbe dvbe vss npn13G2 Nx=1 mm_ok=1
XQ2_1 c2 vbe dvbe vss npn13G2 Nx=1 mm_ok=1
XQ2_2 c2 vbe dvbe vss npn13G2 Nx=1 mm_ok=1
XQ2_3 c2 vbe dvbe vss npn13G2 Nx=1 mm_ok=1
XQ2_4 c2 vbe dvbe vss npn13G2 Nx=1 mm_ok=1
XQ2_5 c2 vbe dvbe vss npn13G2 Nx=1 mm_ok=1
XQ2_6 c2 vbe dvbe vss npn13G2 Nx=1 mm_ok=1
XQ2_7 c2 vbe dvbe vss npn13G2 Nx=1 mm_ok=1
XQ2_8 c2 vbe dvbe vss npn13G2 Nx=1 mm_ok=1
XQ2_9 c2 vbe dvbe vss npn13G2 Nx=1 mm_ok=1
XQ2_10 c2 vbe dvbe vss npn13G2 Nx=1 mm_ok=1
XQ2_11 c2 vbe dvbe vss npn13G2 Nx=1 mm_ok=1
XQ2_12 c2 vbe dvbe vss npn13G2 Nx=1 mm_ok=1
XQ2_13 c2 vbe dvbe vss npn13G2 Nx=1 mm_ok=1
XQ2_14 c2 vbe dvbe vss npn13G2 Nx=1 mm_ok=1
XQ2_15 c2 vbe dvbe vss npn13G2 Nx=1 mm_ok=1
XQ2_16 c2 vbe dvbe vss npn13G2 Nx=1 mm_ok=1
XQ2_17 c2 vbe dvbe vss npn13G2 Nx=1 mm_ok=1
XQ2_18 c2 vbe dvbe vss npn13G2 Nx=1 mm_ok=1
XQ2_19 c2 vbe dvbe vss npn13G2 Nx=1 mm_ok=1
XQ2_20 c2 vbe dvbe vss npn13G2 Nx=1 mm_ok=1
XQ2_21 c2 vbe dvbe vss npn13G2 Nx=1 mm_ok=1
XQ2_22 c2 vbe dvbe vss npn13G2 Nx=1 mm_ok=1
XQ2_23 c2 vbe dvbe vss npn13G2 Nx=1 mm_ok=1
XQ2_24 c2 vbe dvbe vss npn13G2 Nx=1 mm_ok=1
XQ2_25 c2 vbe dvbe vss npn13G2 Nx=1 mm_ok=1
XQ2_26 c2 vbe dvbe vss npn13G2 Nx=1 mm_ok=1
XQ2_27 c2 vbe dvbe vss npn13G2 Nx=1 mm_ok=1
XQ2_28 c2 vbe dvbe vss npn13G2 Nx=1 mm_ok=1
XQ2_29 c2 vbe dvbe vss npn13G2 Nx=1 mm_ok=1
XQ2_30 c2 vbe dvbe vss npn13G2 Nx=1 mm_ok=1
XQ2_31 c2 vbe dvbe vss npn13G2 Nx=1 mm_ok=1
XQ2_32 c2 vbe dvbe vss npn13G2 Nx=1 mm_ok=1
XQ2_33 c2 vbe dvbe vss npn13G2 Nx=1 mm_ok=1
XQ2_34 c2 vbe dvbe vss npn13G2 Nx=1 mm_ok=1
XQ2_35 c2 vbe dvbe vss npn13G2 Nx=1 mm_ok=1
XQ2_36 c2 vbe dvbe vss npn13G2 Nx=1 mm_ok=1
XQ2_37 c2 vbe dvbe vss npn13G2 Nx=1 mm_ok=1
XQ2_38 c2 vbe dvbe vss npn13G2 Nx=1 mm_ok=1
XQ2_39 c2 vbe dvbe vss npn13G2 Nx=1 mm_ok=1
XQ2_40 c2 vbe dvbe vss npn13G2 Nx=1 mm_ok=1
XQ2_41 c2 vbe dvbe vss npn13G2 Nx=1 mm_ok=1
XQ2_42 c2 vbe dvbe vss npn13G2 Nx=1 mm_ok=1
XQ2_43 c2 vbe dvbe vss npn13G2 Nx=1 mm_ok=1
XQ2_44 c2 vbe dvbe vss npn13G2 Nx=1 mm_ok=1
XQ2_45 c2 vbe dvbe vss npn13G2 Nx=1 mm_ok=1
XQ2_46 c2 vbe dvbe vss npn13G2 Nx=1 mm_ok=1
XQ2_47 c2 vbe dvbe vss npn13G2 Nx=1 mm_ok=1
XR1 dvbe vss sub! rppd w=1u l=84u m=1 b=0 mm_ok=1
XMP3 d3 pbias vdd vdd sg13_hv_pmos w=10u l=4u ng=1 m=1 mm_ok=1
XMC3 vref pcasc d3 d3 sg13_hv_pmos w=10u l=4u ng=1 m=1 mm_ok=1
XR2 vref vbe3 sub! rppd w=1u l=347.5u m=1 b=0 mm_ok=1
XQ3_0 vbe3 vbe3 vss vss npn13G2 Nx=1 mm_ok=1
XQ3_1 vbe3 vbe3 vss vss npn13G2 Nx=1 mm_ok=1
XQ3_2 vbe3 vbe3 vss vss npn13G2 Nx=1 mm_ok=1
XQ3_3 vbe3 vbe3 vss vss npn13G2 Nx=1 mm_ok=1
XMP4 d4 pbias vdd vdd sg13_hv_pmos w=10u l=4u ng=1 m=1 mm_ok=1
XMC4 iptat pcasc d4 d4 sg13_hv_pmos w=10u l=4u ng=1 m=1 mm_ok=1
XMPS det pbias vdd vdd sg13_hv_pmos w=10u l=4u ng=1 m=1 mm_ok=1
XRDET det vss sub! rhigh w=0.5u l=735u m=1 b=0 mm_ok=1
XMNI kick det vss vss sg13_hv_nmos w=1u l=0.5u ng=1 m=1 mm_ok=1
XMPI kick det vdd vdd sg13_hv_pmos w=2u l=0.5u ng=1 m=1 mm_ok=1
XMKFB pbias kick vss vss sg13_hv_nmos w=1u l=4u ng=1 m=1 mm_ok=1
.ends
